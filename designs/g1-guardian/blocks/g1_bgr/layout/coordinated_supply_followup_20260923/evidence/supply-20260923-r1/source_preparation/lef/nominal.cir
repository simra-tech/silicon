* G1_BGR standalone capacitance-PEX qualification
.lib /foss/pdks/ihp-sg13g2/libs.tech/ngspice/models/cornerHBT.lib hbt_typ
.lib /foss/pdks/ihp-sg13g2/libs.tech/ngspice/models/cornerMOShv.lib mos_tt
.lib /foss/pdks/ihp-sg13g2/libs.tech/ngspice/models/cornerRES.lib res_typ
.include conditional_metal.spice
.option seed=44001 gmin=1e-15 abstol=1e-14 reltol=1e-5 vntol=1e-7
.global sub!
Vsub sub! 0 0
Vdd vdd 0 3.3
Vr4 r4 0 0
Xbgr vdd 0 r4 vref iptat pbias pcasc vbe dvbe g1_bgr
Vload iptat 0 1
Cload vref 0 1e-12
.control
set num_threads=1
set numdgt=15
set wr_singlescale
set wr_vecnames
op
echo RAW_CURRENT_LEDGER_BEGIN
print @n.xbgr.xr1.nr1[ibody]
print @n.xbgr.xr2.nr1[ibody]
print @n.xbgr.xr3.nr1[ibody]
print @n.xbgr.xr4.nr1[ibody]
print @n.xbgr.xr5.nr1[ibody]
print @n.xbgr.xr6.nr1[ibody]
print @n.xbgr.xr7.nr1[ibody]
print @n.xbgr.xr8.nr1[ibody]
print @n.xbgr.xr9.nr1[ibody]
print @n.xbgr.xr10.nr1[ibody]
print @n.xbgr.xr11.nr1[ibody]
print @n.xbgr.xr12.nr1[ibody]
print @n.xbgr.xr13.nr1[ibody]
print @n.xbgr.xr14.nr1[ibody]
print @n.xbgr.xr15.nr1[ibody]
print @n.xbgr.xr16.nr1[ibody]
print @n.xbgr.xr17.nr1[ibody]
print @n.xbgr.xr18.nr1[ibody]
print @n.xbgr.xr19.nr1[ibody]
print @n.xbgr.xr20.nr1[ibody]
print @n.xbgr.xr21.nr1[ibody]
print @n.xbgr.xr22.nr1[ibody]
print @n.xbgr.xr23.nr1[ibody]
print @n.xbgr.xr24.nr1[ibody]
print @n.xbgr.xr25.nr1[ibody]
print @n.xbgr.xr26.nr1[ibody]
print @n.xbgr.xm27.nsg13_hv_pmos[ide]
print @n.xbgr.xm27.nsg13_hv_pmos[ige]
print @n.xbgr.xm27.nsg13_hv_pmos[ise]
print @n.xbgr.xm27.nsg13_hv_pmos[ibe]
print @n.xbgr.xm27.nsg13_hv_pmos[ctype]
print @n.xbgr.xm28.nsg13_hv_pmos[ide]
print @n.xbgr.xm28.nsg13_hv_pmos[ige]
print @n.xbgr.xm28.nsg13_hv_pmos[ise]
print @n.xbgr.xm28.nsg13_hv_pmos[ibe]
print @n.xbgr.xm28.nsg13_hv_pmos[ctype]
print @n.xbgr.xm29.nsg13_hv_nmos[ide]
print @n.xbgr.xm29.nsg13_hv_nmos[ige]
print @n.xbgr.xm29.nsg13_hv_nmos[ise]
print @n.xbgr.xm29.nsg13_hv_nmos[ibe]
print @n.xbgr.xm29.nsg13_hv_nmos[ctype]
print @n.xbgr.xm30.nsg13_hv_nmos[ide]
print @n.xbgr.xm30.nsg13_hv_nmos[ige]
print @n.xbgr.xm30.nsg13_hv_nmos[ise]
print @n.xbgr.xm30.nsg13_hv_nmos[ibe]
print @n.xbgr.xm30.nsg13_hv_nmos[ctype]
print @n.xbgr.xm31.nsg13_hv_nmos[ide]
print @n.xbgr.xm31.nsg13_hv_nmos[ige]
print @n.xbgr.xm31.nsg13_hv_nmos[ise]
print @n.xbgr.xm31.nsg13_hv_nmos[ibe]
print @n.xbgr.xm31.nsg13_hv_nmos[ctype]
print @n.xbgr.xm32.nsg13_hv_nmos[ide]
print @n.xbgr.xm32.nsg13_hv_nmos[ige]
print @n.xbgr.xm32.nsg13_hv_nmos[ise]
print @n.xbgr.xm32.nsg13_hv_nmos[ibe]
print @n.xbgr.xm32.nsg13_hv_nmos[ctype]
print @n.xbgr.xm33.nsg13_hv_nmos[ide]
print @n.xbgr.xm33.nsg13_hv_nmos[ige]
print @n.xbgr.xm33.nsg13_hv_nmos[ise]
print @n.xbgr.xm33.nsg13_hv_nmos[ibe]
print @n.xbgr.xm33.nsg13_hv_nmos[ctype]
print @n.xbgr.xm34.nsg13_hv_nmos[ide]
print @n.xbgr.xm34.nsg13_hv_nmos[ige]
print @n.xbgr.xm34.nsg13_hv_nmos[ise]
print @n.xbgr.xm34.nsg13_hv_nmos[ibe]
print @n.xbgr.xm34.nsg13_hv_nmos[ctype]
print @n.xbgr.xm35.nsg13_hv_nmos[ide]
print @n.xbgr.xm35.nsg13_hv_nmos[ige]
print @n.xbgr.xm35.nsg13_hv_nmos[ise]
print @n.xbgr.xm35.nsg13_hv_nmos[ibe]
print @n.xbgr.xm35.nsg13_hv_nmos[ctype]
print @n.xbgr.xm36.nsg13_hv_nmos[ide]
print @n.xbgr.xm36.nsg13_hv_nmos[ige]
print @n.xbgr.xm36.nsg13_hv_nmos[ise]
print @n.xbgr.xm36.nsg13_hv_nmos[ibe]
print @n.xbgr.xm36.nsg13_hv_nmos[ctype]
print @n.xbgr.xm37.nsg13_hv_nmos[ide]
print @n.xbgr.xm37.nsg13_hv_nmos[ige]
print @n.xbgr.xm37.nsg13_hv_nmos[ise]
print @n.xbgr.xm37.nsg13_hv_nmos[ibe]
print @n.xbgr.xm37.nsg13_hv_nmos[ctype]
print @n.xbgr.xm38.nsg13_hv_pmos[ide]
print @n.xbgr.xm38.nsg13_hv_pmos[ige]
print @n.xbgr.xm38.nsg13_hv_pmos[ise]
print @n.xbgr.xm38.nsg13_hv_pmos[ibe]
print @n.xbgr.xm38.nsg13_hv_pmos[ctype]
print @n.xbgr.xm39.nsg13_hv_pmos[ide]
print @n.xbgr.xm39.nsg13_hv_pmos[ige]
print @n.xbgr.xm39.nsg13_hv_pmos[ise]
print @n.xbgr.xm39.nsg13_hv_pmos[ibe]
print @n.xbgr.xm39.nsg13_hv_pmos[ctype]
print @n.xbgr.xm40.nsg13_hv_pmos[ide]
print @n.xbgr.xm40.nsg13_hv_pmos[ige]
print @n.xbgr.xm40.nsg13_hv_pmos[ise]
print @n.xbgr.xm40.nsg13_hv_pmos[ibe]
print @n.xbgr.xm40.nsg13_hv_pmos[ctype]
print @n.xbgr.xm41.nsg13_hv_pmos[ide]
print @n.xbgr.xm41.nsg13_hv_pmos[ige]
print @n.xbgr.xm41.nsg13_hv_pmos[ise]
print @n.xbgr.xm41.nsg13_hv_pmos[ibe]
print @n.xbgr.xm41.nsg13_hv_pmos[ctype]
print @n.xbgr.xm42.nsg13_hv_pmos[ide]
print @n.xbgr.xm42.nsg13_hv_pmos[ige]
print @n.xbgr.xm42.nsg13_hv_pmos[ise]
print @n.xbgr.xm42.nsg13_hv_pmos[ibe]
print @n.xbgr.xm42.nsg13_hv_pmos[ctype]
print @n.xbgr.xm43.nsg13_hv_pmos[ide]
print @n.xbgr.xm43.nsg13_hv_pmos[ige]
print @n.xbgr.xm43.nsg13_hv_pmos[ise]
print @n.xbgr.xm43.nsg13_hv_pmos[ibe]
print @n.xbgr.xm43.nsg13_hv_pmos[ctype]
print @n.xbgr.xm44.nsg13_hv_pmos[ide]
print @n.xbgr.xm44.nsg13_hv_pmos[ige]
print @n.xbgr.xm44.nsg13_hv_pmos[ise]
print @n.xbgr.xm44.nsg13_hv_pmos[ibe]
print @n.xbgr.xm44.nsg13_hv_pmos[ctype]
print @n.xbgr.xm45.nsg13_hv_pmos[ide]
print @n.xbgr.xm45.nsg13_hv_pmos[ige]
print @n.xbgr.xm45.nsg13_hv_pmos[ise]
print @n.xbgr.xm45.nsg13_hv_pmos[ibe]
print @n.xbgr.xm45.nsg13_hv_pmos[ctype]
print @n.xbgr.xm46.nsg13_hv_pmos[ide]
print @n.xbgr.xm46.nsg13_hv_pmos[ige]
print @n.xbgr.xm46.nsg13_hv_pmos[ise]
print @n.xbgr.xm46.nsg13_hv_pmos[ibe]
print @n.xbgr.xm46.nsg13_hv_pmos[ctype]
print @n.xbgr.xm47.nsg13_hv_pmos[ide]
print @n.xbgr.xm47.nsg13_hv_pmos[ige]
print @n.xbgr.xm47.nsg13_hv_pmos[ise]
print @n.xbgr.xm47.nsg13_hv_pmos[ibe]
print @n.xbgr.xm47.nsg13_hv_pmos[ctype]
print @n.xbgr.xm48.nsg13_hv_pmos[ide]
print @n.xbgr.xm48.nsg13_hv_pmos[ige]
print @n.xbgr.xm48.nsg13_hv_pmos[ise]
print @n.xbgr.xm48.nsg13_hv_pmos[ibe]
print @n.xbgr.xm48.nsg13_hv_pmos[ctype]
print @n.xbgr.xm49.nsg13_hv_pmos[ide]
print @n.xbgr.xm49.nsg13_hv_pmos[ige]
print @n.xbgr.xm49.nsg13_hv_pmos[ise]
print @n.xbgr.xm49.nsg13_hv_pmos[ibe]
print @n.xbgr.xm49.nsg13_hv_pmos[ctype]
print @n.xbgr.xm50.nsg13_hv_pmos[ide]
print @n.xbgr.xm50.nsg13_hv_pmos[ige]
print @n.xbgr.xm50.nsg13_hv_pmos[ise]
print @n.xbgr.xm50.nsg13_hv_pmos[ibe]
print @n.xbgr.xm50.nsg13_hv_pmos[ctype]
print @n.xbgr.xm51.nsg13_hv_pmos[ide]
print @n.xbgr.xm51.nsg13_hv_pmos[ige]
print @n.xbgr.xm51.nsg13_hv_pmos[ise]
print @n.xbgr.xm51.nsg13_hv_pmos[ibe]
print @n.xbgr.xm51.nsg13_hv_pmos[ctype]
print @n.xbgr.xm52.nsg13_hv_pmos[ide]
print @n.xbgr.xm52.nsg13_hv_pmos[ige]
print @n.xbgr.xm52.nsg13_hv_pmos[ise]
print @n.xbgr.xm52.nsg13_hv_pmos[ibe]
print @n.xbgr.xm52.nsg13_hv_pmos[ctype]
print @n.xbgr.xm53.nsg13_hv_pmos[ide]
print @n.xbgr.xm53.nsg13_hv_pmos[ige]
print @n.xbgr.xm53.nsg13_hv_pmos[ise]
print @n.xbgr.xm53.nsg13_hv_pmos[ibe]
print @n.xbgr.xm53.nsg13_hv_pmos[ctype]
print @n.xbgr.xm54.nsg13_hv_pmos[ide]
print @n.xbgr.xm54.nsg13_hv_pmos[ige]
print @n.xbgr.xm54.nsg13_hv_pmos[ise]
print @n.xbgr.xm54.nsg13_hv_pmos[ibe]
print @n.xbgr.xm54.nsg13_hv_pmos[ctype]
print @q.xbgr.xq55.qnpn13g2[ic]
print @q.xbgr.xq55.qnpn13g2[ib]
print @q.xbgr.xq55.qnpn13g2[ie]
print @q.xbgr.xq55.qnpn13g2[is]
print @r.xbgr.xq55.rsub[i]
print @c.xbgr.xq55.csub[i]
print @q.xbgr.xq56.qnpn13g2[ic]
print @q.xbgr.xq56.qnpn13g2[ib]
print @q.xbgr.xq56.qnpn13g2[ie]
print @q.xbgr.xq56.qnpn13g2[is]
print @r.xbgr.xq56.rsub[i]
print @c.xbgr.xq56.csub[i]
print @q.xbgr.xq57.qnpn13g2[ic]
print @q.xbgr.xq57.qnpn13g2[ib]
print @q.xbgr.xq57.qnpn13g2[ie]
print @q.xbgr.xq57.qnpn13g2[is]
print @r.xbgr.xq57.rsub[i]
print @c.xbgr.xq57.csub[i]
print @q.xbgr.xq58.qnpn13g2[ic]
print @q.xbgr.xq58.qnpn13g2[ib]
print @q.xbgr.xq58.qnpn13g2[ie]
print @q.xbgr.xq58.qnpn13g2[is]
print @r.xbgr.xq58.rsub[i]
print @c.xbgr.xq58.csub[i]
print @q.xbgr.xq59.qnpn13g2[ic]
print @q.xbgr.xq59.qnpn13g2[ib]
print @q.xbgr.xq59.qnpn13g2[ie]
print @q.xbgr.xq59.qnpn13g2[is]
print @r.xbgr.xq59.rsub[i]
print @c.xbgr.xq59.csub[i]
print @q.xbgr.xq60.qnpn13g2[ic]
print @q.xbgr.xq60.qnpn13g2[ib]
print @q.xbgr.xq60.qnpn13g2[ie]
print @q.xbgr.xq60.qnpn13g2[is]
print @r.xbgr.xq60.rsub[i]
print @c.xbgr.xq60.csub[i]
print @q.xbgr.xq61.qnpn13g2[ic]
print @q.xbgr.xq61.qnpn13g2[ib]
print @q.xbgr.xq61.qnpn13g2[ie]
print @q.xbgr.xq61.qnpn13g2[is]
print @r.xbgr.xq61.rsub[i]
print @c.xbgr.xq61.csub[i]
print @q.xbgr.xq62.qnpn13g2[ic]
print @q.xbgr.xq62.qnpn13g2[ib]
print @q.xbgr.xq62.qnpn13g2[ie]
print @q.xbgr.xq62.qnpn13g2[is]
print @r.xbgr.xq62.rsub[i]
print @c.xbgr.xq62.csub[i]
print @q.xbgr.xq63.qnpn13g2[ic]
print @q.xbgr.xq63.qnpn13g2[ib]
print @q.xbgr.xq63.qnpn13g2[ie]
print @q.xbgr.xq63.qnpn13g2[is]
print @r.xbgr.xq63.rsub[i]
print @c.xbgr.xq63.csub[i]
print @q.xbgr.xq64.qnpn13g2[ic]
print @q.xbgr.xq64.qnpn13g2[ib]
print @q.xbgr.xq64.qnpn13g2[ie]
print @q.xbgr.xq64.qnpn13g2[is]
print @r.xbgr.xq64.rsub[i]
print @c.xbgr.xq64.csub[i]
print @q.xbgr.xq65.qnpn13g2[ic]
print @q.xbgr.xq65.qnpn13g2[ib]
print @q.xbgr.xq65.qnpn13g2[ie]
print @q.xbgr.xq65.qnpn13g2[is]
print @r.xbgr.xq65.rsub[i]
print @c.xbgr.xq65.csub[i]
print @q.xbgr.xq66.qnpn13g2[ic]
print @q.xbgr.xq66.qnpn13g2[ib]
print @q.xbgr.xq66.qnpn13g2[ie]
print @q.xbgr.xq66.qnpn13g2[is]
print @r.xbgr.xq66.rsub[i]
print @c.xbgr.xq66.csub[i]
print @q.xbgr.xq67.qnpn13g2[ic]
print @q.xbgr.xq67.qnpn13g2[ib]
print @q.xbgr.xq67.qnpn13g2[ie]
print @q.xbgr.xq67.qnpn13g2[is]
print @r.xbgr.xq67.rsub[i]
print @c.xbgr.xq67.csub[i]
print @q.xbgr.xq68.qnpn13g2[ic]
print @q.xbgr.xq68.qnpn13g2[ib]
print @q.xbgr.xq68.qnpn13g2[ie]
print @q.xbgr.xq68.qnpn13g2[is]
print @r.xbgr.xq68.rsub[i]
print @c.xbgr.xq68.csub[i]
print @q.xbgr.xq69.qnpn13g2[ic]
print @q.xbgr.xq69.qnpn13g2[ib]
print @q.xbgr.xq69.qnpn13g2[ie]
print @q.xbgr.xq69.qnpn13g2[is]
print @r.xbgr.xq69.rsub[i]
print @c.xbgr.xq69.csub[i]
print @q.xbgr.xq70.qnpn13g2[ic]
print @q.xbgr.xq70.qnpn13g2[ib]
print @q.xbgr.xq70.qnpn13g2[ie]
print @q.xbgr.xq70.qnpn13g2[is]
print @r.xbgr.xq70.rsub[i]
print @c.xbgr.xq70.csub[i]
print @q.xbgr.xq71.qnpn13g2[ic]
print @q.xbgr.xq71.qnpn13g2[ib]
print @q.xbgr.xq71.qnpn13g2[ie]
print @q.xbgr.xq71.qnpn13g2[is]
print @r.xbgr.xq71.rsub[i]
print @c.xbgr.xq71.csub[i]
print @q.xbgr.xq72.qnpn13g2[ic]
print @q.xbgr.xq72.qnpn13g2[ib]
print @q.xbgr.xq72.qnpn13g2[ie]
print @q.xbgr.xq72.qnpn13g2[is]
print @r.xbgr.xq72.rsub[i]
print @c.xbgr.xq72.csub[i]
print @q.xbgr.xq73.qnpn13g2[ic]
print @q.xbgr.xq73.qnpn13g2[ib]
print @q.xbgr.xq73.qnpn13g2[ie]
print @q.xbgr.xq73.qnpn13g2[is]
print @r.xbgr.xq73.rsub[i]
print @c.xbgr.xq73.csub[i]
print @q.xbgr.xq74.qnpn13g2[ic]
print @q.xbgr.xq74.qnpn13g2[ib]
print @q.xbgr.xq74.qnpn13g2[ie]
print @q.xbgr.xq74.qnpn13g2[is]
print @r.xbgr.xq74.rsub[i]
print @c.xbgr.xq74.csub[i]
print @q.xbgr.xq75.qnpn13g2[ic]
print @q.xbgr.xq75.qnpn13g2[ib]
print @q.xbgr.xq75.qnpn13g2[ie]
print @q.xbgr.xq75.qnpn13g2[is]
print @r.xbgr.xq75.rsub[i]
print @c.xbgr.xq75.csub[i]
print @q.xbgr.xq76.qnpn13g2[ic]
print @q.xbgr.xq76.qnpn13g2[ib]
print @q.xbgr.xq76.qnpn13g2[ie]
print @q.xbgr.xq76.qnpn13g2[is]
print @r.xbgr.xq76.rsub[i]
print @c.xbgr.xq76.csub[i]
print @n.xbgr.xr77.nr1[ibody]
print @n.xbgr.xr78.nr1[ibody]
print @n.xbgr.xr79.nr1[ibody]
print @n.xbgr.xr80.nr1[ibody]
print @n.xbgr.xr81.nr1[ibody]
print @n.xbgr.xr82.nr1[ibody]
print @n.xbgr.xr83.nr1[ibody]
print @n.xbgr.xr84.nr1[ibody]
print @n.xbgr.xr85.nr1[ibody]
print @n.xbgr.xr86.nr1[ibody]
print @n.xbgr.xr16_u2.nr1[ibody]
print @n.xbgr.xr16_u3.nr1[ibody]
print @n.xbgr.xr16_u4.nr1[ibody]
print @n.xbgr.xr16_u5.nr1[ibody]
print @n.xbgr.xr16_u6.nr1[ibody]
print @n.xbgr.xr16_u7.nr1[ibody]
print @n.xbgr.xr16_u8.nr1[ibody]
print @n.xbgr.xr16_u9.nr1[ibody]
print @n.xbgr.xr16_u10.nr1[ibody]
print @n.xbgr.xr16_u11.nr1[ibody]
print @n.xbgr.xr16_u12.nr1[ibody]
print @n.xbgr.xr16_u13.nr1[ibody]
print @n.xbgr.xr16_u14.nr1[ibody]
print @n.xbgr.xr16_u15.nr1[ibody]
print @n.xbgr.xr16_u16.nr1[ibody]
print @n.xbgr.xr16_u17.nr1[ibody]
print @n.xbgr.xr16_u18.nr1[ibody]
print @n.xbgr.xr16_u19.nr1[ibody]
print @n.xbgr.xr16_u20.nr1[ibody]
print @n.xbgr.xr16_u21.nr1[ibody]
print @n.xbgr.xr16_u22.nr1[ibody]
print @n.xbgr.xr16_u23.nr1[ibody]
print @n.xbgr.xr16_u24.nr1[ibody]
print @n.xbgr.xr17_u2.nr1[ibody]
print @n.xbgr.xr17_u3.nr1[ibody]
print @n.xbgr.xr17_u4.nr1[ibody]
print @n.xbgr.xr18_u2.nr1[ibody]
print @n.xbgr.xr18_u3.nr1[ibody]
print @n.xbgr.xr18_u4.nr1[ibody]
print @n.xbgr.xr19_u2.nr1[ibody]
print @n.xbgr.xr19_u3.nr1[ibody]
print @n.xbgr.xr19_u4.nr1[ibody]
print @n.xbgr.xr20_u2.nr1[ibody]
print @n.xbgr.xr20_u3.nr1[ibody]
print @n.xbgr.xr20_u4.nr1[ibody]
print @n.xbgr.xr21_u2.nr1[ibody]
print @n.xbgr.xr21_u3.nr1[ibody]
print @n.xbgr.xr21_u4.nr1[ibody]
print @n.xbgr.xr22_u2.nr1[ibody]
print @n.xbgr.xr22_u3.nr1[ibody]
print @n.xbgr.xr22_u4.nr1[ibody]
print @n.xbgr.xr23_u2.nr1[ibody]
print @n.xbgr.xr23_u3.nr1[ibody]
print @n.xbgr.xr23_u4.nr1[ibody]
print @n.xbgr.xr23_u5.nr1[ibody]
print @n.xbgr.xr23_u6.nr1[ibody]
print @n.xbgr.xr23_u7.nr1[ibody]
print @n.xbgr.xr23_u8.nr1[ibody]
print @n.xbgr.xr23_u9.nr1[ibody]
print @n.xbgr.xr23_u10.nr1[ibody]
print @n.xbgr.xr23_u11.nr1[ibody]
print @n.xbgr.xr23_u12.nr1[ibody]
print @n.xbgr.xr23_u13.nr1[ibody]
print @n.xbgr.xr23_u14.nr1[ibody]
print @n.xbgr.xr23_u15.nr1[ibody]
print @n.xbgr.xr23_u16.nr1[ibody]
print @n.xbgr.xr23_u17.nr1[ibody]
print @n.xbgr.xr23_u18.nr1[ibody]
print @n.xbgr.xr23_u19.nr1[ibody]
print @n.xbgr.xr23_u20.nr1[ibody]
print @n.xbgr.xr23_u21.nr1[ibody]
print @n.xbgr.xr23_u22.nr1[ibody]
print @n.xbgr.xr23_u23.nr1[ibody]
print @n.xbgr.xr23_u24.nr1[ibody]
print @n.xbgr.xr24_u2.nr1[ibody]
print @n.xbgr.xr24_u3.nr1[ibody]
print @n.xbgr.xr24_u4.nr1[ibody]
print @n.xbgr.xr24_u5.nr1[ibody]
print @n.xbgr.xr24_u6.nr1[ibody]
print @n.xbgr.xr24_u7.nr1[ibody]
print @n.xbgr.xr24_u8.nr1[ibody]
print @n.xbgr.xr24_u9.nr1[ibody]
print @n.xbgr.xr24_u10.nr1[ibody]
print @n.xbgr.xr24_u11.nr1[ibody]
print @n.xbgr.xr24_u12.nr1[ibody]
print @n.xbgr.xr24_u13.nr1[ibody]
print @n.xbgr.xr24_u14.nr1[ibody]
print @n.xbgr.xr24_u15.nr1[ibody]
print @n.xbgr.xr24_u16.nr1[ibody]
print @n.xbgr.xr24_u17.nr1[ibody]
print @n.xbgr.xr24_u18.nr1[ibody]
print @n.xbgr.xr24_u19.nr1[ibody]
print @n.xbgr.xr24_u20.nr1[ibody]
print @n.xbgr.xr24_u21.nr1[ibody]
print @n.xbgr.xr24_u22.nr1[ibody]
print @n.xbgr.xr24_u23.nr1[ibody]
print @n.xbgr.xr24_u24.nr1[ibody]
print @n.xbgr.xr25_u2.nr1[ibody]
print @n.xbgr.xr25_u3.nr1[ibody]
print @n.xbgr.xr25_u4.nr1[ibody]
print @n.xbgr.xr25_u5.nr1[ibody]
print @n.xbgr.xr25_u6.nr1[ibody]
print @n.xbgr.xr25_u7.nr1[ibody]
print @n.xbgr.xr25_u8.nr1[ibody]
print @n.xbgr.xr25_u9.nr1[ibody]
print @n.xbgr.xr25_u10.nr1[ibody]
print @n.xbgr.xr25_u11.nr1[ibody]
print @n.xbgr.xr25_u12.nr1[ibody]
print @n.xbgr.xr25_u13.nr1[ibody]
print @n.xbgr.xr25_u14.nr1[ibody]
print @n.xbgr.xr25_u15.nr1[ibody]
print @n.xbgr.xr25_u16.nr1[ibody]
print @n.xbgr.xr25_u17.nr1[ibody]
print @n.xbgr.xr25_u18.nr1[ibody]
print @n.xbgr.xr25_u19.nr1[ibody]
print @n.xbgr.xr25_u20.nr1[ibody]
print @n.xbgr.xr25_u21.nr1[ibody]
print @n.xbgr.xr25_u22.nr1[ibody]
print @n.xbgr.xr25_u23.nr1[ibody]
print @n.xbgr.xr25_u24.nr1[ibody]
print @n.xbgr.xr26_u2.nr1[ibody]
print @n.xbgr.xr26_u3.nr1[ibody]
print @n.xbgr.xr26_u4.nr1[ibody]
print @n.xbgr.xr26_u5.nr1[ibody]
print @n.xbgr.xr26_u6.nr1[ibody]
print @n.xbgr.xr26_u7.nr1[ibody]
print @n.xbgr.xr26_u8.nr1[ibody]
print @n.xbgr.xr26_u9.nr1[ibody]
print @n.xbgr.xr26_u10.nr1[ibody]
print @n.xbgr.xr26_u11.nr1[ibody]
print @n.xbgr.xr26_u12.nr1[ibody]
print @n.xbgr.xr26_u13.nr1[ibody]
print @n.xbgr.xr26_u14.nr1[ibody]
print @n.xbgr.xr26_u15.nr1[ibody]
print @n.xbgr.xr26_u16.nr1[ibody]
print @n.xbgr.xr26_u17.nr1[ibody]
print @n.xbgr.xr26_u18.nr1[ibody]
print @n.xbgr.xr26_u19.nr1[ibody]
print @n.xbgr.xr26_u20.nr1[ibody]
print @n.xbgr.xr26_u21.nr1[ibody]
print @n.xbgr.xr26_u22.nr1[ibody]
print @n.xbgr.xr26_u23.nr1[ibody]
print @n.xbgr.xr26_u24.nr1[ibody]
print @n.xbgr.xm34_u2.nsg13_hv_nmos[ide]
print @n.xbgr.xm34_u2.nsg13_hv_nmos[ige]
print @n.xbgr.xm34_u2.nsg13_hv_nmos[ise]
print @n.xbgr.xm34_u2.nsg13_hv_nmos[ibe]
print @n.xbgr.xm34_u2.nsg13_hv_nmos[ctype]
print @n.xbgr.xm34_u3.nsg13_hv_nmos[ide]
print @n.xbgr.xm34_u3.nsg13_hv_nmos[ige]
print @n.xbgr.xm34_u3.nsg13_hv_nmos[ise]
print @n.xbgr.xm34_u3.nsg13_hv_nmos[ibe]
print @n.xbgr.xm34_u3.nsg13_hv_nmos[ctype]
print @n.xbgr.xm34_u4.nsg13_hv_nmos[ide]
print @n.xbgr.xm34_u4.nsg13_hv_nmos[ige]
print @n.xbgr.xm34_u4.nsg13_hv_nmos[ise]
print @n.xbgr.xm34_u4.nsg13_hv_nmos[ibe]
print @n.xbgr.xm34_u4.nsg13_hv_nmos[ctype]
print @n.xbgr.xm34_u5.nsg13_hv_nmos[ide]
print @n.xbgr.xm34_u5.nsg13_hv_nmos[ige]
print @n.xbgr.xm34_u5.nsg13_hv_nmos[ise]
print @n.xbgr.xm34_u5.nsg13_hv_nmos[ibe]
print @n.xbgr.xm34_u5.nsg13_hv_nmos[ctype]
print @n.xbgr.xm34_u6.nsg13_hv_nmos[ide]
print @n.xbgr.xm34_u6.nsg13_hv_nmos[ige]
print @n.xbgr.xm34_u6.nsg13_hv_nmos[ise]
print @n.xbgr.xm34_u6.nsg13_hv_nmos[ibe]
print @n.xbgr.xm34_u6.nsg13_hv_nmos[ctype]
print @n.xbgr.xm34_u7.nsg13_hv_nmos[ide]
print @n.xbgr.xm34_u7.nsg13_hv_nmos[ige]
print @n.xbgr.xm34_u7.nsg13_hv_nmos[ise]
print @n.xbgr.xm34_u7.nsg13_hv_nmos[ibe]
print @n.xbgr.xm34_u7.nsg13_hv_nmos[ctype]
print @n.xbgr.xm34_u8.nsg13_hv_nmos[ide]
print @n.xbgr.xm34_u8.nsg13_hv_nmos[ige]
print @n.xbgr.xm34_u8.nsg13_hv_nmos[ise]
print @n.xbgr.xm34_u8.nsg13_hv_nmos[ibe]
print @n.xbgr.xm34_u8.nsg13_hv_nmos[ctype]
print @n.xbgr.xm34_u9.nsg13_hv_nmos[ide]
print @n.xbgr.xm34_u9.nsg13_hv_nmos[ige]
print @n.xbgr.xm34_u9.nsg13_hv_nmos[ise]
print @n.xbgr.xm34_u9.nsg13_hv_nmos[ibe]
print @n.xbgr.xm34_u9.nsg13_hv_nmos[ctype]
print @n.xbgr.xm34_u10.nsg13_hv_nmos[ide]
print @n.xbgr.xm34_u10.nsg13_hv_nmos[ige]
print @n.xbgr.xm34_u10.nsg13_hv_nmos[ise]
print @n.xbgr.xm34_u10.nsg13_hv_nmos[ibe]
print @n.xbgr.xm34_u10.nsg13_hv_nmos[ctype]
print @n.xbgr.xm34_u11.nsg13_hv_nmos[ide]
print @n.xbgr.xm34_u11.nsg13_hv_nmos[ige]
print @n.xbgr.xm34_u11.nsg13_hv_nmos[ise]
print @n.xbgr.xm34_u11.nsg13_hv_nmos[ibe]
print @n.xbgr.xm34_u11.nsg13_hv_nmos[ctype]
print @n.xbgr.xm34_u12.nsg13_hv_nmos[ide]
print @n.xbgr.xm34_u12.nsg13_hv_nmos[ige]
print @n.xbgr.xm34_u12.nsg13_hv_nmos[ise]
print @n.xbgr.xm34_u12.nsg13_hv_nmos[ibe]
print @n.xbgr.xm34_u12.nsg13_hv_nmos[ctype]
print @n.xbgr.xm34_u13.nsg13_hv_nmos[ide]
print @n.xbgr.xm34_u13.nsg13_hv_nmos[ige]
print @n.xbgr.xm34_u13.nsg13_hv_nmos[ise]
print @n.xbgr.xm34_u13.nsg13_hv_nmos[ibe]
print @n.xbgr.xm34_u13.nsg13_hv_nmos[ctype]
print @n.xbgr.xm34_u14.nsg13_hv_nmos[ide]
print @n.xbgr.xm34_u14.nsg13_hv_nmos[ige]
print @n.xbgr.xm34_u14.nsg13_hv_nmos[ise]
print @n.xbgr.xm34_u14.nsg13_hv_nmos[ibe]
print @n.xbgr.xm34_u14.nsg13_hv_nmos[ctype]
print @n.xbgr.xm34_u15.nsg13_hv_nmos[ide]
print @n.xbgr.xm34_u15.nsg13_hv_nmos[ige]
print @n.xbgr.xm34_u15.nsg13_hv_nmos[ise]
print @n.xbgr.xm34_u15.nsg13_hv_nmos[ibe]
print @n.xbgr.xm34_u15.nsg13_hv_nmos[ctype]
print @n.xbgr.xm34_u16.nsg13_hv_nmos[ide]
print @n.xbgr.xm34_u16.nsg13_hv_nmos[ige]
print @n.xbgr.xm34_u16.nsg13_hv_nmos[ise]
print @n.xbgr.xm34_u16.nsg13_hv_nmos[ibe]
print @n.xbgr.xm34_u16.nsg13_hv_nmos[ctype]
print @n.xbgr.xm34_u17.nsg13_hv_nmos[ide]
print @n.xbgr.xm34_u17.nsg13_hv_nmos[ige]
print @n.xbgr.xm34_u17.nsg13_hv_nmos[ise]
print @n.xbgr.xm34_u17.nsg13_hv_nmos[ibe]
print @n.xbgr.xm34_u17.nsg13_hv_nmos[ctype]
print @n.xbgr.xm34_u18.nsg13_hv_nmos[ide]
print @n.xbgr.xm34_u18.nsg13_hv_nmos[ige]
print @n.xbgr.xm34_u18.nsg13_hv_nmos[ise]
print @n.xbgr.xm34_u18.nsg13_hv_nmos[ibe]
print @n.xbgr.xm34_u18.nsg13_hv_nmos[ctype]
print @n.xbgr.xm34_u19.nsg13_hv_nmos[ide]
print @n.xbgr.xm34_u19.nsg13_hv_nmos[ige]
print @n.xbgr.xm34_u19.nsg13_hv_nmos[ise]
print @n.xbgr.xm34_u19.nsg13_hv_nmos[ibe]
print @n.xbgr.xm34_u19.nsg13_hv_nmos[ctype]
print @n.xbgr.xm34_u20.nsg13_hv_nmos[ide]
print @n.xbgr.xm34_u20.nsg13_hv_nmos[ige]
print @n.xbgr.xm34_u20.nsg13_hv_nmos[ise]
print @n.xbgr.xm34_u20.nsg13_hv_nmos[ibe]
print @n.xbgr.xm34_u20.nsg13_hv_nmos[ctype]
print @n.xbgr.xm34_u21.nsg13_hv_nmos[ide]
print @n.xbgr.xm34_u21.nsg13_hv_nmos[ige]
print @n.xbgr.xm34_u21.nsg13_hv_nmos[ise]
print @n.xbgr.xm34_u21.nsg13_hv_nmos[ibe]
print @n.xbgr.xm34_u21.nsg13_hv_nmos[ctype]
print @n.xbgr.xm34_u22.nsg13_hv_nmos[ide]
print @n.xbgr.xm34_u22.nsg13_hv_nmos[ige]
print @n.xbgr.xm34_u22.nsg13_hv_nmos[ise]
print @n.xbgr.xm34_u22.nsg13_hv_nmos[ibe]
print @n.xbgr.xm34_u22.nsg13_hv_nmos[ctype]
print @n.xbgr.xm34_u23.nsg13_hv_nmos[ide]
print @n.xbgr.xm34_u23.nsg13_hv_nmos[ige]
print @n.xbgr.xm34_u23.nsg13_hv_nmos[ise]
print @n.xbgr.xm34_u23.nsg13_hv_nmos[ibe]
print @n.xbgr.xm34_u23.nsg13_hv_nmos[ctype]
print @n.xbgr.xm34_u24.nsg13_hv_nmos[ide]
print @n.xbgr.xm34_u24.nsg13_hv_nmos[ige]
print @n.xbgr.xm34_u24.nsg13_hv_nmos[ise]
print @n.xbgr.xm34_u24.nsg13_hv_nmos[ibe]
print @n.xbgr.xm34_u24.nsg13_hv_nmos[ctype]
print @n.xbgr.xm35_u2.nsg13_hv_nmos[ide]
print @n.xbgr.xm35_u2.nsg13_hv_nmos[ige]
print @n.xbgr.xm35_u2.nsg13_hv_nmos[ise]
print @n.xbgr.xm35_u2.nsg13_hv_nmos[ibe]
print @n.xbgr.xm35_u2.nsg13_hv_nmos[ctype]
print @n.xbgr.xm35_u3.nsg13_hv_nmos[ide]
print @n.xbgr.xm35_u3.nsg13_hv_nmos[ige]
print @n.xbgr.xm35_u3.nsg13_hv_nmos[ise]
print @n.xbgr.xm35_u3.nsg13_hv_nmos[ibe]
print @n.xbgr.xm35_u3.nsg13_hv_nmos[ctype]
print @n.xbgr.xm35_u4.nsg13_hv_nmos[ide]
print @n.xbgr.xm35_u4.nsg13_hv_nmos[ige]
print @n.xbgr.xm35_u4.nsg13_hv_nmos[ise]
print @n.xbgr.xm35_u4.nsg13_hv_nmos[ibe]
print @n.xbgr.xm35_u4.nsg13_hv_nmos[ctype]
print @n.xbgr.xm35_u5.nsg13_hv_nmos[ide]
print @n.xbgr.xm35_u5.nsg13_hv_nmos[ige]
print @n.xbgr.xm35_u5.nsg13_hv_nmos[ise]
print @n.xbgr.xm35_u5.nsg13_hv_nmos[ibe]
print @n.xbgr.xm35_u5.nsg13_hv_nmos[ctype]
print @n.xbgr.xm35_u6.nsg13_hv_nmos[ide]
print @n.xbgr.xm35_u6.nsg13_hv_nmos[ige]
print @n.xbgr.xm35_u6.nsg13_hv_nmos[ise]
print @n.xbgr.xm35_u6.nsg13_hv_nmos[ibe]
print @n.xbgr.xm35_u6.nsg13_hv_nmos[ctype]
print @n.xbgr.xm35_u7.nsg13_hv_nmos[ide]
print @n.xbgr.xm35_u7.nsg13_hv_nmos[ige]
print @n.xbgr.xm35_u7.nsg13_hv_nmos[ise]
print @n.xbgr.xm35_u7.nsg13_hv_nmos[ibe]
print @n.xbgr.xm35_u7.nsg13_hv_nmos[ctype]
print @n.xbgr.xm35_u8.nsg13_hv_nmos[ide]
print @n.xbgr.xm35_u8.nsg13_hv_nmos[ige]
print @n.xbgr.xm35_u8.nsg13_hv_nmos[ise]
print @n.xbgr.xm35_u8.nsg13_hv_nmos[ibe]
print @n.xbgr.xm35_u8.nsg13_hv_nmos[ctype]
print @n.xbgr.xm35_u9.nsg13_hv_nmos[ide]
print @n.xbgr.xm35_u9.nsg13_hv_nmos[ige]
print @n.xbgr.xm35_u9.nsg13_hv_nmos[ise]
print @n.xbgr.xm35_u9.nsg13_hv_nmos[ibe]
print @n.xbgr.xm35_u9.nsg13_hv_nmos[ctype]
print @n.xbgr.xm35_u10.nsg13_hv_nmos[ide]
print @n.xbgr.xm35_u10.nsg13_hv_nmos[ige]
print @n.xbgr.xm35_u10.nsg13_hv_nmos[ise]
print @n.xbgr.xm35_u10.nsg13_hv_nmos[ibe]
print @n.xbgr.xm35_u10.nsg13_hv_nmos[ctype]
print @n.xbgr.xm35_u11.nsg13_hv_nmos[ide]
print @n.xbgr.xm35_u11.nsg13_hv_nmos[ige]
print @n.xbgr.xm35_u11.nsg13_hv_nmos[ise]
print @n.xbgr.xm35_u11.nsg13_hv_nmos[ibe]
print @n.xbgr.xm35_u11.nsg13_hv_nmos[ctype]
print @n.xbgr.xm35_u12.nsg13_hv_nmos[ide]
print @n.xbgr.xm35_u12.nsg13_hv_nmos[ige]
print @n.xbgr.xm35_u12.nsg13_hv_nmos[ise]
print @n.xbgr.xm35_u12.nsg13_hv_nmos[ibe]
print @n.xbgr.xm35_u12.nsg13_hv_nmos[ctype]
print @n.xbgr.xm35_u13.nsg13_hv_nmos[ide]
print @n.xbgr.xm35_u13.nsg13_hv_nmos[ige]
print @n.xbgr.xm35_u13.nsg13_hv_nmos[ise]
print @n.xbgr.xm35_u13.nsg13_hv_nmos[ibe]
print @n.xbgr.xm35_u13.nsg13_hv_nmos[ctype]
print @n.xbgr.xm35_u14.nsg13_hv_nmos[ide]
print @n.xbgr.xm35_u14.nsg13_hv_nmos[ige]
print @n.xbgr.xm35_u14.nsg13_hv_nmos[ise]
print @n.xbgr.xm35_u14.nsg13_hv_nmos[ibe]
print @n.xbgr.xm35_u14.nsg13_hv_nmos[ctype]
print @n.xbgr.xm35_u15.nsg13_hv_nmos[ide]
print @n.xbgr.xm35_u15.nsg13_hv_nmos[ige]
print @n.xbgr.xm35_u15.nsg13_hv_nmos[ise]
print @n.xbgr.xm35_u15.nsg13_hv_nmos[ibe]
print @n.xbgr.xm35_u15.nsg13_hv_nmos[ctype]
print @n.xbgr.xm35_u16.nsg13_hv_nmos[ide]
print @n.xbgr.xm35_u16.nsg13_hv_nmos[ige]
print @n.xbgr.xm35_u16.nsg13_hv_nmos[ise]
print @n.xbgr.xm35_u16.nsg13_hv_nmos[ibe]
print @n.xbgr.xm35_u16.nsg13_hv_nmos[ctype]
print @n.xbgr.xm35_u17.nsg13_hv_nmos[ide]
print @n.xbgr.xm35_u17.nsg13_hv_nmos[ige]
print @n.xbgr.xm35_u17.nsg13_hv_nmos[ise]
print @n.xbgr.xm35_u17.nsg13_hv_nmos[ibe]
print @n.xbgr.xm35_u17.nsg13_hv_nmos[ctype]
print @n.xbgr.xm35_u18.nsg13_hv_nmos[ide]
print @n.xbgr.xm35_u18.nsg13_hv_nmos[ige]
print @n.xbgr.xm35_u18.nsg13_hv_nmos[ise]
print @n.xbgr.xm35_u18.nsg13_hv_nmos[ibe]
print @n.xbgr.xm35_u18.nsg13_hv_nmos[ctype]
print @n.xbgr.xm35_u19.nsg13_hv_nmos[ide]
print @n.xbgr.xm35_u19.nsg13_hv_nmos[ige]
print @n.xbgr.xm35_u19.nsg13_hv_nmos[ise]
print @n.xbgr.xm35_u19.nsg13_hv_nmos[ibe]
print @n.xbgr.xm35_u19.nsg13_hv_nmos[ctype]
print @n.xbgr.xm35_u20.nsg13_hv_nmos[ide]
print @n.xbgr.xm35_u20.nsg13_hv_nmos[ige]
print @n.xbgr.xm35_u20.nsg13_hv_nmos[ise]
print @n.xbgr.xm35_u20.nsg13_hv_nmos[ibe]
print @n.xbgr.xm35_u20.nsg13_hv_nmos[ctype]
print @n.xbgr.xm35_u21.nsg13_hv_nmos[ide]
print @n.xbgr.xm35_u21.nsg13_hv_nmos[ige]
print @n.xbgr.xm35_u21.nsg13_hv_nmos[ise]
print @n.xbgr.xm35_u21.nsg13_hv_nmos[ibe]
print @n.xbgr.xm35_u21.nsg13_hv_nmos[ctype]
print @n.xbgr.xm35_u22.nsg13_hv_nmos[ide]
print @n.xbgr.xm35_u22.nsg13_hv_nmos[ige]
print @n.xbgr.xm35_u22.nsg13_hv_nmos[ise]
print @n.xbgr.xm35_u22.nsg13_hv_nmos[ibe]
print @n.xbgr.xm35_u22.nsg13_hv_nmos[ctype]
print @n.xbgr.xm35_u23.nsg13_hv_nmos[ide]
print @n.xbgr.xm35_u23.nsg13_hv_nmos[ige]
print @n.xbgr.xm35_u23.nsg13_hv_nmos[ise]
print @n.xbgr.xm35_u23.nsg13_hv_nmos[ibe]
print @n.xbgr.xm35_u23.nsg13_hv_nmos[ctype]
print @n.xbgr.xm35_u24.nsg13_hv_nmos[ide]
print @n.xbgr.xm35_u24.nsg13_hv_nmos[ige]
print @n.xbgr.xm35_u24.nsg13_hv_nmos[ise]
print @n.xbgr.xm35_u24.nsg13_hv_nmos[ibe]
print @n.xbgr.xm35_u24.nsg13_hv_nmos[ctype]
print @n.xbgr.xm36_u2.nsg13_hv_nmos[ide]
print @n.xbgr.xm36_u2.nsg13_hv_nmos[ige]
print @n.xbgr.xm36_u2.nsg13_hv_nmos[ise]
print @n.xbgr.xm36_u2.nsg13_hv_nmos[ibe]
print @n.xbgr.xm36_u2.nsg13_hv_nmos[ctype]
print @n.xbgr.xm36_u3.nsg13_hv_nmos[ide]
print @n.xbgr.xm36_u3.nsg13_hv_nmos[ige]
print @n.xbgr.xm36_u3.nsg13_hv_nmos[ise]
print @n.xbgr.xm36_u3.nsg13_hv_nmos[ibe]
print @n.xbgr.xm36_u3.nsg13_hv_nmos[ctype]
print @n.xbgr.xm36_u4.nsg13_hv_nmos[ide]
print @n.xbgr.xm36_u4.nsg13_hv_nmos[ige]
print @n.xbgr.xm36_u4.nsg13_hv_nmos[ise]
print @n.xbgr.xm36_u4.nsg13_hv_nmos[ibe]
print @n.xbgr.xm36_u4.nsg13_hv_nmos[ctype]
print @n.xbgr.xm36_u5.nsg13_hv_nmos[ide]
print @n.xbgr.xm36_u5.nsg13_hv_nmos[ige]
print @n.xbgr.xm36_u5.nsg13_hv_nmos[ise]
print @n.xbgr.xm36_u5.nsg13_hv_nmos[ibe]
print @n.xbgr.xm36_u5.nsg13_hv_nmos[ctype]
print @n.xbgr.xm36_u6.nsg13_hv_nmos[ide]
print @n.xbgr.xm36_u6.nsg13_hv_nmos[ige]
print @n.xbgr.xm36_u6.nsg13_hv_nmos[ise]
print @n.xbgr.xm36_u6.nsg13_hv_nmos[ibe]
print @n.xbgr.xm36_u6.nsg13_hv_nmos[ctype]
print @n.xbgr.xm36_u7.nsg13_hv_nmos[ide]
print @n.xbgr.xm36_u7.nsg13_hv_nmos[ige]
print @n.xbgr.xm36_u7.nsg13_hv_nmos[ise]
print @n.xbgr.xm36_u7.nsg13_hv_nmos[ibe]
print @n.xbgr.xm36_u7.nsg13_hv_nmos[ctype]
print @n.xbgr.xm36_u8.nsg13_hv_nmos[ide]
print @n.xbgr.xm36_u8.nsg13_hv_nmos[ige]
print @n.xbgr.xm36_u8.nsg13_hv_nmos[ise]
print @n.xbgr.xm36_u8.nsg13_hv_nmos[ibe]
print @n.xbgr.xm36_u8.nsg13_hv_nmos[ctype]
print @n.xbgr.xm36_u9.nsg13_hv_nmos[ide]
print @n.xbgr.xm36_u9.nsg13_hv_nmos[ige]
print @n.xbgr.xm36_u9.nsg13_hv_nmos[ise]
print @n.xbgr.xm36_u9.nsg13_hv_nmos[ibe]
print @n.xbgr.xm36_u9.nsg13_hv_nmos[ctype]
print @n.xbgr.xm36_u10.nsg13_hv_nmos[ide]
print @n.xbgr.xm36_u10.nsg13_hv_nmos[ige]
print @n.xbgr.xm36_u10.nsg13_hv_nmos[ise]
print @n.xbgr.xm36_u10.nsg13_hv_nmos[ibe]
print @n.xbgr.xm36_u10.nsg13_hv_nmos[ctype]
print @n.xbgr.xm36_u11.nsg13_hv_nmos[ide]
print @n.xbgr.xm36_u11.nsg13_hv_nmos[ige]
print @n.xbgr.xm36_u11.nsg13_hv_nmos[ise]
print @n.xbgr.xm36_u11.nsg13_hv_nmos[ibe]
print @n.xbgr.xm36_u11.nsg13_hv_nmos[ctype]
print @n.xbgr.xm36_u12.nsg13_hv_nmos[ide]
print @n.xbgr.xm36_u12.nsg13_hv_nmos[ige]
print @n.xbgr.xm36_u12.nsg13_hv_nmos[ise]
print @n.xbgr.xm36_u12.nsg13_hv_nmos[ibe]
print @n.xbgr.xm36_u12.nsg13_hv_nmos[ctype]
print @n.xbgr.xm36_u13.nsg13_hv_nmos[ide]
print @n.xbgr.xm36_u13.nsg13_hv_nmos[ige]
print @n.xbgr.xm36_u13.nsg13_hv_nmos[ise]
print @n.xbgr.xm36_u13.nsg13_hv_nmos[ibe]
print @n.xbgr.xm36_u13.nsg13_hv_nmos[ctype]
print @n.xbgr.xm36_u14.nsg13_hv_nmos[ide]
print @n.xbgr.xm36_u14.nsg13_hv_nmos[ige]
print @n.xbgr.xm36_u14.nsg13_hv_nmos[ise]
print @n.xbgr.xm36_u14.nsg13_hv_nmos[ibe]
print @n.xbgr.xm36_u14.nsg13_hv_nmos[ctype]
print @n.xbgr.xm36_u15.nsg13_hv_nmos[ide]
print @n.xbgr.xm36_u15.nsg13_hv_nmos[ige]
print @n.xbgr.xm36_u15.nsg13_hv_nmos[ise]
print @n.xbgr.xm36_u15.nsg13_hv_nmos[ibe]
print @n.xbgr.xm36_u15.nsg13_hv_nmos[ctype]
print @n.xbgr.xm36_u16.nsg13_hv_nmos[ide]
print @n.xbgr.xm36_u16.nsg13_hv_nmos[ige]
print @n.xbgr.xm36_u16.nsg13_hv_nmos[ise]
print @n.xbgr.xm36_u16.nsg13_hv_nmos[ibe]
print @n.xbgr.xm36_u16.nsg13_hv_nmos[ctype]
print @n.xbgr.xm36_u17.nsg13_hv_nmos[ide]
print @n.xbgr.xm36_u17.nsg13_hv_nmos[ige]
print @n.xbgr.xm36_u17.nsg13_hv_nmos[ise]
print @n.xbgr.xm36_u17.nsg13_hv_nmos[ibe]
print @n.xbgr.xm36_u17.nsg13_hv_nmos[ctype]
print @n.xbgr.xm36_u18.nsg13_hv_nmos[ide]
print @n.xbgr.xm36_u18.nsg13_hv_nmos[ige]
print @n.xbgr.xm36_u18.nsg13_hv_nmos[ise]
print @n.xbgr.xm36_u18.nsg13_hv_nmos[ibe]
print @n.xbgr.xm36_u18.nsg13_hv_nmos[ctype]
print @n.xbgr.xm36_u19.nsg13_hv_nmos[ide]
print @n.xbgr.xm36_u19.nsg13_hv_nmos[ige]
print @n.xbgr.xm36_u19.nsg13_hv_nmos[ise]
print @n.xbgr.xm36_u19.nsg13_hv_nmos[ibe]
print @n.xbgr.xm36_u19.nsg13_hv_nmos[ctype]
print @n.xbgr.xm36_u20.nsg13_hv_nmos[ide]
print @n.xbgr.xm36_u20.nsg13_hv_nmos[ige]
print @n.xbgr.xm36_u20.nsg13_hv_nmos[ise]
print @n.xbgr.xm36_u20.nsg13_hv_nmos[ibe]
print @n.xbgr.xm36_u20.nsg13_hv_nmos[ctype]
print @n.xbgr.xm36_u21.nsg13_hv_nmos[ide]
print @n.xbgr.xm36_u21.nsg13_hv_nmos[ige]
print @n.xbgr.xm36_u21.nsg13_hv_nmos[ise]
print @n.xbgr.xm36_u21.nsg13_hv_nmos[ibe]
print @n.xbgr.xm36_u21.nsg13_hv_nmos[ctype]
print @n.xbgr.xm36_u22.nsg13_hv_nmos[ide]
print @n.xbgr.xm36_u22.nsg13_hv_nmos[ige]
print @n.xbgr.xm36_u22.nsg13_hv_nmos[ise]
print @n.xbgr.xm36_u22.nsg13_hv_nmos[ibe]
print @n.xbgr.xm36_u22.nsg13_hv_nmos[ctype]
print @n.xbgr.xm36_u23.nsg13_hv_nmos[ide]
print @n.xbgr.xm36_u23.nsg13_hv_nmos[ige]
print @n.xbgr.xm36_u23.nsg13_hv_nmos[ise]
print @n.xbgr.xm36_u23.nsg13_hv_nmos[ibe]
print @n.xbgr.xm36_u23.nsg13_hv_nmos[ctype]
print @n.xbgr.xm36_u24.nsg13_hv_nmos[ide]
print @n.xbgr.xm36_u24.nsg13_hv_nmos[ige]
print @n.xbgr.xm36_u24.nsg13_hv_nmos[ise]
print @n.xbgr.xm36_u24.nsg13_hv_nmos[ibe]
print @n.xbgr.xm36_u24.nsg13_hv_nmos[ctype]
print @n.xbgr.xm37_u2.nsg13_hv_nmos[ide]
print @n.xbgr.xm37_u2.nsg13_hv_nmos[ige]
print @n.xbgr.xm37_u2.nsg13_hv_nmos[ise]
print @n.xbgr.xm37_u2.nsg13_hv_nmos[ibe]
print @n.xbgr.xm37_u2.nsg13_hv_nmos[ctype]
print @n.xbgr.xm37_u3.nsg13_hv_nmos[ide]
print @n.xbgr.xm37_u3.nsg13_hv_nmos[ige]
print @n.xbgr.xm37_u3.nsg13_hv_nmos[ise]
print @n.xbgr.xm37_u3.nsg13_hv_nmos[ibe]
print @n.xbgr.xm37_u3.nsg13_hv_nmos[ctype]
print @n.xbgr.xm37_u4.nsg13_hv_nmos[ide]
print @n.xbgr.xm37_u4.nsg13_hv_nmos[ige]
print @n.xbgr.xm37_u4.nsg13_hv_nmos[ise]
print @n.xbgr.xm37_u4.nsg13_hv_nmos[ibe]
print @n.xbgr.xm37_u4.nsg13_hv_nmos[ctype]
print @n.xbgr.xm37_u5.nsg13_hv_nmos[ide]
print @n.xbgr.xm37_u5.nsg13_hv_nmos[ige]
print @n.xbgr.xm37_u5.nsg13_hv_nmos[ise]
print @n.xbgr.xm37_u5.nsg13_hv_nmos[ibe]
print @n.xbgr.xm37_u5.nsg13_hv_nmos[ctype]
print @n.xbgr.xm37_u6.nsg13_hv_nmos[ide]
print @n.xbgr.xm37_u6.nsg13_hv_nmos[ige]
print @n.xbgr.xm37_u6.nsg13_hv_nmos[ise]
print @n.xbgr.xm37_u6.nsg13_hv_nmos[ibe]
print @n.xbgr.xm37_u6.nsg13_hv_nmos[ctype]
print @n.xbgr.xm37_u7.nsg13_hv_nmos[ide]
print @n.xbgr.xm37_u7.nsg13_hv_nmos[ige]
print @n.xbgr.xm37_u7.nsg13_hv_nmos[ise]
print @n.xbgr.xm37_u7.nsg13_hv_nmos[ibe]
print @n.xbgr.xm37_u7.nsg13_hv_nmos[ctype]
print @n.xbgr.xm37_u8.nsg13_hv_nmos[ide]
print @n.xbgr.xm37_u8.nsg13_hv_nmos[ige]
print @n.xbgr.xm37_u8.nsg13_hv_nmos[ise]
print @n.xbgr.xm37_u8.nsg13_hv_nmos[ibe]
print @n.xbgr.xm37_u8.nsg13_hv_nmos[ctype]
print @n.xbgr.xm37_u9.nsg13_hv_nmos[ide]
print @n.xbgr.xm37_u9.nsg13_hv_nmos[ige]
print @n.xbgr.xm37_u9.nsg13_hv_nmos[ise]
print @n.xbgr.xm37_u9.nsg13_hv_nmos[ibe]
print @n.xbgr.xm37_u9.nsg13_hv_nmos[ctype]
print @n.xbgr.xm37_u10.nsg13_hv_nmos[ide]
print @n.xbgr.xm37_u10.nsg13_hv_nmos[ige]
print @n.xbgr.xm37_u10.nsg13_hv_nmos[ise]
print @n.xbgr.xm37_u10.nsg13_hv_nmos[ibe]
print @n.xbgr.xm37_u10.nsg13_hv_nmos[ctype]
print @n.xbgr.xm37_u11.nsg13_hv_nmos[ide]
print @n.xbgr.xm37_u11.nsg13_hv_nmos[ige]
print @n.xbgr.xm37_u11.nsg13_hv_nmos[ise]
print @n.xbgr.xm37_u11.nsg13_hv_nmos[ibe]
print @n.xbgr.xm37_u11.nsg13_hv_nmos[ctype]
print @n.xbgr.xm37_u12.nsg13_hv_nmos[ide]
print @n.xbgr.xm37_u12.nsg13_hv_nmos[ige]
print @n.xbgr.xm37_u12.nsg13_hv_nmos[ise]
print @n.xbgr.xm37_u12.nsg13_hv_nmos[ibe]
print @n.xbgr.xm37_u12.nsg13_hv_nmos[ctype]
print @n.xbgr.xm37_u13.nsg13_hv_nmos[ide]
print @n.xbgr.xm37_u13.nsg13_hv_nmos[ige]
print @n.xbgr.xm37_u13.nsg13_hv_nmos[ise]
print @n.xbgr.xm37_u13.nsg13_hv_nmos[ibe]
print @n.xbgr.xm37_u13.nsg13_hv_nmos[ctype]
print @n.xbgr.xm37_u14.nsg13_hv_nmos[ide]
print @n.xbgr.xm37_u14.nsg13_hv_nmos[ige]
print @n.xbgr.xm37_u14.nsg13_hv_nmos[ise]
print @n.xbgr.xm37_u14.nsg13_hv_nmos[ibe]
print @n.xbgr.xm37_u14.nsg13_hv_nmos[ctype]
print @n.xbgr.xm37_u15.nsg13_hv_nmos[ide]
print @n.xbgr.xm37_u15.nsg13_hv_nmos[ige]
print @n.xbgr.xm37_u15.nsg13_hv_nmos[ise]
print @n.xbgr.xm37_u15.nsg13_hv_nmos[ibe]
print @n.xbgr.xm37_u15.nsg13_hv_nmos[ctype]
print @n.xbgr.xm37_u16.nsg13_hv_nmos[ide]
print @n.xbgr.xm37_u16.nsg13_hv_nmos[ige]
print @n.xbgr.xm37_u16.nsg13_hv_nmos[ise]
print @n.xbgr.xm37_u16.nsg13_hv_nmos[ibe]
print @n.xbgr.xm37_u16.nsg13_hv_nmos[ctype]
print @n.xbgr.xm37_u17.nsg13_hv_nmos[ide]
print @n.xbgr.xm37_u17.nsg13_hv_nmos[ige]
print @n.xbgr.xm37_u17.nsg13_hv_nmos[ise]
print @n.xbgr.xm37_u17.nsg13_hv_nmos[ibe]
print @n.xbgr.xm37_u17.nsg13_hv_nmos[ctype]
print @n.xbgr.xm37_u18.nsg13_hv_nmos[ide]
print @n.xbgr.xm37_u18.nsg13_hv_nmos[ige]
print @n.xbgr.xm37_u18.nsg13_hv_nmos[ise]
print @n.xbgr.xm37_u18.nsg13_hv_nmos[ibe]
print @n.xbgr.xm37_u18.nsg13_hv_nmos[ctype]
print @n.xbgr.xm37_u19.nsg13_hv_nmos[ide]
print @n.xbgr.xm37_u19.nsg13_hv_nmos[ige]
print @n.xbgr.xm37_u19.nsg13_hv_nmos[ise]
print @n.xbgr.xm37_u19.nsg13_hv_nmos[ibe]
print @n.xbgr.xm37_u19.nsg13_hv_nmos[ctype]
print @n.xbgr.xm37_u20.nsg13_hv_nmos[ide]
print @n.xbgr.xm37_u20.nsg13_hv_nmos[ige]
print @n.xbgr.xm37_u20.nsg13_hv_nmos[ise]
print @n.xbgr.xm37_u20.nsg13_hv_nmos[ibe]
print @n.xbgr.xm37_u20.nsg13_hv_nmos[ctype]
print @n.xbgr.xm37_u21.nsg13_hv_nmos[ide]
print @n.xbgr.xm37_u21.nsg13_hv_nmos[ige]
print @n.xbgr.xm37_u21.nsg13_hv_nmos[ise]
print @n.xbgr.xm37_u21.nsg13_hv_nmos[ibe]
print @n.xbgr.xm37_u21.nsg13_hv_nmos[ctype]
print @n.xbgr.xm37_u22.nsg13_hv_nmos[ide]
print @n.xbgr.xm37_u22.nsg13_hv_nmos[ige]
print @n.xbgr.xm37_u22.nsg13_hv_nmos[ise]
print @n.xbgr.xm37_u22.nsg13_hv_nmos[ibe]
print @n.xbgr.xm37_u22.nsg13_hv_nmos[ctype]
print @n.xbgr.xm37_u23.nsg13_hv_nmos[ide]
print @n.xbgr.xm37_u23.nsg13_hv_nmos[ige]
print @n.xbgr.xm37_u23.nsg13_hv_nmos[ise]
print @n.xbgr.xm37_u23.nsg13_hv_nmos[ibe]
print @n.xbgr.xm37_u23.nsg13_hv_nmos[ctype]
print @n.xbgr.xm37_u24.nsg13_hv_nmos[ide]
print @n.xbgr.xm37_u24.nsg13_hv_nmos[ige]
print @n.xbgr.xm37_u24.nsg13_hv_nmos[ise]
print @n.xbgr.xm37_u24.nsg13_hv_nmos[ibe]
print @n.xbgr.xm37_u24.nsg13_hv_nmos[ctype]
print @n.xbgr.xm38_u2.nsg13_hv_pmos[ide]
print @n.xbgr.xm38_u2.nsg13_hv_pmos[ige]
print @n.xbgr.xm38_u2.nsg13_hv_pmos[ise]
print @n.xbgr.xm38_u2.nsg13_hv_pmos[ibe]
print @n.xbgr.xm38_u2.nsg13_hv_pmos[ctype]
print @n.xbgr.xm38_u3.nsg13_hv_pmos[ide]
print @n.xbgr.xm38_u3.nsg13_hv_pmos[ige]
print @n.xbgr.xm38_u3.nsg13_hv_pmos[ise]
print @n.xbgr.xm38_u3.nsg13_hv_pmos[ibe]
print @n.xbgr.xm38_u3.nsg13_hv_pmos[ctype]
print @n.xbgr.xm38_u4.nsg13_hv_pmos[ide]
print @n.xbgr.xm38_u4.nsg13_hv_pmos[ige]
print @n.xbgr.xm38_u4.nsg13_hv_pmos[ise]
print @n.xbgr.xm38_u4.nsg13_hv_pmos[ibe]
print @n.xbgr.xm38_u4.nsg13_hv_pmos[ctype]
print @n.xbgr.xm38_u5.nsg13_hv_pmos[ide]
print @n.xbgr.xm38_u5.nsg13_hv_pmos[ige]
print @n.xbgr.xm38_u5.nsg13_hv_pmos[ise]
print @n.xbgr.xm38_u5.nsg13_hv_pmos[ibe]
print @n.xbgr.xm38_u5.nsg13_hv_pmos[ctype]
print @n.xbgr.xm38_u6.nsg13_hv_pmos[ide]
print @n.xbgr.xm38_u6.nsg13_hv_pmos[ige]
print @n.xbgr.xm38_u6.nsg13_hv_pmos[ise]
print @n.xbgr.xm38_u6.nsg13_hv_pmos[ibe]
print @n.xbgr.xm38_u6.nsg13_hv_pmos[ctype]
print @n.xbgr.xm38_u7.nsg13_hv_pmos[ide]
print @n.xbgr.xm38_u7.nsg13_hv_pmos[ige]
print @n.xbgr.xm38_u7.nsg13_hv_pmos[ise]
print @n.xbgr.xm38_u7.nsg13_hv_pmos[ibe]
print @n.xbgr.xm38_u7.nsg13_hv_pmos[ctype]
print @n.xbgr.xm38_u8.nsg13_hv_pmos[ide]
print @n.xbgr.xm38_u8.nsg13_hv_pmos[ige]
print @n.xbgr.xm38_u8.nsg13_hv_pmos[ise]
print @n.xbgr.xm38_u8.nsg13_hv_pmos[ibe]
print @n.xbgr.xm38_u8.nsg13_hv_pmos[ctype]
print @n.xbgr.xm38_u9.nsg13_hv_pmos[ide]
print @n.xbgr.xm38_u9.nsg13_hv_pmos[ige]
print @n.xbgr.xm38_u9.nsg13_hv_pmos[ise]
print @n.xbgr.xm38_u9.nsg13_hv_pmos[ibe]
print @n.xbgr.xm38_u9.nsg13_hv_pmos[ctype]
print @n.xbgr.xm38_u10.nsg13_hv_pmos[ide]
print @n.xbgr.xm38_u10.nsg13_hv_pmos[ige]
print @n.xbgr.xm38_u10.nsg13_hv_pmos[ise]
print @n.xbgr.xm38_u10.nsg13_hv_pmos[ibe]
print @n.xbgr.xm38_u10.nsg13_hv_pmos[ctype]
print @n.xbgr.xm38_u11.nsg13_hv_pmos[ide]
print @n.xbgr.xm38_u11.nsg13_hv_pmos[ige]
print @n.xbgr.xm38_u11.nsg13_hv_pmos[ise]
print @n.xbgr.xm38_u11.nsg13_hv_pmos[ibe]
print @n.xbgr.xm38_u11.nsg13_hv_pmos[ctype]
print @n.xbgr.xm38_u12.nsg13_hv_pmos[ide]
print @n.xbgr.xm38_u12.nsg13_hv_pmos[ige]
print @n.xbgr.xm38_u12.nsg13_hv_pmos[ise]
print @n.xbgr.xm38_u12.nsg13_hv_pmos[ibe]
print @n.xbgr.xm38_u12.nsg13_hv_pmos[ctype]
print @n.xbgr.xm38_u13.nsg13_hv_pmos[ide]
print @n.xbgr.xm38_u13.nsg13_hv_pmos[ige]
print @n.xbgr.xm38_u13.nsg13_hv_pmos[ise]
print @n.xbgr.xm38_u13.nsg13_hv_pmos[ibe]
print @n.xbgr.xm38_u13.nsg13_hv_pmos[ctype]
print @n.xbgr.xm38_u14.nsg13_hv_pmos[ide]
print @n.xbgr.xm38_u14.nsg13_hv_pmos[ige]
print @n.xbgr.xm38_u14.nsg13_hv_pmos[ise]
print @n.xbgr.xm38_u14.nsg13_hv_pmos[ibe]
print @n.xbgr.xm38_u14.nsg13_hv_pmos[ctype]
print @n.xbgr.xm38_u15.nsg13_hv_pmos[ide]
print @n.xbgr.xm38_u15.nsg13_hv_pmos[ige]
print @n.xbgr.xm38_u15.nsg13_hv_pmos[ise]
print @n.xbgr.xm38_u15.nsg13_hv_pmos[ibe]
print @n.xbgr.xm38_u15.nsg13_hv_pmos[ctype]
print @n.xbgr.xm38_u16.nsg13_hv_pmos[ide]
print @n.xbgr.xm38_u16.nsg13_hv_pmos[ige]
print @n.xbgr.xm38_u16.nsg13_hv_pmos[ise]
print @n.xbgr.xm38_u16.nsg13_hv_pmos[ibe]
print @n.xbgr.xm38_u16.nsg13_hv_pmos[ctype]
print @n.xbgr.xm38_u17.nsg13_hv_pmos[ide]
print @n.xbgr.xm38_u17.nsg13_hv_pmos[ige]
print @n.xbgr.xm38_u17.nsg13_hv_pmos[ise]
print @n.xbgr.xm38_u17.nsg13_hv_pmos[ibe]
print @n.xbgr.xm38_u17.nsg13_hv_pmos[ctype]
print @n.xbgr.xm38_u18.nsg13_hv_pmos[ide]
print @n.xbgr.xm38_u18.nsg13_hv_pmos[ige]
print @n.xbgr.xm38_u18.nsg13_hv_pmos[ise]
print @n.xbgr.xm38_u18.nsg13_hv_pmos[ibe]
print @n.xbgr.xm38_u18.nsg13_hv_pmos[ctype]
print @n.xbgr.xm38_u19.nsg13_hv_pmos[ide]
print @n.xbgr.xm38_u19.nsg13_hv_pmos[ige]
print @n.xbgr.xm38_u19.nsg13_hv_pmos[ise]
print @n.xbgr.xm38_u19.nsg13_hv_pmos[ibe]
print @n.xbgr.xm38_u19.nsg13_hv_pmos[ctype]
print @n.xbgr.xm38_u20.nsg13_hv_pmos[ide]
print @n.xbgr.xm38_u20.nsg13_hv_pmos[ige]
print @n.xbgr.xm38_u20.nsg13_hv_pmos[ise]
print @n.xbgr.xm38_u20.nsg13_hv_pmos[ibe]
print @n.xbgr.xm38_u20.nsg13_hv_pmos[ctype]
print @n.xbgr.xm38_u21.nsg13_hv_pmos[ide]
print @n.xbgr.xm38_u21.nsg13_hv_pmos[ige]
print @n.xbgr.xm38_u21.nsg13_hv_pmos[ise]
print @n.xbgr.xm38_u21.nsg13_hv_pmos[ibe]
print @n.xbgr.xm38_u21.nsg13_hv_pmos[ctype]
print @n.xbgr.xm38_u22.nsg13_hv_pmos[ide]
print @n.xbgr.xm38_u22.nsg13_hv_pmos[ige]
print @n.xbgr.xm38_u22.nsg13_hv_pmos[ise]
print @n.xbgr.xm38_u22.nsg13_hv_pmos[ibe]
print @n.xbgr.xm38_u22.nsg13_hv_pmos[ctype]
print @n.xbgr.xm38_u23.nsg13_hv_pmos[ide]
print @n.xbgr.xm38_u23.nsg13_hv_pmos[ige]
print @n.xbgr.xm38_u23.nsg13_hv_pmos[ise]
print @n.xbgr.xm38_u23.nsg13_hv_pmos[ibe]
print @n.xbgr.xm38_u23.nsg13_hv_pmos[ctype]
print @n.xbgr.xm38_u24.nsg13_hv_pmos[ide]
print @n.xbgr.xm38_u24.nsg13_hv_pmos[ige]
print @n.xbgr.xm38_u24.nsg13_hv_pmos[ise]
print @n.xbgr.xm38_u24.nsg13_hv_pmos[ibe]
print @n.xbgr.xm38_u24.nsg13_hv_pmos[ctype]
print @n.xbgr.xm39_u2.nsg13_hv_pmos[ide]
print @n.xbgr.xm39_u2.nsg13_hv_pmos[ige]
print @n.xbgr.xm39_u2.nsg13_hv_pmos[ise]
print @n.xbgr.xm39_u2.nsg13_hv_pmos[ibe]
print @n.xbgr.xm39_u2.nsg13_hv_pmos[ctype]
print @n.xbgr.xm39_u3.nsg13_hv_pmos[ide]
print @n.xbgr.xm39_u3.nsg13_hv_pmos[ige]
print @n.xbgr.xm39_u3.nsg13_hv_pmos[ise]
print @n.xbgr.xm39_u3.nsg13_hv_pmos[ibe]
print @n.xbgr.xm39_u3.nsg13_hv_pmos[ctype]
print @n.xbgr.xm39_u4.nsg13_hv_pmos[ide]
print @n.xbgr.xm39_u4.nsg13_hv_pmos[ige]
print @n.xbgr.xm39_u4.nsg13_hv_pmos[ise]
print @n.xbgr.xm39_u4.nsg13_hv_pmos[ibe]
print @n.xbgr.xm39_u4.nsg13_hv_pmos[ctype]
print @n.xbgr.xm39_u5.nsg13_hv_pmos[ide]
print @n.xbgr.xm39_u5.nsg13_hv_pmos[ige]
print @n.xbgr.xm39_u5.nsg13_hv_pmos[ise]
print @n.xbgr.xm39_u5.nsg13_hv_pmos[ibe]
print @n.xbgr.xm39_u5.nsg13_hv_pmos[ctype]
print @n.xbgr.xm39_u6.nsg13_hv_pmos[ide]
print @n.xbgr.xm39_u6.nsg13_hv_pmos[ige]
print @n.xbgr.xm39_u6.nsg13_hv_pmos[ise]
print @n.xbgr.xm39_u6.nsg13_hv_pmos[ibe]
print @n.xbgr.xm39_u6.nsg13_hv_pmos[ctype]
print @n.xbgr.xm39_u7.nsg13_hv_pmos[ide]
print @n.xbgr.xm39_u7.nsg13_hv_pmos[ige]
print @n.xbgr.xm39_u7.nsg13_hv_pmos[ise]
print @n.xbgr.xm39_u7.nsg13_hv_pmos[ibe]
print @n.xbgr.xm39_u7.nsg13_hv_pmos[ctype]
print @n.xbgr.xm39_u8.nsg13_hv_pmos[ide]
print @n.xbgr.xm39_u8.nsg13_hv_pmos[ige]
print @n.xbgr.xm39_u8.nsg13_hv_pmos[ise]
print @n.xbgr.xm39_u8.nsg13_hv_pmos[ibe]
print @n.xbgr.xm39_u8.nsg13_hv_pmos[ctype]
print @n.xbgr.xm39_u9.nsg13_hv_pmos[ide]
print @n.xbgr.xm39_u9.nsg13_hv_pmos[ige]
print @n.xbgr.xm39_u9.nsg13_hv_pmos[ise]
print @n.xbgr.xm39_u9.nsg13_hv_pmos[ibe]
print @n.xbgr.xm39_u9.nsg13_hv_pmos[ctype]
print @n.xbgr.xm39_u10.nsg13_hv_pmos[ide]
print @n.xbgr.xm39_u10.nsg13_hv_pmos[ige]
print @n.xbgr.xm39_u10.nsg13_hv_pmos[ise]
print @n.xbgr.xm39_u10.nsg13_hv_pmos[ibe]
print @n.xbgr.xm39_u10.nsg13_hv_pmos[ctype]
print @n.xbgr.xm39_u11.nsg13_hv_pmos[ide]
print @n.xbgr.xm39_u11.nsg13_hv_pmos[ige]
print @n.xbgr.xm39_u11.nsg13_hv_pmos[ise]
print @n.xbgr.xm39_u11.nsg13_hv_pmos[ibe]
print @n.xbgr.xm39_u11.nsg13_hv_pmos[ctype]
print @n.xbgr.xm39_u12.nsg13_hv_pmos[ide]
print @n.xbgr.xm39_u12.nsg13_hv_pmos[ige]
print @n.xbgr.xm39_u12.nsg13_hv_pmos[ise]
print @n.xbgr.xm39_u12.nsg13_hv_pmos[ibe]
print @n.xbgr.xm39_u12.nsg13_hv_pmos[ctype]
print @n.xbgr.xm39_u13.nsg13_hv_pmos[ide]
print @n.xbgr.xm39_u13.nsg13_hv_pmos[ige]
print @n.xbgr.xm39_u13.nsg13_hv_pmos[ise]
print @n.xbgr.xm39_u13.nsg13_hv_pmos[ibe]
print @n.xbgr.xm39_u13.nsg13_hv_pmos[ctype]
print @n.xbgr.xm39_u14.nsg13_hv_pmos[ide]
print @n.xbgr.xm39_u14.nsg13_hv_pmos[ige]
print @n.xbgr.xm39_u14.nsg13_hv_pmos[ise]
print @n.xbgr.xm39_u14.nsg13_hv_pmos[ibe]
print @n.xbgr.xm39_u14.nsg13_hv_pmos[ctype]
print @n.xbgr.xm39_u15.nsg13_hv_pmos[ide]
print @n.xbgr.xm39_u15.nsg13_hv_pmos[ige]
print @n.xbgr.xm39_u15.nsg13_hv_pmos[ise]
print @n.xbgr.xm39_u15.nsg13_hv_pmos[ibe]
print @n.xbgr.xm39_u15.nsg13_hv_pmos[ctype]
print @n.xbgr.xm39_u16.nsg13_hv_pmos[ide]
print @n.xbgr.xm39_u16.nsg13_hv_pmos[ige]
print @n.xbgr.xm39_u16.nsg13_hv_pmos[ise]
print @n.xbgr.xm39_u16.nsg13_hv_pmos[ibe]
print @n.xbgr.xm39_u16.nsg13_hv_pmos[ctype]
print @n.xbgr.xm39_u17.nsg13_hv_pmos[ide]
print @n.xbgr.xm39_u17.nsg13_hv_pmos[ige]
print @n.xbgr.xm39_u17.nsg13_hv_pmos[ise]
print @n.xbgr.xm39_u17.nsg13_hv_pmos[ibe]
print @n.xbgr.xm39_u17.nsg13_hv_pmos[ctype]
print @n.xbgr.xm39_u18.nsg13_hv_pmos[ide]
print @n.xbgr.xm39_u18.nsg13_hv_pmos[ige]
print @n.xbgr.xm39_u18.nsg13_hv_pmos[ise]
print @n.xbgr.xm39_u18.nsg13_hv_pmos[ibe]
print @n.xbgr.xm39_u18.nsg13_hv_pmos[ctype]
print @n.xbgr.xm39_u19.nsg13_hv_pmos[ide]
print @n.xbgr.xm39_u19.nsg13_hv_pmos[ige]
print @n.xbgr.xm39_u19.nsg13_hv_pmos[ise]
print @n.xbgr.xm39_u19.nsg13_hv_pmos[ibe]
print @n.xbgr.xm39_u19.nsg13_hv_pmos[ctype]
print @n.xbgr.xm39_u20.nsg13_hv_pmos[ide]
print @n.xbgr.xm39_u20.nsg13_hv_pmos[ige]
print @n.xbgr.xm39_u20.nsg13_hv_pmos[ise]
print @n.xbgr.xm39_u20.nsg13_hv_pmos[ibe]
print @n.xbgr.xm39_u20.nsg13_hv_pmos[ctype]
print @n.xbgr.xm39_u21.nsg13_hv_pmos[ide]
print @n.xbgr.xm39_u21.nsg13_hv_pmos[ige]
print @n.xbgr.xm39_u21.nsg13_hv_pmos[ise]
print @n.xbgr.xm39_u21.nsg13_hv_pmos[ibe]
print @n.xbgr.xm39_u21.nsg13_hv_pmos[ctype]
print @n.xbgr.xm39_u22.nsg13_hv_pmos[ide]
print @n.xbgr.xm39_u22.nsg13_hv_pmos[ige]
print @n.xbgr.xm39_u22.nsg13_hv_pmos[ise]
print @n.xbgr.xm39_u22.nsg13_hv_pmos[ibe]
print @n.xbgr.xm39_u22.nsg13_hv_pmos[ctype]
print @n.xbgr.xm39_u23.nsg13_hv_pmos[ide]
print @n.xbgr.xm39_u23.nsg13_hv_pmos[ige]
print @n.xbgr.xm39_u23.nsg13_hv_pmos[ise]
print @n.xbgr.xm39_u23.nsg13_hv_pmos[ibe]
print @n.xbgr.xm39_u23.nsg13_hv_pmos[ctype]
print @n.xbgr.xm39_u24.nsg13_hv_pmos[ide]
print @n.xbgr.xm39_u24.nsg13_hv_pmos[ige]
print @n.xbgr.xm39_u24.nsg13_hv_pmos[ise]
print @n.xbgr.xm39_u24.nsg13_hv_pmos[ibe]
print @n.xbgr.xm39_u24.nsg13_hv_pmos[ctype]
print @n.xbgr.xm41_u2.nsg13_hv_pmos[ide]
print @n.xbgr.xm41_u2.nsg13_hv_pmos[ige]
print @n.xbgr.xm41_u2.nsg13_hv_pmos[ise]
print @n.xbgr.xm41_u2.nsg13_hv_pmos[ibe]
print @n.xbgr.xm41_u2.nsg13_hv_pmos[ctype]
print @n.xbgr.xm41_u3.nsg13_hv_pmos[ide]
print @n.xbgr.xm41_u3.nsg13_hv_pmos[ige]
print @n.xbgr.xm41_u3.nsg13_hv_pmos[ise]
print @n.xbgr.xm41_u3.nsg13_hv_pmos[ibe]
print @n.xbgr.xm41_u3.nsg13_hv_pmos[ctype]
print @n.xbgr.xm41_u4.nsg13_hv_pmos[ide]
print @n.xbgr.xm41_u4.nsg13_hv_pmos[ige]
print @n.xbgr.xm41_u4.nsg13_hv_pmos[ise]
print @n.xbgr.xm41_u4.nsg13_hv_pmos[ibe]
print @n.xbgr.xm41_u4.nsg13_hv_pmos[ctype]
print @n.xbgr.xm41_u5.nsg13_hv_pmos[ide]
print @n.xbgr.xm41_u5.nsg13_hv_pmos[ige]
print @n.xbgr.xm41_u5.nsg13_hv_pmos[ise]
print @n.xbgr.xm41_u5.nsg13_hv_pmos[ibe]
print @n.xbgr.xm41_u5.nsg13_hv_pmos[ctype]
print @n.xbgr.xm41_u6.nsg13_hv_pmos[ide]
print @n.xbgr.xm41_u6.nsg13_hv_pmos[ige]
print @n.xbgr.xm41_u6.nsg13_hv_pmos[ise]
print @n.xbgr.xm41_u6.nsg13_hv_pmos[ibe]
print @n.xbgr.xm41_u6.nsg13_hv_pmos[ctype]
print @n.xbgr.xm41_u7.nsg13_hv_pmos[ide]
print @n.xbgr.xm41_u7.nsg13_hv_pmos[ige]
print @n.xbgr.xm41_u7.nsg13_hv_pmos[ise]
print @n.xbgr.xm41_u7.nsg13_hv_pmos[ibe]
print @n.xbgr.xm41_u7.nsg13_hv_pmos[ctype]
print @n.xbgr.xm41_u8.nsg13_hv_pmos[ide]
print @n.xbgr.xm41_u8.nsg13_hv_pmos[ige]
print @n.xbgr.xm41_u8.nsg13_hv_pmos[ise]
print @n.xbgr.xm41_u8.nsg13_hv_pmos[ibe]
print @n.xbgr.xm41_u8.nsg13_hv_pmos[ctype]
print @n.xbgr.xm41_u9.nsg13_hv_pmos[ide]
print @n.xbgr.xm41_u9.nsg13_hv_pmos[ige]
print @n.xbgr.xm41_u9.nsg13_hv_pmos[ise]
print @n.xbgr.xm41_u9.nsg13_hv_pmos[ibe]
print @n.xbgr.xm41_u9.nsg13_hv_pmos[ctype]
print @n.xbgr.xm41_u10.nsg13_hv_pmos[ide]
print @n.xbgr.xm41_u10.nsg13_hv_pmos[ige]
print @n.xbgr.xm41_u10.nsg13_hv_pmos[ise]
print @n.xbgr.xm41_u10.nsg13_hv_pmos[ibe]
print @n.xbgr.xm41_u10.nsg13_hv_pmos[ctype]
print @n.xbgr.xm41_u11.nsg13_hv_pmos[ide]
print @n.xbgr.xm41_u11.nsg13_hv_pmos[ige]
print @n.xbgr.xm41_u11.nsg13_hv_pmos[ise]
print @n.xbgr.xm41_u11.nsg13_hv_pmos[ibe]
print @n.xbgr.xm41_u11.nsg13_hv_pmos[ctype]
print @n.xbgr.xm41_u12.nsg13_hv_pmos[ide]
print @n.xbgr.xm41_u12.nsg13_hv_pmos[ige]
print @n.xbgr.xm41_u12.nsg13_hv_pmos[ise]
print @n.xbgr.xm41_u12.nsg13_hv_pmos[ibe]
print @n.xbgr.xm41_u12.nsg13_hv_pmos[ctype]
print @n.xbgr.xm41_u13.nsg13_hv_pmos[ide]
print @n.xbgr.xm41_u13.nsg13_hv_pmos[ige]
print @n.xbgr.xm41_u13.nsg13_hv_pmos[ise]
print @n.xbgr.xm41_u13.nsg13_hv_pmos[ibe]
print @n.xbgr.xm41_u13.nsg13_hv_pmos[ctype]
print @n.xbgr.xm41_u14.nsg13_hv_pmos[ide]
print @n.xbgr.xm41_u14.nsg13_hv_pmos[ige]
print @n.xbgr.xm41_u14.nsg13_hv_pmos[ise]
print @n.xbgr.xm41_u14.nsg13_hv_pmos[ibe]
print @n.xbgr.xm41_u14.nsg13_hv_pmos[ctype]
print @n.xbgr.xm41_u15.nsg13_hv_pmos[ide]
print @n.xbgr.xm41_u15.nsg13_hv_pmos[ige]
print @n.xbgr.xm41_u15.nsg13_hv_pmos[ise]
print @n.xbgr.xm41_u15.nsg13_hv_pmos[ibe]
print @n.xbgr.xm41_u15.nsg13_hv_pmos[ctype]
print @n.xbgr.xm41_u16.nsg13_hv_pmos[ide]
print @n.xbgr.xm41_u16.nsg13_hv_pmos[ige]
print @n.xbgr.xm41_u16.nsg13_hv_pmos[ise]
print @n.xbgr.xm41_u16.nsg13_hv_pmos[ibe]
print @n.xbgr.xm41_u16.nsg13_hv_pmos[ctype]
print @n.xbgr.xm41_u17.nsg13_hv_pmos[ide]
print @n.xbgr.xm41_u17.nsg13_hv_pmos[ige]
print @n.xbgr.xm41_u17.nsg13_hv_pmos[ise]
print @n.xbgr.xm41_u17.nsg13_hv_pmos[ibe]
print @n.xbgr.xm41_u17.nsg13_hv_pmos[ctype]
print @n.xbgr.xm41_u18.nsg13_hv_pmos[ide]
print @n.xbgr.xm41_u18.nsg13_hv_pmos[ige]
print @n.xbgr.xm41_u18.nsg13_hv_pmos[ise]
print @n.xbgr.xm41_u18.nsg13_hv_pmos[ibe]
print @n.xbgr.xm41_u18.nsg13_hv_pmos[ctype]
print @n.xbgr.xm41_u19.nsg13_hv_pmos[ide]
print @n.xbgr.xm41_u19.nsg13_hv_pmos[ige]
print @n.xbgr.xm41_u19.nsg13_hv_pmos[ise]
print @n.xbgr.xm41_u19.nsg13_hv_pmos[ibe]
print @n.xbgr.xm41_u19.nsg13_hv_pmos[ctype]
print @n.xbgr.xm41_u20.nsg13_hv_pmos[ide]
print @n.xbgr.xm41_u20.nsg13_hv_pmos[ige]
print @n.xbgr.xm41_u20.nsg13_hv_pmos[ise]
print @n.xbgr.xm41_u20.nsg13_hv_pmos[ibe]
print @n.xbgr.xm41_u20.nsg13_hv_pmos[ctype]
print @n.xbgr.xm41_u21.nsg13_hv_pmos[ide]
print @n.xbgr.xm41_u21.nsg13_hv_pmos[ige]
print @n.xbgr.xm41_u21.nsg13_hv_pmos[ise]
print @n.xbgr.xm41_u21.nsg13_hv_pmos[ibe]
print @n.xbgr.xm41_u21.nsg13_hv_pmos[ctype]
print @n.xbgr.xm41_u22.nsg13_hv_pmos[ide]
print @n.xbgr.xm41_u22.nsg13_hv_pmos[ige]
print @n.xbgr.xm41_u22.nsg13_hv_pmos[ise]
print @n.xbgr.xm41_u22.nsg13_hv_pmos[ibe]
print @n.xbgr.xm41_u22.nsg13_hv_pmos[ctype]
print @n.xbgr.xm41_u23.nsg13_hv_pmos[ide]
print @n.xbgr.xm41_u23.nsg13_hv_pmos[ige]
print @n.xbgr.xm41_u23.nsg13_hv_pmos[ise]
print @n.xbgr.xm41_u23.nsg13_hv_pmos[ibe]
print @n.xbgr.xm41_u23.nsg13_hv_pmos[ctype]
print @n.xbgr.xm41_u24.nsg13_hv_pmos[ide]
print @n.xbgr.xm41_u24.nsg13_hv_pmos[ige]
print @n.xbgr.xm41_u24.nsg13_hv_pmos[ise]
print @n.xbgr.xm41_u24.nsg13_hv_pmos[ibe]
print @n.xbgr.xm41_u24.nsg13_hv_pmos[ctype]
print @n.xbgr.xm43_u2.nsg13_hv_pmos[ide]
print @n.xbgr.xm43_u2.nsg13_hv_pmos[ige]
print @n.xbgr.xm43_u2.nsg13_hv_pmos[ise]
print @n.xbgr.xm43_u2.nsg13_hv_pmos[ibe]
print @n.xbgr.xm43_u2.nsg13_hv_pmos[ctype]
print @n.xbgr.xm43_u3.nsg13_hv_pmos[ide]
print @n.xbgr.xm43_u3.nsg13_hv_pmos[ige]
print @n.xbgr.xm43_u3.nsg13_hv_pmos[ise]
print @n.xbgr.xm43_u3.nsg13_hv_pmos[ibe]
print @n.xbgr.xm43_u3.nsg13_hv_pmos[ctype]
print @n.xbgr.xm43_u4.nsg13_hv_pmos[ide]
print @n.xbgr.xm43_u4.nsg13_hv_pmos[ige]
print @n.xbgr.xm43_u4.nsg13_hv_pmos[ise]
print @n.xbgr.xm43_u4.nsg13_hv_pmos[ibe]
print @n.xbgr.xm43_u4.nsg13_hv_pmos[ctype]
print @n.xbgr.xm44_u2.nsg13_hv_pmos[ide]
print @n.xbgr.xm44_u2.nsg13_hv_pmos[ige]
print @n.xbgr.xm44_u2.nsg13_hv_pmos[ise]
print @n.xbgr.xm44_u2.nsg13_hv_pmos[ibe]
print @n.xbgr.xm44_u2.nsg13_hv_pmos[ctype]
print @n.xbgr.xm44_u3.nsg13_hv_pmos[ide]
print @n.xbgr.xm44_u3.nsg13_hv_pmos[ige]
print @n.xbgr.xm44_u3.nsg13_hv_pmos[ise]
print @n.xbgr.xm44_u3.nsg13_hv_pmos[ibe]
print @n.xbgr.xm44_u3.nsg13_hv_pmos[ctype]
print @n.xbgr.xm44_u4.nsg13_hv_pmos[ide]
print @n.xbgr.xm44_u4.nsg13_hv_pmos[ige]
print @n.xbgr.xm44_u4.nsg13_hv_pmos[ise]
print @n.xbgr.xm44_u4.nsg13_hv_pmos[ibe]
print @n.xbgr.xm44_u4.nsg13_hv_pmos[ctype]
print @n.xbgr.xm45_u2.nsg13_hv_pmos[ide]
print @n.xbgr.xm45_u2.nsg13_hv_pmos[ige]
print @n.xbgr.xm45_u2.nsg13_hv_pmos[ise]
print @n.xbgr.xm45_u2.nsg13_hv_pmos[ibe]
print @n.xbgr.xm45_u2.nsg13_hv_pmos[ctype]
print @n.xbgr.xm45_u3.nsg13_hv_pmos[ide]
print @n.xbgr.xm45_u3.nsg13_hv_pmos[ige]
print @n.xbgr.xm45_u3.nsg13_hv_pmos[ise]
print @n.xbgr.xm45_u3.nsg13_hv_pmos[ibe]
print @n.xbgr.xm45_u3.nsg13_hv_pmos[ctype]
print @n.xbgr.xm45_u4.nsg13_hv_pmos[ide]
print @n.xbgr.xm45_u4.nsg13_hv_pmos[ige]
print @n.xbgr.xm45_u4.nsg13_hv_pmos[ise]
print @n.xbgr.xm45_u4.nsg13_hv_pmos[ibe]
print @n.xbgr.xm45_u4.nsg13_hv_pmos[ctype]
print @n.xbgr.xm45_u5.nsg13_hv_pmos[ide]
print @n.xbgr.xm45_u5.nsg13_hv_pmos[ige]
print @n.xbgr.xm45_u5.nsg13_hv_pmos[ise]
print @n.xbgr.xm45_u5.nsg13_hv_pmos[ibe]
print @n.xbgr.xm45_u5.nsg13_hv_pmos[ctype]
print @n.xbgr.xm45_u6.nsg13_hv_pmos[ide]
print @n.xbgr.xm45_u6.nsg13_hv_pmos[ige]
print @n.xbgr.xm45_u6.nsg13_hv_pmos[ise]
print @n.xbgr.xm45_u6.nsg13_hv_pmos[ibe]
print @n.xbgr.xm45_u6.nsg13_hv_pmos[ctype]
print @n.xbgr.xm45_u7.nsg13_hv_pmos[ide]
print @n.xbgr.xm45_u7.nsg13_hv_pmos[ige]
print @n.xbgr.xm45_u7.nsg13_hv_pmos[ise]
print @n.xbgr.xm45_u7.nsg13_hv_pmos[ibe]
print @n.xbgr.xm45_u7.nsg13_hv_pmos[ctype]
print @n.xbgr.xm45_u8.nsg13_hv_pmos[ide]
print @n.xbgr.xm45_u8.nsg13_hv_pmos[ige]
print @n.xbgr.xm45_u8.nsg13_hv_pmos[ise]
print @n.xbgr.xm45_u8.nsg13_hv_pmos[ibe]
print @n.xbgr.xm45_u8.nsg13_hv_pmos[ctype]
print @n.xbgr.xm45_u9.nsg13_hv_pmos[ide]
print @n.xbgr.xm45_u9.nsg13_hv_pmos[ige]
print @n.xbgr.xm45_u9.nsg13_hv_pmos[ise]
print @n.xbgr.xm45_u9.nsg13_hv_pmos[ibe]
print @n.xbgr.xm45_u9.nsg13_hv_pmos[ctype]
print @n.xbgr.xm45_u10.nsg13_hv_pmos[ide]
print @n.xbgr.xm45_u10.nsg13_hv_pmos[ige]
print @n.xbgr.xm45_u10.nsg13_hv_pmos[ise]
print @n.xbgr.xm45_u10.nsg13_hv_pmos[ibe]
print @n.xbgr.xm45_u10.nsg13_hv_pmos[ctype]
print @n.xbgr.xm45_u11.nsg13_hv_pmos[ide]
print @n.xbgr.xm45_u11.nsg13_hv_pmos[ige]
print @n.xbgr.xm45_u11.nsg13_hv_pmos[ise]
print @n.xbgr.xm45_u11.nsg13_hv_pmos[ibe]
print @n.xbgr.xm45_u11.nsg13_hv_pmos[ctype]
print @n.xbgr.xm45_u12.nsg13_hv_pmos[ide]
print @n.xbgr.xm45_u12.nsg13_hv_pmos[ige]
print @n.xbgr.xm45_u12.nsg13_hv_pmos[ise]
print @n.xbgr.xm45_u12.nsg13_hv_pmos[ibe]
print @n.xbgr.xm45_u12.nsg13_hv_pmos[ctype]
print @n.xbgr.xm45_u13.nsg13_hv_pmos[ide]
print @n.xbgr.xm45_u13.nsg13_hv_pmos[ige]
print @n.xbgr.xm45_u13.nsg13_hv_pmos[ise]
print @n.xbgr.xm45_u13.nsg13_hv_pmos[ibe]
print @n.xbgr.xm45_u13.nsg13_hv_pmos[ctype]
print @n.xbgr.xm45_u14.nsg13_hv_pmos[ide]
print @n.xbgr.xm45_u14.nsg13_hv_pmos[ige]
print @n.xbgr.xm45_u14.nsg13_hv_pmos[ise]
print @n.xbgr.xm45_u14.nsg13_hv_pmos[ibe]
print @n.xbgr.xm45_u14.nsg13_hv_pmos[ctype]
print @n.xbgr.xm45_u15.nsg13_hv_pmos[ide]
print @n.xbgr.xm45_u15.nsg13_hv_pmos[ige]
print @n.xbgr.xm45_u15.nsg13_hv_pmos[ise]
print @n.xbgr.xm45_u15.nsg13_hv_pmos[ibe]
print @n.xbgr.xm45_u15.nsg13_hv_pmos[ctype]
print @n.xbgr.xm45_u16.nsg13_hv_pmos[ide]
print @n.xbgr.xm45_u16.nsg13_hv_pmos[ige]
print @n.xbgr.xm45_u16.nsg13_hv_pmos[ise]
print @n.xbgr.xm45_u16.nsg13_hv_pmos[ibe]
print @n.xbgr.xm45_u16.nsg13_hv_pmos[ctype]
print @n.xbgr.xm45_u17.nsg13_hv_pmos[ide]
print @n.xbgr.xm45_u17.nsg13_hv_pmos[ige]
print @n.xbgr.xm45_u17.nsg13_hv_pmos[ise]
print @n.xbgr.xm45_u17.nsg13_hv_pmos[ibe]
print @n.xbgr.xm45_u17.nsg13_hv_pmos[ctype]
print @n.xbgr.xm45_u18.nsg13_hv_pmos[ide]
print @n.xbgr.xm45_u18.nsg13_hv_pmos[ige]
print @n.xbgr.xm45_u18.nsg13_hv_pmos[ise]
print @n.xbgr.xm45_u18.nsg13_hv_pmos[ibe]
print @n.xbgr.xm45_u18.nsg13_hv_pmos[ctype]
print @n.xbgr.xm45_u19.nsg13_hv_pmos[ide]
print @n.xbgr.xm45_u19.nsg13_hv_pmos[ige]
print @n.xbgr.xm45_u19.nsg13_hv_pmos[ise]
print @n.xbgr.xm45_u19.nsg13_hv_pmos[ibe]
print @n.xbgr.xm45_u19.nsg13_hv_pmos[ctype]
print @n.xbgr.xm45_u20.nsg13_hv_pmos[ide]
print @n.xbgr.xm45_u20.nsg13_hv_pmos[ige]
print @n.xbgr.xm45_u20.nsg13_hv_pmos[ise]
print @n.xbgr.xm45_u20.nsg13_hv_pmos[ibe]
print @n.xbgr.xm45_u20.nsg13_hv_pmos[ctype]
print @n.xbgr.xm45_u21.nsg13_hv_pmos[ide]
print @n.xbgr.xm45_u21.nsg13_hv_pmos[ige]
print @n.xbgr.xm45_u21.nsg13_hv_pmos[ise]
print @n.xbgr.xm45_u21.nsg13_hv_pmos[ibe]
print @n.xbgr.xm45_u21.nsg13_hv_pmos[ctype]
print @n.xbgr.xm45_u22.nsg13_hv_pmos[ide]
print @n.xbgr.xm45_u22.nsg13_hv_pmos[ige]
print @n.xbgr.xm45_u22.nsg13_hv_pmos[ise]
print @n.xbgr.xm45_u22.nsg13_hv_pmos[ibe]
print @n.xbgr.xm45_u22.nsg13_hv_pmos[ctype]
print @n.xbgr.xm45_u23.nsg13_hv_pmos[ide]
print @n.xbgr.xm45_u23.nsg13_hv_pmos[ige]
print @n.xbgr.xm45_u23.nsg13_hv_pmos[ise]
print @n.xbgr.xm45_u23.nsg13_hv_pmos[ibe]
print @n.xbgr.xm45_u23.nsg13_hv_pmos[ctype]
print @n.xbgr.xm45_u24.nsg13_hv_pmos[ide]
print @n.xbgr.xm45_u24.nsg13_hv_pmos[ige]
print @n.xbgr.xm45_u24.nsg13_hv_pmos[ise]
print @n.xbgr.xm45_u24.nsg13_hv_pmos[ibe]
print @n.xbgr.xm45_u24.nsg13_hv_pmos[ctype]
print @n.xbgr.xm47_u2.nsg13_hv_pmos[ide]
print @n.xbgr.xm47_u2.nsg13_hv_pmos[ige]
print @n.xbgr.xm47_u2.nsg13_hv_pmos[ise]
print @n.xbgr.xm47_u2.nsg13_hv_pmos[ibe]
print @n.xbgr.xm47_u2.nsg13_hv_pmos[ctype]
print @n.xbgr.xm47_u3.nsg13_hv_pmos[ide]
print @n.xbgr.xm47_u3.nsg13_hv_pmos[ige]
print @n.xbgr.xm47_u3.nsg13_hv_pmos[ise]
print @n.xbgr.xm47_u3.nsg13_hv_pmos[ibe]
print @n.xbgr.xm47_u3.nsg13_hv_pmos[ctype]
print @n.xbgr.xm47_u4.nsg13_hv_pmos[ide]
print @n.xbgr.xm47_u4.nsg13_hv_pmos[ige]
print @n.xbgr.xm47_u4.nsg13_hv_pmos[ise]
print @n.xbgr.xm47_u4.nsg13_hv_pmos[ibe]
print @n.xbgr.xm47_u4.nsg13_hv_pmos[ctype]
print @n.xbgr.xm47_u5.nsg13_hv_pmos[ide]
print @n.xbgr.xm47_u5.nsg13_hv_pmos[ige]
print @n.xbgr.xm47_u5.nsg13_hv_pmos[ise]
print @n.xbgr.xm47_u5.nsg13_hv_pmos[ibe]
print @n.xbgr.xm47_u5.nsg13_hv_pmos[ctype]
print @n.xbgr.xm47_u6.nsg13_hv_pmos[ide]
print @n.xbgr.xm47_u6.nsg13_hv_pmos[ige]
print @n.xbgr.xm47_u6.nsg13_hv_pmos[ise]
print @n.xbgr.xm47_u6.nsg13_hv_pmos[ibe]
print @n.xbgr.xm47_u6.nsg13_hv_pmos[ctype]
print @n.xbgr.xm47_u7.nsg13_hv_pmos[ide]
print @n.xbgr.xm47_u7.nsg13_hv_pmos[ige]
print @n.xbgr.xm47_u7.nsg13_hv_pmos[ise]
print @n.xbgr.xm47_u7.nsg13_hv_pmos[ibe]
print @n.xbgr.xm47_u7.nsg13_hv_pmos[ctype]
print @n.xbgr.xm47_u8.nsg13_hv_pmos[ide]
print @n.xbgr.xm47_u8.nsg13_hv_pmos[ige]
print @n.xbgr.xm47_u8.nsg13_hv_pmos[ise]
print @n.xbgr.xm47_u8.nsg13_hv_pmos[ibe]
print @n.xbgr.xm47_u8.nsg13_hv_pmos[ctype]
print @n.xbgr.xm47_u9.nsg13_hv_pmos[ide]
print @n.xbgr.xm47_u9.nsg13_hv_pmos[ige]
print @n.xbgr.xm47_u9.nsg13_hv_pmos[ise]
print @n.xbgr.xm47_u9.nsg13_hv_pmos[ibe]
print @n.xbgr.xm47_u9.nsg13_hv_pmos[ctype]
print @n.xbgr.xm47_u10.nsg13_hv_pmos[ide]
print @n.xbgr.xm47_u10.nsg13_hv_pmos[ige]
print @n.xbgr.xm47_u10.nsg13_hv_pmos[ise]
print @n.xbgr.xm47_u10.nsg13_hv_pmos[ibe]
print @n.xbgr.xm47_u10.nsg13_hv_pmos[ctype]
print @n.xbgr.xm47_u11.nsg13_hv_pmos[ide]
print @n.xbgr.xm47_u11.nsg13_hv_pmos[ige]
print @n.xbgr.xm47_u11.nsg13_hv_pmos[ise]
print @n.xbgr.xm47_u11.nsg13_hv_pmos[ibe]
print @n.xbgr.xm47_u11.nsg13_hv_pmos[ctype]
print @n.xbgr.xm47_u12.nsg13_hv_pmos[ide]
print @n.xbgr.xm47_u12.nsg13_hv_pmos[ige]
print @n.xbgr.xm47_u12.nsg13_hv_pmos[ise]
print @n.xbgr.xm47_u12.nsg13_hv_pmos[ibe]
print @n.xbgr.xm47_u12.nsg13_hv_pmos[ctype]
print @n.xbgr.xm47_u13.nsg13_hv_pmos[ide]
print @n.xbgr.xm47_u13.nsg13_hv_pmos[ige]
print @n.xbgr.xm47_u13.nsg13_hv_pmos[ise]
print @n.xbgr.xm47_u13.nsg13_hv_pmos[ibe]
print @n.xbgr.xm47_u13.nsg13_hv_pmos[ctype]
print @n.xbgr.xm47_u14.nsg13_hv_pmos[ide]
print @n.xbgr.xm47_u14.nsg13_hv_pmos[ige]
print @n.xbgr.xm47_u14.nsg13_hv_pmos[ise]
print @n.xbgr.xm47_u14.nsg13_hv_pmos[ibe]
print @n.xbgr.xm47_u14.nsg13_hv_pmos[ctype]
print @n.xbgr.xm47_u15.nsg13_hv_pmos[ide]
print @n.xbgr.xm47_u15.nsg13_hv_pmos[ige]
print @n.xbgr.xm47_u15.nsg13_hv_pmos[ise]
print @n.xbgr.xm47_u15.nsg13_hv_pmos[ibe]
print @n.xbgr.xm47_u15.nsg13_hv_pmos[ctype]
print @n.xbgr.xm47_u16.nsg13_hv_pmos[ide]
print @n.xbgr.xm47_u16.nsg13_hv_pmos[ige]
print @n.xbgr.xm47_u16.nsg13_hv_pmos[ise]
print @n.xbgr.xm47_u16.nsg13_hv_pmos[ibe]
print @n.xbgr.xm47_u16.nsg13_hv_pmos[ctype]
print @n.xbgr.xm47_u17.nsg13_hv_pmos[ide]
print @n.xbgr.xm47_u17.nsg13_hv_pmos[ige]
print @n.xbgr.xm47_u17.nsg13_hv_pmos[ise]
print @n.xbgr.xm47_u17.nsg13_hv_pmos[ibe]
print @n.xbgr.xm47_u17.nsg13_hv_pmos[ctype]
print @n.xbgr.xm47_u18.nsg13_hv_pmos[ide]
print @n.xbgr.xm47_u18.nsg13_hv_pmos[ige]
print @n.xbgr.xm47_u18.nsg13_hv_pmos[ise]
print @n.xbgr.xm47_u18.nsg13_hv_pmos[ibe]
print @n.xbgr.xm47_u18.nsg13_hv_pmos[ctype]
print @n.xbgr.xm47_u19.nsg13_hv_pmos[ide]
print @n.xbgr.xm47_u19.nsg13_hv_pmos[ige]
print @n.xbgr.xm47_u19.nsg13_hv_pmos[ise]
print @n.xbgr.xm47_u19.nsg13_hv_pmos[ibe]
print @n.xbgr.xm47_u19.nsg13_hv_pmos[ctype]
print @n.xbgr.xm47_u20.nsg13_hv_pmos[ide]
print @n.xbgr.xm47_u20.nsg13_hv_pmos[ige]
print @n.xbgr.xm47_u20.nsg13_hv_pmos[ise]
print @n.xbgr.xm47_u20.nsg13_hv_pmos[ibe]
print @n.xbgr.xm47_u20.nsg13_hv_pmos[ctype]
print @n.xbgr.xm47_u21.nsg13_hv_pmos[ide]
print @n.xbgr.xm47_u21.nsg13_hv_pmos[ige]
print @n.xbgr.xm47_u21.nsg13_hv_pmos[ise]
print @n.xbgr.xm47_u21.nsg13_hv_pmos[ibe]
print @n.xbgr.xm47_u21.nsg13_hv_pmos[ctype]
print @n.xbgr.xm47_u22.nsg13_hv_pmos[ide]
print @n.xbgr.xm47_u22.nsg13_hv_pmos[ige]
print @n.xbgr.xm47_u22.nsg13_hv_pmos[ise]
print @n.xbgr.xm47_u22.nsg13_hv_pmos[ibe]
print @n.xbgr.xm47_u22.nsg13_hv_pmos[ctype]
print @n.xbgr.xm47_u23.nsg13_hv_pmos[ide]
print @n.xbgr.xm47_u23.nsg13_hv_pmos[ige]
print @n.xbgr.xm47_u23.nsg13_hv_pmos[ise]
print @n.xbgr.xm47_u23.nsg13_hv_pmos[ibe]
print @n.xbgr.xm47_u23.nsg13_hv_pmos[ctype]
print @n.xbgr.xm47_u24.nsg13_hv_pmos[ide]
print @n.xbgr.xm47_u24.nsg13_hv_pmos[ige]
print @n.xbgr.xm47_u24.nsg13_hv_pmos[ise]
print @n.xbgr.xm47_u24.nsg13_hv_pmos[ibe]
print @n.xbgr.xm47_u24.nsg13_hv_pmos[ctype]
print @n.xbgr.xm48_u2.nsg13_hv_pmos[ide]
print @n.xbgr.xm48_u2.nsg13_hv_pmos[ige]
print @n.xbgr.xm48_u2.nsg13_hv_pmos[ise]
print @n.xbgr.xm48_u2.nsg13_hv_pmos[ibe]
print @n.xbgr.xm48_u2.nsg13_hv_pmos[ctype]
print @n.xbgr.xm48_u3.nsg13_hv_pmos[ide]
print @n.xbgr.xm48_u3.nsg13_hv_pmos[ige]
print @n.xbgr.xm48_u3.nsg13_hv_pmos[ise]
print @n.xbgr.xm48_u3.nsg13_hv_pmos[ibe]
print @n.xbgr.xm48_u3.nsg13_hv_pmos[ctype]
print @n.xbgr.xm48_u4.nsg13_hv_pmos[ide]
print @n.xbgr.xm48_u4.nsg13_hv_pmos[ige]
print @n.xbgr.xm48_u4.nsg13_hv_pmos[ise]
print @n.xbgr.xm48_u4.nsg13_hv_pmos[ibe]
print @n.xbgr.xm48_u4.nsg13_hv_pmos[ctype]
print @n.xbgr.xm48_u5.nsg13_hv_pmos[ide]
print @n.xbgr.xm48_u5.nsg13_hv_pmos[ige]
print @n.xbgr.xm48_u5.nsg13_hv_pmos[ise]
print @n.xbgr.xm48_u5.nsg13_hv_pmos[ibe]
print @n.xbgr.xm48_u5.nsg13_hv_pmos[ctype]
print @n.xbgr.xm48_u6.nsg13_hv_pmos[ide]
print @n.xbgr.xm48_u6.nsg13_hv_pmos[ige]
print @n.xbgr.xm48_u6.nsg13_hv_pmos[ise]
print @n.xbgr.xm48_u6.nsg13_hv_pmos[ibe]
print @n.xbgr.xm48_u6.nsg13_hv_pmos[ctype]
print @n.xbgr.xm48_u7.nsg13_hv_pmos[ide]
print @n.xbgr.xm48_u7.nsg13_hv_pmos[ige]
print @n.xbgr.xm48_u7.nsg13_hv_pmos[ise]
print @n.xbgr.xm48_u7.nsg13_hv_pmos[ibe]
print @n.xbgr.xm48_u7.nsg13_hv_pmos[ctype]
print @n.xbgr.xm48_u8.nsg13_hv_pmos[ide]
print @n.xbgr.xm48_u8.nsg13_hv_pmos[ige]
print @n.xbgr.xm48_u8.nsg13_hv_pmos[ise]
print @n.xbgr.xm48_u8.nsg13_hv_pmos[ibe]
print @n.xbgr.xm48_u8.nsg13_hv_pmos[ctype]
print @n.xbgr.xm48_u9.nsg13_hv_pmos[ide]
print @n.xbgr.xm48_u9.nsg13_hv_pmos[ige]
print @n.xbgr.xm48_u9.nsg13_hv_pmos[ise]
print @n.xbgr.xm48_u9.nsg13_hv_pmos[ibe]
print @n.xbgr.xm48_u9.nsg13_hv_pmos[ctype]
print @n.xbgr.xm48_u10.nsg13_hv_pmos[ide]
print @n.xbgr.xm48_u10.nsg13_hv_pmos[ige]
print @n.xbgr.xm48_u10.nsg13_hv_pmos[ise]
print @n.xbgr.xm48_u10.nsg13_hv_pmos[ibe]
print @n.xbgr.xm48_u10.nsg13_hv_pmos[ctype]
print @n.xbgr.xm48_u11.nsg13_hv_pmos[ide]
print @n.xbgr.xm48_u11.nsg13_hv_pmos[ige]
print @n.xbgr.xm48_u11.nsg13_hv_pmos[ise]
print @n.xbgr.xm48_u11.nsg13_hv_pmos[ibe]
print @n.xbgr.xm48_u11.nsg13_hv_pmos[ctype]
print @n.xbgr.xm48_u12.nsg13_hv_pmos[ide]
print @n.xbgr.xm48_u12.nsg13_hv_pmos[ige]
print @n.xbgr.xm48_u12.nsg13_hv_pmos[ise]
print @n.xbgr.xm48_u12.nsg13_hv_pmos[ibe]
print @n.xbgr.xm48_u12.nsg13_hv_pmos[ctype]
print @n.xbgr.xm48_u13.nsg13_hv_pmos[ide]
print @n.xbgr.xm48_u13.nsg13_hv_pmos[ige]
print @n.xbgr.xm48_u13.nsg13_hv_pmos[ise]
print @n.xbgr.xm48_u13.nsg13_hv_pmos[ibe]
print @n.xbgr.xm48_u13.nsg13_hv_pmos[ctype]
print @n.xbgr.xm48_u14.nsg13_hv_pmos[ide]
print @n.xbgr.xm48_u14.nsg13_hv_pmos[ige]
print @n.xbgr.xm48_u14.nsg13_hv_pmos[ise]
print @n.xbgr.xm48_u14.nsg13_hv_pmos[ibe]
print @n.xbgr.xm48_u14.nsg13_hv_pmos[ctype]
print @n.xbgr.xm48_u15.nsg13_hv_pmos[ide]
print @n.xbgr.xm48_u15.nsg13_hv_pmos[ige]
print @n.xbgr.xm48_u15.nsg13_hv_pmos[ise]
print @n.xbgr.xm48_u15.nsg13_hv_pmos[ibe]
print @n.xbgr.xm48_u15.nsg13_hv_pmos[ctype]
print @n.xbgr.xm48_u16.nsg13_hv_pmos[ide]
print @n.xbgr.xm48_u16.nsg13_hv_pmos[ige]
print @n.xbgr.xm48_u16.nsg13_hv_pmos[ise]
print @n.xbgr.xm48_u16.nsg13_hv_pmos[ibe]
print @n.xbgr.xm48_u16.nsg13_hv_pmos[ctype]
print @n.xbgr.xm48_u17.nsg13_hv_pmos[ide]
print @n.xbgr.xm48_u17.nsg13_hv_pmos[ige]
print @n.xbgr.xm48_u17.nsg13_hv_pmos[ise]
print @n.xbgr.xm48_u17.nsg13_hv_pmos[ibe]
print @n.xbgr.xm48_u17.nsg13_hv_pmos[ctype]
print @n.xbgr.xm48_u18.nsg13_hv_pmos[ide]
print @n.xbgr.xm48_u18.nsg13_hv_pmos[ige]
print @n.xbgr.xm48_u18.nsg13_hv_pmos[ise]
print @n.xbgr.xm48_u18.nsg13_hv_pmos[ibe]
print @n.xbgr.xm48_u18.nsg13_hv_pmos[ctype]
print @n.xbgr.xm48_u19.nsg13_hv_pmos[ide]
print @n.xbgr.xm48_u19.nsg13_hv_pmos[ige]
print @n.xbgr.xm48_u19.nsg13_hv_pmos[ise]
print @n.xbgr.xm48_u19.nsg13_hv_pmos[ibe]
print @n.xbgr.xm48_u19.nsg13_hv_pmos[ctype]
print @n.xbgr.xm48_u20.nsg13_hv_pmos[ide]
print @n.xbgr.xm48_u20.nsg13_hv_pmos[ige]
print @n.xbgr.xm48_u20.nsg13_hv_pmos[ise]
print @n.xbgr.xm48_u20.nsg13_hv_pmos[ibe]
print @n.xbgr.xm48_u20.nsg13_hv_pmos[ctype]
print @n.xbgr.xm48_u21.nsg13_hv_pmos[ide]
print @n.xbgr.xm48_u21.nsg13_hv_pmos[ige]
print @n.xbgr.xm48_u21.nsg13_hv_pmos[ise]
print @n.xbgr.xm48_u21.nsg13_hv_pmos[ibe]
print @n.xbgr.xm48_u21.nsg13_hv_pmos[ctype]
print @n.xbgr.xm48_u22.nsg13_hv_pmos[ide]
print @n.xbgr.xm48_u22.nsg13_hv_pmos[ige]
print @n.xbgr.xm48_u22.nsg13_hv_pmos[ise]
print @n.xbgr.xm48_u22.nsg13_hv_pmos[ibe]
print @n.xbgr.xm48_u22.nsg13_hv_pmos[ctype]
print @n.xbgr.xm48_u23.nsg13_hv_pmos[ide]
print @n.xbgr.xm48_u23.nsg13_hv_pmos[ige]
print @n.xbgr.xm48_u23.nsg13_hv_pmos[ise]
print @n.xbgr.xm48_u23.nsg13_hv_pmos[ibe]
print @n.xbgr.xm48_u23.nsg13_hv_pmos[ctype]
print @n.xbgr.xm48_u24.nsg13_hv_pmos[ide]
print @n.xbgr.xm48_u24.nsg13_hv_pmos[ige]
print @n.xbgr.xm48_u24.nsg13_hv_pmos[ise]
print @n.xbgr.xm48_u24.nsg13_hv_pmos[ibe]
print @n.xbgr.xm48_u24.nsg13_hv_pmos[ctype]
print @n.xbgr.xm50_u2.nsg13_hv_pmos[ide]
print @n.xbgr.xm50_u2.nsg13_hv_pmos[ige]
print @n.xbgr.xm50_u2.nsg13_hv_pmos[ise]
print @n.xbgr.xm50_u2.nsg13_hv_pmos[ibe]
print @n.xbgr.xm50_u2.nsg13_hv_pmos[ctype]
print @n.xbgr.xm50_u3.nsg13_hv_pmos[ide]
print @n.xbgr.xm50_u3.nsg13_hv_pmos[ige]
print @n.xbgr.xm50_u3.nsg13_hv_pmos[ise]
print @n.xbgr.xm50_u3.nsg13_hv_pmos[ibe]
print @n.xbgr.xm50_u3.nsg13_hv_pmos[ctype]
print @n.xbgr.xm50_u4.nsg13_hv_pmos[ide]
print @n.xbgr.xm50_u4.nsg13_hv_pmos[ige]
print @n.xbgr.xm50_u4.nsg13_hv_pmos[ise]
print @n.xbgr.xm50_u4.nsg13_hv_pmos[ibe]
print @n.xbgr.xm50_u4.nsg13_hv_pmos[ctype]
print @n.xbgr.xm50_u5.nsg13_hv_pmos[ide]
print @n.xbgr.xm50_u5.nsg13_hv_pmos[ige]
print @n.xbgr.xm50_u5.nsg13_hv_pmos[ise]
print @n.xbgr.xm50_u5.nsg13_hv_pmos[ibe]
print @n.xbgr.xm50_u5.nsg13_hv_pmos[ctype]
print @n.xbgr.xm50_u6.nsg13_hv_pmos[ide]
print @n.xbgr.xm50_u6.nsg13_hv_pmos[ige]
print @n.xbgr.xm50_u6.nsg13_hv_pmos[ise]
print @n.xbgr.xm50_u6.nsg13_hv_pmos[ibe]
print @n.xbgr.xm50_u6.nsg13_hv_pmos[ctype]
print @n.xbgr.xm50_u7.nsg13_hv_pmos[ide]
print @n.xbgr.xm50_u7.nsg13_hv_pmos[ige]
print @n.xbgr.xm50_u7.nsg13_hv_pmos[ise]
print @n.xbgr.xm50_u7.nsg13_hv_pmos[ibe]
print @n.xbgr.xm50_u7.nsg13_hv_pmos[ctype]
print @n.xbgr.xm50_u8.nsg13_hv_pmos[ide]
print @n.xbgr.xm50_u8.nsg13_hv_pmos[ige]
print @n.xbgr.xm50_u8.nsg13_hv_pmos[ise]
print @n.xbgr.xm50_u8.nsg13_hv_pmos[ibe]
print @n.xbgr.xm50_u8.nsg13_hv_pmos[ctype]
print @n.xbgr.xm50_u9.nsg13_hv_pmos[ide]
print @n.xbgr.xm50_u9.nsg13_hv_pmos[ige]
print @n.xbgr.xm50_u9.nsg13_hv_pmos[ise]
print @n.xbgr.xm50_u9.nsg13_hv_pmos[ibe]
print @n.xbgr.xm50_u9.nsg13_hv_pmos[ctype]
print @n.xbgr.xm50_u10.nsg13_hv_pmos[ide]
print @n.xbgr.xm50_u10.nsg13_hv_pmos[ige]
print @n.xbgr.xm50_u10.nsg13_hv_pmos[ise]
print @n.xbgr.xm50_u10.nsg13_hv_pmos[ibe]
print @n.xbgr.xm50_u10.nsg13_hv_pmos[ctype]
print @n.xbgr.xm50_u11.nsg13_hv_pmos[ide]
print @n.xbgr.xm50_u11.nsg13_hv_pmos[ige]
print @n.xbgr.xm50_u11.nsg13_hv_pmos[ise]
print @n.xbgr.xm50_u11.nsg13_hv_pmos[ibe]
print @n.xbgr.xm50_u11.nsg13_hv_pmos[ctype]
print @n.xbgr.xm50_u12.nsg13_hv_pmos[ide]
print @n.xbgr.xm50_u12.nsg13_hv_pmos[ige]
print @n.xbgr.xm50_u12.nsg13_hv_pmos[ise]
print @n.xbgr.xm50_u12.nsg13_hv_pmos[ibe]
print @n.xbgr.xm50_u12.nsg13_hv_pmos[ctype]
print @n.xbgr.xm50_u13.nsg13_hv_pmos[ide]
print @n.xbgr.xm50_u13.nsg13_hv_pmos[ige]
print @n.xbgr.xm50_u13.nsg13_hv_pmos[ise]
print @n.xbgr.xm50_u13.nsg13_hv_pmos[ibe]
print @n.xbgr.xm50_u13.nsg13_hv_pmos[ctype]
print @n.xbgr.xm50_u14.nsg13_hv_pmos[ide]
print @n.xbgr.xm50_u14.nsg13_hv_pmos[ige]
print @n.xbgr.xm50_u14.nsg13_hv_pmos[ise]
print @n.xbgr.xm50_u14.nsg13_hv_pmos[ibe]
print @n.xbgr.xm50_u14.nsg13_hv_pmos[ctype]
print @n.xbgr.xm50_u15.nsg13_hv_pmos[ide]
print @n.xbgr.xm50_u15.nsg13_hv_pmos[ige]
print @n.xbgr.xm50_u15.nsg13_hv_pmos[ise]
print @n.xbgr.xm50_u15.nsg13_hv_pmos[ibe]
print @n.xbgr.xm50_u15.nsg13_hv_pmos[ctype]
print @n.xbgr.xm50_u16.nsg13_hv_pmos[ide]
print @n.xbgr.xm50_u16.nsg13_hv_pmos[ige]
print @n.xbgr.xm50_u16.nsg13_hv_pmos[ise]
print @n.xbgr.xm50_u16.nsg13_hv_pmos[ibe]
print @n.xbgr.xm50_u16.nsg13_hv_pmos[ctype]
print @n.xbgr.xm50_u17.nsg13_hv_pmos[ide]
print @n.xbgr.xm50_u17.nsg13_hv_pmos[ige]
print @n.xbgr.xm50_u17.nsg13_hv_pmos[ise]
print @n.xbgr.xm50_u17.nsg13_hv_pmos[ibe]
print @n.xbgr.xm50_u17.nsg13_hv_pmos[ctype]
print @n.xbgr.xm50_u18.nsg13_hv_pmos[ide]
print @n.xbgr.xm50_u18.nsg13_hv_pmos[ige]
print @n.xbgr.xm50_u18.nsg13_hv_pmos[ise]
print @n.xbgr.xm50_u18.nsg13_hv_pmos[ibe]
print @n.xbgr.xm50_u18.nsg13_hv_pmos[ctype]
print @n.xbgr.xm50_u19.nsg13_hv_pmos[ide]
print @n.xbgr.xm50_u19.nsg13_hv_pmos[ige]
print @n.xbgr.xm50_u19.nsg13_hv_pmos[ise]
print @n.xbgr.xm50_u19.nsg13_hv_pmos[ibe]
print @n.xbgr.xm50_u19.nsg13_hv_pmos[ctype]
print @n.xbgr.xm50_u20.nsg13_hv_pmos[ide]
print @n.xbgr.xm50_u20.nsg13_hv_pmos[ige]
print @n.xbgr.xm50_u20.nsg13_hv_pmos[ise]
print @n.xbgr.xm50_u20.nsg13_hv_pmos[ibe]
print @n.xbgr.xm50_u20.nsg13_hv_pmos[ctype]
print @n.xbgr.xm50_u21.nsg13_hv_pmos[ide]
print @n.xbgr.xm50_u21.nsg13_hv_pmos[ige]
print @n.xbgr.xm50_u21.nsg13_hv_pmos[ise]
print @n.xbgr.xm50_u21.nsg13_hv_pmos[ibe]
print @n.xbgr.xm50_u21.nsg13_hv_pmos[ctype]
print @n.xbgr.xm50_u22.nsg13_hv_pmos[ide]
print @n.xbgr.xm50_u22.nsg13_hv_pmos[ige]
print @n.xbgr.xm50_u22.nsg13_hv_pmos[ise]
print @n.xbgr.xm50_u22.nsg13_hv_pmos[ibe]
print @n.xbgr.xm50_u22.nsg13_hv_pmos[ctype]
print @n.xbgr.xm50_u23.nsg13_hv_pmos[ide]
print @n.xbgr.xm50_u23.nsg13_hv_pmos[ige]
print @n.xbgr.xm50_u23.nsg13_hv_pmos[ise]
print @n.xbgr.xm50_u23.nsg13_hv_pmos[ibe]
print @n.xbgr.xm50_u23.nsg13_hv_pmos[ctype]
print @n.xbgr.xm50_u24.nsg13_hv_pmos[ide]
print @n.xbgr.xm50_u24.nsg13_hv_pmos[ige]
print @n.xbgr.xm50_u24.nsg13_hv_pmos[ise]
print @n.xbgr.xm50_u24.nsg13_hv_pmos[ibe]
print @n.xbgr.xm50_u24.nsg13_hv_pmos[ctype]
print @n.xbgr.xm51_u2.nsg13_hv_pmos[ide]
print @n.xbgr.xm51_u2.nsg13_hv_pmos[ige]
print @n.xbgr.xm51_u2.nsg13_hv_pmos[ise]
print @n.xbgr.xm51_u2.nsg13_hv_pmos[ibe]
print @n.xbgr.xm51_u2.nsg13_hv_pmos[ctype]
print @n.xbgr.xm51_u3.nsg13_hv_pmos[ide]
print @n.xbgr.xm51_u3.nsg13_hv_pmos[ige]
print @n.xbgr.xm51_u3.nsg13_hv_pmos[ise]
print @n.xbgr.xm51_u3.nsg13_hv_pmos[ibe]
print @n.xbgr.xm51_u3.nsg13_hv_pmos[ctype]
print @n.xbgr.xm51_u4.nsg13_hv_pmos[ide]
print @n.xbgr.xm51_u4.nsg13_hv_pmos[ige]
print @n.xbgr.xm51_u4.nsg13_hv_pmos[ise]
print @n.xbgr.xm51_u4.nsg13_hv_pmos[ibe]
print @n.xbgr.xm51_u4.nsg13_hv_pmos[ctype]
print @n.xbgr.xm52_u2.nsg13_hv_pmos[ide]
print @n.xbgr.xm52_u2.nsg13_hv_pmos[ige]
print @n.xbgr.xm52_u2.nsg13_hv_pmos[ise]
print @n.xbgr.xm52_u2.nsg13_hv_pmos[ibe]
print @n.xbgr.xm52_u2.nsg13_hv_pmos[ctype]
print @n.xbgr.xm52_u3.nsg13_hv_pmos[ide]
print @n.xbgr.xm52_u3.nsg13_hv_pmos[ige]
print @n.xbgr.xm52_u3.nsg13_hv_pmos[ise]
print @n.xbgr.xm52_u3.nsg13_hv_pmos[ibe]
print @n.xbgr.xm52_u3.nsg13_hv_pmos[ctype]
print @n.xbgr.xm52_u4.nsg13_hv_pmos[ide]
print @n.xbgr.xm52_u4.nsg13_hv_pmos[ige]
print @n.xbgr.xm52_u4.nsg13_hv_pmos[ise]
print @n.xbgr.xm52_u4.nsg13_hv_pmos[ibe]
print @n.xbgr.xm52_u4.nsg13_hv_pmos[ctype]
print @n.xbgr.xm52_u5.nsg13_hv_pmos[ide]
print @n.xbgr.xm52_u5.nsg13_hv_pmos[ige]
print @n.xbgr.xm52_u5.nsg13_hv_pmos[ise]
print @n.xbgr.xm52_u5.nsg13_hv_pmos[ibe]
print @n.xbgr.xm52_u5.nsg13_hv_pmos[ctype]
print @n.xbgr.xm52_u6.nsg13_hv_pmos[ide]
print @n.xbgr.xm52_u6.nsg13_hv_pmos[ige]
print @n.xbgr.xm52_u6.nsg13_hv_pmos[ise]
print @n.xbgr.xm52_u6.nsg13_hv_pmos[ibe]
print @n.xbgr.xm52_u6.nsg13_hv_pmos[ctype]
print @n.xbgr.xm52_u7.nsg13_hv_pmos[ide]
print @n.xbgr.xm52_u7.nsg13_hv_pmos[ige]
print @n.xbgr.xm52_u7.nsg13_hv_pmos[ise]
print @n.xbgr.xm52_u7.nsg13_hv_pmos[ibe]
print @n.xbgr.xm52_u7.nsg13_hv_pmos[ctype]
print @n.xbgr.xm52_u8.nsg13_hv_pmos[ide]
print @n.xbgr.xm52_u8.nsg13_hv_pmos[ige]
print @n.xbgr.xm52_u8.nsg13_hv_pmos[ise]
print @n.xbgr.xm52_u8.nsg13_hv_pmos[ibe]
print @n.xbgr.xm52_u8.nsg13_hv_pmos[ctype]
print @n.xbgr.xm52_u9.nsg13_hv_pmos[ide]
print @n.xbgr.xm52_u9.nsg13_hv_pmos[ige]
print @n.xbgr.xm52_u9.nsg13_hv_pmos[ise]
print @n.xbgr.xm52_u9.nsg13_hv_pmos[ibe]
print @n.xbgr.xm52_u9.nsg13_hv_pmos[ctype]
print @n.xbgr.xm52_u10.nsg13_hv_pmos[ide]
print @n.xbgr.xm52_u10.nsg13_hv_pmos[ige]
print @n.xbgr.xm52_u10.nsg13_hv_pmos[ise]
print @n.xbgr.xm52_u10.nsg13_hv_pmos[ibe]
print @n.xbgr.xm52_u10.nsg13_hv_pmos[ctype]
print @n.xbgr.xm52_u11.nsg13_hv_pmos[ide]
print @n.xbgr.xm52_u11.nsg13_hv_pmos[ige]
print @n.xbgr.xm52_u11.nsg13_hv_pmos[ise]
print @n.xbgr.xm52_u11.nsg13_hv_pmos[ibe]
print @n.xbgr.xm52_u11.nsg13_hv_pmos[ctype]
print @n.xbgr.xm52_u12.nsg13_hv_pmos[ide]
print @n.xbgr.xm52_u12.nsg13_hv_pmos[ige]
print @n.xbgr.xm52_u12.nsg13_hv_pmos[ise]
print @n.xbgr.xm52_u12.nsg13_hv_pmos[ibe]
print @n.xbgr.xm52_u12.nsg13_hv_pmos[ctype]
print @n.xbgr.xm52_u13.nsg13_hv_pmos[ide]
print @n.xbgr.xm52_u13.nsg13_hv_pmos[ige]
print @n.xbgr.xm52_u13.nsg13_hv_pmos[ise]
print @n.xbgr.xm52_u13.nsg13_hv_pmos[ibe]
print @n.xbgr.xm52_u13.nsg13_hv_pmos[ctype]
print @n.xbgr.xm52_u14.nsg13_hv_pmos[ide]
print @n.xbgr.xm52_u14.nsg13_hv_pmos[ige]
print @n.xbgr.xm52_u14.nsg13_hv_pmos[ise]
print @n.xbgr.xm52_u14.nsg13_hv_pmos[ibe]
print @n.xbgr.xm52_u14.nsg13_hv_pmos[ctype]
print @n.xbgr.xm52_u15.nsg13_hv_pmos[ide]
print @n.xbgr.xm52_u15.nsg13_hv_pmos[ige]
print @n.xbgr.xm52_u15.nsg13_hv_pmos[ise]
print @n.xbgr.xm52_u15.nsg13_hv_pmos[ibe]
print @n.xbgr.xm52_u15.nsg13_hv_pmos[ctype]
print @n.xbgr.xm52_u16.nsg13_hv_pmos[ide]
print @n.xbgr.xm52_u16.nsg13_hv_pmos[ige]
print @n.xbgr.xm52_u16.nsg13_hv_pmos[ise]
print @n.xbgr.xm52_u16.nsg13_hv_pmos[ibe]
print @n.xbgr.xm52_u16.nsg13_hv_pmos[ctype]
print @n.xbgr.xm52_u17.nsg13_hv_pmos[ide]
print @n.xbgr.xm52_u17.nsg13_hv_pmos[ige]
print @n.xbgr.xm52_u17.nsg13_hv_pmos[ise]
print @n.xbgr.xm52_u17.nsg13_hv_pmos[ibe]
print @n.xbgr.xm52_u17.nsg13_hv_pmos[ctype]
print @n.xbgr.xm52_u18.nsg13_hv_pmos[ide]
print @n.xbgr.xm52_u18.nsg13_hv_pmos[ige]
print @n.xbgr.xm52_u18.nsg13_hv_pmos[ise]
print @n.xbgr.xm52_u18.nsg13_hv_pmos[ibe]
print @n.xbgr.xm52_u18.nsg13_hv_pmos[ctype]
print @n.xbgr.xm52_u19.nsg13_hv_pmos[ide]
print @n.xbgr.xm52_u19.nsg13_hv_pmos[ige]
print @n.xbgr.xm52_u19.nsg13_hv_pmos[ise]
print @n.xbgr.xm52_u19.nsg13_hv_pmos[ibe]
print @n.xbgr.xm52_u19.nsg13_hv_pmos[ctype]
print @n.xbgr.xm52_u20.nsg13_hv_pmos[ide]
print @n.xbgr.xm52_u20.nsg13_hv_pmos[ige]
print @n.xbgr.xm52_u20.nsg13_hv_pmos[ise]
print @n.xbgr.xm52_u20.nsg13_hv_pmos[ibe]
print @n.xbgr.xm52_u20.nsg13_hv_pmos[ctype]
print @n.xbgr.xm52_u21.nsg13_hv_pmos[ide]
print @n.xbgr.xm52_u21.nsg13_hv_pmos[ige]
print @n.xbgr.xm52_u21.nsg13_hv_pmos[ise]
print @n.xbgr.xm52_u21.nsg13_hv_pmos[ibe]
print @n.xbgr.xm52_u21.nsg13_hv_pmos[ctype]
print @n.xbgr.xm52_u22.nsg13_hv_pmos[ide]
print @n.xbgr.xm52_u22.nsg13_hv_pmos[ige]
print @n.xbgr.xm52_u22.nsg13_hv_pmos[ise]
print @n.xbgr.xm52_u22.nsg13_hv_pmos[ibe]
print @n.xbgr.xm52_u22.nsg13_hv_pmos[ctype]
print @n.xbgr.xm52_u23.nsg13_hv_pmos[ide]
print @n.xbgr.xm52_u23.nsg13_hv_pmos[ige]
print @n.xbgr.xm52_u23.nsg13_hv_pmos[ise]
print @n.xbgr.xm52_u23.nsg13_hv_pmos[ibe]
print @n.xbgr.xm52_u23.nsg13_hv_pmos[ctype]
print @n.xbgr.xm52_u24.nsg13_hv_pmos[ide]
print @n.xbgr.xm52_u24.nsg13_hv_pmos[ige]
print @n.xbgr.xm52_u24.nsg13_hv_pmos[ise]
print @n.xbgr.xm52_u24.nsg13_hv_pmos[ibe]
print @n.xbgr.xm52_u24.nsg13_hv_pmos[ctype]
print @n.xbgr.xm54_u2.nsg13_hv_pmos[ide]
print @n.xbgr.xm54_u2.nsg13_hv_pmos[ige]
print @n.xbgr.xm54_u2.nsg13_hv_pmos[ise]
print @n.xbgr.xm54_u2.nsg13_hv_pmos[ibe]
print @n.xbgr.xm54_u2.nsg13_hv_pmos[ctype]
print @n.xbgr.xm54_u3.nsg13_hv_pmos[ide]
print @n.xbgr.xm54_u3.nsg13_hv_pmos[ige]
print @n.xbgr.xm54_u3.nsg13_hv_pmos[ise]
print @n.xbgr.xm54_u3.nsg13_hv_pmos[ibe]
print @n.xbgr.xm54_u3.nsg13_hv_pmos[ctype]
print @n.xbgr.xm54_u4.nsg13_hv_pmos[ide]
print @n.xbgr.xm54_u4.nsg13_hv_pmos[ige]
print @n.xbgr.xm54_u4.nsg13_hv_pmos[ise]
print @n.xbgr.xm54_u4.nsg13_hv_pmos[ibe]
print @n.xbgr.xm54_u4.nsg13_hv_pmos[ctype]
print @n.xbgr.xm54_u5.nsg13_hv_pmos[ide]
print @n.xbgr.xm54_u5.nsg13_hv_pmos[ige]
print @n.xbgr.xm54_u5.nsg13_hv_pmos[ise]
print @n.xbgr.xm54_u5.nsg13_hv_pmos[ibe]
print @n.xbgr.xm54_u5.nsg13_hv_pmos[ctype]
print @n.xbgr.xm54_u6.nsg13_hv_pmos[ide]
print @n.xbgr.xm54_u6.nsg13_hv_pmos[ige]
print @n.xbgr.xm54_u6.nsg13_hv_pmos[ise]
print @n.xbgr.xm54_u6.nsg13_hv_pmos[ibe]
print @n.xbgr.xm54_u6.nsg13_hv_pmos[ctype]
print @n.xbgr.xm54_u7.nsg13_hv_pmos[ide]
print @n.xbgr.xm54_u7.nsg13_hv_pmos[ige]
print @n.xbgr.xm54_u7.nsg13_hv_pmos[ise]
print @n.xbgr.xm54_u7.nsg13_hv_pmos[ibe]
print @n.xbgr.xm54_u7.nsg13_hv_pmos[ctype]
print @n.xbgr.xm54_u8.nsg13_hv_pmos[ide]
print @n.xbgr.xm54_u8.nsg13_hv_pmos[ige]
print @n.xbgr.xm54_u8.nsg13_hv_pmos[ise]
print @n.xbgr.xm54_u8.nsg13_hv_pmos[ibe]
print @n.xbgr.xm54_u8.nsg13_hv_pmos[ctype]
print @n.xbgr.xm54_u9.nsg13_hv_pmos[ide]
print @n.xbgr.xm54_u9.nsg13_hv_pmos[ige]
print @n.xbgr.xm54_u9.nsg13_hv_pmos[ise]
print @n.xbgr.xm54_u9.nsg13_hv_pmos[ibe]
print @n.xbgr.xm54_u9.nsg13_hv_pmos[ctype]
print @n.xbgr.xm54_u10.nsg13_hv_pmos[ide]
print @n.xbgr.xm54_u10.nsg13_hv_pmos[ige]
print @n.xbgr.xm54_u10.nsg13_hv_pmos[ise]
print @n.xbgr.xm54_u10.nsg13_hv_pmos[ibe]
print @n.xbgr.xm54_u10.nsg13_hv_pmos[ctype]
print @n.xbgr.xm54_u11.nsg13_hv_pmos[ide]
print @n.xbgr.xm54_u11.nsg13_hv_pmos[ige]
print @n.xbgr.xm54_u11.nsg13_hv_pmos[ise]
print @n.xbgr.xm54_u11.nsg13_hv_pmos[ibe]
print @n.xbgr.xm54_u11.nsg13_hv_pmos[ctype]
print @n.xbgr.xm54_u12.nsg13_hv_pmos[ide]
print @n.xbgr.xm54_u12.nsg13_hv_pmos[ige]
print @n.xbgr.xm54_u12.nsg13_hv_pmos[ise]
print @n.xbgr.xm54_u12.nsg13_hv_pmos[ibe]
print @n.xbgr.xm54_u12.nsg13_hv_pmos[ctype]
print @n.xbgr.xm54_u13.nsg13_hv_pmos[ide]
print @n.xbgr.xm54_u13.nsg13_hv_pmos[ige]
print @n.xbgr.xm54_u13.nsg13_hv_pmos[ise]
print @n.xbgr.xm54_u13.nsg13_hv_pmos[ibe]
print @n.xbgr.xm54_u13.nsg13_hv_pmos[ctype]
print @n.xbgr.xm54_u14.nsg13_hv_pmos[ide]
print @n.xbgr.xm54_u14.nsg13_hv_pmos[ige]
print @n.xbgr.xm54_u14.nsg13_hv_pmos[ise]
print @n.xbgr.xm54_u14.nsg13_hv_pmos[ibe]
print @n.xbgr.xm54_u14.nsg13_hv_pmos[ctype]
print @n.xbgr.xm54_u15.nsg13_hv_pmos[ide]
print @n.xbgr.xm54_u15.nsg13_hv_pmos[ige]
print @n.xbgr.xm54_u15.nsg13_hv_pmos[ise]
print @n.xbgr.xm54_u15.nsg13_hv_pmos[ibe]
print @n.xbgr.xm54_u15.nsg13_hv_pmos[ctype]
print @n.xbgr.xm54_u16.nsg13_hv_pmos[ide]
print @n.xbgr.xm54_u16.nsg13_hv_pmos[ige]
print @n.xbgr.xm54_u16.nsg13_hv_pmos[ise]
print @n.xbgr.xm54_u16.nsg13_hv_pmos[ibe]
print @n.xbgr.xm54_u16.nsg13_hv_pmos[ctype]
print @n.xbgr.xm54_u17.nsg13_hv_pmos[ide]
print @n.xbgr.xm54_u17.nsg13_hv_pmos[ige]
print @n.xbgr.xm54_u17.nsg13_hv_pmos[ise]
print @n.xbgr.xm54_u17.nsg13_hv_pmos[ibe]
print @n.xbgr.xm54_u17.nsg13_hv_pmos[ctype]
print @n.xbgr.xm54_u18.nsg13_hv_pmos[ide]
print @n.xbgr.xm54_u18.nsg13_hv_pmos[ige]
print @n.xbgr.xm54_u18.nsg13_hv_pmos[ise]
print @n.xbgr.xm54_u18.nsg13_hv_pmos[ibe]
print @n.xbgr.xm54_u18.nsg13_hv_pmos[ctype]
print @n.xbgr.xm54_u19.nsg13_hv_pmos[ide]
print @n.xbgr.xm54_u19.nsg13_hv_pmos[ige]
print @n.xbgr.xm54_u19.nsg13_hv_pmos[ise]
print @n.xbgr.xm54_u19.nsg13_hv_pmos[ibe]
print @n.xbgr.xm54_u19.nsg13_hv_pmos[ctype]
print @n.xbgr.xm54_u20.nsg13_hv_pmos[ide]
print @n.xbgr.xm54_u20.nsg13_hv_pmos[ige]
print @n.xbgr.xm54_u20.nsg13_hv_pmos[ise]
print @n.xbgr.xm54_u20.nsg13_hv_pmos[ibe]
print @n.xbgr.xm54_u20.nsg13_hv_pmos[ctype]
print @n.xbgr.xm54_u21.nsg13_hv_pmos[ide]
print @n.xbgr.xm54_u21.nsg13_hv_pmos[ige]
print @n.xbgr.xm54_u21.nsg13_hv_pmos[ise]
print @n.xbgr.xm54_u21.nsg13_hv_pmos[ibe]
print @n.xbgr.xm54_u21.nsg13_hv_pmos[ctype]
print @n.xbgr.xm54_u22.nsg13_hv_pmos[ide]
print @n.xbgr.xm54_u22.nsg13_hv_pmos[ige]
print @n.xbgr.xm54_u22.nsg13_hv_pmos[ise]
print @n.xbgr.xm54_u22.nsg13_hv_pmos[ibe]
print @n.xbgr.xm54_u22.nsg13_hv_pmos[ctype]
print @n.xbgr.xm54_u23.nsg13_hv_pmos[ide]
print @n.xbgr.xm54_u23.nsg13_hv_pmos[ige]
print @n.xbgr.xm54_u23.nsg13_hv_pmos[ise]
print @n.xbgr.xm54_u23.nsg13_hv_pmos[ibe]
print @n.xbgr.xm54_u23.nsg13_hv_pmos[ctype]
print @n.xbgr.xm54_u24.nsg13_hv_pmos[ide]
print @n.xbgr.xm54_u24.nsg13_hv_pmos[ige]
print @n.xbgr.xm54_u24.nsg13_hv_pmos[ise]
print @n.xbgr.xm54_u24.nsg13_hv_pmos[ibe]
print @n.xbgr.xm54_u24.nsg13_hv_pmos[ctype]
print @q.xbgr.xq56_u2.qnpn13g2[ic]
print @q.xbgr.xq56_u2.qnpn13g2[ib]
print @q.xbgr.xq56_u2.qnpn13g2[ie]
print @q.xbgr.xq56_u2.qnpn13g2[is]
print @r.xbgr.xq56_u2.rsub[i]
print @c.xbgr.xq56_u2.csub[i]
print @q.xbgr.xq56_u3.qnpn13g2[ic]
print @q.xbgr.xq56_u3.qnpn13g2[ib]
print @q.xbgr.xq56_u3.qnpn13g2[ie]
print @q.xbgr.xq56_u3.qnpn13g2[is]
print @r.xbgr.xq56_u3.rsub[i]
print @c.xbgr.xq56_u3.csub[i]
print @q.xbgr.xq56_u4.qnpn13g2[ic]
print @q.xbgr.xq56_u4.qnpn13g2[ib]
print @q.xbgr.xq56_u4.qnpn13g2[ie]
print @q.xbgr.xq56_u4.qnpn13g2[is]
print @r.xbgr.xq56_u4.rsub[i]
print @c.xbgr.xq56_u4.csub[i]
print @q.xbgr.xq56_u5.qnpn13g2[ic]
print @q.xbgr.xq56_u5.qnpn13g2[ib]
print @q.xbgr.xq56_u5.qnpn13g2[ie]
print @q.xbgr.xq56_u5.qnpn13g2[is]
print @r.xbgr.xq56_u5.rsub[i]
print @c.xbgr.xq56_u5.csub[i]
print @q.xbgr.xq56_u6.qnpn13g2[ic]
print @q.xbgr.xq56_u6.qnpn13g2[ib]
print @q.xbgr.xq56_u6.qnpn13g2[ie]
print @q.xbgr.xq56_u6.qnpn13g2[is]
print @r.xbgr.xq56_u6.rsub[i]
print @c.xbgr.xq56_u6.csub[i]
print @q.xbgr.xq56_u7.qnpn13g2[ic]
print @q.xbgr.xq56_u7.qnpn13g2[ib]
print @q.xbgr.xq56_u7.qnpn13g2[ie]
print @q.xbgr.xq56_u7.qnpn13g2[is]
print @r.xbgr.xq56_u7.rsub[i]
print @c.xbgr.xq56_u7.csub[i]
print @q.xbgr.xq56_u8.qnpn13g2[ic]
print @q.xbgr.xq56_u8.qnpn13g2[ib]
print @q.xbgr.xq56_u8.qnpn13g2[ie]
print @q.xbgr.xq56_u8.qnpn13g2[is]
print @r.xbgr.xq56_u8.rsub[i]
print @c.xbgr.xq56_u8.csub[i]
print @q.xbgr.xq56_u9.qnpn13g2[ic]
print @q.xbgr.xq56_u9.qnpn13g2[ib]
print @q.xbgr.xq56_u9.qnpn13g2[ie]
print @q.xbgr.xq56_u9.qnpn13g2[is]
print @r.xbgr.xq56_u9.rsub[i]
print @c.xbgr.xq56_u9.csub[i]
print @q.xbgr.xq56_u10.qnpn13g2[ic]
print @q.xbgr.xq56_u10.qnpn13g2[ib]
print @q.xbgr.xq56_u10.qnpn13g2[ie]
print @q.xbgr.xq56_u10.qnpn13g2[is]
print @r.xbgr.xq56_u10.rsub[i]
print @c.xbgr.xq56_u10.csub[i]
print @q.xbgr.xq56_u11.qnpn13g2[ic]
print @q.xbgr.xq56_u11.qnpn13g2[ib]
print @q.xbgr.xq56_u11.qnpn13g2[ie]
print @q.xbgr.xq56_u11.qnpn13g2[is]
print @r.xbgr.xq56_u11.rsub[i]
print @c.xbgr.xq56_u11.csub[i]
print @q.xbgr.xq56_u12.qnpn13g2[ic]
print @q.xbgr.xq56_u12.qnpn13g2[ib]
print @q.xbgr.xq56_u12.qnpn13g2[ie]
print @q.xbgr.xq56_u12.qnpn13g2[is]
print @r.xbgr.xq56_u12.rsub[i]
print @c.xbgr.xq56_u12.csub[i]
print @q.xbgr.xq56_u13.qnpn13g2[ic]
print @q.xbgr.xq56_u13.qnpn13g2[ib]
print @q.xbgr.xq56_u13.qnpn13g2[ie]
print @q.xbgr.xq56_u13.qnpn13g2[is]
print @r.xbgr.xq56_u13.rsub[i]
print @c.xbgr.xq56_u13.csub[i]
print @q.xbgr.xq56_u14.qnpn13g2[ic]
print @q.xbgr.xq56_u14.qnpn13g2[ib]
print @q.xbgr.xq56_u14.qnpn13g2[ie]
print @q.xbgr.xq56_u14.qnpn13g2[is]
print @r.xbgr.xq56_u14.rsub[i]
print @c.xbgr.xq56_u14.csub[i]
print @q.xbgr.xq56_u15.qnpn13g2[ic]
print @q.xbgr.xq56_u15.qnpn13g2[ib]
print @q.xbgr.xq56_u15.qnpn13g2[ie]
print @q.xbgr.xq56_u15.qnpn13g2[is]
print @r.xbgr.xq56_u15.rsub[i]
print @c.xbgr.xq56_u15.csub[i]
print @q.xbgr.xq56_u16.qnpn13g2[ic]
print @q.xbgr.xq56_u16.qnpn13g2[ib]
print @q.xbgr.xq56_u16.qnpn13g2[ie]
print @q.xbgr.xq56_u16.qnpn13g2[is]
print @r.xbgr.xq56_u16.rsub[i]
print @c.xbgr.xq56_u16.csub[i]
print @q.xbgr.xq56_u17.qnpn13g2[ic]
print @q.xbgr.xq56_u17.qnpn13g2[ib]
print @q.xbgr.xq56_u17.qnpn13g2[ie]
print @q.xbgr.xq56_u17.qnpn13g2[is]
print @r.xbgr.xq56_u17.rsub[i]
print @c.xbgr.xq56_u17.csub[i]
print @q.xbgr.xq56_u18.qnpn13g2[ic]
print @q.xbgr.xq56_u18.qnpn13g2[ib]
print @q.xbgr.xq56_u18.qnpn13g2[ie]
print @q.xbgr.xq56_u18.qnpn13g2[is]
print @r.xbgr.xq56_u18.rsub[i]
print @c.xbgr.xq56_u18.csub[i]
print @q.xbgr.xq56_u19.qnpn13g2[ic]
print @q.xbgr.xq56_u19.qnpn13g2[ib]
print @q.xbgr.xq56_u19.qnpn13g2[ie]
print @q.xbgr.xq56_u19.qnpn13g2[is]
print @r.xbgr.xq56_u19.rsub[i]
print @c.xbgr.xq56_u19.csub[i]
print @q.xbgr.xq56_u20.qnpn13g2[ic]
print @q.xbgr.xq56_u20.qnpn13g2[ib]
print @q.xbgr.xq56_u20.qnpn13g2[ie]
print @q.xbgr.xq56_u20.qnpn13g2[is]
print @r.xbgr.xq56_u20.rsub[i]
print @c.xbgr.xq56_u20.csub[i]
print @q.xbgr.xq56_u21.qnpn13g2[ic]
print @q.xbgr.xq56_u21.qnpn13g2[ib]
print @q.xbgr.xq56_u21.qnpn13g2[ie]
print @q.xbgr.xq56_u21.qnpn13g2[is]
print @r.xbgr.xq56_u21.rsub[i]
print @c.xbgr.xq56_u21.csub[i]
print @q.xbgr.xq56_u22.qnpn13g2[ic]
print @q.xbgr.xq56_u22.qnpn13g2[ib]
print @q.xbgr.xq56_u22.qnpn13g2[ie]
print @q.xbgr.xq56_u22.qnpn13g2[is]
print @r.xbgr.xq56_u22.rsub[i]
print @c.xbgr.xq56_u22.csub[i]
print @q.xbgr.xq56_u23.qnpn13g2[ic]
print @q.xbgr.xq56_u23.qnpn13g2[ib]
print @q.xbgr.xq56_u23.qnpn13g2[ie]
print @q.xbgr.xq56_u23.qnpn13g2[is]
print @r.xbgr.xq56_u23.rsub[i]
print @c.xbgr.xq56_u23.csub[i]
print @q.xbgr.xq56_u24.qnpn13g2[ic]
print @q.xbgr.xq56_u24.qnpn13g2[ib]
print @q.xbgr.xq56_u24.qnpn13g2[ie]
print @q.xbgr.xq56_u24.qnpn13g2[is]
print @r.xbgr.xq56_u24.rsub[i]
print @c.xbgr.xq56_u24.csub[i]
print @q.xbgr.xq60_u2.qnpn13g2[ic]
print @q.xbgr.xq60_u2.qnpn13g2[ib]
print @q.xbgr.xq60_u2.qnpn13g2[ie]
print @q.xbgr.xq60_u2.qnpn13g2[is]
print @r.xbgr.xq60_u2.rsub[i]
print @c.xbgr.xq60_u2.csub[i]
print @q.xbgr.xq60_u3.qnpn13g2[ic]
print @q.xbgr.xq60_u3.qnpn13g2[ib]
print @q.xbgr.xq60_u3.qnpn13g2[ie]
print @q.xbgr.xq60_u3.qnpn13g2[is]
print @r.xbgr.xq60_u3.rsub[i]
print @c.xbgr.xq60_u3.csub[i]
print @q.xbgr.xq60_u4.qnpn13g2[ic]
print @q.xbgr.xq60_u4.qnpn13g2[ib]
print @q.xbgr.xq60_u4.qnpn13g2[ie]
print @q.xbgr.xq60_u4.qnpn13g2[is]
print @r.xbgr.xq60_u4.rsub[i]
print @c.xbgr.xq60_u4.csub[i]
print @q.xbgr.xq62_u2.qnpn13g2[ic]
print @q.xbgr.xq62_u2.qnpn13g2[ib]
print @q.xbgr.xq62_u2.qnpn13g2[ie]
print @q.xbgr.xq62_u2.qnpn13g2[is]
print @r.xbgr.xq62_u2.rsub[i]
print @c.xbgr.xq62_u2.csub[i]
print @q.xbgr.xq62_u3.qnpn13g2[ic]
print @q.xbgr.xq62_u3.qnpn13g2[ib]
print @q.xbgr.xq62_u3.qnpn13g2[ie]
print @q.xbgr.xq62_u3.qnpn13g2[is]
print @r.xbgr.xq62_u3.rsub[i]
print @c.xbgr.xq62_u3.csub[i]
print @q.xbgr.xq62_u4.qnpn13g2[ic]
print @q.xbgr.xq62_u4.qnpn13g2[ib]
print @q.xbgr.xq62_u4.qnpn13g2[ie]
print @q.xbgr.xq62_u4.qnpn13g2[is]
print @r.xbgr.xq62_u4.rsub[i]
print @c.xbgr.xq62_u4.csub[i]
print @q.xbgr.xq62_u5.qnpn13g2[ic]
print @q.xbgr.xq62_u5.qnpn13g2[ib]
print @q.xbgr.xq62_u5.qnpn13g2[ie]
print @q.xbgr.xq62_u5.qnpn13g2[is]
print @r.xbgr.xq62_u5.rsub[i]
print @c.xbgr.xq62_u5.csub[i]
print @q.xbgr.xq62_u6.qnpn13g2[ic]
print @q.xbgr.xq62_u6.qnpn13g2[ib]
print @q.xbgr.xq62_u6.qnpn13g2[ie]
print @q.xbgr.xq62_u6.qnpn13g2[is]
print @r.xbgr.xq62_u6.rsub[i]
print @c.xbgr.xq62_u6.csub[i]
print @q.xbgr.xq62_u7.qnpn13g2[ic]
print @q.xbgr.xq62_u7.qnpn13g2[ib]
print @q.xbgr.xq62_u7.qnpn13g2[ie]
print @q.xbgr.xq62_u7.qnpn13g2[is]
print @r.xbgr.xq62_u7.rsub[i]
print @c.xbgr.xq62_u7.csub[i]
print @q.xbgr.xq62_u8.qnpn13g2[ic]
print @q.xbgr.xq62_u8.qnpn13g2[ib]
print @q.xbgr.xq62_u8.qnpn13g2[ie]
print @q.xbgr.xq62_u8.qnpn13g2[is]
print @r.xbgr.xq62_u8.rsub[i]
print @c.xbgr.xq62_u8.csub[i]
print @q.xbgr.xq62_u9.qnpn13g2[ic]
print @q.xbgr.xq62_u9.qnpn13g2[ib]
print @q.xbgr.xq62_u9.qnpn13g2[ie]
print @q.xbgr.xq62_u9.qnpn13g2[is]
print @r.xbgr.xq62_u9.rsub[i]
print @c.xbgr.xq62_u9.csub[i]
print @q.xbgr.xq62_u10.qnpn13g2[ic]
print @q.xbgr.xq62_u10.qnpn13g2[ib]
print @q.xbgr.xq62_u10.qnpn13g2[ie]
print @q.xbgr.xq62_u10.qnpn13g2[is]
print @r.xbgr.xq62_u10.rsub[i]
print @c.xbgr.xq62_u10.csub[i]
print @q.xbgr.xq62_u11.qnpn13g2[ic]
print @q.xbgr.xq62_u11.qnpn13g2[ib]
print @q.xbgr.xq62_u11.qnpn13g2[ie]
print @q.xbgr.xq62_u11.qnpn13g2[is]
print @r.xbgr.xq62_u11.rsub[i]
print @c.xbgr.xq62_u11.csub[i]
print @q.xbgr.xq62_u12.qnpn13g2[ic]
print @q.xbgr.xq62_u12.qnpn13g2[ib]
print @q.xbgr.xq62_u12.qnpn13g2[ie]
print @q.xbgr.xq62_u12.qnpn13g2[is]
print @r.xbgr.xq62_u12.rsub[i]
print @c.xbgr.xq62_u12.csub[i]
print @q.xbgr.xq62_u13.qnpn13g2[ic]
print @q.xbgr.xq62_u13.qnpn13g2[ib]
print @q.xbgr.xq62_u13.qnpn13g2[ie]
print @q.xbgr.xq62_u13.qnpn13g2[is]
print @r.xbgr.xq62_u13.rsub[i]
print @c.xbgr.xq62_u13.csub[i]
print @q.xbgr.xq62_u14.qnpn13g2[ic]
print @q.xbgr.xq62_u14.qnpn13g2[ib]
print @q.xbgr.xq62_u14.qnpn13g2[ie]
print @q.xbgr.xq62_u14.qnpn13g2[is]
print @r.xbgr.xq62_u14.rsub[i]
print @c.xbgr.xq62_u14.csub[i]
print @q.xbgr.xq62_u15.qnpn13g2[ic]
print @q.xbgr.xq62_u15.qnpn13g2[ib]
print @q.xbgr.xq62_u15.qnpn13g2[ie]
print @q.xbgr.xq62_u15.qnpn13g2[is]
print @r.xbgr.xq62_u15.rsub[i]
print @c.xbgr.xq62_u15.csub[i]
print @q.xbgr.xq62_u16.qnpn13g2[ic]
print @q.xbgr.xq62_u16.qnpn13g2[ib]
print @q.xbgr.xq62_u16.qnpn13g2[ie]
print @q.xbgr.xq62_u16.qnpn13g2[is]
print @r.xbgr.xq62_u16.rsub[i]
print @c.xbgr.xq62_u16.csub[i]
print @q.xbgr.xq62_u17.qnpn13g2[ic]
print @q.xbgr.xq62_u17.qnpn13g2[ib]
print @q.xbgr.xq62_u17.qnpn13g2[ie]
print @q.xbgr.xq62_u17.qnpn13g2[is]
print @r.xbgr.xq62_u17.rsub[i]
print @c.xbgr.xq62_u17.csub[i]
print @q.xbgr.xq62_u18.qnpn13g2[ic]
print @q.xbgr.xq62_u18.qnpn13g2[ib]
print @q.xbgr.xq62_u18.qnpn13g2[ie]
print @q.xbgr.xq62_u18.qnpn13g2[is]
print @r.xbgr.xq62_u18.rsub[i]
print @c.xbgr.xq62_u18.csub[i]
print @q.xbgr.xq62_u19.qnpn13g2[ic]
print @q.xbgr.xq62_u19.qnpn13g2[ib]
print @q.xbgr.xq62_u19.qnpn13g2[ie]
print @q.xbgr.xq62_u19.qnpn13g2[is]
print @r.xbgr.xq62_u19.rsub[i]
print @c.xbgr.xq62_u19.csub[i]
print @q.xbgr.xq62_u20.qnpn13g2[ic]
print @q.xbgr.xq62_u20.qnpn13g2[ib]
print @q.xbgr.xq62_u20.qnpn13g2[ie]
print @q.xbgr.xq62_u20.qnpn13g2[is]
print @r.xbgr.xq62_u20.rsub[i]
print @c.xbgr.xq62_u20.csub[i]
print @q.xbgr.xq62_u21.qnpn13g2[ic]
print @q.xbgr.xq62_u21.qnpn13g2[ib]
print @q.xbgr.xq62_u21.qnpn13g2[ie]
print @q.xbgr.xq62_u21.qnpn13g2[is]
print @r.xbgr.xq62_u21.rsub[i]
print @c.xbgr.xq62_u21.csub[i]
print @q.xbgr.xq62_u22.qnpn13g2[ic]
print @q.xbgr.xq62_u22.qnpn13g2[ib]
print @q.xbgr.xq62_u22.qnpn13g2[ie]
print @q.xbgr.xq62_u22.qnpn13g2[is]
print @r.xbgr.xq62_u22.rsub[i]
print @c.xbgr.xq62_u22.csub[i]
print @q.xbgr.xq62_u23.qnpn13g2[ic]
print @q.xbgr.xq62_u23.qnpn13g2[ib]
print @q.xbgr.xq62_u23.qnpn13g2[ie]
print @q.xbgr.xq62_u23.qnpn13g2[is]
print @r.xbgr.xq62_u23.rsub[i]
print @c.xbgr.xq62_u23.csub[i]
print @q.xbgr.xq62_u24.qnpn13g2[ic]
print @q.xbgr.xq62_u24.qnpn13g2[ib]
print @q.xbgr.xq62_u24.qnpn13g2[ie]
print @q.xbgr.xq62_u24.qnpn13g2[is]
print @r.xbgr.xq62_u24.rsub[i]
print @c.xbgr.xq62_u24.csub[i]
print @q.xbgr.xq67_u2.qnpn13g2[ic]
print @q.xbgr.xq67_u2.qnpn13g2[ib]
print @q.xbgr.xq67_u2.qnpn13g2[ie]
print @q.xbgr.xq67_u2.qnpn13g2[is]
print @r.xbgr.xq67_u2.rsub[i]
print @c.xbgr.xq67_u2.csub[i]
print @q.xbgr.xq67_u3.qnpn13g2[ic]
print @q.xbgr.xq67_u3.qnpn13g2[ib]
print @q.xbgr.xq67_u3.qnpn13g2[ie]
print @q.xbgr.xq67_u3.qnpn13g2[is]
print @r.xbgr.xq67_u3.rsub[i]
print @c.xbgr.xq67_u3.csub[i]
print @q.xbgr.xq67_u4.qnpn13g2[ic]
print @q.xbgr.xq67_u4.qnpn13g2[ib]
print @q.xbgr.xq67_u4.qnpn13g2[ie]
print @q.xbgr.xq67_u4.qnpn13g2[is]
print @r.xbgr.xq67_u4.rsub[i]
print @c.xbgr.xq67_u4.csub[i]
print @q.xbgr.xq67_u5.qnpn13g2[ic]
print @q.xbgr.xq67_u5.qnpn13g2[ib]
print @q.xbgr.xq67_u5.qnpn13g2[ie]
print @q.xbgr.xq67_u5.qnpn13g2[is]
print @r.xbgr.xq67_u5.rsub[i]
print @c.xbgr.xq67_u5.csub[i]
print @q.xbgr.xq67_u6.qnpn13g2[ic]
print @q.xbgr.xq67_u6.qnpn13g2[ib]
print @q.xbgr.xq67_u6.qnpn13g2[ie]
print @q.xbgr.xq67_u6.qnpn13g2[is]
print @r.xbgr.xq67_u6.rsub[i]
print @c.xbgr.xq67_u6.csub[i]
print @q.xbgr.xq67_u7.qnpn13g2[ic]
print @q.xbgr.xq67_u7.qnpn13g2[ib]
print @q.xbgr.xq67_u7.qnpn13g2[ie]
print @q.xbgr.xq67_u7.qnpn13g2[is]
print @r.xbgr.xq67_u7.rsub[i]
print @c.xbgr.xq67_u7.csub[i]
print @q.xbgr.xq67_u8.qnpn13g2[ic]
print @q.xbgr.xq67_u8.qnpn13g2[ib]
print @q.xbgr.xq67_u8.qnpn13g2[ie]
print @q.xbgr.xq67_u8.qnpn13g2[is]
print @r.xbgr.xq67_u8.rsub[i]
print @c.xbgr.xq67_u8.csub[i]
print @q.xbgr.xq67_u9.qnpn13g2[ic]
print @q.xbgr.xq67_u9.qnpn13g2[ib]
print @q.xbgr.xq67_u9.qnpn13g2[ie]
print @q.xbgr.xq67_u9.qnpn13g2[is]
print @r.xbgr.xq67_u9.rsub[i]
print @c.xbgr.xq67_u9.csub[i]
print @q.xbgr.xq67_u10.qnpn13g2[ic]
print @q.xbgr.xq67_u10.qnpn13g2[ib]
print @q.xbgr.xq67_u10.qnpn13g2[ie]
print @q.xbgr.xq67_u10.qnpn13g2[is]
print @r.xbgr.xq67_u10.rsub[i]
print @c.xbgr.xq67_u10.csub[i]
print @q.xbgr.xq67_u11.qnpn13g2[ic]
print @q.xbgr.xq67_u11.qnpn13g2[ib]
print @q.xbgr.xq67_u11.qnpn13g2[ie]
print @q.xbgr.xq67_u11.qnpn13g2[is]
print @r.xbgr.xq67_u11.rsub[i]
print @c.xbgr.xq67_u11.csub[i]
print @q.xbgr.xq67_u12.qnpn13g2[ic]
print @q.xbgr.xq67_u12.qnpn13g2[ib]
print @q.xbgr.xq67_u12.qnpn13g2[ie]
print @q.xbgr.xq67_u12.qnpn13g2[is]
print @r.xbgr.xq67_u12.rsub[i]
print @c.xbgr.xq67_u12.csub[i]
print @q.xbgr.xq67_u13.qnpn13g2[ic]
print @q.xbgr.xq67_u13.qnpn13g2[ib]
print @q.xbgr.xq67_u13.qnpn13g2[ie]
print @q.xbgr.xq67_u13.qnpn13g2[is]
print @r.xbgr.xq67_u13.rsub[i]
print @c.xbgr.xq67_u13.csub[i]
print @q.xbgr.xq67_u14.qnpn13g2[ic]
print @q.xbgr.xq67_u14.qnpn13g2[ib]
print @q.xbgr.xq67_u14.qnpn13g2[ie]
print @q.xbgr.xq67_u14.qnpn13g2[is]
print @r.xbgr.xq67_u14.rsub[i]
print @c.xbgr.xq67_u14.csub[i]
print @q.xbgr.xq67_u15.qnpn13g2[ic]
print @q.xbgr.xq67_u15.qnpn13g2[ib]
print @q.xbgr.xq67_u15.qnpn13g2[ie]
print @q.xbgr.xq67_u15.qnpn13g2[is]
print @r.xbgr.xq67_u15.rsub[i]
print @c.xbgr.xq67_u15.csub[i]
print @q.xbgr.xq67_u16.qnpn13g2[ic]
print @q.xbgr.xq67_u16.qnpn13g2[ib]
print @q.xbgr.xq67_u16.qnpn13g2[ie]
print @q.xbgr.xq67_u16.qnpn13g2[is]
print @r.xbgr.xq67_u16.rsub[i]
print @c.xbgr.xq67_u16.csub[i]
print @q.xbgr.xq67_u17.qnpn13g2[ic]
print @q.xbgr.xq67_u17.qnpn13g2[ib]
print @q.xbgr.xq67_u17.qnpn13g2[ie]
print @q.xbgr.xq67_u17.qnpn13g2[is]
print @r.xbgr.xq67_u17.rsub[i]
print @c.xbgr.xq67_u17.csub[i]
print @q.xbgr.xq67_u18.qnpn13g2[ic]
print @q.xbgr.xq67_u18.qnpn13g2[ib]
print @q.xbgr.xq67_u18.qnpn13g2[ie]
print @q.xbgr.xq67_u18.qnpn13g2[is]
print @r.xbgr.xq67_u18.rsub[i]
print @c.xbgr.xq67_u18.csub[i]
print @q.xbgr.xq67_u19.qnpn13g2[ic]
print @q.xbgr.xq67_u19.qnpn13g2[ib]
print @q.xbgr.xq67_u19.qnpn13g2[ie]
print @q.xbgr.xq67_u19.qnpn13g2[is]
print @r.xbgr.xq67_u19.rsub[i]
print @c.xbgr.xq67_u19.csub[i]
print @q.xbgr.xq67_u20.qnpn13g2[ic]
print @q.xbgr.xq67_u20.qnpn13g2[ib]
print @q.xbgr.xq67_u20.qnpn13g2[ie]
print @q.xbgr.xq67_u20.qnpn13g2[is]
print @r.xbgr.xq67_u20.rsub[i]
print @c.xbgr.xq67_u20.csub[i]
print @q.xbgr.xq67_u21.qnpn13g2[ic]
print @q.xbgr.xq67_u21.qnpn13g2[ib]
print @q.xbgr.xq67_u21.qnpn13g2[ie]
print @q.xbgr.xq67_u21.qnpn13g2[is]
print @r.xbgr.xq67_u21.rsub[i]
print @c.xbgr.xq67_u21.csub[i]
print @q.xbgr.xq67_u22.qnpn13g2[ic]
print @q.xbgr.xq67_u22.qnpn13g2[ib]
print @q.xbgr.xq67_u22.qnpn13g2[ie]
print @q.xbgr.xq67_u22.qnpn13g2[is]
print @r.xbgr.xq67_u22.rsub[i]
print @c.xbgr.xq67_u22.csub[i]
print @q.xbgr.xq67_u23.qnpn13g2[ic]
print @q.xbgr.xq67_u23.qnpn13g2[ib]
print @q.xbgr.xq67_u23.qnpn13g2[ie]
print @q.xbgr.xq67_u23.qnpn13g2[is]
print @r.xbgr.xq67_u23.rsub[i]
print @c.xbgr.xq67_u23.csub[i]
print @q.xbgr.xq67_u24.qnpn13g2[ic]
print @q.xbgr.xq67_u24.qnpn13g2[ib]
print @q.xbgr.xq67_u24.qnpn13g2[ie]
print @q.xbgr.xq67_u24.qnpn13g2[is]
print @r.xbgr.xq67_u24.rsub[i]
print @c.xbgr.xq67_u24.csub[i]
print @q.xbgr.xq68_u2.qnpn13g2[ic]
print @q.xbgr.xq68_u2.qnpn13g2[ib]
print @q.xbgr.xq68_u2.qnpn13g2[ie]
print @q.xbgr.xq68_u2.qnpn13g2[is]
print @r.xbgr.xq68_u2.rsub[i]
print @c.xbgr.xq68_u2.csub[i]
print @q.xbgr.xq68_u3.qnpn13g2[ic]
print @q.xbgr.xq68_u3.qnpn13g2[ib]
print @q.xbgr.xq68_u3.qnpn13g2[ie]
print @q.xbgr.xq68_u3.qnpn13g2[is]
print @r.xbgr.xq68_u3.rsub[i]
print @c.xbgr.xq68_u3.csub[i]
print @q.xbgr.xq68_u4.qnpn13g2[ic]
print @q.xbgr.xq68_u4.qnpn13g2[ib]
print @q.xbgr.xq68_u4.qnpn13g2[ie]
print @q.xbgr.xq68_u4.qnpn13g2[is]
print @r.xbgr.xq68_u4.rsub[i]
print @c.xbgr.xq68_u4.csub[i]
print @q.xbgr.xq68_u5.qnpn13g2[ic]
print @q.xbgr.xq68_u5.qnpn13g2[ib]
print @q.xbgr.xq68_u5.qnpn13g2[ie]
print @q.xbgr.xq68_u5.qnpn13g2[is]
print @r.xbgr.xq68_u5.rsub[i]
print @c.xbgr.xq68_u5.csub[i]
print @q.xbgr.xq68_u6.qnpn13g2[ic]
print @q.xbgr.xq68_u6.qnpn13g2[ib]
print @q.xbgr.xq68_u6.qnpn13g2[ie]
print @q.xbgr.xq68_u6.qnpn13g2[is]
print @r.xbgr.xq68_u6.rsub[i]
print @c.xbgr.xq68_u6.csub[i]
print @q.xbgr.xq68_u7.qnpn13g2[ic]
print @q.xbgr.xq68_u7.qnpn13g2[ib]
print @q.xbgr.xq68_u7.qnpn13g2[ie]
print @q.xbgr.xq68_u7.qnpn13g2[is]
print @r.xbgr.xq68_u7.rsub[i]
print @c.xbgr.xq68_u7.csub[i]
print @q.xbgr.xq68_u8.qnpn13g2[ic]
print @q.xbgr.xq68_u8.qnpn13g2[ib]
print @q.xbgr.xq68_u8.qnpn13g2[ie]
print @q.xbgr.xq68_u8.qnpn13g2[is]
print @r.xbgr.xq68_u8.rsub[i]
print @c.xbgr.xq68_u8.csub[i]
print @q.xbgr.xq68_u9.qnpn13g2[ic]
print @q.xbgr.xq68_u9.qnpn13g2[ib]
print @q.xbgr.xq68_u9.qnpn13g2[ie]
print @q.xbgr.xq68_u9.qnpn13g2[is]
print @r.xbgr.xq68_u9.rsub[i]
print @c.xbgr.xq68_u9.csub[i]
print @q.xbgr.xq68_u10.qnpn13g2[ic]
print @q.xbgr.xq68_u10.qnpn13g2[ib]
print @q.xbgr.xq68_u10.qnpn13g2[ie]
print @q.xbgr.xq68_u10.qnpn13g2[is]
print @r.xbgr.xq68_u10.rsub[i]
print @c.xbgr.xq68_u10.csub[i]
print @q.xbgr.xq68_u11.qnpn13g2[ic]
print @q.xbgr.xq68_u11.qnpn13g2[ib]
print @q.xbgr.xq68_u11.qnpn13g2[ie]
print @q.xbgr.xq68_u11.qnpn13g2[is]
print @r.xbgr.xq68_u11.rsub[i]
print @c.xbgr.xq68_u11.csub[i]
print @q.xbgr.xq68_u12.qnpn13g2[ic]
print @q.xbgr.xq68_u12.qnpn13g2[ib]
print @q.xbgr.xq68_u12.qnpn13g2[ie]
print @q.xbgr.xq68_u12.qnpn13g2[is]
print @r.xbgr.xq68_u12.rsub[i]
print @c.xbgr.xq68_u12.csub[i]
print @q.xbgr.xq68_u13.qnpn13g2[ic]
print @q.xbgr.xq68_u13.qnpn13g2[ib]
print @q.xbgr.xq68_u13.qnpn13g2[ie]
print @q.xbgr.xq68_u13.qnpn13g2[is]
print @r.xbgr.xq68_u13.rsub[i]
print @c.xbgr.xq68_u13.csub[i]
print @q.xbgr.xq68_u14.qnpn13g2[ic]
print @q.xbgr.xq68_u14.qnpn13g2[ib]
print @q.xbgr.xq68_u14.qnpn13g2[ie]
print @q.xbgr.xq68_u14.qnpn13g2[is]
print @r.xbgr.xq68_u14.rsub[i]
print @c.xbgr.xq68_u14.csub[i]
print @q.xbgr.xq68_u15.qnpn13g2[ic]
print @q.xbgr.xq68_u15.qnpn13g2[ib]
print @q.xbgr.xq68_u15.qnpn13g2[ie]
print @q.xbgr.xq68_u15.qnpn13g2[is]
print @r.xbgr.xq68_u15.rsub[i]
print @c.xbgr.xq68_u15.csub[i]
print @q.xbgr.xq68_u16.qnpn13g2[ic]
print @q.xbgr.xq68_u16.qnpn13g2[ib]
print @q.xbgr.xq68_u16.qnpn13g2[ie]
print @q.xbgr.xq68_u16.qnpn13g2[is]
print @r.xbgr.xq68_u16.rsub[i]
print @c.xbgr.xq68_u16.csub[i]
print @q.xbgr.xq68_u17.qnpn13g2[ic]
print @q.xbgr.xq68_u17.qnpn13g2[ib]
print @q.xbgr.xq68_u17.qnpn13g2[ie]
print @q.xbgr.xq68_u17.qnpn13g2[is]
print @r.xbgr.xq68_u17.rsub[i]
print @c.xbgr.xq68_u17.csub[i]
print @q.xbgr.xq68_u18.qnpn13g2[ic]
print @q.xbgr.xq68_u18.qnpn13g2[ib]
print @q.xbgr.xq68_u18.qnpn13g2[ie]
print @q.xbgr.xq68_u18.qnpn13g2[is]
print @r.xbgr.xq68_u18.rsub[i]
print @c.xbgr.xq68_u18.csub[i]
print @q.xbgr.xq68_u19.qnpn13g2[ic]
print @q.xbgr.xq68_u19.qnpn13g2[ib]
print @q.xbgr.xq68_u19.qnpn13g2[ie]
print @q.xbgr.xq68_u19.qnpn13g2[is]
print @r.xbgr.xq68_u19.rsub[i]
print @c.xbgr.xq68_u19.csub[i]
print @q.xbgr.xq68_u20.qnpn13g2[ic]
print @q.xbgr.xq68_u20.qnpn13g2[ib]
print @q.xbgr.xq68_u20.qnpn13g2[ie]
print @q.xbgr.xq68_u20.qnpn13g2[is]
print @r.xbgr.xq68_u20.rsub[i]
print @c.xbgr.xq68_u20.csub[i]
print @q.xbgr.xq68_u21.qnpn13g2[ic]
print @q.xbgr.xq68_u21.qnpn13g2[ib]
print @q.xbgr.xq68_u21.qnpn13g2[ie]
print @q.xbgr.xq68_u21.qnpn13g2[is]
print @r.xbgr.xq68_u21.rsub[i]
print @c.xbgr.xq68_u21.csub[i]
print @q.xbgr.xq68_u22.qnpn13g2[ic]
print @q.xbgr.xq68_u22.qnpn13g2[ib]
print @q.xbgr.xq68_u22.qnpn13g2[ie]
print @q.xbgr.xq68_u22.qnpn13g2[is]
print @r.xbgr.xq68_u22.rsub[i]
print @c.xbgr.xq68_u22.csub[i]
print @q.xbgr.xq68_u23.qnpn13g2[ic]
print @q.xbgr.xq68_u23.qnpn13g2[ib]
print @q.xbgr.xq68_u23.qnpn13g2[ie]
print @q.xbgr.xq68_u23.qnpn13g2[is]
print @r.xbgr.xq68_u23.rsub[i]
print @c.xbgr.xq68_u23.csub[i]
print @q.xbgr.xq68_u24.qnpn13g2[ic]
print @q.xbgr.xq68_u24.qnpn13g2[ib]
print @q.xbgr.xq68_u24.qnpn13g2[ie]
print @q.xbgr.xq68_u24.qnpn13g2[is]
print @r.xbgr.xq68_u24.rsub[i]
print @c.xbgr.xq68_u24.csub[i]
print @q.xbgr.xq69_u2.qnpn13g2[ic]
print @q.xbgr.xq69_u2.qnpn13g2[ib]
print @q.xbgr.xq69_u2.qnpn13g2[ie]
print @q.xbgr.xq69_u2.qnpn13g2[is]
print @r.xbgr.xq69_u2.rsub[i]
print @c.xbgr.xq69_u2.csub[i]
print @q.xbgr.xq69_u3.qnpn13g2[ic]
print @q.xbgr.xq69_u3.qnpn13g2[ib]
print @q.xbgr.xq69_u3.qnpn13g2[ie]
print @q.xbgr.xq69_u3.qnpn13g2[is]
print @r.xbgr.xq69_u3.rsub[i]
print @c.xbgr.xq69_u3.csub[i]
print @q.xbgr.xq69_u4.qnpn13g2[ic]
print @q.xbgr.xq69_u4.qnpn13g2[ib]
print @q.xbgr.xq69_u4.qnpn13g2[ie]
print @q.xbgr.xq69_u4.qnpn13g2[is]
print @r.xbgr.xq69_u4.rsub[i]
print @c.xbgr.xq69_u4.csub[i]
print @q.xbgr.xq69_u5.qnpn13g2[ic]
print @q.xbgr.xq69_u5.qnpn13g2[ib]
print @q.xbgr.xq69_u5.qnpn13g2[ie]
print @q.xbgr.xq69_u5.qnpn13g2[is]
print @r.xbgr.xq69_u5.rsub[i]
print @c.xbgr.xq69_u5.csub[i]
print @q.xbgr.xq69_u6.qnpn13g2[ic]
print @q.xbgr.xq69_u6.qnpn13g2[ib]
print @q.xbgr.xq69_u6.qnpn13g2[ie]
print @q.xbgr.xq69_u6.qnpn13g2[is]
print @r.xbgr.xq69_u6.rsub[i]
print @c.xbgr.xq69_u6.csub[i]
print @q.xbgr.xq69_u7.qnpn13g2[ic]
print @q.xbgr.xq69_u7.qnpn13g2[ib]
print @q.xbgr.xq69_u7.qnpn13g2[ie]
print @q.xbgr.xq69_u7.qnpn13g2[is]
print @r.xbgr.xq69_u7.rsub[i]
print @c.xbgr.xq69_u7.csub[i]
print @q.xbgr.xq69_u8.qnpn13g2[ic]
print @q.xbgr.xq69_u8.qnpn13g2[ib]
print @q.xbgr.xq69_u8.qnpn13g2[ie]
print @q.xbgr.xq69_u8.qnpn13g2[is]
print @r.xbgr.xq69_u8.rsub[i]
print @c.xbgr.xq69_u8.csub[i]
print @q.xbgr.xq69_u9.qnpn13g2[ic]
print @q.xbgr.xq69_u9.qnpn13g2[ib]
print @q.xbgr.xq69_u9.qnpn13g2[ie]
print @q.xbgr.xq69_u9.qnpn13g2[is]
print @r.xbgr.xq69_u9.rsub[i]
print @c.xbgr.xq69_u9.csub[i]
print @q.xbgr.xq69_u10.qnpn13g2[ic]
print @q.xbgr.xq69_u10.qnpn13g2[ib]
print @q.xbgr.xq69_u10.qnpn13g2[ie]
print @q.xbgr.xq69_u10.qnpn13g2[is]
print @r.xbgr.xq69_u10.rsub[i]
print @c.xbgr.xq69_u10.csub[i]
print @q.xbgr.xq69_u11.qnpn13g2[ic]
print @q.xbgr.xq69_u11.qnpn13g2[ib]
print @q.xbgr.xq69_u11.qnpn13g2[ie]
print @q.xbgr.xq69_u11.qnpn13g2[is]
print @r.xbgr.xq69_u11.rsub[i]
print @c.xbgr.xq69_u11.csub[i]
print @q.xbgr.xq69_u12.qnpn13g2[ic]
print @q.xbgr.xq69_u12.qnpn13g2[ib]
print @q.xbgr.xq69_u12.qnpn13g2[ie]
print @q.xbgr.xq69_u12.qnpn13g2[is]
print @r.xbgr.xq69_u12.rsub[i]
print @c.xbgr.xq69_u12.csub[i]
print @q.xbgr.xq69_u13.qnpn13g2[ic]
print @q.xbgr.xq69_u13.qnpn13g2[ib]
print @q.xbgr.xq69_u13.qnpn13g2[ie]
print @q.xbgr.xq69_u13.qnpn13g2[is]
print @r.xbgr.xq69_u13.rsub[i]
print @c.xbgr.xq69_u13.csub[i]
print @q.xbgr.xq69_u14.qnpn13g2[ic]
print @q.xbgr.xq69_u14.qnpn13g2[ib]
print @q.xbgr.xq69_u14.qnpn13g2[ie]
print @q.xbgr.xq69_u14.qnpn13g2[is]
print @r.xbgr.xq69_u14.rsub[i]
print @c.xbgr.xq69_u14.csub[i]
print @q.xbgr.xq69_u15.qnpn13g2[ic]
print @q.xbgr.xq69_u15.qnpn13g2[ib]
print @q.xbgr.xq69_u15.qnpn13g2[ie]
print @q.xbgr.xq69_u15.qnpn13g2[is]
print @r.xbgr.xq69_u15.rsub[i]
print @c.xbgr.xq69_u15.csub[i]
print @q.xbgr.xq69_u16.qnpn13g2[ic]
print @q.xbgr.xq69_u16.qnpn13g2[ib]
print @q.xbgr.xq69_u16.qnpn13g2[ie]
print @q.xbgr.xq69_u16.qnpn13g2[is]
print @r.xbgr.xq69_u16.rsub[i]
print @c.xbgr.xq69_u16.csub[i]
print @q.xbgr.xq69_u17.qnpn13g2[ic]
print @q.xbgr.xq69_u17.qnpn13g2[ib]
print @q.xbgr.xq69_u17.qnpn13g2[ie]
print @q.xbgr.xq69_u17.qnpn13g2[is]
print @r.xbgr.xq69_u17.rsub[i]
print @c.xbgr.xq69_u17.csub[i]
print @q.xbgr.xq69_u18.qnpn13g2[ic]
print @q.xbgr.xq69_u18.qnpn13g2[ib]
print @q.xbgr.xq69_u18.qnpn13g2[ie]
print @q.xbgr.xq69_u18.qnpn13g2[is]
print @r.xbgr.xq69_u18.rsub[i]
print @c.xbgr.xq69_u18.csub[i]
print @q.xbgr.xq69_u19.qnpn13g2[ic]
print @q.xbgr.xq69_u19.qnpn13g2[ib]
print @q.xbgr.xq69_u19.qnpn13g2[ie]
print @q.xbgr.xq69_u19.qnpn13g2[is]
print @r.xbgr.xq69_u19.rsub[i]
print @c.xbgr.xq69_u19.csub[i]
print @q.xbgr.xq69_u20.qnpn13g2[ic]
print @q.xbgr.xq69_u20.qnpn13g2[ib]
print @q.xbgr.xq69_u20.qnpn13g2[ie]
print @q.xbgr.xq69_u20.qnpn13g2[is]
print @r.xbgr.xq69_u20.rsub[i]
print @c.xbgr.xq69_u20.csub[i]
print @q.xbgr.xq69_u21.qnpn13g2[ic]
print @q.xbgr.xq69_u21.qnpn13g2[ib]
print @q.xbgr.xq69_u21.qnpn13g2[ie]
print @q.xbgr.xq69_u21.qnpn13g2[is]
print @r.xbgr.xq69_u21.rsub[i]
print @c.xbgr.xq69_u21.csub[i]
print @q.xbgr.xq69_u22.qnpn13g2[ic]
print @q.xbgr.xq69_u22.qnpn13g2[ib]
print @q.xbgr.xq69_u22.qnpn13g2[ie]
print @q.xbgr.xq69_u22.qnpn13g2[is]
print @r.xbgr.xq69_u22.rsub[i]
print @c.xbgr.xq69_u22.csub[i]
print @q.xbgr.xq69_u23.qnpn13g2[ic]
print @q.xbgr.xq69_u23.qnpn13g2[ib]
print @q.xbgr.xq69_u23.qnpn13g2[ie]
print @q.xbgr.xq69_u23.qnpn13g2[is]
print @r.xbgr.xq69_u23.rsub[i]
print @c.xbgr.xq69_u23.csub[i]
print @q.xbgr.xq69_u24.qnpn13g2[ic]
print @q.xbgr.xq69_u24.qnpn13g2[ib]
print @q.xbgr.xq69_u24.qnpn13g2[ie]
print @q.xbgr.xq69_u24.qnpn13g2[is]
print @r.xbgr.xq69_u24.rsub[i]
print @c.xbgr.xq69_u24.csub[i]
print @q.xbgr.xq70_u2.qnpn13g2[ic]
print @q.xbgr.xq70_u2.qnpn13g2[ib]
print @q.xbgr.xq70_u2.qnpn13g2[ie]
print @q.xbgr.xq70_u2.qnpn13g2[is]
print @r.xbgr.xq70_u2.rsub[i]
print @c.xbgr.xq70_u2.csub[i]
print @q.xbgr.xq70_u3.qnpn13g2[ic]
print @q.xbgr.xq70_u3.qnpn13g2[ib]
print @q.xbgr.xq70_u3.qnpn13g2[ie]
print @q.xbgr.xq70_u3.qnpn13g2[is]
print @r.xbgr.xq70_u3.rsub[i]
print @c.xbgr.xq70_u3.csub[i]
print @q.xbgr.xq70_u4.qnpn13g2[ic]
print @q.xbgr.xq70_u4.qnpn13g2[ib]
print @q.xbgr.xq70_u4.qnpn13g2[ie]
print @q.xbgr.xq70_u4.qnpn13g2[is]
print @r.xbgr.xq70_u4.rsub[i]
print @c.xbgr.xq70_u4.csub[i]
print @q.xbgr.xq70_u5.qnpn13g2[ic]
print @q.xbgr.xq70_u5.qnpn13g2[ib]
print @q.xbgr.xq70_u5.qnpn13g2[ie]
print @q.xbgr.xq70_u5.qnpn13g2[is]
print @r.xbgr.xq70_u5.rsub[i]
print @c.xbgr.xq70_u5.csub[i]
print @q.xbgr.xq70_u6.qnpn13g2[ic]
print @q.xbgr.xq70_u6.qnpn13g2[ib]
print @q.xbgr.xq70_u6.qnpn13g2[ie]
print @q.xbgr.xq70_u6.qnpn13g2[is]
print @r.xbgr.xq70_u6.rsub[i]
print @c.xbgr.xq70_u6.csub[i]
print @q.xbgr.xq70_u7.qnpn13g2[ic]
print @q.xbgr.xq70_u7.qnpn13g2[ib]
print @q.xbgr.xq70_u7.qnpn13g2[ie]
print @q.xbgr.xq70_u7.qnpn13g2[is]
print @r.xbgr.xq70_u7.rsub[i]
print @c.xbgr.xq70_u7.csub[i]
print @q.xbgr.xq70_u8.qnpn13g2[ic]
print @q.xbgr.xq70_u8.qnpn13g2[ib]
print @q.xbgr.xq70_u8.qnpn13g2[ie]
print @q.xbgr.xq70_u8.qnpn13g2[is]
print @r.xbgr.xq70_u8.rsub[i]
print @c.xbgr.xq70_u8.csub[i]
print @q.xbgr.xq70_u9.qnpn13g2[ic]
print @q.xbgr.xq70_u9.qnpn13g2[ib]
print @q.xbgr.xq70_u9.qnpn13g2[ie]
print @q.xbgr.xq70_u9.qnpn13g2[is]
print @r.xbgr.xq70_u9.rsub[i]
print @c.xbgr.xq70_u9.csub[i]
print @q.xbgr.xq70_u10.qnpn13g2[ic]
print @q.xbgr.xq70_u10.qnpn13g2[ib]
print @q.xbgr.xq70_u10.qnpn13g2[ie]
print @q.xbgr.xq70_u10.qnpn13g2[is]
print @r.xbgr.xq70_u10.rsub[i]
print @c.xbgr.xq70_u10.csub[i]
print @q.xbgr.xq70_u11.qnpn13g2[ic]
print @q.xbgr.xq70_u11.qnpn13g2[ib]
print @q.xbgr.xq70_u11.qnpn13g2[ie]
print @q.xbgr.xq70_u11.qnpn13g2[is]
print @r.xbgr.xq70_u11.rsub[i]
print @c.xbgr.xq70_u11.csub[i]
print @q.xbgr.xq70_u12.qnpn13g2[ic]
print @q.xbgr.xq70_u12.qnpn13g2[ib]
print @q.xbgr.xq70_u12.qnpn13g2[ie]
print @q.xbgr.xq70_u12.qnpn13g2[is]
print @r.xbgr.xq70_u12.rsub[i]
print @c.xbgr.xq70_u12.csub[i]
print @q.xbgr.xq70_u13.qnpn13g2[ic]
print @q.xbgr.xq70_u13.qnpn13g2[ib]
print @q.xbgr.xq70_u13.qnpn13g2[ie]
print @q.xbgr.xq70_u13.qnpn13g2[is]
print @r.xbgr.xq70_u13.rsub[i]
print @c.xbgr.xq70_u13.csub[i]
print @q.xbgr.xq70_u14.qnpn13g2[ic]
print @q.xbgr.xq70_u14.qnpn13g2[ib]
print @q.xbgr.xq70_u14.qnpn13g2[ie]
print @q.xbgr.xq70_u14.qnpn13g2[is]
print @r.xbgr.xq70_u14.rsub[i]
print @c.xbgr.xq70_u14.csub[i]
print @q.xbgr.xq70_u15.qnpn13g2[ic]
print @q.xbgr.xq70_u15.qnpn13g2[ib]
print @q.xbgr.xq70_u15.qnpn13g2[ie]
print @q.xbgr.xq70_u15.qnpn13g2[is]
print @r.xbgr.xq70_u15.rsub[i]
print @c.xbgr.xq70_u15.csub[i]
print @q.xbgr.xq70_u16.qnpn13g2[ic]
print @q.xbgr.xq70_u16.qnpn13g2[ib]
print @q.xbgr.xq70_u16.qnpn13g2[ie]
print @q.xbgr.xq70_u16.qnpn13g2[is]
print @r.xbgr.xq70_u16.rsub[i]
print @c.xbgr.xq70_u16.csub[i]
print @q.xbgr.xq70_u17.qnpn13g2[ic]
print @q.xbgr.xq70_u17.qnpn13g2[ib]
print @q.xbgr.xq70_u17.qnpn13g2[ie]
print @q.xbgr.xq70_u17.qnpn13g2[is]
print @r.xbgr.xq70_u17.rsub[i]
print @c.xbgr.xq70_u17.csub[i]
print @q.xbgr.xq70_u18.qnpn13g2[ic]
print @q.xbgr.xq70_u18.qnpn13g2[ib]
print @q.xbgr.xq70_u18.qnpn13g2[ie]
print @q.xbgr.xq70_u18.qnpn13g2[is]
print @r.xbgr.xq70_u18.rsub[i]
print @c.xbgr.xq70_u18.csub[i]
print @q.xbgr.xq70_u19.qnpn13g2[ic]
print @q.xbgr.xq70_u19.qnpn13g2[ib]
print @q.xbgr.xq70_u19.qnpn13g2[ie]
print @q.xbgr.xq70_u19.qnpn13g2[is]
print @r.xbgr.xq70_u19.rsub[i]
print @c.xbgr.xq70_u19.csub[i]
print @q.xbgr.xq70_u20.qnpn13g2[ic]
print @q.xbgr.xq70_u20.qnpn13g2[ib]
print @q.xbgr.xq70_u20.qnpn13g2[ie]
print @q.xbgr.xq70_u20.qnpn13g2[is]
print @r.xbgr.xq70_u20.rsub[i]
print @c.xbgr.xq70_u20.csub[i]
print @q.xbgr.xq70_u21.qnpn13g2[ic]
print @q.xbgr.xq70_u21.qnpn13g2[ib]
print @q.xbgr.xq70_u21.qnpn13g2[ie]
print @q.xbgr.xq70_u21.qnpn13g2[is]
print @r.xbgr.xq70_u21.rsub[i]
print @c.xbgr.xq70_u21.csub[i]
print @q.xbgr.xq70_u22.qnpn13g2[ic]
print @q.xbgr.xq70_u22.qnpn13g2[ib]
print @q.xbgr.xq70_u22.qnpn13g2[ie]
print @q.xbgr.xq70_u22.qnpn13g2[is]
print @r.xbgr.xq70_u22.rsub[i]
print @c.xbgr.xq70_u22.csub[i]
print @q.xbgr.xq70_u23.qnpn13g2[ic]
print @q.xbgr.xq70_u23.qnpn13g2[ib]
print @q.xbgr.xq70_u23.qnpn13g2[ie]
print @q.xbgr.xq70_u23.qnpn13g2[is]
print @r.xbgr.xq70_u23.rsub[i]
print @c.xbgr.xq70_u23.csub[i]
print @q.xbgr.xq70_u24.qnpn13g2[ic]
print @q.xbgr.xq70_u24.qnpn13g2[ib]
print @q.xbgr.xq70_u24.qnpn13g2[ie]
print @q.xbgr.xq70_u24.qnpn13g2[is]
print @r.xbgr.xq70_u24.rsub[i]
print @c.xbgr.xq70_u24.csub[i]
print @q.xbgr.xq71_u2.qnpn13g2[ic]
print @q.xbgr.xq71_u2.qnpn13g2[ib]
print @q.xbgr.xq71_u2.qnpn13g2[ie]
print @q.xbgr.xq71_u2.qnpn13g2[is]
print @r.xbgr.xq71_u2.rsub[i]
print @c.xbgr.xq71_u2.csub[i]
print @q.xbgr.xq71_u3.qnpn13g2[ic]
print @q.xbgr.xq71_u3.qnpn13g2[ib]
print @q.xbgr.xq71_u3.qnpn13g2[ie]
print @q.xbgr.xq71_u3.qnpn13g2[is]
print @r.xbgr.xq71_u3.rsub[i]
print @c.xbgr.xq71_u3.csub[i]
print @q.xbgr.xq71_u4.qnpn13g2[ic]
print @q.xbgr.xq71_u4.qnpn13g2[ib]
print @q.xbgr.xq71_u4.qnpn13g2[ie]
print @q.xbgr.xq71_u4.qnpn13g2[is]
print @r.xbgr.xq71_u4.rsub[i]
print @c.xbgr.xq71_u4.csub[i]
print @q.xbgr.xq71_u5.qnpn13g2[ic]
print @q.xbgr.xq71_u5.qnpn13g2[ib]
print @q.xbgr.xq71_u5.qnpn13g2[ie]
print @q.xbgr.xq71_u5.qnpn13g2[is]
print @r.xbgr.xq71_u5.rsub[i]
print @c.xbgr.xq71_u5.csub[i]
print @q.xbgr.xq71_u6.qnpn13g2[ic]
print @q.xbgr.xq71_u6.qnpn13g2[ib]
print @q.xbgr.xq71_u6.qnpn13g2[ie]
print @q.xbgr.xq71_u6.qnpn13g2[is]
print @r.xbgr.xq71_u6.rsub[i]
print @c.xbgr.xq71_u6.csub[i]
print @q.xbgr.xq71_u7.qnpn13g2[ic]
print @q.xbgr.xq71_u7.qnpn13g2[ib]
print @q.xbgr.xq71_u7.qnpn13g2[ie]
print @q.xbgr.xq71_u7.qnpn13g2[is]
print @r.xbgr.xq71_u7.rsub[i]
print @c.xbgr.xq71_u7.csub[i]
print @q.xbgr.xq71_u8.qnpn13g2[ic]
print @q.xbgr.xq71_u8.qnpn13g2[ib]
print @q.xbgr.xq71_u8.qnpn13g2[ie]
print @q.xbgr.xq71_u8.qnpn13g2[is]
print @r.xbgr.xq71_u8.rsub[i]
print @c.xbgr.xq71_u8.csub[i]
print @q.xbgr.xq71_u9.qnpn13g2[ic]
print @q.xbgr.xq71_u9.qnpn13g2[ib]
print @q.xbgr.xq71_u9.qnpn13g2[ie]
print @q.xbgr.xq71_u9.qnpn13g2[is]
print @r.xbgr.xq71_u9.rsub[i]
print @c.xbgr.xq71_u9.csub[i]
print @q.xbgr.xq71_u10.qnpn13g2[ic]
print @q.xbgr.xq71_u10.qnpn13g2[ib]
print @q.xbgr.xq71_u10.qnpn13g2[ie]
print @q.xbgr.xq71_u10.qnpn13g2[is]
print @r.xbgr.xq71_u10.rsub[i]
print @c.xbgr.xq71_u10.csub[i]
print @q.xbgr.xq71_u11.qnpn13g2[ic]
print @q.xbgr.xq71_u11.qnpn13g2[ib]
print @q.xbgr.xq71_u11.qnpn13g2[ie]
print @q.xbgr.xq71_u11.qnpn13g2[is]
print @r.xbgr.xq71_u11.rsub[i]
print @c.xbgr.xq71_u11.csub[i]
print @q.xbgr.xq71_u12.qnpn13g2[ic]
print @q.xbgr.xq71_u12.qnpn13g2[ib]
print @q.xbgr.xq71_u12.qnpn13g2[ie]
print @q.xbgr.xq71_u12.qnpn13g2[is]
print @r.xbgr.xq71_u12.rsub[i]
print @c.xbgr.xq71_u12.csub[i]
print @q.xbgr.xq71_u13.qnpn13g2[ic]
print @q.xbgr.xq71_u13.qnpn13g2[ib]
print @q.xbgr.xq71_u13.qnpn13g2[ie]
print @q.xbgr.xq71_u13.qnpn13g2[is]
print @r.xbgr.xq71_u13.rsub[i]
print @c.xbgr.xq71_u13.csub[i]
print @q.xbgr.xq71_u14.qnpn13g2[ic]
print @q.xbgr.xq71_u14.qnpn13g2[ib]
print @q.xbgr.xq71_u14.qnpn13g2[ie]
print @q.xbgr.xq71_u14.qnpn13g2[is]
print @r.xbgr.xq71_u14.rsub[i]
print @c.xbgr.xq71_u14.csub[i]
print @q.xbgr.xq71_u15.qnpn13g2[ic]
print @q.xbgr.xq71_u15.qnpn13g2[ib]
print @q.xbgr.xq71_u15.qnpn13g2[ie]
print @q.xbgr.xq71_u15.qnpn13g2[is]
print @r.xbgr.xq71_u15.rsub[i]
print @c.xbgr.xq71_u15.csub[i]
print @q.xbgr.xq71_u16.qnpn13g2[ic]
print @q.xbgr.xq71_u16.qnpn13g2[ib]
print @q.xbgr.xq71_u16.qnpn13g2[ie]
print @q.xbgr.xq71_u16.qnpn13g2[is]
print @r.xbgr.xq71_u16.rsub[i]
print @c.xbgr.xq71_u16.csub[i]
print @q.xbgr.xq71_u17.qnpn13g2[ic]
print @q.xbgr.xq71_u17.qnpn13g2[ib]
print @q.xbgr.xq71_u17.qnpn13g2[ie]
print @q.xbgr.xq71_u17.qnpn13g2[is]
print @r.xbgr.xq71_u17.rsub[i]
print @c.xbgr.xq71_u17.csub[i]
print @q.xbgr.xq71_u18.qnpn13g2[ic]
print @q.xbgr.xq71_u18.qnpn13g2[ib]
print @q.xbgr.xq71_u18.qnpn13g2[ie]
print @q.xbgr.xq71_u18.qnpn13g2[is]
print @r.xbgr.xq71_u18.rsub[i]
print @c.xbgr.xq71_u18.csub[i]
print @q.xbgr.xq71_u19.qnpn13g2[ic]
print @q.xbgr.xq71_u19.qnpn13g2[ib]
print @q.xbgr.xq71_u19.qnpn13g2[ie]
print @q.xbgr.xq71_u19.qnpn13g2[is]
print @r.xbgr.xq71_u19.rsub[i]
print @c.xbgr.xq71_u19.csub[i]
print @q.xbgr.xq71_u20.qnpn13g2[ic]
print @q.xbgr.xq71_u20.qnpn13g2[ib]
print @q.xbgr.xq71_u20.qnpn13g2[ie]
print @q.xbgr.xq71_u20.qnpn13g2[is]
print @r.xbgr.xq71_u20.rsub[i]
print @c.xbgr.xq71_u20.csub[i]
print @q.xbgr.xq71_u21.qnpn13g2[ic]
print @q.xbgr.xq71_u21.qnpn13g2[ib]
print @q.xbgr.xq71_u21.qnpn13g2[ie]
print @q.xbgr.xq71_u21.qnpn13g2[is]
print @r.xbgr.xq71_u21.rsub[i]
print @c.xbgr.xq71_u21.csub[i]
print @q.xbgr.xq71_u22.qnpn13g2[ic]
print @q.xbgr.xq71_u22.qnpn13g2[ib]
print @q.xbgr.xq71_u22.qnpn13g2[ie]
print @q.xbgr.xq71_u22.qnpn13g2[is]
print @r.xbgr.xq71_u22.rsub[i]
print @c.xbgr.xq71_u22.csub[i]
print @q.xbgr.xq71_u23.qnpn13g2[ic]
print @q.xbgr.xq71_u23.qnpn13g2[ib]
print @q.xbgr.xq71_u23.qnpn13g2[ie]
print @q.xbgr.xq71_u23.qnpn13g2[is]
print @r.xbgr.xq71_u23.rsub[i]
print @c.xbgr.xq71_u23.csub[i]
print @q.xbgr.xq71_u24.qnpn13g2[ic]
print @q.xbgr.xq71_u24.qnpn13g2[ib]
print @q.xbgr.xq71_u24.qnpn13g2[ie]
print @q.xbgr.xq71_u24.qnpn13g2[is]
print @r.xbgr.xq71_u24.rsub[i]
print @c.xbgr.xq71_u24.csub[i]
print @q.xbgr.xq72_u2.qnpn13g2[ic]
print @q.xbgr.xq72_u2.qnpn13g2[ib]
print @q.xbgr.xq72_u2.qnpn13g2[ie]
print @q.xbgr.xq72_u2.qnpn13g2[is]
print @r.xbgr.xq72_u2.rsub[i]
print @c.xbgr.xq72_u2.csub[i]
print @q.xbgr.xq72_u3.qnpn13g2[ic]
print @q.xbgr.xq72_u3.qnpn13g2[ib]
print @q.xbgr.xq72_u3.qnpn13g2[ie]
print @q.xbgr.xq72_u3.qnpn13g2[is]
print @r.xbgr.xq72_u3.rsub[i]
print @c.xbgr.xq72_u3.csub[i]
print @q.xbgr.xq72_u4.qnpn13g2[ic]
print @q.xbgr.xq72_u4.qnpn13g2[ib]
print @q.xbgr.xq72_u4.qnpn13g2[ie]
print @q.xbgr.xq72_u4.qnpn13g2[is]
print @r.xbgr.xq72_u4.rsub[i]
print @c.xbgr.xq72_u4.csub[i]
print @q.xbgr.xq72_u5.qnpn13g2[ic]
print @q.xbgr.xq72_u5.qnpn13g2[ib]
print @q.xbgr.xq72_u5.qnpn13g2[ie]
print @q.xbgr.xq72_u5.qnpn13g2[is]
print @r.xbgr.xq72_u5.rsub[i]
print @c.xbgr.xq72_u5.csub[i]
print @q.xbgr.xq72_u6.qnpn13g2[ic]
print @q.xbgr.xq72_u6.qnpn13g2[ib]
print @q.xbgr.xq72_u6.qnpn13g2[ie]
print @q.xbgr.xq72_u6.qnpn13g2[is]
print @r.xbgr.xq72_u6.rsub[i]
print @c.xbgr.xq72_u6.csub[i]
print @q.xbgr.xq72_u7.qnpn13g2[ic]
print @q.xbgr.xq72_u7.qnpn13g2[ib]
print @q.xbgr.xq72_u7.qnpn13g2[ie]
print @q.xbgr.xq72_u7.qnpn13g2[is]
print @r.xbgr.xq72_u7.rsub[i]
print @c.xbgr.xq72_u7.csub[i]
print @q.xbgr.xq72_u8.qnpn13g2[ic]
print @q.xbgr.xq72_u8.qnpn13g2[ib]
print @q.xbgr.xq72_u8.qnpn13g2[ie]
print @q.xbgr.xq72_u8.qnpn13g2[is]
print @r.xbgr.xq72_u8.rsub[i]
print @c.xbgr.xq72_u8.csub[i]
print @q.xbgr.xq72_u9.qnpn13g2[ic]
print @q.xbgr.xq72_u9.qnpn13g2[ib]
print @q.xbgr.xq72_u9.qnpn13g2[ie]
print @q.xbgr.xq72_u9.qnpn13g2[is]
print @r.xbgr.xq72_u9.rsub[i]
print @c.xbgr.xq72_u9.csub[i]
print @q.xbgr.xq72_u10.qnpn13g2[ic]
print @q.xbgr.xq72_u10.qnpn13g2[ib]
print @q.xbgr.xq72_u10.qnpn13g2[ie]
print @q.xbgr.xq72_u10.qnpn13g2[is]
print @r.xbgr.xq72_u10.rsub[i]
print @c.xbgr.xq72_u10.csub[i]
print @q.xbgr.xq72_u11.qnpn13g2[ic]
print @q.xbgr.xq72_u11.qnpn13g2[ib]
print @q.xbgr.xq72_u11.qnpn13g2[ie]
print @q.xbgr.xq72_u11.qnpn13g2[is]
print @r.xbgr.xq72_u11.rsub[i]
print @c.xbgr.xq72_u11.csub[i]
print @q.xbgr.xq72_u12.qnpn13g2[ic]
print @q.xbgr.xq72_u12.qnpn13g2[ib]
print @q.xbgr.xq72_u12.qnpn13g2[ie]
print @q.xbgr.xq72_u12.qnpn13g2[is]
print @r.xbgr.xq72_u12.rsub[i]
print @c.xbgr.xq72_u12.csub[i]
print @q.xbgr.xq72_u13.qnpn13g2[ic]
print @q.xbgr.xq72_u13.qnpn13g2[ib]
print @q.xbgr.xq72_u13.qnpn13g2[ie]
print @q.xbgr.xq72_u13.qnpn13g2[is]
print @r.xbgr.xq72_u13.rsub[i]
print @c.xbgr.xq72_u13.csub[i]
print @q.xbgr.xq72_u14.qnpn13g2[ic]
print @q.xbgr.xq72_u14.qnpn13g2[ib]
print @q.xbgr.xq72_u14.qnpn13g2[ie]
print @q.xbgr.xq72_u14.qnpn13g2[is]
print @r.xbgr.xq72_u14.rsub[i]
print @c.xbgr.xq72_u14.csub[i]
print @q.xbgr.xq72_u15.qnpn13g2[ic]
print @q.xbgr.xq72_u15.qnpn13g2[ib]
print @q.xbgr.xq72_u15.qnpn13g2[ie]
print @q.xbgr.xq72_u15.qnpn13g2[is]
print @r.xbgr.xq72_u15.rsub[i]
print @c.xbgr.xq72_u15.csub[i]
print @q.xbgr.xq72_u16.qnpn13g2[ic]
print @q.xbgr.xq72_u16.qnpn13g2[ib]
print @q.xbgr.xq72_u16.qnpn13g2[ie]
print @q.xbgr.xq72_u16.qnpn13g2[is]
print @r.xbgr.xq72_u16.rsub[i]
print @c.xbgr.xq72_u16.csub[i]
print @q.xbgr.xq72_u17.qnpn13g2[ic]
print @q.xbgr.xq72_u17.qnpn13g2[ib]
print @q.xbgr.xq72_u17.qnpn13g2[ie]
print @q.xbgr.xq72_u17.qnpn13g2[is]
print @r.xbgr.xq72_u17.rsub[i]
print @c.xbgr.xq72_u17.csub[i]
print @q.xbgr.xq72_u18.qnpn13g2[ic]
print @q.xbgr.xq72_u18.qnpn13g2[ib]
print @q.xbgr.xq72_u18.qnpn13g2[ie]
print @q.xbgr.xq72_u18.qnpn13g2[is]
print @r.xbgr.xq72_u18.rsub[i]
print @c.xbgr.xq72_u18.csub[i]
print @q.xbgr.xq72_u19.qnpn13g2[ic]
print @q.xbgr.xq72_u19.qnpn13g2[ib]
print @q.xbgr.xq72_u19.qnpn13g2[ie]
print @q.xbgr.xq72_u19.qnpn13g2[is]
print @r.xbgr.xq72_u19.rsub[i]
print @c.xbgr.xq72_u19.csub[i]
print @q.xbgr.xq72_u20.qnpn13g2[ic]
print @q.xbgr.xq72_u20.qnpn13g2[ib]
print @q.xbgr.xq72_u20.qnpn13g2[ie]
print @q.xbgr.xq72_u20.qnpn13g2[is]
print @r.xbgr.xq72_u20.rsub[i]
print @c.xbgr.xq72_u20.csub[i]
print @q.xbgr.xq72_u21.qnpn13g2[ic]
print @q.xbgr.xq72_u21.qnpn13g2[ib]
print @q.xbgr.xq72_u21.qnpn13g2[ie]
print @q.xbgr.xq72_u21.qnpn13g2[is]
print @r.xbgr.xq72_u21.rsub[i]
print @c.xbgr.xq72_u21.csub[i]
print @q.xbgr.xq72_u22.qnpn13g2[ic]
print @q.xbgr.xq72_u22.qnpn13g2[ib]
print @q.xbgr.xq72_u22.qnpn13g2[ie]
print @q.xbgr.xq72_u22.qnpn13g2[is]
print @r.xbgr.xq72_u22.rsub[i]
print @c.xbgr.xq72_u22.csub[i]
print @q.xbgr.xq72_u23.qnpn13g2[ic]
print @q.xbgr.xq72_u23.qnpn13g2[ib]
print @q.xbgr.xq72_u23.qnpn13g2[ie]
print @q.xbgr.xq72_u23.qnpn13g2[is]
print @r.xbgr.xq72_u23.rsub[i]
print @c.xbgr.xq72_u23.csub[i]
print @q.xbgr.xq72_u24.qnpn13g2[ic]
print @q.xbgr.xq72_u24.qnpn13g2[ib]
print @q.xbgr.xq72_u24.qnpn13g2[ie]
print @q.xbgr.xq72_u24.qnpn13g2[is]
print @r.xbgr.xq72_u24.rsub[i]
print @c.xbgr.xq72_u24.csub[i]
print @q.xbgr.xq73_u2.qnpn13g2[ic]
print @q.xbgr.xq73_u2.qnpn13g2[ib]
print @q.xbgr.xq73_u2.qnpn13g2[ie]
print @q.xbgr.xq73_u2.qnpn13g2[is]
print @r.xbgr.xq73_u2.rsub[i]
print @c.xbgr.xq73_u2.csub[i]
print @q.xbgr.xq73_u3.qnpn13g2[ic]
print @q.xbgr.xq73_u3.qnpn13g2[ib]
print @q.xbgr.xq73_u3.qnpn13g2[ie]
print @q.xbgr.xq73_u3.qnpn13g2[is]
print @r.xbgr.xq73_u3.rsub[i]
print @c.xbgr.xq73_u3.csub[i]
print @q.xbgr.xq73_u4.qnpn13g2[ic]
print @q.xbgr.xq73_u4.qnpn13g2[ib]
print @q.xbgr.xq73_u4.qnpn13g2[ie]
print @q.xbgr.xq73_u4.qnpn13g2[is]
print @r.xbgr.xq73_u4.rsub[i]
print @c.xbgr.xq73_u4.csub[i]
print @q.xbgr.xq73_u5.qnpn13g2[ic]
print @q.xbgr.xq73_u5.qnpn13g2[ib]
print @q.xbgr.xq73_u5.qnpn13g2[ie]
print @q.xbgr.xq73_u5.qnpn13g2[is]
print @r.xbgr.xq73_u5.rsub[i]
print @c.xbgr.xq73_u5.csub[i]
print @q.xbgr.xq73_u6.qnpn13g2[ic]
print @q.xbgr.xq73_u6.qnpn13g2[ib]
print @q.xbgr.xq73_u6.qnpn13g2[ie]
print @q.xbgr.xq73_u6.qnpn13g2[is]
print @r.xbgr.xq73_u6.rsub[i]
print @c.xbgr.xq73_u6.csub[i]
print @q.xbgr.xq73_u7.qnpn13g2[ic]
print @q.xbgr.xq73_u7.qnpn13g2[ib]
print @q.xbgr.xq73_u7.qnpn13g2[ie]
print @q.xbgr.xq73_u7.qnpn13g2[is]
print @r.xbgr.xq73_u7.rsub[i]
print @c.xbgr.xq73_u7.csub[i]
print @q.xbgr.xq73_u8.qnpn13g2[ic]
print @q.xbgr.xq73_u8.qnpn13g2[ib]
print @q.xbgr.xq73_u8.qnpn13g2[ie]
print @q.xbgr.xq73_u8.qnpn13g2[is]
print @r.xbgr.xq73_u8.rsub[i]
print @c.xbgr.xq73_u8.csub[i]
print @q.xbgr.xq73_u9.qnpn13g2[ic]
print @q.xbgr.xq73_u9.qnpn13g2[ib]
print @q.xbgr.xq73_u9.qnpn13g2[ie]
print @q.xbgr.xq73_u9.qnpn13g2[is]
print @r.xbgr.xq73_u9.rsub[i]
print @c.xbgr.xq73_u9.csub[i]
print @q.xbgr.xq73_u10.qnpn13g2[ic]
print @q.xbgr.xq73_u10.qnpn13g2[ib]
print @q.xbgr.xq73_u10.qnpn13g2[ie]
print @q.xbgr.xq73_u10.qnpn13g2[is]
print @r.xbgr.xq73_u10.rsub[i]
print @c.xbgr.xq73_u10.csub[i]
print @q.xbgr.xq73_u11.qnpn13g2[ic]
print @q.xbgr.xq73_u11.qnpn13g2[ib]
print @q.xbgr.xq73_u11.qnpn13g2[ie]
print @q.xbgr.xq73_u11.qnpn13g2[is]
print @r.xbgr.xq73_u11.rsub[i]
print @c.xbgr.xq73_u11.csub[i]
print @q.xbgr.xq73_u12.qnpn13g2[ic]
print @q.xbgr.xq73_u12.qnpn13g2[ib]
print @q.xbgr.xq73_u12.qnpn13g2[ie]
print @q.xbgr.xq73_u12.qnpn13g2[is]
print @r.xbgr.xq73_u12.rsub[i]
print @c.xbgr.xq73_u12.csub[i]
print @q.xbgr.xq73_u13.qnpn13g2[ic]
print @q.xbgr.xq73_u13.qnpn13g2[ib]
print @q.xbgr.xq73_u13.qnpn13g2[ie]
print @q.xbgr.xq73_u13.qnpn13g2[is]
print @r.xbgr.xq73_u13.rsub[i]
print @c.xbgr.xq73_u13.csub[i]
print @q.xbgr.xq73_u14.qnpn13g2[ic]
print @q.xbgr.xq73_u14.qnpn13g2[ib]
print @q.xbgr.xq73_u14.qnpn13g2[ie]
print @q.xbgr.xq73_u14.qnpn13g2[is]
print @r.xbgr.xq73_u14.rsub[i]
print @c.xbgr.xq73_u14.csub[i]
print @q.xbgr.xq73_u15.qnpn13g2[ic]
print @q.xbgr.xq73_u15.qnpn13g2[ib]
print @q.xbgr.xq73_u15.qnpn13g2[ie]
print @q.xbgr.xq73_u15.qnpn13g2[is]
print @r.xbgr.xq73_u15.rsub[i]
print @c.xbgr.xq73_u15.csub[i]
print @q.xbgr.xq73_u16.qnpn13g2[ic]
print @q.xbgr.xq73_u16.qnpn13g2[ib]
print @q.xbgr.xq73_u16.qnpn13g2[ie]
print @q.xbgr.xq73_u16.qnpn13g2[is]
print @r.xbgr.xq73_u16.rsub[i]
print @c.xbgr.xq73_u16.csub[i]
print @q.xbgr.xq73_u17.qnpn13g2[ic]
print @q.xbgr.xq73_u17.qnpn13g2[ib]
print @q.xbgr.xq73_u17.qnpn13g2[ie]
print @q.xbgr.xq73_u17.qnpn13g2[is]
print @r.xbgr.xq73_u17.rsub[i]
print @c.xbgr.xq73_u17.csub[i]
print @q.xbgr.xq73_u18.qnpn13g2[ic]
print @q.xbgr.xq73_u18.qnpn13g2[ib]
print @q.xbgr.xq73_u18.qnpn13g2[ie]
print @q.xbgr.xq73_u18.qnpn13g2[is]
print @r.xbgr.xq73_u18.rsub[i]
print @c.xbgr.xq73_u18.csub[i]
print @q.xbgr.xq73_u19.qnpn13g2[ic]
print @q.xbgr.xq73_u19.qnpn13g2[ib]
print @q.xbgr.xq73_u19.qnpn13g2[ie]
print @q.xbgr.xq73_u19.qnpn13g2[is]
print @r.xbgr.xq73_u19.rsub[i]
print @c.xbgr.xq73_u19.csub[i]
print @q.xbgr.xq73_u20.qnpn13g2[ic]
print @q.xbgr.xq73_u20.qnpn13g2[ib]
print @q.xbgr.xq73_u20.qnpn13g2[ie]
print @q.xbgr.xq73_u20.qnpn13g2[is]
print @r.xbgr.xq73_u20.rsub[i]
print @c.xbgr.xq73_u20.csub[i]
print @q.xbgr.xq73_u21.qnpn13g2[ic]
print @q.xbgr.xq73_u21.qnpn13g2[ib]
print @q.xbgr.xq73_u21.qnpn13g2[ie]
print @q.xbgr.xq73_u21.qnpn13g2[is]
print @r.xbgr.xq73_u21.rsub[i]
print @c.xbgr.xq73_u21.csub[i]
print @q.xbgr.xq73_u22.qnpn13g2[ic]
print @q.xbgr.xq73_u22.qnpn13g2[ib]
print @q.xbgr.xq73_u22.qnpn13g2[ie]
print @q.xbgr.xq73_u22.qnpn13g2[is]
print @r.xbgr.xq73_u22.rsub[i]
print @c.xbgr.xq73_u22.csub[i]
print @q.xbgr.xq73_u23.qnpn13g2[ic]
print @q.xbgr.xq73_u23.qnpn13g2[ib]
print @q.xbgr.xq73_u23.qnpn13g2[ie]
print @q.xbgr.xq73_u23.qnpn13g2[is]
print @r.xbgr.xq73_u23.rsub[i]
print @c.xbgr.xq73_u23.csub[i]
print @q.xbgr.xq73_u24.qnpn13g2[ic]
print @q.xbgr.xq73_u24.qnpn13g2[ib]
print @q.xbgr.xq73_u24.qnpn13g2[ie]
print @q.xbgr.xq73_u24.qnpn13g2[is]
print @r.xbgr.xq73_u24.rsub[i]
print @c.xbgr.xq73_u24.csub[i]
print @q.xbgr.xq74_u2.qnpn13g2[ic]
print @q.xbgr.xq74_u2.qnpn13g2[ib]
print @q.xbgr.xq74_u2.qnpn13g2[ie]
print @q.xbgr.xq74_u2.qnpn13g2[is]
print @r.xbgr.xq74_u2.rsub[i]
print @c.xbgr.xq74_u2.csub[i]
print @q.xbgr.xq74_u3.qnpn13g2[ic]
print @q.xbgr.xq74_u3.qnpn13g2[ib]
print @q.xbgr.xq74_u3.qnpn13g2[ie]
print @q.xbgr.xq74_u3.qnpn13g2[is]
print @r.xbgr.xq74_u3.rsub[i]
print @c.xbgr.xq74_u3.csub[i]
print @q.xbgr.xq74_u4.qnpn13g2[ic]
print @q.xbgr.xq74_u4.qnpn13g2[ib]
print @q.xbgr.xq74_u4.qnpn13g2[ie]
print @q.xbgr.xq74_u4.qnpn13g2[is]
print @r.xbgr.xq74_u4.rsub[i]
print @c.xbgr.xq74_u4.csub[i]
print @q.xbgr.xq74_u5.qnpn13g2[ic]
print @q.xbgr.xq74_u5.qnpn13g2[ib]
print @q.xbgr.xq74_u5.qnpn13g2[ie]
print @q.xbgr.xq74_u5.qnpn13g2[is]
print @r.xbgr.xq74_u5.rsub[i]
print @c.xbgr.xq74_u5.csub[i]
print @q.xbgr.xq74_u6.qnpn13g2[ic]
print @q.xbgr.xq74_u6.qnpn13g2[ib]
print @q.xbgr.xq74_u6.qnpn13g2[ie]
print @q.xbgr.xq74_u6.qnpn13g2[is]
print @r.xbgr.xq74_u6.rsub[i]
print @c.xbgr.xq74_u6.csub[i]
print @q.xbgr.xq74_u7.qnpn13g2[ic]
print @q.xbgr.xq74_u7.qnpn13g2[ib]
print @q.xbgr.xq74_u7.qnpn13g2[ie]
print @q.xbgr.xq74_u7.qnpn13g2[is]
print @r.xbgr.xq74_u7.rsub[i]
print @c.xbgr.xq74_u7.csub[i]
print @q.xbgr.xq74_u8.qnpn13g2[ic]
print @q.xbgr.xq74_u8.qnpn13g2[ib]
print @q.xbgr.xq74_u8.qnpn13g2[ie]
print @q.xbgr.xq74_u8.qnpn13g2[is]
print @r.xbgr.xq74_u8.rsub[i]
print @c.xbgr.xq74_u8.csub[i]
print @q.xbgr.xq74_u9.qnpn13g2[ic]
print @q.xbgr.xq74_u9.qnpn13g2[ib]
print @q.xbgr.xq74_u9.qnpn13g2[ie]
print @q.xbgr.xq74_u9.qnpn13g2[is]
print @r.xbgr.xq74_u9.rsub[i]
print @c.xbgr.xq74_u9.csub[i]
print @q.xbgr.xq74_u10.qnpn13g2[ic]
print @q.xbgr.xq74_u10.qnpn13g2[ib]
print @q.xbgr.xq74_u10.qnpn13g2[ie]
print @q.xbgr.xq74_u10.qnpn13g2[is]
print @r.xbgr.xq74_u10.rsub[i]
print @c.xbgr.xq74_u10.csub[i]
print @q.xbgr.xq74_u11.qnpn13g2[ic]
print @q.xbgr.xq74_u11.qnpn13g2[ib]
print @q.xbgr.xq74_u11.qnpn13g2[ie]
print @q.xbgr.xq74_u11.qnpn13g2[is]
print @r.xbgr.xq74_u11.rsub[i]
print @c.xbgr.xq74_u11.csub[i]
print @q.xbgr.xq74_u12.qnpn13g2[ic]
print @q.xbgr.xq74_u12.qnpn13g2[ib]
print @q.xbgr.xq74_u12.qnpn13g2[ie]
print @q.xbgr.xq74_u12.qnpn13g2[is]
print @r.xbgr.xq74_u12.rsub[i]
print @c.xbgr.xq74_u12.csub[i]
print @q.xbgr.xq74_u13.qnpn13g2[ic]
print @q.xbgr.xq74_u13.qnpn13g2[ib]
print @q.xbgr.xq74_u13.qnpn13g2[ie]
print @q.xbgr.xq74_u13.qnpn13g2[is]
print @r.xbgr.xq74_u13.rsub[i]
print @c.xbgr.xq74_u13.csub[i]
print @q.xbgr.xq74_u14.qnpn13g2[ic]
print @q.xbgr.xq74_u14.qnpn13g2[ib]
print @q.xbgr.xq74_u14.qnpn13g2[ie]
print @q.xbgr.xq74_u14.qnpn13g2[is]
print @r.xbgr.xq74_u14.rsub[i]
print @c.xbgr.xq74_u14.csub[i]
print @q.xbgr.xq74_u15.qnpn13g2[ic]
print @q.xbgr.xq74_u15.qnpn13g2[ib]
print @q.xbgr.xq74_u15.qnpn13g2[ie]
print @q.xbgr.xq74_u15.qnpn13g2[is]
print @r.xbgr.xq74_u15.rsub[i]
print @c.xbgr.xq74_u15.csub[i]
print @q.xbgr.xq74_u16.qnpn13g2[ic]
print @q.xbgr.xq74_u16.qnpn13g2[ib]
print @q.xbgr.xq74_u16.qnpn13g2[ie]
print @q.xbgr.xq74_u16.qnpn13g2[is]
print @r.xbgr.xq74_u16.rsub[i]
print @c.xbgr.xq74_u16.csub[i]
print @q.xbgr.xq74_u17.qnpn13g2[ic]
print @q.xbgr.xq74_u17.qnpn13g2[ib]
print @q.xbgr.xq74_u17.qnpn13g2[ie]
print @q.xbgr.xq74_u17.qnpn13g2[is]
print @r.xbgr.xq74_u17.rsub[i]
print @c.xbgr.xq74_u17.csub[i]
print @q.xbgr.xq74_u18.qnpn13g2[ic]
print @q.xbgr.xq74_u18.qnpn13g2[ib]
print @q.xbgr.xq74_u18.qnpn13g2[ie]
print @q.xbgr.xq74_u18.qnpn13g2[is]
print @r.xbgr.xq74_u18.rsub[i]
print @c.xbgr.xq74_u18.csub[i]
print @q.xbgr.xq74_u19.qnpn13g2[ic]
print @q.xbgr.xq74_u19.qnpn13g2[ib]
print @q.xbgr.xq74_u19.qnpn13g2[ie]
print @q.xbgr.xq74_u19.qnpn13g2[is]
print @r.xbgr.xq74_u19.rsub[i]
print @c.xbgr.xq74_u19.csub[i]
print @q.xbgr.xq74_u20.qnpn13g2[ic]
print @q.xbgr.xq74_u20.qnpn13g2[ib]
print @q.xbgr.xq74_u20.qnpn13g2[ie]
print @q.xbgr.xq74_u20.qnpn13g2[is]
print @r.xbgr.xq74_u20.rsub[i]
print @c.xbgr.xq74_u20.csub[i]
print @q.xbgr.xq74_u21.qnpn13g2[ic]
print @q.xbgr.xq74_u21.qnpn13g2[ib]
print @q.xbgr.xq74_u21.qnpn13g2[ie]
print @q.xbgr.xq74_u21.qnpn13g2[is]
print @r.xbgr.xq74_u21.rsub[i]
print @c.xbgr.xq74_u21.csub[i]
print @q.xbgr.xq74_u22.qnpn13g2[ic]
print @q.xbgr.xq74_u22.qnpn13g2[ib]
print @q.xbgr.xq74_u22.qnpn13g2[ie]
print @q.xbgr.xq74_u22.qnpn13g2[is]
print @r.xbgr.xq74_u22.rsub[i]
print @c.xbgr.xq74_u22.csub[i]
print @q.xbgr.xq74_u23.qnpn13g2[ic]
print @q.xbgr.xq74_u23.qnpn13g2[ib]
print @q.xbgr.xq74_u23.qnpn13g2[ie]
print @q.xbgr.xq74_u23.qnpn13g2[is]
print @r.xbgr.xq74_u23.rsub[i]
print @c.xbgr.xq74_u23.csub[i]
print @q.xbgr.xq74_u24.qnpn13g2[ic]
print @q.xbgr.xq74_u24.qnpn13g2[ib]
print @q.xbgr.xq74_u24.qnpn13g2[ie]
print @q.xbgr.xq74_u24.qnpn13g2[is]
print @r.xbgr.xq74_u24.rsub[i]
print @c.xbgr.xq74_u24.csub[i]
print @q.xbgr.xq75_u2.qnpn13g2[ic]
print @q.xbgr.xq75_u2.qnpn13g2[ib]
print @q.xbgr.xq75_u2.qnpn13g2[ie]
print @q.xbgr.xq75_u2.qnpn13g2[is]
print @r.xbgr.xq75_u2.rsub[i]
print @c.xbgr.xq75_u2.csub[i]
print @q.xbgr.xq75_u3.qnpn13g2[ic]
print @q.xbgr.xq75_u3.qnpn13g2[ib]
print @q.xbgr.xq75_u3.qnpn13g2[ie]
print @q.xbgr.xq75_u3.qnpn13g2[is]
print @r.xbgr.xq75_u3.rsub[i]
print @c.xbgr.xq75_u3.csub[i]
print @q.xbgr.xq75_u4.qnpn13g2[ic]
print @q.xbgr.xq75_u4.qnpn13g2[ib]
print @q.xbgr.xq75_u4.qnpn13g2[ie]
print @q.xbgr.xq75_u4.qnpn13g2[is]
print @r.xbgr.xq75_u4.rsub[i]
print @c.xbgr.xq75_u4.csub[i]
print @q.xbgr.xq75_u5.qnpn13g2[ic]
print @q.xbgr.xq75_u5.qnpn13g2[ib]
print @q.xbgr.xq75_u5.qnpn13g2[ie]
print @q.xbgr.xq75_u5.qnpn13g2[is]
print @r.xbgr.xq75_u5.rsub[i]
print @c.xbgr.xq75_u5.csub[i]
print @q.xbgr.xq75_u6.qnpn13g2[ic]
print @q.xbgr.xq75_u6.qnpn13g2[ib]
print @q.xbgr.xq75_u6.qnpn13g2[ie]
print @q.xbgr.xq75_u6.qnpn13g2[is]
print @r.xbgr.xq75_u6.rsub[i]
print @c.xbgr.xq75_u6.csub[i]
print @q.xbgr.xq75_u7.qnpn13g2[ic]
print @q.xbgr.xq75_u7.qnpn13g2[ib]
print @q.xbgr.xq75_u7.qnpn13g2[ie]
print @q.xbgr.xq75_u7.qnpn13g2[is]
print @r.xbgr.xq75_u7.rsub[i]
print @c.xbgr.xq75_u7.csub[i]
print @q.xbgr.xq75_u8.qnpn13g2[ic]
print @q.xbgr.xq75_u8.qnpn13g2[ib]
print @q.xbgr.xq75_u8.qnpn13g2[ie]
print @q.xbgr.xq75_u8.qnpn13g2[is]
print @r.xbgr.xq75_u8.rsub[i]
print @c.xbgr.xq75_u8.csub[i]
print @q.xbgr.xq75_u9.qnpn13g2[ic]
print @q.xbgr.xq75_u9.qnpn13g2[ib]
print @q.xbgr.xq75_u9.qnpn13g2[ie]
print @q.xbgr.xq75_u9.qnpn13g2[is]
print @r.xbgr.xq75_u9.rsub[i]
print @c.xbgr.xq75_u9.csub[i]
print @q.xbgr.xq75_u10.qnpn13g2[ic]
print @q.xbgr.xq75_u10.qnpn13g2[ib]
print @q.xbgr.xq75_u10.qnpn13g2[ie]
print @q.xbgr.xq75_u10.qnpn13g2[is]
print @r.xbgr.xq75_u10.rsub[i]
print @c.xbgr.xq75_u10.csub[i]
print @q.xbgr.xq75_u11.qnpn13g2[ic]
print @q.xbgr.xq75_u11.qnpn13g2[ib]
print @q.xbgr.xq75_u11.qnpn13g2[ie]
print @q.xbgr.xq75_u11.qnpn13g2[is]
print @r.xbgr.xq75_u11.rsub[i]
print @c.xbgr.xq75_u11.csub[i]
print @q.xbgr.xq75_u12.qnpn13g2[ic]
print @q.xbgr.xq75_u12.qnpn13g2[ib]
print @q.xbgr.xq75_u12.qnpn13g2[ie]
print @q.xbgr.xq75_u12.qnpn13g2[is]
print @r.xbgr.xq75_u12.rsub[i]
print @c.xbgr.xq75_u12.csub[i]
print @q.xbgr.xq75_u13.qnpn13g2[ic]
print @q.xbgr.xq75_u13.qnpn13g2[ib]
print @q.xbgr.xq75_u13.qnpn13g2[ie]
print @q.xbgr.xq75_u13.qnpn13g2[is]
print @r.xbgr.xq75_u13.rsub[i]
print @c.xbgr.xq75_u13.csub[i]
print @q.xbgr.xq75_u14.qnpn13g2[ic]
print @q.xbgr.xq75_u14.qnpn13g2[ib]
print @q.xbgr.xq75_u14.qnpn13g2[ie]
print @q.xbgr.xq75_u14.qnpn13g2[is]
print @r.xbgr.xq75_u14.rsub[i]
print @c.xbgr.xq75_u14.csub[i]
print @q.xbgr.xq75_u15.qnpn13g2[ic]
print @q.xbgr.xq75_u15.qnpn13g2[ib]
print @q.xbgr.xq75_u15.qnpn13g2[ie]
print @q.xbgr.xq75_u15.qnpn13g2[is]
print @r.xbgr.xq75_u15.rsub[i]
print @c.xbgr.xq75_u15.csub[i]
print @q.xbgr.xq75_u16.qnpn13g2[ic]
print @q.xbgr.xq75_u16.qnpn13g2[ib]
print @q.xbgr.xq75_u16.qnpn13g2[ie]
print @q.xbgr.xq75_u16.qnpn13g2[is]
print @r.xbgr.xq75_u16.rsub[i]
print @c.xbgr.xq75_u16.csub[i]
print @q.xbgr.xq75_u17.qnpn13g2[ic]
print @q.xbgr.xq75_u17.qnpn13g2[ib]
print @q.xbgr.xq75_u17.qnpn13g2[ie]
print @q.xbgr.xq75_u17.qnpn13g2[is]
print @r.xbgr.xq75_u17.rsub[i]
print @c.xbgr.xq75_u17.csub[i]
print @q.xbgr.xq75_u18.qnpn13g2[ic]
print @q.xbgr.xq75_u18.qnpn13g2[ib]
print @q.xbgr.xq75_u18.qnpn13g2[ie]
print @q.xbgr.xq75_u18.qnpn13g2[is]
print @r.xbgr.xq75_u18.rsub[i]
print @c.xbgr.xq75_u18.csub[i]
print @q.xbgr.xq75_u19.qnpn13g2[ic]
print @q.xbgr.xq75_u19.qnpn13g2[ib]
print @q.xbgr.xq75_u19.qnpn13g2[ie]
print @q.xbgr.xq75_u19.qnpn13g2[is]
print @r.xbgr.xq75_u19.rsub[i]
print @c.xbgr.xq75_u19.csub[i]
print @q.xbgr.xq75_u20.qnpn13g2[ic]
print @q.xbgr.xq75_u20.qnpn13g2[ib]
print @q.xbgr.xq75_u20.qnpn13g2[ie]
print @q.xbgr.xq75_u20.qnpn13g2[is]
print @r.xbgr.xq75_u20.rsub[i]
print @c.xbgr.xq75_u20.csub[i]
print @q.xbgr.xq75_u21.qnpn13g2[ic]
print @q.xbgr.xq75_u21.qnpn13g2[ib]
print @q.xbgr.xq75_u21.qnpn13g2[ie]
print @q.xbgr.xq75_u21.qnpn13g2[is]
print @r.xbgr.xq75_u21.rsub[i]
print @c.xbgr.xq75_u21.csub[i]
print @q.xbgr.xq75_u22.qnpn13g2[ic]
print @q.xbgr.xq75_u22.qnpn13g2[ib]
print @q.xbgr.xq75_u22.qnpn13g2[ie]
print @q.xbgr.xq75_u22.qnpn13g2[is]
print @r.xbgr.xq75_u22.rsub[i]
print @c.xbgr.xq75_u22.csub[i]
print @q.xbgr.xq75_u23.qnpn13g2[ic]
print @q.xbgr.xq75_u23.qnpn13g2[ib]
print @q.xbgr.xq75_u23.qnpn13g2[ie]
print @q.xbgr.xq75_u23.qnpn13g2[is]
print @r.xbgr.xq75_u23.rsub[i]
print @c.xbgr.xq75_u23.csub[i]
print @q.xbgr.xq75_u24.qnpn13g2[ic]
print @q.xbgr.xq75_u24.qnpn13g2[ib]
print @q.xbgr.xq75_u24.qnpn13g2[ie]
print @q.xbgr.xq75_u24.qnpn13g2[is]
print @r.xbgr.xq75_u24.rsub[i]
print @c.xbgr.xq75_u24.csub[i]
print @q.xbgr.xq76_u2.qnpn13g2[ic]
print @q.xbgr.xq76_u2.qnpn13g2[ib]
print @q.xbgr.xq76_u2.qnpn13g2[ie]
print @q.xbgr.xq76_u2.qnpn13g2[is]
print @r.xbgr.xq76_u2.rsub[i]
print @c.xbgr.xq76_u2.csub[i]
print @q.xbgr.xq76_u3.qnpn13g2[ic]
print @q.xbgr.xq76_u3.qnpn13g2[ib]
print @q.xbgr.xq76_u3.qnpn13g2[ie]
print @q.xbgr.xq76_u3.qnpn13g2[is]
print @r.xbgr.xq76_u3.rsub[i]
print @c.xbgr.xq76_u3.csub[i]
print @q.xbgr.xq76_u4.qnpn13g2[ic]
print @q.xbgr.xq76_u4.qnpn13g2[ib]
print @q.xbgr.xq76_u4.qnpn13g2[ie]
print @q.xbgr.xq76_u4.qnpn13g2[is]
print @r.xbgr.xq76_u4.rsub[i]
print @c.xbgr.xq76_u4.csub[i]
print @q.xbgr.xq76_u5.qnpn13g2[ic]
print @q.xbgr.xq76_u5.qnpn13g2[ib]
print @q.xbgr.xq76_u5.qnpn13g2[ie]
print @q.xbgr.xq76_u5.qnpn13g2[is]
print @r.xbgr.xq76_u5.rsub[i]
print @c.xbgr.xq76_u5.csub[i]
print @q.xbgr.xq76_u6.qnpn13g2[ic]
print @q.xbgr.xq76_u6.qnpn13g2[ib]
print @q.xbgr.xq76_u6.qnpn13g2[ie]
print @q.xbgr.xq76_u6.qnpn13g2[is]
print @r.xbgr.xq76_u6.rsub[i]
print @c.xbgr.xq76_u6.csub[i]
print @q.xbgr.xq76_u7.qnpn13g2[ic]
print @q.xbgr.xq76_u7.qnpn13g2[ib]
print @q.xbgr.xq76_u7.qnpn13g2[ie]
print @q.xbgr.xq76_u7.qnpn13g2[is]
print @r.xbgr.xq76_u7.rsub[i]
print @c.xbgr.xq76_u7.csub[i]
print @q.xbgr.xq76_u8.qnpn13g2[ic]
print @q.xbgr.xq76_u8.qnpn13g2[ib]
print @q.xbgr.xq76_u8.qnpn13g2[ie]
print @q.xbgr.xq76_u8.qnpn13g2[is]
print @r.xbgr.xq76_u8.rsub[i]
print @c.xbgr.xq76_u8.csub[i]
print @q.xbgr.xq76_u9.qnpn13g2[ic]
print @q.xbgr.xq76_u9.qnpn13g2[ib]
print @q.xbgr.xq76_u9.qnpn13g2[ie]
print @q.xbgr.xq76_u9.qnpn13g2[is]
print @r.xbgr.xq76_u9.rsub[i]
print @c.xbgr.xq76_u9.csub[i]
print @q.xbgr.xq76_u10.qnpn13g2[ic]
print @q.xbgr.xq76_u10.qnpn13g2[ib]
print @q.xbgr.xq76_u10.qnpn13g2[ie]
print @q.xbgr.xq76_u10.qnpn13g2[is]
print @r.xbgr.xq76_u10.rsub[i]
print @c.xbgr.xq76_u10.csub[i]
print @q.xbgr.xq76_u11.qnpn13g2[ic]
print @q.xbgr.xq76_u11.qnpn13g2[ib]
print @q.xbgr.xq76_u11.qnpn13g2[ie]
print @q.xbgr.xq76_u11.qnpn13g2[is]
print @r.xbgr.xq76_u11.rsub[i]
print @c.xbgr.xq76_u11.csub[i]
print @q.xbgr.xq76_u12.qnpn13g2[ic]
print @q.xbgr.xq76_u12.qnpn13g2[ib]
print @q.xbgr.xq76_u12.qnpn13g2[ie]
print @q.xbgr.xq76_u12.qnpn13g2[is]
print @r.xbgr.xq76_u12.rsub[i]
print @c.xbgr.xq76_u12.csub[i]
print @q.xbgr.xq76_u13.qnpn13g2[ic]
print @q.xbgr.xq76_u13.qnpn13g2[ib]
print @q.xbgr.xq76_u13.qnpn13g2[ie]
print @q.xbgr.xq76_u13.qnpn13g2[is]
print @r.xbgr.xq76_u13.rsub[i]
print @c.xbgr.xq76_u13.csub[i]
print @q.xbgr.xq76_u14.qnpn13g2[ic]
print @q.xbgr.xq76_u14.qnpn13g2[ib]
print @q.xbgr.xq76_u14.qnpn13g2[ie]
print @q.xbgr.xq76_u14.qnpn13g2[is]
print @r.xbgr.xq76_u14.rsub[i]
print @c.xbgr.xq76_u14.csub[i]
print @q.xbgr.xq76_u15.qnpn13g2[ic]
print @q.xbgr.xq76_u15.qnpn13g2[ib]
print @q.xbgr.xq76_u15.qnpn13g2[ie]
print @q.xbgr.xq76_u15.qnpn13g2[is]
print @r.xbgr.xq76_u15.rsub[i]
print @c.xbgr.xq76_u15.csub[i]
print @q.xbgr.xq76_u16.qnpn13g2[ic]
print @q.xbgr.xq76_u16.qnpn13g2[ib]
print @q.xbgr.xq76_u16.qnpn13g2[ie]
print @q.xbgr.xq76_u16.qnpn13g2[is]
print @r.xbgr.xq76_u16.rsub[i]
print @c.xbgr.xq76_u16.csub[i]
print @q.xbgr.xq76_u17.qnpn13g2[ic]
print @q.xbgr.xq76_u17.qnpn13g2[ib]
print @q.xbgr.xq76_u17.qnpn13g2[ie]
print @q.xbgr.xq76_u17.qnpn13g2[is]
print @r.xbgr.xq76_u17.rsub[i]
print @c.xbgr.xq76_u17.csub[i]
print @q.xbgr.xq76_u18.qnpn13g2[ic]
print @q.xbgr.xq76_u18.qnpn13g2[ib]
print @q.xbgr.xq76_u18.qnpn13g2[ie]
print @q.xbgr.xq76_u18.qnpn13g2[is]
print @r.xbgr.xq76_u18.rsub[i]
print @c.xbgr.xq76_u18.csub[i]
print @q.xbgr.xq76_u19.qnpn13g2[ic]
print @q.xbgr.xq76_u19.qnpn13g2[ib]
print @q.xbgr.xq76_u19.qnpn13g2[ie]
print @q.xbgr.xq76_u19.qnpn13g2[is]
print @r.xbgr.xq76_u19.rsub[i]
print @c.xbgr.xq76_u19.csub[i]
print @q.xbgr.xq76_u20.qnpn13g2[ic]
print @q.xbgr.xq76_u20.qnpn13g2[ib]
print @q.xbgr.xq76_u20.qnpn13g2[ie]
print @q.xbgr.xq76_u20.qnpn13g2[is]
print @r.xbgr.xq76_u20.rsub[i]
print @c.xbgr.xq76_u20.csub[i]
print @q.xbgr.xq76_u21.qnpn13g2[ic]
print @q.xbgr.xq76_u21.qnpn13g2[ib]
print @q.xbgr.xq76_u21.qnpn13g2[ie]
print @q.xbgr.xq76_u21.qnpn13g2[is]
print @r.xbgr.xq76_u21.rsub[i]
print @c.xbgr.xq76_u21.csub[i]
print @q.xbgr.xq76_u22.qnpn13g2[ic]
print @q.xbgr.xq76_u22.qnpn13g2[ib]
print @q.xbgr.xq76_u22.qnpn13g2[ie]
print @q.xbgr.xq76_u22.qnpn13g2[is]
print @r.xbgr.xq76_u22.rsub[i]
print @c.xbgr.xq76_u22.csub[i]
print @q.xbgr.xq76_u23.qnpn13g2[ic]
print @q.xbgr.xq76_u23.qnpn13g2[ib]
print @q.xbgr.xq76_u23.qnpn13g2[ie]
print @q.xbgr.xq76_u23.qnpn13g2[is]
print @r.xbgr.xq76_u23.rsub[i]
print @c.xbgr.xq76_u23.csub[i]
print @q.xbgr.xq76_u24.qnpn13g2[ic]
print @q.xbgr.xq76_u24.qnpn13g2[ib]
print @q.xbgr.xq76_u24.qnpn13g2[ie]
print @q.xbgr.xq76_u24.qnpn13g2[is]
print @r.xbgr.xq76_u24.rsub[i]
print @c.xbgr.xq76_u24.csub[i]
print @n.xbgr.xr77_u2.nr1[ibody]
print @n.xbgr.xr77_u3.nr1[ibody]
print @n.xbgr.xr77_u4.nr1[ibody]
print @n.xbgr.xr77_u5.nr1[ibody]
print @n.xbgr.xr77_u6.nr1[ibody]
print @n.xbgr.xr77_u7.nr1[ibody]
print @n.xbgr.xr77_u8.nr1[ibody]
print @n.xbgr.xr77_u9.nr1[ibody]
print @n.xbgr.xr77_u10.nr1[ibody]
print @n.xbgr.xr77_u11.nr1[ibody]
print @n.xbgr.xr77_u12.nr1[ibody]
print @n.xbgr.xr77_u13.nr1[ibody]
print @n.xbgr.xr77_u14.nr1[ibody]
print @n.xbgr.xr77_u15.nr1[ibody]
print @n.xbgr.xr77_u16.nr1[ibody]
print @n.xbgr.xr77_u17.nr1[ibody]
print @n.xbgr.xr77_u18.nr1[ibody]
print @n.xbgr.xr77_u19.nr1[ibody]
print @n.xbgr.xr77_u20.nr1[ibody]
print @n.xbgr.xr77_u21.nr1[ibody]
print @n.xbgr.xr77_u22.nr1[ibody]
print @n.xbgr.xr77_u23.nr1[ibody]
print @n.xbgr.xr77_u24.nr1[ibody]
print @n.xbgr.xr78_u2.nr1[ibody]
print @n.xbgr.xr78_u3.nr1[ibody]
print @n.xbgr.xr78_u4.nr1[ibody]
print @n.xbgr.xr78_u5.nr1[ibody]
print @n.xbgr.xr78_u6.nr1[ibody]
print @n.xbgr.xr78_u7.nr1[ibody]
print @n.xbgr.xr78_u8.nr1[ibody]
print @n.xbgr.xr78_u9.nr1[ibody]
print @n.xbgr.xr78_u10.nr1[ibody]
print @n.xbgr.xr78_u11.nr1[ibody]
print @n.xbgr.xr78_u12.nr1[ibody]
print @n.xbgr.xr78_u13.nr1[ibody]
print @n.xbgr.xr78_u14.nr1[ibody]
print @n.xbgr.xr78_u15.nr1[ibody]
print @n.xbgr.xr78_u16.nr1[ibody]
print @n.xbgr.xr78_u17.nr1[ibody]
print @n.xbgr.xr78_u18.nr1[ibody]
print @n.xbgr.xr78_u19.nr1[ibody]
print @n.xbgr.xr78_u20.nr1[ibody]
print @n.xbgr.xr78_u21.nr1[ibody]
print @n.xbgr.xr78_u22.nr1[ibody]
print @n.xbgr.xr78_u23.nr1[ibody]
print @n.xbgr.xr78_u24.nr1[ibody]
print @n.xbgr.xr79_u2.nr1[ibody]
print @n.xbgr.xr79_u3.nr1[ibody]
print @n.xbgr.xr79_u4.nr1[ibody]
print @n.xbgr.xr79_u5.nr1[ibody]
print @n.xbgr.xr79_u6.nr1[ibody]
print @n.xbgr.xr79_u7.nr1[ibody]
print @n.xbgr.xr79_u8.nr1[ibody]
print @n.xbgr.xr79_u9.nr1[ibody]
print @n.xbgr.xr79_u10.nr1[ibody]
print @n.xbgr.xr79_u11.nr1[ibody]
print @n.xbgr.xr79_u12.nr1[ibody]
print @n.xbgr.xr79_u13.nr1[ibody]
print @n.xbgr.xr79_u14.nr1[ibody]
print @n.xbgr.xr79_u15.nr1[ibody]
print @n.xbgr.xr79_u16.nr1[ibody]
print @n.xbgr.xr79_u17.nr1[ibody]
print @n.xbgr.xr79_u18.nr1[ibody]
print @n.xbgr.xr79_u19.nr1[ibody]
print @n.xbgr.xr79_u20.nr1[ibody]
print @n.xbgr.xr79_u21.nr1[ibody]
print @n.xbgr.xr79_u22.nr1[ibody]
print @n.xbgr.xr79_u23.nr1[ibody]
print @n.xbgr.xr79_u24.nr1[ibody]
print @n.xbgr.xr80_u2.nr1[ibody]
print @n.xbgr.xr80_u3.nr1[ibody]
print @n.xbgr.xr80_u4.nr1[ibody]
print @n.xbgr.xr80_u5.nr1[ibody]
print @n.xbgr.xr80_u6.nr1[ibody]
print @n.xbgr.xr80_u7.nr1[ibody]
print @n.xbgr.xr80_u8.nr1[ibody]
print @n.xbgr.xr80_u9.nr1[ibody]
print @n.xbgr.xr80_u10.nr1[ibody]
print @n.xbgr.xr80_u11.nr1[ibody]
print @n.xbgr.xr80_u12.nr1[ibody]
print @n.xbgr.xr80_u13.nr1[ibody]
print @n.xbgr.xr80_u14.nr1[ibody]
print @n.xbgr.xr80_u15.nr1[ibody]
print @n.xbgr.xr80_u16.nr1[ibody]
print @n.xbgr.xr80_u17.nr1[ibody]
print @n.xbgr.xr80_u18.nr1[ibody]
print @n.xbgr.xr80_u19.nr1[ibody]
print @n.xbgr.xr80_u20.nr1[ibody]
print @n.xbgr.xr80_u21.nr1[ibody]
print @n.xbgr.xr80_u22.nr1[ibody]
print @n.xbgr.xr80_u23.nr1[ibody]
print @n.xbgr.xr80_u24.nr1[ibody]
print @n.xbgr.xr81_u2.nr1[ibody]
print @n.xbgr.xr81_u3.nr1[ibody]
print @n.xbgr.xr81_u4.nr1[ibody]
print @n.xbgr.xr81_u5.nr1[ibody]
print @n.xbgr.xr81_u6.nr1[ibody]
print @n.xbgr.xr81_u7.nr1[ibody]
print @n.xbgr.xr81_u8.nr1[ibody]
print @n.xbgr.xr81_u9.nr1[ibody]
print @n.xbgr.xr81_u10.nr1[ibody]
print @n.xbgr.xr81_u11.nr1[ibody]
print @n.xbgr.xr81_u12.nr1[ibody]
print @n.xbgr.xr81_u13.nr1[ibody]
print @n.xbgr.xr81_u14.nr1[ibody]
print @n.xbgr.xr81_u15.nr1[ibody]
print @n.xbgr.xr81_u16.nr1[ibody]
print @n.xbgr.xr81_u17.nr1[ibody]
print @n.xbgr.xr81_u18.nr1[ibody]
print @n.xbgr.xr81_u19.nr1[ibody]
print @n.xbgr.xr81_u20.nr1[ibody]
print @n.xbgr.xr81_u21.nr1[ibody]
print @n.xbgr.xr81_u22.nr1[ibody]
print @n.xbgr.xr81_u23.nr1[ibody]
print @n.xbgr.xr81_u24.nr1[ibody]
print @n.xbgr.xr82_u2.nr1[ibody]
print @n.xbgr.xr82_u3.nr1[ibody]
print @n.xbgr.xr82_u4.nr1[ibody]
print @n.xbgr.xr82_u5.nr1[ibody]
print @n.xbgr.xr82_u6.nr1[ibody]
print @n.xbgr.xr82_u7.nr1[ibody]
print @n.xbgr.xr82_u8.nr1[ibody]
print @n.xbgr.xr82_u9.nr1[ibody]
print @n.xbgr.xr82_u10.nr1[ibody]
print @n.xbgr.xr82_u11.nr1[ibody]
print @n.xbgr.xr82_u12.nr1[ibody]
print @n.xbgr.xr82_u13.nr1[ibody]
print @n.xbgr.xr82_u14.nr1[ibody]
print @n.xbgr.xr82_u15.nr1[ibody]
print @n.xbgr.xr82_u16.nr1[ibody]
print @n.xbgr.xr82_u17.nr1[ibody]
print @n.xbgr.xr82_u18.nr1[ibody]
print @n.xbgr.xr82_u19.nr1[ibody]
print @n.xbgr.xr82_u20.nr1[ibody]
print @n.xbgr.xr82_u21.nr1[ibody]
print @n.xbgr.xr82_u22.nr1[ibody]
print @n.xbgr.xr82_u23.nr1[ibody]
print @n.xbgr.xr82_u24.nr1[ibody]
print @n.xbgr.xr83_u2.nr1[ibody]
print @n.xbgr.xr83_u3.nr1[ibody]
print @n.xbgr.xr83_u4.nr1[ibody]
print @n.xbgr.xr83_u5.nr1[ibody]
print @n.xbgr.xr83_u6.nr1[ibody]
print @n.xbgr.xr83_u7.nr1[ibody]
print @n.xbgr.xr83_u8.nr1[ibody]
print @n.xbgr.xr83_u9.nr1[ibody]
print @n.xbgr.xr83_u10.nr1[ibody]
print @n.xbgr.xr83_u11.nr1[ibody]
print @n.xbgr.xr83_u12.nr1[ibody]
print @n.xbgr.xr83_u13.nr1[ibody]
print @n.xbgr.xr83_u14.nr1[ibody]
print @n.xbgr.xr83_u15.nr1[ibody]
print @n.xbgr.xr83_u16.nr1[ibody]
print @n.xbgr.xr83_u17.nr1[ibody]
print @n.xbgr.xr83_u18.nr1[ibody]
print @n.xbgr.xr83_u19.nr1[ibody]
print @n.xbgr.xr83_u20.nr1[ibody]
print @n.xbgr.xr83_u21.nr1[ibody]
print @n.xbgr.xr83_u22.nr1[ibody]
print @n.xbgr.xr83_u23.nr1[ibody]
print @n.xbgr.xr83_u24.nr1[ibody]
print @n.xbgr.xr84_u2.nr1[ibody]
print @n.xbgr.xr84_u3.nr1[ibody]
print @n.xbgr.xr84_u4.nr1[ibody]
print @n.xbgr.xr84_u5.nr1[ibody]
print @n.xbgr.xr84_u6.nr1[ibody]
print @n.xbgr.xr84_u7.nr1[ibody]
print @n.xbgr.xr84_u8.nr1[ibody]
print @n.xbgr.xr84_u9.nr1[ibody]
print @n.xbgr.xr84_u10.nr1[ibody]
print @n.xbgr.xr84_u11.nr1[ibody]
print @n.xbgr.xr84_u12.nr1[ibody]
print @n.xbgr.xr84_u13.nr1[ibody]
print @n.xbgr.xr84_u14.nr1[ibody]
print @n.xbgr.xr84_u15.nr1[ibody]
print @n.xbgr.xr84_u16.nr1[ibody]
print @n.xbgr.xr84_u17.nr1[ibody]
print @n.xbgr.xr84_u18.nr1[ibody]
print @n.xbgr.xr84_u19.nr1[ibody]
print @n.xbgr.xr84_u20.nr1[ibody]
print @n.xbgr.xr84_u21.nr1[ibody]
print @n.xbgr.xr84_u22.nr1[ibody]
print @n.xbgr.xr84_u23.nr1[ibody]
print @n.xbgr.xr84_u24.nr1[ibody]
print @n.xbgr.xr85_u2.nr1[ibody]
print @n.xbgr.xr85_u3.nr1[ibody]
print @n.xbgr.xr85_u4.nr1[ibody]
print @n.xbgr.xr85_u5.nr1[ibody]
print @n.xbgr.xr85_u6.nr1[ibody]
print @n.xbgr.xr85_u7.nr1[ibody]
print @n.xbgr.xr85_u8.nr1[ibody]
print @n.xbgr.xr85_u9.nr1[ibody]
print @n.xbgr.xr85_u10.nr1[ibody]
print @n.xbgr.xr85_u11.nr1[ibody]
print @n.xbgr.xr85_u12.nr1[ibody]
print @n.xbgr.xr85_u13.nr1[ibody]
print @n.xbgr.xr85_u14.nr1[ibody]
print @n.xbgr.xr85_u15.nr1[ibody]
print @n.xbgr.xr85_u16.nr1[ibody]
print @n.xbgr.xr85_u17.nr1[ibody]
print @n.xbgr.xr85_u18.nr1[ibody]
print @n.xbgr.xr85_u19.nr1[ibody]
print @n.xbgr.xr85_u20.nr1[ibody]
print @n.xbgr.xr85_u21.nr1[ibody]
print @n.xbgr.xr85_u22.nr1[ibody]
print @n.xbgr.xr85_u23.nr1[ibody]
print @n.xbgr.xr85_u24.nr1[ibody]
print @n.xbgr.xr86_u2.nr1[ibody]
print @n.xbgr.xr86_u3.nr1[ibody]
print @n.xbgr.xr86_u4.nr1[ibody]
print @n.xbgr.xr86_u5.nr1[ibody]
print @n.xbgr.xr86_u6.nr1[ibody]
print @n.xbgr.xr86_u7.nr1[ibody]
print @n.xbgr.xr86_u8.nr1[ibody]
print @n.xbgr.xr86_u9.nr1[ibody]
print @n.xbgr.xr86_u10.nr1[ibody]
print @n.xbgr.xr86_u11.nr1[ibody]
print @n.xbgr.xr86_u12.nr1[ibody]
print @n.xbgr.xr86_u13.nr1[ibody]
print @n.xbgr.xr86_u14.nr1[ibody]
print @n.xbgr.xr86_u15.nr1[ibody]
print @n.xbgr.xr86_u16.nr1[ibody]
print @n.xbgr.xr86_u17.nr1[ibody]
print @n.xbgr.xr86_u18.nr1[ibody]
print @n.xbgr.xr86_u19.nr1[ibody]
print @n.xbgr.xr86_u20.nr1[ibody]
print @n.xbgr.xr86_u21.nr1[ibody]
print @n.xbgr.xr86_u22.nr1[ibody]
print @n.xbgr.xr86_u23.nr1[ibody]
print @n.xbgr.xr86_u24.nr1[ibody]
echo RAW_CURRENT_LEDGER_END
wrdata op_nodes.dat v(xbgr.b1b) v(xbgr.c2) v(xbgr.d1) v(xbgr.d2) v(xbgr.d3) v(xbgr.d4) v(xbgr.d5) v(xbgr.det) v(dvbe) v(iptat) v(xbgr.kick) v(xbgr.n1) v(xbgr.n_10) v(xbgr.n_11) v(xbgr.n_12) v(xbgr.n_13) v(xbgr.n_14) v(xbgr.n_15) v(xbgr.n_16) v(xbgr.n_17) v(xbgr.n_18) v(xbgr.n_19) v(xbgr.n_2) v(xbgr.n_21) v(xbgr.n_22) v(xbgr.n_23) v(xbgr.n_24) v(xbgr.n_25) v(xbgr.n_26) v(xbgr.n_27) v(xbgr.n_3) v(xbgr.n_30) v(xbgr.n_31) v(xbgr.n_33) v(xbgr.n_34) v(xbgr.n_36) v(xbgr.n_37) v(xbgr.n_4) v(xbgr.n_5) v(xbgr.n_6) v(xbgr.n_7) v(xbgr.n_8) v(xbgr.n_9) v(pbias) v(pcasc) v(r4) v(xbgr.r4n) v(xbgr.vb2) v(vbe) v(xbgr.vbe3) v(xbgr.vd1) v(xbgr.vd2) v(vdd) v(vref) v(vdd)-v(vdd) i(vdd) i(vload) i(vr4) i(vsub)
print @n.xbgr.xr1.nr1[nsmm_rsh]
print @n.xbgr.xr1.nr1[nsmm_w]
print @n.xbgr.xr1.nr1[nsmm_l]
print @n.xbgr.xr2.nr1[nsmm_rsh]
print @n.xbgr.xr2.nr1[nsmm_w]
print @n.xbgr.xr2.nr1[nsmm_l]
print @n.xbgr.xr3.nr1[nsmm_rsh]
print @n.xbgr.xr3.nr1[nsmm_w]
print @n.xbgr.xr3.nr1[nsmm_l]
print @n.xbgr.xr4.nr1[nsmm_rsh]
print @n.xbgr.xr4.nr1[nsmm_w]
print @n.xbgr.xr4.nr1[nsmm_l]
print @n.xbgr.xr5.nr1[nsmm_rsh]
print @n.xbgr.xr5.nr1[nsmm_w]
print @n.xbgr.xr5.nr1[nsmm_l]
print @n.xbgr.xr6.nr1[nsmm_rsh]
print @n.xbgr.xr6.nr1[nsmm_w]
print @n.xbgr.xr6.nr1[nsmm_l]
print @n.xbgr.xr7.nr1[nsmm_rsh]
print @n.xbgr.xr7.nr1[nsmm_w]
print @n.xbgr.xr7.nr1[nsmm_l]
print @n.xbgr.xr8.nr1[nsmm_rsh]
print @n.xbgr.xr8.nr1[nsmm_w]
print @n.xbgr.xr8.nr1[nsmm_l]
print @n.xbgr.xr9.nr1[nsmm_rsh]
print @n.xbgr.xr9.nr1[nsmm_w]
print @n.xbgr.xr9.nr1[nsmm_l]
print @n.xbgr.xr10.nr1[nsmm_rsh]
print @n.xbgr.xr10.nr1[nsmm_w]
print @n.xbgr.xr10.nr1[nsmm_l]
print @n.xbgr.xr11.nr1[nsmm_rsh]
print @n.xbgr.xr11.nr1[nsmm_w]
print @n.xbgr.xr11.nr1[nsmm_l]
print @n.xbgr.xr12.nr1[nsmm_rsh]
print @n.xbgr.xr12.nr1[nsmm_w]
print @n.xbgr.xr12.nr1[nsmm_l]
print @n.xbgr.xr13.nr1[nsmm_rsh]
print @n.xbgr.xr13.nr1[nsmm_w]
print @n.xbgr.xr13.nr1[nsmm_l]
print @n.xbgr.xr14.nr1[nsmm_rsh]
print @n.xbgr.xr14.nr1[nsmm_w]
print @n.xbgr.xr14.nr1[nsmm_l]
print @n.xbgr.xr15.nr1[nsmm_rsh]
print @n.xbgr.xr15.nr1[nsmm_w]
print @n.xbgr.xr15.nr1[nsmm_l]
print @n.xbgr.xr16.nr1[nsmm_rsh]
print @n.xbgr.xr16.nr1[nsmm_w]
print @n.xbgr.xr16.nr1[nsmm_l]
print @n.xbgr.xr17.nr1[nsmm_rsh]
print @n.xbgr.xr17.nr1[nsmm_w]
print @n.xbgr.xr17.nr1[nsmm_l]
print @n.xbgr.xr18.nr1[nsmm_rsh]
print @n.xbgr.xr18.nr1[nsmm_w]
print @n.xbgr.xr18.nr1[nsmm_l]
print @n.xbgr.xr19.nr1[nsmm_rsh]
print @n.xbgr.xr19.nr1[nsmm_w]
print @n.xbgr.xr19.nr1[nsmm_l]
print @n.xbgr.xr20.nr1[nsmm_rsh]
print @n.xbgr.xr20.nr1[nsmm_w]
print @n.xbgr.xr20.nr1[nsmm_l]
print @n.xbgr.xr21.nr1[nsmm_rsh]
print @n.xbgr.xr21.nr1[nsmm_w]
print @n.xbgr.xr21.nr1[nsmm_l]
print @n.xbgr.xr22.nr1[nsmm_rsh]
print @n.xbgr.xr22.nr1[nsmm_w]
print @n.xbgr.xr22.nr1[nsmm_l]
print @n.xbgr.xr23.nr1[nsmm_rsh]
print @n.xbgr.xr23.nr1[nsmm_w]
print @n.xbgr.xr23.nr1[nsmm_l]
print @n.xbgr.xr24.nr1[nsmm_rsh]
print @n.xbgr.xr24.nr1[nsmm_w]
print @n.xbgr.xr24.nr1[nsmm_l]
print @n.xbgr.xr25.nr1[nsmm_rsh]
print @n.xbgr.xr25.nr1[nsmm_w]
print @n.xbgr.xr25.nr1[nsmm_l]
print @n.xbgr.xr26.nr1[nsmm_rsh]
print @n.xbgr.xr26.nr1[nsmm_w]
print @n.xbgr.xr26.nr1[nsmm_l]
print @n.xbgr.xm27.nsg13_hv_pmos[w]
print @n.xbgr.xm27.nsg13_hv_pmos[l]
print @n.xbgr.xm27.nsg13_hv_pmos[delvto]
print @n.xbgr.xm27.nsg13_hv_pmos[factuo]
print @n.xbgr.xm28.nsg13_hv_pmos[w]
print @n.xbgr.xm28.nsg13_hv_pmos[l]
print @n.xbgr.xm28.nsg13_hv_pmos[delvto]
print @n.xbgr.xm28.nsg13_hv_pmos[factuo]
print @n.xbgr.xm29.nsg13_hv_nmos[w]
print @n.xbgr.xm29.nsg13_hv_nmos[l]
print @n.xbgr.xm29.nsg13_hv_nmos[delvto]
print @n.xbgr.xm29.nsg13_hv_nmos[factuo]
print @n.xbgr.xm30.nsg13_hv_nmos[w]
print @n.xbgr.xm30.nsg13_hv_nmos[l]
print @n.xbgr.xm30.nsg13_hv_nmos[delvto]
print @n.xbgr.xm30.nsg13_hv_nmos[factuo]
print @n.xbgr.xm31.nsg13_hv_nmos[w]
print @n.xbgr.xm31.nsg13_hv_nmos[l]
print @n.xbgr.xm31.nsg13_hv_nmos[delvto]
print @n.xbgr.xm31.nsg13_hv_nmos[factuo]
print @n.xbgr.xm32.nsg13_hv_nmos[w]
print @n.xbgr.xm32.nsg13_hv_nmos[l]
print @n.xbgr.xm32.nsg13_hv_nmos[delvto]
print @n.xbgr.xm32.nsg13_hv_nmos[factuo]
print @n.xbgr.xm33.nsg13_hv_nmos[w]
print @n.xbgr.xm33.nsg13_hv_nmos[l]
print @n.xbgr.xm33.nsg13_hv_nmos[delvto]
print @n.xbgr.xm33.nsg13_hv_nmos[factuo]
print @n.xbgr.xm34.nsg13_hv_nmos[w]
print @n.xbgr.xm34.nsg13_hv_nmos[l]
print @n.xbgr.xm34.nsg13_hv_nmos[delvto]
print @n.xbgr.xm34.nsg13_hv_nmos[factuo]
print @n.xbgr.xm35.nsg13_hv_nmos[w]
print @n.xbgr.xm35.nsg13_hv_nmos[l]
print @n.xbgr.xm35.nsg13_hv_nmos[delvto]
print @n.xbgr.xm35.nsg13_hv_nmos[factuo]
print @n.xbgr.xm36.nsg13_hv_nmos[w]
print @n.xbgr.xm36.nsg13_hv_nmos[l]
print @n.xbgr.xm36.nsg13_hv_nmos[delvto]
print @n.xbgr.xm36.nsg13_hv_nmos[factuo]
print @n.xbgr.xm37.nsg13_hv_nmos[w]
print @n.xbgr.xm37.nsg13_hv_nmos[l]
print @n.xbgr.xm37.nsg13_hv_nmos[delvto]
print @n.xbgr.xm37.nsg13_hv_nmos[factuo]
print @n.xbgr.xm38.nsg13_hv_pmos[w]
print @n.xbgr.xm38.nsg13_hv_pmos[l]
print @n.xbgr.xm38.nsg13_hv_pmos[delvto]
print @n.xbgr.xm38.nsg13_hv_pmos[factuo]
print @n.xbgr.xm39.nsg13_hv_pmos[w]
print @n.xbgr.xm39.nsg13_hv_pmos[l]
print @n.xbgr.xm39.nsg13_hv_pmos[delvto]
print @n.xbgr.xm39.nsg13_hv_pmos[factuo]
print @n.xbgr.xm40.nsg13_hv_pmos[w]
print @n.xbgr.xm40.nsg13_hv_pmos[l]
print @n.xbgr.xm40.nsg13_hv_pmos[delvto]
print @n.xbgr.xm40.nsg13_hv_pmos[factuo]
print @n.xbgr.xm41.nsg13_hv_pmos[w]
print @n.xbgr.xm41.nsg13_hv_pmos[l]
print @n.xbgr.xm41.nsg13_hv_pmos[delvto]
print @n.xbgr.xm41.nsg13_hv_pmos[factuo]
print @n.xbgr.xm42.nsg13_hv_pmos[w]
print @n.xbgr.xm42.nsg13_hv_pmos[l]
print @n.xbgr.xm42.nsg13_hv_pmos[delvto]
print @n.xbgr.xm42.nsg13_hv_pmos[factuo]
print @n.xbgr.xm43.nsg13_hv_pmos[w]
print @n.xbgr.xm43.nsg13_hv_pmos[l]
print @n.xbgr.xm43.nsg13_hv_pmos[delvto]
print @n.xbgr.xm43.nsg13_hv_pmos[factuo]
print @n.xbgr.xm44.nsg13_hv_pmos[w]
print @n.xbgr.xm44.nsg13_hv_pmos[l]
print @n.xbgr.xm44.nsg13_hv_pmos[delvto]
print @n.xbgr.xm44.nsg13_hv_pmos[factuo]
print @n.xbgr.xm45.nsg13_hv_pmos[w]
print @n.xbgr.xm45.nsg13_hv_pmos[l]
print @n.xbgr.xm45.nsg13_hv_pmos[delvto]
print @n.xbgr.xm45.nsg13_hv_pmos[factuo]
print @n.xbgr.xm46.nsg13_hv_pmos[w]
print @n.xbgr.xm46.nsg13_hv_pmos[l]
print @n.xbgr.xm46.nsg13_hv_pmos[delvto]
print @n.xbgr.xm46.nsg13_hv_pmos[factuo]
print @n.xbgr.xm47.nsg13_hv_pmos[w]
print @n.xbgr.xm47.nsg13_hv_pmos[l]
print @n.xbgr.xm47.nsg13_hv_pmos[delvto]
print @n.xbgr.xm47.nsg13_hv_pmos[factuo]
print @n.xbgr.xm48.nsg13_hv_pmos[w]
print @n.xbgr.xm48.nsg13_hv_pmos[l]
print @n.xbgr.xm48.nsg13_hv_pmos[delvto]
print @n.xbgr.xm48.nsg13_hv_pmos[factuo]
print @n.xbgr.xm49.nsg13_hv_pmos[w]
print @n.xbgr.xm49.nsg13_hv_pmos[l]
print @n.xbgr.xm49.nsg13_hv_pmos[delvto]
print @n.xbgr.xm49.nsg13_hv_pmos[factuo]
print @n.xbgr.xm50.nsg13_hv_pmos[w]
print @n.xbgr.xm50.nsg13_hv_pmos[l]
print @n.xbgr.xm50.nsg13_hv_pmos[delvto]
print @n.xbgr.xm50.nsg13_hv_pmos[factuo]
print @n.xbgr.xm51.nsg13_hv_pmos[w]
print @n.xbgr.xm51.nsg13_hv_pmos[l]
print @n.xbgr.xm51.nsg13_hv_pmos[delvto]
print @n.xbgr.xm51.nsg13_hv_pmos[factuo]
print @n.xbgr.xm52.nsg13_hv_pmos[w]
print @n.xbgr.xm52.nsg13_hv_pmos[l]
print @n.xbgr.xm52.nsg13_hv_pmos[delvto]
print @n.xbgr.xm52.nsg13_hv_pmos[factuo]
print @n.xbgr.xm53.nsg13_hv_pmos[w]
print @n.xbgr.xm53.nsg13_hv_pmos[l]
print @n.xbgr.xm53.nsg13_hv_pmos[delvto]
print @n.xbgr.xm53.nsg13_hv_pmos[factuo]
print @n.xbgr.xm54.nsg13_hv_pmos[w]
print @n.xbgr.xm54.nsg13_hv_pmos[l]
print @n.xbgr.xm54.nsg13_hv_pmos[delvto]
print @n.xbgr.xm54.nsg13_hv_pmos[factuo]
print @q.xbgr.xq55.qnpn13g2[area]
print @q.xbgr.xq56.qnpn13g2[area]
print @q.xbgr.xq57.qnpn13g2[area]
print @q.xbgr.xq58.qnpn13g2[area]
print @q.xbgr.xq59.qnpn13g2[area]
print @q.xbgr.xq60.qnpn13g2[area]
print @q.xbgr.xq61.qnpn13g2[area]
print @q.xbgr.xq62.qnpn13g2[area]
print @q.xbgr.xq63.qnpn13g2[area]
print @q.xbgr.xq64.qnpn13g2[area]
print @q.xbgr.xq65.qnpn13g2[area]
print @q.xbgr.xq66.qnpn13g2[area]
print @q.xbgr.xq67.qnpn13g2[area]
print @q.xbgr.xq68.qnpn13g2[area]
print @q.xbgr.xq69.qnpn13g2[area]
print @q.xbgr.xq70.qnpn13g2[area]
print @q.xbgr.xq71.qnpn13g2[area]
print @q.xbgr.xq72.qnpn13g2[area]
print @q.xbgr.xq73.qnpn13g2[area]
print @q.xbgr.xq74.qnpn13g2[area]
print @q.xbgr.xq75.qnpn13g2[area]
print @q.xbgr.xq76.qnpn13g2[area]
print @n.xbgr.xr77.nr1[nsmm_rsh]
print @n.xbgr.xr77.nr1[nsmm_w]
print @n.xbgr.xr77.nr1[nsmm_l]
print @n.xbgr.xr78.nr1[nsmm_rsh]
print @n.xbgr.xr78.nr1[nsmm_w]
print @n.xbgr.xr78.nr1[nsmm_l]
print @n.xbgr.xr79.nr1[nsmm_rsh]
print @n.xbgr.xr79.nr1[nsmm_w]
print @n.xbgr.xr79.nr1[nsmm_l]
print @n.xbgr.xr80.nr1[nsmm_rsh]
print @n.xbgr.xr80.nr1[nsmm_w]
print @n.xbgr.xr80.nr1[nsmm_l]
print @n.xbgr.xr81.nr1[nsmm_rsh]
print @n.xbgr.xr81.nr1[nsmm_w]
print @n.xbgr.xr81.nr1[nsmm_l]
print @n.xbgr.xr82.nr1[nsmm_rsh]
print @n.xbgr.xr82.nr1[nsmm_w]
print @n.xbgr.xr82.nr1[nsmm_l]
print @n.xbgr.xr83.nr1[nsmm_rsh]
print @n.xbgr.xr83.nr1[nsmm_w]
print @n.xbgr.xr83.nr1[nsmm_l]
print @n.xbgr.xr84.nr1[nsmm_rsh]
print @n.xbgr.xr84.nr1[nsmm_w]
print @n.xbgr.xr84.nr1[nsmm_l]
print @n.xbgr.xr85.nr1[nsmm_rsh]
print @n.xbgr.xr85.nr1[nsmm_w]
print @n.xbgr.xr85.nr1[nsmm_l]
print @n.xbgr.xr86.nr1[nsmm_rsh]
print @n.xbgr.xr86.nr1[nsmm_w]
print @n.xbgr.xr86.nr1[nsmm_l]
print @n.xbgr.xr16_u2.nr1[nsmm_rsh]
print @n.xbgr.xr16_u2.nr1[nsmm_w]
print @n.xbgr.xr16_u2.nr1[nsmm_l]
print @n.xbgr.xr16_u3.nr1[nsmm_rsh]
print @n.xbgr.xr16_u3.nr1[nsmm_w]
print @n.xbgr.xr16_u3.nr1[nsmm_l]
print @n.xbgr.xr16_u4.nr1[nsmm_rsh]
print @n.xbgr.xr16_u4.nr1[nsmm_w]
print @n.xbgr.xr16_u4.nr1[nsmm_l]
print @n.xbgr.xr16_u5.nr1[nsmm_rsh]
print @n.xbgr.xr16_u5.nr1[nsmm_w]
print @n.xbgr.xr16_u5.nr1[nsmm_l]
print @n.xbgr.xr16_u6.nr1[nsmm_rsh]
print @n.xbgr.xr16_u6.nr1[nsmm_w]
print @n.xbgr.xr16_u6.nr1[nsmm_l]
print @n.xbgr.xr16_u7.nr1[nsmm_rsh]
print @n.xbgr.xr16_u7.nr1[nsmm_w]
print @n.xbgr.xr16_u7.nr1[nsmm_l]
print @n.xbgr.xr16_u8.nr1[nsmm_rsh]
print @n.xbgr.xr16_u8.nr1[nsmm_w]
print @n.xbgr.xr16_u8.nr1[nsmm_l]
print @n.xbgr.xr16_u9.nr1[nsmm_rsh]
print @n.xbgr.xr16_u9.nr1[nsmm_w]
print @n.xbgr.xr16_u9.nr1[nsmm_l]
print @n.xbgr.xr16_u10.nr1[nsmm_rsh]
print @n.xbgr.xr16_u10.nr1[nsmm_w]
print @n.xbgr.xr16_u10.nr1[nsmm_l]
print @n.xbgr.xr16_u11.nr1[nsmm_rsh]
print @n.xbgr.xr16_u11.nr1[nsmm_w]
print @n.xbgr.xr16_u11.nr1[nsmm_l]
print @n.xbgr.xr16_u12.nr1[nsmm_rsh]
print @n.xbgr.xr16_u12.nr1[nsmm_w]
print @n.xbgr.xr16_u12.nr1[nsmm_l]
print @n.xbgr.xr16_u13.nr1[nsmm_rsh]
print @n.xbgr.xr16_u13.nr1[nsmm_w]
print @n.xbgr.xr16_u13.nr1[nsmm_l]
print @n.xbgr.xr16_u14.nr1[nsmm_rsh]
print @n.xbgr.xr16_u14.nr1[nsmm_w]
print @n.xbgr.xr16_u14.nr1[nsmm_l]
print @n.xbgr.xr16_u15.nr1[nsmm_rsh]
print @n.xbgr.xr16_u15.nr1[nsmm_w]
print @n.xbgr.xr16_u15.nr1[nsmm_l]
print @n.xbgr.xr16_u16.nr1[nsmm_rsh]
print @n.xbgr.xr16_u16.nr1[nsmm_w]
print @n.xbgr.xr16_u16.nr1[nsmm_l]
print @n.xbgr.xr16_u17.nr1[nsmm_rsh]
print @n.xbgr.xr16_u17.nr1[nsmm_w]
print @n.xbgr.xr16_u17.nr1[nsmm_l]
print @n.xbgr.xr16_u18.nr1[nsmm_rsh]
print @n.xbgr.xr16_u18.nr1[nsmm_w]
print @n.xbgr.xr16_u18.nr1[nsmm_l]
print @n.xbgr.xr16_u19.nr1[nsmm_rsh]
print @n.xbgr.xr16_u19.nr1[nsmm_w]
print @n.xbgr.xr16_u19.nr1[nsmm_l]
print @n.xbgr.xr16_u20.nr1[nsmm_rsh]
print @n.xbgr.xr16_u20.nr1[nsmm_w]
print @n.xbgr.xr16_u20.nr1[nsmm_l]
print @n.xbgr.xr16_u21.nr1[nsmm_rsh]
print @n.xbgr.xr16_u21.nr1[nsmm_w]
print @n.xbgr.xr16_u21.nr1[nsmm_l]
print @n.xbgr.xr16_u22.nr1[nsmm_rsh]
print @n.xbgr.xr16_u22.nr1[nsmm_w]
print @n.xbgr.xr16_u22.nr1[nsmm_l]
print @n.xbgr.xr16_u23.nr1[nsmm_rsh]
print @n.xbgr.xr16_u23.nr1[nsmm_w]
print @n.xbgr.xr16_u23.nr1[nsmm_l]
print @n.xbgr.xr16_u24.nr1[nsmm_rsh]
print @n.xbgr.xr16_u24.nr1[nsmm_w]
print @n.xbgr.xr16_u24.nr1[nsmm_l]
print @n.xbgr.xr17_u2.nr1[nsmm_rsh]
print @n.xbgr.xr17_u2.nr1[nsmm_w]
print @n.xbgr.xr17_u2.nr1[nsmm_l]
print @n.xbgr.xr17_u3.nr1[nsmm_rsh]
print @n.xbgr.xr17_u3.nr1[nsmm_w]
print @n.xbgr.xr17_u3.nr1[nsmm_l]
print @n.xbgr.xr17_u4.nr1[nsmm_rsh]
print @n.xbgr.xr17_u4.nr1[nsmm_w]
print @n.xbgr.xr17_u4.nr1[nsmm_l]
print @n.xbgr.xr18_u2.nr1[nsmm_rsh]
print @n.xbgr.xr18_u2.nr1[nsmm_w]
print @n.xbgr.xr18_u2.nr1[nsmm_l]
print @n.xbgr.xr18_u3.nr1[nsmm_rsh]
print @n.xbgr.xr18_u3.nr1[nsmm_w]
print @n.xbgr.xr18_u3.nr1[nsmm_l]
print @n.xbgr.xr18_u4.nr1[nsmm_rsh]
print @n.xbgr.xr18_u4.nr1[nsmm_w]
print @n.xbgr.xr18_u4.nr1[nsmm_l]
print @n.xbgr.xr19_u2.nr1[nsmm_rsh]
print @n.xbgr.xr19_u2.nr1[nsmm_w]
print @n.xbgr.xr19_u2.nr1[nsmm_l]
print @n.xbgr.xr19_u3.nr1[nsmm_rsh]
print @n.xbgr.xr19_u3.nr1[nsmm_w]
print @n.xbgr.xr19_u3.nr1[nsmm_l]
print @n.xbgr.xr19_u4.nr1[nsmm_rsh]
print @n.xbgr.xr19_u4.nr1[nsmm_w]
print @n.xbgr.xr19_u4.nr1[nsmm_l]
print @n.xbgr.xr20_u2.nr1[nsmm_rsh]
print @n.xbgr.xr20_u2.nr1[nsmm_w]
print @n.xbgr.xr20_u2.nr1[nsmm_l]
print @n.xbgr.xr20_u3.nr1[nsmm_rsh]
print @n.xbgr.xr20_u3.nr1[nsmm_w]
print @n.xbgr.xr20_u3.nr1[nsmm_l]
print @n.xbgr.xr20_u4.nr1[nsmm_rsh]
print @n.xbgr.xr20_u4.nr1[nsmm_w]
print @n.xbgr.xr20_u4.nr1[nsmm_l]
print @n.xbgr.xr21_u2.nr1[nsmm_rsh]
print @n.xbgr.xr21_u2.nr1[nsmm_w]
print @n.xbgr.xr21_u2.nr1[nsmm_l]
print @n.xbgr.xr21_u3.nr1[nsmm_rsh]
print @n.xbgr.xr21_u3.nr1[nsmm_w]
print @n.xbgr.xr21_u3.nr1[nsmm_l]
print @n.xbgr.xr21_u4.nr1[nsmm_rsh]
print @n.xbgr.xr21_u4.nr1[nsmm_w]
print @n.xbgr.xr21_u4.nr1[nsmm_l]
print @n.xbgr.xr22_u2.nr1[nsmm_rsh]
print @n.xbgr.xr22_u2.nr1[nsmm_w]
print @n.xbgr.xr22_u2.nr1[nsmm_l]
print @n.xbgr.xr22_u3.nr1[nsmm_rsh]
print @n.xbgr.xr22_u3.nr1[nsmm_w]
print @n.xbgr.xr22_u3.nr1[nsmm_l]
print @n.xbgr.xr22_u4.nr1[nsmm_rsh]
print @n.xbgr.xr22_u4.nr1[nsmm_w]
print @n.xbgr.xr22_u4.nr1[nsmm_l]
print @n.xbgr.xr23_u2.nr1[nsmm_rsh]
print @n.xbgr.xr23_u2.nr1[nsmm_w]
print @n.xbgr.xr23_u2.nr1[nsmm_l]
print @n.xbgr.xr23_u3.nr1[nsmm_rsh]
print @n.xbgr.xr23_u3.nr1[nsmm_w]
print @n.xbgr.xr23_u3.nr1[nsmm_l]
print @n.xbgr.xr23_u4.nr1[nsmm_rsh]
print @n.xbgr.xr23_u4.nr1[nsmm_w]
print @n.xbgr.xr23_u4.nr1[nsmm_l]
print @n.xbgr.xr23_u5.nr1[nsmm_rsh]
print @n.xbgr.xr23_u5.nr1[nsmm_w]
print @n.xbgr.xr23_u5.nr1[nsmm_l]
print @n.xbgr.xr23_u6.nr1[nsmm_rsh]
print @n.xbgr.xr23_u6.nr1[nsmm_w]
print @n.xbgr.xr23_u6.nr1[nsmm_l]
print @n.xbgr.xr23_u7.nr1[nsmm_rsh]
print @n.xbgr.xr23_u7.nr1[nsmm_w]
print @n.xbgr.xr23_u7.nr1[nsmm_l]
print @n.xbgr.xr23_u8.nr1[nsmm_rsh]
print @n.xbgr.xr23_u8.nr1[nsmm_w]
print @n.xbgr.xr23_u8.nr1[nsmm_l]
print @n.xbgr.xr23_u9.nr1[nsmm_rsh]
print @n.xbgr.xr23_u9.nr1[nsmm_w]
print @n.xbgr.xr23_u9.nr1[nsmm_l]
print @n.xbgr.xr23_u10.nr1[nsmm_rsh]
print @n.xbgr.xr23_u10.nr1[nsmm_w]
print @n.xbgr.xr23_u10.nr1[nsmm_l]
print @n.xbgr.xr23_u11.nr1[nsmm_rsh]
print @n.xbgr.xr23_u11.nr1[nsmm_w]
print @n.xbgr.xr23_u11.nr1[nsmm_l]
print @n.xbgr.xr23_u12.nr1[nsmm_rsh]
print @n.xbgr.xr23_u12.nr1[nsmm_w]
print @n.xbgr.xr23_u12.nr1[nsmm_l]
print @n.xbgr.xr23_u13.nr1[nsmm_rsh]
print @n.xbgr.xr23_u13.nr1[nsmm_w]
print @n.xbgr.xr23_u13.nr1[nsmm_l]
print @n.xbgr.xr23_u14.nr1[nsmm_rsh]
print @n.xbgr.xr23_u14.nr1[nsmm_w]
print @n.xbgr.xr23_u14.nr1[nsmm_l]
print @n.xbgr.xr23_u15.nr1[nsmm_rsh]
print @n.xbgr.xr23_u15.nr1[nsmm_w]
print @n.xbgr.xr23_u15.nr1[nsmm_l]
print @n.xbgr.xr23_u16.nr1[nsmm_rsh]
print @n.xbgr.xr23_u16.nr1[nsmm_w]
print @n.xbgr.xr23_u16.nr1[nsmm_l]
print @n.xbgr.xr23_u17.nr1[nsmm_rsh]
print @n.xbgr.xr23_u17.nr1[nsmm_w]
print @n.xbgr.xr23_u17.nr1[nsmm_l]
print @n.xbgr.xr23_u18.nr1[nsmm_rsh]
print @n.xbgr.xr23_u18.nr1[nsmm_w]
print @n.xbgr.xr23_u18.nr1[nsmm_l]
print @n.xbgr.xr23_u19.nr1[nsmm_rsh]
print @n.xbgr.xr23_u19.nr1[nsmm_w]
print @n.xbgr.xr23_u19.nr1[nsmm_l]
print @n.xbgr.xr23_u20.nr1[nsmm_rsh]
print @n.xbgr.xr23_u20.nr1[nsmm_w]
print @n.xbgr.xr23_u20.nr1[nsmm_l]
print @n.xbgr.xr23_u21.nr1[nsmm_rsh]
print @n.xbgr.xr23_u21.nr1[nsmm_w]
print @n.xbgr.xr23_u21.nr1[nsmm_l]
print @n.xbgr.xr23_u22.nr1[nsmm_rsh]
print @n.xbgr.xr23_u22.nr1[nsmm_w]
print @n.xbgr.xr23_u22.nr1[nsmm_l]
print @n.xbgr.xr23_u23.nr1[nsmm_rsh]
print @n.xbgr.xr23_u23.nr1[nsmm_w]
print @n.xbgr.xr23_u23.nr1[nsmm_l]
print @n.xbgr.xr23_u24.nr1[nsmm_rsh]
print @n.xbgr.xr23_u24.nr1[nsmm_w]
print @n.xbgr.xr23_u24.nr1[nsmm_l]
print @n.xbgr.xr24_u2.nr1[nsmm_rsh]
print @n.xbgr.xr24_u2.nr1[nsmm_w]
print @n.xbgr.xr24_u2.nr1[nsmm_l]
print @n.xbgr.xr24_u3.nr1[nsmm_rsh]
print @n.xbgr.xr24_u3.nr1[nsmm_w]
print @n.xbgr.xr24_u3.nr1[nsmm_l]
print @n.xbgr.xr24_u4.nr1[nsmm_rsh]
print @n.xbgr.xr24_u4.nr1[nsmm_w]
print @n.xbgr.xr24_u4.nr1[nsmm_l]
print @n.xbgr.xr24_u5.nr1[nsmm_rsh]
print @n.xbgr.xr24_u5.nr1[nsmm_w]
print @n.xbgr.xr24_u5.nr1[nsmm_l]
print @n.xbgr.xr24_u6.nr1[nsmm_rsh]
print @n.xbgr.xr24_u6.nr1[nsmm_w]
print @n.xbgr.xr24_u6.nr1[nsmm_l]
print @n.xbgr.xr24_u7.nr1[nsmm_rsh]
print @n.xbgr.xr24_u7.nr1[nsmm_w]
print @n.xbgr.xr24_u7.nr1[nsmm_l]
print @n.xbgr.xr24_u8.nr1[nsmm_rsh]
print @n.xbgr.xr24_u8.nr1[nsmm_w]
print @n.xbgr.xr24_u8.nr1[nsmm_l]
print @n.xbgr.xr24_u9.nr1[nsmm_rsh]
print @n.xbgr.xr24_u9.nr1[nsmm_w]
print @n.xbgr.xr24_u9.nr1[nsmm_l]
print @n.xbgr.xr24_u10.nr1[nsmm_rsh]
print @n.xbgr.xr24_u10.nr1[nsmm_w]
print @n.xbgr.xr24_u10.nr1[nsmm_l]
print @n.xbgr.xr24_u11.nr1[nsmm_rsh]
print @n.xbgr.xr24_u11.nr1[nsmm_w]
print @n.xbgr.xr24_u11.nr1[nsmm_l]
print @n.xbgr.xr24_u12.nr1[nsmm_rsh]
print @n.xbgr.xr24_u12.nr1[nsmm_w]
print @n.xbgr.xr24_u12.nr1[nsmm_l]
print @n.xbgr.xr24_u13.nr1[nsmm_rsh]
print @n.xbgr.xr24_u13.nr1[nsmm_w]
print @n.xbgr.xr24_u13.nr1[nsmm_l]
print @n.xbgr.xr24_u14.nr1[nsmm_rsh]
print @n.xbgr.xr24_u14.nr1[nsmm_w]
print @n.xbgr.xr24_u14.nr1[nsmm_l]
print @n.xbgr.xr24_u15.nr1[nsmm_rsh]
print @n.xbgr.xr24_u15.nr1[nsmm_w]
print @n.xbgr.xr24_u15.nr1[nsmm_l]
print @n.xbgr.xr24_u16.nr1[nsmm_rsh]
print @n.xbgr.xr24_u16.nr1[nsmm_w]
print @n.xbgr.xr24_u16.nr1[nsmm_l]
print @n.xbgr.xr24_u17.nr1[nsmm_rsh]
print @n.xbgr.xr24_u17.nr1[nsmm_w]
print @n.xbgr.xr24_u17.nr1[nsmm_l]
print @n.xbgr.xr24_u18.nr1[nsmm_rsh]
print @n.xbgr.xr24_u18.nr1[nsmm_w]
print @n.xbgr.xr24_u18.nr1[nsmm_l]
print @n.xbgr.xr24_u19.nr1[nsmm_rsh]
print @n.xbgr.xr24_u19.nr1[nsmm_w]
print @n.xbgr.xr24_u19.nr1[nsmm_l]
print @n.xbgr.xr24_u20.nr1[nsmm_rsh]
print @n.xbgr.xr24_u20.nr1[nsmm_w]
print @n.xbgr.xr24_u20.nr1[nsmm_l]
print @n.xbgr.xr24_u21.nr1[nsmm_rsh]
print @n.xbgr.xr24_u21.nr1[nsmm_w]
print @n.xbgr.xr24_u21.nr1[nsmm_l]
print @n.xbgr.xr24_u22.nr1[nsmm_rsh]
print @n.xbgr.xr24_u22.nr1[nsmm_w]
print @n.xbgr.xr24_u22.nr1[nsmm_l]
print @n.xbgr.xr24_u23.nr1[nsmm_rsh]
print @n.xbgr.xr24_u23.nr1[nsmm_w]
print @n.xbgr.xr24_u23.nr1[nsmm_l]
print @n.xbgr.xr24_u24.nr1[nsmm_rsh]
print @n.xbgr.xr24_u24.nr1[nsmm_w]
print @n.xbgr.xr24_u24.nr1[nsmm_l]
print @n.xbgr.xr25_u2.nr1[nsmm_rsh]
print @n.xbgr.xr25_u2.nr1[nsmm_w]
print @n.xbgr.xr25_u2.nr1[nsmm_l]
print @n.xbgr.xr25_u3.nr1[nsmm_rsh]
print @n.xbgr.xr25_u3.nr1[nsmm_w]
print @n.xbgr.xr25_u3.nr1[nsmm_l]
print @n.xbgr.xr25_u4.nr1[nsmm_rsh]
print @n.xbgr.xr25_u4.nr1[nsmm_w]
print @n.xbgr.xr25_u4.nr1[nsmm_l]
print @n.xbgr.xr25_u5.nr1[nsmm_rsh]
print @n.xbgr.xr25_u5.nr1[nsmm_w]
print @n.xbgr.xr25_u5.nr1[nsmm_l]
print @n.xbgr.xr25_u6.nr1[nsmm_rsh]
print @n.xbgr.xr25_u6.nr1[nsmm_w]
print @n.xbgr.xr25_u6.nr1[nsmm_l]
print @n.xbgr.xr25_u7.nr1[nsmm_rsh]
print @n.xbgr.xr25_u7.nr1[nsmm_w]
print @n.xbgr.xr25_u7.nr1[nsmm_l]
print @n.xbgr.xr25_u8.nr1[nsmm_rsh]
print @n.xbgr.xr25_u8.nr1[nsmm_w]
print @n.xbgr.xr25_u8.nr1[nsmm_l]
print @n.xbgr.xr25_u9.nr1[nsmm_rsh]
print @n.xbgr.xr25_u9.nr1[nsmm_w]
print @n.xbgr.xr25_u9.nr1[nsmm_l]
print @n.xbgr.xr25_u10.nr1[nsmm_rsh]
print @n.xbgr.xr25_u10.nr1[nsmm_w]
print @n.xbgr.xr25_u10.nr1[nsmm_l]
print @n.xbgr.xr25_u11.nr1[nsmm_rsh]
print @n.xbgr.xr25_u11.nr1[nsmm_w]
print @n.xbgr.xr25_u11.nr1[nsmm_l]
print @n.xbgr.xr25_u12.nr1[nsmm_rsh]
print @n.xbgr.xr25_u12.nr1[nsmm_w]
print @n.xbgr.xr25_u12.nr1[nsmm_l]
print @n.xbgr.xr25_u13.nr1[nsmm_rsh]
print @n.xbgr.xr25_u13.nr1[nsmm_w]
print @n.xbgr.xr25_u13.nr1[nsmm_l]
print @n.xbgr.xr25_u14.nr1[nsmm_rsh]
print @n.xbgr.xr25_u14.nr1[nsmm_w]
print @n.xbgr.xr25_u14.nr1[nsmm_l]
print @n.xbgr.xr25_u15.nr1[nsmm_rsh]
print @n.xbgr.xr25_u15.nr1[nsmm_w]
print @n.xbgr.xr25_u15.nr1[nsmm_l]
print @n.xbgr.xr25_u16.nr1[nsmm_rsh]
print @n.xbgr.xr25_u16.nr1[nsmm_w]
print @n.xbgr.xr25_u16.nr1[nsmm_l]
print @n.xbgr.xr25_u17.nr1[nsmm_rsh]
print @n.xbgr.xr25_u17.nr1[nsmm_w]
print @n.xbgr.xr25_u17.nr1[nsmm_l]
print @n.xbgr.xr25_u18.nr1[nsmm_rsh]
print @n.xbgr.xr25_u18.nr1[nsmm_w]
print @n.xbgr.xr25_u18.nr1[nsmm_l]
print @n.xbgr.xr25_u19.nr1[nsmm_rsh]
print @n.xbgr.xr25_u19.nr1[nsmm_w]
print @n.xbgr.xr25_u19.nr1[nsmm_l]
print @n.xbgr.xr25_u20.nr1[nsmm_rsh]
print @n.xbgr.xr25_u20.nr1[nsmm_w]
print @n.xbgr.xr25_u20.nr1[nsmm_l]
print @n.xbgr.xr25_u21.nr1[nsmm_rsh]
print @n.xbgr.xr25_u21.nr1[nsmm_w]
print @n.xbgr.xr25_u21.nr1[nsmm_l]
print @n.xbgr.xr25_u22.nr1[nsmm_rsh]
print @n.xbgr.xr25_u22.nr1[nsmm_w]
print @n.xbgr.xr25_u22.nr1[nsmm_l]
print @n.xbgr.xr25_u23.nr1[nsmm_rsh]
print @n.xbgr.xr25_u23.nr1[nsmm_w]
print @n.xbgr.xr25_u23.nr1[nsmm_l]
print @n.xbgr.xr25_u24.nr1[nsmm_rsh]
print @n.xbgr.xr25_u24.nr1[nsmm_w]
print @n.xbgr.xr25_u24.nr1[nsmm_l]
print @n.xbgr.xr26_u2.nr1[nsmm_rsh]
print @n.xbgr.xr26_u2.nr1[nsmm_w]
print @n.xbgr.xr26_u2.nr1[nsmm_l]
print @n.xbgr.xr26_u3.nr1[nsmm_rsh]
print @n.xbgr.xr26_u3.nr1[nsmm_w]
print @n.xbgr.xr26_u3.nr1[nsmm_l]
print @n.xbgr.xr26_u4.nr1[nsmm_rsh]
print @n.xbgr.xr26_u4.nr1[nsmm_w]
print @n.xbgr.xr26_u4.nr1[nsmm_l]
print @n.xbgr.xr26_u5.nr1[nsmm_rsh]
print @n.xbgr.xr26_u5.nr1[nsmm_w]
print @n.xbgr.xr26_u5.nr1[nsmm_l]
print @n.xbgr.xr26_u6.nr1[nsmm_rsh]
print @n.xbgr.xr26_u6.nr1[nsmm_w]
print @n.xbgr.xr26_u6.nr1[nsmm_l]
print @n.xbgr.xr26_u7.nr1[nsmm_rsh]
print @n.xbgr.xr26_u7.nr1[nsmm_w]
print @n.xbgr.xr26_u7.nr1[nsmm_l]
print @n.xbgr.xr26_u8.nr1[nsmm_rsh]
print @n.xbgr.xr26_u8.nr1[nsmm_w]
print @n.xbgr.xr26_u8.nr1[nsmm_l]
print @n.xbgr.xr26_u9.nr1[nsmm_rsh]
print @n.xbgr.xr26_u9.nr1[nsmm_w]
print @n.xbgr.xr26_u9.nr1[nsmm_l]
print @n.xbgr.xr26_u10.nr1[nsmm_rsh]
print @n.xbgr.xr26_u10.nr1[nsmm_w]
print @n.xbgr.xr26_u10.nr1[nsmm_l]
print @n.xbgr.xr26_u11.nr1[nsmm_rsh]
print @n.xbgr.xr26_u11.nr1[nsmm_w]
print @n.xbgr.xr26_u11.nr1[nsmm_l]
print @n.xbgr.xr26_u12.nr1[nsmm_rsh]
print @n.xbgr.xr26_u12.nr1[nsmm_w]
print @n.xbgr.xr26_u12.nr1[nsmm_l]
print @n.xbgr.xr26_u13.nr1[nsmm_rsh]
print @n.xbgr.xr26_u13.nr1[nsmm_w]
print @n.xbgr.xr26_u13.nr1[nsmm_l]
print @n.xbgr.xr26_u14.nr1[nsmm_rsh]
print @n.xbgr.xr26_u14.nr1[nsmm_w]
print @n.xbgr.xr26_u14.nr1[nsmm_l]
print @n.xbgr.xr26_u15.nr1[nsmm_rsh]
print @n.xbgr.xr26_u15.nr1[nsmm_w]
print @n.xbgr.xr26_u15.nr1[nsmm_l]
print @n.xbgr.xr26_u16.nr1[nsmm_rsh]
print @n.xbgr.xr26_u16.nr1[nsmm_w]
print @n.xbgr.xr26_u16.nr1[nsmm_l]
print @n.xbgr.xr26_u17.nr1[nsmm_rsh]
print @n.xbgr.xr26_u17.nr1[nsmm_w]
print @n.xbgr.xr26_u17.nr1[nsmm_l]
print @n.xbgr.xr26_u18.nr1[nsmm_rsh]
print @n.xbgr.xr26_u18.nr1[nsmm_w]
print @n.xbgr.xr26_u18.nr1[nsmm_l]
print @n.xbgr.xr26_u19.nr1[nsmm_rsh]
print @n.xbgr.xr26_u19.nr1[nsmm_w]
print @n.xbgr.xr26_u19.nr1[nsmm_l]
print @n.xbgr.xr26_u20.nr1[nsmm_rsh]
print @n.xbgr.xr26_u20.nr1[nsmm_w]
print @n.xbgr.xr26_u20.nr1[nsmm_l]
print @n.xbgr.xr26_u21.nr1[nsmm_rsh]
print @n.xbgr.xr26_u21.nr1[nsmm_w]
print @n.xbgr.xr26_u21.nr1[nsmm_l]
print @n.xbgr.xr26_u22.nr1[nsmm_rsh]
print @n.xbgr.xr26_u22.nr1[nsmm_w]
print @n.xbgr.xr26_u22.nr1[nsmm_l]
print @n.xbgr.xr26_u23.nr1[nsmm_rsh]
print @n.xbgr.xr26_u23.nr1[nsmm_w]
print @n.xbgr.xr26_u23.nr1[nsmm_l]
print @n.xbgr.xr26_u24.nr1[nsmm_rsh]
print @n.xbgr.xr26_u24.nr1[nsmm_w]
print @n.xbgr.xr26_u24.nr1[nsmm_l]
print @n.xbgr.xm34_u2.nsg13_hv_nmos[w]
print @n.xbgr.xm34_u2.nsg13_hv_nmos[l]
print @n.xbgr.xm34_u2.nsg13_hv_nmos[delvto]
print @n.xbgr.xm34_u2.nsg13_hv_nmos[factuo]
print @n.xbgr.xm34_u3.nsg13_hv_nmos[w]
print @n.xbgr.xm34_u3.nsg13_hv_nmos[l]
print @n.xbgr.xm34_u3.nsg13_hv_nmos[delvto]
print @n.xbgr.xm34_u3.nsg13_hv_nmos[factuo]
print @n.xbgr.xm34_u4.nsg13_hv_nmos[w]
print @n.xbgr.xm34_u4.nsg13_hv_nmos[l]
print @n.xbgr.xm34_u4.nsg13_hv_nmos[delvto]
print @n.xbgr.xm34_u4.nsg13_hv_nmos[factuo]
print @n.xbgr.xm34_u5.nsg13_hv_nmos[w]
print @n.xbgr.xm34_u5.nsg13_hv_nmos[l]
print @n.xbgr.xm34_u5.nsg13_hv_nmos[delvto]
print @n.xbgr.xm34_u5.nsg13_hv_nmos[factuo]
print @n.xbgr.xm34_u6.nsg13_hv_nmos[w]
print @n.xbgr.xm34_u6.nsg13_hv_nmos[l]
print @n.xbgr.xm34_u6.nsg13_hv_nmos[delvto]
print @n.xbgr.xm34_u6.nsg13_hv_nmos[factuo]
print @n.xbgr.xm34_u7.nsg13_hv_nmos[w]
print @n.xbgr.xm34_u7.nsg13_hv_nmos[l]
print @n.xbgr.xm34_u7.nsg13_hv_nmos[delvto]
print @n.xbgr.xm34_u7.nsg13_hv_nmos[factuo]
print @n.xbgr.xm34_u8.nsg13_hv_nmos[w]
print @n.xbgr.xm34_u8.nsg13_hv_nmos[l]
print @n.xbgr.xm34_u8.nsg13_hv_nmos[delvto]
print @n.xbgr.xm34_u8.nsg13_hv_nmos[factuo]
print @n.xbgr.xm34_u9.nsg13_hv_nmos[w]
print @n.xbgr.xm34_u9.nsg13_hv_nmos[l]
print @n.xbgr.xm34_u9.nsg13_hv_nmos[delvto]
print @n.xbgr.xm34_u9.nsg13_hv_nmos[factuo]
print @n.xbgr.xm34_u10.nsg13_hv_nmos[w]
print @n.xbgr.xm34_u10.nsg13_hv_nmos[l]
print @n.xbgr.xm34_u10.nsg13_hv_nmos[delvto]
print @n.xbgr.xm34_u10.nsg13_hv_nmos[factuo]
print @n.xbgr.xm34_u11.nsg13_hv_nmos[w]
print @n.xbgr.xm34_u11.nsg13_hv_nmos[l]
print @n.xbgr.xm34_u11.nsg13_hv_nmos[delvto]
print @n.xbgr.xm34_u11.nsg13_hv_nmos[factuo]
print @n.xbgr.xm34_u12.nsg13_hv_nmos[w]
print @n.xbgr.xm34_u12.nsg13_hv_nmos[l]
print @n.xbgr.xm34_u12.nsg13_hv_nmos[delvto]
print @n.xbgr.xm34_u12.nsg13_hv_nmos[factuo]
print @n.xbgr.xm34_u13.nsg13_hv_nmos[w]
print @n.xbgr.xm34_u13.nsg13_hv_nmos[l]
print @n.xbgr.xm34_u13.nsg13_hv_nmos[delvto]
print @n.xbgr.xm34_u13.nsg13_hv_nmos[factuo]
print @n.xbgr.xm34_u14.nsg13_hv_nmos[w]
print @n.xbgr.xm34_u14.nsg13_hv_nmos[l]
print @n.xbgr.xm34_u14.nsg13_hv_nmos[delvto]
print @n.xbgr.xm34_u14.nsg13_hv_nmos[factuo]
print @n.xbgr.xm34_u15.nsg13_hv_nmos[w]
print @n.xbgr.xm34_u15.nsg13_hv_nmos[l]
print @n.xbgr.xm34_u15.nsg13_hv_nmos[delvto]
print @n.xbgr.xm34_u15.nsg13_hv_nmos[factuo]
print @n.xbgr.xm34_u16.nsg13_hv_nmos[w]
print @n.xbgr.xm34_u16.nsg13_hv_nmos[l]
print @n.xbgr.xm34_u16.nsg13_hv_nmos[delvto]
print @n.xbgr.xm34_u16.nsg13_hv_nmos[factuo]
print @n.xbgr.xm34_u17.nsg13_hv_nmos[w]
print @n.xbgr.xm34_u17.nsg13_hv_nmos[l]
print @n.xbgr.xm34_u17.nsg13_hv_nmos[delvto]
print @n.xbgr.xm34_u17.nsg13_hv_nmos[factuo]
print @n.xbgr.xm34_u18.nsg13_hv_nmos[w]
print @n.xbgr.xm34_u18.nsg13_hv_nmos[l]
print @n.xbgr.xm34_u18.nsg13_hv_nmos[delvto]
print @n.xbgr.xm34_u18.nsg13_hv_nmos[factuo]
print @n.xbgr.xm34_u19.nsg13_hv_nmos[w]
print @n.xbgr.xm34_u19.nsg13_hv_nmos[l]
print @n.xbgr.xm34_u19.nsg13_hv_nmos[delvto]
print @n.xbgr.xm34_u19.nsg13_hv_nmos[factuo]
print @n.xbgr.xm34_u20.nsg13_hv_nmos[w]
print @n.xbgr.xm34_u20.nsg13_hv_nmos[l]
print @n.xbgr.xm34_u20.nsg13_hv_nmos[delvto]
print @n.xbgr.xm34_u20.nsg13_hv_nmos[factuo]
print @n.xbgr.xm34_u21.nsg13_hv_nmos[w]
print @n.xbgr.xm34_u21.nsg13_hv_nmos[l]
print @n.xbgr.xm34_u21.nsg13_hv_nmos[delvto]
print @n.xbgr.xm34_u21.nsg13_hv_nmos[factuo]
print @n.xbgr.xm34_u22.nsg13_hv_nmos[w]
print @n.xbgr.xm34_u22.nsg13_hv_nmos[l]
print @n.xbgr.xm34_u22.nsg13_hv_nmos[delvto]
print @n.xbgr.xm34_u22.nsg13_hv_nmos[factuo]
print @n.xbgr.xm34_u23.nsg13_hv_nmos[w]
print @n.xbgr.xm34_u23.nsg13_hv_nmos[l]
print @n.xbgr.xm34_u23.nsg13_hv_nmos[delvto]
print @n.xbgr.xm34_u23.nsg13_hv_nmos[factuo]
print @n.xbgr.xm34_u24.nsg13_hv_nmos[w]
print @n.xbgr.xm34_u24.nsg13_hv_nmos[l]
print @n.xbgr.xm34_u24.nsg13_hv_nmos[delvto]
print @n.xbgr.xm34_u24.nsg13_hv_nmos[factuo]
print @n.xbgr.xm35_u2.nsg13_hv_nmos[w]
print @n.xbgr.xm35_u2.nsg13_hv_nmos[l]
print @n.xbgr.xm35_u2.nsg13_hv_nmos[delvto]
print @n.xbgr.xm35_u2.nsg13_hv_nmos[factuo]
print @n.xbgr.xm35_u3.nsg13_hv_nmos[w]
print @n.xbgr.xm35_u3.nsg13_hv_nmos[l]
print @n.xbgr.xm35_u3.nsg13_hv_nmos[delvto]
print @n.xbgr.xm35_u3.nsg13_hv_nmos[factuo]
print @n.xbgr.xm35_u4.nsg13_hv_nmos[w]
print @n.xbgr.xm35_u4.nsg13_hv_nmos[l]
print @n.xbgr.xm35_u4.nsg13_hv_nmos[delvto]
print @n.xbgr.xm35_u4.nsg13_hv_nmos[factuo]
print @n.xbgr.xm35_u5.nsg13_hv_nmos[w]
print @n.xbgr.xm35_u5.nsg13_hv_nmos[l]
print @n.xbgr.xm35_u5.nsg13_hv_nmos[delvto]
print @n.xbgr.xm35_u5.nsg13_hv_nmos[factuo]
print @n.xbgr.xm35_u6.nsg13_hv_nmos[w]
print @n.xbgr.xm35_u6.nsg13_hv_nmos[l]
print @n.xbgr.xm35_u6.nsg13_hv_nmos[delvto]
print @n.xbgr.xm35_u6.nsg13_hv_nmos[factuo]
print @n.xbgr.xm35_u7.nsg13_hv_nmos[w]
print @n.xbgr.xm35_u7.nsg13_hv_nmos[l]
print @n.xbgr.xm35_u7.nsg13_hv_nmos[delvto]
print @n.xbgr.xm35_u7.nsg13_hv_nmos[factuo]
print @n.xbgr.xm35_u8.nsg13_hv_nmos[w]
print @n.xbgr.xm35_u8.nsg13_hv_nmos[l]
print @n.xbgr.xm35_u8.nsg13_hv_nmos[delvto]
print @n.xbgr.xm35_u8.nsg13_hv_nmos[factuo]
print @n.xbgr.xm35_u9.nsg13_hv_nmos[w]
print @n.xbgr.xm35_u9.nsg13_hv_nmos[l]
print @n.xbgr.xm35_u9.nsg13_hv_nmos[delvto]
print @n.xbgr.xm35_u9.nsg13_hv_nmos[factuo]
print @n.xbgr.xm35_u10.nsg13_hv_nmos[w]
print @n.xbgr.xm35_u10.nsg13_hv_nmos[l]
print @n.xbgr.xm35_u10.nsg13_hv_nmos[delvto]
print @n.xbgr.xm35_u10.nsg13_hv_nmos[factuo]
print @n.xbgr.xm35_u11.nsg13_hv_nmos[w]
print @n.xbgr.xm35_u11.nsg13_hv_nmos[l]
print @n.xbgr.xm35_u11.nsg13_hv_nmos[delvto]
print @n.xbgr.xm35_u11.nsg13_hv_nmos[factuo]
print @n.xbgr.xm35_u12.nsg13_hv_nmos[w]
print @n.xbgr.xm35_u12.nsg13_hv_nmos[l]
print @n.xbgr.xm35_u12.nsg13_hv_nmos[delvto]
print @n.xbgr.xm35_u12.nsg13_hv_nmos[factuo]
print @n.xbgr.xm35_u13.nsg13_hv_nmos[w]
print @n.xbgr.xm35_u13.nsg13_hv_nmos[l]
print @n.xbgr.xm35_u13.nsg13_hv_nmos[delvto]
print @n.xbgr.xm35_u13.nsg13_hv_nmos[factuo]
print @n.xbgr.xm35_u14.nsg13_hv_nmos[w]
print @n.xbgr.xm35_u14.nsg13_hv_nmos[l]
print @n.xbgr.xm35_u14.nsg13_hv_nmos[delvto]
print @n.xbgr.xm35_u14.nsg13_hv_nmos[factuo]
print @n.xbgr.xm35_u15.nsg13_hv_nmos[w]
print @n.xbgr.xm35_u15.nsg13_hv_nmos[l]
print @n.xbgr.xm35_u15.nsg13_hv_nmos[delvto]
print @n.xbgr.xm35_u15.nsg13_hv_nmos[factuo]
print @n.xbgr.xm35_u16.nsg13_hv_nmos[w]
print @n.xbgr.xm35_u16.nsg13_hv_nmos[l]
print @n.xbgr.xm35_u16.nsg13_hv_nmos[delvto]
print @n.xbgr.xm35_u16.nsg13_hv_nmos[factuo]
print @n.xbgr.xm35_u17.nsg13_hv_nmos[w]
print @n.xbgr.xm35_u17.nsg13_hv_nmos[l]
print @n.xbgr.xm35_u17.nsg13_hv_nmos[delvto]
print @n.xbgr.xm35_u17.nsg13_hv_nmos[factuo]
print @n.xbgr.xm35_u18.nsg13_hv_nmos[w]
print @n.xbgr.xm35_u18.nsg13_hv_nmos[l]
print @n.xbgr.xm35_u18.nsg13_hv_nmos[delvto]
print @n.xbgr.xm35_u18.nsg13_hv_nmos[factuo]
print @n.xbgr.xm35_u19.nsg13_hv_nmos[w]
print @n.xbgr.xm35_u19.nsg13_hv_nmos[l]
print @n.xbgr.xm35_u19.nsg13_hv_nmos[delvto]
print @n.xbgr.xm35_u19.nsg13_hv_nmos[factuo]
print @n.xbgr.xm35_u20.nsg13_hv_nmos[w]
print @n.xbgr.xm35_u20.nsg13_hv_nmos[l]
print @n.xbgr.xm35_u20.nsg13_hv_nmos[delvto]
print @n.xbgr.xm35_u20.nsg13_hv_nmos[factuo]
print @n.xbgr.xm35_u21.nsg13_hv_nmos[w]
print @n.xbgr.xm35_u21.nsg13_hv_nmos[l]
print @n.xbgr.xm35_u21.nsg13_hv_nmos[delvto]
print @n.xbgr.xm35_u21.nsg13_hv_nmos[factuo]
print @n.xbgr.xm35_u22.nsg13_hv_nmos[w]
print @n.xbgr.xm35_u22.nsg13_hv_nmos[l]
print @n.xbgr.xm35_u22.nsg13_hv_nmos[delvto]
print @n.xbgr.xm35_u22.nsg13_hv_nmos[factuo]
print @n.xbgr.xm35_u23.nsg13_hv_nmos[w]
print @n.xbgr.xm35_u23.nsg13_hv_nmos[l]
print @n.xbgr.xm35_u23.nsg13_hv_nmos[delvto]
print @n.xbgr.xm35_u23.nsg13_hv_nmos[factuo]
print @n.xbgr.xm35_u24.nsg13_hv_nmos[w]
print @n.xbgr.xm35_u24.nsg13_hv_nmos[l]
print @n.xbgr.xm35_u24.nsg13_hv_nmos[delvto]
print @n.xbgr.xm35_u24.nsg13_hv_nmos[factuo]
print @n.xbgr.xm36_u2.nsg13_hv_nmos[w]
print @n.xbgr.xm36_u2.nsg13_hv_nmos[l]
print @n.xbgr.xm36_u2.nsg13_hv_nmos[delvto]
print @n.xbgr.xm36_u2.nsg13_hv_nmos[factuo]
print @n.xbgr.xm36_u3.nsg13_hv_nmos[w]
print @n.xbgr.xm36_u3.nsg13_hv_nmos[l]
print @n.xbgr.xm36_u3.nsg13_hv_nmos[delvto]
print @n.xbgr.xm36_u3.nsg13_hv_nmos[factuo]
print @n.xbgr.xm36_u4.nsg13_hv_nmos[w]
print @n.xbgr.xm36_u4.nsg13_hv_nmos[l]
print @n.xbgr.xm36_u4.nsg13_hv_nmos[delvto]
print @n.xbgr.xm36_u4.nsg13_hv_nmos[factuo]
print @n.xbgr.xm36_u5.nsg13_hv_nmos[w]
print @n.xbgr.xm36_u5.nsg13_hv_nmos[l]
print @n.xbgr.xm36_u5.nsg13_hv_nmos[delvto]
print @n.xbgr.xm36_u5.nsg13_hv_nmos[factuo]
print @n.xbgr.xm36_u6.nsg13_hv_nmos[w]
print @n.xbgr.xm36_u6.nsg13_hv_nmos[l]
print @n.xbgr.xm36_u6.nsg13_hv_nmos[delvto]
print @n.xbgr.xm36_u6.nsg13_hv_nmos[factuo]
print @n.xbgr.xm36_u7.nsg13_hv_nmos[w]
print @n.xbgr.xm36_u7.nsg13_hv_nmos[l]
print @n.xbgr.xm36_u7.nsg13_hv_nmos[delvto]
print @n.xbgr.xm36_u7.nsg13_hv_nmos[factuo]
print @n.xbgr.xm36_u8.nsg13_hv_nmos[w]
print @n.xbgr.xm36_u8.nsg13_hv_nmos[l]
print @n.xbgr.xm36_u8.nsg13_hv_nmos[delvto]
print @n.xbgr.xm36_u8.nsg13_hv_nmos[factuo]
print @n.xbgr.xm36_u9.nsg13_hv_nmos[w]
print @n.xbgr.xm36_u9.nsg13_hv_nmos[l]
print @n.xbgr.xm36_u9.nsg13_hv_nmos[delvto]
print @n.xbgr.xm36_u9.nsg13_hv_nmos[factuo]
print @n.xbgr.xm36_u10.nsg13_hv_nmos[w]
print @n.xbgr.xm36_u10.nsg13_hv_nmos[l]
print @n.xbgr.xm36_u10.nsg13_hv_nmos[delvto]
print @n.xbgr.xm36_u10.nsg13_hv_nmos[factuo]
print @n.xbgr.xm36_u11.nsg13_hv_nmos[w]
print @n.xbgr.xm36_u11.nsg13_hv_nmos[l]
print @n.xbgr.xm36_u11.nsg13_hv_nmos[delvto]
print @n.xbgr.xm36_u11.nsg13_hv_nmos[factuo]
print @n.xbgr.xm36_u12.nsg13_hv_nmos[w]
print @n.xbgr.xm36_u12.nsg13_hv_nmos[l]
print @n.xbgr.xm36_u12.nsg13_hv_nmos[delvto]
print @n.xbgr.xm36_u12.nsg13_hv_nmos[factuo]
print @n.xbgr.xm36_u13.nsg13_hv_nmos[w]
print @n.xbgr.xm36_u13.nsg13_hv_nmos[l]
print @n.xbgr.xm36_u13.nsg13_hv_nmos[delvto]
print @n.xbgr.xm36_u13.nsg13_hv_nmos[factuo]
print @n.xbgr.xm36_u14.nsg13_hv_nmos[w]
print @n.xbgr.xm36_u14.nsg13_hv_nmos[l]
print @n.xbgr.xm36_u14.nsg13_hv_nmos[delvto]
print @n.xbgr.xm36_u14.nsg13_hv_nmos[factuo]
print @n.xbgr.xm36_u15.nsg13_hv_nmos[w]
print @n.xbgr.xm36_u15.nsg13_hv_nmos[l]
print @n.xbgr.xm36_u15.nsg13_hv_nmos[delvto]
print @n.xbgr.xm36_u15.nsg13_hv_nmos[factuo]
print @n.xbgr.xm36_u16.nsg13_hv_nmos[w]
print @n.xbgr.xm36_u16.nsg13_hv_nmos[l]
print @n.xbgr.xm36_u16.nsg13_hv_nmos[delvto]
print @n.xbgr.xm36_u16.nsg13_hv_nmos[factuo]
print @n.xbgr.xm36_u17.nsg13_hv_nmos[w]
print @n.xbgr.xm36_u17.nsg13_hv_nmos[l]
print @n.xbgr.xm36_u17.nsg13_hv_nmos[delvto]
print @n.xbgr.xm36_u17.nsg13_hv_nmos[factuo]
print @n.xbgr.xm36_u18.nsg13_hv_nmos[w]
print @n.xbgr.xm36_u18.nsg13_hv_nmos[l]
print @n.xbgr.xm36_u18.nsg13_hv_nmos[delvto]
print @n.xbgr.xm36_u18.nsg13_hv_nmos[factuo]
print @n.xbgr.xm36_u19.nsg13_hv_nmos[w]
print @n.xbgr.xm36_u19.nsg13_hv_nmos[l]
print @n.xbgr.xm36_u19.nsg13_hv_nmos[delvto]
print @n.xbgr.xm36_u19.nsg13_hv_nmos[factuo]
print @n.xbgr.xm36_u20.nsg13_hv_nmos[w]
print @n.xbgr.xm36_u20.nsg13_hv_nmos[l]
print @n.xbgr.xm36_u20.nsg13_hv_nmos[delvto]
print @n.xbgr.xm36_u20.nsg13_hv_nmos[factuo]
print @n.xbgr.xm36_u21.nsg13_hv_nmos[w]
print @n.xbgr.xm36_u21.nsg13_hv_nmos[l]
print @n.xbgr.xm36_u21.nsg13_hv_nmos[delvto]
print @n.xbgr.xm36_u21.nsg13_hv_nmos[factuo]
print @n.xbgr.xm36_u22.nsg13_hv_nmos[w]
print @n.xbgr.xm36_u22.nsg13_hv_nmos[l]
print @n.xbgr.xm36_u22.nsg13_hv_nmos[delvto]
print @n.xbgr.xm36_u22.nsg13_hv_nmos[factuo]
print @n.xbgr.xm36_u23.nsg13_hv_nmos[w]
print @n.xbgr.xm36_u23.nsg13_hv_nmos[l]
print @n.xbgr.xm36_u23.nsg13_hv_nmos[delvto]
print @n.xbgr.xm36_u23.nsg13_hv_nmos[factuo]
print @n.xbgr.xm36_u24.nsg13_hv_nmos[w]
print @n.xbgr.xm36_u24.nsg13_hv_nmos[l]
print @n.xbgr.xm36_u24.nsg13_hv_nmos[delvto]
print @n.xbgr.xm36_u24.nsg13_hv_nmos[factuo]
print @n.xbgr.xm37_u2.nsg13_hv_nmos[w]
print @n.xbgr.xm37_u2.nsg13_hv_nmos[l]
print @n.xbgr.xm37_u2.nsg13_hv_nmos[delvto]
print @n.xbgr.xm37_u2.nsg13_hv_nmos[factuo]
print @n.xbgr.xm37_u3.nsg13_hv_nmos[w]
print @n.xbgr.xm37_u3.nsg13_hv_nmos[l]
print @n.xbgr.xm37_u3.nsg13_hv_nmos[delvto]
print @n.xbgr.xm37_u3.nsg13_hv_nmos[factuo]
print @n.xbgr.xm37_u4.nsg13_hv_nmos[w]
print @n.xbgr.xm37_u4.nsg13_hv_nmos[l]
print @n.xbgr.xm37_u4.nsg13_hv_nmos[delvto]
print @n.xbgr.xm37_u4.nsg13_hv_nmos[factuo]
print @n.xbgr.xm37_u5.nsg13_hv_nmos[w]
print @n.xbgr.xm37_u5.nsg13_hv_nmos[l]
print @n.xbgr.xm37_u5.nsg13_hv_nmos[delvto]
print @n.xbgr.xm37_u5.nsg13_hv_nmos[factuo]
print @n.xbgr.xm37_u6.nsg13_hv_nmos[w]
print @n.xbgr.xm37_u6.nsg13_hv_nmos[l]
print @n.xbgr.xm37_u6.nsg13_hv_nmos[delvto]
print @n.xbgr.xm37_u6.nsg13_hv_nmos[factuo]
print @n.xbgr.xm37_u7.nsg13_hv_nmos[w]
print @n.xbgr.xm37_u7.nsg13_hv_nmos[l]
print @n.xbgr.xm37_u7.nsg13_hv_nmos[delvto]
print @n.xbgr.xm37_u7.nsg13_hv_nmos[factuo]
print @n.xbgr.xm37_u8.nsg13_hv_nmos[w]
print @n.xbgr.xm37_u8.nsg13_hv_nmos[l]
print @n.xbgr.xm37_u8.nsg13_hv_nmos[delvto]
print @n.xbgr.xm37_u8.nsg13_hv_nmos[factuo]
print @n.xbgr.xm37_u9.nsg13_hv_nmos[w]
print @n.xbgr.xm37_u9.nsg13_hv_nmos[l]
print @n.xbgr.xm37_u9.nsg13_hv_nmos[delvto]
print @n.xbgr.xm37_u9.nsg13_hv_nmos[factuo]
print @n.xbgr.xm37_u10.nsg13_hv_nmos[w]
print @n.xbgr.xm37_u10.nsg13_hv_nmos[l]
print @n.xbgr.xm37_u10.nsg13_hv_nmos[delvto]
print @n.xbgr.xm37_u10.nsg13_hv_nmos[factuo]
print @n.xbgr.xm37_u11.nsg13_hv_nmos[w]
print @n.xbgr.xm37_u11.nsg13_hv_nmos[l]
print @n.xbgr.xm37_u11.nsg13_hv_nmos[delvto]
print @n.xbgr.xm37_u11.nsg13_hv_nmos[factuo]
print @n.xbgr.xm37_u12.nsg13_hv_nmos[w]
print @n.xbgr.xm37_u12.nsg13_hv_nmos[l]
print @n.xbgr.xm37_u12.nsg13_hv_nmos[delvto]
print @n.xbgr.xm37_u12.nsg13_hv_nmos[factuo]
print @n.xbgr.xm37_u13.nsg13_hv_nmos[w]
print @n.xbgr.xm37_u13.nsg13_hv_nmos[l]
print @n.xbgr.xm37_u13.nsg13_hv_nmos[delvto]
print @n.xbgr.xm37_u13.nsg13_hv_nmos[factuo]
print @n.xbgr.xm37_u14.nsg13_hv_nmos[w]
print @n.xbgr.xm37_u14.nsg13_hv_nmos[l]
print @n.xbgr.xm37_u14.nsg13_hv_nmos[delvto]
print @n.xbgr.xm37_u14.nsg13_hv_nmos[factuo]
print @n.xbgr.xm37_u15.nsg13_hv_nmos[w]
print @n.xbgr.xm37_u15.nsg13_hv_nmos[l]
print @n.xbgr.xm37_u15.nsg13_hv_nmos[delvto]
print @n.xbgr.xm37_u15.nsg13_hv_nmos[factuo]
print @n.xbgr.xm37_u16.nsg13_hv_nmos[w]
print @n.xbgr.xm37_u16.nsg13_hv_nmos[l]
print @n.xbgr.xm37_u16.nsg13_hv_nmos[delvto]
print @n.xbgr.xm37_u16.nsg13_hv_nmos[factuo]
print @n.xbgr.xm37_u17.nsg13_hv_nmos[w]
print @n.xbgr.xm37_u17.nsg13_hv_nmos[l]
print @n.xbgr.xm37_u17.nsg13_hv_nmos[delvto]
print @n.xbgr.xm37_u17.nsg13_hv_nmos[factuo]
print @n.xbgr.xm37_u18.nsg13_hv_nmos[w]
print @n.xbgr.xm37_u18.nsg13_hv_nmos[l]
print @n.xbgr.xm37_u18.nsg13_hv_nmos[delvto]
print @n.xbgr.xm37_u18.nsg13_hv_nmos[factuo]
print @n.xbgr.xm37_u19.nsg13_hv_nmos[w]
print @n.xbgr.xm37_u19.nsg13_hv_nmos[l]
print @n.xbgr.xm37_u19.nsg13_hv_nmos[delvto]
print @n.xbgr.xm37_u19.nsg13_hv_nmos[factuo]
print @n.xbgr.xm37_u20.nsg13_hv_nmos[w]
print @n.xbgr.xm37_u20.nsg13_hv_nmos[l]
print @n.xbgr.xm37_u20.nsg13_hv_nmos[delvto]
print @n.xbgr.xm37_u20.nsg13_hv_nmos[factuo]
print @n.xbgr.xm37_u21.nsg13_hv_nmos[w]
print @n.xbgr.xm37_u21.nsg13_hv_nmos[l]
print @n.xbgr.xm37_u21.nsg13_hv_nmos[delvto]
print @n.xbgr.xm37_u21.nsg13_hv_nmos[factuo]
print @n.xbgr.xm37_u22.nsg13_hv_nmos[w]
print @n.xbgr.xm37_u22.nsg13_hv_nmos[l]
print @n.xbgr.xm37_u22.nsg13_hv_nmos[delvto]
print @n.xbgr.xm37_u22.nsg13_hv_nmos[factuo]
print @n.xbgr.xm37_u23.nsg13_hv_nmos[w]
print @n.xbgr.xm37_u23.nsg13_hv_nmos[l]
print @n.xbgr.xm37_u23.nsg13_hv_nmos[delvto]
print @n.xbgr.xm37_u23.nsg13_hv_nmos[factuo]
print @n.xbgr.xm37_u24.nsg13_hv_nmos[w]
print @n.xbgr.xm37_u24.nsg13_hv_nmos[l]
print @n.xbgr.xm37_u24.nsg13_hv_nmos[delvto]
print @n.xbgr.xm37_u24.nsg13_hv_nmos[factuo]
print @n.xbgr.xm38_u2.nsg13_hv_pmos[w]
print @n.xbgr.xm38_u2.nsg13_hv_pmos[l]
print @n.xbgr.xm38_u2.nsg13_hv_pmos[delvto]
print @n.xbgr.xm38_u2.nsg13_hv_pmos[factuo]
print @n.xbgr.xm38_u3.nsg13_hv_pmos[w]
print @n.xbgr.xm38_u3.nsg13_hv_pmos[l]
print @n.xbgr.xm38_u3.nsg13_hv_pmos[delvto]
print @n.xbgr.xm38_u3.nsg13_hv_pmos[factuo]
print @n.xbgr.xm38_u4.nsg13_hv_pmos[w]
print @n.xbgr.xm38_u4.nsg13_hv_pmos[l]
print @n.xbgr.xm38_u4.nsg13_hv_pmos[delvto]
print @n.xbgr.xm38_u4.nsg13_hv_pmos[factuo]
print @n.xbgr.xm38_u5.nsg13_hv_pmos[w]
print @n.xbgr.xm38_u5.nsg13_hv_pmos[l]
print @n.xbgr.xm38_u5.nsg13_hv_pmos[delvto]
print @n.xbgr.xm38_u5.nsg13_hv_pmos[factuo]
print @n.xbgr.xm38_u6.nsg13_hv_pmos[w]
print @n.xbgr.xm38_u6.nsg13_hv_pmos[l]
print @n.xbgr.xm38_u6.nsg13_hv_pmos[delvto]
print @n.xbgr.xm38_u6.nsg13_hv_pmos[factuo]
print @n.xbgr.xm38_u7.nsg13_hv_pmos[w]
print @n.xbgr.xm38_u7.nsg13_hv_pmos[l]
print @n.xbgr.xm38_u7.nsg13_hv_pmos[delvto]
print @n.xbgr.xm38_u7.nsg13_hv_pmos[factuo]
print @n.xbgr.xm38_u8.nsg13_hv_pmos[w]
print @n.xbgr.xm38_u8.nsg13_hv_pmos[l]
print @n.xbgr.xm38_u8.nsg13_hv_pmos[delvto]
print @n.xbgr.xm38_u8.nsg13_hv_pmos[factuo]
print @n.xbgr.xm38_u9.nsg13_hv_pmos[w]
print @n.xbgr.xm38_u9.nsg13_hv_pmos[l]
print @n.xbgr.xm38_u9.nsg13_hv_pmos[delvto]
print @n.xbgr.xm38_u9.nsg13_hv_pmos[factuo]
print @n.xbgr.xm38_u10.nsg13_hv_pmos[w]
print @n.xbgr.xm38_u10.nsg13_hv_pmos[l]
print @n.xbgr.xm38_u10.nsg13_hv_pmos[delvto]
print @n.xbgr.xm38_u10.nsg13_hv_pmos[factuo]
print @n.xbgr.xm38_u11.nsg13_hv_pmos[w]
print @n.xbgr.xm38_u11.nsg13_hv_pmos[l]
print @n.xbgr.xm38_u11.nsg13_hv_pmos[delvto]
print @n.xbgr.xm38_u11.nsg13_hv_pmos[factuo]
print @n.xbgr.xm38_u12.nsg13_hv_pmos[w]
print @n.xbgr.xm38_u12.nsg13_hv_pmos[l]
print @n.xbgr.xm38_u12.nsg13_hv_pmos[delvto]
print @n.xbgr.xm38_u12.nsg13_hv_pmos[factuo]
print @n.xbgr.xm38_u13.nsg13_hv_pmos[w]
print @n.xbgr.xm38_u13.nsg13_hv_pmos[l]
print @n.xbgr.xm38_u13.nsg13_hv_pmos[delvto]
print @n.xbgr.xm38_u13.nsg13_hv_pmos[factuo]
print @n.xbgr.xm38_u14.nsg13_hv_pmos[w]
print @n.xbgr.xm38_u14.nsg13_hv_pmos[l]
print @n.xbgr.xm38_u14.nsg13_hv_pmos[delvto]
print @n.xbgr.xm38_u14.nsg13_hv_pmos[factuo]
print @n.xbgr.xm38_u15.nsg13_hv_pmos[w]
print @n.xbgr.xm38_u15.nsg13_hv_pmos[l]
print @n.xbgr.xm38_u15.nsg13_hv_pmos[delvto]
print @n.xbgr.xm38_u15.nsg13_hv_pmos[factuo]
print @n.xbgr.xm38_u16.nsg13_hv_pmos[w]
print @n.xbgr.xm38_u16.nsg13_hv_pmos[l]
print @n.xbgr.xm38_u16.nsg13_hv_pmos[delvto]
print @n.xbgr.xm38_u16.nsg13_hv_pmos[factuo]
print @n.xbgr.xm38_u17.nsg13_hv_pmos[w]
print @n.xbgr.xm38_u17.nsg13_hv_pmos[l]
print @n.xbgr.xm38_u17.nsg13_hv_pmos[delvto]
print @n.xbgr.xm38_u17.nsg13_hv_pmos[factuo]
print @n.xbgr.xm38_u18.nsg13_hv_pmos[w]
print @n.xbgr.xm38_u18.nsg13_hv_pmos[l]
print @n.xbgr.xm38_u18.nsg13_hv_pmos[delvto]
print @n.xbgr.xm38_u18.nsg13_hv_pmos[factuo]
print @n.xbgr.xm38_u19.nsg13_hv_pmos[w]
print @n.xbgr.xm38_u19.nsg13_hv_pmos[l]
print @n.xbgr.xm38_u19.nsg13_hv_pmos[delvto]
print @n.xbgr.xm38_u19.nsg13_hv_pmos[factuo]
print @n.xbgr.xm38_u20.nsg13_hv_pmos[w]
print @n.xbgr.xm38_u20.nsg13_hv_pmos[l]
print @n.xbgr.xm38_u20.nsg13_hv_pmos[delvto]
print @n.xbgr.xm38_u20.nsg13_hv_pmos[factuo]
print @n.xbgr.xm38_u21.nsg13_hv_pmos[w]
print @n.xbgr.xm38_u21.nsg13_hv_pmos[l]
print @n.xbgr.xm38_u21.nsg13_hv_pmos[delvto]
print @n.xbgr.xm38_u21.nsg13_hv_pmos[factuo]
print @n.xbgr.xm38_u22.nsg13_hv_pmos[w]
print @n.xbgr.xm38_u22.nsg13_hv_pmos[l]
print @n.xbgr.xm38_u22.nsg13_hv_pmos[delvto]
print @n.xbgr.xm38_u22.nsg13_hv_pmos[factuo]
print @n.xbgr.xm38_u23.nsg13_hv_pmos[w]
print @n.xbgr.xm38_u23.nsg13_hv_pmos[l]
print @n.xbgr.xm38_u23.nsg13_hv_pmos[delvto]
print @n.xbgr.xm38_u23.nsg13_hv_pmos[factuo]
print @n.xbgr.xm38_u24.nsg13_hv_pmos[w]
print @n.xbgr.xm38_u24.nsg13_hv_pmos[l]
print @n.xbgr.xm38_u24.nsg13_hv_pmos[delvto]
print @n.xbgr.xm38_u24.nsg13_hv_pmos[factuo]
print @n.xbgr.xm39_u2.nsg13_hv_pmos[w]
print @n.xbgr.xm39_u2.nsg13_hv_pmos[l]
print @n.xbgr.xm39_u2.nsg13_hv_pmos[delvto]
print @n.xbgr.xm39_u2.nsg13_hv_pmos[factuo]
print @n.xbgr.xm39_u3.nsg13_hv_pmos[w]
print @n.xbgr.xm39_u3.nsg13_hv_pmos[l]
print @n.xbgr.xm39_u3.nsg13_hv_pmos[delvto]
print @n.xbgr.xm39_u3.nsg13_hv_pmos[factuo]
print @n.xbgr.xm39_u4.nsg13_hv_pmos[w]
print @n.xbgr.xm39_u4.nsg13_hv_pmos[l]
print @n.xbgr.xm39_u4.nsg13_hv_pmos[delvto]
print @n.xbgr.xm39_u4.nsg13_hv_pmos[factuo]
print @n.xbgr.xm39_u5.nsg13_hv_pmos[w]
print @n.xbgr.xm39_u5.nsg13_hv_pmos[l]
print @n.xbgr.xm39_u5.nsg13_hv_pmos[delvto]
print @n.xbgr.xm39_u5.nsg13_hv_pmos[factuo]
print @n.xbgr.xm39_u6.nsg13_hv_pmos[w]
print @n.xbgr.xm39_u6.nsg13_hv_pmos[l]
print @n.xbgr.xm39_u6.nsg13_hv_pmos[delvto]
print @n.xbgr.xm39_u6.nsg13_hv_pmos[factuo]
print @n.xbgr.xm39_u7.nsg13_hv_pmos[w]
print @n.xbgr.xm39_u7.nsg13_hv_pmos[l]
print @n.xbgr.xm39_u7.nsg13_hv_pmos[delvto]
print @n.xbgr.xm39_u7.nsg13_hv_pmos[factuo]
print @n.xbgr.xm39_u8.nsg13_hv_pmos[w]
print @n.xbgr.xm39_u8.nsg13_hv_pmos[l]
print @n.xbgr.xm39_u8.nsg13_hv_pmos[delvto]
print @n.xbgr.xm39_u8.nsg13_hv_pmos[factuo]
print @n.xbgr.xm39_u9.nsg13_hv_pmos[w]
print @n.xbgr.xm39_u9.nsg13_hv_pmos[l]
print @n.xbgr.xm39_u9.nsg13_hv_pmos[delvto]
print @n.xbgr.xm39_u9.nsg13_hv_pmos[factuo]
print @n.xbgr.xm39_u10.nsg13_hv_pmos[w]
print @n.xbgr.xm39_u10.nsg13_hv_pmos[l]
print @n.xbgr.xm39_u10.nsg13_hv_pmos[delvto]
print @n.xbgr.xm39_u10.nsg13_hv_pmos[factuo]
print @n.xbgr.xm39_u11.nsg13_hv_pmos[w]
print @n.xbgr.xm39_u11.nsg13_hv_pmos[l]
print @n.xbgr.xm39_u11.nsg13_hv_pmos[delvto]
print @n.xbgr.xm39_u11.nsg13_hv_pmos[factuo]
print @n.xbgr.xm39_u12.nsg13_hv_pmos[w]
print @n.xbgr.xm39_u12.nsg13_hv_pmos[l]
print @n.xbgr.xm39_u12.nsg13_hv_pmos[delvto]
print @n.xbgr.xm39_u12.nsg13_hv_pmos[factuo]
print @n.xbgr.xm39_u13.nsg13_hv_pmos[w]
print @n.xbgr.xm39_u13.nsg13_hv_pmos[l]
print @n.xbgr.xm39_u13.nsg13_hv_pmos[delvto]
print @n.xbgr.xm39_u13.nsg13_hv_pmos[factuo]
print @n.xbgr.xm39_u14.nsg13_hv_pmos[w]
print @n.xbgr.xm39_u14.nsg13_hv_pmos[l]
print @n.xbgr.xm39_u14.nsg13_hv_pmos[delvto]
print @n.xbgr.xm39_u14.nsg13_hv_pmos[factuo]
print @n.xbgr.xm39_u15.nsg13_hv_pmos[w]
print @n.xbgr.xm39_u15.nsg13_hv_pmos[l]
print @n.xbgr.xm39_u15.nsg13_hv_pmos[delvto]
print @n.xbgr.xm39_u15.nsg13_hv_pmos[factuo]
print @n.xbgr.xm39_u16.nsg13_hv_pmos[w]
print @n.xbgr.xm39_u16.nsg13_hv_pmos[l]
print @n.xbgr.xm39_u16.nsg13_hv_pmos[delvto]
print @n.xbgr.xm39_u16.nsg13_hv_pmos[factuo]
print @n.xbgr.xm39_u17.nsg13_hv_pmos[w]
print @n.xbgr.xm39_u17.nsg13_hv_pmos[l]
print @n.xbgr.xm39_u17.nsg13_hv_pmos[delvto]
print @n.xbgr.xm39_u17.nsg13_hv_pmos[factuo]
print @n.xbgr.xm39_u18.nsg13_hv_pmos[w]
print @n.xbgr.xm39_u18.nsg13_hv_pmos[l]
print @n.xbgr.xm39_u18.nsg13_hv_pmos[delvto]
print @n.xbgr.xm39_u18.nsg13_hv_pmos[factuo]
print @n.xbgr.xm39_u19.nsg13_hv_pmos[w]
print @n.xbgr.xm39_u19.nsg13_hv_pmos[l]
print @n.xbgr.xm39_u19.nsg13_hv_pmos[delvto]
print @n.xbgr.xm39_u19.nsg13_hv_pmos[factuo]
print @n.xbgr.xm39_u20.nsg13_hv_pmos[w]
print @n.xbgr.xm39_u20.nsg13_hv_pmos[l]
print @n.xbgr.xm39_u20.nsg13_hv_pmos[delvto]
print @n.xbgr.xm39_u20.nsg13_hv_pmos[factuo]
print @n.xbgr.xm39_u21.nsg13_hv_pmos[w]
print @n.xbgr.xm39_u21.nsg13_hv_pmos[l]
print @n.xbgr.xm39_u21.nsg13_hv_pmos[delvto]
print @n.xbgr.xm39_u21.nsg13_hv_pmos[factuo]
print @n.xbgr.xm39_u22.nsg13_hv_pmos[w]
print @n.xbgr.xm39_u22.nsg13_hv_pmos[l]
print @n.xbgr.xm39_u22.nsg13_hv_pmos[delvto]
print @n.xbgr.xm39_u22.nsg13_hv_pmos[factuo]
print @n.xbgr.xm39_u23.nsg13_hv_pmos[w]
print @n.xbgr.xm39_u23.nsg13_hv_pmos[l]
print @n.xbgr.xm39_u23.nsg13_hv_pmos[delvto]
print @n.xbgr.xm39_u23.nsg13_hv_pmos[factuo]
print @n.xbgr.xm39_u24.nsg13_hv_pmos[w]
print @n.xbgr.xm39_u24.nsg13_hv_pmos[l]
print @n.xbgr.xm39_u24.nsg13_hv_pmos[delvto]
print @n.xbgr.xm39_u24.nsg13_hv_pmos[factuo]
print @n.xbgr.xm41_u2.nsg13_hv_pmos[w]
print @n.xbgr.xm41_u2.nsg13_hv_pmos[l]
print @n.xbgr.xm41_u2.nsg13_hv_pmos[delvto]
print @n.xbgr.xm41_u2.nsg13_hv_pmos[factuo]
print @n.xbgr.xm41_u3.nsg13_hv_pmos[w]
print @n.xbgr.xm41_u3.nsg13_hv_pmos[l]
print @n.xbgr.xm41_u3.nsg13_hv_pmos[delvto]
print @n.xbgr.xm41_u3.nsg13_hv_pmos[factuo]
print @n.xbgr.xm41_u4.nsg13_hv_pmos[w]
print @n.xbgr.xm41_u4.nsg13_hv_pmos[l]
print @n.xbgr.xm41_u4.nsg13_hv_pmos[delvto]
print @n.xbgr.xm41_u4.nsg13_hv_pmos[factuo]
print @n.xbgr.xm41_u5.nsg13_hv_pmos[w]
print @n.xbgr.xm41_u5.nsg13_hv_pmos[l]
print @n.xbgr.xm41_u5.nsg13_hv_pmos[delvto]
print @n.xbgr.xm41_u5.nsg13_hv_pmos[factuo]
print @n.xbgr.xm41_u6.nsg13_hv_pmos[w]
print @n.xbgr.xm41_u6.nsg13_hv_pmos[l]
print @n.xbgr.xm41_u6.nsg13_hv_pmos[delvto]
print @n.xbgr.xm41_u6.nsg13_hv_pmos[factuo]
print @n.xbgr.xm41_u7.nsg13_hv_pmos[w]
print @n.xbgr.xm41_u7.nsg13_hv_pmos[l]
print @n.xbgr.xm41_u7.nsg13_hv_pmos[delvto]
print @n.xbgr.xm41_u7.nsg13_hv_pmos[factuo]
print @n.xbgr.xm41_u8.nsg13_hv_pmos[w]
print @n.xbgr.xm41_u8.nsg13_hv_pmos[l]
print @n.xbgr.xm41_u8.nsg13_hv_pmos[delvto]
print @n.xbgr.xm41_u8.nsg13_hv_pmos[factuo]
print @n.xbgr.xm41_u9.nsg13_hv_pmos[w]
print @n.xbgr.xm41_u9.nsg13_hv_pmos[l]
print @n.xbgr.xm41_u9.nsg13_hv_pmos[delvto]
print @n.xbgr.xm41_u9.nsg13_hv_pmos[factuo]
print @n.xbgr.xm41_u10.nsg13_hv_pmos[w]
print @n.xbgr.xm41_u10.nsg13_hv_pmos[l]
print @n.xbgr.xm41_u10.nsg13_hv_pmos[delvto]
print @n.xbgr.xm41_u10.nsg13_hv_pmos[factuo]
print @n.xbgr.xm41_u11.nsg13_hv_pmos[w]
print @n.xbgr.xm41_u11.nsg13_hv_pmos[l]
print @n.xbgr.xm41_u11.nsg13_hv_pmos[delvto]
print @n.xbgr.xm41_u11.nsg13_hv_pmos[factuo]
print @n.xbgr.xm41_u12.nsg13_hv_pmos[w]
print @n.xbgr.xm41_u12.nsg13_hv_pmos[l]
print @n.xbgr.xm41_u12.nsg13_hv_pmos[delvto]
print @n.xbgr.xm41_u12.nsg13_hv_pmos[factuo]
print @n.xbgr.xm41_u13.nsg13_hv_pmos[w]
print @n.xbgr.xm41_u13.nsg13_hv_pmos[l]
print @n.xbgr.xm41_u13.nsg13_hv_pmos[delvto]
print @n.xbgr.xm41_u13.nsg13_hv_pmos[factuo]
print @n.xbgr.xm41_u14.nsg13_hv_pmos[w]
print @n.xbgr.xm41_u14.nsg13_hv_pmos[l]
print @n.xbgr.xm41_u14.nsg13_hv_pmos[delvto]
print @n.xbgr.xm41_u14.nsg13_hv_pmos[factuo]
print @n.xbgr.xm41_u15.nsg13_hv_pmos[w]
print @n.xbgr.xm41_u15.nsg13_hv_pmos[l]
print @n.xbgr.xm41_u15.nsg13_hv_pmos[delvto]
print @n.xbgr.xm41_u15.nsg13_hv_pmos[factuo]
print @n.xbgr.xm41_u16.nsg13_hv_pmos[w]
print @n.xbgr.xm41_u16.nsg13_hv_pmos[l]
print @n.xbgr.xm41_u16.nsg13_hv_pmos[delvto]
print @n.xbgr.xm41_u16.nsg13_hv_pmos[factuo]
print @n.xbgr.xm41_u17.nsg13_hv_pmos[w]
print @n.xbgr.xm41_u17.nsg13_hv_pmos[l]
print @n.xbgr.xm41_u17.nsg13_hv_pmos[delvto]
print @n.xbgr.xm41_u17.nsg13_hv_pmos[factuo]
print @n.xbgr.xm41_u18.nsg13_hv_pmos[w]
print @n.xbgr.xm41_u18.nsg13_hv_pmos[l]
print @n.xbgr.xm41_u18.nsg13_hv_pmos[delvto]
print @n.xbgr.xm41_u18.nsg13_hv_pmos[factuo]
print @n.xbgr.xm41_u19.nsg13_hv_pmos[w]
print @n.xbgr.xm41_u19.nsg13_hv_pmos[l]
print @n.xbgr.xm41_u19.nsg13_hv_pmos[delvto]
print @n.xbgr.xm41_u19.nsg13_hv_pmos[factuo]
print @n.xbgr.xm41_u20.nsg13_hv_pmos[w]
print @n.xbgr.xm41_u20.nsg13_hv_pmos[l]
print @n.xbgr.xm41_u20.nsg13_hv_pmos[delvto]
print @n.xbgr.xm41_u20.nsg13_hv_pmos[factuo]
print @n.xbgr.xm41_u21.nsg13_hv_pmos[w]
print @n.xbgr.xm41_u21.nsg13_hv_pmos[l]
print @n.xbgr.xm41_u21.nsg13_hv_pmos[delvto]
print @n.xbgr.xm41_u21.nsg13_hv_pmos[factuo]
print @n.xbgr.xm41_u22.nsg13_hv_pmos[w]
print @n.xbgr.xm41_u22.nsg13_hv_pmos[l]
print @n.xbgr.xm41_u22.nsg13_hv_pmos[delvto]
print @n.xbgr.xm41_u22.nsg13_hv_pmos[factuo]
print @n.xbgr.xm41_u23.nsg13_hv_pmos[w]
print @n.xbgr.xm41_u23.nsg13_hv_pmos[l]
print @n.xbgr.xm41_u23.nsg13_hv_pmos[delvto]
print @n.xbgr.xm41_u23.nsg13_hv_pmos[factuo]
print @n.xbgr.xm41_u24.nsg13_hv_pmos[w]
print @n.xbgr.xm41_u24.nsg13_hv_pmos[l]
print @n.xbgr.xm41_u24.nsg13_hv_pmos[delvto]
print @n.xbgr.xm41_u24.nsg13_hv_pmos[factuo]
print @n.xbgr.xm43_u2.nsg13_hv_pmos[w]
print @n.xbgr.xm43_u2.nsg13_hv_pmos[l]
print @n.xbgr.xm43_u2.nsg13_hv_pmos[delvto]
print @n.xbgr.xm43_u2.nsg13_hv_pmos[factuo]
print @n.xbgr.xm43_u3.nsg13_hv_pmos[w]
print @n.xbgr.xm43_u3.nsg13_hv_pmos[l]
print @n.xbgr.xm43_u3.nsg13_hv_pmos[delvto]
print @n.xbgr.xm43_u3.nsg13_hv_pmos[factuo]
print @n.xbgr.xm43_u4.nsg13_hv_pmos[w]
print @n.xbgr.xm43_u4.nsg13_hv_pmos[l]
print @n.xbgr.xm43_u4.nsg13_hv_pmos[delvto]
print @n.xbgr.xm43_u4.nsg13_hv_pmos[factuo]
print @n.xbgr.xm44_u2.nsg13_hv_pmos[w]
print @n.xbgr.xm44_u2.nsg13_hv_pmos[l]
print @n.xbgr.xm44_u2.nsg13_hv_pmos[delvto]
print @n.xbgr.xm44_u2.nsg13_hv_pmos[factuo]
print @n.xbgr.xm44_u3.nsg13_hv_pmos[w]
print @n.xbgr.xm44_u3.nsg13_hv_pmos[l]
print @n.xbgr.xm44_u3.nsg13_hv_pmos[delvto]
print @n.xbgr.xm44_u3.nsg13_hv_pmos[factuo]
print @n.xbgr.xm44_u4.nsg13_hv_pmos[w]
print @n.xbgr.xm44_u4.nsg13_hv_pmos[l]
print @n.xbgr.xm44_u4.nsg13_hv_pmos[delvto]
print @n.xbgr.xm44_u4.nsg13_hv_pmos[factuo]
print @n.xbgr.xm45_u2.nsg13_hv_pmos[w]
print @n.xbgr.xm45_u2.nsg13_hv_pmos[l]
print @n.xbgr.xm45_u2.nsg13_hv_pmos[delvto]
print @n.xbgr.xm45_u2.nsg13_hv_pmos[factuo]
print @n.xbgr.xm45_u3.nsg13_hv_pmos[w]
print @n.xbgr.xm45_u3.nsg13_hv_pmos[l]
print @n.xbgr.xm45_u3.nsg13_hv_pmos[delvto]
print @n.xbgr.xm45_u3.nsg13_hv_pmos[factuo]
print @n.xbgr.xm45_u4.nsg13_hv_pmos[w]
print @n.xbgr.xm45_u4.nsg13_hv_pmos[l]
print @n.xbgr.xm45_u4.nsg13_hv_pmos[delvto]
print @n.xbgr.xm45_u4.nsg13_hv_pmos[factuo]
print @n.xbgr.xm45_u5.nsg13_hv_pmos[w]
print @n.xbgr.xm45_u5.nsg13_hv_pmos[l]
print @n.xbgr.xm45_u5.nsg13_hv_pmos[delvto]
print @n.xbgr.xm45_u5.nsg13_hv_pmos[factuo]
print @n.xbgr.xm45_u6.nsg13_hv_pmos[w]
print @n.xbgr.xm45_u6.nsg13_hv_pmos[l]
print @n.xbgr.xm45_u6.nsg13_hv_pmos[delvto]
print @n.xbgr.xm45_u6.nsg13_hv_pmos[factuo]
print @n.xbgr.xm45_u7.nsg13_hv_pmos[w]
print @n.xbgr.xm45_u7.nsg13_hv_pmos[l]
print @n.xbgr.xm45_u7.nsg13_hv_pmos[delvto]
print @n.xbgr.xm45_u7.nsg13_hv_pmos[factuo]
print @n.xbgr.xm45_u8.nsg13_hv_pmos[w]
print @n.xbgr.xm45_u8.nsg13_hv_pmos[l]
print @n.xbgr.xm45_u8.nsg13_hv_pmos[delvto]
print @n.xbgr.xm45_u8.nsg13_hv_pmos[factuo]
print @n.xbgr.xm45_u9.nsg13_hv_pmos[w]
print @n.xbgr.xm45_u9.nsg13_hv_pmos[l]
print @n.xbgr.xm45_u9.nsg13_hv_pmos[delvto]
print @n.xbgr.xm45_u9.nsg13_hv_pmos[factuo]
print @n.xbgr.xm45_u10.nsg13_hv_pmos[w]
print @n.xbgr.xm45_u10.nsg13_hv_pmos[l]
print @n.xbgr.xm45_u10.nsg13_hv_pmos[delvto]
print @n.xbgr.xm45_u10.nsg13_hv_pmos[factuo]
print @n.xbgr.xm45_u11.nsg13_hv_pmos[w]
print @n.xbgr.xm45_u11.nsg13_hv_pmos[l]
print @n.xbgr.xm45_u11.nsg13_hv_pmos[delvto]
print @n.xbgr.xm45_u11.nsg13_hv_pmos[factuo]
print @n.xbgr.xm45_u12.nsg13_hv_pmos[w]
print @n.xbgr.xm45_u12.nsg13_hv_pmos[l]
print @n.xbgr.xm45_u12.nsg13_hv_pmos[delvto]
print @n.xbgr.xm45_u12.nsg13_hv_pmos[factuo]
print @n.xbgr.xm45_u13.nsg13_hv_pmos[w]
print @n.xbgr.xm45_u13.nsg13_hv_pmos[l]
print @n.xbgr.xm45_u13.nsg13_hv_pmos[delvto]
print @n.xbgr.xm45_u13.nsg13_hv_pmos[factuo]
print @n.xbgr.xm45_u14.nsg13_hv_pmos[w]
print @n.xbgr.xm45_u14.nsg13_hv_pmos[l]
print @n.xbgr.xm45_u14.nsg13_hv_pmos[delvto]
print @n.xbgr.xm45_u14.nsg13_hv_pmos[factuo]
print @n.xbgr.xm45_u15.nsg13_hv_pmos[w]
print @n.xbgr.xm45_u15.nsg13_hv_pmos[l]
print @n.xbgr.xm45_u15.nsg13_hv_pmos[delvto]
print @n.xbgr.xm45_u15.nsg13_hv_pmos[factuo]
print @n.xbgr.xm45_u16.nsg13_hv_pmos[w]
print @n.xbgr.xm45_u16.nsg13_hv_pmos[l]
print @n.xbgr.xm45_u16.nsg13_hv_pmos[delvto]
print @n.xbgr.xm45_u16.nsg13_hv_pmos[factuo]
print @n.xbgr.xm45_u17.nsg13_hv_pmos[w]
print @n.xbgr.xm45_u17.nsg13_hv_pmos[l]
print @n.xbgr.xm45_u17.nsg13_hv_pmos[delvto]
print @n.xbgr.xm45_u17.nsg13_hv_pmos[factuo]
print @n.xbgr.xm45_u18.nsg13_hv_pmos[w]
print @n.xbgr.xm45_u18.nsg13_hv_pmos[l]
print @n.xbgr.xm45_u18.nsg13_hv_pmos[delvto]
print @n.xbgr.xm45_u18.nsg13_hv_pmos[factuo]
print @n.xbgr.xm45_u19.nsg13_hv_pmos[w]
print @n.xbgr.xm45_u19.nsg13_hv_pmos[l]
print @n.xbgr.xm45_u19.nsg13_hv_pmos[delvto]
print @n.xbgr.xm45_u19.nsg13_hv_pmos[factuo]
print @n.xbgr.xm45_u20.nsg13_hv_pmos[w]
print @n.xbgr.xm45_u20.nsg13_hv_pmos[l]
print @n.xbgr.xm45_u20.nsg13_hv_pmos[delvto]
print @n.xbgr.xm45_u20.nsg13_hv_pmos[factuo]
print @n.xbgr.xm45_u21.nsg13_hv_pmos[w]
print @n.xbgr.xm45_u21.nsg13_hv_pmos[l]
print @n.xbgr.xm45_u21.nsg13_hv_pmos[delvto]
print @n.xbgr.xm45_u21.nsg13_hv_pmos[factuo]
print @n.xbgr.xm45_u22.nsg13_hv_pmos[w]
print @n.xbgr.xm45_u22.nsg13_hv_pmos[l]
print @n.xbgr.xm45_u22.nsg13_hv_pmos[delvto]
print @n.xbgr.xm45_u22.nsg13_hv_pmos[factuo]
print @n.xbgr.xm45_u23.nsg13_hv_pmos[w]
print @n.xbgr.xm45_u23.nsg13_hv_pmos[l]
print @n.xbgr.xm45_u23.nsg13_hv_pmos[delvto]
print @n.xbgr.xm45_u23.nsg13_hv_pmos[factuo]
print @n.xbgr.xm45_u24.nsg13_hv_pmos[w]
print @n.xbgr.xm45_u24.nsg13_hv_pmos[l]
print @n.xbgr.xm45_u24.nsg13_hv_pmos[delvto]
print @n.xbgr.xm45_u24.nsg13_hv_pmos[factuo]
print @n.xbgr.xm47_u2.nsg13_hv_pmos[w]
print @n.xbgr.xm47_u2.nsg13_hv_pmos[l]
print @n.xbgr.xm47_u2.nsg13_hv_pmos[delvto]
print @n.xbgr.xm47_u2.nsg13_hv_pmos[factuo]
print @n.xbgr.xm47_u3.nsg13_hv_pmos[w]
print @n.xbgr.xm47_u3.nsg13_hv_pmos[l]
print @n.xbgr.xm47_u3.nsg13_hv_pmos[delvto]
print @n.xbgr.xm47_u3.nsg13_hv_pmos[factuo]
print @n.xbgr.xm47_u4.nsg13_hv_pmos[w]
print @n.xbgr.xm47_u4.nsg13_hv_pmos[l]
print @n.xbgr.xm47_u4.nsg13_hv_pmos[delvto]
print @n.xbgr.xm47_u4.nsg13_hv_pmos[factuo]
print @n.xbgr.xm47_u5.nsg13_hv_pmos[w]
print @n.xbgr.xm47_u5.nsg13_hv_pmos[l]
print @n.xbgr.xm47_u5.nsg13_hv_pmos[delvto]
print @n.xbgr.xm47_u5.nsg13_hv_pmos[factuo]
print @n.xbgr.xm47_u6.nsg13_hv_pmos[w]
print @n.xbgr.xm47_u6.nsg13_hv_pmos[l]
print @n.xbgr.xm47_u6.nsg13_hv_pmos[delvto]
print @n.xbgr.xm47_u6.nsg13_hv_pmos[factuo]
print @n.xbgr.xm47_u7.nsg13_hv_pmos[w]
print @n.xbgr.xm47_u7.nsg13_hv_pmos[l]
print @n.xbgr.xm47_u7.nsg13_hv_pmos[delvto]
print @n.xbgr.xm47_u7.nsg13_hv_pmos[factuo]
print @n.xbgr.xm47_u8.nsg13_hv_pmos[w]
print @n.xbgr.xm47_u8.nsg13_hv_pmos[l]
print @n.xbgr.xm47_u8.nsg13_hv_pmos[delvto]
print @n.xbgr.xm47_u8.nsg13_hv_pmos[factuo]
print @n.xbgr.xm47_u9.nsg13_hv_pmos[w]
print @n.xbgr.xm47_u9.nsg13_hv_pmos[l]
print @n.xbgr.xm47_u9.nsg13_hv_pmos[delvto]
print @n.xbgr.xm47_u9.nsg13_hv_pmos[factuo]
print @n.xbgr.xm47_u10.nsg13_hv_pmos[w]
print @n.xbgr.xm47_u10.nsg13_hv_pmos[l]
print @n.xbgr.xm47_u10.nsg13_hv_pmos[delvto]
print @n.xbgr.xm47_u10.nsg13_hv_pmos[factuo]
print @n.xbgr.xm47_u11.nsg13_hv_pmos[w]
print @n.xbgr.xm47_u11.nsg13_hv_pmos[l]
print @n.xbgr.xm47_u11.nsg13_hv_pmos[delvto]
print @n.xbgr.xm47_u11.nsg13_hv_pmos[factuo]
print @n.xbgr.xm47_u12.nsg13_hv_pmos[w]
print @n.xbgr.xm47_u12.nsg13_hv_pmos[l]
print @n.xbgr.xm47_u12.nsg13_hv_pmos[delvto]
print @n.xbgr.xm47_u12.nsg13_hv_pmos[factuo]
print @n.xbgr.xm47_u13.nsg13_hv_pmos[w]
print @n.xbgr.xm47_u13.nsg13_hv_pmos[l]
print @n.xbgr.xm47_u13.nsg13_hv_pmos[delvto]
print @n.xbgr.xm47_u13.nsg13_hv_pmos[factuo]
print @n.xbgr.xm47_u14.nsg13_hv_pmos[w]
print @n.xbgr.xm47_u14.nsg13_hv_pmos[l]
print @n.xbgr.xm47_u14.nsg13_hv_pmos[delvto]
print @n.xbgr.xm47_u14.nsg13_hv_pmos[factuo]
print @n.xbgr.xm47_u15.nsg13_hv_pmos[w]
print @n.xbgr.xm47_u15.nsg13_hv_pmos[l]
print @n.xbgr.xm47_u15.nsg13_hv_pmos[delvto]
print @n.xbgr.xm47_u15.nsg13_hv_pmos[factuo]
print @n.xbgr.xm47_u16.nsg13_hv_pmos[w]
print @n.xbgr.xm47_u16.nsg13_hv_pmos[l]
print @n.xbgr.xm47_u16.nsg13_hv_pmos[delvto]
print @n.xbgr.xm47_u16.nsg13_hv_pmos[factuo]
print @n.xbgr.xm47_u17.nsg13_hv_pmos[w]
print @n.xbgr.xm47_u17.nsg13_hv_pmos[l]
print @n.xbgr.xm47_u17.nsg13_hv_pmos[delvto]
print @n.xbgr.xm47_u17.nsg13_hv_pmos[factuo]
print @n.xbgr.xm47_u18.nsg13_hv_pmos[w]
print @n.xbgr.xm47_u18.nsg13_hv_pmos[l]
print @n.xbgr.xm47_u18.nsg13_hv_pmos[delvto]
print @n.xbgr.xm47_u18.nsg13_hv_pmos[factuo]
print @n.xbgr.xm47_u19.nsg13_hv_pmos[w]
print @n.xbgr.xm47_u19.nsg13_hv_pmos[l]
print @n.xbgr.xm47_u19.nsg13_hv_pmos[delvto]
print @n.xbgr.xm47_u19.nsg13_hv_pmos[factuo]
print @n.xbgr.xm47_u20.nsg13_hv_pmos[w]
print @n.xbgr.xm47_u20.nsg13_hv_pmos[l]
print @n.xbgr.xm47_u20.nsg13_hv_pmos[delvto]
print @n.xbgr.xm47_u20.nsg13_hv_pmos[factuo]
print @n.xbgr.xm47_u21.nsg13_hv_pmos[w]
print @n.xbgr.xm47_u21.nsg13_hv_pmos[l]
print @n.xbgr.xm47_u21.nsg13_hv_pmos[delvto]
print @n.xbgr.xm47_u21.nsg13_hv_pmos[factuo]
print @n.xbgr.xm47_u22.nsg13_hv_pmos[w]
print @n.xbgr.xm47_u22.nsg13_hv_pmos[l]
print @n.xbgr.xm47_u22.nsg13_hv_pmos[delvto]
print @n.xbgr.xm47_u22.nsg13_hv_pmos[factuo]
print @n.xbgr.xm47_u23.nsg13_hv_pmos[w]
print @n.xbgr.xm47_u23.nsg13_hv_pmos[l]
print @n.xbgr.xm47_u23.nsg13_hv_pmos[delvto]
print @n.xbgr.xm47_u23.nsg13_hv_pmos[factuo]
print @n.xbgr.xm47_u24.nsg13_hv_pmos[w]
print @n.xbgr.xm47_u24.nsg13_hv_pmos[l]
print @n.xbgr.xm47_u24.nsg13_hv_pmos[delvto]
print @n.xbgr.xm47_u24.nsg13_hv_pmos[factuo]
print @n.xbgr.xm48_u2.nsg13_hv_pmos[w]
print @n.xbgr.xm48_u2.nsg13_hv_pmos[l]
print @n.xbgr.xm48_u2.nsg13_hv_pmos[delvto]
print @n.xbgr.xm48_u2.nsg13_hv_pmos[factuo]
print @n.xbgr.xm48_u3.nsg13_hv_pmos[w]
print @n.xbgr.xm48_u3.nsg13_hv_pmos[l]
print @n.xbgr.xm48_u3.nsg13_hv_pmos[delvto]
print @n.xbgr.xm48_u3.nsg13_hv_pmos[factuo]
print @n.xbgr.xm48_u4.nsg13_hv_pmos[w]
print @n.xbgr.xm48_u4.nsg13_hv_pmos[l]
print @n.xbgr.xm48_u4.nsg13_hv_pmos[delvto]
print @n.xbgr.xm48_u4.nsg13_hv_pmos[factuo]
print @n.xbgr.xm48_u5.nsg13_hv_pmos[w]
print @n.xbgr.xm48_u5.nsg13_hv_pmos[l]
print @n.xbgr.xm48_u5.nsg13_hv_pmos[delvto]
print @n.xbgr.xm48_u5.nsg13_hv_pmos[factuo]
print @n.xbgr.xm48_u6.nsg13_hv_pmos[w]
print @n.xbgr.xm48_u6.nsg13_hv_pmos[l]
print @n.xbgr.xm48_u6.nsg13_hv_pmos[delvto]
print @n.xbgr.xm48_u6.nsg13_hv_pmos[factuo]
print @n.xbgr.xm48_u7.nsg13_hv_pmos[w]
print @n.xbgr.xm48_u7.nsg13_hv_pmos[l]
print @n.xbgr.xm48_u7.nsg13_hv_pmos[delvto]
print @n.xbgr.xm48_u7.nsg13_hv_pmos[factuo]
print @n.xbgr.xm48_u8.nsg13_hv_pmos[w]
print @n.xbgr.xm48_u8.nsg13_hv_pmos[l]
print @n.xbgr.xm48_u8.nsg13_hv_pmos[delvto]
print @n.xbgr.xm48_u8.nsg13_hv_pmos[factuo]
print @n.xbgr.xm48_u9.nsg13_hv_pmos[w]
print @n.xbgr.xm48_u9.nsg13_hv_pmos[l]
print @n.xbgr.xm48_u9.nsg13_hv_pmos[delvto]
print @n.xbgr.xm48_u9.nsg13_hv_pmos[factuo]
print @n.xbgr.xm48_u10.nsg13_hv_pmos[w]
print @n.xbgr.xm48_u10.nsg13_hv_pmos[l]
print @n.xbgr.xm48_u10.nsg13_hv_pmos[delvto]
print @n.xbgr.xm48_u10.nsg13_hv_pmos[factuo]
print @n.xbgr.xm48_u11.nsg13_hv_pmos[w]
print @n.xbgr.xm48_u11.nsg13_hv_pmos[l]
print @n.xbgr.xm48_u11.nsg13_hv_pmos[delvto]
print @n.xbgr.xm48_u11.nsg13_hv_pmos[factuo]
print @n.xbgr.xm48_u12.nsg13_hv_pmos[w]
print @n.xbgr.xm48_u12.nsg13_hv_pmos[l]
print @n.xbgr.xm48_u12.nsg13_hv_pmos[delvto]
print @n.xbgr.xm48_u12.nsg13_hv_pmos[factuo]
print @n.xbgr.xm48_u13.nsg13_hv_pmos[w]
print @n.xbgr.xm48_u13.nsg13_hv_pmos[l]
print @n.xbgr.xm48_u13.nsg13_hv_pmos[delvto]
print @n.xbgr.xm48_u13.nsg13_hv_pmos[factuo]
print @n.xbgr.xm48_u14.nsg13_hv_pmos[w]
print @n.xbgr.xm48_u14.nsg13_hv_pmos[l]
print @n.xbgr.xm48_u14.nsg13_hv_pmos[delvto]
print @n.xbgr.xm48_u14.nsg13_hv_pmos[factuo]
print @n.xbgr.xm48_u15.nsg13_hv_pmos[w]
print @n.xbgr.xm48_u15.nsg13_hv_pmos[l]
print @n.xbgr.xm48_u15.nsg13_hv_pmos[delvto]
print @n.xbgr.xm48_u15.nsg13_hv_pmos[factuo]
print @n.xbgr.xm48_u16.nsg13_hv_pmos[w]
print @n.xbgr.xm48_u16.nsg13_hv_pmos[l]
print @n.xbgr.xm48_u16.nsg13_hv_pmos[delvto]
print @n.xbgr.xm48_u16.nsg13_hv_pmos[factuo]
print @n.xbgr.xm48_u17.nsg13_hv_pmos[w]
print @n.xbgr.xm48_u17.nsg13_hv_pmos[l]
print @n.xbgr.xm48_u17.nsg13_hv_pmos[delvto]
print @n.xbgr.xm48_u17.nsg13_hv_pmos[factuo]
print @n.xbgr.xm48_u18.nsg13_hv_pmos[w]
print @n.xbgr.xm48_u18.nsg13_hv_pmos[l]
print @n.xbgr.xm48_u18.nsg13_hv_pmos[delvto]
print @n.xbgr.xm48_u18.nsg13_hv_pmos[factuo]
print @n.xbgr.xm48_u19.nsg13_hv_pmos[w]
print @n.xbgr.xm48_u19.nsg13_hv_pmos[l]
print @n.xbgr.xm48_u19.nsg13_hv_pmos[delvto]
print @n.xbgr.xm48_u19.nsg13_hv_pmos[factuo]
print @n.xbgr.xm48_u20.nsg13_hv_pmos[w]
print @n.xbgr.xm48_u20.nsg13_hv_pmos[l]
print @n.xbgr.xm48_u20.nsg13_hv_pmos[delvto]
print @n.xbgr.xm48_u20.nsg13_hv_pmos[factuo]
print @n.xbgr.xm48_u21.nsg13_hv_pmos[w]
print @n.xbgr.xm48_u21.nsg13_hv_pmos[l]
print @n.xbgr.xm48_u21.nsg13_hv_pmos[delvto]
print @n.xbgr.xm48_u21.nsg13_hv_pmos[factuo]
print @n.xbgr.xm48_u22.nsg13_hv_pmos[w]
print @n.xbgr.xm48_u22.nsg13_hv_pmos[l]
print @n.xbgr.xm48_u22.nsg13_hv_pmos[delvto]
print @n.xbgr.xm48_u22.nsg13_hv_pmos[factuo]
print @n.xbgr.xm48_u23.nsg13_hv_pmos[w]
print @n.xbgr.xm48_u23.nsg13_hv_pmos[l]
print @n.xbgr.xm48_u23.nsg13_hv_pmos[delvto]
print @n.xbgr.xm48_u23.nsg13_hv_pmos[factuo]
print @n.xbgr.xm48_u24.nsg13_hv_pmos[w]
print @n.xbgr.xm48_u24.nsg13_hv_pmos[l]
print @n.xbgr.xm48_u24.nsg13_hv_pmos[delvto]
print @n.xbgr.xm48_u24.nsg13_hv_pmos[factuo]
print @n.xbgr.xm50_u2.nsg13_hv_pmos[w]
print @n.xbgr.xm50_u2.nsg13_hv_pmos[l]
print @n.xbgr.xm50_u2.nsg13_hv_pmos[delvto]
print @n.xbgr.xm50_u2.nsg13_hv_pmos[factuo]
print @n.xbgr.xm50_u3.nsg13_hv_pmos[w]
print @n.xbgr.xm50_u3.nsg13_hv_pmos[l]
print @n.xbgr.xm50_u3.nsg13_hv_pmos[delvto]
print @n.xbgr.xm50_u3.nsg13_hv_pmos[factuo]
print @n.xbgr.xm50_u4.nsg13_hv_pmos[w]
print @n.xbgr.xm50_u4.nsg13_hv_pmos[l]
print @n.xbgr.xm50_u4.nsg13_hv_pmos[delvto]
print @n.xbgr.xm50_u4.nsg13_hv_pmos[factuo]
print @n.xbgr.xm50_u5.nsg13_hv_pmos[w]
print @n.xbgr.xm50_u5.nsg13_hv_pmos[l]
print @n.xbgr.xm50_u5.nsg13_hv_pmos[delvto]
print @n.xbgr.xm50_u5.nsg13_hv_pmos[factuo]
print @n.xbgr.xm50_u6.nsg13_hv_pmos[w]
print @n.xbgr.xm50_u6.nsg13_hv_pmos[l]
print @n.xbgr.xm50_u6.nsg13_hv_pmos[delvto]
print @n.xbgr.xm50_u6.nsg13_hv_pmos[factuo]
print @n.xbgr.xm50_u7.nsg13_hv_pmos[w]
print @n.xbgr.xm50_u7.nsg13_hv_pmos[l]
print @n.xbgr.xm50_u7.nsg13_hv_pmos[delvto]
print @n.xbgr.xm50_u7.nsg13_hv_pmos[factuo]
print @n.xbgr.xm50_u8.nsg13_hv_pmos[w]
print @n.xbgr.xm50_u8.nsg13_hv_pmos[l]
print @n.xbgr.xm50_u8.nsg13_hv_pmos[delvto]
print @n.xbgr.xm50_u8.nsg13_hv_pmos[factuo]
print @n.xbgr.xm50_u9.nsg13_hv_pmos[w]
print @n.xbgr.xm50_u9.nsg13_hv_pmos[l]
print @n.xbgr.xm50_u9.nsg13_hv_pmos[delvto]
print @n.xbgr.xm50_u9.nsg13_hv_pmos[factuo]
print @n.xbgr.xm50_u10.nsg13_hv_pmos[w]
print @n.xbgr.xm50_u10.nsg13_hv_pmos[l]
print @n.xbgr.xm50_u10.nsg13_hv_pmos[delvto]
print @n.xbgr.xm50_u10.nsg13_hv_pmos[factuo]
print @n.xbgr.xm50_u11.nsg13_hv_pmos[w]
print @n.xbgr.xm50_u11.nsg13_hv_pmos[l]
print @n.xbgr.xm50_u11.nsg13_hv_pmos[delvto]
print @n.xbgr.xm50_u11.nsg13_hv_pmos[factuo]
print @n.xbgr.xm50_u12.nsg13_hv_pmos[w]
print @n.xbgr.xm50_u12.nsg13_hv_pmos[l]
print @n.xbgr.xm50_u12.nsg13_hv_pmos[delvto]
print @n.xbgr.xm50_u12.nsg13_hv_pmos[factuo]
print @n.xbgr.xm50_u13.nsg13_hv_pmos[w]
print @n.xbgr.xm50_u13.nsg13_hv_pmos[l]
print @n.xbgr.xm50_u13.nsg13_hv_pmos[delvto]
print @n.xbgr.xm50_u13.nsg13_hv_pmos[factuo]
print @n.xbgr.xm50_u14.nsg13_hv_pmos[w]
print @n.xbgr.xm50_u14.nsg13_hv_pmos[l]
print @n.xbgr.xm50_u14.nsg13_hv_pmos[delvto]
print @n.xbgr.xm50_u14.nsg13_hv_pmos[factuo]
print @n.xbgr.xm50_u15.nsg13_hv_pmos[w]
print @n.xbgr.xm50_u15.nsg13_hv_pmos[l]
print @n.xbgr.xm50_u15.nsg13_hv_pmos[delvto]
print @n.xbgr.xm50_u15.nsg13_hv_pmos[factuo]
print @n.xbgr.xm50_u16.nsg13_hv_pmos[w]
print @n.xbgr.xm50_u16.nsg13_hv_pmos[l]
print @n.xbgr.xm50_u16.nsg13_hv_pmos[delvto]
print @n.xbgr.xm50_u16.nsg13_hv_pmos[factuo]
print @n.xbgr.xm50_u17.nsg13_hv_pmos[w]
print @n.xbgr.xm50_u17.nsg13_hv_pmos[l]
print @n.xbgr.xm50_u17.nsg13_hv_pmos[delvto]
print @n.xbgr.xm50_u17.nsg13_hv_pmos[factuo]
print @n.xbgr.xm50_u18.nsg13_hv_pmos[w]
print @n.xbgr.xm50_u18.nsg13_hv_pmos[l]
print @n.xbgr.xm50_u18.nsg13_hv_pmos[delvto]
print @n.xbgr.xm50_u18.nsg13_hv_pmos[factuo]
print @n.xbgr.xm50_u19.nsg13_hv_pmos[w]
print @n.xbgr.xm50_u19.nsg13_hv_pmos[l]
print @n.xbgr.xm50_u19.nsg13_hv_pmos[delvto]
print @n.xbgr.xm50_u19.nsg13_hv_pmos[factuo]
print @n.xbgr.xm50_u20.nsg13_hv_pmos[w]
print @n.xbgr.xm50_u20.nsg13_hv_pmos[l]
print @n.xbgr.xm50_u20.nsg13_hv_pmos[delvto]
print @n.xbgr.xm50_u20.nsg13_hv_pmos[factuo]
print @n.xbgr.xm50_u21.nsg13_hv_pmos[w]
print @n.xbgr.xm50_u21.nsg13_hv_pmos[l]
print @n.xbgr.xm50_u21.nsg13_hv_pmos[delvto]
print @n.xbgr.xm50_u21.nsg13_hv_pmos[factuo]
print @n.xbgr.xm50_u22.nsg13_hv_pmos[w]
print @n.xbgr.xm50_u22.nsg13_hv_pmos[l]
print @n.xbgr.xm50_u22.nsg13_hv_pmos[delvto]
print @n.xbgr.xm50_u22.nsg13_hv_pmos[factuo]
print @n.xbgr.xm50_u23.nsg13_hv_pmos[w]
print @n.xbgr.xm50_u23.nsg13_hv_pmos[l]
print @n.xbgr.xm50_u23.nsg13_hv_pmos[delvto]
print @n.xbgr.xm50_u23.nsg13_hv_pmos[factuo]
print @n.xbgr.xm50_u24.nsg13_hv_pmos[w]
print @n.xbgr.xm50_u24.nsg13_hv_pmos[l]
print @n.xbgr.xm50_u24.nsg13_hv_pmos[delvto]
print @n.xbgr.xm50_u24.nsg13_hv_pmos[factuo]
print @n.xbgr.xm51_u2.nsg13_hv_pmos[w]
print @n.xbgr.xm51_u2.nsg13_hv_pmos[l]
print @n.xbgr.xm51_u2.nsg13_hv_pmos[delvto]
print @n.xbgr.xm51_u2.nsg13_hv_pmos[factuo]
print @n.xbgr.xm51_u3.nsg13_hv_pmos[w]
print @n.xbgr.xm51_u3.nsg13_hv_pmos[l]
print @n.xbgr.xm51_u3.nsg13_hv_pmos[delvto]
print @n.xbgr.xm51_u3.nsg13_hv_pmos[factuo]
print @n.xbgr.xm51_u4.nsg13_hv_pmos[w]
print @n.xbgr.xm51_u4.nsg13_hv_pmos[l]
print @n.xbgr.xm51_u4.nsg13_hv_pmos[delvto]
print @n.xbgr.xm51_u4.nsg13_hv_pmos[factuo]
print @n.xbgr.xm52_u2.nsg13_hv_pmos[w]
print @n.xbgr.xm52_u2.nsg13_hv_pmos[l]
print @n.xbgr.xm52_u2.nsg13_hv_pmos[delvto]
print @n.xbgr.xm52_u2.nsg13_hv_pmos[factuo]
print @n.xbgr.xm52_u3.nsg13_hv_pmos[w]
print @n.xbgr.xm52_u3.nsg13_hv_pmos[l]
print @n.xbgr.xm52_u3.nsg13_hv_pmos[delvto]
print @n.xbgr.xm52_u3.nsg13_hv_pmos[factuo]
print @n.xbgr.xm52_u4.nsg13_hv_pmos[w]
print @n.xbgr.xm52_u4.nsg13_hv_pmos[l]
print @n.xbgr.xm52_u4.nsg13_hv_pmos[delvto]
print @n.xbgr.xm52_u4.nsg13_hv_pmos[factuo]
print @n.xbgr.xm52_u5.nsg13_hv_pmos[w]
print @n.xbgr.xm52_u5.nsg13_hv_pmos[l]
print @n.xbgr.xm52_u5.nsg13_hv_pmos[delvto]
print @n.xbgr.xm52_u5.nsg13_hv_pmos[factuo]
print @n.xbgr.xm52_u6.nsg13_hv_pmos[w]
print @n.xbgr.xm52_u6.nsg13_hv_pmos[l]
print @n.xbgr.xm52_u6.nsg13_hv_pmos[delvto]
print @n.xbgr.xm52_u6.nsg13_hv_pmos[factuo]
print @n.xbgr.xm52_u7.nsg13_hv_pmos[w]
print @n.xbgr.xm52_u7.nsg13_hv_pmos[l]
print @n.xbgr.xm52_u7.nsg13_hv_pmos[delvto]
print @n.xbgr.xm52_u7.nsg13_hv_pmos[factuo]
print @n.xbgr.xm52_u8.nsg13_hv_pmos[w]
print @n.xbgr.xm52_u8.nsg13_hv_pmos[l]
print @n.xbgr.xm52_u8.nsg13_hv_pmos[delvto]
print @n.xbgr.xm52_u8.nsg13_hv_pmos[factuo]
print @n.xbgr.xm52_u9.nsg13_hv_pmos[w]
print @n.xbgr.xm52_u9.nsg13_hv_pmos[l]
print @n.xbgr.xm52_u9.nsg13_hv_pmos[delvto]
print @n.xbgr.xm52_u9.nsg13_hv_pmos[factuo]
print @n.xbgr.xm52_u10.nsg13_hv_pmos[w]
print @n.xbgr.xm52_u10.nsg13_hv_pmos[l]
print @n.xbgr.xm52_u10.nsg13_hv_pmos[delvto]
print @n.xbgr.xm52_u10.nsg13_hv_pmos[factuo]
print @n.xbgr.xm52_u11.nsg13_hv_pmos[w]
print @n.xbgr.xm52_u11.nsg13_hv_pmos[l]
print @n.xbgr.xm52_u11.nsg13_hv_pmos[delvto]
print @n.xbgr.xm52_u11.nsg13_hv_pmos[factuo]
print @n.xbgr.xm52_u12.nsg13_hv_pmos[w]
print @n.xbgr.xm52_u12.nsg13_hv_pmos[l]
print @n.xbgr.xm52_u12.nsg13_hv_pmos[delvto]
print @n.xbgr.xm52_u12.nsg13_hv_pmos[factuo]
print @n.xbgr.xm52_u13.nsg13_hv_pmos[w]
print @n.xbgr.xm52_u13.nsg13_hv_pmos[l]
print @n.xbgr.xm52_u13.nsg13_hv_pmos[delvto]
print @n.xbgr.xm52_u13.nsg13_hv_pmos[factuo]
print @n.xbgr.xm52_u14.nsg13_hv_pmos[w]
print @n.xbgr.xm52_u14.nsg13_hv_pmos[l]
print @n.xbgr.xm52_u14.nsg13_hv_pmos[delvto]
print @n.xbgr.xm52_u14.nsg13_hv_pmos[factuo]
print @n.xbgr.xm52_u15.nsg13_hv_pmos[w]
print @n.xbgr.xm52_u15.nsg13_hv_pmos[l]
print @n.xbgr.xm52_u15.nsg13_hv_pmos[delvto]
print @n.xbgr.xm52_u15.nsg13_hv_pmos[factuo]
print @n.xbgr.xm52_u16.nsg13_hv_pmos[w]
print @n.xbgr.xm52_u16.nsg13_hv_pmos[l]
print @n.xbgr.xm52_u16.nsg13_hv_pmos[delvto]
print @n.xbgr.xm52_u16.nsg13_hv_pmos[factuo]
print @n.xbgr.xm52_u17.nsg13_hv_pmos[w]
print @n.xbgr.xm52_u17.nsg13_hv_pmos[l]
print @n.xbgr.xm52_u17.nsg13_hv_pmos[delvto]
print @n.xbgr.xm52_u17.nsg13_hv_pmos[factuo]
print @n.xbgr.xm52_u18.nsg13_hv_pmos[w]
print @n.xbgr.xm52_u18.nsg13_hv_pmos[l]
print @n.xbgr.xm52_u18.nsg13_hv_pmos[delvto]
print @n.xbgr.xm52_u18.nsg13_hv_pmos[factuo]
print @n.xbgr.xm52_u19.nsg13_hv_pmos[w]
print @n.xbgr.xm52_u19.nsg13_hv_pmos[l]
print @n.xbgr.xm52_u19.nsg13_hv_pmos[delvto]
print @n.xbgr.xm52_u19.nsg13_hv_pmos[factuo]
print @n.xbgr.xm52_u20.nsg13_hv_pmos[w]
print @n.xbgr.xm52_u20.nsg13_hv_pmos[l]
print @n.xbgr.xm52_u20.nsg13_hv_pmos[delvto]
print @n.xbgr.xm52_u20.nsg13_hv_pmos[factuo]
print @n.xbgr.xm52_u21.nsg13_hv_pmos[w]
print @n.xbgr.xm52_u21.nsg13_hv_pmos[l]
print @n.xbgr.xm52_u21.nsg13_hv_pmos[delvto]
print @n.xbgr.xm52_u21.nsg13_hv_pmos[factuo]
print @n.xbgr.xm52_u22.nsg13_hv_pmos[w]
print @n.xbgr.xm52_u22.nsg13_hv_pmos[l]
print @n.xbgr.xm52_u22.nsg13_hv_pmos[delvto]
print @n.xbgr.xm52_u22.nsg13_hv_pmos[factuo]
print @n.xbgr.xm52_u23.nsg13_hv_pmos[w]
print @n.xbgr.xm52_u23.nsg13_hv_pmos[l]
print @n.xbgr.xm52_u23.nsg13_hv_pmos[delvto]
print @n.xbgr.xm52_u23.nsg13_hv_pmos[factuo]
print @n.xbgr.xm52_u24.nsg13_hv_pmos[w]
print @n.xbgr.xm52_u24.nsg13_hv_pmos[l]
print @n.xbgr.xm52_u24.nsg13_hv_pmos[delvto]
print @n.xbgr.xm52_u24.nsg13_hv_pmos[factuo]
print @n.xbgr.xm54_u2.nsg13_hv_pmos[w]
print @n.xbgr.xm54_u2.nsg13_hv_pmos[l]
print @n.xbgr.xm54_u2.nsg13_hv_pmos[delvto]
print @n.xbgr.xm54_u2.nsg13_hv_pmos[factuo]
print @n.xbgr.xm54_u3.nsg13_hv_pmos[w]
print @n.xbgr.xm54_u3.nsg13_hv_pmos[l]
print @n.xbgr.xm54_u3.nsg13_hv_pmos[delvto]
print @n.xbgr.xm54_u3.nsg13_hv_pmos[factuo]
print @n.xbgr.xm54_u4.nsg13_hv_pmos[w]
print @n.xbgr.xm54_u4.nsg13_hv_pmos[l]
print @n.xbgr.xm54_u4.nsg13_hv_pmos[delvto]
print @n.xbgr.xm54_u4.nsg13_hv_pmos[factuo]
print @n.xbgr.xm54_u5.nsg13_hv_pmos[w]
print @n.xbgr.xm54_u5.nsg13_hv_pmos[l]
print @n.xbgr.xm54_u5.nsg13_hv_pmos[delvto]
print @n.xbgr.xm54_u5.nsg13_hv_pmos[factuo]
print @n.xbgr.xm54_u6.nsg13_hv_pmos[w]
print @n.xbgr.xm54_u6.nsg13_hv_pmos[l]
print @n.xbgr.xm54_u6.nsg13_hv_pmos[delvto]
print @n.xbgr.xm54_u6.nsg13_hv_pmos[factuo]
print @n.xbgr.xm54_u7.nsg13_hv_pmos[w]
print @n.xbgr.xm54_u7.nsg13_hv_pmos[l]
print @n.xbgr.xm54_u7.nsg13_hv_pmos[delvto]
print @n.xbgr.xm54_u7.nsg13_hv_pmos[factuo]
print @n.xbgr.xm54_u8.nsg13_hv_pmos[w]
print @n.xbgr.xm54_u8.nsg13_hv_pmos[l]
print @n.xbgr.xm54_u8.nsg13_hv_pmos[delvto]
print @n.xbgr.xm54_u8.nsg13_hv_pmos[factuo]
print @n.xbgr.xm54_u9.nsg13_hv_pmos[w]
print @n.xbgr.xm54_u9.nsg13_hv_pmos[l]
print @n.xbgr.xm54_u9.nsg13_hv_pmos[delvto]
print @n.xbgr.xm54_u9.nsg13_hv_pmos[factuo]
print @n.xbgr.xm54_u10.nsg13_hv_pmos[w]
print @n.xbgr.xm54_u10.nsg13_hv_pmos[l]
print @n.xbgr.xm54_u10.nsg13_hv_pmos[delvto]
print @n.xbgr.xm54_u10.nsg13_hv_pmos[factuo]
print @n.xbgr.xm54_u11.nsg13_hv_pmos[w]
print @n.xbgr.xm54_u11.nsg13_hv_pmos[l]
print @n.xbgr.xm54_u11.nsg13_hv_pmos[delvto]
print @n.xbgr.xm54_u11.nsg13_hv_pmos[factuo]
print @n.xbgr.xm54_u12.nsg13_hv_pmos[w]
print @n.xbgr.xm54_u12.nsg13_hv_pmos[l]
print @n.xbgr.xm54_u12.nsg13_hv_pmos[delvto]
print @n.xbgr.xm54_u12.nsg13_hv_pmos[factuo]
print @n.xbgr.xm54_u13.nsg13_hv_pmos[w]
print @n.xbgr.xm54_u13.nsg13_hv_pmos[l]
print @n.xbgr.xm54_u13.nsg13_hv_pmos[delvto]
print @n.xbgr.xm54_u13.nsg13_hv_pmos[factuo]
print @n.xbgr.xm54_u14.nsg13_hv_pmos[w]
print @n.xbgr.xm54_u14.nsg13_hv_pmos[l]
print @n.xbgr.xm54_u14.nsg13_hv_pmos[delvto]
print @n.xbgr.xm54_u14.nsg13_hv_pmos[factuo]
print @n.xbgr.xm54_u15.nsg13_hv_pmos[w]
print @n.xbgr.xm54_u15.nsg13_hv_pmos[l]
print @n.xbgr.xm54_u15.nsg13_hv_pmos[delvto]
print @n.xbgr.xm54_u15.nsg13_hv_pmos[factuo]
print @n.xbgr.xm54_u16.nsg13_hv_pmos[w]
print @n.xbgr.xm54_u16.nsg13_hv_pmos[l]
print @n.xbgr.xm54_u16.nsg13_hv_pmos[delvto]
print @n.xbgr.xm54_u16.nsg13_hv_pmos[factuo]
print @n.xbgr.xm54_u17.nsg13_hv_pmos[w]
print @n.xbgr.xm54_u17.nsg13_hv_pmos[l]
print @n.xbgr.xm54_u17.nsg13_hv_pmos[delvto]
print @n.xbgr.xm54_u17.nsg13_hv_pmos[factuo]
print @n.xbgr.xm54_u18.nsg13_hv_pmos[w]
print @n.xbgr.xm54_u18.nsg13_hv_pmos[l]
print @n.xbgr.xm54_u18.nsg13_hv_pmos[delvto]
print @n.xbgr.xm54_u18.nsg13_hv_pmos[factuo]
print @n.xbgr.xm54_u19.nsg13_hv_pmos[w]
print @n.xbgr.xm54_u19.nsg13_hv_pmos[l]
print @n.xbgr.xm54_u19.nsg13_hv_pmos[delvto]
print @n.xbgr.xm54_u19.nsg13_hv_pmos[factuo]
print @n.xbgr.xm54_u20.nsg13_hv_pmos[w]
print @n.xbgr.xm54_u20.nsg13_hv_pmos[l]
print @n.xbgr.xm54_u20.nsg13_hv_pmos[delvto]
print @n.xbgr.xm54_u20.nsg13_hv_pmos[factuo]
print @n.xbgr.xm54_u21.nsg13_hv_pmos[w]
print @n.xbgr.xm54_u21.nsg13_hv_pmos[l]
print @n.xbgr.xm54_u21.nsg13_hv_pmos[delvto]
print @n.xbgr.xm54_u21.nsg13_hv_pmos[factuo]
print @n.xbgr.xm54_u22.nsg13_hv_pmos[w]
print @n.xbgr.xm54_u22.nsg13_hv_pmos[l]
print @n.xbgr.xm54_u22.nsg13_hv_pmos[delvto]
print @n.xbgr.xm54_u22.nsg13_hv_pmos[factuo]
print @n.xbgr.xm54_u23.nsg13_hv_pmos[w]
print @n.xbgr.xm54_u23.nsg13_hv_pmos[l]
print @n.xbgr.xm54_u23.nsg13_hv_pmos[delvto]
print @n.xbgr.xm54_u23.nsg13_hv_pmos[factuo]
print @n.xbgr.xm54_u24.nsg13_hv_pmos[w]
print @n.xbgr.xm54_u24.nsg13_hv_pmos[l]
print @n.xbgr.xm54_u24.nsg13_hv_pmos[delvto]
print @n.xbgr.xm54_u24.nsg13_hv_pmos[factuo]
print @q.xbgr.xq56_u2.qnpn13g2[area]
print @q.xbgr.xq56_u3.qnpn13g2[area]
print @q.xbgr.xq56_u4.qnpn13g2[area]
print @q.xbgr.xq56_u5.qnpn13g2[area]
print @q.xbgr.xq56_u6.qnpn13g2[area]
print @q.xbgr.xq56_u7.qnpn13g2[area]
print @q.xbgr.xq56_u8.qnpn13g2[area]
print @q.xbgr.xq56_u9.qnpn13g2[area]
print @q.xbgr.xq56_u10.qnpn13g2[area]
print @q.xbgr.xq56_u11.qnpn13g2[area]
print @q.xbgr.xq56_u12.qnpn13g2[area]
print @q.xbgr.xq56_u13.qnpn13g2[area]
print @q.xbgr.xq56_u14.qnpn13g2[area]
print @q.xbgr.xq56_u15.qnpn13g2[area]
print @q.xbgr.xq56_u16.qnpn13g2[area]
print @q.xbgr.xq56_u17.qnpn13g2[area]
print @q.xbgr.xq56_u18.qnpn13g2[area]
print @q.xbgr.xq56_u19.qnpn13g2[area]
print @q.xbgr.xq56_u20.qnpn13g2[area]
print @q.xbgr.xq56_u21.qnpn13g2[area]
print @q.xbgr.xq56_u22.qnpn13g2[area]
print @q.xbgr.xq56_u23.qnpn13g2[area]
print @q.xbgr.xq56_u24.qnpn13g2[area]
print @q.xbgr.xq60_u2.qnpn13g2[area]
print @q.xbgr.xq60_u3.qnpn13g2[area]
print @q.xbgr.xq60_u4.qnpn13g2[area]
print @q.xbgr.xq62_u2.qnpn13g2[area]
print @q.xbgr.xq62_u3.qnpn13g2[area]
print @q.xbgr.xq62_u4.qnpn13g2[area]
print @q.xbgr.xq62_u5.qnpn13g2[area]
print @q.xbgr.xq62_u6.qnpn13g2[area]
print @q.xbgr.xq62_u7.qnpn13g2[area]
print @q.xbgr.xq62_u8.qnpn13g2[area]
print @q.xbgr.xq62_u9.qnpn13g2[area]
print @q.xbgr.xq62_u10.qnpn13g2[area]
print @q.xbgr.xq62_u11.qnpn13g2[area]
print @q.xbgr.xq62_u12.qnpn13g2[area]
print @q.xbgr.xq62_u13.qnpn13g2[area]
print @q.xbgr.xq62_u14.qnpn13g2[area]
print @q.xbgr.xq62_u15.qnpn13g2[area]
print @q.xbgr.xq62_u16.qnpn13g2[area]
print @q.xbgr.xq62_u17.qnpn13g2[area]
print @q.xbgr.xq62_u18.qnpn13g2[area]
print @q.xbgr.xq62_u19.qnpn13g2[area]
print @q.xbgr.xq62_u20.qnpn13g2[area]
print @q.xbgr.xq62_u21.qnpn13g2[area]
print @q.xbgr.xq62_u22.qnpn13g2[area]
print @q.xbgr.xq62_u23.qnpn13g2[area]
print @q.xbgr.xq62_u24.qnpn13g2[area]
print @q.xbgr.xq67_u2.qnpn13g2[area]
print @q.xbgr.xq67_u3.qnpn13g2[area]
print @q.xbgr.xq67_u4.qnpn13g2[area]
print @q.xbgr.xq67_u5.qnpn13g2[area]
print @q.xbgr.xq67_u6.qnpn13g2[area]
print @q.xbgr.xq67_u7.qnpn13g2[area]
print @q.xbgr.xq67_u8.qnpn13g2[area]
print @q.xbgr.xq67_u9.qnpn13g2[area]
print @q.xbgr.xq67_u10.qnpn13g2[area]
print @q.xbgr.xq67_u11.qnpn13g2[area]
print @q.xbgr.xq67_u12.qnpn13g2[area]
print @q.xbgr.xq67_u13.qnpn13g2[area]
print @q.xbgr.xq67_u14.qnpn13g2[area]
print @q.xbgr.xq67_u15.qnpn13g2[area]
print @q.xbgr.xq67_u16.qnpn13g2[area]
print @q.xbgr.xq67_u17.qnpn13g2[area]
print @q.xbgr.xq67_u18.qnpn13g2[area]
print @q.xbgr.xq67_u19.qnpn13g2[area]
print @q.xbgr.xq67_u20.qnpn13g2[area]
print @q.xbgr.xq67_u21.qnpn13g2[area]
print @q.xbgr.xq67_u22.qnpn13g2[area]
print @q.xbgr.xq67_u23.qnpn13g2[area]
print @q.xbgr.xq67_u24.qnpn13g2[area]
print @q.xbgr.xq68_u2.qnpn13g2[area]
print @q.xbgr.xq68_u3.qnpn13g2[area]
print @q.xbgr.xq68_u4.qnpn13g2[area]
print @q.xbgr.xq68_u5.qnpn13g2[area]
print @q.xbgr.xq68_u6.qnpn13g2[area]
print @q.xbgr.xq68_u7.qnpn13g2[area]
print @q.xbgr.xq68_u8.qnpn13g2[area]
print @q.xbgr.xq68_u9.qnpn13g2[area]
print @q.xbgr.xq68_u10.qnpn13g2[area]
print @q.xbgr.xq68_u11.qnpn13g2[area]
print @q.xbgr.xq68_u12.qnpn13g2[area]
print @q.xbgr.xq68_u13.qnpn13g2[area]
print @q.xbgr.xq68_u14.qnpn13g2[area]
print @q.xbgr.xq68_u15.qnpn13g2[area]
print @q.xbgr.xq68_u16.qnpn13g2[area]
print @q.xbgr.xq68_u17.qnpn13g2[area]
print @q.xbgr.xq68_u18.qnpn13g2[area]
print @q.xbgr.xq68_u19.qnpn13g2[area]
print @q.xbgr.xq68_u20.qnpn13g2[area]
print @q.xbgr.xq68_u21.qnpn13g2[area]
print @q.xbgr.xq68_u22.qnpn13g2[area]
print @q.xbgr.xq68_u23.qnpn13g2[area]
print @q.xbgr.xq68_u24.qnpn13g2[area]
print @q.xbgr.xq69_u2.qnpn13g2[area]
print @q.xbgr.xq69_u3.qnpn13g2[area]
print @q.xbgr.xq69_u4.qnpn13g2[area]
print @q.xbgr.xq69_u5.qnpn13g2[area]
print @q.xbgr.xq69_u6.qnpn13g2[area]
print @q.xbgr.xq69_u7.qnpn13g2[area]
print @q.xbgr.xq69_u8.qnpn13g2[area]
print @q.xbgr.xq69_u9.qnpn13g2[area]
print @q.xbgr.xq69_u10.qnpn13g2[area]
print @q.xbgr.xq69_u11.qnpn13g2[area]
print @q.xbgr.xq69_u12.qnpn13g2[area]
print @q.xbgr.xq69_u13.qnpn13g2[area]
print @q.xbgr.xq69_u14.qnpn13g2[area]
print @q.xbgr.xq69_u15.qnpn13g2[area]
print @q.xbgr.xq69_u16.qnpn13g2[area]
print @q.xbgr.xq69_u17.qnpn13g2[area]
print @q.xbgr.xq69_u18.qnpn13g2[area]
print @q.xbgr.xq69_u19.qnpn13g2[area]
print @q.xbgr.xq69_u20.qnpn13g2[area]
print @q.xbgr.xq69_u21.qnpn13g2[area]
print @q.xbgr.xq69_u22.qnpn13g2[area]
print @q.xbgr.xq69_u23.qnpn13g2[area]
print @q.xbgr.xq69_u24.qnpn13g2[area]
print @q.xbgr.xq70_u2.qnpn13g2[area]
print @q.xbgr.xq70_u3.qnpn13g2[area]
print @q.xbgr.xq70_u4.qnpn13g2[area]
print @q.xbgr.xq70_u5.qnpn13g2[area]
print @q.xbgr.xq70_u6.qnpn13g2[area]
print @q.xbgr.xq70_u7.qnpn13g2[area]
print @q.xbgr.xq70_u8.qnpn13g2[area]
print @q.xbgr.xq70_u9.qnpn13g2[area]
print @q.xbgr.xq70_u10.qnpn13g2[area]
print @q.xbgr.xq70_u11.qnpn13g2[area]
print @q.xbgr.xq70_u12.qnpn13g2[area]
print @q.xbgr.xq70_u13.qnpn13g2[area]
print @q.xbgr.xq70_u14.qnpn13g2[area]
print @q.xbgr.xq70_u15.qnpn13g2[area]
print @q.xbgr.xq70_u16.qnpn13g2[area]
print @q.xbgr.xq70_u17.qnpn13g2[area]
print @q.xbgr.xq70_u18.qnpn13g2[area]
print @q.xbgr.xq70_u19.qnpn13g2[area]
print @q.xbgr.xq70_u20.qnpn13g2[area]
print @q.xbgr.xq70_u21.qnpn13g2[area]
print @q.xbgr.xq70_u22.qnpn13g2[area]
print @q.xbgr.xq70_u23.qnpn13g2[area]
print @q.xbgr.xq70_u24.qnpn13g2[area]
print @q.xbgr.xq71_u2.qnpn13g2[area]
print @q.xbgr.xq71_u3.qnpn13g2[area]
print @q.xbgr.xq71_u4.qnpn13g2[area]
print @q.xbgr.xq71_u5.qnpn13g2[area]
print @q.xbgr.xq71_u6.qnpn13g2[area]
print @q.xbgr.xq71_u7.qnpn13g2[area]
print @q.xbgr.xq71_u8.qnpn13g2[area]
print @q.xbgr.xq71_u9.qnpn13g2[area]
print @q.xbgr.xq71_u10.qnpn13g2[area]
print @q.xbgr.xq71_u11.qnpn13g2[area]
print @q.xbgr.xq71_u12.qnpn13g2[area]
print @q.xbgr.xq71_u13.qnpn13g2[area]
print @q.xbgr.xq71_u14.qnpn13g2[area]
print @q.xbgr.xq71_u15.qnpn13g2[area]
print @q.xbgr.xq71_u16.qnpn13g2[area]
print @q.xbgr.xq71_u17.qnpn13g2[area]
print @q.xbgr.xq71_u18.qnpn13g2[area]
print @q.xbgr.xq71_u19.qnpn13g2[area]
print @q.xbgr.xq71_u20.qnpn13g2[area]
print @q.xbgr.xq71_u21.qnpn13g2[area]
print @q.xbgr.xq71_u22.qnpn13g2[area]
print @q.xbgr.xq71_u23.qnpn13g2[area]
print @q.xbgr.xq71_u24.qnpn13g2[area]
print @q.xbgr.xq72_u2.qnpn13g2[area]
print @q.xbgr.xq72_u3.qnpn13g2[area]
print @q.xbgr.xq72_u4.qnpn13g2[area]
print @q.xbgr.xq72_u5.qnpn13g2[area]
print @q.xbgr.xq72_u6.qnpn13g2[area]
print @q.xbgr.xq72_u7.qnpn13g2[area]
print @q.xbgr.xq72_u8.qnpn13g2[area]
print @q.xbgr.xq72_u9.qnpn13g2[area]
print @q.xbgr.xq72_u10.qnpn13g2[area]
print @q.xbgr.xq72_u11.qnpn13g2[area]
print @q.xbgr.xq72_u12.qnpn13g2[area]
print @q.xbgr.xq72_u13.qnpn13g2[area]
print @q.xbgr.xq72_u14.qnpn13g2[area]
print @q.xbgr.xq72_u15.qnpn13g2[area]
print @q.xbgr.xq72_u16.qnpn13g2[area]
print @q.xbgr.xq72_u17.qnpn13g2[area]
print @q.xbgr.xq72_u18.qnpn13g2[area]
print @q.xbgr.xq72_u19.qnpn13g2[area]
print @q.xbgr.xq72_u20.qnpn13g2[area]
print @q.xbgr.xq72_u21.qnpn13g2[area]
print @q.xbgr.xq72_u22.qnpn13g2[area]
print @q.xbgr.xq72_u23.qnpn13g2[area]
print @q.xbgr.xq72_u24.qnpn13g2[area]
print @q.xbgr.xq73_u2.qnpn13g2[area]
print @q.xbgr.xq73_u3.qnpn13g2[area]
print @q.xbgr.xq73_u4.qnpn13g2[area]
print @q.xbgr.xq73_u5.qnpn13g2[area]
print @q.xbgr.xq73_u6.qnpn13g2[area]
print @q.xbgr.xq73_u7.qnpn13g2[area]
print @q.xbgr.xq73_u8.qnpn13g2[area]
print @q.xbgr.xq73_u9.qnpn13g2[area]
print @q.xbgr.xq73_u10.qnpn13g2[area]
print @q.xbgr.xq73_u11.qnpn13g2[area]
print @q.xbgr.xq73_u12.qnpn13g2[area]
print @q.xbgr.xq73_u13.qnpn13g2[area]
print @q.xbgr.xq73_u14.qnpn13g2[area]
print @q.xbgr.xq73_u15.qnpn13g2[area]
print @q.xbgr.xq73_u16.qnpn13g2[area]
print @q.xbgr.xq73_u17.qnpn13g2[area]
print @q.xbgr.xq73_u18.qnpn13g2[area]
print @q.xbgr.xq73_u19.qnpn13g2[area]
print @q.xbgr.xq73_u20.qnpn13g2[area]
print @q.xbgr.xq73_u21.qnpn13g2[area]
print @q.xbgr.xq73_u22.qnpn13g2[area]
print @q.xbgr.xq73_u23.qnpn13g2[area]
print @q.xbgr.xq73_u24.qnpn13g2[area]
print @q.xbgr.xq74_u2.qnpn13g2[area]
print @q.xbgr.xq74_u3.qnpn13g2[area]
print @q.xbgr.xq74_u4.qnpn13g2[area]
print @q.xbgr.xq74_u5.qnpn13g2[area]
print @q.xbgr.xq74_u6.qnpn13g2[area]
print @q.xbgr.xq74_u7.qnpn13g2[area]
print @q.xbgr.xq74_u8.qnpn13g2[area]
print @q.xbgr.xq74_u9.qnpn13g2[area]
print @q.xbgr.xq74_u10.qnpn13g2[area]
print @q.xbgr.xq74_u11.qnpn13g2[area]
print @q.xbgr.xq74_u12.qnpn13g2[area]
print @q.xbgr.xq74_u13.qnpn13g2[area]
print @q.xbgr.xq74_u14.qnpn13g2[area]
print @q.xbgr.xq74_u15.qnpn13g2[area]
print @q.xbgr.xq74_u16.qnpn13g2[area]
print @q.xbgr.xq74_u17.qnpn13g2[area]
print @q.xbgr.xq74_u18.qnpn13g2[area]
print @q.xbgr.xq74_u19.qnpn13g2[area]
print @q.xbgr.xq74_u20.qnpn13g2[area]
print @q.xbgr.xq74_u21.qnpn13g2[area]
print @q.xbgr.xq74_u22.qnpn13g2[area]
print @q.xbgr.xq74_u23.qnpn13g2[area]
print @q.xbgr.xq74_u24.qnpn13g2[area]
print @q.xbgr.xq75_u2.qnpn13g2[area]
print @q.xbgr.xq75_u3.qnpn13g2[area]
print @q.xbgr.xq75_u4.qnpn13g2[area]
print @q.xbgr.xq75_u5.qnpn13g2[area]
print @q.xbgr.xq75_u6.qnpn13g2[area]
print @q.xbgr.xq75_u7.qnpn13g2[area]
print @q.xbgr.xq75_u8.qnpn13g2[area]
print @q.xbgr.xq75_u9.qnpn13g2[area]
print @q.xbgr.xq75_u10.qnpn13g2[area]
print @q.xbgr.xq75_u11.qnpn13g2[area]
print @q.xbgr.xq75_u12.qnpn13g2[area]
print @q.xbgr.xq75_u13.qnpn13g2[area]
print @q.xbgr.xq75_u14.qnpn13g2[area]
print @q.xbgr.xq75_u15.qnpn13g2[area]
print @q.xbgr.xq75_u16.qnpn13g2[area]
print @q.xbgr.xq75_u17.qnpn13g2[area]
print @q.xbgr.xq75_u18.qnpn13g2[area]
print @q.xbgr.xq75_u19.qnpn13g2[area]
print @q.xbgr.xq75_u20.qnpn13g2[area]
print @q.xbgr.xq75_u21.qnpn13g2[area]
print @q.xbgr.xq75_u22.qnpn13g2[area]
print @q.xbgr.xq75_u23.qnpn13g2[area]
print @q.xbgr.xq75_u24.qnpn13g2[area]
print @q.xbgr.xq76_u2.qnpn13g2[area]
print @q.xbgr.xq76_u3.qnpn13g2[area]
print @q.xbgr.xq76_u4.qnpn13g2[area]
print @q.xbgr.xq76_u5.qnpn13g2[area]
print @q.xbgr.xq76_u6.qnpn13g2[area]
print @q.xbgr.xq76_u7.qnpn13g2[area]
print @q.xbgr.xq76_u8.qnpn13g2[area]
print @q.xbgr.xq76_u9.qnpn13g2[area]
print @q.xbgr.xq76_u10.qnpn13g2[area]
print @q.xbgr.xq76_u11.qnpn13g2[area]
print @q.xbgr.xq76_u12.qnpn13g2[area]
print @q.xbgr.xq76_u13.qnpn13g2[area]
print @q.xbgr.xq76_u14.qnpn13g2[area]
print @q.xbgr.xq76_u15.qnpn13g2[area]
print @q.xbgr.xq76_u16.qnpn13g2[area]
print @q.xbgr.xq76_u17.qnpn13g2[area]
print @q.xbgr.xq76_u18.qnpn13g2[area]
print @q.xbgr.xq76_u19.qnpn13g2[area]
print @q.xbgr.xq76_u20.qnpn13g2[area]
print @q.xbgr.xq76_u21.qnpn13g2[area]
print @q.xbgr.xq76_u22.qnpn13g2[area]
print @q.xbgr.xq76_u23.qnpn13g2[area]
print @q.xbgr.xq76_u24.qnpn13g2[area]
print @n.xbgr.xr77_u2.nr1[nsmm_rsh]
print @n.xbgr.xr77_u2.nr1[nsmm_w]
print @n.xbgr.xr77_u2.nr1[nsmm_l]
print @n.xbgr.xr77_u3.nr1[nsmm_rsh]
print @n.xbgr.xr77_u3.nr1[nsmm_w]
print @n.xbgr.xr77_u3.nr1[nsmm_l]
print @n.xbgr.xr77_u4.nr1[nsmm_rsh]
print @n.xbgr.xr77_u4.nr1[nsmm_w]
print @n.xbgr.xr77_u4.nr1[nsmm_l]
print @n.xbgr.xr77_u5.nr1[nsmm_rsh]
print @n.xbgr.xr77_u5.nr1[nsmm_w]
print @n.xbgr.xr77_u5.nr1[nsmm_l]
print @n.xbgr.xr77_u6.nr1[nsmm_rsh]
print @n.xbgr.xr77_u6.nr1[nsmm_w]
print @n.xbgr.xr77_u6.nr1[nsmm_l]
print @n.xbgr.xr77_u7.nr1[nsmm_rsh]
print @n.xbgr.xr77_u7.nr1[nsmm_w]
print @n.xbgr.xr77_u7.nr1[nsmm_l]
print @n.xbgr.xr77_u8.nr1[nsmm_rsh]
print @n.xbgr.xr77_u8.nr1[nsmm_w]
print @n.xbgr.xr77_u8.nr1[nsmm_l]
print @n.xbgr.xr77_u9.nr1[nsmm_rsh]
print @n.xbgr.xr77_u9.nr1[nsmm_w]
print @n.xbgr.xr77_u9.nr1[nsmm_l]
print @n.xbgr.xr77_u10.nr1[nsmm_rsh]
print @n.xbgr.xr77_u10.nr1[nsmm_w]
print @n.xbgr.xr77_u10.nr1[nsmm_l]
print @n.xbgr.xr77_u11.nr1[nsmm_rsh]
print @n.xbgr.xr77_u11.nr1[nsmm_w]
print @n.xbgr.xr77_u11.nr1[nsmm_l]
print @n.xbgr.xr77_u12.nr1[nsmm_rsh]
print @n.xbgr.xr77_u12.nr1[nsmm_w]
print @n.xbgr.xr77_u12.nr1[nsmm_l]
print @n.xbgr.xr77_u13.nr1[nsmm_rsh]
print @n.xbgr.xr77_u13.nr1[nsmm_w]
print @n.xbgr.xr77_u13.nr1[nsmm_l]
print @n.xbgr.xr77_u14.nr1[nsmm_rsh]
print @n.xbgr.xr77_u14.nr1[nsmm_w]
print @n.xbgr.xr77_u14.nr1[nsmm_l]
print @n.xbgr.xr77_u15.nr1[nsmm_rsh]
print @n.xbgr.xr77_u15.nr1[nsmm_w]
print @n.xbgr.xr77_u15.nr1[nsmm_l]
print @n.xbgr.xr77_u16.nr1[nsmm_rsh]
print @n.xbgr.xr77_u16.nr1[nsmm_w]
print @n.xbgr.xr77_u16.nr1[nsmm_l]
print @n.xbgr.xr77_u17.nr1[nsmm_rsh]
print @n.xbgr.xr77_u17.nr1[nsmm_w]
print @n.xbgr.xr77_u17.nr1[nsmm_l]
print @n.xbgr.xr77_u18.nr1[nsmm_rsh]
print @n.xbgr.xr77_u18.nr1[nsmm_w]
print @n.xbgr.xr77_u18.nr1[nsmm_l]
print @n.xbgr.xr77_u19.nr1[nsmm_rsh]
print @n.xbgr.xr77_u19.nr1[nsmm_w]
print @n.xbgr.xr77_u19.nr1[nsmm_l]
print @n.xbgr.xr77_u20.nr1[nsmm_rsh]
print @n.xbgr.xr77_u20.nr1[nsmm_w]
print @n.xbgr.xr77_u20.nr1[nsmm_l]
print @n.xbgr.xr77_u21.nr1[nsmm_rsh]
print @n.xbgr.xr77_u21.nr1[nsmm_w]
print @n.xbgr.xr77_u21.nr1[nsmm_l]
print @n.xbgr.xr77_u22.nr1[nsmm_rsh]
print @n.xbgr.xr77_u22.nr1[nsmm_w]
print @n.xbgr.xr77_u22.nr1[nsmm_l]
print @n.xbgr.xr77_u23.nr1[nsmm_rsh]
print @n.xbgr.xr77_u23.nr1[nsmm_w]
print @n.xbgr.xr77_u23.nr1[nsmm_l]
print @n.xbgr.xr77_u24.nr1[nsmm_rsh]
print @n.xbgr.xr77_u24.nr1[nsmm_w]
print @n.xbgr.xr77_u24.nr1[nsmm_l]
print @n.xbgr.xr78_u2.nr1[nsmm_rsh]
print @n.xbgr.xr78_u2.nr1[nsmm_w]
print @n.xbgr.xr78_u2.nr1[nsmm_l]
print @n.xbgr.xr78_u3.nr1[nsmm_rsh]
print @n.xbgr.xr78_u3.nr1[nsmm_w]
print @n.xbgr.xr78_u3.nr1[nsmm_l]
print @n.xbgr.xr78_u4.nr1[nsmm_rsh]
print @n.xbgr.xr78_u4.nr1[nsmm_w]
print @n.xbgr.xr78_u4.nr1[nsmm_l]
print @n.xbgr.xr78_u5.nr1[nsmm_rsh]
print @n.xbgr.xr78_u5.nr1[nsmm_w]
print @n.xbgr.xr78_u5.nr1[nsmm_l]
print @n.xbgr.xr78_u6.nr1[nsmm_rsh]
print @n.xbgr.xr78_u6.nr1[nsmm_w]
print @n.xbgr.xr78_u6.nr1[nsmm_l]
print @n.xbgr.xr78_u7.nr1[nsmm_rsh]
print @n.xbgr.xr78_u7.nr1[nsmm_w]
print @n.xbgr.xr78_u7.nr1[nsmm_l]
print @n.xbgr.xr78_u8.nr1[nsmm_rsh]
print @n.xbgr.xr78_u8.nr1[nsmm_w]
print @n.xbgr.xr78_u8.nr1[nsmm_l]
print @n.xbgr.xr78_u9.nr1[nsmm_rsh]
print @n.xbgr.xr78_u9.nr1[nsmm_w]
print @n.xbgr.xr78_u9.nr1[nsmm_l]
print @n.xbgr.xr78_u10.nr1[nsmm_rsh]
print @n.xbgr.xr78_u10.nr1[nsmm_w]
print @n.xbgr.xr78_u10.nr1[nsmm_l]
print @n.xbgr.xr78_u11.nr1[nsmm_rsh]
print @n.xbgr.xr78_u11.nr1[nsmm_w]
print @n.xbgr.xr78_u11.nr1[nsmm_l]
print @n.xbgr.xr78_u12.nr1[nsmm_rsh]
print @n.xbgr.xr78_u12.nr1[nsmm_w]
print @n.xbgr.xr78_u12.nr1[nsmm_l]
print @n.xbgr.xr78_u13.nr1[nsmm_rsh]
print @n.xbgr.xr78_u13.nr1[nsmm_w]
print @n.xbgr.xr78_u13.nr1[nsmm_l]
print @n.xbgr.xr78_u14.nr1[nsmm_rsh]
print @n.xbgr.xr78_u14.nr1[nsmm_w]
print @n.xbgr.xr78_u14.nr1[nsmm_l]
print @n.xbgr.xr78_u15.nr1[nsmm_rsh]
print @n.xbgr.xr78_u15.nr1[nsmm_w]
print @n.xbgr.xr78_u15.nr1[nsmm_l]
print @n.xbgr.xr78_u16.nr1[nsmm_rsh]
print @n.xbgr.xr78_u16.nr1[nsmm_w]
print @n.xbgr.xr78_u16.nr1[nsmm_l]
print @n.xbgr.xr78_u17.nr1[nsmm_rsh]
print @n.xbgr.xr78_u17.nr1[nsmm_w]
print @n.xbgr.xr78_u17.nr1[nsmm_l]
print @n.xbgr.xr78_u18.nr1[nsmm_rsh]
print @n.xbgr.xr78_u18.nr1[nsmm_w]
print @n.xbgr.xr78_u18.nr1[nsmm_l]
print @n.xbgr.xr78_u19.nr1[nsmm_rsh]
print @n.xbgr.xr78_u19.nr1[nsmm_w]
print @n.xbgr.xr78_u19.nr1[nsmm_l]
print @n.xbgr.xr78_u20.nr1[nsmm_rsh]
print @n.xbgr.xr78_u20.nr1[nsmm_w]
print @n.xbgr.xr78_u20.nr1[nsmm_l]
print @n.xbgr.xr78_u21.nr1[nsmm_rsh]
print @n.xbgr.xr78_u21.nr1[nsmm_w]
print @n.xbgr.xr78_u21.nr1[nsmm_l]
print @n.xbgr.xr78_u22.nr1[nsmm_rsh]
print @n.xbgr.xr78_u22.nr1[nsmm_w]
print @n.xbgr.xr78_u22.nr1[nsmm_l]
print @n.xbgr.xr78_u23.nr1[nsmm_rsh]
print @n.xbgr.xr78_u23.nr1[nsmm_w]
print @n.xbgr.xr78_u23.nr1[nsmm_l]
print @n.xbgr.xr78_u24.nr1[nsmm_rsh]
print @n.xbgr.xr78_u24.nr1[nsmm_w]
print @n.xbgr.xr78_u24.nr1[nsmm_l]
print @n.xbgr.xr79_u2.nr1[nsmm_rsh]
print @n.xbgr.xr79_u2.nr1[nsmm_w]
print @n.xbgr.xr79_u2.nr1[nsmm_l]
print @n.xbgr.xr79_u3.nr1[nsmm_rsh]
print @n.xbgr.xr79_u3.nr1[nsmm_w]
print @n.xbgr.xr79_u3.nr1[nsmm_l]
print @n.xbgr.xr79_u4.nr1[nsmm_rsh]
print @n.xbgr.xr79_u4.nr1[nsmm_w]
print @n.xbgr.xr79_u4.nr1[nsmm_l]
print @n.xbgr.xr79_u5.nr1[nsmm_rsh]
print @n.xbgr.xr79_u5.nr1[nsmm_w]
print @n.xbgr.xr79_u5.nr1[nsmm_l]
print @n.xbgr.xr79_u6.nr1[nsmm_rsh]
print @n.xbgr.xr79_u6.nr1[nsmm_w]
print @n.xbgr.xr79_u6.nr1[nsmm_l]
print @n.xbgr.xr79_u7.nr1[nsmm_rsh]
print @n.xbgr.xr79_u7.nr1[nsmm_w]
print @n.xbgr.xr79_u7.nr1[nsmm_l]
print @n.xbgr.xr79_u8.nr1[nsmm_rsh]
print @n.xbgr.xr79_u8.nr1[nsmm_w]
print @n.xbgr.xr79_u8.nr1[nsmm_l]
print @n.xbgr.xr79_u9.nr1[nsmm_rsh]
print @n.xbgr.xr79_u9.nr1[nsmm_w]
print @n.xbgr.xr79_u9.nr1[nsmm_l]
print @n.xbgr.xr79_u10.nr1[nsmm_rsh]
print @n.xbgr.xr79_u10.nr1[nsmm_w]
print @n.xbgr.xr79_u10.nr1[nsmm_l]
print @n.xbgr.xr79_u11.nr1[nsmm_rsh]
print @n.xbgr.xr79_u11.nr1[nsmm_w]
print @n.xbgr.xr79_u11.nr1[nsmm_l]
print @n.xbgr.xr79_u12.nr1[nsmm_rsh]
print @n.xbgr.xr79_u12.nr1[nsmm_w]
print @n.xbgr.xr79_u12.nr1[nsmm_l]
print @n.xbgr.xr79_u13.nr1[nsmm_rsh]
print @n.xbgr.xr79_u13.nr1[nsmm_w]
print @n.xbgr.xr79_u13.nr1[nsmm_l]
print @n.xbgr.xr79_u14.nr1[nsmm_rsh]
print @n.xbgr.xr79_u14.nr1[nsmm_w]
print @n.xbgr.xr79_u14.nr1[nsmm_l]
print @n.xbgr.xr79_u15.nr1[nsmm_rsh]
print @n.xbgr.xr79_u15.nr1[nsmm_w]
print @n.xbgr.xr79_u15.nr1[nsmm_l]
print @n.xbgr.xr79_u16.nr1[nsmm_rsh]
print @n.xbgr.xr79_u16.nr1[nsmm_w]
print @n.xbgr.xr79_u16.nr1[nsmm_l]
print @n.xbgr.xr79_u17.nr1[nsmm_rsh]
print @n.xbgr.xr79_u17.nr1[nsmm_w]
print @n.xbgr.xr79_u17.nr1[nsmm_l]
print @n.xbgr.xr79_u18.nr1[nsmm_rsh]
print @n.xbgr.xr79_u18.nr1[nsmm_w]
print @n.xbgr.xr79_u18.nr1[nsmm_l]
print @n.xbgr.xr79_u19.nr1[nsmm_rsh]
print @n.xbgr.xr79_u19.nr1[nsmm_w]
print @n.xbgr.xr79_u19.nr1[nsmm_l]
print @n.xbgr.xr79_u20.nr1[nsmm_rsh]
print @n.xbgr.xr79_u20.nr1[nsmm_w]
print @n.xbgr.xr79_u20.nr1[nsmm_l]
print @n.xbgr.xr79_u21.nr1[nsmm_rsh]
print @n.xbgr.xr79_u21.nr1[nsmm_w]
print @n.xbgr.xr79_u21.nr1[nsmm_l]
print @n.xbgr.xr79_u22.nr1[nsmm_rsh]
print @n.xbgr.xr79_u22.nr1[nsmm_w]
print @n.xbgr.xr79_u22.nr1[nsmm_l]
print @n.xbgr.xr79_u23.nr1[nsmm_rsh]
print @n.xbgr.xr79_u23.nr1[nsmm_w]
print @n.xbgr.xr79_u23.nr1[nsmm_l]
print @n.xbgr.xr79_u24.nr1[nsmm_rsh]
print @n.xbgr.xr79_u24.nr1[nsmm_w]
print @n.xbgr.xr79_u24.nr1[nsmm_l]
print @n.xbgr.xr80_u2.nr1[nsmm_rsh]
print @n.xbgr.xr80_u2.nr1[nsmm_w]
print @n.xbgr.xr80_u2.nr1[nsmm_l]
print @n.xbgr.xr80_u3.nr1[nsmm_rsh]
print @n.xbgr.xr80_u3.nr1[nsmm_w]
print @n.xbgr.xr80_u3.nr1[nsmm_l]
print @n.xbgr.xr80_u4.nr1[nsmm_rsh]
print @n.xbgr.xr80_u4.nr1[nsmm_w]
print @n.xbgr.xr80_u4.nr1[nsmm_l]
print @n.xbgr.xr80_u5.nr1[nsmm_rsh]
print @n.xbgr.xr80_u5.nr1[nsmm_w]
print @n.xbgr.xr80_u5.nr1[nsmm_l]
print @n.xbgr.xr80_u6.nr1[nsmm_rsh]
print @n.xbgr.xr80_u6.nr1[nsmm_w]
print @n.xbgr.xr80_u6.nr1[nsmm_l]
print @n.xbgr.xr80_u7.nr1[nsmm_rsh]
print @n.xbgr.xr80_u7.nr1[nsmm_w]
print @n.xbgr.xr80_u7.nr1[nsmm_l]
print @n.xbgr.xr80_u8.nr1[nsmm_rsh]
print @n.xbgr.xr80_u8.nr1[nsmm_w]
print @n.xbgr.xr80_u8.nr1[nsmm_l]
print @n.xbgr.xr80_u9.nr1[nsmm_rsh]
print @n.xbgr.xr80_u9.nr1[nsmm_w]
print @n.xbgr.xr80_u9.nr1[nsmm_l]
print @n.xbgr.xr80_u10.nr1[nsmm_rsh]
print @n.xbgr.xr80_u10.nr1[nsmm_w]
print @n.xbgr.xr80_u10.nr1[nsmm_l]
print @n.xbgr.xr80_u11.nr1[nsmm_rsh]
print @n.xbgr.xr80_u11.nr1[nsmm_w]
print @n.xbgr.xr80_u11.nr1[nsmm_l]
print @n.xbgr.xr80_u12.nr1[nsmm_rsh]
print @n.xbgr.xr80_u12.nr1[nsmm_w]
print @n.xbgr.xr80_u12.nr1[nsmm_l]
print @n.xbgr.xr80_u13.nr1[nsmm_rsh]
print @n.xbgr.xr80_u13.nr1[nsmm_w]
print @n.xbgr.xr80_u13.nr1[nsmm_l]
print @n.xbgr.xr80_u14.nr1[nsmm_rsh]
print @n.xbgr.xr80_u14.nr1[nsmm_w]
print @n.xbgr.xr80_u14.nr1[nsmm_l]
print @n.xbgr.xr80_u15.nr1[nsmm_rsh]
print @n.xbgr.xr80_u15.nr1[nsmm_w]
print @n.xbgr.xr80_u15.nr1[nsmm_l]
print @n.xbgr.xr80_u16.nr1[nsmm_rsh]
print @n.xbgr.xr80_u16.nr1[nsmm_w]
print @n.xbgr.xr80_u16.nr1[nsmm_l]
print @n.xbgr.xr80_u17.nr1[nsmm_rsh]
print @n.xbgr.xr80_u17.nr1[nsmm_w]
print @n.xbgr.xr80_u17.nr1[nsmm_l]
print @n.xbgr.xr80_u18.nr1[nsmm_rsh]
print @n.xbgr.xr80_u18.nr1[nsmm_w]
print @n.xbgr.xr80_u18.nr1[nsmm_l]
print @n.xbgr.xr80_u19.nr1[nsmm_rsh]
print @n.xbgr.xr80_u19.nr1[nsmm_w]
print @n.xbgr.xr80_u19.nr1[nsmm_l]
print @n.xbgr.xr80_u20.nr1[nsmm_rsh]
print @n.xbgr.xr80_u20.nr1[nsmm_w]
print @n.xbgr.xr80_u20.nr1[nsmm_l]
print @n.xbgr.xr80_u21.nr1[nsmm_rsh]
print @n.xbgr.xr80_u21.nr1[nsmm_w]
print @n.xbgr.xr80_u21.nr1[nsmm_l]
print @n.xbgr.xr80_u22.nr1[nsmm_rsh]
print @n.xbgr.xr80_u22.nr1[nsmm_w]
print @n.xbgr.xr80_u22.nr1[nsmm_l]
print @n.xbgr.xr80_u23.nr1[nsmm_rsh]
print @n.xbgr.xr80_u23.nr1[nsmm_w]
print @n.xbgr.xr80_u23.nr1[nsmm_l]
print @n.xbgr.xr80_u24.nr1[nsmm_rsh]
print @n.xbgr.xr80_u24.nr1[nsmm_w]
print @n.xbgr.xr80_u24.nr1[nsmm_l]
print @n.xbgr.xr81_u2.nr1[nsmm_rsh]
print @n.xbgr.xr81_u2.nr1[nsmm_w]
print @n.xbgr.xr81_u2.nr1[nsmm_l]
print @n.xbgr.xr81_u3.nr1[nsmm_rsh]
print @n.xbgr.xr81_u3.nr1[nsmm_w]
print @n.xbgr.xr81_u3.nr1[nsmm_l]
print @n.xbgr.xr81_u4.nr1[nsmm_rsh]
print @n.xbgr.xr81_u4.nr1[nsmm_w]
print @n.xbgr.xr81_u4.nr1[nsmm_l]
print @n.xbgr.xr81_u5.nr1[nsmm_rsh]
print @n.xbgr.xr81_u5.nr1[nsmm_w]
print @n.xbgr.xr81_u5.nr1[nsmm_l]
print @n.xbgr.xr81_u6.nr1[nsmm_rsh]
print @n.xbgr.xr81_u6.nr1[nsmm_w]
print @n.xbgr.xr81_u6.nr1[nsmm_l]
print @n.xbgr.xr81_u7.nr1[nsmm_rsh]
print @n.xbgr.xr81_u7.nr1[nsmm_w]
print @n.xbgr.xr81_u7.nr1[nsmm_l]
print @n.xbgr.xr81_u8.nr1[nsmm_rsh]
print @n.xbgr.xr81_u8.nr1[nsmm_w]
print @n.xbgr.xr81_u8.nr1[nsmm_l]
print @n.xbgr.xr81_u9.nr1[nsmm_rsh]
print @n.xbgr.xr81_u9.nr1[nsmm_w]
print @n.xbgr.xr81_u9.nr1[nsmm_l]
print @n.xbgr.xr81_u10.nr1[nsmm_rsh]
print @n.xbgr.xr81_u10.nr1[nsmm_w]
print @n.xbgr.xr81_u10.nr1[nsmm_l]
print @n.xbgr.xr81_u11.nr1[nsmm_rsh]
print @n.xbgr.xr81_u11.nr1[nsmm_w]
print @n.xbgr.xr81_u11.nr1[nsmm_l]
print @n.xbgr.xr81_u12.nr1[nsmm_rsh]
print @n.xbgr.xr81_u12.nr1[nsmm_w]
print @n.xbgr.xr81_u12.nr1[nsmm_l]
print @n.xbgr.xr81_u13.nr1[nsmm_rsh]
print @n.xbgr.xr81_u13.nr1[nsmm_w]
print @n.xbgr.xr81_u13.nr1[nsmm_l]
print @n.xbgr.xr81_u14.nr1[nsmm_rsh]
print @n.xbgr.xr81_u14.nr1[nsmm_w]
print @n.xbgr.xr81_u14.nr1[nsmm_l]
print @n.xbgr.xr81_u15.nr1[nsmm_rsh]
print @n.xbgr.xr81_u15.nr1[nsmm_w]
print @n.xbgr.xr81_u15.nr1[nsmm_l]
print @n.xbgr.xr81_u16.nr1[nsmm_rsh]
print @n.xbgr.xr81_u16.nr1[nsmm_w]
print @n.xbgr.xr81_u16.nr1[nsmm_l]
print @n.xbgr.xr81_u17.nr1[nsmm_rsh]
print @n.xbgr.xr81_u17.nr1[nsmm_w]
print @n.xbgr.xr81_u17.nr1[nsmm_l]
print @n.xbgr.xr81_u18.nr1[nsmm_rsh]
print @n.xbgr.xr81_u18.nr1[nsmm_w]
print @n.xbgr.xr81_u18.nr1[nsmm_l]
print @n.xbgr.xr81_u19.nr1[nsmm_rsh]
print @n.xbgr.xr81_u19.nr1[nsmm_w]
print @n.xbgr.xr81_u19.nr1[nsmm_l]
print @n.xbgr.xr81_u20.nr1[nsmm_rsh]
print @n.xbgr.xr81_u20.nr1[nsmm_w]
print @n.xbgr.xr81_u20.nr1[nsmm_l]
print @n.xbgr.xr81_u21.nr1[nsmm_rsh]
print @n.xbgr.xr81_u21.nr1[nsmm_w]
print @n.xbgr.xr81_u21.nr1[nsmm_l]
print @n.xbgr.xr81_u22.nr1[nsmm_rsh]
print @n.xbgr.xr81_u22.nr1[nsmm_w]
print @n.xbgr.xr81_u22.nr1[nsmm_l]
print @n.xbgr.xr81_u23.nr1[nsmm_rsh]
print @n.xbgr.xr81_u23.nr1[nsmm_w]
print @n.xbgr.xr81_u23.nr1[nsmm_l]
print @n.xbgr.xr81_u24.nr1[nsmm_rsh]
print @n.xbgr.xr81_u24.nr1[nsmm_w]
print @n.xbgr.xr81_u24.nr1[nsmm_l]
print @n.xbgr.xr82_u2.nr1[nsmm_rsh]
print @n.xbgr.xr82_u2.nr1[nsmm_w]
print @n.xbgr.xr82_u2.nr1[nsmm_l]
print @n.xbgr.xr82_u3.nr1[nsmm_rsh]
print @n.xbgr.xr82_u3.nr1[nsmm_w]
print @n.xbgr.xr82_u3.nr1[nsmm_l]
print @n.xbgr.xr82_u4.nr1[nsmm_rsh]
print @n.xbgr.xr82_u4.nr1[nsmm_w]
print @n.xbgr.xr82_u4.nr1[nsmm_l]
print @n.xbgr.xr82_u5.nr1[nsmm_rsh]
print @n.xbgr.xr82_u5.nr1[nsmm_w]
print @n.xbgr.xr82_u5.nr1[nsmm_l]
print @n.xbgr.xr82_u6.nr1[nsmm_rsh]
print @n.xbgr.xr82_u6.nr1[nsmm_w]
print @n.xbgr.xr82_u6.nr1[nsmm_l]
print @n.xbgr.xr82_u7.nr1[nsmm_rsh]
print @n.xbgr.xr82_u7.nr1[nsmm_w]
print @n.xbgr.xr82_u7.nr1[nsmm_l]
print @n.xbgr.xr82_u8.nr1[nsmm_rsh]
print @n.xbgr.xr82_u8.nr1[nsmm_w]
print @n.xbgr.xr82_u8.nr1[nsmm_l]
print @n.xbgr.xr82_u9.nr1[nsmm_rsh]
print @n.xbgr.xr82_u9.nr1[nsmm_w]
print @n.xbgr.xr82_u9.nr1[nsmm_l]
print @n.xbgr.xr82_u10.nr1[nsmm_rsh]
print @n.xbgr.xr82_u10.nr1[nsmm_w]
print @n.xbgr.xr82_u10.nr1[nsmm_l]
print @n.xbgr.xr82_u11.nr1[nsmm_rsh]
print @n.xbgr.xr82_u11.nr1[nsmm_w]
print @n.xbgr.xr82_u11.nr1[nsmm_l]
print @n.xbgr.xr82_u12.nr1[nsmm_rsh]
print @n.xbgr.xr82_u12.nr1[nsmm_w]
print @n.xbgr.xr82_u12.nr1[nsmm_l]
print @n.xbgr.xr82_u13.nr1[nsmm_rsh]
print @n.xbgr.xr82_u13.nr1[nsmm_w]
print @n.xbgr.xr82_u13.nr1[nsmm_l]
print @n.xbgr.xr82_u14.nr1[nsmm_rsh]
print @n.xbgr.xr82_u14.nr1[nsmm_w]
print @n.xbgr.xr82_u14.nr1[nsmm_l]
print @n.xbgr.xr82_u15.nr1[nsmm_rsh]
print @n.xbgr.xr82_u15.nr1[nsmm_w]
print @n.xbgr.xr82_u15.nr1[nsmm_l]
print @n.xbgr.xr82_u16.nr1[nsmm_rsh]
print @n.xbgr.xr82_u16.nr1[nsmm_w]
print @n.xbgr.xr82_u16.nr1[nsmm_l]
print @n.xbgr.xr82_u17.nr1[nsmm_rsh]
print @n.xbgr.xr82_u17.nr1[nsmm_w]
print @n.xbgr.xr82_u17.nr1[nsmm_l]
print @n.xbgr.xr82_u18.nr1[nsmm_rsh]
print @n.xbgr.xr82_u18.nr1[nsmm_w]
print @n.xbgr.xr82_u18.nr1[nsmm_l]
print @n.xbgr.xr82_u19.nr1[nsmm_rsh]
print @n.xbgr.xr82_u19.nr1[nsmm_w]
print @n.xbgr.xr82_u19.nr1[nsmm_l]
print @n.xbgr.xr82_u20.nr1[nsmm_rsh]
print @n.xbgr.xr82_u20.nr1[nsmm_w]
print @n.xbgr.xr82_u20.nr1[nsmm_l]
print @n.xbgr.xr82_u21.nr1[nsmm_rsh]
print @n.xbgr.xr82_u21.nr1[nsmm_w]
print @n.xbgr.xr82_u21.nr1[nsmm_l]
print @n.xbgr.xr82_u22.nr1[nsmm_rsh]
print @n.xbgr.xr82_u22.nr1[nsmm_w]
print @n.xbgr.xr82_u22.nr1[nsmm_l]
print @n.xbgr.xr82_u23.nr1[nsmm_rsh]
print @n.xbgr.xr82_u23.nr1[nsmm_w]
print @n.xbgr.xr82_u23.nr1[nsmm_l]
print @n.xbgr.xr82_u24.nr1[nsmm_rsh]
print @n.xbgr.xr82_u24.nr1[nsmm_w]
print @n.xbgr.xr82_u24.nr1[nsmm_l]
print @n.xbgr.xr83_u2.nr1[nsmm_rsh]
print @n.xbgr.xr83_u2.nr1[nsmm_w]
print @n.xbgr.xr83_u2.nr1[nsmm_l]
print @n.xbgr.xr83_u3.nr1[nsmm_rsh]
print @n.xbgr.xr83_u3.nr1[nsmm_w]
print @n.xbgr.xr83_u3.nr1[nsmm_l]
print @n.xbgr.xr83_u4.nr1[nsmm_rsh]
print @n.xbgr.xr83_u4.nr1[nsmm_w]
print @n.xbgr.xr83_u4.nr1[nsmm_l]
print @n.xbgr.xr83_u5.nr1[nsmm_rsh]
print @n.xbgr.xr83_u5.nr1[nsmm_w]
print @n.xbgr.xr83_u5.nr1[nsmm_l]
print @n.xbgr.xr83_u6.nr1[nsmm_rsh]
print @n.xbgr.xr83_u6.nr1[nsmm_w]
print @n.xbgr.xr83_u6.nr1[nsmm_l]
print @n.xbgr.xr83_u7.nr1[nsmm_rsh]
print @n.xbgr.xr83_u7.nr1[nsmm_w]
print @n.xbgr.xr83_u7.nr1[nsmm_l]
print @n.xbgr.xr83_u8.nr1[nsmm_rsh]
print @n.xbgr.xr83_u8.nr1[nsmm_w]
print @n.xbgr.xr83_u8.nr1[nsmm_l]
print @n.xbgr.xr83_u9.nr1[nsmm_rsh]
print @n.xbgr.xr83_u9.nr1[nsmm_w]
print @n.xbgr.xr83_u9.nr1[nsmm_l]
print @n.xbgr.xr83_u10.nr1[nsmm_rsh]
print @n.xbgr.xr83_u10.nr1[nsmm_w]
print @n.xbgr.xr83_u10.nr1[nsmm_l]
print @n.xbgr.xr83_u11.nr1[nsmm_rsh]
print @n.xbgr.xr83_u11.nr1[nsmm_w]
print @n.xbgr.xr83_u11.nr1[nsmm_l]
print @n.xbgr.xr83_u12.nr1[nsmm_rsh]
print @n.xbgr.xr83_u12.nr1[nsmm_w]
print @n.xbgr.xr83_u12.nr1[nsmm_l]
print @n.xbgr.xr83_u13.nr1[nsmm_rsh]
print @n.xbgr.xr83_u13.nr1[nsmm_w]
print @n.xbgr.xr83_u13.nr1[nsmm_l]
print @n.xbgr.xr83_u14.nr1[nsmm_rsh]
print @n.xbgr.xr83_u14.nr1[nsmm_w]
print @n.xbgr.xr83_u14.nr1[nsmm_l]
print @n.xbgr.xr83_u15.nr1[nsmm_rsh]
print @n.xbgr.xr83_u15.nr1[nsmm_w]
print @n.xbgr.xr83_u15.nr1[nsmm_l]
print @n.xbgr.xr83_u16.nr1[nsmm_rsh]
print @n.xbgr.xr83_u16.nr1[nsmm_w]
print @n.xbgr.xr83_u16.nr1[nsmm_l]
print @n.xbgr.xr83_u17.nr1[nsmm_rsh]
print @n.xbgr.xr83_u17.nr1[nsmm_w]
print @n.xbgr.xr83_u17.nr1[nsmm_l]
print @n.xbgr.xr83_u18.nr1[nsmm_rsh]
print @n.xbgr.xr83_u18.nr1[nsmm_w]
print @n.xbgr.xr83_u18.nr1[nsmm_l]
print @n.xbgr.xr83_u19.nr1[nsmm_rsh]
print @n.xbgr.xr83_u19.nr1[nsmm_w]
print @n.xbgr.xr83_u19.nr1[nsmm_l]
print @n.xbgr.xr83_u20.nr1[nsmm_rsh]
print @n.xbgr.xr83_u20.nr1[nsmm_w]
print @n.xbgr.xr83_u20.nr1[nsmm_l]
print @n.xbgr.xr83_u21.nr1[nsmm_rsh]
print @n.xbgr.xr83_u21.nr1[nsmm_w]
print @n.xbgr.xr83_u21.nr1[nsmm_l]
print @n.xbgr.xr83_u22.nr1[nsmm_rsh]
print @n.xbgr.xr83_u22.nr1[nsmm_w]
print @n.xbgr.xr83_u22.nr1[nsmm_l]
print @n.xbgr.xr83_u23.nr1[nsmm_rsh]
print @n.xbgr.xr83_u23.nr1[nsmm_w]
print @n.xbgr.xr83_u23.nr1[nsmm_l]
print @n.xbgr.xr83_u24.nr1[nsmm_rsh]
print @n.xbgr.xr83_u24.nr1[nsmm_w]
print @n.xbgr.xr83_u24.nr1[nsmm_l]
print @n.xbgr.xr84_u2.nr1[nsmm_rsh]
print @n.xbgr.xr84_u2.nr1[nsmm_w]
print @n.xbgr.xr84_u2.nr1[nsmm_l]
print @n.xbgr.xr84_u3.nr1[nsmm_rsh]
print @n.xbgr.xr84_u3.nr1[nsmm_w]
print @n.xbgr.xr84_u3.nr1[nsmm_l]
print @n.xbgr.xr84_u4.nr1[nsmm_rsh]
print @n.xbgr.xr84_u4.nr1[nsmm_w]
print @n.xbgr.xr84_u4.nr1[nsmm_l]
print @n.xbgr.xr84_u5.nr1[nsmm_rsh]
print @n.xbgr.xr84_u5.nr1[nsmm_w]
print @n.xbgr.xr84_u5.nr1[nsmm_l]
print @n.xbgr.xr84_u6.nr1[nsmm_rsh]
print @n.xbgr.xr84_u6.nr1[nsmm_w]
print @n.xbgr.xr84_u6.nr1[nsmm_l]
print @n.xbgr.xr84_u7.nr1[nsmm_rsh]
print @n.xbgr.xr84_u7.nr1[nsmm_w]
print @n.xbgr.xr84_u7.nr1[nsmm_l]
print @n.xbgr.xr84_u8.nr1[nsmm_rsh]
print @n.xbgr.xr84_u8.nr1[nsmm_w]
print @n.xbgr.xr84_u8.nr1[nsmm_l]
print @n.xbgr.xr84_u9.nr1[nsmm_rsh]
print @n.xbgr.xr84_u9.nr1[nsmm_w]
print @n.xbgr.xr84_u9.nr1[nsmm_l]
print @n.xbgr.xr84_u10.nr1[nsmm_rsh]
print @n.xbgr.xr84_u10.nr1[nsmm_w]
print @n.xbgr.xr84_u10.nr1[nsmm_l]
print @n.xbgr.xr84_u11.nr1[nsmm_rsh]
print @n.xbgr.xr84_u11.nr1[nsmm_w]
print @n.xbgr.xr84_u11.nr1[nsmm_l]
print @n.xbgr.xr84_u12.nr1[nsmm_rsh]
print @n.xbgr.xr84_u12.nr1[nsmm_w]
print @n.xbgr.xr84_u12.nr1[nsmm_l]
print @n.xbgr.xr84_u13.nr1[nsmm_rsh]
print @n.xbgr.xr84_u13.nr1[nsmm_w]
print @n.xbgr.xr84_u13.nr1[nsmm_l]
print @n.xbgr.xr84_u14.nr1[nsmm_rsh]
print @n.xbgr.xr84_u14.nr1[nsmm_w]
print @n.xbgr.xr84_u14.nr1[nsmm_l]
print @n.xbgr.xr84_u15.nr1[nsmm_rsh]
print @n.xbgr.xr84_u15.nr1[nsmm_w]
print @n.xbgr.xr84_u15.nr1[nsmm_l]
print @n.xbgr.xr84_u16.nr1[nsmm_rsh]
print @n.xbgr.xr84_u16.nr1[nsmm_w]
print @n.xbgr.xr84_u16.nr1[nsmm_l]
print @n.xbgr.xr84_u17.nr1[nsmm_rsh]
print @n.xbgr.xr84_u17.nr1[nsmm_w]
print @n.xbgr.xr84_u17.nr1[nsmm_l]
print @n.xbgr.xr84_u18.nr1[nsmm_rsh]
print @n.xbgr.xr84_u18.nr1[nsmm_w]
print @n.xbgr.xr84_u18.nr1[nsmm_l]
print @n.xbgr.xr84_u19.nr1[nsmm_rsh]
print @n.xbgr.xr84_u19.nr1[nsmm_w]
print @n.xbgr.xr84_u19.nr1[nsmm_l]
print @n.xbgr.xr84_u20.nr1[nsmm_rsh]
print @n.xbgr.xr84_u20.nr1[nsmm_w]
print @n.xbgr.xr84_u20.nr1[nsmm_l]
print @n.xbgr.xr84_u21.nr1[nsmm_rsh]
print @n.xbgr.xr84_u21.nr1[nsmm_w]
print @n.xbgr.xr84_u21.nr1[nsmm_l]
print @n.xbgr.xr84_u22.nr1[nsmm_rsh]
print @n.xbgr.xr84_u22.nr1[nsmm_w]
print @n.xbgr.xr84_u22.nr1[nsmm_l]
print @n.xbgr.xr84_u23.nr1[nsmm_rsh]
print @n.xbgr.xr84_u23.nr1[nsmm_w]
print @n.xbgr.xr84_u23.nr1[nsmm_l]
print @n.xbgr.xr84_u24.nr1[nsmm_rsh]
print @n.xbgr.xr84_u24.nr1[nsmm_w]
print @n.xbgr.xr84_u24.nr1[nsmm_l]
print @n.xbgr.xr85_u2.nr1[nsmm_rsh]
print @n.xbgr.xr85_u2.nr1[nsmm_w]
print @n.xbgr.xr85_u2.nr1[nsmm_l]
print @n.xbgr.xr85_u3.nr1[nsmm_rsh]
print @n.xbgr.xr85_u3.nr1[nsmm_w]
print @n.xbgr.xr85_u3.nr1[nsmm_l]
print @n.xbgr.xr85_u4.nr1[nsmm_rsh]
print @n.xbgr.xr85_u4.nr1[nsmm_w]
print @n.xbgr.xr85_u4.nr1[nsmm_l]
print @n.xbgr.xr85_u5.nr1[nsmm_rsh]
print @n.xbgr.xr85_u5.nr1[nsmm_w]
print @n.xbgr.xr85_u5.nr1[nsmm_l]
print @n.xbgr.xr85_u6.nr1[nsmm_rsh]
print @n.xbgr.xr85_u6.nr1[nsmm_w]
print @n.xbgr.xr85_u6.nr1[nsmm_l]
print @n.xbgr.xr85_u7.nr1[nsmm_rsh]
print @n.xbgr.xr85_u7.nr1[nsmm_w]
print @n.xbgr.xr85_u7.nr1[nsmm_l]
print @n.xbgr.xr85_u8.nr1[nsmm_rsh]
print @n.xbgr.xr85_u8.nr1[nsmm_w]
print @n.xbgr.xr85_u8.nr1[nsmm_l]
print @n.xbgr.xr85_u9.nr1[nsmm_rsh]
print @n.xbgr.xr85_u9.nr1[nsmm_w]
print @n.xbgr.xr85_u9.nr1[nsmm_l]
print @n.xbgr.xr85_u10.nr1[nsmm_rsh]
print @n.xbgr.xr85_u10.nr1[nsmm_w]
print @n.xbgr.xr85_u10.nr1[nsmm_l]
print @n.xbgr.xr85_u11.nr1[nsmm_rsh]
print @n.xbgr.xr85_u11.nr1[nsmm_w]
print @n.xbgr.xr85_u11.nr1[nsmm_l]
print @n.xbgr.xr85_u12.nr1[nsmm_rsh]
print @n.xbgr.xr85_u12.nr1[nsmm_w]
print @n.xbgr.xr85_u12.nr1[nsmm_l]
print @n.xbgr.xr85_u13.nr1[nsmm_rsh]
print @n.xbgr.xr85_u13.nr1[nsmm_w]
print @n.xbgr.xr85_u13.nr1[nsmm_l]
print @n.xbgr.xr85_u14.nr1[nsmm_rsh]
print @n.xbgr.xr85_u14.nr1[nsmm_w]
print @n.xbgr.xr85_u14.nr1[nsmm_l]
print @n.xbgr.xr85_u15.nr1[nsmm_rsh]
print @n.xbgr.xr85_u15.nr1[nsmm_w]
print @n.xbgr.xr85_u15.nr1[nsmm_l]
print @n.xbgr.xr85_u16.nr1[nsmm_rsh]
print @n.xbgr.xr85_u16.nr1[nsmm_w]
print @n.xbgr.xr85_u16.nr1[nsmm_l]
print @n.xbgr.xr85_u17.nr1[nsmm_rsh]
print @n.xbgr.xr85_u17.nr1[nsmm_w]
print @n.xbgr.xr85_u17.nr1[nsmm_l]
print @n.xbgr.xr85_u18.nr1[nsmm_rsh]
print @n.xbgr.xr85_u18.nr1[nsmm_w]
print @n.xbgr.xr85_u18.nr1[nsmm_l]
print @n.xbgr.xr85_u19.nr1[nsmm_rsh]
print @n.xbgr.xr85_u19.nr1[nsmm_w]
print @n.xbgr.xr85_u19.nr1[nsmm_l]
print @n.xbgr.xr85_u20.nr1[nsmm_rsh]
print @n.xbgr.xr85_u20.nr1[nsmm_w]
print @n.xbgr.xr85_u20.nr1[nsmm_l]
print @n.xbgr.xr85_u21.nr1[nsmm_rsh]
print @n.xbgr.xr85_u21.nr1[nsmm_w]
print @n.xbgr.xr85_u21.nr1[nsmm_l]
print @n.xbgr.xr85_u22.nr1[nsmm_rsh]
print @n.xbgr.xr85_u22.nr1[nsmm_w]
print @n.xbgr.xr85_u22.nr1[nsmm_l]
print @n.xbgr.xr85_u23.nr1[nsmm_rsh]
print @n.xbgr.xr85_u23.nr1[nsmm_w]
print @n.xbgr.xr85_u23.nr1[nsmm_l]
print @n.xbgr.xr85_u24.nr1[nsmm_rsh]
print @n.xbgr.xr85_u24.nr1[nsmm_w]
print @n.xbgr.xr85_u24.nr1[nsmm_l]
print @n.xbgr.xr86_u2.nr1[nsmm_rsh]
print @n.xbgr.xr86_u2.nr1[nsmm_w]
print @n.xbgr.xr86_u2.nr1[nsmm_l]
print @n.xbgr.xr86_u3.nr1[nsmm_rsh]
print @n.xbgr.xr86_u3.nr1[nsmm_w]
print @n.xbgr.xr86_u3.nr1[nsmm_l]
print @n.xbgr.xr86_u4.nr1[nsmm_rsh]
print @n.xbgr.xr86_u4.nr1[nsmm_w]
print @n.xbgr.xr86_u4.nr1[nsmm_l]
print @n.xbgr.xr86_u5.nr1[nsmm_rsh]
print @n.xbgr.xr86_u5.nr1[nsmm_w]
print @n.xbgr.xr86_u5.nr1[nsmm_l]
print @n.xbgr.xr86_u6.nr1[nsmm_rsh]
print @n.xbgr.xr86_u6.nr1[nsmm_w]
print @n.xbgr.xr86_u6.nr1[nsmm_l]
print @n.xbgr.xr86_u7.nr1[nsmm_rsh]
print @n.xbgr.xr86_u7.nr1[nsmm_w]
print @n.xbgr.xr86_u7.nr1[nsmm_l]
print @n.xbgr.xr86_u8.nr1[nsmm_rsh]
print @n.xbgr.xr86_u8.nr1[nsmm_w]
print @n.xbgr.xr86_u8.nr1[nsmm_l]
print @n.xbgr.xr86_u9.nr1[nsmm_rsh]
print @n.xbgr.xr86_u9.nr1[nsmm_w]
print @n.xbgr.xr86_u9.nr1[nsmm_l]
print @n.xbgr.xr86_u10.nr1[nsmm_rsh]
print @n.xbgr.xr86_u10.nr1[nsmm_w]
print @n.xbgr.xr86_u10.nr1[nsmm_l]
print @n.xbgr.xr86_u11.nr1[nsmm_rsh]
print @n.xbgr.xr86_u11.nr1[nsmm_w]
print @n.xbgr.xr86_u11.nr1[nsmm_l]
print @n.xbgr.xr86_u12.nr1[nsmm_rsh]
print @n.xbgr.xr86_u12.nr1[nsmm_w]
print @n.xbgr.xr86_u12.nr1[nsmm_l]
print @n.xbgr.xr86_u13.nr1[nsmm_rsh]
print @n.xbgr.xr86_u13.nr1[nsmm_w]
print @n.xbgr.xr86_u13.nr1[nsmm_l]
print @n.xbgr.xr86_u14.nr1[nsmm_rsh]
print @n.xbgr.xr86_u14.nr1[nsmm_w]
print @n.xbgr.xr86_u14.nr1[nsmm_l]
print @n.xbgr.xr86_u15.nr1[nsmm_rsh]
print @n.xbgr.xr86_u15.nr1[nsmm_w]
print @n.xbgr.xr86_u15.nr1[nsmm_l]
print @n.xbgr.xr86_u16.nr1[nsmm_rsh]
print @n.xbgr.xr86_u16.nr1[nsmm_w]
print @n.xbgr.xr86_u16.nr1[nsmm_l]
print @n.xbgr.xr86_u17.nr1[nsmm_rsh]
print @n.xbgr.xr86_u17.nr1[nsmm_w]
print @n.xbgr.xr86_u17.nr1[nsmm_l]
print @n.xbgr.xr86_u18.nr1[nsmm_rsh]
print @n.xbgr.xr86_u18.nr1[nsmm_w]
print @n.xbgr.xr86_u18.nr1[nsmm_l]
print @n.xbgr.xr86_u19.nr1[nsmm_rsh]
print @n.xbgr.xr86_u19.nr1[nsmm_w]
print @n.xbgr.xr86_u19.nr1[nsmm_l]
print @n.xbgr.xr86_u20.nr1[nsmm_rsh]
print @n.xbgr.xr86_u20.nr1[nsmm_w]
print @n.xbgr.xr86_u20.nr1[nsmm_l]
print @n.xbgr.xr86_u21.nr1[nsmm_rsh]
print @n.xbgr.xr86_u21.nr1[nsmm_w]
print @n.xbgr.xr86_u21.nr1[nsmm_l]
print @n.xbgr.xr86_u22.nr1[nsmm_rsh]
print @n.xbgr.xr86_u22.nr1[nsmm_w]
print @n.xbgr.xr86_u22.nr1[nsmm_l]
print @n.xbgr.xr86_u23.nr1[nsmm_rsh]
print @n.xbgr.xr86_u23.nr1[nsmm_w]
print @n.xbgr.xr86_u23.nr1[nsmm_l]
print @n.xbgr.xr86_u24.nr1[nsmm_rsh]
print @n.xbgr.xr86_u24.nr1[nsmm_w]
print @n.xbgr.xr86_u24.nr1[nsmm_l]
set numdgt=17
echo METALLIC_POINT_VOLTAGES_BEGIN
print v(xbgr.mr_n76032976)
print v(xbgr.vd2)
print v(xbgr.mr_n75245312)
print v(xbgr.c2)
print v(xbgr.mr_n76321552)
print v(xbgr.mr_n76422784)
print v(xbgr.mr_n76538752)
print v(xbgr.mr_n76596864)
print v(xbgr.mr_n76773008)
print v(xbgr.mr_n76859968)
print v(xbgr.mr_n77082912)
print v(xbgr.mr_n77207456)
print v(xbgr.mr_n76972128)
print v(xbgr.mr_n77498272)
print v(xbgr.mr_n77526928)
print v(xbgr.mr_n77813456)
print v(xbgr.mr_n77904640)
print v(xbgr.mr_n77969040)
print v(xbgr.mr_n75063088)
print v(xbgr.mr_n78583200)
print v(xbgr.mr_n78755280)
print v(xbgr.mr_n78953232)
print v(xbgr.mr_n79065408)
print v(xbgr.mr_n79257584)
print v(xbgr.mr_n79465488)
print v(xbgr.mr_n79667664)
print v(xbgr.mr_n79878768)
print v(xbgr.mr_n76910096)
print v(xbgr.mr_n79964512)
print v(xbgr.mr_n80247584)
print v(xbgr.mr_n80440368)
print v(xbgr.mr_n80653136)
print v(xbgr.mr_n80837584)
print v(xbgr.mr_n81144320)
print v(xbgr.mr_n81347216)
print v(xbgr.mr_n81559920)
print v(xbgr.mr_n81915808)
print v(xbgr.mr_n76033424)
print v(xbgr.mr_n76096864)
print v(xbgr.b1b)
print v(xbgr.mr_n76185712)
print v(xbgr.mr_n76278640)
print v(xbgr.mr_n76375792)
print v(xbgr.mr_n76480800)
print v(xbgr.mr_n76598848)
print v(xbgr.mr_n76711248)
print v(xbgr.mr_n77052416)
print v(xbgr.mr_n77169856)
print v(xbgr.mr_n77302016)
print v(xbgr.mr_n77402816)
print v(xbgr.mr_n77576224)
print v(xbgr.mr_n77691344)
print v(xbgr.mr_n77844448)
print v(xbgr.mr_n78093504)
print v(xbgr.mr_n76068240)
print v(xbgr.mr_n76129744)
print v(xbgr.mr_n75824272)
print v(xbgr.mr_n76267680)
print v(xbgr.mr_n76367520)
print v(xbgr.mr_n76483168)
print v(xbgr.mr_n76541408)
print v(xbgr.mr_n76689088)
print v(xbgr.mr_n76793632)
print v(xbgr.mr_n76910768)
print v(xbgr.mr_n77097712)
print v(xbgr.mr_n77217552)
print v(xbgr.mr_n77378096)
print v(xbgr.mr_n77498384)
print v(xbgr.mr_n77699712)
print v(xbgr.mr_n77816272)
print v(xbgr.mr_n77924096)
print v(xbgr.mr_n78095552)
print v(xbgr.mr_n75211872)
print v(xbgr.mr_n75565488)
print v(xbgr.n_13)
print v(xbgr.n_24)
print v(xbgr.mr_n75300080)
print v(xbgr.mr_n75567728)
print v(xbgr.n_14)
print v(xbgr.mr_n75910256)
print v(xbgr.mr_n75982832)
print v(xbgr.mr_n76097056)
print v(xbgr.mr_n75309216)
print v(xbgr.mr_n76243328)
print v(xbgr.mr_n76324224)
print v(xbgr.mr_n76406864)
print v(xbgr.mr_n76532064)
print v(xbgr.vd1)
print v(xbgr.mr_n76773120)
print v(xbgr.mr_n76817664)
print v(xbgr.mr_n77020848)
print v(xbgr.mr_n77147184)
print v(xbgr.mr_n77379264)
print v(xbgr.mr_n77501264)
print v(xbgr.mr_n77611152)
print v(xbgr.mr_n77770208)
print v(xbgr.mr_n77923440)
print v(xbgr.mr_n78094512)
print v(xbgr.mr_n78442160)
print v(xbgr.mr_n78584464)
print v(xbgr.mr_n78759424)
print v(xbgr.mr_n78953424)
print v(xbgr.mr_n79120816)
print v(xbgr.mr_n79304576)
print v(xbgr.mr_n79506544)
print v(xbgr.mr_n79668832)
print v(xbgr.mr_n79883216)
print v(xbgr.mr_n76847872)
print v(xbgr.mr_n79970048)
print v(xbgr.mr_n80262544)
print v(xbgr.mr_n80439904)
print v(xbgr.mr_n80658048)
print v(xbgr.mr_n80845136)
print v(xbgr.mr_n81145888)
print v(xbgr.mr_n81348352)
print v(xbgr.mr_n81581168)
print v(xbgr.mr_n81918640)
print v(xbgr.mr_n76034000)
print v(xbgr.mr_n76098000)
print v(xbgr.mr_n75521856)
print v(xbgr.mr_n76208192)
print v(xbgr.mr_n76280032)
print v(xbgr.mr_n76376064)
print v(xbgr.mr_n76480464)
print v(xbgr.mr_n76530240)
print v(xbgr.mr_n76713248)
print v(xbgr.mr_n77053808)
print v(xbgr.mr_n77171248)
print v(xbgr.mr_n77303408)
print v(xbgr.mr_n77449632)
print v(xbgr.mr_n77577680)
print v(xbgr.mr_n77693136)
print v(xbgr.mr_n77840832)
print v(xbgr.mr_n78094176)
print v(xbgr.mr_n75302880)
print v(xbgr.mr_n75568400)
print v(xbgr.mr_n75795696)
print v(xbgr.n_26)
print v(xbgr.mr_n75302416)
print v(xbgr.mr_n75568992)
print v(xbgr.n_15)
print v(xbgr.mr_n75911696)
print v(xbgr.mr_n76069696)
print v(xbgr.mr_n76130384)
print v(xbgr.mr_n75877680)
print v(xbgr.mr_n76269200)
print v(xbgr.mr_n76368320)
print v(xbgr.mr_n76483936)
print v(xbgr.mr_n76525360)
print v(xbgr.mr_n76690272)
print v(xbgr.mr_n76795424)
print v(xbgr.mr_n76910432)
print v(xbgr.mr_n77099648)
print v(xbgr.mr_n77210320)
print v(xbgr.mr_n77393392)
print v(xbgr.mr_n77515104)
print v(xbgr.mr_n77700928)
print v(xbgr.mr_n77814048)
print v(xbgr.mr_n77923104)
print v(xbgr.mr_n77970128)
print v(xbgr.mr_n75303808)
print v(xbgr.mr_n75569584)
print v(xbgr.mr_n75796624)
print v(xbgr.n_27)
print v(xbgr.mr_n75211984)
print v(xbgr.mr_n75570176)
print v(xbgr.n_16)
print v(xbgr.mr_n75913136)
print v(xbgr.mr_n75304736)
print v(xbgr.mr_n75412640)
print v(xbgr.mr_n75797088)
print v(xbgr.n_21)
print v(xbgr.mr_n76033616)
print v(xbgr.mr_n76096672)
print v(xbgr.mr_n75237952)
print v(xbgr.mr_n76268464)
print v(xbgr.mr_n75227072)
print v(xbgr.mr_n76423488)
print v(xbgr.mr_n76480128)
print v(xbgr.mr_n76652976)
print v(xbgr.mr_n76773312)
print v(xbgr.mr_n77022928)
print v(xbgr.mr_n77208160)
print v(xbgr.mr_n77393216)
print v(xbgr.mr_n77497920)
print v(xbgr.mr_n77608736)
print v(xbgr.mr_n77753136)
print v(xbgr.mr_n77905824)
print v(xbgr.mr_n78096064)
print v(xbgr.mr_n75304272)
print v(xbgr.mr_n75565312)
print v(xbgr.mr_n78449664)
print v(xbgr.mr_n78562480)
print v(xbgr.mr_n78832784)
print v(xbgr.mr_n78954368)
print v(xbgr.mr_n79120928)
print v(xbgr.mr_n79089152)
print v(xbgr.mr_n79495680)
print v(xbgr.mr_n79650000)
print v(xbgr.mr_n79887872)
print v(xbgr.mr_n80256992)
print v(xbgr.mr_n80455712)
print v(xbgr.mr_n80663648)
print v(xbgr.mr_n80850112)
print v(xbgr.mr_n81157232)
print v(xbgr.mr_n81360784)
print v(xbgr.mr_n81561184)
print v(xbgr.mr_n81929856)
print v(xbgr.mr_n76039760)
print v(xbgr.mr_n76116320)
print v(xbgr.mr_n75269952)
print v(xbgr.mr_n76209584)
print v(xbgr.mr_n76281424)
print v(xbgr.mr_n76376672)
print v(xbgr.mr_n76520960)
print v(xbgr.mr_n76655456)
print v(xbgr.mr_n76727040)
print v(xbgr.mr_n77053344)
print v(xbgr.mr_n77172640)
print v(xbgr.mr_n77304800)
print v(xbgr.mr_n77451408)
print v(xbgr.mr_n77579456)
print v(xbgr.mr_n77697936)
print v(xbgr.mr_n77872832)
print v(xbgr.mr_n78093840)
print v(xbgr.mr_n75305664)
print v(xbgr.mr_n75512896)
print v(xbgr.n_8)
print v(xbgr.vbe3)
print v(xbgr.mr_n76071072)
print v(xbgr.mr_n76130784)
print v(xbgr.mr_n75865552)
print v(xbgr.mr_n76270160)
print v(xbgr.mr_n76369120)
print v(xbgr.mr_n76484336)
print v(xbgr.mr_n76545648)
print v(xbgr.mr_n76691152)
print v(xbgr.mr_n76796304)
print v(xbgr.mr_n77101456)
print v(xbgr.mr_n77220880)
print v(xbgr.mr_n77394192)
print v(xbgr.mr_n77515904)
print v(xbgr.mr_n77702528)
print v(xbgr.mr_n77813712)
print v(xbgr.mr_n77906416)
print v(xbgr.mr_n77968496)
print v(xbgr.mr_n75305200)
print v(xbgr.mr_n75573136)
print v(xbgr.mr_n75646160)
print v(xbgr.mr_n75958416)
print v(xbgr.mr_n75306592)
print v(xbgr.mr_n75574912)
print v(xbgr.mr_n75641104)
print v(xbgr.n_37)
print v(xbgr.mr_n75306128)
print v(xbgr.mr_n75576688)
print v(xbgr.mr_n75646880)
print v(xbgr.mr_n75959344)
print v(xbgr.n_6)
print v(xbgr.vb2)
print v(xbgr.n_2)
print v(xbgr.mr_n75959808)
print v(xbgr.mr_n76005824)
print v(xbgr.mr_n76117024)
print v(xbgr.mr_n75946736)
print v(xbgr.mr_n76165856)
print v(xbgr.mr_n76328160)
print v(xbgr.mr_n76448768)
print v(xbgr.mr_n76539280)
print v(xbgr.mr_n76653488)
print v(xbgr.mr_n76777440)
print v(xbgr.mr_n77054272)
print v(xbgr.mr_n77207648)
print v(xbgr.mr_n77371744)
print v(xbgr.mr_n77502496)
print v(xbgr.mr_n77677600)
print v(xbgr.mr_n77819136)
print v(xbgr.mr_n77905232)
print v(xbgr.mr_n77958160)
print v(xbgr.mr_n78437024)
print v(xbgr.mr_n78620704)
print v(xbgr.mr_n78841136)
print v(xbgr.mr_n78945936)
print v(xbgr.mr_n79110192)
print v(xbgr.mr_n79315712)
print v(xbgr.mr_n79495408)
print v(xbgr.mr_n79667776)
print v(xbgr.mr_n79892848)
print v(xbgr.mr_n80244224)
print v(xbgr.mr_n80461408)
print v(xbgr.mr_n80668512)
print v(xbgr.mr_n80855088)
print v(xbgr.mr_n81158976)
print v(xbgr.mr_n81339952)
print v(xbgr.mr_n81581552)
print v(xbgr.mr_n81917696)
print v(xbgr.mr_n75408960)
print v(xbgr.mr_n75421728)
print v(xbgr.mr_n75647680)
print v(xbgr.mr_n75960336)
print v(xbgr.mr_n76040672)
print v(xbgr.mr_n76117376)
print v(xbgr.mr_n75519424)
print v(xbgr.mr_n76210976)
print v(xbgr.mr_n76282816)
print v(xbgr.mr_n76391840)
print v(xbgr.mr_n76522112)
print v(xbgr.mr_n76678032)
print v(xbgr.mr_n76728432)
print v(xbgr.mr_n77052880)
print v(xbgr.mr_n77174352)
print v(xbgr.mr_n77306512)
print v(xbgr.mr_n77453184)
print v(xbgr.mr_n77581232)
print v(xbgr.mr_n77698272)
print v(xbgr.mr_n77874224)
print v(xbgr.mr_n78098128)
print v(xbgr.mr_n75409920)
print v(xbgr.mr_n75444544)
print v(xbgr.n_7)
print v(xbgr.n_36)
print v(xbgr.mr_n76072208)
print v(xbgr.mr_n76128752)
print v(xbgr.mr_n76134496)
print v(xbgr.mr_n76271040)
print v(xbgr.mr_n76369920)
print v(xbgr.mr_n76484736)
print v(xbgr.mr_n76534416)
print v(xbgr.mr_n76691712)
print v(xbgr.mr_n76797104)
print v(xbgr.mr_n77103264)
print v(xbgr.mr_n77223456)
print v(xbgr.mr_n77394992)
print v(xbgr.mr_n77516704)
print v(xbgr.mr_n77703872)
print v(xbgr.mr_n77819024)
print v(xbgr.mr_n77904048)
print v(xbgr.mr_n78096288)
print v(xbgr.mr_n75212208)
print v(xbgr.mr_n75444944)
print v(xbgr.mr_n75648480)
print v(xbgr.mr_n75961520)
print v(xbgr.mr_n75411392)
print v(xbgr.mr_n75445408)
print v(xbgr.mr_n75635856)
print v(xbgr.mr_n75962112)
print v(xbgr.mr_n75412128)
print v(xbgr.mr_n75446000)
print v(xbgr.mr_n75649280)
print v(xbgr.mr_n75962704)
print v(xbgr.mr_n75412864)
print v(xbgr.mr_n75446592)
print v(xbgr.mr_n75649680)
print v(xbgr.mr_n75963296)
print v(xbgr.mr_n76033808)
print v(xbgr.mr_n76118080)
print v(xbgr.mr_n76008448)
print v(xbgr.mr_n76270864)
print v(xbgr.mr_n76329488)
print v(xbgr.mr_n76449568)
print v(xbgr.mr_n76548736)
print v(xbgr.mr_n76600000)
print v(xbgr.mr_n76776688)
print v(xbgr.mr_n77101968)
print v(xbgr.mr_n77218208)
print v(xbgr.mr_n77375040)
print v(xbgr.mr_n77501680)
print v(xbgr.mr_n77678784)
print v(xbgr.mr_n77820832)
print v(xbgr.mr_n77903456)
print v(xbgr.mr_n78098352)
print v(xbgr.mr_n78449472)
print v(xbgr.mr_n78615600)
print v(xbgr.mr_n78840432)
print v(xbgr.mr_n78959360)
print v(xbgr.mr_n79122896)
print v(xbgr.mr_n79087744)
print v(xbgr.mr_n79528544)
print v(xbgr.mr_n79674640)
print v(xbgr.mr_n79897824)
print v(xbgr.mr_n80263712)
print v(xbgr.mr_n80472256)
print v(xbgr.mr_n80673024)
print v(xbgr.mr_n80860064)
print v(xbgr.mr_n81164656)
print v(xbgr.mr_n81360272)
print v(xbgr.mr_n81585264)
print v(xbgr.mr_n81929408)
print v(xbgr.mr_n76044752)
print v(xbgr.mr_n76118432)
print v(xbgr.mr_n75253760)
print v(xbgr.mr_n76212368)
print v(xbgr.mr_n76284208)
print v(xbgr.mr_n76394384)
print v(xbgr.mr_n76523504)
print v(xbgr.mr_n76679504)
print v(xbgr.mr_n76729824)
print v(xbgr.mr_n77083680)
print v(xbgr.mr_n77176128)
print v(xbgr.mr_n77308288)
print v(xbgr.mr_n77454960)
print v(xbgr.mr_n77583008)
print v(xbgr.mr_n77683520)
print v(xbgr.mr_n77875744)
print v(xbgr.mr_n78102256)
print v(xbgr.mr_n75413376)
print v(xbgr.mr_n75447184)
print v(xbgr.mr_n75650080)
print v(xbgr.mr_n75964480)
print v(xbgr.mr_n75413920)
print v(xbgr.mr_n75420912)
print v(xbgr.n_11)
print v(xbgr.mr_n75963888)
print v(xbgr.mr_n76073904)
print v(xbgr.mr_n76131584)
print v(xbgr.mr_n76138624)
print v(xbgr.mr_n76244976)
print v(xbgr.mr_n76370720)
print v(xbgr.mr_n76485136)
print v(xbgr.mr_n76551344)
print v(xbgr.mr_n76692528)
print v(xbgr.mr_n76797904)
print v(xbgr.mr_n77105248)
print v(xbgr.mr_n77225184)
print v(xbgr.mr_n77395792)
print v(xbgr.mr_n77517504)
print v(xbgr.mr_n77706016)
print v(xbgr.mr_n77817056)
print v(xbgr.mr_n77928224)
print v(xbgr.mr_n78100192)
print v(xbgr.mr_n75414416)
print v(xbgr.mr_n75448432)
print v(xbgr.mr_n75729424)
print v(xbgr.mr_n75965072)
print v(xbgr.mr_n75415472)
print v(xbgr.mr_n75448960)
print v(xbgr.mr_n75730016)
print v(xbgr.mr_n75913744)
print v(xbgr.mr_n75415744)
print v(xbgr.mr_n75449552)
print v(xbgr.mr_n75730608)
print v(xbgr.mr_n75966176)
print v(xbgr.mr_n76039008)
print v(xbgr.mr_n76119136)
print v(xbgr.mr_n75551936)
print v(xbgr.mr_n76200832)
print v(xbgr.mr_n76334304)
print v(xbgr.mr_n76450368)
print v(xbgr.mr_n76551984)
print v(xbgr.mr_n76678768)
print v(xbgr.mr_n76794912)
print v(xbgr.mr_n77100160)
print v(xbgr.mr_n77143456)
print v(xbgr.mr_n77395616)
print v(xbgr.mr_n77517328)
print v(xbgr.mr_n77679968)
print v(xbgr.mr_n77752320)
print v(xbgr.mr_n77926528)
print v(xbgr.mr_n78098240)
print v(xbgr.n_9)
print v(xbgr.mr_n75450144)
print v(xbgr.mr_n75640000)
print v(xbgr.mr_n75966848)
print v(xbgr.mr_n78453824)
print v(xbgr.mr_n78628736)
print v(xbgr.mr_n78854800)
print v(xbgr.mr_n78961376)
print v(xbgr.mr_n78975168)
print v(xbgr.mr_n79326768)
print v(xbgr.mr_n79528032)
print v(xbgr.mr_n79668944)
print v(xbgr.mr_n79902800)
print v(xbgr.mr_n80274352)
print v(xbgr.mr_n80446560)
print v(xbgr.mr_n80677920)
print v(xbgr.mr_n80855200)
print v(xbgr.mr_n81177024)
print v(xbgr.mr_n81355088)
print v(xbgr.mr_n81609072)
print v(xbgr.mr_n81831744)
print v(xbgr.mr_n76045664)
print v(xbgr.mr_n76119488)
print v(xbgr.mr_n75916976)
print v(xbgr.mr_n76213760)
print v(xbgr.mr_n76285600)
print v(xbgr.mr_n76403520)
print v(xbgr.mr_n76524896)
print v(xbgr.mr_n76680432)
print v(xbgr.mr_n76731216)
print v(xbgr.mr_n77023808)
print v(xbgr.mr_n77177904)
print v(xbgr.mr_n77310064)
print v(xbgr.mr_n77456736)
print v(xbgr.mr_n77584784)
print v(xbgr.mr_n77704496)
print v(xbgr.mr_n77877520)
print v(xbgr.mr_n78100416)
print v(xbgr.mr_n75416832)
print v(xbgr.mr_n75450736)
print v(xbgr.mr_n75720688)
print v(xbgr.mr_n75967440)
print v(xbgr.mr_n76075120)
print v(xbgr.mr_n76131984)
print v(xbgr.mr_n76142544)
print v(xbgr.mr_n75907728)
print v(xbgr.mr_n76371520)
print v(xbgr.mr_n76485536)
print v(xbgr.mr_n76543888)
print v(xbgr.mr_n76693408)
print v(xbgr.mr_n76798704)
print v(xbgr.mr_n77104672)
print v(xbgr.mr_n77227072)
print v(xbgr.mr_n77396592)
print v(xbgr.mr_n77518304)
print v(xbgr.mr_n77707536)
print v(xbgr.mr_n77822752)
print v(xbgr.mr_n77926416)
print v(xbgr.mr_n78096176)
print v(xbgr.mr_n75417376)
print v(xbgr.mr_n75451328)
print v(xbgr.mr_n75731104)
print v(xbgr.mr_n75968032)
print v(xbgr.mr_n75417920)
print v(xbgr.mr_n75451920)
print v(xbgr.mr_n75731488)
print v(xbgr.mr_n75968624)
print v(xbgr.mr_n75418464)
print v(xbgr.mr_n75452512)
print v(xbgr.mr_n75200672)
print v(xbgr.mr_n75969216)
print v(xbgr.mr_n75419008)
print v(xbgr.mr_n75453104)
print v(xbgr.mr_n75733152)
print v(xbgr.mr_n75969808)
print v(xbgr.mr_n76049744)
print v(xbgr.mr_n76120192)
print v(xbgr.mr_n76137680)
print v(xbgr.mr_n76269728)
print v(xbgr.mr_n76335632)
print v(xbgr.mr_n76451232)
print v(xbgr.mr_n76546352)
print v(xbgr.mr_n76679856)
print v(xbgr.mr_n76796928)
print v(xbgr.mr_n77083424)
print v(xbgr.mr_n77217776)
print v(xbgr.mr_n77394016)
print v(xbgr.mr_n77514928)
print v(xbgr.mr_n77681152)
print v(xbgr.mr_n77747184)
print v(xbgr.mr_n77924720)
print v(xbgr.mr_n78102368)
print v(xbgr.mr_n78457760)
print v(xbgr.mr_n78624592)
print v(xbgr.mr_n78837696)
print v(xbgr.mr_n78979520)
print v(xbgr.mr_n79151872)
print v(xbgr.mr_n79321872)
print v(xbgr.mr_n79519376)
print v(xbgr.mr_n79683888)
print v(xbgr.mr_n79915904)
print v(xbgr.mr_n80300304)
print v(xbgr.mr_n80477328)
print v(xbgr.mr_n80682816)
print v(xbgr.mr_n80868848)
print v(xbgr.mr_n81193584)
print v(xbgr.mr_n81379408)
print v(xbgr.mr_n81024704)
print v(xbgr.mr_n81800736)
print v(xbgr.mr_n75419552)
print v(xbgr.mr_n75453696)
print v(xbgr.mr_n75395232)
print v(xbgr.mr_n75970400)
print v(xbgr.mr_n76041424)
print v(xbgr.mr_n76120544)
print v(xbgr.mr_n75461344)
print v(xbgr.mr_n76215152)
print v(xbgr.mr_n76285136)
print v(xbgr.mr_n76397104)
print v(xbgr.mr_n76524432)
print v(xbgr.mr_n76681456)
print v(xbgr.mr_n76732608)
print v(xbgr.mr_n77106736)
print v(xbgr.mr_n77177312)
print v(xbgr.mr_n77309472)
print v(xbgr.mr_n77458512)
print v(xbgr.mr_n77584192)
print v(xbgr.mr_n77708128)
print v(xbgr.mr_n77879296)
print v(xbgr.mr_n78104320)
print v(xbgr.mr_n75420368)
print v(xbgr.mr_n75454288)
print v(xbgr.mr_n75734336)
print v(xbgr.mr_n75970992)
print v(xbgr.mr_n76076976)
print v(xbgr.mr_n76120368)
print v(xbgr.mr_n76144352)
print v(xbgr.mr_n75312624)
print v(xbgr.mr_n76372320)
print v(xbgr.mr_n76485936)
print v(xbgr.mr_n76556256)
print v(xbgr.mr_n76694384)
print v(xbgr.mr_n76799504)
print v(xbgr.mr_n77109456)
print v(xbgr.mr_n77228880)
print v(xbgr.mr_n77397392)
print v(xbgr.mr_n77516528)
print v(xbgr.mr_n77709360)
print v(xbgr.mr_n77820944)
print v(xbgr.mr_n77924608)
print v(xbgr.mr_n78100304)
print v(xbgr.mr_n75420640)
print v(xbgr.mr_n75454880)
print v(xbgr.n_3)
print v(xbgr.n_33)
print v(xbgr.mr_n75421184)
print v(xbgr.mr_n75455472)
print v(xbgr.mr_n75735520)
print v(xbgr.mr_n75972176)
print v(xbgr.mr_n75402656)
print v(xbgr.mr_n75456064)
print v(xbgr.mr_n75736112)
print v(xbgr.mr_n75972768)
print v(xbgr.mr_n75423120)
print v(xbgr.mr_n75456656)
print v(xbgr.mr_n75736704)
print v(xbgr.mr_n75973360)
print v(xbgr.mr_n76044000)
print v(xbgr.mr_n76121600)
print v(xbgr.mr_n75231088)
print v(xbgr.mr_n76269904)
print v(xbgr.mr_n76340448)
print v(xbgr.mr_n76452416)
print v(xbgr.mr_n76557152)
print v(xbgr.mr_n76680784)
print v(xbgr.mr_n76794480)
print v(xbgr.mr_n76968176)
print v(xbgr.mr_n77107152)
print v(xbgr.mr_n77142480)
print v(xbgr.mr_n77397216)
print v(xbgr.mr_n77519104)
print v(xbgr.mr_n77682336)
print v(xbgr.mr_n77824560)
print v(xbgr.mr_n77930032)
print v(xbgr.mr_n78106608)
print v(xbgr.mr_n78455504)
print v(xbgr.mr_n78650240)
print v(xbgr.mr_n78854096)
print v(xbgr.mr_n78981728)
print v(xbgr.mr_n79119616)
print v(xbgr.mr_n79337984)
print v(xbgr.mr_n79539104)
print v(xbgr.mr_n79703408)
print v(xbgr.mr_n79912912)
print v(xbgr.mr_n80084208)
print v(xbgr.mr_n80276544)
print v(xbgr.mr_n80465040)
print v(xbgr.mr_n80685328)
print v(xbgr.mr_n80871504)
print v(xbgr.mr_n81179264)
print v(xbgr.mr_n81350432)
print v(xbgr.mr_n81584528)
print v(xbgr.mr_n81773008)
print v(xbgr.mr_n76050656)
print v(xbgr.mr_n76096048)
print v(xbgr.mr_n75922288)
print v(xbgr.mr_n76215616)
print v(xbgr.mr_n76284672)
print v(xbgr.mr_n75948384)
print v(xbgr.mr_n76523968)
print v(xbgr.mr_n76682768)
print v(xbgr.mr_n76734000)
print v(xbgr.mr_n76968368)
print v(xbgr.mr_n77103776)
print v(xbgr.mr_n77176720)
print v(xbgr.mr_n77308880)
print v(xbgr.mr_n77460288)
print v(xbgr.mr_n77583600)
print v(xbgr.mr_n77708864)
print v(xbgr.mr_n77881072)
print v(xbgr.mr_n78104432)
print v(xbgr.mr_n75423584)
print v(xbgr.n_19)
print v(xbgr.mr_n75737296)
print v(xbgr.mr_n75973952)
print v(xbgr.mr_n76078432)
print v(xbgr.mr_n76129088)
print v(xbgr.mr_n76146160)
print v(xbgr.mr_n76247184)
print v(xbgr.mr_n76373120)
print v(xbgr.mr_n76486336)
print v(xbgr.mr_n76559120)
print v(xbgr.mr_n76695840)
print v(xbgr.mr_n76800304)
print v(xbgr.mr_n76978880)
print v(xbgr.mr_n77085648)
print v(xbgr.mr_n77230608)
print v(xbgr.mr_n77398192)
print v(xbgr.mr_n77519904)
print v(xbgr.mr_n77707024)
print v(xbgr.mr_n77814384)
print v(xbgr.mr_n77933760)
print v(xbgr.mr_n78102480)
print v(xbgr.mr_n75424512)
print v(xbgr.mr_n75412016)
print v(xbgr.mr_n75737888)
print v(xbgr.mr_n75974544)
print v(xbgr.mr_n75425440)
print v(xbgr.mr_n75458352)
print v(xbgr.mr_n75640512)
print v(xbgr.mr_n75975136)
print v(xbgr.mr_n75426832)
print v(xbgr.mr_n75459024)
print v(xbgr.mr_n75739072)
print v(xbgr.mr_n75975728)
print v(xbgr.mr_n75426368)
print v(xbgr.mr_n75459616)
print v(xbgr.mr_n75727056)
print v(xbgr.mr_n75976320)
print v(xbgr.mr_n76048688)
print v(xbgr.mr_n76128416)
print v(xbgr.mr_n75954480)
print v(xbgr.mr_n75478064)
print v(xbgr.mr_n76341776)
print v(xbgr.mr_n76453600)
print v(xbgr.mr_n76553904)
print v(xbgr.mr_n76681280)
print v(xbgr.mr_n76770944)
print v(xbgr.mr_n76971040)
print v(xbgr.mr_n77108800)
print v(xbgr.mr_n77223968)
print v(xbgr.mr_n77396416)
print v(xbgr.mr_n77501792)
print v(xbgr.mr_n77682928)
print v(xbgr.mr_n77822640)
print v(xbgr.mr_n77930144)
print v(xbgr.mr_n78108672)
print v(xbgr.mr_n75425904)
print v(xbgr.mr_n75460208)
print v(xbgr.mr_n75740256)
print v(xbgr.mr_n75976912)
print v(xbgr.mr_n78452208)
print v(xbgr.mr_n78655024)
print v(xbgr.mr_n78850512)
print v(xbgr.mr_n78981264)
print v(xbgr.mr_n79137328)
print v(xbgr.mr_n79315248)
print v(xbgr.mr_n79551072)
print v(xbgr.mr_n79693136)
print v(xbgr.mr_n79817728)
print v(xbgr.mr_n80087408)
print v(xbgr.mr_n80272480)
print v(xbgr.mr_n80495200)
print v(xbgr.mr_n80675472)
print v(xbgr.mr_n80878048)
print v(xbgr.mr_n81196928)
print v(xbgr.mr_n81332128)
print v(xbgr.mr_n81562448)
print v(xbgr.mr_n81831392)
print v(xbgr.mr_n76054736)
print v(xbgr.mr_n76095776)
print v(xbgr.mr_n75197328)
print v(xbgr.mr_n76214688)
print v(xbgr.mr_n76283744)
print v(xbgr.mr_n76406976)
print v(xbgr.mr_n76523040)
print v(xbgr.mr_n76683424)
print v(xbgr.mr_n76770608)
print v(xbgr.mr_n76977744)
print v(xbgr.mr_n77110864)
print v(xbgr.mr_n77175536)
print v(xbgr.mr_n77307696)
print v(xbgr.mr_n77462064)
print v(xbgr.mr_n77582416)
print v(xbgr.mr_n77711184)
print v(xbgr.mr_n77882848)
print v(xbgr.mr_n78104544)
print v(xbgr.mr_n75424976)
print v(xbgr.mr_n75245808)
print v(xbgr.mr_n75732560)
print v(xbgr.mr_n75977504)
print v(xbgr.mr_n76079488)
print v(xbgr.mr_n76131184)
print v(xbgr.mr_n76147968)
print v(xbgr.mr_n76136720)
print v(xbgr.mr_n76373520)
print v(xbgr.mr_n76486736)
print v(xbgr.mr_n76558416)
print v(xbgr.mr_n76696720)
print v(xbgr.mr_n76801104)
print v(xbgr.mr_n76982544)
print v(xbgr.mr_n77113504)
print v(xbgr.mr_n77232496)
print v(xbgr.mr_n77375152)
print v(xbgr.mr_n77520704)
print v(xbgr.mr_n77713648)
print v(xbgr.mr_n77826368)
print v(xbgr.mr_n77935456)
print v(xbgr.mr_n78108448)
print v(xbgr.mr_n75424048)
print v(xbgr.mr_n75266928)
print v(xbgr.mr_n75741440)
print v(xbgr.mr_n75978096)
print v(xbgr.mr_n75422656)
print v(xbgr.mr_n75280304)
print v(xbgr.n_4)
print v(xbgr.n_30)
print v(xbgr.mr_n75422192)
print v(xbgr.mr_n75293680)
print v(xbgr.mr_n75742624)
print v(xbgr.mr_n75979280)
print v(xbgr.mr_n75421456)
print v(xbgr.mr_n75264112)
print v(xbgr.mr_n75743216)
print v(xbgr.mr_n75979872)
print v(xbgr.mr_n76046416)
print v(xbgr.mr_n76133424)
print v(xbgr.mr_n75871344)
print v(xbgr.mr_n76188032)
print v(xbgr.mr_n76346592)
print v(xbgr.mr_n76454784)
print v(xbgr.mr_n76562096)
print v(xbgr.mr_n76680320)
print v(xbgr.mr_n76707968)
print v(xbgr.mr_n76969072)
print v(xbgr.mr_n77107904)
print v(xbgr.mr_n77207904)
print v(xbgr.mr_n77394816)
print v(xbgr.mr_n77520528)
print v(xbgr.mr_n77681744)
print v(xbgr.mr_n77817168)
print v(xbgr.mr_n77931952)
print v(xbgr.mr_n78108560)
print v(xbgr.mr_n78431536)
print v(xbgr.mr_n78660800)
print v(xbgr.mr_n78865168)
print v(xbgr.mr_n78993872)
print v(xbgr.mr_n79155952)
print v(xbgr.mr_n79356112)
print v(xbgr.mr_n79548848)
print v(xbgr.mr_n79658816)
print v(xbgr.mr_n79821152)
print v(xbgr.mr_n80118720)
print v(xbgr.mr_n80253280)
print v(xbgr.mr_n80500176)
print v(xbgr.mr_n80680368)
print v(xbgr.mr_n80883024)
print v(xbgr.mr_n81197040)
print v(xbgr.mr_n81358272)
print v(xbgr.mr_n81585952)
print v(xbgr.mr_n81753440)
print v(xbgr.mr_n75418192)
print v(xbgr.mr_n75275376)
print v(xbgr.mr_n75743808)
print v(xbgr.mr_n75980464)
print v(xbgr.mr_n76055648)
print v(xbgr.mr_n76095504)
print v(xbgr.mr_n75282624)
print v(xbgr.mr_n76214224)
print v(xbgr.mr_n76283280)
print v(xbgr.mr_n76408256)
print v(xbgr.mr_n76522576)
print v(xbgr.mr_n76682112)
print v(xbgr.mr_n76714304)
print v(xbgr.mr_n76325520)
print v(xbgr.mr_n77105840)
print v(xbgr.mr_n77174944)
print v(xbgr.mr_n77307104)
print v(xbgr.mr_n77463840)
print v(xbgr.mr_n77581824)
print v(xbgr.mr_n77712896)
print v(xbgr.mr_n77884624)
print v(xbgr.mr_n78110512)
print v(xbgr.mr_n75420096)
print v(xbgr.mr_n75292272)
print v(xbgr.mr_n75733744)
print v(xbgr.mr_n75981056)
print v(xbgr.mr_n76081344)
print v(xbgr.mr_n76134224)
print v(xbgr.mr_n76149776)
print v(xbgr.mr_n76137456)
print v(xbgr.mr_n76372720)
print v(xbgr.mr_n76487136)
print v(xbgr.mr_n76559760)
print v(xbgr.mr_n76697696)
print v(xbgr.mr_n76801664)
print v(xbgr.mr_n76984352)
print v(xbgr.mr_n77115648)
print v(xbgr.mr_n77234304)
print v(xbgr.mr_n77399792)
print v(xbgr.mr_n77521504)
print v(xbgr.mr_n77714528)
print v(xbgr.mr_n77824448)
print v(xbgr.mr_n77928336)
print v(xbgr.mr_n78106384)
print v(xbgr.mr_n75419824)
print v(xbgr.mr_n75414304)
print v(xbgr.mr_n75744992)
print v(xbgr.mr_n75981648)
print v(xbgr.mr_n75414192)
print v(xbgr.mr_n75287344)
print v(xbgr.mr_n75734928)
print v(xbgr.mr_n75982240)
print v(xbgr.mr_n75418736)
print v(xbgr.mr_n75242288)
print v(xbgr.mr_n75746112)
print v(xbgr.mr_n75858464)
print v(xbgr.mr_n76051408)
print v(xbgr.mr_n76132784)
print v(xbgr.mr_n76137792)
print v(xbgr.mr_n76217024)
print v(xbgr.mr_n76347920)
print v(xbgr.mr_n76455968)
print v(xbgr.mr_n76564128)
print v(xbgr.mr_n76679392)
print v(xbgr.mr_n76797728)
print v(xbgr.mr_n76941728)
print v(xbgr.mr_n77112032)
print v(xbgr.mr_n77218960)
print v(xbgr.mr_n77378448)
print v(xbgr.mr_n77494976)
print v(xbgr.mr_n77680560)
print v(xbgr.mr_n77828176)
print v(xbgr.mr_n77937264)
print v(xbgr.mr_n78106496)
print v(xbgr.mr_n75212096)
print v(xbgr.mr_n75272560)
print v(xbgr.mr_n75745584)
print v(xbgr.mr_n75983344)
print v(xbgr.mr_n78445152)
print v(xbgr.mr_n78653584)
print v(xbgr.mr_n78861648)
print v(xbgr.mr_n79010640)
print v(xbgr.mr_n79149360)
print v(xbgr.mr_n79343680)
print v(xbgr.mr_n79544800)
print v(xbgr.mr_n79700608)
print v(xbgr.mr_n76798528)
print v(xbgr.mr_n79821264)
print v(xbgr.mr_n80115824)
print v(xbgr.mr_n80260032)
print v(xbgr.mr_n80492688)
print v(xbgr.mr_n80670576)
print v(xbgr.mr_n80888000)
print v(xbgr.mr_n81204464)
print v(xbgr.mr_n81364400)
print v(xbgr.mr_n81589520)
print v(xbgr.mr_n81810560)
print v(xbgr.mr_n76059728)
print v(xbgr.mr_n76095232)
print v(xbgr.mr_n75329952)
print v(xbgr.mr_n76213296)
print v(xbgr.mr_n76282352)
print v(xbgr.mr_n76409264)
print v(xbgr.mr_n76521648)
print v(xbgr.mr_n76680896)
print v(xbgr.mr_n76903024)
print v(xbgr.mr_n77098352)
print v(xbgr.mr_n77173760)
print v(xbgr.mr_n77305920)
print v(xbgr.mr_n77463008)
print v(xbgr.mr_n77580640)
print v(xbgr.mr_n77711296)
print v(xbgr.mr_n77933648)
print v(xbgr.mr_n78114640)
print v(xbgr.mr_n75417648)
print v(xbgr.mr_n75270480)
print v(xbgr.mr_n75747360)
print v(xbgr.mr_n75984000)
print v(xbgr.mr_n76082800)
print v(xbgr.mr_n76135024)
print v(xbgr.mr_n76151584)
print v(xbgr.mr_n76225072)
print v(xbgr.mr_n76371920)
print v(xbgr.mr_n76487536)
print v(xbgr.mr_n76563904)
print v(xbgr.mr_n76698576)
print v(xbgr.mr_n76800928)
print v(xbgr.mr_n76986080)
print v(xbgr.mr_n77117712)
print v(xbgr.mr_n77236032)
print v(xbgr.mr_n77400592)
print v(xbgr.mr_n77522304)
print v(xbgr.mr_n77716912)
print v(xbgr.mr_n77829872)
print v(xbgr.mr_n77939184)
print v(xbgr.mr_n78112576)
print v(xbgr.mr_n75417104)
print v(xbgr.mr_n75250032)
print v(xbgr.mr_n75747952)
print v(xbgr.mr_n75984592)
print v(xbgr.mr_n75416560)
print v(xbgr.mr_n75241584)
print v(xbgr.mr_n75748544)
print v(xbgr.mr_n75985184)
print v(xbgr.mr_n75416016)
print v(xbgr.mr_n75244400)
print v(xbgr.n_5)
print v(xbgr.mr_n75985776)
print v(xbgr.mr_n75415200)
print v(xbgr.mr_n75271152)
print v(xbgr.mr_n75749728)
print v(xbgr.mr_n75965664)
print v(xbgr.mr_n76058672)
print v(xbgr.mr_n76124544)
print v(xbgr.mr_n76144864)
print v(xbgr.mr_n75257984)
print v(xbgr.mr_n76322000)
print v(xbgr.mr_n76457152)
print v(xbgr.mr_n76562208)
print v(xbgr.mr_n76678656)
print v(xbgr.mr_n76822208)
print v(xbgr.mr_n76937984)
print v(xbgr.mr_n77114096)
print v(xbgr.mr_n77225776)
print v(xbgr.mr_n77399616)
print v(xbgr.mr_n77515728)
print v(xbgr.mr_n77679376)
print v(xbgr.mr_n77829984)
print v(xbgr.mr_n77940992)
print v(xbgr.mr_n78112688)
print v(xbgr.mr_n78201328)
print v(xbgr.mr_n78564368)
print v(xbgr.mr_n78888464)
print v(xbgr.mr_n79005088)
print v(xbgr.mr_n79175152)
print v(xbgr.mr_n79332544)
print v(xbgr.mr_n79533664)
print v(xbgr.mr_n79711360)
print v(xbgr.mr_n76822880)
print v(xbgr.mr_n79809904)
print v(xbgr.mr_n80120912)
print v(xbgr.mr_n80256800)
print v(xbgr.mr_n80483488)
print v(xbgr.mr_n80685840)
print v(xbgr.mr_n80900848)
print v(xbgr.mr_n81216944)
print v(xbgr.mr_n81369056)
print v(xbgr.mr_n81584064)
print v(xbgr.mr_n81809888)
print v(xbgr.mr_n75414928)
print v(xbgr.mr_n75285936)
print v(xbgr.mr_n75739664)
print v(xbgr.mr_n75986880)
print v(xbgr.mr_n76058784)
print v(xbgr.mr_n76094960)
print v(xbgr.mr_n75327520)
print v(xbgr.mr_n76212832)
print v(xbgr.mr_n76281888)
print v(xbgr.mr_n76410192)
print v(xbgr.mr_n76521264)
print v(xbgr.mr_n76679968)
print v(xbgr.mr_n76812016)
print v(xbgr.mr_n77109968)
print v(xbgr.mr_n77173168)
print v(xbgr.mr_n77305328)
print v(xbgr.mr_n77466928)
print v(xbgr.mr_n77580048)
print v(xbgr.mr_n77710304)
print v(xbgr.mr_n77939072)
print v(xbgr.mr_n78110624)
print v(xbgr.mr_n75413648)
print v(xbgr.mr_n75273968)
print v(xbgr.mr_n75750912)
print v(xbgr.mr_n75987552)
print v(xbgr.mr_n76084256)
print v(xbgr.mr_n76135824)
print v(xbgr.mr_n76153392)
print v(xbgr.mr_n76193152)
print v(xbgr.mr_n76371120)
print v(xbgr.mr_n76487936)
print v(xbgr.mr_n76569088)
print v(xbgr.mr_n76699552)
print v(xbgr.mr_n76825952)
print v(xbgr.mr_n76987968)
print v(xbgr.mr_n77117056)
print v(xbgr.mr_n77237840)
print v(xbgr.mr_n77401392)
print v(xbgr.mr_n77523104)
print v(xbgr.mr_n77717872)
print v(xbgr.mr_n77826256)
print v(xbgr.mr_n77931840)
print v(xbgr.mr_n78110736)
print v(xbgr.mr_n75374816)
print v(xbgr.mr_n75571872)
print v(xbgr.mr_n75740848)
print v(xbgr.mr_n75988144)
print v(xbgr.mr_n75375280)
print v(xbgr.mr_n75582016)
print v(xbgr.mr_n75752096)
print v(xbgr.mr_n75988736)
print v(xbgr.mr_n75375744)
print v(xbgr.mr_n75582608)
print v(xbgr.mr_n75744400)
print v(xbgr.mr_n75989328)
print v(xbgr.mr_n75376208)
print v(xbgr.mr_n75583200)
print v(xbgr.mr_n75753280)
print v(xbgr.mr_n75989920)
print v(xbgr.mr_n76053680)
print v(xbgr.mr_n76134048)
print v(xbgr.mr_n76137568)
print v(xbgr.mr_n76216704)
print v(xbgr.mr_n76322256)
print v(xbgr.mr_n76458336)
print v(xbgr.mr_n76568336)
print v(xbgr.mr_n76629712)
print v(xbgr.mr_n76770432)
print v(xbgr.mr_n76968560)
print v(xbgr.mr_n77112928)
print v(xbgr.mr_n77231200)
print v(xbgr.mr_n77401216)
print v(xbgr.mr_n77522128)
print v(xbgr.mr_n77678192)
print v(xbgr.mr_n77831792)
print v(xbgr.mr_n77942800)
print v(xbgr.mr_n78118768)
print v(xbgr.mr_n74623888)
print v(xbgr.mr_n78604144)
print v(xbgr.mr_n78867488)
print v(xbgr.mr_n78998464)
print v(xbgr.mr_n79146176)
print v(xbgr.mr_n79321408)
print v(xbgr.mr_n79530288)
print v(xbgr.mr_n79715824)
print v(xbgr.mr_n76822720)
print v(xbgr.mr_n79815584)
print v(xbgr.mr_n80125776)
print v(xbgr.mr_n80279696)
print v(xbgr.mr_n80471744)
print v(xbgr.mr_n80659312)
print v(xbgr.mr_n80897952)
print v(xbgr.mr_n81206672)
print v(xbgr.mr_n81387680)
print v(xbgr.mr_n81585040)
print v(xbgr.mr_n81825536)
print v(xbgr.mr_n76053792)
print v(xbgr.mr_n76094688)
print v(xbgr.mr_n75226224)
print v(xbgr.mr_n76211904)
print v(xbgr.mr_n76280960)
print v(xbgr.mr_n76409728)
print v(xbgr.mr_n76520656)
print v(xbgr.mr_n76678880)
print v(xbgr.mr_n76902736)
print v(xbgr.mr_n77114992)
print v(xbgr.mr_n77172176)
print v(xbgr.mr_n77304336)
print v(xbgr.mr_n77467536)
print v(xbgr.mr_n77578864)
print v(xbgr.mr_n77716080)
print v(xbgr.mr_n77940880)
print v(xbgr.mr_n78114752)
print v(xbgr.mr_n75376672)
print v(xbgr.mr_n75575504)
print v(xbgr.mr_n75753872)
print v(xbgr.mr_n75990512)
print v(xbgr.mr_n75377136)
print v(xbgr.mr_n75584384)
print v(xbgr.mr_n75754464)
print v(xbgr.mr_n75991104)
print v(xbgr.mr_n76085312)
print v(xbgr.mr_n75949488)
print v(xbgr.mr_n76155200)
print v(xbgr.mr_n76197184)
print v(xbgr.mr_n76370320)
print v(xbgr.mr_n76488336)
print v(xbgr.mr_n76571488)
print v(xbgr.mr_n76700192)
print v(xbgr.mr_n76796128)
print v(xbgr.mr_n76989776)
print v(xbgr.mr_n77121840)
print v(xbgr.mr_n77239648)
print v(xbgr.mr_n77402192)
print v(xbgr.mr_n77523904)
print v(xbgr.mr_n77719536)
print v(xbgr.mr_n77831680)
print v(xbgr.mr_n77942688)
print v(xbgr.mr_n78116704)
print v(xbgr.mr_n75377600)
print v(xbgr.mr_n75579056)
print v(xbgr.mr_n75755056)
print v(xbgr.mr_n75991696)
print v(xbgr.mr_n75378064)
print v(xbgr.mr_n75570768)
print v(xbgr.mr_n75752688)
print v(xbgr.mr_n75992288)
print v(xbgr.mr_n75378528)
print v(xbgr.mr_n75586080)
print v(xbgr.mr_n75738480)
print v(xbgr.n_31)
print v(xbgr.mr_n76048800)
print v(xbgr.mr_n76135648)
print v(xbgr.mr_n76148480)
print v(xbgr.mr_n76200320)
print v(xbgr.mr_n75948112)
print v(xbgr.mr_n76459520)
print v(xbgr.mr_n76572320)
print v(xbgr.mr_n76678144)
print v(xbgr.mr_n76834016)
print v(xbgr.mr_n76981888)
print v(xbgr.mr_n77120288)
print v(xbgr.mr_n77227584)
print v(xbgr.mr_n77400416)
print v(xbgr.mr_n77523728)
print v(xbgr.mr_n77677008)
print v(xbgr.mr_n77833600)
print v(xbgr.mr_n77942912)
print v(xbgr.mr_n78116928)
print v(xbgr.mr_n75378992)
print v(xbgr.mr_n75583792)
print v(xbgr.mr_n75756832)
print v(xbgr.mr_n75993472)
print v(xbgr.mr_n78436832)
print v(xbgr.mr_n78585728)
print v(xbgr.mr_n78856416)
print v(xbgr.mr_n78987328)
print v(xbgr.mr_n79136864)
print v(xbgr.mr_n79310272)
print v(xbgr.mr_n79504224)
print v(xbgr.mr_n79700352)
print v(xbgr.mr_n76844272)
print v(xbgr.mr_n79817840)
print v(xbgr.mr_n80138624)
print v(xbgr.mr_n80259648)
print v(xbgr.mr_n80455520)
print v(xbgr.mr_n80647936)
print v(xbgr.mr_n80902928)
print v(xbgr.mr_n81181152)
print v(xbgr.mr_n81401648)
print v(xbgr.mr_n81585760)
print v(xbgr.mr_n81818752)
print v(xbgr.mr_n76048992)
print v(xbgr.mr_n76094496)
print v(xbgr.mr_n75548064)
print v(xbgr.mr_n76211440)
print v(xbgr.mr_n76280496)
print v(xbgr.mr_n76408800)
print v(xbgr.mr_n76520352)
print v(xbgr.mr_n76605584)
print v(xbgr.mr_n76887248)
print v(xbgr.mr_n77121184)
print v(xbgr.mr_n77171712)
print v(xbgr.mr_n77303872)
print v(xbgr.mr_n77467200)
print v(xbgr.mr_n77578272)
print v(xbgr.mr_n77719040)
print v(xbgr.mr_n77944752)
print v(xbgr.mr_n78114864)
print v(xbgr.mr_n75379456)
print v(xbgr.mr_n75587264)
print v(xbgr.mr_n75746768)
print v(xbgr.mr_n75994064)
print v(xbgr.mr_n76086688)
print v(xbgr.mr_n75274880)
print v(xbgr.mr_n76157008)
print v(xbgr.mr_n76137184)
print v(xbgr.mr_n76369520)
print v(xbgr.mr_n76488736)
print v(xbgr.mr_n76554016)
print v(xbgr.mr_n76701408)
print v(xbgr.mr_n76828880)
print v(xbgr.mr_n76991584)
print v(xbgr.mr_n77123904)
print v(xbgr.mr_n77241536)
print v(xbgr.mr_n77402992)
print v(xbgr.mr_n77524704)
print v(xbgr.mr_n77721200)
print v(xbgr.mr_n77828064)
print v(xbgr.mr_n77937376)
print v(xbgr.mr_n78112800)
print v(xbgr.mr_n75379920)
print v(xbgr.mr_n75587936)
print v(xbgr.mr_n75758016)
print v(xbgr.mr_n75994656)
print v(xbgr.mr_n75380384)
print v(xbgr.n_34)
print v(xbgr.mr_n75750320)
print v(xbgr.mr_n75986368)
print v(xbgr.mr_n75380848)
print v(xbgr.mr_n75589056)
print v(xbgr.mr_n75759200)
print v(xbgr.mr_n75995760)
print v(xbgr.mr_n75381312)
print v(xbgr.mr_n75585488)
print v(xbgr.mr_n75759792)
print v(xbgr.mr_n75996432)
print v(xbgr.mr_n76043696)
print v(xbgr.mr_n76121248)
print v(xbgr.mr_n76153904)
print v(xbgr.mr_n76220816)
print v(xbgr.mr_n76286064)
print v(xbgr.mr_n76460704)
print v(xbgr.mr_n76572208)
print v(xbgr.mr_n76677328)
print v(xbgr.mr_n76833728)
print v(xbgr.mr_n76979520)
print v(xbgr.mr_n77083168)
print v(xbgr.mr_n77238432)
print v(xbgr.mr_n77378560)
print v(xbgr.mr_n77491056)
print v(xbgr.mr_n77608992)
print v(xbgr.mr_n77838912)
print v(xbgr.mr_n77944976)
print v(xbgr.mr_n78118992)
print v(xbgr.mr_n78436560)
print v(xbgr.mr_n78618960)
print v(xbgr.mr_n78845280)
print v(xbgr.mr_n78950384)
print v(xbgr.mr_n79155488)
print v(xbgr.mr_n79299136)
print v(xbgr.mr_n79468320)
print v(xbgr.mr_n79727840)
print v(xbgr.mr_n76849168)
print v(xbgr.mr_n79815392)
print v(xbgr.mr_n80135728)
print v(xbgr.mr_n80259840)
print v(xbgr.mr_n80450272)
print v(xbgr.mr_n80651872)
print v(xbgr.mr_n80907904)
print v(xbgr.mr_n81181664)
print v(xbgr.mr_n81404944)
print v(xbgr.mr_n81497744)
print v(xbgr.mr_n81801024)
print v(xbgr.mr_n75381776)
print v(xbgr.mr_n75590304)
print v(xbgr.mr_n75760384)
print v(xbgr.mr_n75997024)
print v(xbgr.mr_n76043808)
print v(xbgr.mr_n76092832)
print v(xbgr.mr_n75204832)
print v(xbgr.mr_n76210512)
print v(xbgr.mr_n76279568)
print v(xbgr.mr_n76408528)
print v(xbgr.mr_n76410656)
print v(xbgr.mr_n76605280)
print v(xbgr.mr_n76882448)
print v(xbgr.mr_n77118224)
print v(xbgr.mr_n77170784)
print v(xbgr.mr_n77302944)
print v(xbgr.mr_n77466656)
print v(xbgr.mr_n77577152)
print v(xbgr.mr_n77720048)
print v(xbgr.mr_n77948880)
print v(xbgr.mr_n78120832)
print v(xbgr.mr_n75382240)
print v(xbgr.mr_n75584976)
print v(xbgr.mr_n75760976)
print v(xbgr.mr_n75997616)
print v(xbgr.mr_n76088224)
print v(xbgr.mr_n75230720)
print v(xbgr.mr_n76158816)
print v(xbgr.mr_n76225328)
print v(xbgr.mr_n76354064)
print v(xbgr.mr_n76489136)
print v(xbgr.mr_n76574016)
print v(xbgr.mr_n76702288)
print v(xbgr.mr_n76828992)
print v(xbgr.mr_n76993392)
print v(xbgr.mr_n77125968)
print v(xbgr.mr_n77243344)
print v(xbgr.mr_n77403792)
print v(xbgr.mr_n77525504)
print v(xbgr.mr_n77722880)
print v(xbgr.mr_n77835296)
print v(xbgr.mr_n77935568)
print v(xbgr.mr_n78116816)
print v(xbgr.mr_n75382704)
print v(xbgr.mr_n75591408)
print v(xbgr.mr_n75761568)
print v(xbgr.mr_n75998208)
print v(xbgr.mr_n75383168)
print v(xbgr.mr_n75592080)
print v(xbgr.mr_n75751504)
print v(xbgr.mr_n75998800)
print v(xbgr.mr_n75383632)
print v(xbgr.mr_n75592672)
print v(xbgr.mr_n75762752)
print v(xbgr.mr_n75999392)
print v(xbgr.mr_n75368000)
print v(xbgr.mr_n75593264)
print v(xbgr.n_10)
print v(xbgr.mr_n75999984)
print v(xbgr.mr_n76038704)
print v(xbgr.mr_n76132384)
print v(xbgr.mr_n76139504)
print v(xbgr.mr_n76248304)
print v(xbgr.mr_n76321744)
print v(xbgr.mr_n76461888)
print v(xbgr.mr_n76566560)
print v(xbgr.mr_n76597280)
print v(xbgr.mr_n76835408)
print v(xbgr.mr_n76986672)
print v(xbgr.mr_n77119120)
print v(xbgr.mr_n77240240)
print v(xbgr.mr_n77402016)
print v(xbgr.mr_n77525328)
print v(xbgr.mr_n77522928)
print v(xbgr.mr_n77833488)
print v(xbgr.mr_n77947040)
print v(xbgr.mr_n78124080)
print v(xbgr.mr_n78326784)
print v(xbgr.mr_n78616848)
print v(xbgr.mr_n78608144)
print v(xbgr.mr_n78965760)
print v(xbgr.mr_n79160144)
print v(xbgr.mr_n79289584)
print v(xbgr.mr_n79492512)
print v(xbgr.mr_n79732928)
print v(xbgr.mr_n76853648)
print v(xbgr.mr_n79814816)
print v(xbgr.mr_n80148576)
print v(xbgr.mr_n80262032)
print v(xbgr.mr_n80437008)
print v(xbgr.mr_n80656928)
print v(xbgr.mr_n80912880)
print v(xbgr.mr_n81144512)
print v(xbgr.mr_n81276512)
print v(xbgr.mr_n81477008)
print v(xbgr.mr_n81818112)
print v(xbgr.mr_n76038816)
print v(xbgr.mr_n76090960)
print v(xbgr.mr_n75949856)
print v(xbgr.mr_n76210048)
print v(xbgr.mr_n76279104)
print v(xbgr.mr_n76302848)
print v(xbgr.mr_n76407680)
print v(xbgr.mr_n76574240)
print v(xbgr.mr_n76881360)
print v(xbgr.mr_n77116160)
print v(xbgr.mr_n77170320)
print v(xbgr.mr_n77302480)
print v(xbgr.mr_n77454128)
print v(xbgr.mr_n77576688)
print v(xbgr.mr_n77721792)
print v(xbgr.mr_n77946928)
print v(xbgr.mr_n78127584)
print v(xbgr.mr_n75384560)
print v(xbgr.mr_n75593856)
print v(xbgr.mr_n75763936)
print v(xbgr.mr_n76000576)
print v(xbgr.mr_n75385024)
print v(xbgr.mr_n75586752)
print v(xbgr.mr_n75756240)
print v(xbgr.mr_n75953456)
print v(xbgr.mr_n76090080)
print v(xbgr.mr_n76134848)
print v(xbgr.mr_n76160624)
print v(xbgr.mr_n76222368)
print v(xbgr.mr_n76367920)
print v(xbgr.mr_n76489536)
print v(xbgr.mr_n76569984)
print v(xbgr.mr_n76703264)
print v(xbgr.mr_n76823552)
print v(xbgr.mr_n76995200)
print v(xbgr.mr_n77127952)
print v(xbgr.mr_n77245072)
print v(xbgr.mr_n77404592)
print v(xbgr.mr_n77526304)
print v(xbgr.mr_n77724224)
print v(xbgr.mr_n77840720)
print v(xbgr.mr_n77946816)
print v(xbgr.mr_n78120944)
print v(xbgr.mr_n75385488)
print v(xbgr.mr_n75595040)
print v(xbgr.mr_n75765120)
print v(xbgr.mr_n75254256)
print v(xbgr.mr_n75367536)
print v(xbgr.mr_n75588528)
print v(xbgr.mr_n75765712)
print v(xbgr.mr_n76000320)
print v(xbgr.mr_n75386416)
print v(xbgr.mr_n75561136)
print v(xbgr.mr_n75766304)
print v(xbgr.mr_n75560240)
print v(xbgr.mr_n75860832)
print v(xbgr.mr_n75235584)
print v(xbgr.mr_n76152096)
print v(xbgr.mr_n76220480)
print v(xbgr.mr_n76216192)
print v(xbgr.mr_n76463072)
print v(xbgr.mr_n76579232)
print v(xbgr.mr_n76652784)
print v(xbgr.mr_n76844448)
print v(xbgr.mr_n76984864)
print v(xbgr.mr_n77123248)
print v(xbgr.mr_n77178496)
print v(xbgr.mr_n77375856)
print v(xbgr.mr_n77518128)
print v(xbgr.mr_n77608288)
print v(xbgr.mr_n77835408)
print v(xbgr.mr_n77944864)
print v(xbgr.mr_n78128064)
print v(xbgr.mr_n75386880)
print v(xbgr.mr_n75590896)
print v(xbgr.mr_n75766896)
print v(xbgr.mr_n75722928)
print v(xbgr.mr_n74380272)
print v(xbgr.mr_n78607248)
print v(xbgr.mr_n78828368)
print v(xbgr.mr_n78961104)
print v(xbgr.mr_n79164800)
print v(xbgr.mr_n79256320)
print v(xbgr.mr_n79463600)
print v(xbgr.mr_n79737792)
print v(xbgr.mr_n76857088)
print v(xbgr.mr_n79815008)
print v(xbgr.mr_n80109232)
print v(xbgr.mr_n80224528)
print v(xbgr.mr_n80404272)
print v(xbgr.mr_n80643024)
print v(xbgr.mr_n80816544)
print v(xbgr.mr_n81138064)
print v(xbgr.mr_n81274480)
print v(xbgr.mr_n81558784)
print v(xbgr.mr_n81826752)
print v(xbgr.mr_n76034944)
print v(xbgr.mr_n76094032)
print v(xbgr.mr_n75520640)
print v(xbgr.mr_n76209120)
print v(xbgr.mr_n76136944)
print v(xbgr.mr_n76399648)
print v(xbgr.mr_n76466064)
print v(xbgr.mr_n76599536)
print v(xbgr.mr_n76944288)
print v(xbgr.mr_n77017536)
print v(xbgr.mr_n77146560)
print v(xbgr.mr_n77271296)
print v(xbgr.mr_n77464784)
print v(xbgr.mr_n77526128)
print v(xbgr.mr_n77718864)
print v(xbgr.mr_n77950944)
print v(xbgr.mr_n78123712)
print v(xbgr.mr_n75387344)
print v(xbgr.mr_n75594448)
print v(xbgr.mr_n75767488)
print v(xbgr.mr_n75559984)
print v(xbgr.mr_n76091136)
print v(xbgr.mr_n75321376)
print v(xbgr.mr_n76162352)
print v(xbgr.mr_n76268640)
print v(xbgr.mr_n76349968)
print v(xbgr.mr_n76489936)
print v(xbgr.mr_n76579008)
print v(xbgr.mr_n76703904)
print v(xbgr.mr_n76843728)
print v(xbgr.mr_n76996928)
print v(xbgr.mr_n77129840)
print v(xbgr.mr_n77246880)
print v(xbgr.mr_n77405392)
print v(xbgr.mr_n77527104)
print v(xbgr.mr_n77727088)
print v(xbgr.mr_n77842528)
print v(xbgr.mr_n77949104)
print v(xbgr.mr_n78121056)
print v(xbgr.mr_n75387808)
print v(xbgr.mr_n75552560)
print v(xbgr.mr_n75757424)
print v(xbgr.mr_n75720944)
print v(xbgr.mr_n75385952)
print v(xbgr.mr_n75556592)
print v(xbgr.mr_n75768672)
print v(xbgr.mr_n75857200)
print v(xbgr.mr_n75384096)
print v(xbgr.mr_n75594784)
print v(xbgr.mr_n75758608)
print v(xbgr.mr_n75953664)
print v(xbgr.mr_n75389200)
print v(xbgr.mr_n75296064)
print v(xbgr.mr_n75769856)
print v(xbgr.mr_n75874032)
print v(xbgr.mr_n75350848)
print v(xbgr.mr_n75566608)
print v(xbgr.mr_n75762160)
print v(xbgr.mr_n75957392)
print v(xbgr.mr_n75390128)
print v(xbgr.mr_n75580240)
print v(xbgr.mr_n75771040)
print v(xbgr.mr_n75953072)
print v(xbgr.mr_n75390592)
print v(xbgr.mr_n75505568)
print v(xbgr.mr_n75771632)
print v(xbgr.mr_n76001248)
print v(xbgr.mr_n75391056)
print v(xbgr.mr_n75559584)
print v(xbgr.mr_n75772224)
print v(xbgr.mr_n76001360)
print v(xbgr.mr_n76219936)
print v(xbgr.mr_n77726080)
print v(xbgr.mr_n77953232)
print v(xbgr.mr_n78131680)
print v(xbgr.mr_n75391520)
print v(xbgr.mr_n75595744)
print v(xbgr.mr_n75772816)
print v(xbgr.mr_n76002384)
print v(xbgr.d5)
print v(xbgr.d1)
print v(xbgr.mr_n76222256)
print v(xbgr.mr_n76579504)
print v(xbgr.mr_n76091760)
print v(xbgr.mr_n76157520)
print v(xbgr.mr_n76576976)
print v(xbgr.mr_n77724960)
print v(xbgr.n1)
print v(xbgr.mr_n78132048)
print v(xbgr.mr_n75391984)
print v(xbgr.mr_n75596160)
print v(xbgr.mr_n75773408)
print v(xbgr.mr_n76002928)
print v(xbgr.mr_n77518928)
print v(xbgr.mr_n77752064)
print v(xbgr.mr_n77964144)
print v(xbgr.mr_n76032160)
print v(xbgr.mr_n76124272)
print v(xbgr.kick)
print v(xbgr.mr_n76422976)
print v(xbgr.mr_n77724736)
print v(xbgr.mr_n77896064)
print v(xbgr.mr_n78131568)
print v(xbgr.mr_n75392448)
print v(xbgr.mr_n75596800)
print v(xbgr.mr_n75763344)
print v(xbgr.mr_n76003856)
print v(xbgr.mr_n75392912)
print v(xbgr.mr_n75597488)
print v(xbgr.mr_n75774592)
print v(xbgr.mr_n76004320)
print v(xbgr.mr_n76087888)
print v(xbgr.mr_n76162944)
print v(xbgr.mr_n76224192)
print v(xbgr.mr_n76576784)
print v(xbgr.mr_n77727680)
print v(xbgr.mr_n77948992)
print v(xbgr.mr_n78118880)
print v(xbgr.mr_n76702912)
print v(xbgr.mr_n76852032)
print v(xbgr.mr_n76915344)
print v(xbgr.mr_n76990288)
print v(xbgr.mr_n77234816)
print v(xbgr.mr_n77091248)
print v(xbgr.mr_n77353008)
print v(xbgr.mr_n76703088)
print v(xbgr.mr_n76854128)
print v(xbgr.mr_n76914560)
print v(xbgr.mr_n76995712)
print v(xbgr.mr_n77245664)
print v(xbgr.mr_n77374624)
print v(xbgr.mr_n77495680)
print v(xbgr.mr_n75393376)
print v(xbgr.mr_n75581424)
print v(xbgr.mr_n75764528)
print v(xbgr.mr_n76004784)
print v(xbgr.mr_n77724848)
print v(xbgr.mr_n77893936)
print v(xbgr.mr_n78135664)
print v(xbgr.mr_n76605968)
print v(xbgr.mr_n76735392)
print v(xbgr.mr_n76790240)
print v(xbgr.mr_n76936624)
print v(xbgr.mr_n77143872)
print v(xbgr.mr_n77270144)
print v(xbgr.mr_n77398816)
print v(xbgr.mr_n77539648)
print v(xbgr.mr_n77769744)
print v(xbgr.mr_n77972416)
print v(xbgr.mr_n75393840)
print v(xbgr.mr_n75505824)
print v(xbgr.mr_n75775712)
print v(xbgr.mr_n75952032)
print v(xbgr.mr_n77728336)
print v(xbgr.mr_n77896944)
print v(xbgr.mr_n78136032)
print v(xbgr.mr_n76246496)
print v(xbgr.mr_n76702112)
print v(xbgr.d2)
print v(xbgr.mr_n76926400)
print v(xbgr.mr_n76983056)
print v(xbgr.mr_n77243856)
print v(xbgr.mr_n77337888)
print v(xbgr.mr_n77455904)
print v(xbgr.mr_n76091984)
print v(xbgr.mr_n76163056)
print v(xbgr.mr_n76581728)
print v(xbgr.mr_n75394304)
print v(xbgr.mr_n75589712)
print v(xbgr.mr_n75775184)
print v(xbgr.mr_n76006800)
print v(xbgr.mr_n76092096)
print v(xbgr.mr_n76143056)
print v(xbgr.mr_n76582544)
print v(xbgr.mr_n77729072)
print v(xbgr.mr_n77955072)
print v(xbgr.mr_n78123600)
print v(xbgr.mr_n76245760)
print v(xbgr.mr_n75394768)
print v(xbgr.mr_n75600288)
print v(xbgr.mr_n75776960)
print v(xbgr.mr_n76007920)
print v(xbgr.mr_n76032704)
print v(xbgr.mr_n76124000)
print v(xbgr.mr_n76465328)
print v(xbgr.det)
print v(xbgr.mr_n77728960)
print v(xbgr.mr_n77893600)
print v(xbgr.mr_n78127696)
print v(xbgr.mr_n76221152)
print v(xbgr.mr_n75388272)
print v(xbgr.mr_n75600960)
print v(xbgr.mr_n75777552)
print v(xbgr.mr_n76007328)
print v(xbgr.mr_n77541424)
print v(xbgr.mr_n77769280)
print v(xbgr.mr_n77974272)
print v(xbgr.mr_n76089584)
print v(xbgr.mr_n76146672)
print v(xbgr.mr_n76581840)
print v(xbgr.mr_n77730816)
print v(xbgr.mr_n77893824)
print v(xbgr.mr_n78140240)
print v(xbgr.mr_n76704512)
print v(xbgr.mr_n76852144)
print v(xbgr.mr_n76918016)
print v(xbgr.mr_n76940368)
print v(xbgr.mr_n77221392)
print v(xbgr.mr_n77368336)
print v(xbgr.mr_n77490352)
print v(xbgr.mr_n76704624)
print v(xbgr.mr_n76855648)
print v(xbgr.mr_n76918128)
print v(xbgr.mr_n76997632)
print v(xbgr.mr_n77247696)
print v(xbgr.mr_n77371632)
print v(xbgr.mr_n77499088)
print v(xbgr.mr_n75388736)
print v(xbgr.mr_n75601552)
print v(xbgr.mr_n75778144)
print v(xbgr.mr_n75956096)
print v(xbgr.mr_n76629248)
print v(xbgr.mr_n76737312)
print v(xbgr.mr_n76860784)
print v(xbgr.mr_n76945104)
print v(xbgr.mr_n77147904)
print v(xbgr.mr_n77274176)
print v(xbgr.mr_n77405936)
print v(xbgr.mr_n77731232)
print v(xbgr.mr_n77957616)
print v(xbgr.mr_n78138736)
print v(xbgr.mr_n75396160)
print v(xbgr.mr_n75599104)
print v(xbgr.mr_n75778736)
print v(xbgr.mr_n76013632)
print v(xbgr.mr_n77729536)
print v(xbgr.mr_n77898128)
print v(xbgr.mr_n78143520)
print v(xbgr.mr_n75396624)
print v(xbgr.mr_n75602624)
print v(xbgr.mr_n75776368)
print v(xbgr.mr_n76013744)
print v(xbgr.mr_n76244784)
print v(xbgr.mr_n76693232)
print v(xbgr.mr_n76857904)
print v(xbgr.mr_n76919888)
print v(xbgr.mr_n76997744)
print v(xbgr.mr_n77247584)
print v(xbgr.mr_n77335520)
print v(xbgr.mr_n77461888)
print v(xbgr.mr_n76092720)
print v(xbgr.mr_n76164016)
print v(xbgr.mr_n76583232)
print v(xbgr.mr_n77543280)
print v(xbgr.mr_n77768816)
print v(xbgr.mr_n77976128)
print v(xbgr.mr_n76087280)
print v(xbgr.mr_n76164128)
print v(xbgr.mr_n76583856)
print v(xbgr.mr_n77733408)
print v(xbgr.mr_n77898720)
print v(xbgr.mr_n78142704)
print v(xbgr.mr_n75397088)
print v(xbgr.mr_n75603296)
print v(xbgr.mr_n75769264)
print v(xbgr.mr_n76013968)
print v(xbgr.mr_n76223472)
print v(xbgr.mr_n76032432)
print v(xbgr.mr_n76123728)
print v(xbgr.mr_n76185184)
print v(xbgr.mr_n76465600)
print v(xbgr.r4n)
print v(xbgr.mr_n75397552)
print v(xbgr.mr_n75603888)
print v(xbgr.mr_n75780512)
print v(xbgr.mr_n76014080)
print v(xbgr.mr_n77722288)
print v(xbgr.mr_n77959248)
print v(xbgr.mr_n78138624)
print v(xbgr.mr_n76091872)
print v(xbgr.mr_n76164752)
print v(xbgr.mr_n76584384)
print v(xbgr.mr_n76705248)
print v(xbgr.mr_n76851200)
print v(xbgr.mr_n76925312)
print v(xbgr.mr_n76992096)
print v(xbgr.mr_n77248656)
print v(xbgr.mr_n77371280)
print v(xbgr.mr_n77494512)
print v(xbgr.mr_n76700896)
print v(xbgr.mr_n76813984)
print v(xbgr.mr_n76917904)
print v(xbgr.mr_n76993904)
print v(xbgr.mr_n77236624)
print v(xbgr.mr_n77369040)
print v(xbgr.mr_n77494864)
print v(xbgr.mr_n75395696)
print v(xbgr.mr_n75604480)
print v(xbgr.mr_n75770448)
print v(xbgr.mr_n76014192)
print v(xbgr.mr_n77732160)
print v(xbgr.mr_n77901680)
print v(xbgr.mr_n78141136)
print v(xbgr.mr_n77545136)
print v(xbgr.mr_n77768352)
print v(xbgr.mr_n77977984)
print v(xbgr.mr_n76628784)
print v(xbgr.mr_n76736784)
print v(xbgr.mr_n76861600)
print v(xbgr.mr_n76945920)
print v(xbgr.mr_n77148720)
print v(xbgr.mr_n77274992)
print v(xbgr.mr_n77406352)
print v(xbgr.mr_n75398480)
print v(xbgr.mr_n75605072)
print v(xbgr.mr_n75781696)
print v(xbgr.mr_n76014304)
print v(xbgr.mr_n77731344)
print v(xbgr.mr_n77902272)
print v(xbgr.mr_n78143696)
print v(xbgr.mr_n75398944)
print v(xbgr.mr_n75605664)
print v(xbgr.mr_n75774000)
print v(xbgr.mr_n76014496)
print v(xbgr.mr_n76243936)
print v(xbgr.mr_n76706560)
print v(xbgr.mr_n76815792)
print v(xbgr.mr_n76914752)
print v(xbgr.mr_n76998160)
print v(xbgr.mr_n77247808)
print v(xbgr.mr_n77338480)
print v(xbgr.mr_n77461232)
print v(xbgr.mr_n77735376)
print v(xbgr.mr_n77960880)
print v(xbgr.mr_n78140960)
print v(xbgr.mr_n76093456)
print v(xbgr.mr_n76164864)
print v(xbgr.mr_n76582880)
print v(xbgr.mr_n76093696)
print v(xbgr.mr_n76163664)
print v(xbgr.mr_n76582032)
print v(xbgr.mr_n75399408)
print v(xbgr.mr_n75606256)
print v(xbgr.mr_n75782880)
print v(xbgr.mr_n76015040)
print v(xbgr.mr_n77736592)
print v(xbgr.mr_n77899904)
print v(xbgr.mr_n78145264)
print v(xbgr.mr_n76238208)
print v(xbgr.mr_n76031888)
print v(xbgr.mr_n76123456)
print v(xbgr.mr_n76465136)
print v(xbgr.mr_n76180480)
print v(xbgr.mr_n77546992)
print v(xbgr.mr_n77767888)
print v(xbgr.mr_n77979840)
print v(xbgr.mr_n75399872)
print v(xbgr.mr_n75606848)
print v(xbgr.mr_n75783472)
print v(xbgr.mr_n76015312)
print v(xbgr.mr_n76216080)
print v(xbgr.mr_n77737536)
print v(xbgr.mr_n77900496)
print v(xbgr.mr_n78147824)
print v(xbgr.mr_n76093104)
print v(xbgr.mr_n76163280)
print v(xbgr.mr_n76579120)
print v(xbgr.mr_n75400336)
print v(xbgr.mr_n75607440)
print v(xbgr.mr_n75784064)
print v(xbgr.mr_n76015584)
print v(xbgr.mr_n76705472)
print v(xbgr.mr_n76849360)
print v(xbgr.mr_n76927632)
print v(xbgr.mr_n76997968)
print v(xbgr.mr_n77249280)
print v(xbgr.mr_n77364928)
print v(xbgr.mr_n77488176)
print v(xbgr.mr_n76697520)
print v(xbgr.mr_n76858992)
print v(xbgr.mr_n76914160)
print v(xbgr.mr_n76998704)
print v(xbgr.mr_n77233008)
print v(xbgr.mr_n77372448)
print v(xbgr.mr_n77488784)
print v(xbgr.mr_n77737952)
print v(xbgr.mr_n77962512)
print v(xbgr.mr_n78135552)
print v(xbgr.mr_n75400800)
print v(xbgr.mr_n75602112)
print v(xbgr.mr_n75784656)
print v(xbgr.mr_n76015856)
print v(xbgr.mr_n76628320)
print v(xbgr.mr_n76736320)
print v(xbgr.mr_n76862416)
print v(xbgr.mr_n76946656)
print v(xbgr.mr_n77149536)
print v(xbgr.mr_n77275808)
print v(xbgr.mr_n77407168)
print v(xbgr.mr_n77726512)
print v(xbgr.mr_n77902864)
print v(xbgr.mr_n78146256)
print v(xbgr.mr_n75401264)
print v(xbgr.mr_n75608544)
print v(xbgr.mr_n75785248)
print v(xbgr.mr_n76016128)
print v(xbgr.mr_n77548848)
print v(xbgr.mr_n77767424)
print v(xbgr.mr_n77981728)
print v(xbgr.mr_n76707280)
print v(xbgr.mr_n76840432)
print v(xbgr.mr_n76911440)
print v(xbgr.mr_n76998976)
print v(xbgr.mr_n77248544)
print v(xbgr.mr_n77334336)
print v(xbgr.mr_n77456560)
print v(xbgr.mr_n77739824)
print v(xbgr.mr_n77901088)
print v(xbgr.mr_n78148816)
print v(xbgr.mr_n76085824)
print v(xbgr.mr_n76167248)
print v(xbgr.d3)
print v(xbgr.mr_n76574512)
print v(xbgr.mr_n76090784)
print v(xbgr.mr_n76166400)
print v(xbgr.mr_n76320800)
print v(xbgr.mr_n76585424)
print v(xbgr.mr_n75401728)
print v(xbgr.mr_n75609216)
print v(xbgr.mr_n75768080)
print v(xbgr.mr_n76016400)
print v(xbgr.mr_n76031616)
print v(xbgr.mr_n76123184)
print v(xbgr.mr_n75954112)
print v(xbgr.mr_n76463952)
print v(xbgr.mr_n77740352)
print v(xbgr.mr_n77959792)
print v(xbgr.mr_n78146080)
print v(xbgr.mr_n75402192)
print v(xbgr.mr_n75609808)
print v(xbgr.mr_n75786432)
print v(xbgr.mr_n76016672)
print v(xbgr.mr_n77741232)
print v(xbgr.mr_n77899312)
print v(xbgr.mr_n78150384)
print v(xbgr.mr_n75398016)
print v(xbgr.mr_n75610400)
print v(xbgr.mr_n75779328)
print v(xbgr.mr_n76017376)
print v(xbgr.mr_n76089408)
print v(xbgr.mr_n76163552)
print v(xbgr.mr_n76374432)
print v(xbgr.mr_n76584736)
print v(xbgr.mr_n76705360)
print v(xbgr.mr_n76803600)
print v(xbgr.mr_n76924320)
print v(xbgr.mr_n76997856)
print v(xbgr.mr_n77124416)
print v(xbgr.mr_n77250736)
print v(xbgr.mr_n77367808)
print v(xbgr.mr_n77489888)
print v(xbgr.mr_n76708576)
print v(xbgr.mr_n75200080)
print v(xbgr.mr_n76912032)
print v(xbgr.mr_n76999568)
print v(xbgr.mr_n77130960)
print v(xbgr.mr_n77252016)
print v(xbgr.mr_n77368224)
print v(xbgr.mr_n77490240)
print v(xbgr.mr_n77550704)
print v(xbgr.mr_n77766960)
print v(xbgr.mr_n77984096)
print v(xbgr.mr_n77742576)
print v(xbgr.mr_n77895152)
print v(xbgr.mr_n78152944)
print v(xbgr.mr_n75403120)
print v(xbgr.mr_n75610992)
print v(xbgr.mr_n75787616)
print v(xbgr.mr_n76017776)
print v(xbgr.mr_n76627856)
print v(xbgr.mr_n76735856)
print v(xbgr.mr_n76863232)
print v(xbgr.mr_n76946192)
print v(xbgr.mr_n77022240)
print v(xbgr.mr_n77150352)
print v(xbgr.mr_n77276624)
print v(xbgr.mr_n77407984)
print v(xbgr.mr_n75403584)
print v(xbgr.mr_n75611584)
print v(xbgr.mr_n75779920)
print v(xbgr.mr_n76018176)
print v(xbgr.mr_n77740464)
print v(xbgr.mr_n77965232)
print v(xbgr.mr_n78148640)
print v(xbgr.mr_n76709728)
print v(xbgr.mr_n76830736)
print v(xbgr.mr_n76925120)
print v(xbgr.mr_n76998592)
print v(xbgr.mr_n77130688)
print v(xbgr.mr_n77250256)
print v(xbgr.mr_n77337296)
print v(xbgr.mr_n77459456)
print v(xbgr.mr_n76053984)
print v(xbgr.mr_n76168816)
print v(xbgr.mr_n76404560)
print v(xbgr.mr_n76585888)
print v(xbgr.mr_n76088848)
print v(xbgr.mr_n76167936)
print v(xbgr.mr_n76314784)
print v(xbgr.mr_n76586992)
print v(xbgr.mr_n75362432)
print v(xbgr.mr_n75612176)
print v(xbgr.mr_n75788800)
print v(xbgr.mr_n76018576)
print v(xbgr.mr_n77736256)
print v(xbgr.mr_n77897536)
print v(xbgr.mr_n78151376)
print v(xbgr.mr_n77551632)
print v(xbgr.mr_n77766512)
print v(xbgr.mr_n77985280)
print v(xbgr.mr_n75404512)
print v(xbgr.mr_n75612768)
print v(xbgr.mr_n75789392)
print v(xbgr.mr_n76019376)
print v(xbgr.mr_n76031344)
print v(xbgr.mr_n76122912)
print v(xbgr.mr_n75906672)
print v(xbgr.mr_n76462768)
print v(xbgr.mr_n77743936)
print v(xbgr.mr_n77893264)
print v(xbgr.mr_n78153936)
print v(xbgr.mr_n75404976)
print v(xbgr.mr_n75613360)
print v(xbgr.mr_n75789984)
print v(xbgr.mr_n76019776)
print v(xbgr.mr_n76085136)
print v(xbgr.mr_n76165232)
print v(xbgr.mr_n76343824)
print v(xbgr.mr_n76589024)
print v(xbgr.mr_n77744784)
print v(xbgr.mr_n77967408)
print v(xbgr.mr_n78151200)
print v(xbgr.mr_n76706912)
print v(xbgr.mr_n75345136)
print v(xbgr.mr_n76912256)
print v(xbgr.mr_n77000320)
print v(xbgr.mr_n77131424)
print v(xbgr.mr_n77252896)
print v(xbgr.mr_n77361520)
print v(xbgr.mr_n77483904)
print v(xbgr.mr_n76710448)
print v(xbgr.mr_n76796768)
print v(xbgr.mr_n76921008)
print v(xbgr.mr_n76968816)
print v(xbgr.mr_n77128544)
print v(xbgr.mr_n77249392)
print v(xbgr.mr_n77364816)
print v(xbgr.mr_n77487424)
print v(xbgr.mr_n75405440)
print v(xbgr.mr_n75613952)
print v(xbgr.mr_n75790576)
print v(xbgr.mr_n76020176)
print v(xbgr.mr_n77745600)
print v(xbgr.mr_n77808592)
print v(xbgr.mr_n78158880)
print v(xbgr.mr_n76627392)
print v(xbgr.mr_n76734928)
print v(xbgr.mr_n76864304)
print v(xbgr.mr_n76945648)
print v(xbgr.mr_n77024704)
print v(xbgr.mr_n77151168)
print v(xbgr.mr_n77277440)
print v(xbgr.mr_n77408800)
print v(xbgr.mr_n77551168)
print v(xbgr.mr_n77766048)
print v(xbgr.mr_n77984688)
print v(xbgr.mr_n75405904)
print v(xbgr.mr_n75614544)
print v(xbgr.mr_n75791168)
print v(xbgr.mr_n76020576)
print v(xbgr.mr_n77743760)
print v(xbgr.mr_n77893712)
print v(xbgr.mr_n78158064)
print v(xbgr.mr_n76709072)
print v(xbgr.mr_n75248624)
print v(xbgr.mr_n76912368)
print v(xbgr.mr_n77003040)
print v(xbgr.mr_n77131536)
print v(xbgr.mr_n77255680)
print v(xbgr.mr_n77333152)
print v(xbgr.mr_n77460112)
print v(xbgr.mr_n75406368)
print v(xbgr.mr_n75615136)
print v(xbgr.mr_n75781104)
print v(xbgr.mr_n76020976)
print v(xbgr.mr_n76087712)
print v(xbgr.mr_n76170384)
print v(xbgr.mr_n76405584)
print v(xbgr.mr_n76587456)
print v(xbgr.mr_n76086432)
print v(xbgr.mr_n76166832)
print v(xbgr.mr_n76397888)
print v(xbgr.mr_n76588560)
print v(xbgr.mr_n77747072)
print v(xbgr.mr_n77967952)
print v(xbgr.mr_n78153760)
print v(xbgr.mr_n75406832)
print v(xbgr.mr_n75615728)
print v(xbgr.mr_n75792352)
print v(xbgr.mr_n76021776)
print v(xbgr.mr_n76031072)
print v(xbgr.mr_n76122640)
print v(xbgr.mr_n76196736)
print v(xbgr.mr_n76461584)
print v(xbgr.mr_n77745344)
print v(xbgr.mr_n77806320)
print v(xbgr.mr_n78156496)
print v(xbgr.mr_n75407296)
print v(xbgr.mr_n75598592)
print v(xbgr.mr_n75782288)
print v(xbgr.mr_n76022176)
print v(xbgr.mr_n77550240)
print v(xbgr.mr_n77765584)
print v(xbgr.mr_n77983504)
print v(xbgr.mr_n76083312)
print v(xbgr.mr_n76170032)
print v(xbgr.mr_n76374128)
print v(xbgr.mr_n76590592)
print v(xbgr.mr_n76711136)
print v(xbgr.mr_n76854272)
print v(xbgr.mr_n76911920)
print v(xbgr.mr_n77000752)
print v(xbgr.mr_n77131648)
print v(xbgr.mr_n77254016)
print v(xbgr.mr_n77365632)
print v(xbgr.mr_n77468352)
print v(xbgr.mr_n77746544)
print v(xbgr.mr_n77684048)
print v(xbgr.mr_n78156320)
print v(xbgr.mr_n76707616)
print v(xbgr.mr_n76794320)
print v(xbgr.mr_n76928464)
print v(xbgr.mr_n77002608)
print v(xbgr.mr_n77111280)
print v(xbgr.mr_n77251328)
print v(xbgr.mr_n77364400)
print v(xbgr.mr_n77489136)
print v(xbgr.mr_n75407760)
print v(xbgr.mr_n75608032)
print v(xbgr.mr_n75793472)
print v(xbgr.mr_n75913024)
print v(xbgr.mr_n76626928)
print v(xbgr.mr_n76734464)
print v(xbgr.mr_n76864768)
print v(xbgr.mr_n76945376)
print v(xbgr.mr_n77025520)
print v(xbgr.mr_n77151984)
print v(xbgr.mr_n77278256)
print v(xbgr.mr_n77409616)
print v(xbgr.mr_n75374352)
print v(xbgr.mr_n75617424)
print v(xbgr.mr_n75792944)
print v(xbgr.mr_n76022896)
print v(xbgr.mr_n77749104)
print v(xbgr.mr_n77966864)
print v(xbgr.mr_n78163184)
print v(xbgr.mr_n77750032)
print v(xbgr.mr_n77892672)
print v(xbgr.mr_n78159056)
print v(xbgr.mr_n75373888)
print v(xbgr.mr_n75618096)
print v(xbgr.mr_n75728240)
print v(xbgr.mr_n75995248)
print v(xbgr.mr_n76712896)
print v(xbgr.mr_n76856896)
print v(xbgr.mr_n76912752)
print v(xbgr.mr_n77004144)
print v(xbgr.mr_n77132080)
print v(xbgr.mr_n77254640)
print v(xbgr.mr_n77336112)
print v(xbgr.mr_n77457680)
print v(xbgr.mr_n76086256)
print v(xbgr.mr_n76171952)
print v(xbgr.mr_n76364320)
print v(xbgr.mr_n76586304)
print v(xbgr.mr_n76080672)
print v(xbgr.mr_n76171072)
print v(xbgr.mr_n76406560)
print v(xbgr.mr_n76590128)
print v(xbgr.mr_n77549776)
print v(xbgr.mr_n77765120)
print v(xbgr.mr_n77982912)
print v(xbgr.mr_n77747952)
print v(xbgr.mr_n77890896)
print v(xbgr.mr_n78160624)
print v(xbgr.mr_n75373424)
print v(xbgr.mr_n75618688)
print v(xbgr.mr_n75727648)
print v(xbgr.mr_n76024176)
print v(xbgr.mr_n76030800)
print v(xbgr.mr_n76122368)
print v(xbgr.mr_n75907568)
print v(xbgr.mr_n76460400)
print v(xbgr.mr_n75373024)
print v(xbgr.mr_n75619280)
print v(xbgr.mr_n75648880)
print v(xbgr.mr_n76024576)
print v(xbgr.mr_n77751392)
print v(xbgr.mr_n77966320)
print v(xbgr.mr_n78155504)
print v(xbgr.mr_n76084960)
print v(xbgr.mr_n76169504)
print v(xbgr.mr_n76375248)
print v(xbgr.mr_n76592160)
print v(xbgr.mr_n76712720)
print v(xbgr.mr_n76787008)
print v(xbgr.mr_n76929872)
print v(xbgr.mr_n76999328)
print v(xbgr.mr_n77134144)
print v(xbgr.mr_n77253328)
print v(xbgr.mr_n77358112)
print v(xbgr.mr_n77484016)
print v(xbgr.mr_n75372624)
print v(xbgr.mr_n75619872)
print v(xbgr.mr_n75726464)
print v(xbgr.mr_n76024976)
print v(xbgr.mr_n76713616)
print v(xbgr.mr_n76855120)
print v(xbgr.mr_n76912480)
print v(xbgr.mr_n77006144)
print v(xbgr.mr_n77132736)
print v(xbgr.mr_n77258720)
print v(xbgr.mr_n77361408)
print v(xbgr.mr_n77488064)
print v(xbgr.mr_n77743328)
print v(xbgr.mr_n77809232)
print v(xbgr.mr_n78042208)
print v(xbgr.mr_n77549312)
print v(xbgr.mr_n77764656)
print v(xbgr.mr_n77982320)
print v(xbgr.mr_n75372160)
print v(xbgr.mr_n75599696)
print v(xbgr.mr_n75725872)
print v(xbgr.mr_n76025376)
print v(xbgr.mr_n76626464)
print v(xbgr.mr_n76733536)
print v(xbgr.mr_n76863840)
print v(xbgr.mr_n76944832)
print v(xbgr.mr_n77026336)
print v(xbgr.mr_n77151712)
print v(xbgr.mr_n77277984)
print v(xbgr.mr_n77409344)
print v(xbgr.mr_n77751504)
print v(xbgr.mr_n77892080)
print v(xbgr.mr_n78094928)
print v(xbgr.mr_n75371712)
print v(xbgr.mr_n75339056)
print v(xbgr.mr_n75725280)
print v(xbgr.mr_n76025776)
print v(xbgr.mr_n76713952)
print v(xbgr.mr_n76819728)
print v(xbgr.mr_n76931216)
print v(xbgr.mr_n77007808)
print v(xbgr.mr_n77134256)
print v(xbgr.mr_n77260384)
print v(xbgr.mr_n77333744)
print v(xbgr.mr_n77458336)
print v(xbgr.mr_n76081856)
print v(xbgr.mr_n76173520)
print v(xbgr.mr_n76403040)
print v(xbgr.mr_n76587872)
print v(xbgr.mr_n77749776)
print v(xbgr.mr_n77965776)
print v(xbgr.mr_n78161440)
print v(xbgr.mr_n76083920)
print v(xbgr.mr_n76174208)
print v(xbgr.mr_n76406064)
print v(xbgr.mr_n76591696)
print v(xbgr.mr_n75371248)
print v(xbgr.mr_n75621568)
print v(xbgr.mr_n75723280)
print v(xbgr.mr_n76026576)
print v(xbgr.mr_n77750976)
print v(xbgr.mr_n77810288)
print v(xbgr.mr_n78089888)
print v(xbgr.mr_n76030528)
print v(xbgr.mr_n76122176)
print v(xbgr.mr_n76012752)
print v(xbgr.mr_n76459216)
print v(xbgr.mr_n75370784)
print v(xbgr.mr_n75616320)
print v(xbgr.mr_n75799072)
print v(xbgr.mr_n75854240)
print v(xbgr.mr_n77548384)
print v(xbgr.mr_n77764192)
print v(xbgr.mr_n77981232)
print v(xbgr.mr_n77748288)
print v(xbgr.mr_n77891488)
print v(xbgr.mr_n78095168)
print v(xbgr.mr_n76082464)
print v(xbgr.mr_n76168400)
print v(xbgr.mr_n76374976)
print v(xbgr.mr_n76591008)
print v(xbgr.mr_n75370320)
print v(xbgr.mr_n75616832)
print v(xbgr.mr_n75800512)
print v(xbgr.mr_n75863792)
print v(xbgr.mr_n76711744)
print v(xbgr.mr_n76845520)
print v(xbgr.mr_n76930848)
print v(xbgr.mr_n77003456)
print v(xbgr.mr_n77133088)
print v(xbgr.mr_n77256032)
print v(xbgr.mr_n77361056)
print v(xbgr.mr_n77480608)
print v(xbgr.mr_n76708080)
print v(xbgr.mr_n76846336)
print v(xbgr.mr_n76932064)
print v(xbgr.mr_n77008848)
print v(xbgr.mr_n77136624)
print v(xbgr.mr_n77261424)
print v(xbgr.mr_n77357648)
print v(xbgr.mr_n77487312)
print v(xbgr.mr_n77749216)
print v(xbgr.mr_n77964688)
print v(xbgr.mr_n78079792)
print v(xbgr.mr_n75369856)
print v(xbgr.mr_n75623344)
print v(xbgr.mr_n75788208)
print v(xbgr.mr_n75863120)
print v(xbgr.mr_n76626000)
print v(xbgr.mr_n76733072)
print v(xbgr.mr_n76863504)
print v(xbgr.mr_n76944560)
print v(xbgr.mr_n77027152)
print v(xbgr.mr_n77151440)
print v(xbgr.mr_n77277712)
print v(xbgr.mr_n77409072)
print v(xbgr.mr_n77746960)
print v(xbgr.mr_n77890304)
print v(xbgr.mr_n78086288)
print v(xbgr.mr_n75369392)
print v(xbgr.mr_n75624016)
print v(xbgr.mr_n75802112)
print v(xbgr.mr_n75855504)
print v(xbgr.mr_n77547920)
print v(xbgr.mr_n77763728)
print v(xbgr.mr_n77980768)
print v(xbgr.mr_n76710784)
print v(xbgr.mr_n76824192)
print v(xbgr.mr_n76929136)
print v(xbgr.mr_n77005024)
print v(xbgr.mr_n77135248)
print v(xbgr.mr_n77257600)
print v(xbgr.mr_n77334928)
print v(xbgr.mr_n77452352)
print v(xbgr.mr_n76082288)
print v(xbgr.mr_n76175088)
print v(xbgr.mr_n76403952)
print v(xbgr.mr_n76593264)
print v(xbgr.mr_n77742752)
print v(xbgr.mr_n77889712)
print v(xbgr.mr_n78081680)
print v(xbgr.mr_n76083744)
print v(xbgr.mr_n76171536)
print v(xbgr.mr_n76404736)
print v(xbgr.mr_n76594832)
print v(xbgr.mr_n75368928)
print v(xbgr.mr_n75595632)
print v(xbgr.mr_n75802912)
print v(xbgr.mr_n75862016)
print v(xbgr.mr_n76030256)
print v(xbgr.mr_n76121424)
print v(xbgr.mr_n76241808)
print v(xbgr.mr_n76458032)
print v(xbgr.mr_n75368464)
print v(xbgr.mr_n75625120)
print v(xbgr.mr_n75803312)
print v(xbgr.mr_n75861344)
print v(xbgr.mr_n77744672)
print v(xbgr.mr_n78045072)
print v(xbgr.mr_n75361040)
print v(xbgr.mr_n75622752)
print v(xbgr.mr_n75804512)
print v(xbgr.mr_n75841888)
print v(xbgr.mr_n77738880)
print v(xbgr.mr_n78161616)
print v(xbgr.mr_n76080000)
print v(xbgr.mr_n76173104)
print v(xbgr.mr_n76374704)
print v(xbgr.mr_n76595360)
print v(xbgr.mr_n76705904)
print v(xbgr.mr_n76787840)
print v(xbgr.mr_n76929568)
print v(xbgr.mr_n76988480)
print v(xbgr.mr_n77134752)
print v(xbgr.mr_n77262304)
print v(xbgr.mr_n77354128)
print v(xbgr.mr_n77465440)
print v(xbgr.mr_n76709552)
print v(xbgr.mr_n76841328)
print v(xbgr.mr_n76933616)
print v(xbgr.mr_n77010848)
print v(xbgr.mr_n77137920)
print v(xbgr.mr_n77257184)
print v(xbgr.mr_n77362224)
print v(xbgr.mr_n77486896)
print v(xbgr.mr_n77547456)
print v(xbgr.mr_n77980304)
print v(xbgr.mr_n75303344)
print v(xbgr.mr_n75626304)
print v(xbgr.mr_n75796512)
print v(xbgr.mr_n75851280)
print v(xbgr.mr_n77741568)
print v(xbgr.mr_n78082608)
print v(xbgr.mr_n76625536)
print v(xbgr.mr_n76732144)
print v(xbgr.mr_n76862960)
print v(xbgr.mr_n76944016)
print v(xbgr.mr_n77027696)
print v(xbgr.mr_n77150896)
print v(xbgr.mr_n77277168)
print v(xbgr.mr_n77408528)
print v(xbgr.mr_n75367072)
print v(xbgr.mr_n75626976)
print v(xbgr.mr_n75798480)
print v(xbgr.mr_n75859648)
print v(xbgr.mr_n77732976)
print v(xbgr.mr_n78082272)
print v(xbgr.mr_n76704176)
print v(xbgr.mr_n76803088)
print v(xbgr.mr_n76935024)
print v(xbgr.mr_n77012640)
print v(xbgr.mr_n77136256)
print v(xbgr.mr_n77262736)
print v(xbgr.mr_n77330784)
print v(xbgr.mr_n77453008)
print v(xbgr.mr_n76077488)
print v(xbgr.mr_n76176656)
print v(xbgr.mr_n76402016)
print v(xbgr.mr_n76589440)
print v(xbgr.mr_n75366608)
print v(xbgr.mr_n75627568)
print v(xbgr.mr_n75787024)
print v(xbgr.mr_n75859120)
print v(xbgr.mr_n76080848)
print v(xbgr.mr_n76175776)
print v(xbgr.mr_n76400352)
print v(xbgr.mr_n76592576)
print v(xbgr.mr_n77740240)
print v(xbgr.mr_n78038112)
print v(xbgr.mr_n77546528)
print v(xbgr.mr_n77979376)
print v(xbgr.mr_n75366144)
print v(xbgr.mr_n75628160)
print v(xbgr.mr_n75807312)
print v(xbgr.mr_n75856688)
print v(xbgr.mr_n76029984)
print v(xbgr.mr_n76119312)
print v(xbgr.mr_n76236464)
print v(xbgr.mr_n76456848)
print v(xbgr.mr_n77735264)
print v(xbgr.mr_n78083744)
print v(xbgr.mr_n75365680)
print v(xbgr.mr_n75628752)
print v(xbgr.mr_n75806112)
print v(xbgr.mr_n75857808)
print v(xbgr.mr_n76080112)
print v(xbgr.mr_n76172640)
print v(xbgr.mr_n76356112)
print v(xbgr.mr_n76594144)
print v(xbgr.mr_n76704400)
print v(xbgr.mr_n76848832)
print v(xbgr.mr_n76931632)
print v(xbgr.mr_n77008160)
print v(xbgr.mr_n77137424)
print v(xbgr.mr_n77260736)
print v(xbgr.mr_n77353424)
print v(xbgr.mr_n77484720)
print v(xbgr.mr_n77738064)
print v(xbgr.mr_n78050560)
print v(xbgr.mr_n76706384)
print v(xbgr.mr_n76797296)
print v(xbgr.mr_n76935808)
print v(xbgr.mr_n77013520)
print v(xbgr.mr_n77138896)
print v(xbgr.mr_n77266128)
print v(xbgr.mr_n77358000)
print v(xbgr.mr_n77483488)
print v(xbgr.mr_n75365216)
print v(xbgr.mr_n75629344)
print v(xbgr.mr_n75801712)
print v(xbgr.mr_n75853136)
print v(xbgr.mr_n77738624)
print v(xbgr.mr_n78082784)
print v(xbgr.mr_n76625072)
print v(xbgr.mr_n76731680)
print v(xbgr.mr_n76862688)
print v(xbgr.mr_n76943744)
print v(xbgr.mr_n77027424)
print v(xbgr.mr_n77150624)
print v(xbgr.mr_n77276896)
print v(xbgr.mr_n77408256)
print v(xbgr.mr_n75364752)
print v(xbgr.mr_n75629936)
print v(xbgr.mr_n75810112)
print v(xbgr.mr_n75853728)
print v(xbgr.mr_n77546064)
print v(xbgr.mr_n77978912)
print v(xbgr.mr_n77734688)
print v(xbgr.mr_n78085456)
print v(xbgr.mr_n75364288)
print v(xbgr.mr_n75630528)
print v(xbgr.mr_n75806912)
print v(xbgr.mr_n75839440)
print v(xbgr.mr_n76704896)
print v(xbgr.mr_n76818800)
print v(xbgr.mr_n76934240)
print v(xbgr.mr_n77011536)
print v(xbgr.mr_n77139856)
print v(xbgr.mr_n77259408)
print v(xbgr.mr_n77331968)
print v(xbgr.mr_n77447280)
print v(xbgr.mr_n76076480)
print v(xbgr.mr_n76178224)
print v(xbgr.mr_n76401472)
print v(xbgr.mr_n76596400)
print v(xbgr.mr_n76078096)
print v(xbgr.mr_n76177344)
print v(xbgr.mr_n76402192)
print v(xbgr.mr_n76597968)
print v(xbgr.mr_n77735488)
print v(xbgr.mr_n77963600)
print v(xbgr.mr_n78075616)
print v(xbgr.mr_n75363824)
print v(xbgr.mr_n75631120)
print v(xbgr.mr_n75811312)
print v(xbgr.mr_n75843664)
print v(xbgr.mr_n76029712)
print v(xbgr.mr_n76118256)
print v(xbgr.mr_n76241616)
print v(xbgr.mr_n76455664)
print v(xbgr.mr_n77733584)
print v(xbgr.mr_n77889120)
print v(xbgr.mr_n78078480)
print v(xbgr.mr_n75363360)
print v(xbgr.mr_n75625792)
print v(xbgr.mr_n75812512)
print v(xbgr.mr_n75854912)
print v(xbgr.mr_n77545600)
print v(xbgr.mr_n77763264)
print v(xbgr.mr_n77978448)
print v(xbgr.mr_n76079312)
print v(xbgr.mr_n76177808)
print v(xbgr.mr_n76374240)
print v(xbgr.mr_n76598496)
print v(xbgr.mr_n76701072)
print v(xbgr.mr_n76809120)
print v(xbgr.mr_n76913568)
print v(xbgr.mr_n77014400)
print v(xbgr.mr_n77140736)
print v(xbgr.mr_n77263424)
print v(xbgr.mr_n76967168)
print v(xbgr.mr_n77477200)
print v(xbgr.mr_n77734512)
print v(xbgr.mr_n77888528)
print v(xbgr.mr_n78166240)
print v(xbgr.mr_n76704288)
print v(xbgr.mr_n76811376)
print v(xbgr.mr_n76937360)
print v(xbgr.mr_n77009376)
print v(xbgr.mr_n77139072)
print v(xbgr.mr_n77268128)
print v(xbgr.mr_n77358816)
print v(xbgr.mr_n77480496)
print v(xbgr.mr_n75362896)
print v(xbgr.mr_n75620464)
print v(xbgr.mr_n75805712)
print v(xbgr.mr_n75850176)
print v(xbgr.mr_n76624608)
print v(xbgr.mr_n76730752)
print v(xbgr.mr_n76862144)
print v(xbgr.mr_n76943472)
print v(xbgr.mr_n77026880)
print v(xbgr.mr_n77150080)
print v(xbgr.mr_n77276352)
print v(xbgr.mr_n77407712)
print v(xbgr.mr_n75212784)
print v(xbgr.mr_n75632816)
print v(xbgr.mr_n75814176)
print v(xbgr.mr_n75850704)
print v(xbgr.mr_n77729872)
print v(xbgr.mr_n77963056)
print v(xbgr.mr_n78082896)
print v(xbgr.mr_n75361968)
print v(xbgr.mr_n75633488)
print v(xbgr.mr_n75808912)
print v(xbgr.mr_n75846032)
print v(xbgr.mr_n77731904)
print v(xbgr.mr_n77887936)
print v(xbgr.mr_n78170608)
print v(xbgr.mr_n76699200)
print v(xbgr.mr_n76810992)
print v(xbgr.mr_n76937056)
print v(xbgr.mr_n77017120)
print v(xbgr.mr_n77139424)
print v(xbgr.mr_n77267440)
print v(xbgr.mr_n77271712)
print v(xbgr.mr_n77454784)
print v(xbgr.mr_n76079136)
print v(xbgr.mr_n76179792)
print v(xbgr.mr_n76400976)
print v(xbgr.mr_n76593728)
print v(xbgr.mr_n76075744)
print v(xbgr.mr_n76178912)
print v(xbgr.mr_n76399472)
print v(xbgr.mr_n76595712)
print v(xbgr.mr_n77544672)
print v(xbgr.mr_n77762800)
print v(xbgr.mr_n77977520)
print v(xbgr.mr_n75361504)
print v(xbgr.mr_n75634080)
print v(xbgr.mr_n75816544)
print v(xbgr.mr_n75852480)
print v(xbgr.mr_n77727984)
print v(xbgr.mr_n77887344)
print v(xbgr.mr_n78169088)
print v(xbgr.mr_n76029440)
print v(xbgr.mr_n76117200)
print v(xbgr.mr_n76198656)
print v(xbgr.mr_n76454480)
print v(xbgr.mr_n75212512)
print v(xbgr.mr_n75634672)
print v(xbgr.mr_n75817728)
print v(xbgr.mr_n75851888)
print v(xbgr.mr_n77729184)
print v(xbgr.mr_n77961968)
print v(xbgr.mr_n78164320)
print v(xbgr.mr_n76076304)
print v(xbgr.mr_n76179376)
print v(xbgr.mr_n76358880)
print v(xbgr.mr_n76576672)
print v(xbgr.mr_n75360576)
print v(xbgr.mr_n75635264)
print v(xbgr.mr_n75809712)
print v(xbgr.mr_n75819504)
print v(xbgr.mr_n76700464)
print v(xbgr.mr_n76805280)
print v(xbgr.mr_n76933312)
print v(xbgr.mr_n77018224)
print v(xbgr.mr_n77143024)
print v(xbgr.mr_n77265088)
print v(xbgr.mr_n77353312)
print v(xbgr.mr_n77481312)
print v(xbgr.mr_n76694208)
print v(xbgr.mr_n76807184)
print v(xbgr.mr_n76935376)
print v(xbgr.mr_n77016688)
print v(xbgr.mr_n77144560)
print v(xbgr.mr_n77265440)
print v(xbgr.mr_n77356912)
print v(xbgr.mr_n77480080)
print v(xbgr.mr_n77728448)
print v(xbgr.mr_n77886400)
print v(xbgr.mr_n78166976)
print v(xbgr.mr_n77544208)
print v(xbgr.mr_n77762336)
print v(xbgr.mr_n77977056)
print v(xbgr.mr_n75360112)
print v(xbgr.mr_n75620976)
print v(xbgr.mr_n75818320)
print v(xbgr.mr_n75798736)
print v(xbgr.mr_n76624144)
print v(xbgr.mr_n76730288)
print v(xbgr.mr_n76861872)
print v(xbgr.mr_n76943200)
print v(xbgr.mr_n77026608)
print v(xbgr.mr_n77149808)
print v(xbgr.mr_n77276080)
print v(xbgr.mr_n77407440)
print v(xbgr.mr_n77727792)
print v(xbgr.mr_n77885568)
print v(xbgr.mr_n78170784)
print v(xbgr.mr_n75359648)
print v(xbgr.mr_n75636368)
print v(xbgr.mr_n75820096)
print v(xbgr.mr_n75835472)
print v(xbgr.mr_n76695328)
print v(xbgr.mr_n76817312)
print v(xbgr.mr_n76939552)
print v(xbgr.mr_n77009728)
print v(xbgr.mr_n77138416)
print v(xbgr.mr_n77270832)
print v(xbgr.mr_n77332560)
print v(xbgr.mr_n77447616)
print v(xbgr.mr_n76074944)
print v(xbgr.mr_n76181360)
print v(xbgr.mr_n76395408)
print v(xbgr.mr_n76574128)
print v(xbgr.mr_n76077920)
print v(xbgr.mr_n76182048)
print v(xbgr.mr_n76398928)
print v(xbgr.mr_n76566672)
print v(xbgr.mr_n77726256)
print v(xbgr.mr_n77961424)
print v(xbgr.mr_n78166864)
print v(xbgr.mr_n75359184)
print v(xbgr.mr_n75637040)
print v(xbgr.mr_n75818848)
print v(xbgr.mr_n75849584)
print v(xbgr.mr_n77720864)
print v(xbgr.mr_n77882672)
print v(xbgr.mr_n78172352)
print v(xbgr.mr_n76029168)
print v(xbgr.mr_n76116144)
print v(xbgr.mr_n76202112)
print v(xbgr.mr_n76453296)
print v(xbgr.mr_n75358720)
print v(xbgr.mr_n75637632)
print v(xbgr.mr_n75817136)
print v(xbgr.mr_n75848992)
print v(xbgr.mr_n77543744)
print v(xbgr.mr_n77761872)
print v(xbgr.mr_n77976592)
print v(xbgr.mr_n77714352)
print v(xbgr.mr_n77873648)
print v(xbgr.mr_n78173344)
print v(xbgr.mr_n75358256)
print v(xbgr.mr_n75638224)
print v(xbgr.mr_n75815952)
print v(xbgr.mr_n75848400)
print v(xbgr.mr_n76063776)
print v(xbgr.mr_n76174736)
print v(xbgr.mr_n76374016)
print v(xbgr.mr_n76564016)
print v(xbgr.mr_n76699376)
print v(xbgr.mr_n76839888)
print v(xbgr.mr_n76938768)
print v(xbgr.mr_n77019104)
print v(xbgr.mr_n77145440)
print v(xbgr.mr_n77269792)
print v(xbgr.mr_n77350352)
print v(xbgr.mr_n77473792)
print v(xbgr.mr_n76697344)
print v(xbgr.mr_n76809824)
print v(xbgr.mr_n76941104)
print v(xbgr.mr_n77014832)
print v(xbgr.mr_n77141168)
print v(xbgr.mr_n77272832)
print v(xbgr.mr_n77351824)
print v(xbgr.mr_n77477088)
print v(xbgr.mr_n75357792)
print v(xbgr.mr_n75638816)
print v(xbgr.mr_n75815360)
print v(xbgr.mr_n75847808)
print v(xbgr.mr_n77723888)
print v(xbgr.mr_n77960336)
print v(xbgr.mr_n78164512)
print v(xbgr.mr_n76623680)
print v(xbgr.mr_n76729360)
print v(xbgr.mr_n76861328)
print v(xbgr.mr_n76942928)
print v(xbgr.mr_n77026064)
print v(xbgr.mr_n77149264)
print v(xbgr.mr_n77275536)
print v(xbgr.mr_n77406896)
print v(xbgr.mr_n77713072)
print v(xbgr.mr_n77839024)
print v(xbgr.mr_n78178288)
print v(xbgr.mr_n75357328)
print v(xbgr.mr_n75639408)
print v(xbgr.mr_n75806512)
print v(xbgr.mr_n75847216)
print v(xbgr.mr_n77542816)
print v(xbgr.mr_n77761408)
print v(xbgr.mr_n77975664)
print v(xbgr.mr_n76698400)
print v(xbgr.mr_n76819984)
print v(xbgr.mr_n76939952)
print v(xbgr.mr_n77021824)
print v(xbgr.mr_n77145088)
print v(xbgr.mr_n77267008)
print v(xbgr.mr_n77329008)
print v(xbgr.mr_n77404416)
print v(xbgr.mr_n76075632)
print v(xbgr.mr_n76182928)
print v(xbgr.mr_n76396928)
print v(xbgr.mr_n76561216)
print v(xbgr.mr_n76072032)
print v(xbgr.mr_n76176240)
print v(xbgr.mr_n76398432)
print v(xbgr.mr_n76569872)
print v(xbgr.mr_n77722464)
print v(xbgr.mr_n77886224)
print v(xbgr.mr_n78177472)
print v(xbgr.mr_n75356864)
print v(xbgr.mr_n75622240)
print v(xbgr.mr_n75813312)
print v(xbgr.mr_n75846544)
print v(xbgr.mr_n76028896)
print v(xbgr.mr_n76091648)
print v(xbgr.mr_n76204736)
print v(xbgr.mr_n76452112)
print v(xbgr.mr_n75356400)
print v(xbgr.mr_n75631712)
print v(xbgr.mr_n75808112)
print v(xbgr.mr_n75838928)
print v(xbgr.mr_n77723392)
print v(xbgr.mr_n77958704)
print v(xbgr.mr_n78175904)
print v(xbgr.mr_n75355936)
print v(xbgr.mr_n75632224)
print v(xbgr.mr_n75811712)
print v(xbgr.mr_n75845440)
print v(xbgr.mr_n77720160)
print v(xbgr.mr_n77883792)
print v(xbgr.mr_n78173168)
print v(xbgr.mr_n76074768)
print v(xbgr.mr_n76180944)
print v(xbgr.mr_n76373904)
print v(xbgr.mr_n76564400)
print v(xbgr.mr_n76695504)
print v(xbgr.mr_n76787264)
print v(xbgr.mr_n76932880)
print v(xbgr.mr_n77019536)
print v(xbgr.mr_n77141856)
print v(xbgr.mr_n77264048)
print v(xbgr.mr_n77351328)
print v(xbgr.mr_n77477904)
print v(xbgr.mr_n76696544)
print v(xbgr.mr_n76824304)
print v(xbgr.mr_n76938336)
print v(xbgr.mr_n77021392)
print v(xbgr.mr_n77140320)
print v(xbgr.mr_n77269296)
print v(xbgr.mr_n76973616)
print v(xbgr.mr_n77476672)
print v(xbgr.mr_n77542352)
print v(xbgr.mr_n77760944)
print v(xbgr.mr_n77975200)
print v(xbgr.mr_n75355472)
print v(xbgr.mr_n75641696)
print v(xbgr.mr_n75810912)
print v(xbgr.mr_n75844848)
print v(xbgr.mr_n77715072)
print v(xbgr.mr_n77884448)
print v(xbgr.mr_n78175728)
print v(xbgr.mr_n76623216)
print v(xbgr.mr_n76728896)
print v(xbgr.mr_n76861056)
print v(xbgr.mr_n76942656)
print v(xbgr.mr_n77025792)
print v(xbgr.mr_n77148992)
print v(xbgr.mr_n77275264)
print v(xbgr.mr_n77406624)
print v(xbgr.mr_n75355008)
print v(xbgr.mr_n75642368)
print v(xbgr.mr_n75802512)
print v(xbgr.mr_n75844256)
print v(xbgr.mr_n77716336)
print v(xbgr.mr_n77951056)
print v(xbgr.mr_n78178464)
print v(xbgr.mr_n76694896)
print v(xbgr.mr_n76803968)
print v(xbgr.mr_n76936272)
print v(xbgr.mr_n77016144)
print v(xbgr.mr_n77137312)
print v(xbgr.mr_n77266656)
print v(xbgr.mr_n77331376)
print v(xbgr.mr_n77450576)
print v(xbgr.mr_n75354544)
print v(xbgr.mr_n75642960)
print v(xbgr.mr_n75809312)
print v(xbgr.mr_n75814768)
print v(xbgr.mr_n76072832)
print v(xbgr.mr_n76184496)
print v(xbgr.mr_n76377072)
print v(xbgr.mr_n76559872)
print v(xbgr.mr_n76061392)
print v(xbgr.mr_n76183616)
print v(xbgr.mr_n76396384)
print v(xbgr.mr_n76566864)
print v(xbgr.mr_n77717696)
print v(xbgr.mr_n77882016)
print v(xbgr.mr_n78180032)
print v(xbgr.mr_n75354080)
print v(xbgr.mr_n75643552)
print v(xbgr.mr_n75808512)
print v(xbgr.mr_n75843072)
print v(xbgr.mr_n77541888)
print v(xbgr.mr_n77760480)
print v(xbgr.mr_n77974736)
print v(xbgr.mr_n76028624)
print v(xbgr.mr_n76097248)
print v(xbgr.mr_n76240560)
print v(xbgr.mr_n76450928)
print v(xbgr.mr_n77715904)
print v(xbgr.mr_n77875568)
print v(xbgr.mr_n78182592)
print v(xbgr.mr_n75353616)
print v(xbgr.mr_n75644144)
print v(xbgr.mr_n75807712)
print v(xbgr.mr_n75842544)
print v(xbgr.mr_n76073392)
print v(xbgr.mr_n76184000)
print v(xbgr.mr_n76373792)
print v(xbgr.mr_n76548960)
print v(xbgr.mr_n76692352)
print v(xbgr.mr_n76531232)
print v(xbgr.mr_n76930496)
print v(xbgr.mr_n77020224)
print v(xbgr.mr_n77136960)
print v(xbgr.mr_n77258032)
print v(xbgr.mr_n77086416)
print v(xbgr.mr_n77468928)
print v(xbgr.mr_n76684080)
print v(xbgr.mr_n76787616)
print v(xbgr.mr_n76934592)
print v(xbgr.mr_n77012832)
print v(xbgr.mr_n77133456)
print v(xbgr.mr_n77264592)
print v(xbgr.mr_n77339664)
print v(xbgr.mr_n77473680)
print v(xbgr.mr_n77718304)
print v(xbgr.mr_n77951168)
print v(xbgr.mr_n78174912)
print v(xbgr.mr_n75353152)
print v(xbgr.mr_n75644736)
print v(xbgr.mr_n75730992)
print v(xbgr.mr_n75837152)
print v(xbgr.mr_n77714960)
print v(xbgr.mr_n77880240)
print v(xbgr.mr_n78181024)
print v(xbgr.mr_n76622752)
print v(xbgr.mr_n76727968)
print v(xbgr.mr_n76860512)
print v(xbgr.mr_n76942384)
print v(xbgr.mr_n77025248)
print v(xbgr.mr_n77148448)
print v(xbgr.mr_n77274720)
print v(xbgr.mr_n77406160)
print v(xbgr.mr_n75351040)
print v(xbgr.mr_n75645328)
print v(xbgr.mr_n75804912)
print v(xbgr.mr_n75841296)
print v(xbgr.mr_n77540960)
print v(xbgr.mr_n77760016)
print v(xbgr.mr_n77973808)
print v(xbgr.mr_n77706528)
print v(xbgr.mr_n77880896)
print v(xbgr.mr_n78185152)
print v(xbgr.mr_n75219808)
print v(xbgr.mr_n75580752)
print v(xbgr.mr_n75805312)
print v(xbgr.mr_n75840704)
print v(xbgr.mr_n76694032)
print v(xbgr.mr_n76803456)
print v(xbgr.mr_n76932528)
print v(xbgr.mr_n77018752)
print v(xbgr.mr_n77135904)
print v(xbgr.mr_n77261952)
print v(xbgr.mr_n77328672)
print v(xbgr.mr_n77451232)
print v(xbgr.mr_n76072720)
print v(xbgr.mr_n76163168)
print v(xbgr.mr_n76392864)
print v(xbgr.mr_n76557040)
print v(xbgr.mr_n76073568)
print v(xbgr.mr_n76164400)
print v(xbgr.mr_n76395888)
print v(xbgr.mr_n76548848)
print v(xbgr.mr_n75219344)
print v(xbgr.mr_n75571296)
print v(xbgr.mr_n75804112)
print v(xbgr.mr_n75840112)
print v(xbgr.mr_n77708688)
print v(xbgr.mr_n77957072)
print v(xbgr.mr_n78180848)
print v(xbgr.mr_n76028432)
print v(xbgr.mr_n76094384)
print v(xbgr.mr_n75236368)
print v(xbgr.mr_n76450064)
print v(xbgr.mr_n75218880)
print v(xbgr.mr_n75579568)
print v(xbgr.mr_n75803712)
print v(xbgr.mr_n75812912)
print v(xbgr.mr_n77711408)
print v(xbgr.mr_n77878464)
print v(xbgr.mr_n78183584)
print v(xbgr.mr_n77540496)
print v(xbgr.mr_n77759552)
print v(xbgr.mr_n77973344)
print v(xbgr.mr_n76068752)
print v(xbgr.mr_n76161136)
print v(xbgr.mr_n76352736)
print v(xbgr.mr_n76554288)
print v(xbgr.mr_n76682592)
print v(xbgr.mr_n76791328)
print v(xbgr.mr_n76913216)
print v(xbgr.mr_n77015520)
print v(xbgr.mr_n77122352)
print v(xbgr.mr_n77256720)
print v(xbgr.mr_n77352560)
print v(xbgr.mr_n77473328)
print v(xbgr.mr_n75218416)
print v(xbgr.mr_n75565664)
print v(xbgr.mr_n75796976)
print v(xbgr.mr_n75812112)
print v(xbgr.mr_n76690976)
print v(xbgr.mr_n76812144)
print v(xbgr.mr_n76924208)
print v(xbgr.mr_n77014048)
print v(xbgr.mr_n77135728)
print v(xbgr.mr_n77259888)
print v(xbgr.mr_n77341440)
print v(xbgr.mr_n77463664)
print v(xbgr.mr_n77700752)
print v(xbgr.mr_n77879120)
print v(xbgr.mr_n78187712)
print v(xbgr.mr_n75217952)
print v(xbgr.mr_n75578464)
print v(xbgr.mr_n75800912)
print v(xbgr.mr_n75838336)
print v(xbgr.mr_n76622288)
print v(xbgr.mr_n76727504)
print v(xbgr.mr_n76860240)
print v(xbgr.mr_n76942192)
print v(xbgr.mr_n77024976)
print v(xbgr.mr_n77148176)
print v(xbgr.mr_n77274448)
print v(xbgr.mr_n77406048)
print v(xbgr.mr_n77711072)
print v(xbgr.mr_n77956560)
print v(xbgr.mr_n78186144)
print v(xbgr.mr_n75217488)
print v(xbgr.mr_n75513616)
print v(xbgr.mr_n75801312)
print v(xbgr.mr_n75837664)
print v(xbgr.mr_n77710480)
print v(xbgr.mr_n77876688)
print v(xbgr.mr_n78183408)
print v(xbgr.mr_n76683904)
print v(xbgr.mr_n76814256)
print v(xbgr.mr_n76928784)
print v(xbgr.d4)
print v(xbgr.mr_n77133792)
print v(xbgr.mr_n77247472)
print v(xbgr.mr_n77268816)
print v(xbgr.mr_n77447104)
print v(xbgr.mr_n76071856)
print v(xbgr.mr_n76159328)
print v(xbgr.mr_n76393840)
print v(xbgr.mr_n76481136)
print v(xbgr.mr_n76070208)
print v(xbgr.mr_n76150288)
print v(xbgr.mr_n76394560)
print v(xbgr.mr_n76552096)
print v(xbgr.mr_n77540032)
print v(xbgr.mr_n77759008)
print v(xbgr.mr_n77972880)
print v(xbgr.mr_n75217024)
print v(xbgr.mr_n75577280)
print v(xbgr.mr_n75800112)
print v(xbgr.mr_n75810512)
print v(xbgr.mr_n77710128)
print v(xbgr.mr_n77877344)
print v(xbgr.mr_n78190272)
print v(xbgr.mr_n76022576)
print v(xbgr.mr_n76092368)
print v(xbgr.mr_n76230064)
print v(xbgr.mr_n76449264)
print v(xbgr.mr_n75216560)
print v(xbgr.mr_n75576096)
print v(xbgr.mr_n75799712)
print v(xbgr.mr_n75813712)
print v(xbgr.mr_n77707200)
print v(xbgr.mr_n77956208)
print v(xbgr.mr_n78185968)
print v(xbgr.mr_n76070816)
print v(xbgr.mr_n76155712)
print v(xbgr.mr_n76337680)
print v(xbgr.mr_n76553792)
print v(xbgr.mr_n75216096)
print v(xbgr.mr_n75444016)
print v(xbgr.mr_n75686064)
print v(xbgr.mr_n75956208)
print v(xbgr.mr_n76692176)
print v(xbgr.mr_n76848496)
print v(xbgr.mr_n76912144)
print v(xbgr.mr_n77006832)
print v(xbgr.mr_n77132560)
print v(xbgr.mr_n77250912)
print v(xbgr.mr_n77336704)
print v(xbgr.mr_n77468544)
print v(xbgr.mr_n76684736)
print v(xbgr.mr_n76857712)
print v(xbgr.mr_n76913104)
print v(xbgr.mr_n77012016)
print v(xbgr.mr_n77131072)
print v(xbgr.mr_n77255184)
print v(xbgr.mr_n77350896)
print v(xbgr.mr_n77474496)
print v(xbgr.mr_n77703536)
print v(xbgr.mr_n77875040)
print v(xbgr.mr_n78193648)
print v(xbgr.mr_n75215632)
print v(xbgr.mr_n75574320)
print v(xbgr.mr_n75686656)
print v(xbgr.mr_n76027776)
print v(xbgr.mr_n77539344)
print v(xbgr.mr_n77685584)
print v(xbgr.mr_n77971952)
print v(xbgr.mr_n76621824)
print v(xbgr.mr_n76726576)
print v(xbgr.mr_n76818096)
print v(xbgr.mr_n76942080)
print v(xbgr.mr_n77024432)
print v(xbgr.mr_n77147712)
print v(xbgr.mr_n77273984)
print v(xbgr.mr_n77405824)
print v(xbgr.mr_n77704384)
print v(xbgr.mr_n77846144)
print v(xbgr.mr_n78192832)
print v(xbgr.mr_n75215168)
print v(xbgr.mr_n75573728)
print v(xbgr.mr_n75684880)
print v(xbgr.mr_n76027376)
print v(xbgr.mr_n76690096)
print v(xbgr.mr_n76813360)
print v(xbgr.mr_n76911808)
print v(xbgr.mr_n77005456)
print v(xbgr.mr_n77130464)
print v(xbgr.mr_n77252544)
print v(xbgr.mr_n77328496)
print v(xbgr.mr_n77449456)
print v(xbgr.mr_n76063968)
print v(xbgr.mr_n76375520)
print v(xbgr.mr_n76544224)
print v(xbgr.mr_n76070640)
print v(xbgr.mr_n76393344)
print v(xbgr.mr_n76549232)
print v(xbgr.mr_n77705600)
print v(xbgr.mr_n77955184)
print v(xbgr.mr_n78188528)
print v(xbgr.mr_n75213056)
print v(xbgr.mr_n75572480)
print v(xbgr.mr_n75685472)
print v(xbgr.mr_n76026976)
print v(xbgr.mr_n76133248)
print v(xbgr.mr_n75520032)
print v(xbgr.mr_n77704608)
print v(xbgr.mr_n77844336)
print v(xbgr.mr_n78196208)
print v(xbgr.mr_n76023376)
print v(xbgr.mr_n75322352)
print v(xbgr.mr_n76262816)
print v(xbgr.mr_n76423232)
print v(xbgr.mr_n75411280)
print v(xbgr.n_23)
print v(xbgr.mr_n75683696)
print v(xbgr.mr_n76026176)
print v(xbgr.mr_n75332080)
print v(xbgr.mr_n77539040)
print v(xbgr.mr_n77687264)
print v(xbgr.mr_n77971568)
print v(xbgr.mr_n77701936)
print v(xbgr.mr_n77874112)
print v(xbgr.mr_n78195392)
print v(xbgr.n_12)
print v(xbgr.n_25)
print v(xbgr.mr_n75684288)
print v(xbgr.mr_n76023776)
print v(xbgr.mr_n76069360)
print v(xbgr.mr_n76368720)
print v(xbgr.mr_n76539088)
print v(xbgr.mr_n76689920)
print v(xbgr.mr_n76858096)
print v(xbgr.mr_n76926736)
print v(xbgr.mr_n77002064)
print v(xbgr.mr_n77125312)
print v(xbgr.mr_n77249760)
print v(xbgr.mr_n77348688)
print v(xbgr.mr_n77465616)
print v(xbgr.mr_n76683248)
print v(xbgr.mr_n76815376)
print v(xbgr.mr_n76911696)
print v(xbgr.mr_n77007312)
print v(xbgr.mr_n77130576)
print v(xbgr.mr_n77248928)
print v(xbgr.mr_n77339072)
print v(xbgr.mr_n77468736)
print v(xbgr.mr_n75410544)
print v(xbgr.mr_n75512288)
print v(xbgr.mr_n75682512)
print v(xbgr.mr_n76021376)
print v(xbgr.mr_n77703040)
print v(xbgr.mr_n77953008)
print v(xbgr.mr_n78191088)
print v(xbgr.mr_n76621360)
print v(xbgr.mr_n76726192)
print v(xbgr.mr_n76825328)
print v(xbgr.mr_n76939120)
print v(xbgr.mr_n77024240)
print v(xbgr.mr_n77147600)
print v(xbgr.mr_n77273872)
print v(xbgr.mr_n77398016)
print v(xbgr.n_17)
print v(xbgr.n_22)
print v(xbgr.mr_n75683104)
print v(xbgr.mr_n76018976)
print v(xbgr.mr_n77521328)
print v(xbgr.mr_n77872256)
print v(xbgr.mr_n78193824)
print v(xbgr.mr_n77538736)
print v(xbgr.mr_n77686800)
print v(xbgr.mr_n77971264)
print v(xbgr.mr_n76688432)
print v(xbgr.mr_n76845408)
print v(xbgr.mr_n76925504)
print v(xbgr.mr_n77004608)
print v(xbgr.mr_n77130352)
print v(xbgr.mr_n77248192)
print v(xbgr.mr_n77310656)
print v(xbgr.mr_n77398992)
print v(xbgr.mr_n76056400)
print v(xbgr.mr_n76391296)
print v(xbgr.mr_n76530752)
print v(xbgr.n_18)
print v(xbgr.mr_n75510848)
print v(xbgr.mr_n75681328)
print v(xbgr.mr_n76016976)
print v(xbgr.mr_n76069184)
print v(xbgr.mr_n76392016)
print v(xbgr.mr_n76546464)
print v(xbgr.mr_n77701440)
print v(xbgr.mr_n77872720)
print v(xbgr.mr_n78197952)
print v(xbgr.mr_n75253120)
print v(xbgr.mr_n76128080)
print v(xbgr.mr_n75408336)
print v(xbgr.mr_n75510128)
print v(xbgr.mr_n75681920)
print v(xbgr.mr_n76014768)
print v(xbgr.mr_n76028176)
print v(xbgr.mr_n75550992)
print v(xbgr.mr_n76186576)
print v(xbgr.mr_n76425456)
print v(xbgr.mr_n77702112)
print v(xbgr.mr_n77953120)
print v(xbgr.mr_n78196384)
print v(xbgr.mr_n75548976)
print v(xbgr.mr_n75301952)
print v(xbgr.mr_n75509408)
print v(xbgr.mr_n75680736)
print v(xbgr.mr_n76013856)
print v(xbgr.mr_n76058976)
print v(xbgr.mr_n76331536)
print v(xbgr.mr_n76538080)
print v(xbgr.mr_n77608480)
print v(xbgr.mr_n77846256)
print v(xbgr.mr_n78188704)
print v(xbgr.mr_n76688096)
print v(xbgr.mr_n76737904)
print v(xbgr.mr_n76920816)
print v(xbgr.mr_n77001440)
print v(xbgr.mr_n77127376)
print v(xbgr.mr_n77242048)
print v(xbgr.mr_n77340848)
print v(xbgr.mr_n77468000)
print v(xbgr.mr_n76684560)
print v(xbgr.mr_n76774064)
print v(xbgr.mr_n76915456)
print v(xbgr.mr_n76997520)
print v(xbgr.mr_n77126480)
print v(xbgr.mr_n77248080)
print v(xbgr.mr_n77340256)
print v(xbgr.mr_n77469680)
print v(xbgr.mr_n77524528)
print v(xbgr.mr_n77753744)
print v(xbgr.mr_n77969584)
print v(xbgr.mr_n75389664)
print v(xbgr.mr_n75508688)
print v(xbgr.mr_n75678832)
print v(xbgr.mr_n76003392)
print v(xbgr.mr_n77690992)
print v(xbgr.mr_n77837104)
print v(xbgr.mr_n78200512)
print v(xbgr.mr_n76620896)
print v(xbgr.mr_n76710080)
print v(xbgr.mr_n76805712)
print v(xbgr.mr_n76940800)
print v(xbgr.mr_n77023392)
print v(xbgr.mr_n77145872)
print v(xbgr.mr_n77272144)
print v(xbgr.mr_n77405216)
print v(xbgr.mr_n77697600)
print v(xbgr.mr_n77955296)
print v(xbgr.mr_n78198944)
print v(xbgr.mr_n75521248)
print v(xbgr.mr_n76681936)
print v(xbgr.mr_n76712240)
print v(xbgr.mr_n76913888)
print v(xbgr.mr_n76999968)
print v(xbgr.mr_n77119616)
print v(xbgr.mr_n77229392)
print v(xbgr.mr_n77273520)
print v(xbgr.mr_n77403616)
print v(xbgr.mr_n76063664)
print v(xbgr.mr_n76376336)
print v(xbgr.mr_n76538416)
print v(xbgr.mr_n76064720)
print v(xbgr.mr_n76389568)
print v(xbgr.mr_n76478880)
print v(xbgr.mr_n77691168)
print v(xbgr.mr_n77842640)
print v(xbgr.mr_n78191264)
print v(xbgr.mr_n75549984)
print v(xbgr.mr_n77519728)
print v(xbgr.mr_n77753568)
print v(xbgr.mr_n77970672)
print v(xbgr.mr_n76012016)
print v(xbgr.mr_n75545264)
print v(xbgr.mr_n76239888)
print v(xbgr.mr_n76406752)
print v(xbgr.mr_n75315904)
print v(xbgr.mr_n77585376)
print v(xbgr.mr_n77837216)
print v(xbgr.mr_n78203072)
print v(xbgr.mr_n76060640)
print v(xbgr.mr_n76360208)
print v(xbgr.mr_n76464256)
print v(dvbe)
print v(iptat)
print v(pbias)
print v(pcasc)
print v(r4)
print v(vbe)
print v(vdd)
print v(vref)
print v(vdd)-v(vdd)
echo METALLIC_POINT_VOLTAGES_END
echo METALLIC_ALL_NODE_VOLTAGES_BEGIN
print v(xbgr.b1b)
print v(xbgr.c2)
print v(xbgr.d1)
print v(xbgr.d2)
print v(xbgr.d3)
print v(xbgr.d4)
print v(xbgr.d5)
print v(xbgr.det)
print v(dvbe)
print v(iptat)
print v(xbgr.kick)
print v(xbgr.mr_n62084080)
print v(xbgr.mr_n62129696)
print v(xbgr.mr_n64521536)
print v(xbgr.mr_n64597792)
print v(xbgr.mr_n64635056)
print v(xbgr.mr_n65491728)
print v(xbgr.mr_n65491840)
print v(xbgr.mr_n65494576)
print v(xbgr.mr_n65494688)
print v(xbgr.mr_n65495104)
print v(xbgr.mr_n65495216)
print v(xbgr.mr_n65495536)
print v(xbgr.mr_n65495648)
print v(xbgr.mr_n65496080)
print v(xbgr.mr_n65496320)
print v(xbgr.mr_n65496432)
print v(xbgr.mr_n65496784)
print v(xbgr.mr_n65497104)
print v(xbgr.mr_n65497216)
print v(xbgr.mr_n65497648)
print v(xbgr.mr_n65497968)
print v(xbgr.mr_n65498080)
print v(xbgr.mr_n65498512)
print v(xbgr.mr_n65498832)
print v(xbgr.mr_n65498944)
print v(xbgr.mr_n65499376)
print v(xbgr.mr_n65499696)
print v(xbgr.mr_n65499808)
print v(xbgr.mr_n65500240)
print v(xbgr.mr_n65500560)
print v(xbgr.mr_n65500672)
print v(xbgr.mr_n65501104)
print v(xbgr.mr_n65501424)
print v(xbgr.mr_n65501536)
print v(xbgr.mr_n65501968)
print v(xbgr.mr_n65502288)
print v(xbgr.mr_n65502400)
print v(xbgr.mr_n65502832)
print v(xbgr.mr_n65503152)
print v(xbgr.mr_n65503264)
print v(xbgr.mr_n65503696)
print v(xbgr.mr_n65504016)
print v(xbgr.mr_n65504128)
print v(xbgr.mr_n65504560)
print v(xbgr.mr_n65504880)
print v(xbgr.mr_n65504992)
print v(xbgr.mr_n65505424)
print v(xbgr.mr_n65505744)
print v(xbgr.mr_n65505856)
print v(xbgr.mr_n65506288)
print v(xbgr.mr_n65506608)
print v(xbgr.mr_n65506720)
print v(xbgr.mr_n65507152)
print v(xbgr.mr_n65507472)
print v(xbgr.mr_n65507584)
print v(xbgr.mr_n65508016)
print v(xbgr.mr_n65508336)
print v(xbgr.mr_n65508448)
print v(xbgr.mr_n65508880)
print v(xbgr.mr_n65509200)
print v(xbgr.mr_n65509312)
print v(xbgr.mr_n65509744)
print v(xbgr.mr_n65510064)
print v(xbgr.mr_n65510176)
print v(xbgr.mr_n65510496)
print v(xbgr.mr_n65510608)
print v(xbgr.mr_n65510928)
print v(xbgr.mr_n65511040)
print v(xbgr.mr_n65511360)
print v(xbgr.mr_n65511472)
print v(xbgr.mr_n65511792)
print v(xbgr.mr_n65511904)
print v(xbgr.mr_n65512224)
print v(xbgr.mr_n65512336)
print v(xbgr.mr_n65512656)
print v(xbgr.mr_n65512768)
print v(xbgr.mr_n65513088)
print v(xbgr.mr_n65513200)
print v(xbgr.mr_n65513520)
print v(xbgr.mr_n65513632)
print v(xbgr.mr_n65513952)
print v(xbgr.mr_n65514064)
print v(xbgr.mr_n65514384)
print v(xbgr.mr_n65514496)
print v(xbgr.mr_n65514816)
print v(xbgr.mr_n65514928)
print v(xbgr.mr_n65515248)
print v(xbgr.mr_n65515360)
print v(xbgr.mr_n65515680)
print v(xbgr.mr_n65515792)
print v(xbgr.mr_n65516112)
print v(xbgr.mr_n65516224)
print v(xbgr.mr_n65516544)
print v(xbgr.mr_n65516656)
print v(xbgr.mr_n65516976)
print v(xbgr.mr_n65517088)
print v(xbgr.mr_n65517408)
print v(xbgr.mr_n65517520)
print v(xbgr.mr_n65517840)
print v(xbgr.mr_n65517952)
print v(xbgr.mr_n65518272)
print v(xbgr.mr_n65518384)
print v(xbgr.mr_n65518704)
print v(xbgr.mr_n65518816)
print v(xbgr.mr_n65519136)
print v(xbgr.mr_n65519248)
print v(xbgr.mr_n65519568)
print v(xbgr.mr_n65519680)
print v(xbgr.mr_n65520000)
print v(xbgr.mr_n65520112)
print v(xbgr.mr_n65520432)
print v(xbgr.mr_n65520544)
print v(xbgr.mr_n65520864)
print v(xbgr.mr_n65520976)
print v(xbgr.mr_n65521296)
print v(xbgr.mr_n65521408)
print v(xbgr.mr_n65521728)
print v(xbgr.mr_n65521840)
print v(xbgr.mr_n65522160)
print v(xbgr.mr_n65522272)
print v(xbgr.mr_n65522592)
print v(xbgr.mr_n65522704)
print v(xbgr.mr_n65523024)
print v(xbgr.mr_n65523136)
print v(xbgr.mr_n65523456)
print v(xbgr.mr_n65523568)
print v(xbgr.mr_n65523888)
print v(xbgr.mr_n65524000)
print v(xbgr.mr_n65524320)
print v(xbgr.mr_n65524432)
print v(xbgr.mr_n65524752)
print v(xbgr.mr_n65524864)
print v(xbgr.mr_n65525184)
print v(xbgr.mr_n65525296)
print v(xbgr.mr_n65525616)
print v(xbgr.mr_n65525728)
print v(xbgr.mr_n65525856)
print v(xbgr.mr_n65525968)
print v(xbgr.mr_n65526288)
print v(xbgr.mr_n65526400)
print v(xbgr.mr_n65526720)
print v(xbgr.mr_n65526832)
print v(xbgr.mr_n65527152)
print v(xbgr.mr_n65527264)
print v(xbgr.mr_n65527584)
print v(xbgr.mr_n65527696)
print v(xbgr.mr_n65528016)
print v(xbgr.mr_n65528128)
print v(xbgr.mr_n65528448)
print v(xbgr.mr_n65528560)
print v(xbgr.mr_n65528880)
print v(xbgr.mr_n65528992)
print v(xbgr.mr_n65529312)
print v(xbgr.mr_n65529424)
print v(xbgr.mr_n65529744)
print v(xbgr.mr_n65529856)
print v(xbgr.mr_n65530176)
print v(xbgr.mr_n65530288)
print v(xbgr.mr_n65530608)
print v(xbgr.mr_n65530720)
print v(xbgr.mr_n65531040)
print v(xbgr.mr_n65531152)
print v(xbgr.mr_n65531472)
print v(xbgr.mr_n65531584)
print v(xbgr.mr_n65531904)
print v(xbgr.mr_n65532016)
print v(xbgr.mr_n65532336)
print v(xbgr.mr_n65532448)
print v(xbgr.mr_n65532768)
print v(xbgr.mr_n65532880)
print v(xbgr.mr_n65533200)
print v(xbgr.mr_n65533312)
print v(xbgr.mr_n65533632)
print v(xbgr.mr_n65533744)
print v(xbgr.mr_n65534064)
print v(xbgr.mr_n65534176)
print v(xbgr.mr_n65534496)
print v(xbgr.mr_n65534608)
print v(xbgr.mr_n65534928)
print v(xbgr.mr_n65535040)
print v(xbgr.mr_n65535360)
print v(xbgr.mr_n65535472)
print v(xbgr.mr_n65535792)
print v(xbgr.mr_n65535904)
print v(xbgr.mr_n65536224)
print v(xbgr.mr_n65536336)
print v(xbgr.mr_n65536656)
print v(xbgr.mr_n65536768)
print v(xbgr.mr_n65537088)
print v(xbgr.mr_n65537200)
print v(xbgr.mr_n65537520)
print v(xbgr.mr_n65537632)
print v(xbgr.mr_n65537952)
print v(xbgr.mr_n65538064)
print v(xbgr.mr_n65538384)
print v(xbgr.mr_n65538496)
print v(xbgr.mr_n65538816)
print v(xbgr.mr_n65538928)
print v(xbgr.mr_n65539248)
print v(xbgr.mr_n65539360)
print v(xbgr.mr_n65539680)
print v(xbgr.mr_n65539792)
print v(xbgr.mr_n65540112)
print v(xbgr.mr_n65540224)
print v(xbgr.mr_n65540544)
print v(xbgr.mr_n65540656)
print v(xbgr.mr_n65540976)
print v(xbgr.mr_n65541088)
print v(xbgr.mr_n65541408)
print v(xbgr.mr_n65541520)
print v(xbgr.mr_n65541840)
print v(xbgr.mr_n65541952)
print v(xbgr.mr_n65542272)
print v(xbgr.mr_n65542384)
print v(xbgr.mr_n65542704)
print v(xbgr.mr_n65542816)
print v(xbgr.mr_n65543136)
print v(xbgr.mr_n65543248)
print v(xbgr.mr_n65543568)
print v(xbgr.mr_n65543680)
print v(xbgr.mr_n65544000)
print v(xbgr.mr_n65544112)
print v(xbgr.mr_n65544432)
print v(xbgr.mr_n65544544)
print v(xbgr.mr_n65544864)
print v(xbgr.mr_n65544976)
print v(xbgr.mr_n65545296)
print v(xbgr.mr_n65545408)
print v(xbgr.mr_n65545728)
print v(xbgr.mr_n65545840)
print v(xbgr.mr_n65546160)
print v(xbgr.mr_n65546272)
print v(xbgr.mr_n65546592)
print v(xbgr.mr_n65546704)
print v(xbgr.mr_n65547024)
print v(xbgr.mr_n65547136)
print v(xbgr.mr_n65547456)
print v(xbgr.mr_n65547568)
print v(xbgr.mr_n65547888)
print v(xbgr.mr_n65548000)
print v(xbgr.mr_n65548320)
print v(xbgr.mr_n65548432)
print v(xbgr.mr_n65548752)
print v(xbgr.mr_n65548864)
print v(xbgr.mr_n65549184)
print v(xbgr.mr_n65549296)
print v(xbgr.mr_n65549616)
print v(xbgr.mr_n65549728)
print v(xbgr.mr_n65550048)
print v(xbgr.mr_n65550160)
print v(xbgr.mr_n65550480)
print v(xbgr.mr_n65550592)
print v(xbgr.mr_n65550912)
print v(xbgr.mr_n65551024)
print v(xbgr.mr_n65551344)
print v(xbgr.mr_n65551456)
print v(xbgr.mr_n65551776)
print v(xbgr.mr_n65551888)
print v(xbgr.mr_n65552208)
print v(xbgr.mr_n65552320)
print v(xbgr.mr_n65552640)
print v(xbgr.mr_n65552752)
print v(xbgr.mr_n65553072)
print v(xbgr.mr_n65553184)
print v(xbgr.mr_n65553504)
print v(xbgr.mr_n65553616)
print v(xbgr.mr_n65553936)
print v(xbgr.mr_n65554048)
print v(xbgr.mr_n65554368)
print v(xbgr.mr_n65554480)
print v(xbgr.mr_n65554800)
print v(xbgr.mr_n65554912)
print v(xbgr.mr_n65555232)
print v(xbgr.mr_n65555344)
print v(xbgr.mr_n65555664)
print v(xbgr.mr_n65555776)
print v(xbgr.mr_n65556096)
print v(xbgr.mr_n65556208)
print v(xbgr.mr_n65556528)
print v(xbgr.mr_n65556640)
print v(xbgr.mr_n65556960)
print v(xbgr.mr_n65557072)
print v(xbgr.mr_n65557392)
print v(xbgr.mr_n65557504)
print v(xbgr.mr_n65557824)
print v(xbgr.mr_n65557936)
print v(xbgr.mr_n65558256)
print v(xbgr.mr_n65558368)
print v(xbgr.mr_n65558688)
print v(xbgr.mr_n65558800)
print v(xbgr.mr_n65559120)
print v(xbgr.mr_n65559232)
print v(xbgr.mr_n65559552)
print v(xbgr.mr_n65559664)
print v(xbgr.mr_n65559984)
print v(xbgr.mr_n65560096)
print v(xbgr.mr_n65560416)
print v(xbgr.mr_n65560528)
print v(xbgr.mr_n65560848)
print v(xbgr.mr_n65560960)
print v(xbgr.mr_n65561280)
print v(xbgr.mr_n65561392)
print v(xbgr.mr_n65561936)
print v(xbgr.mr_n65562048)
print v(xbgr.mr_n65562368)
print v(xbgr.mr_n65562480)
print v(xbgr.mr_n65562800)
print v(xbgr.mr_n65562912)
print v(xbgr.mr_n65563232)
print v(xbgr.mr_n65563344)
print v(xbgr.mr_n65563664)
print v(xbgr.mr_n65563776)
print v(xbgr.mr_n65564096)
print v(xbgr.mr_n65564208)
print v(xbgr.mr_n65564528)
print v(xbgr.mr_n65564640)
print v(xbgr.mr_n65564960)
print v(xbgr.mr_n65565072)
print v(xbgr.mr_n65565392)
print v(xbgr.mr_n65565504)
print v(xbgr.mr_n65565824)
print v(xbgr.mr_n65565936)
print v(xbgr.mr_n65566256)
print v(xbgr.mr_n65566368)
print v(xbgr.mr_n65566688)
print v(xbgr.mr_n65566800)
print v(xbgr.mr_n65567120)
print v(xbgr.mr_n65567232)
print v(xbgr.mr_n65567552)
print v(xbgr.mr_n65567664)
print v(xbgr.mr_n65567984)
print v(xbgr.mr_n65568096)
print v(xbgr.mr_n65568416)
print v(xbgr.mr_n65568528)
print v(xbgr.mr_n65568848)
print v(xbgr.mr_n65568960)
print v(xbgr.mr_n65569280)
print v(xbgr.mr_n65569392)
print v(xbgr.mr_n65569712)
print v(xbgr.mr_n65569824)
print v(xbgr.mr_n65570144)
print v(xbgr.mr_n65570256)
print v(xbgr.mr_n65570576)
print v(xbgr.mr_n65570688)
print v(xbgr.mr_n65571008)
print v(xbgr.mr_n65571120)
print v(xbgr.mr_n65571440)
print v(xbgr.mr_n65571552)
print v(xbgr.mr_n65571872)
print v(xbgr.mr_n65571984)
print v(xbgr.mr_n65572304)
print v(xbgr.mr_n65572416)
print v(xbgr.mr_n65572736)
print v(xbgr.mr_n65572848)
print v(xbgr.mr_n65573168)
print v(xbgr.mr_n65573280)
print v(xbgr.mr_n65573600)
print v(xbgr.mr_n65573712)
print v(xbgr.mr_n65574032)
print v(xbgr.mr_n65574144)
print v(xbgr.mr_n65574464)
print v(xbgr.mr_n65574576)
print v(xbgr.mr_n65574896)
print v(xbgr.mr_n65575008)
print v(xbgr.mr_n65575328)
print v(xbgr.mr_n65575440)
print v(xbgr.mr_n65575760)
print v(xbgr.mr_n65575872)
print v(xbgr.mr_n65576192)
print v(xbgr.mr_n65576304)
print v(xbgr.mr_n65576624)
print v(xbgr.mr_n65576736)
print v(xbgr.mr_n65577056)
print v(xbgr.mr_n65577168)
print v(xbgr.mr_n65577488)
print v(xbgr.mr_n65577600)
print v(xbgr.mr_n65577920)
print v(xbgr.mr_n65578032)
print v(xbgr.mr_n65578352)
print v(xbgr.mr_n65578464)
print v(xbgr.mr_n65578784)
print v(xbgr.mr_n65578896)
print v(xbgr.mr_n65579216)
print v(xbgr.mr_n65579328)
print v(xbgr.mr_n65579648)
print v(xbgr.mr_n65579760)
print v(xbgr.mr_n65580080)
print v(xbgr.mr_n65580192)
print v(xbgr.mr_n65580512)
print v(xbgr.mr_n65580624)
print v(xbgr.mr_n65580944)
print v(xbgr.mr_n65581056)
print v(xbgr.mr_n65581376)
print v(xbgr.mr_n65581488)
print v(xbgr.mr_n65581808)
print v(xbgr.mr_n65581920)
print v(xbgr.mr_n65582240)
print v(xbgr.mr_n65582352)
print v(xbgr.mr_n65582672)
print v(xbgr.mr_n65582784)
print v(xbgr.mr_n65583104)
print v(xbgr.mr_n65583216)
print v(xbgr.mr_n65583536)
print v(xbgr.mr_n65583648)
print v(xbgr.mr_n65583968)
print v(xbgr.mr_n65584080)
print v(xbgr.mr_n65584400)
print v(xbgr.mr_n65584512)
print v(xbgr.mr_n65584832)
print v(xbgr.mr_n65584944)
print v(xbgr.mr_n65585264)
print v(xbgr.mr_n65585376)
print v(xbgr.mr_n65585696)
print v(xbgr.mr_n65585808)
print v(xbgr.mr_n65586128)
print v(xbgr.mr_n65586240)
print v(xbgr.mr_n65586560)
print v(xbgr.mr_n65586672)
print v(xbgr.mr_n65586992)
print v(xbgr.mr_n65587104)
print v(xbgr.mr_n65587424)
print v(xbgr.mr_n65587536)
print v(xbgr.mr_n65587856)
print v(xbgr.mr_n65587968)
print v(xbgr.mr_n65588288)
print v(xbgr.mr_n65588400)
print v(xbgr.mr_n65588720)
print v(xbgr.mr_n65588832)
print v(xbgr.mr_n65589152)
print v(xbgr.mr_n65589264)
print v(xbgr.mr_n65589584)
print v(xbgr.mr_n65589696)
print v(xbgr.mr_n65590016)
print v(xbgr.mr_n65590128)
print v(xbgr.mr_n65590448)
print v(xbgr.mr_n65590560)
print v(xbgr.mr_n65590880)
print v(xbgr.mr_n65590992)
print v(xbgr.mr_n65591312)
print v(xbgr.mr_n65591424)
print v(xbgr.mr_n65591744)
print v(xbgr.mr_n65591856)
print v(xbgr.mr_n65592176)
print v(xbgr.mr_n65592288)
print v(xbgr.mr_n65592608)
print v(xbgr.mr_n65592720)
print v(xbgr.mr_n65593040)
print v(xbgr.mr_n65593152)
print v(xbgr.mr_n65593472)
print v(xbgr.mr_n65593584)
print v(xbgr.mr_n65593904)
print v(xbgr.mr_n65594016)
print v(xbgr.mr_n65594336)
print v(xbgr.mr_n65594448)
print v(xbgr.mr_n65594768)
print v(xbgr.mr_n65594880)
print v(xbgr.mr_n65595200)
print v(xbgr.mr_n65595312)
print v(xbgr.mr_n65595632)
print v(xbgr.mr_n65595744)
print v(xbgr.mr_n65596064)
print v(xbgr.mr_n65596176)
print v(xbgr.mr_n65596496)
print v(xbgr.mr_n65596608)
print v(xbgr.mr_n65596928)
print v(xbgr.mr_n65597040)
print v(xbgr.mr_n65597360)
print v(xbgr.mr_n65597472)
print v(xbgr.mr_n65597792)
print v(xbgr.mr_n65597904)
print v(xbgr.mr_n65598224)
print v(xbgr.mr_n65598336)
print v(xbgr.mr_n65598656)
print v(xbgr.mr_n65598768)
print v(xbgr.mr_n65599088)
print v(xbgr.mr_n65599200)
print v(xbgr.mr_n65599520)
print v(xbgr.mr_n65599632)
print v(xbgr.mr_n65599952)
print v(xbgr.mr_n65600064)
print v(xbgr.mr_n65600384)
print v(xbgr.mr_n65600496)
print v(xbgr.mr_n65600816)
print v(xbgr.mr_n65600928)
print v(xbgr.mr_n65601248)
print v(xbgr.mr_n65601360)
print v(xbgr.mr_n65601680)
print v(xbgr.mr_n65601792)
print v(xbgr.mr_n65602112)
print v(xbgr.mr_n65602224)
print v(xbgr.mr_n65602544)
print v(xbgr.mr_n65602656)
print v(xbgr.mr_n65602976)
print v(xbgr.mr_n65603088)
print v(xbgr.mr_n65603408)
print v(xbgr.mr_n65603520)
print v(xbgr.mr_n65603840)
print v(xbgr.mr_n65603952)
print v(xbgr.mr_n65604272)
print v(xbgr.mr_n65604384)
print v(xbgr.mr_n65604704)
print v(xbgr.mr_n65604816)
print v(xbgr.mr_n65605136)
print v(xbgr.mr_n65605248)
print v(xbgr.mr_n65605568)
print v(xbgr.mr_n65605680)
print v(xbgr.mr_n65606000)
print v(xbgr.mr_n65606112)
print v(xbgr.mr_n65606432)
print v(xbgr.mr_n65606544)
print v(xbgr.mr_n65606864)
print v(xbgr.mr_n65606976)
print v(xbgr.mr_n65607296)
print v(xbgr.mr_n65607408)
print v(xbgr.mr_n65607728)
print v(xbgr.mr_n65607840)
print v(xbgr.mr_n65608160)
print v(xbgr.mr_n65608272)
print v(xbgr.mr_n65608592)
print v(xbgr.mr_n65608704)
print v(xbgr.mr_n65609024)
print v(xbgr.mr_n65609136)
print v(xbgr.mr_n65609456)
print v(xbgr.mr_n65609568)
print v(xbgr.mr_n65609888)
print v(xbgr.mr_n65610000)
print v(xbgr.mr_n65610320)
print v(xbgr.mr_n65610432)
print v(xbgr.mr_n65610752)
print v(xbgr.mr_n65610864)
print v(xbgr.mr_n65611184)
print v(xbgr.mr_n65611296)
print v(xbgr.mr_n65611616)
print v(xbgr.mr_n65611728)
print v(xbgr.mr_n65612048)
print v(xbgr.mr_n65612160)
print v(xbgr.mr_n65612480)
print v(xbgr.mr_n65612592)
print v(xbgr.mr_n65612912)
print v(xbgr.mr_n65613024)
print v(xbgr.mr_n65613344)
print v(xbgr.mr_n65613456)
print v(xbgr.mr_n65613776)
print v(xbgr.mr_n65613888)
print v(xbgr.mr_n65614208)
print v(xbgr.mr_n65614320)
print v(xbgr.mr_n65614640)
print v(xbgr.mr_n65614752)
print v(xbgr.mr_n65615072)
print v(xbgr.mr_n65615184)
print v(xbgr.mr_n65615504)
print v(xbgr.mr_n65615616)
print v(xbgr.mr_n65615936)
print v(xbgr.mr_n65616048)
print v(xbgr.mr_n65616368)
print v(xbgr.mr_n65616480)
print v(xbgr.mr_n65616800)
print v(xbgr.mr_n65616912)
print v(xbgr.mr_n65617232)
print v(xbgr.mr_n65617344)
print v(xbgr.mr_n65617664)
print v(xbgr.mr_n65617776)
print v(xbgr.mr_n65618096)
print v(xbgr.mr_n65618208)
print v(xbgr.mr_n65618528)
print v(xbgr.mr_n65618640)
print v(xbgr.mr_n65618960)
print v(xbgr.mr_n65619072)
print v(xbgr.mr_n65619392)
print v(xbgr.mr_n65619504)
print v(xbgr.mr_n65619824)
print v(xbgr.mr_n65619936)
print v(xbgr.mr_n65620256)
print v(xbgr.mr_n65620368)
print v(xbgr.mr_n65620688)
print v(xbgr.mr_n65620800)
print v(xbgr.mr_n65621120)
print v(xbgr.mr_n65621232)
print v(xbgr.mr_n65621552)
print v(xbgr.mr_n65621664)
print v(xbgr.mr_n65621984)
print v(xbgr.mr_n65622096)
print v(xbgr.mr_n65622416)
print v(xbgr.mr_n65622528)
print v(xbgr.mr_n65622848)
print v(xbgr.mr_n65622960)
print v(xbgr.mr_n65623280)
print v(xbgr.mr_n65623392)
print v(xbgr.mr_n65623712)
print v(xbgr.mr_n65623824)
print v(xbgr.mr_n65624144)
print v(xbgr.mr_n65624256)
print v(xbgr.mr_n65624576)
print v(xbgr.mr_n65624688)
print v(xbgr.mr_n65625008)
print v(xbgr.mr_n65625120)
print v(xbgr.mr_n65625440)
print v(xbgr.mr_n65625552)
print v(xbgr.mr_n65625872)
print v(xbgr.mr_n65625984)
print v(xbgr.mr_n65626304)
print v(xbgr.mr_n65626416)
print v(xbgr.mr_n65626736)
print v(xbgr.mr_n65626848)
print v(xbgr.mr_n65627168)
print v(xbgr.mr_n65627280)
print v(xbgr.mr_n65627600)
print v(xbgr.mr_n65627712)
print v(xbgr.mr_n65628032)
print v(xbgr.mr_n65628144)
print v(xbgr.mr_n65628464)
print v(xbgr.mr_n65628576)
print v(xbgr.mr_n65628896)
print v(xbgr.mr_n65629008)
print v(xbgr.mr_n65629328)
print v(xbgr.mr_n65629440)
print v(xbgr.mr_n65629760)
print v(xbgr.mr_n65629872)
print v(xbgr.mr_n65630192)
print v(xbgr.mr_n65630304)
print v(xbgr.mr_n65630624)
print v(xbgr.mr_n65630736)
print v(xbgr.mr_n65631056)
print v(xbgr.mr_n65631168)
print v(xbgr.mr_n65631488)
print v(xbgr.mr_n65631600)
print v(xbgr.mr_n65631920)
print v(xbgr.mr_n65632032)
print v(xbgr.mr_n65632352)
print v(xbgr.mr_n65632464)
print v(xbgr.mr_n65632784)
print v(xbgr.mr_n65632896)
print v(xbgr.mr_n65633216)
print v(xbgr.mr_n65633328)
print v(xbgr.mr_n65633648)
print v(xbgr.mr_n65633760)
print v(xbgr.mr_n65634080)
print v(xbgr.mr_n65634192)
print v(xbgr.mr_n65634512)
print v(xbgr.mr_n65634624)
print v(xbgr.mr_n65634944)
print v(xbgr.mr_n65635056)
print v(xbgr.mr_n65635376)
print v(xbgr.mr_n65635488)
print v(xbgr.mr_n65635808)
print v(xbgr.mr_n65635920)
print v(xbgr.mr_n65636240)
print v(xbgr.mr_n65636352)
print v(xbgr.mr_n65636672)
print v(xbgr.mr_n65636784)
print v(xbgr.mr_n65637104)
print v(xbgr.mr_n65637216)
print v(xbgr.mr_n65637536)
print v(xbgr.mr_n65637648)
print v(xbgr.mr_n65637968)
print v(xbgr.mr_n65638080)
print v(xbgr.mr_n65638400)
print v(xbgr.mr_n65638512)
print v(xbgr.mr_n65638832)
print v(xbgr.mr_n65638944)
print v(xbgr.mr_n65639264)
print v(xbgr.mr_n65639376)
print v(xbgr.mr_n65639696)
print v(xbgr.mr_n65639808)
print v(xbgr.mr_n65640128)
print v(xbgr.mr_n65640240)
print v(xbgr.mr_n65640560)
print v(xbgr.mr_n65640672)
print v(xbgr.mr_n65640992)
print v(xbgr.mr_n65641104)
print v(xbgr.mr_n65641424)
print v(xbgr.mr_n65641536)
print v(xbgr.mr_n65641856)
print v(xbgr.mr_n65641968)
print v(xbgr.mr_n65642288)
print v(xbgr.mr_n65642400)
print v(xbgr.mr_n65642720)
print v(xbgr.mr_n65642832)
print v(xbgr.mr_n65643152)
print v(xbgr.mr_n65643264)
print v(xbgr.mr_n65643584)
print v(xbgr.mr_n65643696)
print v(xbgr.mr_n65644016)
print v(xbgr.mr_n65644128)
print v(xbgr.mr_n65644448)
print v(xbgr.mr_n65644560)
print v(xbgr.mr_n65644880)
print v(xbgr.mr_n65644992)
print v(xbgr.mr_n65645312)
print v(xbgr.mr_n65645424)
print v(xbgr.mr_n65645744)
print v(xbgr.mr_n65645856)
print v(xbgr.mr_n65646176)
print v(xbgr.mr_n65646288)
print v(xbgr.mr_n65646608)
print v(xbgr.mr_n65646720)
print v(xbgr.mr_n65647040)
print v(xbgr.mr_n65647152)
print v(xbgr.mr_n65647472)
print v(xbgr.mr_n65647584)
print v(xbgr.mr_n65647904)
print v(xbgr.mr_n65648016)
print v(xbgr.mr_n65648336)
print v(xbgr.mr_n65648448)
print v(xbgr.mr_n65648768)
print v(xbgr.mr_n65648880)
print v(xbgr.mr_n65649200)
print v(xbgr.mr_n65649312)
print v(xbgr.mr_n65649632)
print v(xbgr.mr_n65649744)
print v(xbgr.mr_n65650064)
print v(xbgr.mr_n65650176)
print v(xbgr.mr_n65650496)
print v(xbgr.mr_n65650608)
print v(xbgr.mr_n65650928)
print v(xbgr.mr_n65651040)
print v(xbgr.mr_n65651360)
print v(xbgr.mr_n65651472)
print v(xbgr.mr_n65651792)
print v(xbgr.mr_n65651904)
print v(xbgr.mr_n65652224)
print v(xbgr.mr_n65652336)
print v(xbgr.mr_n65652656)
print v(xbgr.mr_n65652768)
print v(xbgr.mr_n65653088)
print v(xbgr.mr_n65653200)
print v(xbgr.mr_n65653520)
print v(xbgr.mr_n65653632)
print v(xbgr.mr_n65653952)
print v(xbgr.mr_n65654064)
print v(xbgr.mr_n65654384)
print v(xbgr.mr_n65654496)
print v(xbgr.mr_n65654816)
print v(xbgr.mr_n65654928)
print v(xbgr.mr_n65655248)
print v(xbgr.mr_n65655360)
print v(xbgr.mr_n65655680)
print v(xbgr.mr_n65655792)
print v(xbgr.mr_n65656112)
print v(xbgr.mr_n65656224)
print v(xbgr.mr_n65656544)
print v(xbgr.mr_n65656656)
print v(xbgr.mr_n65656976)
print v(xbgr.mr_n65657088)
print v(xbgr.mr_n65657408)
print v(xbgr.mr_n65657520)
print v(xbgr.mr_n65657840)
print v(xbgr.mr_n65657952)
print v(xbgr.mr_n65658272)
print v(xbgr.mr_n65658384)
print v(xbgr.mr_n65658704)
print v(xbgr.mr_n65658816)
print v(xbgr.mr_n65659136)
print v(xbgr.mr_n65659248)
print v(xbgr.mr_n65659568)
print v(xbgr.mr_n65659680)
print v(xbgr.mr_n66664272)
print v(xbgr.mr_n66664384)
print v(xbgr.mr_n66664640)
print v(xbgr.mr_n66664752)
print v(xbgr.mr_n66665008)
print v(xbgr.mr_n66665120)
print v(xbgr.mr_n66665376)
print v(xbgr.mr_n66665488)
print v(xbgr.mr_n66665744)
print v(xbgr.mr_n66665856)
print v(xbgr.mr_n66666112)
print v(xbgr.mr_n66666224)
print v(xbgr.mr_n66666480)
print v(xbgr.mr_n66666592)
print v(xbgr.mr_n66666848)
print v(xbgr.mr_n66666960)
print v(xbgr.mr_n66667280)
print v(xbgr.mr_n66667392)
print v(xbgr.mr_n66667712)
print v(xbgr.mr_n66667824)
print v(xbgr.mr_n66668144)
print v(xbgr.mr_n66668256)
print v(xbgr.mr_n66668576)
print v(xbgr.mr_n66668688)
print v(xbgr.mr_n66669008)
print v(xbgr.mr_n66669120)
print v(xbgr.mr_n66669440)
print v(xbgr.mr_n66669552)
print v(xbgr.mr_n66669872)
print v(xbgr.mr_n66669984)
print v(xbgr.mr_n66670304)
print v(xbgr.mr_n66670416)
print v(xbgr.mr_n66670736)
print v(xbgr.mr_n66670848)
print v(xbgr.mr_n66671168)
print v(xbgr.mr_n66671280)
print v(xbgr.mr_n66671600)
print v(xbgr.mr_n66671712)
print v(xbgr.mr_n66672032)
print v(xbgr.mr_n66672144)
print v(xbgr.mr_n66672464)
print v(xbgr.mr_n66672576)
print v(xbgr.mr_n66672896)
print v(xbgr.mr_n66673008)
print v(xbgr.mr_n66673328)
print v(xbgr.mr_n66673440)
print v(xbgr.mr_n66673760)
print v(xbgr.mr_n66673872)
print v(xbgr.mr_n66674192)
print v(xbgr.mr_n66674304)
print v(xbgr.mr_n66674624)
print v(xbgr.mr_n66674736)
print v(xbgr.mr_n66675056)
print v(xbgr.mr_n66675168)
print v(xbgr.mr_n66675488)
print v(xbgr.mr_n66675600)
print v(xbgr.mr_n66675920)
print v(xbgr.mr_n66676032)
print v(xbgr.mr_n66676352)
print v(xbgr.mr_n66676464)
print v(xbgr.mr_n66676784)
print v(xbgr.mr_n66676896)
print v(xbgr.mr_n66677216)
print v(xbgr.mr_n66677328)
print v(xbgr.mr_n66677648)
print v(xbgr.mr_n66677760)
print v(xbgr.mr_n66678080)
print v(xbgr.mr_n66678192)
print v(xbgr.mr_n66678512)
print v(xbgr.mr_n66678624)
print v(xbgr.mr_n66678944)
print v(xbgr.mr_n66679056)
print v(xbgr.mr_n66679376)
print v(xbgr.mr_n66679488)
print v(xbgr.mr_n66679808)
print v(xbgr.mr_n66679920)
print v(xbgr.mr_n66680240)
print v(xbgr.mr_n66680352)
print v(xbgr.mr_n66680672)
print v(xbgr.mr_n66680784)
print v(xbgr.mr_n66681104)
print v(xbgr.mr_n66681216)
print v(xbgr.mr_n66681536)
print v(xbgr.mr_n66681648)
print v(xbgr.mr_n66681968)
print v(xbgr.mr_n66682080)
print v(xbgr.mr_n66682400)
print v(xbgr.mr_n66682512)
print v(xbgr.mr_n66682832)
print v(xbgr.mr_n66682944)
print v(xbgr.mr_n66683264)
print v(xbgr.mr_n66683376)
print v(xbgr.mr_n66683696)
print v(xbgr.mr_n66683808)
print v(xbgr.mr_n66684128)
print v(xbgr.mr_n66684240)
print v(xbgr.mr_n66684560)
print v(xbgr.mr_n66684672)
print v(xbgr.mr_n66684992)
print v(xbgr.mr_n66685104)
print v(xbgr.mr_n66685424)
print v(xbgr.mr_n66685536)
print v(xbgr.mr_n66685856)
print v(xbgr.mr_n66685968)
print v(xbgr.mr_n66686288)
print v(xbgr.mr_n66686400)
print v(xbgr.mr_n66686720)
print v(xbgr.mr_n66686832)
print v(xbgr.mr_n66687152)
print v(xbgr.mr_n66687264)
print v(xbgr.mr_n66687584)
print v(xbgr.mr_n66687696)
print v(xbgr.mr_n66688016)
print v(xbgr.mr_n66688128)
print v(xbgr.mr_n66688448)
print v(xbgr.mr_n66688560)
print v(xbgr.mr_n66688880)
print v(xbgr.mr_n66688992)
print v(xbgr.mr_n66689312)
print v(xbgr.mr_n66689424)
print v(xbgr.mr_n66689744)
print v(xbgr.mr_n66689856)
print v(xbgr.mr_n66690176)
print v(xbgr.mr_n66690288)
print v(xbgr.mr_n66690608)
print v(xbgr.mr_n66690720)
print v(xbgr.mr_n66691040)
print v(xbgr.mr_n66691152)
print v(xbgr.mr_n66691472)
print v(xbgr.mr_n66691584)
print v(xbgr.mr_n66691904)
print v(xbgr.mr_n66692016)
print v(xbgr.mr_n66692336)
print v(xbgr.mr_n66692448)
print v(xbgr.mr_n66692768)
print v(xbgr.mr_n66692880)
print v(xbgr.mr_n66693200)
print v(xbgr.mr_n66693312)
print v(xbgr.mr_n66693632)
print v(xbgr.mr_n66693744)
print v(xbgr.mr_n66694064)
print v(xbgr.mr_n66694176)
print v(xbgr.mr_n66694496)
print v(xbgr.mr_n66694608)
print v(xbgr.mr_n66694928)
print v(xbgr.mr_n66695040)
print v(xbgr.mr_n66695360)
print v(xbgr.mr_n66695472)
print v(xbgr.mr_n66695792)
print v(xbgr.mr_n66695904)
print v(xbgr.mr_n66696224)
print v(xbgr.mr_n66696336)
print v(xbgr.mr_n66696656)
print v(xbgr.mr_n66696768)
print v(xbgr.mr_n66697088)
print v(xbgr.mr_n66697200)
print v(xbgr.mr_n66697520)
print v(xbgr.mr_n66697632)
print v(xbgr.mr_n66697952)
print v(xbgr.mr_n66698064)
print v(xbgr.mr_n66698384)
print v(xbgr.mr_n66698496)
print v(xbgr.mr_n66698816)
print v(xbgr.mr_n66698928)
print v(xbgr.mr_n66699248)
print v(xbgr.mr_n66699360)
print v(xbgr.mr_n66699680)
print v(xbgr.mr_n66699792)
print v(xbgr.mr_n66700112)
print v(xbgr.mr_n66700224)
print v(xbgr.mr_n66700544)
print v(xbgr.mr_n66700656)
print v(xbgr.mr_n66700976)
print v(xbgr.mr_n66701088)
print v(xbgr.mr_n66701408)
print v(xbgr.mr_n66701520)
print v(xbgr.mr_n66701840)
print v(xbgr.mr_n66701952)
print v(xbgr.mr_n66702272)
print v(xbgr.mr_n66702384)
print v(xbgr.mr_n66702704)
print v(xbgr.mr_n66702816)
print v(xbgr.mr_n66703136)
print v(xbgr.mr_n66703248)
print v(xbgr.mr_n66703568)
print v(xbgr.mr_n66703680)
print v(xbgr.mr_n66704000)
print v(xbgr.mr_n66704112)
print v(xbgr.mr_n66704432)
print v(xbgr.mr_n66704544)
print v(xbgr.mr_n66704864)
print v(xbgr.mr_n66704976)
print v(xbgr.mr_n66705296)
print v(xbgr.mr_n66705408)
print v(xbgr.mr_n66705728)
print v(xbgr.mr_n66705840)
print v(xbgr.mr_n66706160)
print v(xbgr.mr_n66706272)
print v(xbgr.mr_n66706592)
print v(xbgr.mr_n66706704)
print v(xbgr.mr_n66707024)
print v(xbgr.mr_n66707136)
print v(xbgr.mr_n66707456)
print v(xbgr.mr_n66707568)
print v(xbgr.mr_n66707888)
print v(xbgr.mr_n66708000)
print v(xbgr.mr_n66708320)
print v(xbgr.mr_n66708432)
print v(xbgr.mr_n66708752)
print v(xbgr.mr_n66708864)
print v(xbgr.mr_n66709184)
print v(xbgr.mr_n66709296)
print v(xbgr.mr_n66709616)
print v(xbgr.mr_n66709728)
print v(xbgr.mr_n66710048)
print v(xbgr.mr_n66710160)
print v(xbgr.mr_n66710480)
print v(xbgr.mr_n66710592)
print v(xbgr.mr_n66710912)
print v(xbgr.mr_n66711024)
print v(xbgr.mr_n66711344)
print v(xbgr.mr_n66711456)
print v(xbgr.mr_n66711776)
print v(xbgr.mr_n66711888)
print v(xbgr.mr_n66712208)
print v(xbgr.mr_n66712320)
print v(xbgr.mr_n66712640)
print v(xbgr.mr_n66712752)
print v(xbgr.mr_n66713072)
print v(xbgr.mr_n66713184)
print v(xbgr.mr_n66713504)
print v(xbgr.mr_n66713616)
print v(xbgr.mr_n66713936)
print v(xbgr.mr_n66714048)
print v(xbgr.mr_n66714368)
print v(xbgr.mr_n66714480)
print v(xbgr.mr_n66714800)
print v(xbgr.mr_n66714912)
print v(xbgr.mr_n66715232)
print v(xbgr.mr_n66715344)
print v(xbgr.mr_n66715664)
print v(xbgr.mr_n66715776)
print v(xbgr.mr_n66716096)
print v(xbgr.mr_n66716208)
print v(xbgr.mr_n66716528)
print v(xbgr.mr_n66716640)
print v(xbgr.mr_n66716960)
print v(xbgr.mr_n66717072)
print v(xbgr.mr_n66717392)
print v(xbgr.mr_n66717504)
print v(xbgr.mr_n66717824)
print v(xbgr.mr_n66717936)
print v(xbgr.mr_n66718256)
print v(xbgr.mr_n66718368)
print v(xbgr.mr_n66718688)
print v(xbgr.mr_n66718800)
print v(xbgr.mr_n66719120)
print v(xbgr.mr_n66719232)
print v(xbgr.mr_n66719552)
print v(xbgr.mr_n66719664)
print v(xbgr.mr_n66719984)
print v(xbgr.mr_n66720096)
print v(xbgr.mr_n66720416)
print v(xbgr.mr_n66720528)
print v(xbgr.mr_n66720848)
print v(xbgr.mr_n66720960)
print v(xbgr.mr_n66721280)
print v(xbgr.mr_n66721392)
print v(xbgr.mr_n66721712)
print v(xbgr.mr_n66721824)
print v(xbgr.mr_n66722144)
print v(xbgr.mr_n66722256)
print v(xbgr.mr_n66722576)
print v(xbgr.mr_n66722688)
print v(xbgr.mr_n66723008)
print v(xbgr.mr_n66723120)
print v(xbgr.mr_n66723440)
print v(xbgr.mr_n66723552)
print v(xbgr.mr_n66723872)
print v(xbgr.mr_n66723984)
print v(xbgr.mr_n66724304)
print v(xbgr.mr_n66724416)
print v(xbgr.mr_n66724736)
print v(xbgr.mr_n66724848)
print v(xbgr.mr_n66725168)
print v(xbgr.mr_n66725280)
print v(xbgr.mr_n66725600)
print v(xbgr.mr_n66725712)
print v(xbgr.mr_n66726032)
print v(xbgr.mr_n66726144)
print v(xbgr.mr_n66726464)
print v(xbgr.mr_n66726576)
print v(xbgr.mr_n66726896)
print v(xbgr.mr_n66727008)
print v(xbgr.mr_n66727328)
print v(xbgr.mr_n66727440)
print v(xbgr.mr_n66727760)
print v(xbgr.mr_n66727872)
print v(xbgr.mr_n66728192)
print v(xbgr.mr_n66728304)
print v(xbgr.mr_n66728624)
print v(xbgr.mr_n66728736)
print v(xbgr.mr_n66729056)
print v(xbgr.mr_n66729168)
print v(xbgr.mr_n66729488)
print v(xbgr.mr_n66729600)
print v(xbgr.mr_n66729920)
print v(xbgr.mr_n66730032)
print v(xbgr.mr_n66730352)
print v(xbgr.mr_n66730464)
print v(xbgr.mr_n66730784)
print v(xbgr.mr_n66730896)
print v(xbgr.mr_n66731216)
print v(xbgr.mr_n66731328)
print v(xbgr.mr_n66731648)
print v(xbgr.mr_n66731760)
print v(xbgr.mr_n66732080)
print v(xbgr.mr_n66732192)
print v(xbgr.mr_n66732512)
print v(xbgr.mr_n66732624)
print v(xbgr.mr_n66732944)
print v(xbgr.mr_n66733056)
print v(xbgr.mr_n66733376)
print v(xbgr.mr_n66733488)
print v(xbgr.mr_n66733808)
print v(xbgr.mr_n66733920)
print v(xbgr.mr_n66734240)
print v(xbgr.mr_n66734352)
print v(xbgr.mr_n66734672)
print v(xbgr.mr_n66734784)
print v(xbgr.mr_n66735104)
print v(xbgr.mr_n66735216)
print v(xbgr.mr_n66735536)
print v(xbgr.mr_n66735648)
print v(xbgr.mr_n66735968)
print v(xbgr.mr_n66736080)
print v(xbgr.mr_n66736400)
print v(xbgr.mr_n66736512)
print v(xbgr.mr_n66736832)
print v(xbgr.mr_n66736944)
print v(xbgr.mr_n66737264)
print v(xbgr.mr_n66737376)
print v(xbgr.mr_n66737696)
print v(xbgr.mr_n66737808)
print v(xbgr.mr_n66738128)
print v(xbgr.mr_n66738240)
print v(xbgr.mr_n66738560)
print v(xbgr.mr_n66738672)
print v(xbgr.mr_n66738992)
print v(xbgr.mr_n66739104)
print v(xbgr.mr_n66739424)
print v(xbgr.mr_n66739536)
print v(xbgr.mr_n66739856)
print v(xbgr.mr_n66739968)
print v(xbgr.mr_n66740288)
print v(xbgr.mr_n66740400)
print v(xbgr.mr_n66740720)
print v(xbgr.mr_n66740832)
print v(xbgr.mr_n66741152)
print v(xbgr.mr_n66741264)
print v(xbgr.mr_n66741584)
print v(xbgr.mr_n66741696)
print v(xbgr.mr_n66742016)
print v(xbgr.mr_n66742128)
print v(xbgr.mr_n66742448)
print v(xbgr.mr_n66742560)
print v(xbgr.mr_n66742880)
print v(xbgr.mr_n66742992)
print v(xbgr.mr_n66743312)
print v(xbgr.mr_n66743424)
print v(xbgr.mr_n66743744)
print v(xbgr.mr_n66743856)
print v(xbgr.mr_n66744176)
print v(xbgr.mr_n66744288)
print v(xbgr.mr_n66744608)
print v(xbgr.mr_n66744720)
print v(xbgr.mr_n66745040)
print v(xbgr.mr_n66745152)
print v(xbgr.mr_n66745472)
print v(xbgr.mr_n66745584)
print v(xbgr.mr_n66745904)
print v(xbgr.mr_n66746016)
print v(xbgr.mr_n66746336)
print v(xbgr.mr_n66746448)
print v(xbgr.mr_n66746768)
print v(xbgr.mr_n66746880)
print v(xbgr.mr_n66747200)
print v(xbgr.mr_n66747312)
print v(xbgr.mr_n66747632)
print v(xbgr.mr_n66747744)
print v(xbgr.mr_n66748064)
print v(xbgr.mr_n66748176)
print v(xbgr.mr_n66748496)
print v(xbgr.mr_n66748608)
print v(xbgr.mr_n66748928)
print v(xbgr.mr_n66749040)
print v(xbgr.mr_n66749360)
print v(xbgr.mr_n66749472)
print v(xbgr.mr_n66749792)
print v(xbgr.mr_n66749904)
print v(xbgr.mr_n66750224)
print v(xbgr.mr_n66750336)
print v(xbgr.mr_n66750656)
print v(xbgr.mr_n66750768)
print v(xbgr.mr_n66751088)
print v(xbgr.mr_n66751200)
print v(xbgr.mr_n66751520)
print v(xbgr.mr_n66751632)
print v(xbgr.mr_n66751952)
print v(xbgr.mr_n66752064)
print v(xbgr.mr_n66752384)
print v(xbgr.mr_n66752496)
print v(xbgr.mr_n66752816)
print v(xbgr.mr_n66752928)
print v(xbgr.mr_n66753248)
print v(xbgr.mr_n66753360)
print v(xbgr.mr_n66753680)
print v(xbgr.mr_n66753792)
print v(xbgr.mr_n66754112)
print v(xbgr.mr_n66754224)
print v(xbgr.mr_n66754544)
print v(xbgr.mr_n66754656)
print v(xbgr.mr_n66754976)
print v(xbgr.mr_n66755088)
print v(xbgr.mr_n66755408)
print v(xbgr.mr_n66755520)
print v(xbgr.mr_n66755840)
print v(xbgr.mr_n66755952)
print v(xbgr.mr_n66756272)
print v(xbgr.mr_n66756384)
print v(xbgr.mr_n66756704)
print v(xbgr.mr_n66756816)
print v(xbgr.mr_n66757136)
print v(xbgr.mr_n66757248)
print v(xbgr.mr_n66757568)
print v(xbgr.mr_n66757680)
print v(xbgr.mr_n66758000)
print v(xbgr.mr_n66758112)
print v(xbgr.mr_n66758432)
print v(xbgr.mr_n66758544)
print v(xbgr.mr_n66758864)
print v(xbgr.mr_n66758976)
print v(xbgr.mr_n66759296)
print v(xbgr.mr_n66759408)
print v(xbgr.mr_n66759728)
print v(xbgr.mr_n66759840)
print v(xbgr.mr_n66760160)
print v(xbgr.mr_n66760272)
print v(xbgr.mr_n66760592)
print v(xbgr.mr_n66760704)
print v(xbgr.mr_n66761024)
print v(xbgr.mr_n66761136)
print v(xbgr.mr_n66761456)
print v(xbgr.mr_n66761568)
print v(xbgr.mr_n66761888)
print v(xbgr.mr_n66762000)
print v(xbgr.mr_n66762320)
print v(xbgr.mr_n66762432)
print v(xbgr.mr_n66762752)
print v(xbgr.mr_n66762864)
print v(xbgr.mr_n66763184)
print v(xbgr.mr_n66763296)
print v(xbgr.mr_n66763616)
print v(xbgr.mr_n66763728)
print v(xbgr.mr_n66764048)
print v(xbgr.mr_n66764160)
print v(xbgr.mr_n66764480)
print v(xbgr.mr_n66764592)
print v(xbgr.mr_n66764912)
print v(xbgr.mr_n66765024)
print v(xbgr.mr_n66765344)
print v(xbgr.mr_n66765456)
print v(xbgr.mr_n66765776)
print v(xbgr.mr_n66765888)
print v(xbgr.mr_n66766208)
print v(xbgr.mr_n66766320)
print v(xbgr.mr_n66766640)
print v(xbgr.mr_n66766752)
print v(xbgr.mr_n66767072)
print v(xbgr.mr_n66767184)
print v(xbgr.mr_n66767504)
print v(xbgr.mr_n66767616)
print v(xbgr.mr_n66767936)
print v(xbgr.mr_n66768048)
print v(xbgr.mr_n66768336)
print v(xbgr.mr_n66768448)
print v(xbgr.mr_n66768768)
print v(xbgr.mr_n66768880)
print v(xbgr.mr_n66769200)
print v(xbgr.mr_n66769312)
print v(xbgr.mr_n66769632)
print v(xbgr.mr_n66769744)
print v(xbgr.mr_n66770064)
print v(xbgr.mr_n66770176)
print v(xbgr.mr_n66770496)
print v(xbgr.mr_n66770608)
print v(xbgr.mr_n66770928)
print v(xbgr.mr_n66771040)
print v(xbgr.mr_n66771360)
print v(xbgr.mr_n66771472)
print v(xbgr.mr_n66771792)
print v(xbgr.mr_n66771904)
print v(xbgr.mr_n66772224)
print v(xbgr.mr_n66772336)
print v(xbgr.mr_n66772656)
print v(xbgr.mr_n66772768)
print v(xbgr.mr_n66773088)
print v(xbgr.mr_n66773200)
print v(xbgr.mr_n66773520)
print v(xbgr.mr_n66773632)
print v(xbgr.mr_n66773952)
print v(xbgr.mr_n66774064)
print v(xbgr.mr_n66774384)
print v(xbgr.mr_n66774496)
print v(xbgr.mr_n66774816)
print v(xbgr.mr_n66774928)
print v(xbgr.mr_n66775248)
print v(xbgr.mr_n66775360)
print v(xbgr.mr_n66775680)
print v(xbgr.mr_n66775792)
print v(xbgr.mr_n66776112)
print v(xbgr.mr_n66776224)
print v(xbgr.mr_n66776544)
print v(xbgr.mr_n66776656)
print v(xbgr.mr_n66776976)
print v(xbgr.mr_n66777088)
print v(xbgr.mr_n66777408)
print v(xbgr.mr_n66777520)
print v(xbgr.mr_n66777840)
print v(xbgr.mr_n66777952)
print v(xbgr.mr_n66778272)
print v(xbgr.mr_n66778384)
print v(xbgr.mr_n66778704)
print v(xbgr.mr_n66778816)
print v(xbgr.mr_n66779136)
print v(xbgr.mr_n66779248)
print v(xbgr.mr_n66779568)
print v(xbgr.mr_n66779680)
print v(xbgr.mr_n66780000)
print v(xbgr.mr_n66780112)
print v(xbgr.mr_n66780432)
print v(xbgr.mr_n66780544)
print v(xbgr.mr_n66780864)
print v(xbgr.mr_n66780976)
print v(xbgr.mr_n66781296)
print v(xbgr.mr_n66781408)
print v(xbgr.mr_n66781728)
print v(xbgr.mr_n66781840)
print v(xbgr.mr_n66782160)
print v(xbgr.mr_n66782272)
print v(xbgr.mr_n66782592)
print v(xbgr.mr_n66782704)
print v(xbgr.mr_n66783024)
print v(xbgr.mr_n66783136)
print v(xbgr.mr_n66783456)
print v(xbgr.mr_n66783568)
print v(xbgr.mr_n66783888)
print v(xbgr.mr_n66784000)
print v(xbgr.mr_n66784320)
print v(xbgr.mr_n66784432)
print v(xbgr.mr_n66784752)
print v(xbgr.mr_n66784864)
print v(xbgr.mr_n66785184)
print v(xbgr.mr_n66785296)
print v(xbgr.mr_n66785616)
print v(xbgr.mr_n66785728)
print v(xbgr.mr_n66786048)
print v(xbgr.mr_n66786160)
print v(xbgr.mr_n66786480)
print v(xbgr.mr_n66786592)
print v(xbgr.mr_n66786912)
print v(xbgr.mr_n66787024)
print v(xbgr.mr_n66787344)
print v(xbgr.mr_n66787456)
print v(xbgr.mr_n66787776)
print v(xbgr.mr_n66787888)
print v(xbgr.mr_n66788208)
print v(xbgr.mr_n66788320)
print v(xbgr.mr_n66788640)
print v(xbgr.mr_n66788752)
print v(xbgr.mr_n66789072)
print v(xbgr.mr_n66789184)
print v(xbgr.mr_n66789504)
print v(xbgr.mr_n66789616)
print v(xbgr.mr_n66789936)
print v(xbgr.mr_n66790048)
print v(xbgr.mr_n66790368)
print v(xbgr.mr_n66790480)
print v(xbgr.mr_n66790800)
print v(xbgr.mr_n66790912)
print v(xbgr.mr_n66791232)
print v(xbgr.mr_n66791344)
print v(xbgr.mr_n66791664)
print v(xbgr.mr_n66791776)
print v(xbgr.mr_n66792096)
print v(xbgr.mr_n66792208)
print v(xbgr.mr_n66792528)
print v(xbgr.mr_n66792640)
print v(xbgr.mr_n66792960)
print v(xbgr.mr_n66793072)
print v(xbgr.mr_n66793392)
print v(xbgr.mr_n66793504)
print v(xbgr.mr_n66793824)
print v(xbgr.mr_n66793936)
print v(xbgr.mr_n66794256)
print v(xbgr.mr_n66794368)
print v(xbgr.mr_n66794688)
print v(xbgr.mr_n66794800)
print v(xbgr.mr_n66795120)
print v(xbgr.mr_n66795232)
print v(xbgr.mr_n66795552)
print v(xbgr.mr_n66795664)
print v(xbgr.mr_n66795984)
print v(xbgr.mr_n66796096)
print v(xbgr.mr_n66796416)
print v(xbgr.mr_n66796528)
print v(xbgr.mr_n66796848)
print v(xbgr.mr_n66796960)
print v(xbgr.mr_n66797280)
print v(xbgr.mr_n66797392)
print v(xbgr.mr_n66797712)
print v(xbgr.mr_n66797824)
print v(xbgr.mr_n66798144)
print v(xbgr.mr_n66798256)
print v(xbgr.mr_n66798576)
print v(xbgr.mr_n66798688)
print v(xbgr.mr_n66799008)
print v(xbgr.mr_n66799120)
print v(xbgr.mr_n66799440)
print v(xbgr.mr_n66799552)
print v(xbgr.mr_n66799872)
print v(xbgr.mr_n66799984)
print v(xbgr.mr_n66800304)
print v(xbgr.mr_n66800416)
print v(xbgr.mr_n66800736)
print v(xbgr.mr_n66800848)
print v(xbgr.mr_n66801168)
print v(xbgr.mr_n66801280)
print v(xbgr.mr_n66801600)
print v(xbgr.mr_n66801712)
print v(xbgr.mr_n66802032)
print v(xbgr.mr_n66802144)
print v(xbgr.mr_n66802464)
print v(xbgr.mr_n66802576)
print v(xbgr.mr_n66802896)
print v(xbgr.mr_n66803008)
print v(xbgr.mr_n66803328)
print v(xbgr.mr_n66803440)
print v(xbgr.mr_n66803760)
print v(xbgr.mr_n66803872)
print v(xbgr.mr_n66804192)
print v(xbgr.mr_n66804304)
print v(xbgr.mr_n66804624)
print v(xbgr.mr_n66804736)
print v(xbgr.mr_n66805056)
print v(xbgr.mr_n66805168)
print v(xbgr.mr_n66805488)
print v(xbgr.mr_n66805600)
print v(xbgr.mr_n66805920)
print v(xbgr.mr_n66806032)
print v(xbgr.mr_n66806352)
print v(xbgr.mr_n66806464)
print v(xbgr.mr_n66806784)
print v(xbgr.mr_n66806896)
print v(xbgr.mr_n66807216)
print v(xbgr.mr_n66807328)
print v(xbgr.mr_n66807648)
print v(xbgr.mr_n66807760)
print v(xbgr.mr_n66808080)
print v(xbgr.mr_n66808192)
print v(xbgr.mr_n66808512)
print v(xbgr.mr_n66808624)
print v(xbgr.mr_n66808944)
print v(xbgr.mr_n66809056)
print v(xbgr.mr_n66809376)
print v(xbgr.mr_n66809488)
print v(xbgr.mr_n66809808)
print v(xbgr.mr_n66809920)
print v(xbgr.mr_n66810240)
print v(xbgr.mr_n66810352)
print v(xbgr.mr_n66810672)
print v(xbgr.mr_n66810784)
print v(xbgr.mr_n66811104)
print v(xbgr.mr_n66811216)
print v(xbgr.mr_n66811536)
print v(xbgr.mr_n66811648)
print v(xbgr.mr_n66811968)
print v(xbgr.mr_n66812080)
print v(xbgr.mr_n66812400)
print v(xbgr.mr_n66812512)
print v(xbgr.mr_n66812832)
print v(xbgr.mr_n66812944)
print v(xbgr.mr_n66813264)
print v(xbgr.mr_n66813376)
print v(xbgr.mr_n66813696)
print v(xbgr.mr_n66813808)
print v(xbgr.mr_n66814128)
print v(xbgr.mr_n66814240)
print v(xbgr.mr_n66814560)
print v(xbgr.mr_n66814672)
print v(xbgr.mr_n66814992)
print v(xbgr.mr_n66815104)
print v(xbgr.mr_n66815424)
print v(xbgr.mr_n66815536)
print v(xbgr.mr_n66815856)
print v(xbgr.mr_n66815968)
print v(xbgr.mr_n66816288)
print v(xbgr.mr_n66816400)
print v(xbgr.mr_n66816720)
print v(xbgr.mr_n66816832)
print v(xbgr.mr_n66817152)
print v(xbgr.mr_n66817264)
print v(xbgr.mr_n66817584)
print v(xbgr.mr_n66817696)
print v(xbgr.mr_n66818016)
print v(xbgr.mr_n66818128)
print v(xbgr.mr_n66818448)
print v(xbgr.mr_n66818560)
print v(xbgr.mr_n66818880)
print v(xbgr.mr_n66818992)
print v(xbgr.mr_n66819312)
print v(xbgr.mr_n66819424)
print v(xbgr.mr_n66819744)
print v(xbgr.mr_n66819856)
print v(xbgr.mr_n66820176)
print v(xbgr.mr_n66820288)
print v(xbgr.mr_n66820608)
print v(xbgr.mr_n66820720)
print v(xbgr.mr_n66821040)
print v(xbgr.mr_n66821152)
print v(xbgr.mr_n66821472)
print v(xbgr.mr_n66821584)
print v(xbgr.mr_n66821904)
print v(xbgr.mr_n66822016)
print v(xbgr.mr_n66822336)
print v(xbgr.mr_n66822448)
print v(xbgr.mr_n66822768)
print v(xbgr.mr_n66822880)
print v(xbgr.mr_n66823200)
print v(xbgr.mr_n66823312)
print v(xbgr.mr_n66823632)
print v(xbgr.mr_n66823744)
print v(xbgr.mr_n66824064)
print v(xbgr.mr_n66824176)
print v(xbgr.mr_n66824496)
print v(xbgr.mr_n66824608)
print v(xbgr.mr_n66824928)
print v(xbgr.mr_n66825040)
print v(xbgr.mr_n66825360)
print v(xbgr.mr_n66825472)
print v(xbgr.mr_n66825792)
print v(xbgr.mr_n66825904)
print v(xbgr.mr_n66826224)
print v(xbgr.mr_n66826336)
print v(xbgr.mr_n66826656)
print v(xbgr.mr_n66826768)
print v(xbgr.mr_n66827088)
print v(xbgr.mr_n66827200)
print v(xbgr.mr_n66827520)
print v(xbgr.mr_n66827632)
print v(xbgr.mr_n66827952)
print v(xbgr.mr_n66828064)
print v(xbgr.mr_n66828384)
print v(xbgr.mr_n66828496)
print v(xbgr.mr_n66828816)
print v(xbgr.mr_n66828928)
print v(xbgr.mr_n66829248)
print v(xbgr.mr_n66829360)
print v(xbgr.mr_n66829680)
print v(xbgr.mr_n66829792)
print v(xbgr.mr_n66830112)
print v(xbgr.mr_n66830224)
print v(xbgr.mr_n66830544)
print v(xbgr.mr_n66830656)
print v(xbgr.mr_n66830976)
print v(xbgr.mr_n66831088)
print v(xbgr.mr_n66831408)
print v(xbgr.mr_n66831520)
print v(xbgr.mr_n66831840)
print v(xbgr.mr_n66831952)
print v(xbgr.mr_n66832272)
print v(xbgr.mr_n66832384)
print v(xbgr.mr_n66832704)
print v(xbgr.mr_n66832816)
print v(xbgr.mr_n66833136)
print v(xbgr.mr_n66833248)
print v(xbgr.mr_n66833568)
print v(xbgr.mr_n66833680)
print v(xbgr.mr_n66834000)
print v(xbgr.mr_n66834112)
print v(xbgr.mr_n66834432)
print v(xbgr.mr_n66834544)
print v(xbgr.mr_n66834864)
print v(xbgr.mr_n66834976)
print v(xbgr.mr_n66835296)
print v(xbgr.mr_n66835408)
print v(xbgr.mr_n66835728)
print v(xbgr.mr_n66835840)
print v(xbgr.mr_n66836160)
print v(xbgr.mr_n66836272)
print v(xbgr.mr_n66836592)
print v(xbgr.mr_n66836704)
print v(xbgr.mr_n66837024)
print v(xbgr.mr_n66837136)
print v(xbgr.mr_n66837456)
print v(xbgr.mr_n66837568)
print v(xbgr.mr_n66837888)
print v(xbgr.mr_n66838000)
print v(xbgr.mr_n66838320)
print v(xbgr.mr_n66838432)
print v(xbgr.mr_n66838752)
print v(xbgr.mr_n66838864)
print v(xbgr.mr_n66839184)
print v(xbgr.mr_n66839296)
print v(xbgr.mr_n66839616)
print v(xbgr.mr_n66839728)
print v(xbgr.mr_n66840048)
print v(xbgr.mr_n66840160)
print v(xbgr.mr_n66840480)
print v(xbgr.mr_n66840592)
print v(xbgr.mr_n66840912)
print v(xbgr.mr_n66841024)
print v(xbgr.mr_n66841344)
print v(xbgr.mr_n66841456)
print v(xbgr.mr_n66841776)
print v(xbgr.mr_n66841888)
print v(xbgr.mr_n66842208)
print v(xbgr.mr_n66842320)
print v(xbgr.mr_n66842640)
print v(xbgr.mr_n66842752)
print v(xbgr.mr_n66843072)
print v(xbgr.mr_n66843184)
print v(xbgr.mr_n66843504)
print v(xbgr.mr_n66843616)
print v(xbgr.mr_n66843936)
print v(xbgr.mr_n66844048)
print v(xbgr.mr_n66844368)
print v(xbgr.mr_n66844480)
print v(xbgr.mr_n66844800)
print v(xbgr.mr_n66844912)
print v(xbgr.mr_n66845232)
print v(xbgr.mr_n66845344)
print v(xbgr.mr_n66845664)
print v(xbgr.mr_n66845776)
print v(xbgr.mr_n66846096)
print v(xbgr.mr_n66846208)
print v(xbgr.mr_n66846528)
print v(xbgr.mr_n66846640)
print v(xbgr.mr_n66846960)
print v(xbgr.mr_n66847072)
print v(xbgr.mr_n66847392)
print v(xbgr.mr_n66847504)
print v(xbgr.mr_n66847824)
print v(xbgr.mr_n66847936)
print v(xbgr.mr_n66848256)
print v(xbgr.mr_n66848368)
print v(xbgr.mr_n66848688)
print v(xbgr.mr_n66848800)
print v(xbgr.mr_n66849120)
print v(xbgr.mr_n66849232)
print v(xbgr.mr_n66849552)
print v(xbgr.mr_n66849664)
print v(xbgr.mr_n66849984)
print v(xbgr.mr_n66850096)
print v(xbgr.mr_n66850416)
print v(xbgr.mr_n66850528)
print v(xbgr.mr_n66850848)
print v(xbgr.mr_n66850960)
print v(xbgr.mr_n66851280)
print v(xbgr.mr_n66851392)
print v(xbgr.mr_n66851712)
print v(xbgr.mr_n66851824)
print v(xbgr.mr_n66852144)
print v(xbgr.mr_n66852256)
print v(xbgr.mr_n66852576)
print v(xbgr.mr_n66852688)
print v(xbgr.mr_n66853008)
print v(xbgr.mr_n66853120)
print v(xbgr.mr_n66853440)
print v(xbgr.mr_n66853552)
print v(xbgr.mr_n66853872)
print v(xbgr.mr_n66853984)
print v(xbgr.mr_n66854304)
print v(xbgr.mr_n66854416)
print v(xbgr.mr_n66854736)
print v(xbgr.mr_n66854848)
print v(xbgr.mr_n66855168)
print v(xbgr.mr_n66855280)
print v(xbgr.mr_n66855600)
print v(xbgr.mr_n66855712)
print v(xbgr.mr_n66856032)
print v(xbgr.mr_n66856144)
print v(xbgr.mr_n66856464)
print v(xbgr.mr_n66856576)
print v(xbgr.mr_n66856896)
print v(xbgr.mr_n66857008)
print v(xbgr.mr_n66857328)
print v(xbgr.mr_n66857440)
print v(xbgr.mr_n66857760)
print v(xbgr.mr_n66857872)
print v(xbgr.mr_n66858192)
print v(xbgr.mr_n66858304)
print v(xbgr.mr_n66858624)
print v(xbgr.mr_n66858736)
print v(xbgr.mr_n66859056)
print v(xbgr.mr_n66859168)
print v(xbgr.mr_n66859488)
print v(xbgr.mr_n66859600)
print v(xbgr.mr_n66859920)
print v(xbgr.mr_n66860032)
print v(xbgr.mr_n66860352)
print v(xbgr.mr_n66860464)
print v(xbgr.mr_n66860784)
print v(xbgr.mr_n66860896)
print v(xbgr.mr_n66861216)
print v(xbgr.mr_n66861328)
print v(xbgr.mr_n66861648)
print v(xbgr.mr_n66861760)
print v(xbgr.mr_n66862080)
print v(xbgr.mr_n66862192)
print v(xbgr.mr_n66862512)
print v(xbgr.mr_n66862624)
print v(xbgr.mr_n66862944)
print v(xbgr.mr_n66863056)
print v(xbgr.mr_n66863376)
print v(xbgr.mr_n66863488)
print v(xbgr.mr_n66863808)
print v(xbgr.mr_n66863920)
print v(xbgr.mr_n66864240)
print v(xbgr.mr_n66864352)
print v(xbgr.mr_n66864672)
print v(xbgr.mr_n66864784)
print v(xbgr.mr_n66865104)
print v(xbgr.mr_n66865216)
print v(xbgr.mr_n66865536)
print v(xbgr.mr_n66865648)
print v(xbgr.mr_n66865968)
print v(xbgr.mr_n66866080)
print v(xbgr.mr_n66866400)
print v(xbgr.mr_n66866512)
print v(xbgr.mr_n66866832)
print v(xbgr.mr_n66866944)
print v(xbgr.mr_n66867264)
print v(xbgr.mr_n66867376)
print v(xbgr.mr_n66867696)
print v(xbgr.mr_n66867808)
print v(xbgr.mr_n66868128)
print v(xbgr.mr_n66868240)
print v(xbgr.mr_n66868560)
print v(xbgr.mr_n66868672)
print v(xbgr.mr_n66868992)
print v(xbgr.mr_n66869104)
print v(xbgr.mr_n66869424)
print v(xbgr.mr_n66869536)
print v(xbgr.mr_n66869856)
print v(xbgr.mr_n66869968)
print v(xbgr.mr_n66870288)
print v(xbgr.mr_n66870400)
print v(xbgr.mr_n66870720)
print v(xbgr.mr_n66870832)
print v(xbgr.mr_n66871152)
print v(xbgr.mr_n66871264)
print v(xbgr.mr_n66871584)
print v(xbgr.mr_n66871696)
print v(xbgr.mr_n66872016)
print v(xbgr.mr_n66872128)
print v(xbgr.mr_n66872448)
print v(xbgr.mr_n66872560)
print v(xbgr.mr_n66872880)
print v(xbgr.mr_n66872992)
print v(xbgr.mr_n66873312)
print v(xbgr.mr_n66873424)
print v(xbgr.mr_n66873744)
print v(xbgr.mr_n66873856)
print v(xbgr.mr_n66874176)
print v(xbgr.mr_n66874288)
print v(xbgr.mr_n66874608)
print v(xbgr.mr_n66874720)
print v(xbgr.mr_n66875040)
print v(xbgr.mr_n66875152)
print v(xbgr.mr_n66875472)
print v(xbgr.mr_n66875584)
print v(xbgr.mr_n66875904)
print v(xbgr.mr_n66876016)
print v(xbgr.mr_n66876336)
print v(xbgr.mr_n66876448)
print v(xbgr.mr_n66876768)
print v(xbgr.mr_n66876880)
print v(xbgr.mr_n66877200)
print v(xbgr.mr_n66877312)
print v(xbgr.mr_n66877632)
print v(xbgr.mr_n66877744)
print v(xbgr.mr_n66878064)
print v(xbgr.mr_n66878176)
print v(xbgr.mr_n66878496)
print v(xbgr.mr_n66878608)
print v(xbgr.mr_n66878928)
print v(xbgr.mr_n66879040)
print v(xbgr.mr_n66879360)
print v(xbgr.mr_n66879472)
print v(xbgr.mr_n66879792)
print v(xbgr.mr_n66879904)
print v(xbgr.mr_n66880224)
print v(xbgr.mr_n66880336)
print v(xbgr.mr_n66880656)
print v(xbgr.mr_n66880768)
print v(xbgr.mr_n66881088)
print v(xbgr.mr_n66881200)
print v(xbgr.mr_n66881520)
print v(xbgr.mr_n66881632)
print v(xbgr.mr_n66881952)
print v(xbgr.mr_n66882064)
print v(xbgr.mr_n66882384)
print v(xbgr.mr_n66882496)
print v(xbgr.mr_n66882816)
print v(xbgr.mr_n66882928)
print v(xbgr.mr_n66883248)
print v(xbgr.mr_n66883360)
print v(xbgr.mr_n66883680)
print v(xbgr.mr_n66883792)
print v(xbgr.mr_n66884112)
print v(xbgr.mr_n66884224)
print v(xbgr.mr_n66884544)
print v(xbgr.mr_n66884656)
print v(xbgr.mr_n66884976)
print v(xbgr.mr_n66885088)
print v(xbgr.mr_n66885408)
print v(xbgr.mr_n66885520)
print v(xbgr.mr_n66885840)
print v(xbgr.mr_n66885952)
print v(xbgr.mr_n66886272)
print v(xbgr.mr_n66886384)
print v(xbgr.mr_n66886704)
print v(xbgr.mr_n66886816)
print v(xbgr.mr_n66887136)
print v(xbgr.mr_n66887248)
print v(xbgr.mr_n66887568)
print v(xbgr.mr_n66887680)
print v(xbgr.mr_n66888000)
print v(xbgr.mr_n66888112)
print v(xbgr.mr_n66888432)
print v(xbgr.mr_n66888544)
print v(xbgr.mr_n66888864)
print v(xbgr.mr_n66888976)
print v(xbgr.mr_n66889296)
print v(xbgr.mr_n66889408)
print v(xbgr.mr_n66889728)
print v(xbgr.mr_n66889840)
print v(xbgr.mr_n66890160)
print v(xbgr.mr_n66890272)
print v(xbgr.mr_n66890592)
print v(xbgr.mr_n66890704)
print v(xbgr.mr_n66891024)
print v(xbgr.mr_n66891136)
print v(xbgr.mr_n66891456)
print v(xbgr.mr_n66891568)
print v(xbgr.mr_n66891888)
print v(xbgr.mr_n66892000)
print v(xbgr.mr_n66892320)
print v(xbgr.mr_n66892432)
print v(xbgr.mr_n66892752)
print v(xbgr.mr_n66892864)
print v(xbgr.mr_n66893184)
print v(xbgr.mr_n66893296)
print v(xbgr.mr_n66893616)
print v(xbgr.mr_n66893728)
print v(xbgr.mr_n66894048)
print v(xbgr.mr_n66894160)
print v(xbgr.mr_n66894480)
print v(xbgr.mr_n66894592)
print v(xbgr.mr_n66894912)
print v(xbgr.mr_n66895024)
print v(xbgr.mr_n66895344)
print v(xbgr.mr_n66895456)
print v(xbgr.mr_n66895776)
print v(xbgr.mr_n66895888)
print v(xbgr.mr_n66896208)
print v(xbgr.mr_n66896320)
print v(xbgr.mr_n66896640)
print v(xbgr.mr_n66896752)
print v(xbgr.mr_n66897072)
print v(xbgr.mr_n66897184)
print v(xbgr.mr_n66897504)
print v(xbgr.mr_n66897616)
print v(xbgr.mr_n66897936)
print v(xbgr.mr_n66898048)
print v(xbgr.mr_n66898368)
print v(xbgr.mr_n66898480)
print v(xbgr.mr_n66898800)
print v(xbgr.mr_n66898912)
print v(xbgr.mr_n66899232)
print v(xbgr.mr_n66899344)
print v(xbgr.mr_n66899664)
print v(xbgr.mr_n66899776)
print v(xbgr.mr_n66900096)
print v(xbgr.mr_n66900208)
print v(xbgr.mr_n66900528)
print v(xbgr.mr_n66900640)
print v(xbgr.mr_n66900960)
print v(xbgr.mr_n66901072)
print v(xbgr.mr_n66901392)
print v(xbgr.mr_n66901504)
print v(xbgr.mr_n66901824)
print v(xbgr.mr_n66901936)
print v(xbgr.mr_n66902256)
print v(xbgr.mr_n66902368)
print v(xbgr.mr_n66902688)
print v(xbgr.mr_n66902800)
print v(xbgr.mr_n66903120)
print v(xbgr.mr_n66903232)
print v(xbgr.mr_n66903552)
print v(xbgr.mr_n66903664)
print v(xbgr.mr_n66903984)
print v(xbgr.mr_n66904096)
print v(xbgr.mr_n66904416)
print v(xbgr.mr_n66904528)
print v(xbgr.mr_n66904848)
print v(xbgr.mr_n66904960)
print v(xbgr.mr_n66905280)
print v(xbgr.mr_n66905392)
print v(xbgr.mr_n66905712)
print v(xbgr.mr_n66905824)
print v(xbgr.mr_n66906144)
print v(xbgr.mr_n66906256)
print v(xbgr.mr_n66906576)
print v(xbgr.mr_n66906688)
print v(xbgr.mr_n66907008)
print v(xbgr.mr_n66907120)
print v(xbgr.mr_n66907440)
print v(xbgr.mr_n66907552)
print v(xbgr.mr_n66907872)
print v(xbgr.mr_n66907984)
print v(xbgr.mr_n66908304)
print v(xbgr.mr_n66908416)
print v(xbgr.mr_n66908736)
print v(xbgr.mr_n66908848)
print v(xbgr.mr_n66909168)
print v(xbgr.mr_n66909280)
print v(xbgr.mr_n66909600)
print v(xbgr.mr_n66909712)
print v(xbgr.mr_n66910032)
print v(xbgr.mr_n66910144)
print v(xbgr.mr_n66910464)
print v(xbgr.mr_n66910576)
print v(xbgr.mr_n66910896)
print v(xbgr.mr_n66911008)
print v(xbgr.mr_n66911328)
print v(xbgr.mr_n66911440)
print v(xbgr.mr_n66911760)
print v(xbgr.mr_n66911872)
print v(xbgr.mr_n66912192)
print v(xbgr.mr_n66912304)
print v(xbgr.mr_n66912624)
print v(xbgr.mr_n66912736)
print v(xbgr.mr_n66913056)
print v(xbgr.mr_n66913168)
print v(xbgr.mr_n66913488)
print v(xbgr.mr_n66913600)
print v(xbgr.mr_n66913920)
print v(xbgr.mr_n66914032)
print v(xbgr.mr_n66914352)
print v(xbgr.mr_n66914464)
print v(xbgr.mr_n66914784)
print v(xbgr.mr_n66914896)
print v(xbgr.mr_n66915216)
print v(xbgr.mr_n66915328)
print v(xbgr.mr_n66915648)
print v(xbgr.mr_n66915760)
print v(xbgr.mr_n66916080)
print v(xbgr.mr_n66916192)
print v(xbgr.mr_n66916512)
print v(xbgr.mr_n66916624)
print v(xbgr.mr_n66916944)
print v(xbgr.mr_n66917056)
print v(xbgr.mr_n66917376)
print v(xbgr.mr_n66917488)
print v(xbgr.mr_n66917808)
print v(xbgr.mr_n66917920)
print v(xbgr.mr_n66918240)
print v(xbgr.mr_n66918352)
print v(xbgr.mr_n66918672)
print v(xbgr.mr_n66918784)
print v(xbgr.mr_n66919104)
print v(xbgr.mr_n66919216)
print v(xbgr.mr_n66919536)
print v(xbgr.mr_n66919648)
print v(xbgr.mr_n66919968)
print v(xbgr.mr_n66920080)
print v(xbgr.mr_n66920400)
print v(xbgr.mr_n66920512)
print v(xbgr.mr_n66920832)
print v(xbgr.mr_n66920944)
print v(xbgr.mr_n66921264)
print v(xbgr.mr_n66921376)
print v(xbgr.mr_n66921696)
print v(xbgr.mr_n66921808)
print v(xbgr.mr_n66922128)
print v(xbgr.mr_n66922240)
print v(xbgr.mr_n66922560)
print v(xbgr.mr_n66922672)
print v(xbgr.mr_n66922992)
print v(xbgr.mr_n66923104)
print v(xbgr.mr_n66923424)
print v(xbgr.mr_n66923536)
print v(xbgr.mr_n66923856)
print v(xbgr.mr_n66923968)
print v(xbgr.mr_n66924288)
print v(xbgr.mr_n66924400)
print v(xbgr.mr_n66924720)
print v(xbgr.mr_n66924832)
print v(xbgr.mr_n66925152)
print v(xbgr.mr_n66925264)
print v(xbgr.mr_n66925584)
print v(xbgr.mr_n66925696)
print v(xbgr.mr_n66926016)
print v(xbgr.mr_n66926128)
print v(xbgr.mr_n66926448)
print v(xbgr.mr_n66926560)
print v(xbgr.mr_n66926880)
print v(xbgr.mr_n66926992)
print v(xbgr.mr_n66927312)
print v(xbgr.mr_n66927424)
print v(xbgr.mr_n66927744)
print v(xbgr.mr_n66927856)
print v(xbgr.mr_n66928176)
print v(xbgr.mr_n66928288)
print v(xbgr.mr_n66928608)
print v(xbgr.mr_n66928720)
print v(xbgr.mr_n66929040)
print v(xbgr.mr_n66929152)
print v(xbgr.mr_n66929472)
print v(xbgr.mr_n66929584)
print v(xbgr.mr_n66929904)
print v(xbgr.mr_n66930016)
print v(xbgr.mr_n66930336)
print v(xbgr.mr_n66930448)
print v(xbgr.mr_n66930768)
print v(xbgr.mr_n66930880)
print v(xbgr.mr_n66931200)
print v(xbgr.mr_n66931312)
print v(xbgr.mr_n66931632)
print v(xbgr.mr_n66931744)
print v(xbgr.mr_n66932064)
print v(xbgr.mr_n66932176)
print v(xbgr.mr_n66932496)
print v(xbgr.mr_n66932608)
print v(xbgr.mr_n66932928)
print v(xbgr.mr_n66933040)
print v(xbgr.mr_n66933360)
print v(xbgr.mr_n66933472)
print v(xbgr.mr_n66933792)
print v(xbgr.mr_n66933904)
print v(xbgr.mr_n66934224)
print v(xbgr.mr_n66934336)
print v(xbgr.mr_n66934656)
print v(xbgr.mr_n66934768)
print v(xbgr.mr_n66935088)
print v(xbgr.mr_n66935200)
print v(xbgr.mr_n66935520)
print v(xbgr.mr_n66935632)
print v(xbgr.mr_n66935952)
print v(xbgr.mr_n66936064)
print v(xbgr.mr_n66936384)
print v(xbgr.mr_n66936496)
print v(xbgr.mr_n66936816)
print v(xbgr.mr_n66936928)
print v(xbgr.mr_n66937248)
print v(xbgr.mr_n66937360)
print v(xbgr.mr_n66937680)
print v(xbgr.mr_n66937792)
print v(xbgr.mr_n66938112)
print v(xbgr.mr_n66938224)
print v(xbgr.mr_n66938544)
print v(xbgr.mr_n66938656)
print v(xbgr.mr_n66938976)
print v(xbgr.mr_n66939088)
print v(xbgr.mr_n66939408)
print v(xbgr.mr_n66939520)
print v(xbgr.mr_n66939840)
print v(xbgr.mr_n66939952)
print v(xbgr.mr_n66940272)
print v(xbgr.mr_n66940384)
print v(xbgr.mr_n66940704)
print v(xbgr.mr_n66940816)
print v(xbgr.mr_n66941136)
print v(xbgr.mr_n66941248)
print v(xbgr.mr_n66941568)
print v(xbgr.mr_n66941680)
print v(xbgr.mr_n66942000)
print v(xbgr.mr_n66942112)
print v(xbgr.mr_n66942432)
print v(xbgr.mr_n66942544)
print v(xbgr.mr_n66942864)
print v(xbgr.mr_n66942976)
print v(xbgr.mr_n66943296)
print v(xbgr.mr_n66943408)
print v(xbgr.mr_n66943728)
print v(xbgr.mr_n66943840)
print v(xbgr.mr_n66944160)
print v(xbgr.mr_n66944272)
print v(xbgr.mr_n66944592)
print v(xbgr.mr_n66944704)
print v(xbgr.mr_n66945024)
print v(xbgr.mr_n66945136)
print v(xbgr.mr_n66945456)
print v(xbgr.mr_n66945568)
print v(xbgr.mr_n66945888)
print v(xbgr.mr_n66946000)
print v(xbgr.mr_n66946320)
print v(xbgr.mr_n66946432)
print v(xbgr.mr_n66946752)
print v(xbgr.mr_n66946864)
print v(xbgr.mr_n66947184)
print v(xbgr.mr_n66947296)
print v(xbgr.mr_n66947616)
print v(xbgr.mr_n66947728)
print v(xbgr.mr_n66948048)
print v(xbgr.mr_n66948160)
print v(xbgr.mr_n66948480)
print v(xbgr.mr_n66948592)
print v(xbgr.mr_n66948912)
print v(xbgr.mr_n66949024)
print v(xbgr.mr_n66949344)
print v(xbgr.mr_n66949456)
print v(xbgr.mr_n66949776)
print v(xbgr.mr_n66949888)
print v(xbgr.mr_n66950208)
print v(xbgr.mr_n66950320)
print v(xbgr.mr_n66950640)
print v(xbgr.mr_n66950752)
print v(xbgr.mr_n66951072)
print v(xbgr.mr_n66951184)
print v(xbgr.mr_n66951504)
print v(xbgr.mr_n66951616)
print v(xbgr.mr_n66951936)
print v(xbgr.mr_n66952048)
print v(xbgr.mr_n66952368)
print v(xbgr.mr_n66952480)
print v(xbgr.mr_n66952800)
print v(xbgr.mr_n66952912)
print v(xbgr.mr_n66953232)
print v(xbgr.mr_n66953344)
print v(xbgr.mr_n66953664)
print v(xbgr.mr_n66953776)
print v(xbgr.mr_n66954096)
print v(xbgr.mr_n66954208)
print v(xbgr.mr_n66954528)
print v(xbgr.mr_n66954640)
print v(xbgr.mr_n66954960)
print v(xbgr.mr_n66955072)
print v(xbgr.mr_n66955392)
print v(xbgr.mr_n66955504)
print v(xbgr.mr_n66955824)
print v(xbgr.mr_n66955936)
print v(xbgr.mr_n66956256)
print v(xbgr.mr_n66956368)
print v(xbgr.mr_n66956688)
print v(xbgr.mr_n66956800)
print v(xbgr.mr_n66957120)
print v(xbgr.mr_n66957232)
print v(xbgr.mr_n66957552)
print v(xbgr.mr_n66957664)
print v(xbgr.mr_n66957984)
print v(xbgr.mr_n66958096)
print v(xbgr.mr_n66958416)
print v(xbgr.mr_n66958528)
print v(xbgr.mr_n66958848)
print v(xbgr.mr_n66958960)
print v(xbgr.mr_n66959280)
print v(xbgr.mr_n66959392)
print v(xbgr.mr_n66959712)
print v(xbgr.mr_n66959824)
print v(xbgr.mr_n66960144)
print v(xbgr.mr_n66960256)
print v(xbgr.mr_n66960576)
print v(xbgr.mr_n66960688)
print v(xbgr.mr_n66961008)
print v(xbgr.mr_n66961120)
print v(xbgr.mr_n66961440)
print v(xbgr.mr_n66961552)
print v(xbgr.mr_n66961872)
print v(xbgr.mr_n66961984)
print v(xbgr.mr_n66962304)
print v(xbgr.mr_n66962416)
print v(xbgr.mr_n66962736)
print v(xbgr.mr_n66962848)
print v(xbgr.mr_n66963168)
print v(xbgr.mr_n66963280)
print v(xbgr.mr_n66963600)
print v(xbgr.mr_n66963712)
print v(xbgr.mr_n66964032)
print v(xbgr.mr_n66964144)
print v(xbgr.mr_n66964464)
print v(xbgr.mr_n66964576)
print v(xbgr.mr_n66964896)
print v(xbgr.mr_n66965008)
print v(xbgr.mr_n66965328)
print v(xbgr.mr_n66965440)
print v(xbgr.mr_n66965760)
print v(xbgr.mr_n66965872)
print v(xbgr.mr_n66966192)
print v(xbgr.mr_n66966304)
print v(xbgr.mr_n66966624)
print v(xbgr.mr_n66966736)
print v(xbgr.mr_n66967056)
print v(xbgr.mr_n66967168)
print v(xbgr.mr_n66967488)
print v(xbgr.mr_n66967600)
print v(xbgr.mr_n66967920)
print v(xbgr.mr_n66968032)
print v(xbgr.mr_n66968352)
print v(xbgr.mr_n66968464)
print v(xbgr.mr_n66968784)
print v(xbgr.mr_n66968896)
print v(xbgr.mr_n66969216)
print v(xbgr.mr_n66969328)
print v(xbgr.mr_n66969648)
print v(xbgr.mr_n66969760)
print v(xbgr.mr_n66970080)
print v(xbgr.mr_n66970192)
print v(xbgr.mr_n66970512)
print v(xbgr.mr_n66970624)
print v(xbgr.mr_n66970944)
print v(xbgr.mr_n66971056)
print v(xbgr.mr_n66971376)
print v(xbgr.mr_n66971488)
print v(xbgr.mr_n66971808)
print v(xbgr.mr_n66971920)
print v(xbgr.mr_n66972240)
print v(xbgr.mr_n66972352)
print v(xbgr.mr_n66972672)
print v(xbgr.mr_n66972784)
print v(xbgr.mr_n66973104)
print v(xbgr.mr_n66973216)
print v(xbgr.mr_n66973648)
print v(xbgr.mr_n66973968)
print v(xbgr.mr_n66974080)
print v(xbgr.mr_n66974512)
print v(xbgr.mr_n66974832)
print v(xbgr.mr_n66974944)
print v(xbgr.mr_n66975376)
print v(xbgr.mr_n66975696)
print v(xbgr.mr_n66976560)
print v(xbgr.mr_n66977424)
print v(xbgr.mr_n66978288)
print v(xbgr.mr_n66979152)
print v(xbgr.mr_n66980016)
print v(xbgr.mr_n66980880)
print v(xbgr.mr_n66980992)
print v(xbgr.mr_n66981312)
print v(xbgr.mr_n66981424)
print v(xbgr.mr_n66981744)
print v(xbgr.mr_n66981856)
print v(xbgr.mr_n66982176)
print v(xbgr.mr_n66982288)
print v(xbgr.mr_n66982608)
print v(xbgr.mr_n66983472)
print v(xbgr.mr_n66984336)
print v(xbgr.mr_n66985200)
print v(xbgr.mr_n66985312)
print v(xbgr.mr_n66985632)
print v(xbgr.mr_n66985744)
print v(xbgr.mr_n66986064)
print v(xbgr.mr_n66986176)
print v(xbgr.mr_n66986608)
print v(xbgr.mr_n66987040)
print v(xbgr.mr_n66987472)
print v(xbgr.mr_n66987792)
print v(xbgr.mr_n66987904)
print v(xbgr.mr_n66988224)
print v(xbgr.mr_n66988336)
print v(xbgr.mr_n66988656)
print v(xbgr.mr_n66988768)
print v(xbgr.mr_n66989088)
print v(xbgr.mr_n66989200)
print v(xbgr.mr_n66989520)
print v(xbgr.mr_n66989632)
print v(xbgr.mr_n66989952)
print v(xbgr.mr_n66990064)
print v(xbgr.mr_n66990384)
print v(xbgr.mr_n66990496)
print v(xbgr.mr_n66990816)
print v(xbgr.mr_n66990928)
print v(xbgr.mr_n66991248)
print v(xbgr.mr_n66991360)
print v(xbgr.mr_n66991680)
print v(xbgr.mr_n66991792)
print v(xbgr.mr_n66992112)
print v(xbgr.mr_n66992224)
print v(xbgr.mr_n66992544)
print v(xbgr.mr_n66992656)
print v(xbgr.mr_n66992976)
print v(xbgr.mr_n66993088)
print v(xbgr.mr_n66993408)
print v(xbgr.mr_n66993520)
print v(xbgr.mr_n66993840)
print v(xbgr.mr_n66993952)
print v(xbgr.mr_n66994272)
print v(xbgr.mr_n66994384)
print v(xbgr.mr_n66994704)
print v(xbgr.mr_n66994816)
print v(xbgr.mr_n66995136)
print v(xbgr.mr_n66995248)
print v(xbgr.mr_n66995568)
print v(xbgr.mr_n66995680)
print v(xbgr.mr_n66996000)
print v(xbgr.mr_n66996112)
print v(xbgr.mr_n66996432)
print v(xbgr.mr_n66996544)
print v(xbgr.mr_n66996864)
print v(xbgr.mr_n66996976)
print v(xbgr.mr_n66997296)
print v(xbgr.mr_n66997408)
print v(xbgr.mr_n66997728)
print v(xbgr.mr_n66997840)
print v(xbgr.mr_n66998160)
print v(xbgr.mr_n66998272)
print v(xbgr.mr_n66998592)
print v(xbgr.mr_n66998704)
print v(xbgr.mr_n66999024)
print v(xbgr.mr_n66999136)
print v(xbgr.mr_n66999456)
print v(xbgr.mr_n66999568)
print v(xbgr.mr_n66999888)
print v(xbgr.mr_n67000000)
print v(xbgr.mr_n67000320)
print v(xbgr.mr_n67000432)
print v(xbgr.mr_n67000752)
print v(xbgr.mr_n67000864)
print v(xbgr.mr_n67001296)
print v(xbgr.mr_n67001616)
print v(xbgr.mr_n67001728)
print v(xbgr.mr_n67002160)
print v(xbgr.mr_n67002480)
print v(xbgr.mr_n67003344)
print v(xbgr.mr_n67004208)
print v(xbgr.mr_n67005072)
print v(xbgr.mr_n67005936)
print v(xbgr.mr_n67006048)
print v(xbgr.mr_n67006368)
print v(xbgr.mr_n67006480)
print v(xbgr.mr_n67006800)
print v(xbgr.mr_n67006912)
print v(xbgr.mr_n67007232)
print v(xbgr.mr_n67007344)
print v(xbgr.mr_n67007664)
print v(xbgr.mr_n67008528)
print v(xbgr.mr_n67009392)
print v(xbgr.mr_n67009504)
print v(xbgr.mr_n67009824)
print v(xbgr.mr_n67009936)
print v(xbgr.mr_n67010256)
print v(xbgr.mr_n67010368)
print v(xbgr.mr_n67010688)
print v(xbgr.mr_n67010800)
print v(xbgr.mr_n67011120)
print v(xbgr.mr_n67011232)
print v(xbgr.mr_n67011664)
print v(xbgr.mr_n67011984)
print v(xbgr.mr_n67012096)
print v(xbgr.mr_n67012528)
print v(xbgr.mr_n67012848)
print v(xbgr.mr_n67013712)
print v(xbgr.mr_n67014576)
print v(xbgr.mr_n67015440)
print v(xbgr.mr_n67016304)
print v(xbgr.mr_n67016416)
print v(xbgr.mr_n67016736)
print v(xbgr.mr_n67016848)
print v(xbgr.mr_n67017168)
print v(xbgr.mr_n67017280)
print v(xbgr.mr_n67017600)
print v(xbgr.mr_n67017712)
print v(xbgr.mr_n67018032)
print v(xbgr.mr_n67018896)
print v(xbgr.mr_n67019760)
print v(xbgr.mr_n67019872)
print v(xbgr.mr_n67020304)
print v(xbgr.mr_n67020624)
print v(xbgr.mr_n67020736)
print v(xbgr.mr_n67021056)
print v(xbgr.mr_n67021168)
print v(xbgr.mr_n67021488)
print v(xbgr.mr_n67021600)
print v(xbgr.mr_n67021920)
print v(xbgr.mr_n67022032)
print v(xbgr.mr_n67022352)
print v(xbgr.mr_n67022464)
print v(xbgr.mr_n67022896)
print v(xbgr.mr_n67023216)
print v(xbgr.mr_n67024080)
print v(xbgr.mr_n67024192)
print v(xbgr.mr_n67024624)
print v(xbgr.mr_n67024944)
print v(xbgr.mr_n67025056)
print v(xbgr.mr_n67025488)
print v(xbgr.mr_n67025808)
print v(xbgr.mr_n67025920)
print v(xbgr.mr_n67026240)
print v(xbgr.mr_n67026352)
print v(xbgr.mr_n67026672)
print v(xbgr.mr_n67026784)
print v(xbgr.mr_n67027104)
print v(xbgr.mr_n67027216)
print v(xbgr.mr_n67027536)
print v(xbgr.mr_n67028400)
print v(xbgr.mr_n67029264)
print v(xbgr.mr_n67029376)
print v(xbgr.mr_n67029696)
print v(xbgr.mr_n67029808)
print v(xbgr.mr_n67030128)
print v(xbgr.mr_n67030240)
print v(xbgr.mr_n67030560)
print v(xbgr.mr_n67030672)
print v(xbgr.mr_n67030992)
print v(xbgr.mr_n67031856)
print v(xbgr.mr_n67032720)
print v(xbgr.mr_n67032832)
print v(xbgr.mr_n67033152)
print v(xbgr.mr_n67033264)
print v(xbgr.mr_n67033584)
print v(xbgr.mr_n67034448)
print v(xbgr.mr_n67034560)
print v(xbgr.mr_n67034880)
print v(xbgr.mr_n67034992)
print v(xbgr.mr_n67035312)
print v(xbgr.mr_n67035424)
print v(xbgr.mr_n67035744)
print v(xbgr.mr_n67035856)
print v(xbgr.mr_n67036176)
print v(xbgr.mr_n67036288)
print v(xbgr.mr_n67036608)
print v(xbgr.mr_n67036720)
print v(xbgr.mr_n67037040)
print v(xbgr.mr_n67037904)
print v(xbgr.mr_n67038704)
print v(xbgr.mr_n67038816)
print v(xbgr.mr_n67039136)
print v(xbgr.mr_n67039248)
print v(xbgr.mr_n67039568)
print v(xbgr.mr_n67039680)
print v(xbgr.mr_n67040000)
print v(xbgr.mr_n67040112)
print v(xbgr.mr_n67040432)
print v(xbgr.mr_n67040544)
print v(xbgr.mr_n67040864)
print v(xbgr.mr_n67040976)
print v(xbgr.mr_n67041296)
print v(xbgr.mr_n67041408)
print v(xbgr.mr_n67041728)
print v(xbgr.mr_n67041840)
print v(xbgr.mr_n67042160)
print v(xbgr.mr_n67042272)
print v(xbgr.mr_n67042592)
print v(xbgr.mr_n67042704)
print v(xbgr.mr_n67043024)
print v(xbgr.mr_n67043136)
print v(xbgr.mr_n67043456)
print v(xbgr.mr_n67043568)
print v(xbgr.mr_n67043888)
print v(xbgr.mr_n67044000)
print v(xbgr.mr_n67044320)
print v(xbgr.mr_n67044432)
print v(xbgr.mr_n67044752)
print v(xbgr.mr_n67044864)
print v(xbgr.mr_n67045184)
print v(xbgr.mr_n67045296)
print v(xbgr.mr_n67045616)
print v(xbgr.mr_n67045728)
print v(xbgr.mr_n67046048)
print v(xbgr.mr_n67046160)
print v(xbgr.mr_n67046480)
print v(xbgr.mr_n67046592)
print v(xbgr.mr_n67046912)
print v(xbgr.mr_n67047024)
print v(xbgr.mr_n67047344)
print v(xbgr.mr_n67047456)
print v(xbgr.mr_n67047776)
print v(xbgr.mr_n67047888)
print v(xbgr.mr_n67048208)
print v(xbgr.mr_n67048320)
print v(xbgr.mr_n67048640)
print v(xbgr.mr_n67048752)
print v(xbgr.mr_n67049072)
print v(xbgr.mr_n67049184)
print v(xbgr.mr_n67049504)
print v(xbgr.mr_n67049616)
print v(xbgr.mr_n67049936)
print v(xbgr.mr_n67050048)
print v(xbgr.mr_n67050368)
print v(xbgr.mr_n67050480)
print v(xbgr.mr_n67050800)
print v(xbgr.mr_n67050912)
print v(xbgr.mr_n67051232)
print v(xbgr.mr_n67051344)
print v(xbgr.mr_n67051664)
print v(xbgr.mr_n67051776)
print v(xbgr.mr_n67052096)
print v(xbgr.mr_n67052208)
print v(xbgr.mr_n67052528)
print v(xbgr.mr_n67052640)
print v(xbgr.mr_n67052960)
print v(xbgr.mr_n67053072)
print v(xbgr.mr_n67053392)
print v(xbgr.mr_n67053504)
print v(xbgr.mr_n67053824)
print v(xbgr.mr_n67053936)
print v(xbgr.mr_n67054256)
print v(xbgr.mr_n67054368)
print v(xbgr.mr_n67054688)
print v(xbgr.mr_n67054800)
print v(xbgr.mr_n67055120)
print v(xbgr.mr_n67055232)
print v(xbgr.mr_n67055552)
print v(xbgr.mr_n67055664)
print v(xbgr.mr_n67055984)
print v(xbgr.mr_n67056096)
print v(xbgr.mr_n67056416)
print v(xbgr.mr_n67056528)
print v(xbgr.mr_n67056848)
print v(xbgr.mr_n67056960)
print v(xbgr.mr_n67057280)
print v(xbgr.mr_n67057392)
print v(xbgr.mr_n67057712)
print v(xbgr.mr_n67057824)
print v(xbgr.mr_n67058144)
print v(xbgr.mr_n67058256)
print v(xbgr.mr_n67058576)
print v(xbgr.mr_n67058688)
print v(xbgr.mr_n67059008)
print v(xbgr.mr_n67059120)
print v(xbgr.mr_n67059440)
print v(xbgr.mr_n67059552)
print v(xbgr.mr_n67059872)
print v(xbgr.mr_n67059984)
print v(xbgr.mr_n67060304)
print v(xbgr.mr_n67060416)
print v(xbgr.mr_n67060736)
print v(xbgr.mr_n67060848)
print v(xbgr.mr_n67061168)
print v(xbgr.mr_n67061280)
print v(xbgr.mr_n67061600)
print v(xbgr.mr_n67061712)
print v(xbgr.mr_n67062032)
print v(xbgr.mr_n67062144)
print v(xbgr.mr_n67062464)
print v(xbgr.mr_n67062576)
print v(xbgr.mr_n67062896)
print v(xbgr.mr_n67063008)
print v(xbgr.mr_n67063328)
print v(xbgr.mr_n67063440)
print v(xbgr.mr_n67063760)
print v(xbgr.mr_n67063872)
print v(xbgr.mr_n67064192)
print v(xbgr.mr_n67064304)
print v(xbgr.mr_n67064624)
print v(xbgr.mr_n67064736)
print v(xbgr.mr_n67065056)
print v(xbgr.mr_n67065168)
print v(xbgr.mr_n67065488)
print v(xbgr.mr_n67065600)
print v(xbgr.mr_n67065920)
print v(xbgr.mr_n67066032)
print v(xbgr.mr_n67066352)
print v(xbgr.mr_n67066464)
print v(xbgr.mr_n67066784)
print v(xbgr.mr_n67066896)
print v(xbgr.mr_n67067216)
print v(xbgr.mr_n67067328)
print v(xbgr.mr_n67067648)
print v(xbgr.mr_n67067760)
print v(xbgr.mr_n67068080)
print v(xbgr.mr_n67068192)
print v(xbgr.mr_n67068512)
print v(xbgr.mr_n67068624)
print v(xbgr.mr_n67068944)
print v(xbgr.mr_n67069056)
print v(xbgr.mr_n67069376)
print v(xbgr.mr_n67069488)
print v(xbgr.mr_n67069808)
print v(xbgr.mr_n67069920)
print v(xbgr.mr_n67070240)
print v(xbgr.mr_n67070352)
print v(xbgr.mr_n67070672)
print v(xbgr.mr_n67070784)
print v(xbgr.mr_n67071104)
print v(xbgr.mr_n67071216)
print v(xbgr.mr_n67071536)
print v(xbgr.mr_n67071648)
print v(xbgr.mr_n67071968)
print v(xbgr.mr_n67072080)
print v(xbgr.mr_n67072400)
print v(xbgr.mr_n67072512)
print v(xbgr.mr_n67072832)
print v(xbgr.mr_n67072944)
print v(xbgr.mr_n67073264)
print v(xbgr.mr_n67073376)
print v(xbgr.mr_n67073696)
print v(xbgr.mr_n67073808)
print v(xbgr.mr_n67074128)
print v(xbgr.mr_n67074240)
print v(xbgr.mr_n67074560)
print v(xbgr.mr_n67074672)
print v(xbgr.mr_n67074992)
print v(xbgr.mr_n67075104)
print v(xbgr.mr_n67075424)
print v(xbgr.mr_n67075536)
print v(xbgr.mr_n67075856)
print v(xbgr.mr_n67075968)
print v(xbgr.mr_n67076288)
print v(xbgr.mr_n67076400)
print v(xbgr.mr_n67076720)
print v(xbgr.mr_n67076832)
print v(xbgr.mr_n67077152)
print v(xbgr.mr_n67077264)
print v(xbgr.mr_n67077584)
print v(xbgr.mr_n67077696)
print v(xbgr.mr_n67078016)
print v(xbgr.mr_n67078128)
print v(xbgr.mr_n67078448)
print v(xbgr.mr_n67078560)
print v(xbgr.mr_n67078880)
print v(xbgr.mr_n67078992)
print v(xbgr.mr_n67079312)
print v(xbgr.mr_n67079424)
print v(xbgr.mr_n67079744)
print v(xbgr.mr_n67079856)
print v(xbgr.mr_n67080176)
print v(xbgr.mr_n67080288)
print v(xbgr.mr_n67080608)
print v(xbgr.mr_n67080720)
print v(xbgr.mr_n67081040)
print v(xbgr.mr_n67081152)
print v(xbgr.mr_n67081472)
print v(xbgr.mr_n67081584)
print v(xbgr.mr_n67081904)
print v(xbgr.mr_n67082016)
print v(xbgr.mr_n67082336)
print v(xbgr.mr_n67082448)
print v(xbgr.mr_n67082768)
print v(xbgr.mr_n67082880)
print v(xbgr.mr_n67083200)
print v(xbgr.mr_n67083312)
print v(xbgr.mr_n67083632)
print v(xbgr.mr_n67083744)
print v(xbgr.mr_n67084064)
print v(xbgr.mr_n67084176)
print v(xbgr.mr_n67084496)
print v(xbgr.mr_n67084608)
print v(xbgr.mr_n67084928)
print v(xbgr.mr_n67085040)
print v(xbgr.mr_n67085360)
print v(xbgr.mr_n67085472)
print v(xbgr.mr_n67085792)
print v(xbgr.mr_n67085904)
print v(xbgr.mr_n67086224)
print v(xbgr.mr_n67086336)
print v(xbgr.mr_n67086656)
print v(xbgr.mr_n67086768)
print v(xbgr.mr_n67087088)
print v(xbgr.mr_n67087200)
print v(xbgr.mr_n67087520)
print v(xbgr.mr_n67087632)
print v(xbgr.mr_n67087952)
print v(xbgr.mr_n67088064)
print v(xbgr.mr_n67088384)
print v(xbgr.mr_n67088496)
print v(xbgr.mr_n67088816)
print v(xbgr.mr_n67088928)
print v(xbgr.mr_n67089248)
print v(xbgr.mr_n67089360)
print v(xbgr.mr_n67089680)
print v(xbgr.mr_n67089792)
print v(xbgr.mr_n67090112)
print v(xbgr.mr_n67090224)
print v(xbgr.mr_n67090544)
print v(xbgr.mr_n67090656)
print v(xbgr.mr_n67090976)
print v(xbgr.mr_n67091088)
print v(xbgr.mr_n67091408)
print v(xbgr.mr_n67091520)
print v(xbgr.mr_n67091840)
print v(xbgr.mr_n67091952)
print v(xbgr.mr_n67092272)
print v(xbgr.mr_n67092384)
print v(xbgr.mr_n67092704)
print v(xbgr.mr_n67092816)
print v(xbgr.mr_n67093136)
print v(xbgr.mr_n67093248)
print v(xbgr.mr_n67093568)
print v(xbgr.mr_n67093680)
print v(xbgr.mr_n67094000)
print v(xbgr.mr_n67094112)
print v(xbgr.mr_n67094432)
print v(xbgr.mr_n67094544)
print v(xbgr.mr_n67094864)
print v(xbgr.mr_n67094976)
print v(xbgr.mr_n67095296)
print v(xbgr.mr_n67095408)
print v(xbgr.mr_n67095728)
print v(xbgr.mr_n67095840)
print v(xbgr.mr_n67096160)
print v(xbgr.mr_n67096272)
print v(xbgr.mr_n67096592)
print v(xbgr.mr_n67096704)
print v(xbgr.mr_n67097024)
print v(xbgr.mr_n67097136)
print v(xbgr.mr_n67097456)
print v(xbgr.mr_n67097568)
print v(xbgr.mr_n67097888)
print v(xbgr.mr_n67098000)
print v(xbgr.mr_n67098320)
print v(xbgr.mr_n67098432)
print v(xbgr.mr_n67098752)
print v(xbgr.mr_n67098864)
print v(xbgr.mr_n67099184)
print v(xbgr.mr_n67099296)
print v(xbgr.mr_n67099616)
print v(xbgr.mr_n67099728)
print v(xbgr.mr_n67100048)
print v(xbgr.mr_n67100160)
print v(xbgr.mr_n67100480)
print v(xbgr.mr_n67100592)
print v(xbgr.mr_n67100912)
print v(xbgr.mr_n67101024)
print v(xbgr.mr_n67101344)
print v(xbgr.mr_n67101456)
print v(xbgr.mr_n67101776)
print v(xbgr.mr_n67101888)
print v(xbgr.mr_n67102208)
print v(xbgr.mr_n67102320)
print v(xbgr.mr_n67102640)
print v(xbgr.mr_n67102752)
print v(xbgr.mr_n67103072)
print v(xbgr.mr_n67103184)
print v(xbgr.mr_n67103504)
print v(xbgr.mr_n67103616)
print v(xbgr.mr_n67103936)
print v(xbgr.mr_n67104048)
print v(xbgr.mr_n67104368)
print v(xbgr.mr_n67104480)
print v(xbgr.mr_n67104800)
print v(xbgr.mr_n67104912)
print v(xbgr.mr_n67105232)
print v(xbgr.mr_n67105344)
print v(xbgr.mr_n67105664)
print v(xbgr.mr_n67105776)
print v(xbgr.mr_n67106096)
print v(xbgr.mr_n67106208)
print v(xbgr.mr_n67106528)
print v(xbgr.mr_n67106640)
print v(xbgr.mr_n67106960)
print v(xbgr.mr_n67107072)
print v(xbgr.mr_n67107392)
print v(xbgr.mr_n67107504)
print v(xbgr.mr_n67107824)
print v(xbgr.mr_n67107936)
print v(xbgr.mr_n67108256)
print v(xbgr.mr_n67108368)
print v(xbgr.mr_n67108688)
print v(xbgr.mr_n67108800)
print v(xbgr.mr_n67109120)
print v(xbgr.mr_n67109232)
print v(xbgr.mr_n67109552)
print v(xbgr.mr_n67109664)
print v(xbgr.mr_n67109984)
print v(xbgr.mr_n67110096)
print v(xbgr.mr_n67110416)
print v(xbgr.mr_n67110528)
print v(xbgr.mr_n67110848)
print v(xbgr.mr_n67110960)
print v(xbgr.mr_n67111280)
print v(xbgr.mr_n67111392)
print v(xbgr.mr_n67111712)
print v(xbgr.mr_n67111824)
print v(xbgr.mr_n67112144)
print v(xbgr.mr_n67112256)
print v(xbgr.mr_n67112576)
print v(xbgr.mr_n67112688)
print v(xbgr.mr_n67113008)
print v(xbgr.mr_n67113120)
print v(xbgr.mr_n67113440)
print v(xbgr.mr_n67113552)
print v(xbgr.mr_n67113872)
print v(xbgr.mr_n67113984)
print v(xbgr.mr_n67114304)
print v(xbgr.mr_n67114416)
print v(xbgr.mr_n67114736)
print v(xbgr.mr_n67114848)
print v(xbgr.mr_n67115168)
print v(xbgr.mr_n67115280)
print v(xbgr.mr_n67115600)
print v(xbgr.mr_n67115712)
print v(xbgr.mr_n67116032)
print v(xbgr.mr_n67116144)
print v(xbgr.mr_n67116464)
print v(xbgr.mr_n67116576)
print v(xbgr.mr_n67116896)
print v(xbgr.mr_n67117008)
print v(xbgr.mr_n67117328)
print v(xbgr.mr_n67117440)
print v(xbgr.mr_n67117760)
print v(xbgr.mr_n67117872)
print v(xbgr.mr_n67118192)
print v(xbgr.mr_n67118304)
print v(xbgr.mr_n67118624)
print v(xbgr.mr_n67118736)
print v(xbgr.mr_n67119056)
print v(xbgr.mr_n67119168)
print v(xbgr.mr_n67119488)
print v(xbgr.mr_n67119600)
print v(xbgr.mr_n67119920)
print v(xbgr.mr_n67120032)
print v(xbgr.mr_n67120352)
print v(xbgr.mr_n67120464)
print v(xbgr.mr_n67120784)
print v(xbgr.mr_n67120896)
print v(xbgr.mr_n67121216)
print v(xbgr.mr_n67121328)
print v(xbgr.mr_n67121648)
print v(xbgr.mr_n67121760)
print v(xbgr.mr_n67122080)
print v(xbgr.mr_n67122192)
print v(xbgr.mr_n67122512)
print v(xbgr.mr_n67122624)
print v(xbgr.mr_n67122944)
print v(xbgr.mr_n67123056)
print v(xbgr.mr_n67123376)
print v(xbgr.mr_n67123488)
print v(xbgr.mr_n67123808)
print v(xbgr.mr_n67123920)
print v(xbgr.mr_n67124240)
print v(xbgr.mr_n67124352)
print v(xbgr.mr_n67124672)
print v(xbgr.mr_n67124784)
print v(xbgr.mr_n67125104)
print v(xbgr.mr_n67125216)
print v(xbgr.mr_n67125536)
print v(xbgr.mr_n67125648)
print v(xbgr.mr_n67125968)
print v(xbgr.mr_n67126080)
print v(xbgr.mr_n67126400)
print v(xbgr.mr_n67126512)
print v(xbgr.mr_n67126832)
print v(xbgr.mr_n67126944)
print v(xbgr.mr_n67127264)
print v(xbgr.mr_n67127376)
print v(xbgr.mr_n67127696)
print v(xbgr.mr_n67127808)
print v(xbgr.mr_n67128128)
print v(xbgr.mr_n67128240)
print v(xbgr.mr_n67128560)
print v(xbgr.mr_n67128672)
print v(xbgr.mr_n67128992)
print v(xbgr.mr_n67129104)
print v(xbgr.mr_n67129424)
print v(xbgr.mr_n67129536)
print v(xbgr.mr_n67129856)
print v(xbgr.mr_n67129968)
print v(xbgr.mr_n67130288)
print v(xbgr.mr_n67130400)
print v(xbgr.mr_n67130720)
print v(xbgr.mr_n67130832)
print v(xbgr.mr_n67131152)
print v(xbgr.mr_n67131264)
print v(xbgr.mr_n67131584)
print v(xbgr.mr_n67131696)
print v(xbgr.mr_n67132016)
print v(xbgr.mr_n67132128)
print v(xbgr.mr_n67132448)
print v(xbgr.mr_n67132560)
print v(xbgr.mr_n67132880)
print v(xbgr.mr_n67132992)
print v(xbgr.mr_n67133312)
print v(xbgr.mr_n67133424)
print v(xbgr.mr_n67133744)
print v(xbgr.mr_n67133856)
print v(xbgr.mr_n67134176)
print v(xbgr.mr_n67134288)
print v(xbgr.mr_n67134608)
print v(xbgr.mr_n67134720)
print v(xbgr.mr_n67135040)
print v(xbgr.mr_n67135152)
print v(xbgr.mr_n67135472)
print v(xbgr.mr_n67135584)
print v(xbgr.mr_n67135904)
print v(xbgr.mr_n67136016)
print v(xbgr.mr_n67136336)
print v(xbgr.mr_n67136448)
print v(xbgr.mr_n67136768)
print v(xbgr.mr_n67136880)
print v(xbgr.mr_n67137200)
print v(xbgr.mr_n67137312)
print v(xbgr.mr_n67137632)
print v(xbgr.mr_n67137744)
print v(xbgr.mr_n67138064)
print v(xbgr.mr_n67138176)
print v(xbgr.mr_n67138496)
print v(xbgr.mr_n67138608)
print v(xbgr.mr_n67138928)
print v(xbgr.mr_n67139040)
print v(xbgr.mr_n67139360)
print v(xbgr.mr_n67139472)
print v(xbgr.mr_n67139792)
print v(xbgr.mr_n67139904)
print v(xbgr.mr_n67140224)
print v(xbgr.mr_n67140336)
print v(xbgr.mr_n67140656)
print v(xbgr.mr_n67140768)
print v(xbgr.mr_n67141088)
print v(xbgr.mr_n67141200)
print v(xbgr.mr_n67141520)
print v(xbgr.mr_n67141632)
print v(xbgr.mr_n67141952)
print v(xbgr.mr_n67142064)
print v(xbgr.mr_n67142384)
print v(xbgr.mr_n67142496)
print v(xbgr.mr_n67142816)
print v(xbgr.mr_n67142928)
print v(xbgr.mr_n67143248)
print v(xbgr.mr_n67143360)
print v(xbgr.mr_n67143680)
print v(xbgr.mr_n67143792)
print v(xbgr.mr_n67144112)
print v(xbgr.mr_n67144224)
print v(xbgr.mr_n67144544)
print v(xbgr.mr_n67144656)
print v(xbgr.mr_n67144976)
print v(xbgr.mr_n67145088)
print v(xbgr.mr_n67145408)
print v(xbgr.mr_n67145520)
print v(xbgr.mr_n67145840)
print v(xbgr.mr_n67145952)
print v(xbgr.mr_n67146272)
print v(xbgr.mr_n67146384)
print v(xbgr.mr_n67146704)
print v(xbgr.mr_n67146816)
print v(xbgr.mr_n67147136)
print v(xbgr.mr_n67147248)
print v(xbgr.mr_n67147568)
print v(xbgr.mr_n67147680)
print v(xbgr.mr_n67148000)
print v(xbgr.mr_n67148112)
print v(xbgr.mr_n67148432)
print v(xbgr.mr_n67148544)
print v(xbgr.mr_n67148864)
print v(xbgr.mr_n67148976)
print v(xbgr.mr_n67149296)
print v(xbgr.mr_n67149408)
print v(xbgr.mr_n67149728)
print v(xbgr.mr_n67149840)
print v(xbgr.mr_n67150160)
print v(xbgr.mr_n67150272)
print v(xbgr.mr_n67150592)
print v(xbgr.mr_n67150704)
print v(xbgr.mr_n67151024)
print v(xbgr.mr_n67151136)
print v(xbgr.mr_n67151456)
print v(xbgr.mr_n67151568)
print v(xbgr.mr_n67151888)
print v(xbgr.mr_n67152000)
print v(xbgr.mr_n67152320)
print v(xbgr.mr_n67152432)
print v(xbgr.mr_n67152752)
print v(xbgr.mr_n67152864)
print v(xbgr.mr_n67153184)
print v(xbgr.mr_n67153296)
print v(xbgr.mr_n67153616)
print v(xbgr.mr_n67153728)
print v(xbgr.mr_n67154048)
print v(xbgr.mr_n67154160)
print v(xbgr.mr_n67154480)
print v(xbgr.mr_n67154592)
print v(xbgr.mr_n67154912)
print v(xbgr.mr_n67155024)
print v(xbgr.mr_n67155344)
print v(xbgr.mr_n67155456)
print v(xbgr.mr_n67155776)
print v(xbgr.mr_n67155888)
print v(xbgr.mr_n67156208)
print v(xbgr.mr_n67156320)
print v(xbgr.mr_n67156640)
print v(xbgr.mr_n67156752)
print v(xbgr.mr_n67157072)
print v(xbgr.mr_n67157184)
print v(xbgr.mr_n67157504)
print v(xbgr.mr_n67157616)
print v(xbgr.mr_n67157936)
print v(xbgr.mr_n67158048)
print v(xbgr.mr_n67158368)
print v(xbgr.mr_n67158480)
print v(xbgr.mr_n67158800)
print v(xbgr.mr_n67158912)
print v(xbgr.mr_n67159232)
print v(xbgr.mr_n67159344)
print v(xbgr.mr_n67159664)
print v(xbgr.mr_n67159776)
print v(xbgr.mr_n67160096)
print v(xbgr.mr_n67160208)
print v(xbgr.mr_n67160528)
print v(xbgr.mr_n67160640)
print v(xbgr.mr_n67160960)
print v(xbgr.mr_n67161072)
print v(xbgr.mr_n67161392)
print v(xbgr.mr_n67161504)
print v(xbgr.mr_n67161824)
print v(xbgr.mr_n67161936)
print v(xbgr.mr_n67162256)
print v(xbgr.mr_n67162368)
print v(xbgr.mr_n67162688)
print v(xbgr.mr_n67162800)
print v(xbgr.mr_n67163120)
print v(xbgr.mr_n67163232)
print v(xbgr.mr_n67163552)
print v(xbgr.mr_n67163664)
print v(xbgr.mr_n67163984)
print v(xbgr.mr_n67164096)
print v(xbgr.mr_n67164416)
print v(xbgr.mr_n67164528)
print v(xbgr.mr_n67164848)
print v(xbgr.mr_n67164960)
print v(xbgr.mr_n67165280)
print v(xbgr.mr_n67165392)
print v(xbgr.mr_n67165712)
print v(xbgr.mr_n67165824)
print v(xbgr.mr_n67166144)
print v(xbgr.mr_n67166256)
print v(xbgr.mr_n67166576)
print v(xbgr.mr_n67166688)
print v(xbgr.mr_n67167008)
print v(xbgr.mr_n67167120)
print v(xbgr.mr_n67167440)
print v(xbgr.mr_n67167552)
print v(xbgr.mr_n67167872)
print v(xbgr.mr_n67167984)
print v(xbgr.mr_n67168304)
print v(xbgr.mr_n67168416)
print v(xbgr.mr_n67168736)
print v(xbgr.mr_n67168848)
print v(xbgr.mr_n67169168)
print v(xbgr.mr_n67169280)
print v(xbgr.mr_n67169600)
print v(xbgr.mr_n67169712)
print v(xbgr.mr_n67170032)
print v(xbgr.mr_n67170144)
print v(xbgr.mr_n67170464)
print v(xbgr.mr_n67170576)
print v(xbgr.mr_n67170896)
print v(xbgr.mr_n67171008)
print v(xbgr.mr_n67171328)
print v(xbgr.mr_n67171440)
print v(xbgr.mr_n67171760)
print v(xbgr.mr_n67171872)
print v(xbgr.mr_n67172192)
print v(xbgr.mr_n67172304)
print v(xbgr.mr_n67172624)
print v(xbgr.mr_n67172736)
print v(xbgr.mr_n67173056)
print v(xbgr.mr_n67173168)
print v(xbgr.mr_n67173488)
print v(xbgr.mr_n67173600)
print v(xbgr.mr_n67173920)
print v(xbgr.mr_n67174032)
print v(xbgr.mr_n67174352)
print v(xbgr.mr_n67174464)
print v(xbgr.mr_n67174784)
print v(xbgr.mr_n67174896)
print v(xbgr.mr_n67175216)
print v(xbgr.mr_n67175328)
print v(xbgr.mr_n67175648)
print v(xbgr.mr_n67175760)
print v(xbgr.mr_n67176080)
print v(xbgr.mr_n67176192)
print v(xbgr.mr_n67176512)
print v(xbgr.mr_n67176624)
print v(xbgr.mr_n67176944)
print v(xbgr.mr_n67177056)
print v(xbgr.mr_n67177376)
print v(xbgr.mr_n67177488)
print v(xbgr.mr_n67177808)
print v(xbgr.mr_n67177920)
print v(xbgr.mr_n67178240)
print v(xbgr.mr_n67178352)
print v(xbgr.mr_n67178672)
print v(xbgr.mr_n67178784)
print v(xbgr.mr_n67179104)
print v(xbgr.mr_n67179216)
print v(xbgr.mr_n67179536)
print v(xbgr.mr_n67179648)
print v(xbgr.mr_n67179968)
print v(xbgr.mr_n67180080)
print v(xbgr.mr_n67180400)
print v(xbgr.mr_n67180512)
print v(xbgr.mr_n67180832)
print v(xbgr.mr_n67180944)
print v(xbgr.mr_n67181264)
print v(xbgr.mr_n67181376)
print v(xbgr.mr_n67181696)
print v(xbgr.mr_n67181808)
print v(xbgr.mr_n67182128)
print v(xbgr.mr_n67182240)
print v(xbgr.mr_n67182560)
print v(xbgr.mr_n67182672)
print v(xbgr.mr_n67182992)
print v(xbgr.mr_n67183104)
print v(xbgr.mr_n67183424)
print v(xbgr.mr_n67183536)
print v(xbgr.mr_n67183856)
print v(xbgr.mr_n67183968)
print v(xbgr.mr_n67184288)
print v(xbgr.mr_n67184400)
print v(xbgr.mr_n67184720)
print v(xbgr.mr_n67184832)
print v(xbgr.mr_n67185152)
print v(xbgr.mr_n67185264)
print v(xbgr.mr_n67185584)
print v(xbgr.mr_n67185696)
print v(xbgr.mr_n67186016)
print v(xbgr.mr_n67186128)
print v(xbgr.mr_n67186448)
print v(xbgr.mr_n67186560)
print v(xbgr.mr_n67186880)
print v(xbgr.mr_n67186992)
print v(xbgr.mr_n67187312)
print v(xbgr.mr_n67187424)
print v(xbgr.mr_n67187744)
print v(xbgr.mr_n67187856)
print v(xbgr.mr_n67188176)
print v(xbgr.mr_n67188288)
print v(xbgr.mr_n67188608)
print v(xbgr.mr_n67188720)
print v(xbgr.mr_n67189040)
print v(xbgr.mr_n67189152)
print v(xbgr.mr_n67189472)
print v(xbgr.mr_n67189584)
print v(xbgr.mr_n67189904)
print v(xbgr.mr_n67190016)
print v(xbgr.mr_n67190336)
print v(xbgr.mr_n67190448)
print v(xbgr.mr_n67190768)
print v(xbgr.mr_n67190880)
print v(xbgr.mr_n67191200)
print v(xbgr.mr_n67191312)
print v(xbgr.mr_n67191632)
print v(xbgr.mr_n67191744)
print v(xbgr.mr_n67192064)
print v(xbgr.mr_n67192176)
print v(xbgr.mr_n67192496)
print v(xbgr.mr_n67192608)
print v(xbgr.mr_n67192928)
print v(xbgr.mr_n67193040)
print v(xbgr.mr_n67193360)
print v(xbgr.mr_n67193472)
print v(xbgr.mr_n67193792)
print v(xbgr.mr_n67193904)
print v(xbgr.mr_n67194224)
print v(xbgr.mr_n67194336)
print v(xbgr.mr_n67194656)
print v(xbgr.mr_n67194768)
print v(xbgr.mr_n67195088)
print v(xbgr.mr_n67195200)
print v(xbgr.mr_n67195520)
print v(xbgr.mr_n67195632)
print v(xbgr.mr_n67195952)
print v(xbgr.mr_n67196064)
print v(xbgr.mr_n67196384)
print v(xbgr.mr_n67196496)
print v(xbgr.mr_n67196816)
print v(xbgr.mr_n67196928)
print v(xbgr.mr_n67197248)
print v(xbgr.mr_n67197360)
print v(xbgr.mr_n67197680)
print v(xbgr.mr_n67197792)
print v(xbgr.mr_n67198112)
print v(xbgr.mr_n67198224)
print v(xbgr.mr_n67198544)
print v(xbgr.mr_n67198656)
print v(xbgr.mr_n67198976)
print v(xbgr.mr_n67199088)
print v(xbgr.mr_n67199408)
print v(xbgr.mr_n67199520)
print v(xbgr.mr_n67199840)
print v(xbgr.mr_n67200272)
print v(xbgr.mr_n67200384)
print v(xbgr.mr_n67200704)
print v(xbgr.mr_n67201136)
print v(xbgr.mr_n67201248)
print v(xbgr.mr_n67201568)
print v(xbgr.mr_n67201680)
print v(xbgr.mr_n67202000)
print v(xbgr.mr_n67202112)
print v(xbgr.mr_n67202432)
print v(xbgr.mr_n67202544)
print v(xbgr.mr_n67202864)
print v(xbgr.mr_n67202976)
print v(xbgr.mr_n67203296)
print v(xbgr.mr_n67203408)
print v(xbgr.mr_n67203728)
print v(xbgr.mr_n67203840)
print v(xbgr.mr_n67204160)
print v(xbgr.mr_n67204272)
print v(xbgr.mr_n67204592)
print v(xbgr.mr_n67204704)
print v(xbgr.mr_n67205024)
print v(xbgr.mr_n67205136)
print v(xbgr.mr_n67205456)
print v(xbgr.mr_n67205568)
print v(xbgr.mr_n67205888)
print v(xbgr.mr_n67206000)
print v(xbgr.mr_n67206320)
print v(xbgr.mr_n67206432)
print v(xbgr.mr_n67206752)
print v(xbgr.mr_n67206864)
print v(xbgr.mr_n67207184)
print v(xbgr.mr_n67207296)
print v(xbgr.mr_n67207616)
print v(xbgr.mr_n67207728)
print v(xbgr.mr_n67208048)
print v(xbgr.mr_n67208160)
print v(xbgr.mr_n67208480)
print v(xbgr.mr_n67208592)
print v(xbgr.mr_n67208912)
print v(xbgr.mr_n67209024)
print v(xbgr.mr_n67209344)
print v(xbgr.mr_n67209456)
print v(xbgr.mr_n67209776)
print v(xbgr.mr_n67209888)
print v(xbgr.mr_n67210208)
print v(xbgr.mr_n67210320)
print v(xbgr.mr_n67210640)
print v(xbgr.mr_n67211072)
print v(xbgr.mr_n67211184)
print v(xbgr.mr_n67211504)
print v(xbgr.mr_n67211936)
print v(xbgr.mr_n67212048)
print v(xbgr.mr_n67212368)
print v(xbgr.mr_n67212800)
print v(xbgr.mr_n67212912)
print v(xbgr.mr_n67213232)
print v(xbgr.mr_n67213664)
print v(xbgr.mr_n67213776)
print v(xbgr.mr_n67214096)
print v(xbgr.mr_n67214528)
print v(xbgr.mr_n67214640)
print v(xbgr.mr_n67214960)
print v(xbgr.mr_n67215072)
print v(xbgr.mr_n67215392)
print v(xbgr.mr_n67215504)
print v(xbgr.mr_n67215824)
print v(xbgr.mr_n67215936)
print v(xbgr.mr_n67216256)
print v(xbgr.mr_n67216368)
print v(xbgr.mr_n67216688)
print v(xbgr.mr_n67216800)
print v(xbgr.mr_n67217120)
print v(xbgr.mr_n67217232)
print v(xbgr.mr_n67217552)
print v(xbgr.mr_n67217664)
print v(xbgr.mr_n67217984)
print v(xbgr.mr_n67218096)
print v(xbgr.mr_n67218416)
print v(xbgr.mr_n67218528)
print v(xbgr.mr_n67218848)
print v(xbgr.mr_n67218960)
print v(xbgr.mr_n67219280)
print v(xbgr.mr_n67219392)
print v(xbgr.mr_n67219712)
print v(xbgr.mr_n67219824)
print v(xbgr.mr_n67220144)
print v(xbgr.mr_n67220256)
print v(xbgr.mr_n67220576)
print v(xbgr.mr_n67220688)
print v(xbgr.mr_n67221008)
print v(xbgr.mr_n67221120)
print v(xbgr.mr_n67221440)
print v(xbgr.mr_n67221552)
print v(xbgr.mr_n67221872)
print v(xbgr.mr_n67221984)
print v(xbgr.mr_n67222304)
print v(xbgr.mr_n67222416)
print v(xbgr.mr_n67222736)
print v(xbgr.mr_n67222848)
print v(xbgr.mr_n67223168)
print v(xbgr.mr_n67223280)
print v(xbgr.mr_n67223600)
print v(xbgr.mr_n67223712)
print v(xbgr.mr_n67224032)
print v(xbgr.mr_n67224144)
print v(xbgr.mr_n67224464)
print v(xbgr.mr_n67224576)
print v(xbgr.mr_n67224896)
print v(xbgr.mr_n67225008)
print v(xbgr.mr_n67225328)
print v(xbgr.mr_n67225440)
print v(xbgr.mr_n67225760)
print v(xbgr.mr_n67225872)
print v(xbgr.mr_n67226192)
print v(xbgr.mr_n67226304)
print v(xbgr.mr_n67226624)
print v(xbgr.mr_n67226736)
print v(xbgr.mr_n67227056)
print v(xbgr.mr_n67227168)
print v(xbgr.mr_n67227488)
print v(xbgr.mr_n67227600)
print v(xbgr.mr_n67227920)
print v(xbgr.mr_n67228032)
print v(xbgr.mr_n67228352)
print v(xbgr.mr_n67228464)
print v(xbgr.mr_n67228784)
print v(xbgr.mr_n67228896)
print v(xbgr.mr_n67229216)
print v(xbgr.mr_n67229328)
print v(xbgr.mr_n67229648)
print v(xbgr.mr_n67229760)
print v(xbgr.mr_n67230080)
print v(xbgr.mr_n67230192)
print v(xbgr.mr_n67230512)
print v(xbgr.mr_n67230624)
print v(xbgr.mr_n67230944)
print v(xbgr.mr_n67231056)
print v(xbgr.mr_n67231376)
print v(xbgr.mr_n67231488)
print v(xbgr.mr_n67231808)
print v(xbgr.mr_n67231920)
print v(xbgr.mr_n67232240)
print v(xbgr.mr_n67232352)
print v(xbgr.mr_n67232672)
print v(xbgr.mr_n67232784)
print v(xbgr.mr_n67233104)
print v(xbgr.mr_n67233216)
print v(xbgr.mr_n67233536)
print v(xbgr.mr_n67233648)
print v(xbgr.mr_n67233968)
print v(xbgr.mr_n67234080)
print v(xbgr.mr_n67234400)
print v(xbgr.mr_n67234832)
print v(xbgr.mr_n67234944)
print v(xbgr.mr_n67235264)
print v(xbgr.mr_n67235696)
print v(xbgr.mr_n67235808)
print v(xbgr.mr_n67236128)
print v(xbgr.mr_n67236560)
print v(xbgr.mr_n67236672)
print v(xbgr.mr_n67236992)
print v(xbgr.mr_n67237104)
print v(xbgr.mr_n67237424)
print v(xbgr.mr_n67237536)
print v(xbgr.mr_n67237856)
print v(xbgr.mr_n67237968)
print v(xbgr.mr_n67238288)
print v(xbgr.mr_n67238400)
print v(xbgr.mr_n67238720)
print v(xbgr.mr_n67238832)
print v(xbgr.mr_n67239152)
print v(xbgr.mr_n67239264)
print v(xbgr.mr_n67239584)
print v(xbgr.mr_n67239696)
print v(xbgr.mr_n67240016)
print v(xbgr.mr_n67240128)
print v(xbgr.mr_n67240448)
print v(xbgr.mr_n67240560)
print v(xbgr.mr_n67240880)
print v(xbgr.mr_n67240992)
print v(xbgr.mr_n67241312)
print v(xbgr.mr_n67241424)
print v(xbgr.mr_n67241744)
print v(xbgr.mr_n67241856)
print v(xbgr.mr_n67242176)
print v(xbgr.mr_n67242288)
print v(xbgr.mr_n67242608)
print v(xbgr.mr_n67242720)
print v(xbgr.mr_n67243040)
print v(xbgr.mr_n67243152)
print v(xbgr.mr_n67243472)
print v(xbgr.mr_n67243584)
print v(xbgr.mr_n67243904)
print v(xbgr.mr_n67244016)
print v(xbgr.mr_n67244336)
print v(xbgr.mr_n67244448)
print v(xbgr.mr_n67244768)
print v(xbgr.mr_n67244880)
print v(xbgr.mr_n67245200)
print v(xbgr.mr_n67245312)
print v(xbgr.mr_n67245632)
print v(xbgr.mr_n67245744)
print v(xbgr.mr_n67246064)
print v(xbgr.mr_n67246176)
print v(xbgr.mr_n67246496)
print v(xbgr.mr_n67246608)
print v(xbgr.mr_n67246928)
print v(xbgr.mr_n67247040)
print v(xbgr.mr_n67247360)
print v(xbgr.mr_n67247472)
print v(xbgr.mr_n67247792)
print v(xbgr.mr_n67247904)
print v(xbgr.mr_n67248224)
print v(xbgr.mr_n67248336)
print v(xbgr.mr_n67248656)
print v(xbgr.mr_n67248768)
print v(xbgr.mr_n67249088)
print v(xbgr.mr_n67249200)
print v(xbgr.mr_n67249520)
print v(xbgr.mr_n67249632)
print v(xbgr.mr_n67249952)
print v(xbgr.mr_n67250064)
print v(xbgr.mr_n67250384)
print v(xbgr.mr_n67250496)
print v(xbgr.mr_n67250816)
print v(xbgr.mr_n67250928)
print v(xbgr.mr_n67251248)
print v(xbgr.mr_n67251360)
print v(xbgr.mr_n67251680)
print v(xbgr.mr_n67251792)
print v(xbgr.mr_n67252112)
print v(xbgr.mr_n67252224)
print v(xbgr.mr_n67252544)
print v(xbgr.mr_n67252656)
print v(xbgr.mr_n67252976)
print v(xbgr.mr_n67253088)
print v(xbgr.mr_n67253408)
print v(xbgr.mr_n67253520)
print v(xbgr.mr_n67253840)
print v(xbgr.mr_n67253952)
print v(xbgr.mr_n67254272)
print v(xbgr.mr_n67254384)
print v(xbgr.mr_n67254704)
print v(xbgr.mr_n67254816)
print v(xbgr.mr_n67255136)
print v(xbgr.mr_n67255248)
print v(xbgr.mr_n67255568)
print v(xbgr.mr_n67255680)
print v(xbgr.mr_n67256000)
print v(xbgr.mr_n67256112)
print v(xbgr.mr_n67256432)
print v(xbgr.mr_n67256544)
print v(xbgr.mr_n67256864)
print v(xbgr.mr_n67256976)
print v(xbgr.mr_n67257296)
print v(xbgr.mr_n67257408)
print v(xbgr.mr_n67257728)
print v(xbgr.mr_n67257840)
print v(xbgr.mr_n67258160)
print v(xbgr.mr_n67258272)
print v(xbgr.mr_n67258592)
print v(xbgr.mr_n67258704)
print v(xbgr.mr_n67259024)
print v(xbgr.mr_n67259136)
print v(xbgr.mr_n67259456)
print v(xbgr.mr_n67259568)
print v(xbgr.mr_n67259888)
print v(xbgr.mr_n67260000)
print v(xbgr.mr_n67260320)
print v(xbgr.mr_n67260432)
print v(xbgr.mr_n67260752)
print v(xbgr.mr_n67260864)
print v(xbgr.mr_n67261184)
print v(xbgr.mr_n67261296)
print v(xbgr.mr_n67261616)
print v(xbgr.mr_n67261728)
print v(xbgr.mr_n67262048)
print v(xbgr.mr_n67262160)
print v(xbgr.mr_n67262480)
print v(xbgr.mr_n67262592)
print v(xbgr.mr_n67262912)
print v(xbgr.mr_n67263024)
print v(xbgr.mr_n67263344)
print v(xbgr.mr_n67263456)
print v(xbgr.mr_n67263776)
print v(xbgr.mr_n67263888)
print v(xbgr.mr_n67264208)
print v(xbgr.mr_n67264320)
print v(xbgr.mr_n67264640)
print v(xbgr.mr_n67264752)
print v(xbgr.mr_n67265072)
print v(xbgr.mr_n67265184)
print v(xbgr.mr_n67265504)
print v(xbgr.mr_n67265616)
print v(xbgr.mr_n67265936)
print v(xbgr.mr_n67266048)
print v(xbgr.mr_n67266368)
print v(xbgr.mr_n67266480)
print v(xbgr.mr_n67266800)
print v(xbgr.mr_n67266912)
print v(xbgr.mr_n67267232)
print v(xbgr.mr_n67267344)
print v(xbgr.mr_n67267664)
print v(xbgr.mr_n67267776)
print v(xbgr.mr_n67268096)
print v(xbgr.mr_n67268208)
print v(xbgr.mr_n67268528)
print v(xbgr.mr_n67268640)
print v(xbgr.mr_n67268960)
print v(xbgr.mr_n67269072)
print v(xbgr.mr_n67269392)
print v(xbgr.mr_n67269504)
print v(xbgr.mr_n67269824)
print v(xbgr.mr_n67269936)
print v(xbgr.mr_n67270256)
print v(xbgr.mr_n67270368)
print v(xbgr.mr_n67270688)
print v(xbgr.mr_n67270800)
print v(xbgr.mr_n67271120)
print v(xbgr.mr_n67271232)
print v(xbgr.mr_n67271552)
print v(xbgr.mr_n67271664)
print v(xbgr.mr_n67271984)
print v(xbgr.mr_n67272096)
print v(xbgr.mr_n67272416)
print v(xbgr.mr_n67272528)
print v(xbgr.mr_n67272848)
print v(xbgr.mr_n67272960)
print v(xbgr.mr_n67273280)
print v(xbgr.mr_n67273392)
print v(xbgr.mr_n67273712)
print v(xbgr.mr_n67273824)
print v(xbgr.mr_n67274144)
print v(xbgr.mr_n67274256)
print v(xbgr.mr_n67274576)
print v(xbgr.mr_n67274688)
print v(xbgr.mr_n67275008)
print v(xbgr.mr_n67275120)
print v(xbgr.mr_n67275440)
print v(xbgr.mr_n67275552)
print v(xbgr.mr_n67275872)
print v(xbgr.mr_n67275984)
print v(xbgr.mr_n67276304)
print v(xbgr.mr_n67276416)
print v(xbgr.mr_n67276736)
print v(xbgr.mr_n67276848)
print v(xbgr.mr_n67277168)
print v(xbgr.mr_n67277280)
print v(xbgr.mr_n67277600)
print v(xbgr.mr_n67277712)
print v(xbgr.mr_n67278032)
print v(xbgr.mr_n67278144)
print v(xbgr.mr_n67278464)
print v(xbgr.mr_n67278576)
print v(xbgr.mr_n67278896)
print v(xbgr.mr_n67279008)
print v(xbgr.mr_n67279328)
print v(xbgr.mr_n67279440)
print v(xbgr.mr_n67279760)
print v(xbgr.mr_n67279872)
print v(xbgr.mr_n67280192)
print v(xbgr.mr_n67280304)
print v(xbgr.mr_n67280624)
print v(xbgr.mr_n67280736)
print v(xbgr.mr_n67281056)
print v(xbgr.mr_n67281168)
print v(xbgr.mr_n67281488)
print v(xbgr.mr_n67281600)
print v(xbgr.mr_n67281920)
print v(xbgr.mr_n67282032)
print v(xbgr.mr_n67282352)
print v(xbgr.mr_n67282464)
print v(xbgr.mr_n67282784)
print v(xbgr.mr_n67282896)
print v(xbgr.mr_n67283216)
print v(xbgr.mr_n67283328)
print v(xbgr.mr_n67283648)
print v(xbgr.mr_n67283760)
print v(xbgr.mr_n67284080)
print v(xbgr.mr_n67284192)
print v(xbgr.mr_n67284512)
print v(xbgr.mr_n67284624)
print v(xbgr.mr_n67284944)
print v(xbgr.mr_n67285056)
print v(xbgr.mr_n67285376)
print v(xbgr.mr_n67285488)
print v(xbgr.mr_n67285808)
print v(xbgr.mr_n67285920)
print v(xbgr.mr_n67286240)
print v(xbgr.mr_n67286352)
print v(xbgr.mr_n67286672)
print v(xbgr.mr_n67286784)
print v(xbgr.mr_n67287104)
print v(xbgr.mr_n67287216)
print v(xbgr.mr_n67287536)
print v(xbgr.mr_n67287648)
print v(xbgr.mr_n67287968)
print v(xbgr.mr_n67288080)
print v(xbgr.mr_n67288400)
print v(xbgr.mr_n67288512)
print v(xbgr.mr_n67288832)
print v(xbgr.mr_n67288944)
print v(xbgr.mr_n67289264)
print v(xbgr.mr_n67289376)
print v(xbgr.mr_n67289696)
print v(xbgr.mr_n67289808)
print v(xbgr.mr_n67290128)
print v(xbgr.mr_n67290240)
print v(xbgr.mr_n67290560)
print v(xbgr.mr_n67290672)
print v(xbgr.mr_n67290992)
print v(xbgr.mr_n67291104)
print v(xbgr.mr_n67291424)
print v(xbgr.mr_n67291536)
print v(xbgr.mr_n67291856)
print v(xbgr.mr_n67291968)
print v(xbgr.mr_n67292288)
print v(xbgr.mr_n67292400)
print v(xbgr.mr_n67292720)
print v(xbgr.mr_n67292832)
print v(xbgr.mr_n67293152)
print v(xbgr.mr_n67293264)
print v(xbgr.mr_n67293584)
print v(xbgr.mr_n67293696)
print v(xbgr.mr_n67294016)
print v(xbgr.mr_n67294128)
print v(xbgr.mr_n67294448)
print v(xbgr.mr_n67294560)
print v(xbgr.mr_n67294880)
print v(xbgr.mr_n67294992)
print v(xbgr.mr_n67295312)
print v(xbgr.mr_n67295424)
print v(xbgr.mr_n67295744)
print v(xbgr.mr_n67295856)
print v(xbgr.mr_n67296176)
print v(xbgr.mr_n67296288)
print v(xbgr.mr_n67296608)
print v(xbgr.mr_n67296720)
print v(xbgr.mr_n67297040)
print v(xbgr.mr_n67297152)
print v(xbgr.mr_n67297472)
print v(xbgr.mr_n67297584)
print v(xbgr.mr_n67297904)
print v(xbgr.mr_n67298016)
print v(xbgr.mr_n67298336)
print v(xbgr.mr_n67298448)
print v(xbgr.mr_n67298768)
print v(xbgr.mr_n67298880)
print v(xbgr.mr_n67299200)
print v(xbgr.mr_n67299312)
print v(xbgr.mr_n67299632)
print v(xbgr.mr_n67299744)
print v(xbgr.mr_n67300064)
print v(xbgr.mr_n67300176)
print v(xbgr.mr_n67300496)
print v(xbgr.mr_n67300608)
print v(xbgr.mr_n67300928)
print v(xbgr.mr_n67301040)
print v(xbgr.mr_n67301360)
print v(xbgr.mr_n67301472)
print v(xbgr.mr_n67301792)
print v(xbgr.mr_n67301904)
print v(xbgr.mr_n67302224)
print v(xbgr.mr_n67302336)
print v(xbgr.mr_n67302656)
print v(xbgr.mr_n67302768)
print v(xbgr.mr_n67303088)
print v(xbgr.mr_n67303200)
print v(xbgr.mr_n67303520)
print v(xbgr.mr_n67303632)
print v(xbgr.mr_n67303952)
print v(xbgr.mr_n67304064)
print v(xbgr.mr_n67304384)
print v(xbgr.mr_n67304496)
print v(xbgr.mr_n67304816)
print v(xbgr.mr_n67304928)
print v(xbgr.mr_n67305248)
print v(xbgr.mr_n67305360)
print v(xbgr.mr_n67305680)
print v(xbgr.mr_n67305792)
print v(xbgr.mr_n67306112)
print v(xbgr.mr_n67306224)
print v(xbgr.mr_n67306544)
print v(xbgr.mr_n67306656)
print v(xbgr.mr_n67306976)
print v(xbgr.mr_n67307088)
print v(xbgr.mr_n67307408)
print v(xbgr.mr_n67307520)
print v(xbgr.mr_n67307840)
print v(xbgr.mr_n67307952)
print v(xbgr.mr_n67308272)
print v(xbgr.mr_n67308384)
print v(xbgr.mr_n67308704)
print v(xbgr.mr_n67308816)
print v(xbgr.mr_n67309136)
print v(xbgr.mr_n67309248)
print v(xbgr.mr_n67309568)
print v(xbgr.mr_n67309680)
print v(xbgr.mr_n67310000)
print v(xbgr.mr_n67310112)
print v(xbgr.mr_n67310432)
print v(xbgr.mr_n67310544)
print v(xbgr.mr_n67310864)
print v(xbgr.mr_n67310976)
print v(xbgr.mr_n67311296)
print v(xbgr.mr_n67311408)
print v(xbgr.mr_n67311728)
print v(xbgr.mr_n67311840)
print v(xbgr.mr_n67312160)
print v(xbgr.mr_n67312272)
print v(xbgr.mr_n67312592)
print v(xbgr.mr_n67312704)
print v(xbgr.mr_n67313024)
print v(xbgr.mr_n67313136)
print v(xbgr.mr_n67313456)
print v(xbgr.mr_n67313568)
print v(xbgr.mr_n67313888)
print v(xbgr.mr_n67314000)
print v(xbgr.mr_n67314320)
print v(xbgr.mr_n67314432)
print v(xbgr.mr_n67314752)
print v(xbgr.mr_n67314864)
print v(xbgr.mr_n67315184)
print v(xbgr.mr_n67315296)
print v(xbgr.mr_n67315616)
print v(xbgr.mr_n67315728)
print v(xbgr.mr_n67316048)
print v(xbgr.mr_n67316160)
print v(xbgr.mr_n67316480)
print v(xbgr.mr_n67316592)
print v(xbgr.mr_n67316912)
print v(xbgr.mr_n67317024)
print v(xbgr.mr_n67317344)
print v(xbgr.mr_n67317456)
print v(xbgr.mr_n67317776)
print v(xbgr.mr_n67317888)
print v(xbgr.mr_n67318208)
print v(xbgr.mr_n67318320)
print v(xbgr.mr_n67318640)
print v(xbgr.mr_n67318752)
print v(xbgr.mr_n67319072)
print v(xbgr.mr_n67319184)
print v(xbgr.mr_n67319504)
print v(xbgr.mr_n67319616)
print v(xbgr.mr_n67319936)
print v(xbgr.mr_n67320048)
print v(xbgr.mr_n67320368)
print v(xbgr.mr_n67320480)
print v(xbgr.mr_n67320800)
print v(xbgr.mr_n67320912)
print v(xbgr.mr_n67321232)
print v(xbgr.mr_n67321344)
print v(xbgr.mr_n67321664)
print v(xbgr.mr_n67321776)
print v(xbgr.mr_n67322096)
print v(xbgr.mr_n67322208)
print v(xbgr.mr_n67322528)
print v(xbgr.mr_n67322640)
print v(xbgr.mr_n67322960)
print v(xbgr.mr_n67323072)
print v(xbgr.mr_n67323392)
print v(xbgr.mr_n67323504)
print v(xbgr.mr_n67323824)
print v(xbgr.mr_n67323936)
print v(xbgr.mr_n67324256)
print v(xbgr.mr_n67324368)
print v(xbgr.mr_n67324688)
print v(xbgr.mr_n67324800)
print v(xbgr.mr_n67325120)
print v(xbgr.mr_n67325232)
print v(xbgr.mr_n67325552)
print v(xbgr.mr_n67325664)
print v(xbgr.mr_n67325984)
print v(xbgr.mr_n67326096)
print v(xbgr.mr_n67326416)
print v(xbgr.mr_n67326528)
print v(xbgr.mr_n67326848)
print v(xbgr.mr_n67326960)
print v(xbgr.mr_n67327280)
print v(xbgr.mr_n67327392)
print v(xbgr.mr_n67327712)
print v(xbgr.mr_n67327824)
print v(xbgr.mr_n67328144)
print v(xbgr.mr_n67328256)
print v(xbgr.mr_n67328576)
print v(xbgr.mr_n67328688)
print v(xbgr.mr_n67329008)
print v(xbgr.mr_n67329120)
print v(xbgr.mr_n67329440)
print v(xbgr.mr_n67329552)
print v(xbgr.mr_n67329872)
print v(xbgr.mr_n67329984)
print v(xbgr.mr_n67330304)
print v(xbgr.mr_n67330416)
print v(xbgr.mr_n67330736)
print v(xbgr.mr_n67330848)
print v(xbgr.mr_n67331168)
print v(xbgr.mr_n67331280)
print v(xbgr.mr_n67331600)
print v(xbgr.mr_n67331712)
print v(xbgr.mr_n67332032)
print v(xbgr.mr_n67332144)
print v(xbgr.mr_n67332464)
print v(xbgr.mr_n67332576)
print v(xbgr.mr_n67332896)
print v(xbgr.mr_n67333008)
print v(xbgr.mr_n67333328)
print v(xbgr.mr_n67333440)
print v(xbgr.mr_n67333760)
print v(xbgr.mr_n67333872)
print v(xbgr.mr_n67334192)
print v(xbgr.mr_n67334304)
print v(xbgr.mr_n67334624)
print v(xbgr.mr_n67334736)
print v(xbgr.mr_n67335056)
print v(xbgr.mr_n67335168)
print v(xbgr.mr_n67335488)
print v(xbgr.mr_n67335600)
print v(xbgr.mr_n67335920)
print v(xbgr.mr_n67336032)
print v(xbgr.mr_n67336352)
print v(xbgr.mr_n67336464)
print v(xbgr.mr_n67336784)
print v(xbgr.mr_n67336896)
print v(xbgr.mr_n67337216)
print v(xbgr.mr_n67337328)
print v(xbgr.mr_n67337648)
print v(xbgr.mr_n67337760)
print v(xbgr.mr_n67338080)
print v(xbgr.mr_n67338192)
print v(xbgr.mr_n67338512)
print v(xbgr.mr_n67338624)
print v(xbgr.mr_n67338944)
print v(xbgr.mr_n67339056)
print v(xbgr.mr_n67339376)
print v(xbgr.mr_n67339488)
print v(xbgr.mr_n67339808)
print v(xbgr.mr_n67339920)
print v(xbgr.mr_n67340240)
print v(xbgr.mr_n67340352)
print v(xbgr.mr_n67340672)
print v(xbgr.mr_n67340784)
print v(xbgr.mr_n67341104)
print v(xbgr.mr_n67341216)
print v(xbgr.mr_n67341536)
print v(xbgr.mr_n67341648)
print v(xbgr.mr_n67341968)
print v(xbgr.mr_n67342080)
print v(xbgr.mr_n67342400)
print v(xbgr.mr_n67342512)
print v(xbgr.mr_n67342832)
print v(xbgr.mr_n67342944)
print v(xbgr.mr_n67343264)
print v(xbgr.mr_n67343376)
print v(xbgr.mr_n67343696)
print v(xbgr.mr_n67343808)
print v(xbgr.mr_n67344128)
print v(xbgr.mr_n67344240)
print v(xbgr.mr_n67344560)
print v(xbgr.mr_n67344672)
print v(xbgr.mr_n67344992)
print v(xbgr.mr_n67345104)
print v(xbgr.mr_n67345424)
print v(xbgr.mr_n67345536)
print v(xbgr.mr_n67345856)
print v(xbgr.mr_n67345968)
print v(xbgr.mr_n67346288)
print v(xbgr.mr_n67346400)
print v(xbgr.mr_n67346720)
print v(xbgr.mr_n67346832)
print v(xbgr.mr_n67347152)
print v(xbgr.mr_n67347264)
print v(xbgr.mr_n67347584)
print v(xbgr.mr_n67347696)
print v(xbgr.mr_n67348016)
print v(xbgr.mr_n67348128)
print v(xbgr.mr_n67348448)
print v(xbgr.mr_n67348560)
print v(xbgr.mr_n67348880)
print v(xbgr.mr_n67348992)
print v(xbgr.mr_n67349312)
print v(xbgr.mr_n67349424)
print v(xbgr.mr_n67349744)
print v(xbgr.mr_n67349856)
print v(xbgr.mr_n67350176)
print v(xbgr.mr_n67350288)
print v(xbgr.mr_n67350608)
print v(xbgr.mr_n67350720)
print v(xbgr.mr_n67351040)
print v(xbgr.mr_n67351152)
print v(xbgr.mr_n67351472)
print v(xbgr.mr_n67351584)
print v(xbgr.mr_n67351904)
print v(xbgr.mr_n67352016)
print v(xbgr.mr_n67352336)
print v(xbgr.mr_n67352448)
print v(xbgr.mr_n67352768)
print v(xbgr.mr_n67352880)
print v(xbgr.mr_n67353200)
print v(xbgr.mr_n67353312)
print v(xbgr.mr_n67353632)
print v(xbgr.mr_n67353744)
print v(xbgr.mr_n67354064)
print v(xbgr.mr_n67354176)
print v(xbgr.mr_n67354496)
print v(xbgr.mr_n67354608)
print v(xbgr.mr_n67354928)
print v(xbgr.mr_n67355040)
print v(xbgr.mr_n67355360)
print v(xbgr.mr_n67355472)
print v(xbgr.mr_n67355792)
print v(xbgr.mr_n67355904)
print v(xbgr.mr_n67356224)
print v(xbgr.mr_n67356336)
print v(xbgr.mr_n67356656)
print v(xbgr.mr_n67356768)
print v(xbgr.mr_n67357088)
print v(xbgr.mr_n67357200)
print v(xbgr.mr_n67357520)
print v(xbgr.mr_n67357632)
print v(xbgr.mr_n67357952)
print v(xbgr.mr_n67358064)
print v(xbgr.mr_n67358384)
print v(xbgr.mr_n67358496)
print v(xbgr.mr_n67358816)
print v(xbgr.mr_n67358928)
print v(xbgr.mr_n67359248)
print v(xbgr.mr_n67359360)
print v(xbgr.mr_n67359680)
print v(xbgr.mr_n67359792)
print v(xbgr.mr_n67360112)
print v(xbgr.mr_n67360224)
print v(xbgr.mr_n67360544)
print v(xbgr.mr_n67360656)
print v(xbgr.mr_n67360976)
print v(xbgr.mr_n67361088)
print v(xbgr.mr_n67361408)
print v(xbgr.mr_n67361520)
print v(xbgr.mr_n67361840)
print v(xbgr.mr_n67361952)
print v(xbgr.mr_n67362272)
print v(xbgr.mr_n67362384)
print v(xbgr.mr_n67362704)
print v(xbgr.mr_n67362816)
print v(xbgr.mr_n67363136)
print v(xbgr.mr_n67363248)
print v(xbgr.mr_n67363568)
print v(xbgr.mr_n67363680)
print v(xbgr.mr_n67364000)
print v(xbgr.mr_n67364112)
print v(xbgr.mr_n67364432)
print v(xbgr.mr_n67364544)
print v(xbgr.mr_n67364864)
print v(xbgr.mr_n67364976)
print v(xbgr.mr_n67365296)
print v(xbgr.mr_n67365408)
print v(xbgr.mr_n67365728)
print v(xbgr.mr_n67365840)
print v(xbgr.mr_n67366160)
print v(xbgr.mr_n67366272)
print v(xbgr.mr_n67366592)
print v(xbgr.mr_n67366704)
print v(xbgr.mr_n67367024)
print v(xbgr.mr_n67367136)
print v(xbgr.mr_n67367456)
print v(xbgr.mr_n67367568)
print v(xbgr.mr_n67367888)
print v(xbgr.mr_n67368000)
print v(xbgr.mr_n67368320)
print v(xbgr.mr_n67368432)
print v(xbgr.mr_n67368752)
print v(xbgr.mr_n67368864)
print v(xbgr.mr_n67369184)
print v(xbgr.mr_n67369296)
print v(xbgr.mr_n67369616)
print v(xbgr.mr_n67369728)
print v(xbgr.mr_n67370048)
print v(xbgr.mr_n67370160)
print v(xbgr.mr_n67370480)
print v(xbgr.mr_n67370592)
print v(xbgr.mr_n67370912)
print v(xbgr.mr_n67371024)
print v(xbgr.mr_n67371344)
print v(xbgr.mr_n67371456)
print v(xbgr.mr_n67371776)
print v(xbgr.mr_n67371888)
print v(xbgr.mr_n67372208)
print v(xbgr.mr_n67372320)
print v(xbgr.mr_n67372640)
print v(xbgr.mr_n67372752)
print v(xbgr.mr_n67373072)
print v(xbgr.mr_n67373184)
print v(xbgr.mr_n67373504)
print v(xbgr.mr_n67373616)
print v(xbgr.mr_n67373936)
print v(xbgr.mr_n67374048)
print v(xbgr.mr_n67374368)
print v(xbgr.mr_n67374480)
print v(xbgr.mr_n67374800)
print v(xbgr.mr_n67374912)
print v(xbgr.mr_n67375232)
print v(xbgr.mr_n67375344)
print v(xbgr.mr_n67375664)
print v(xbgr.mr_n67375776)
print v(xbgr.mr_n67376096)
print v(xbgr.mr_n67376208)
print v(xbgr.mr_n67376528)
print v(xbgr.mr_n67376640)
print v(xbgr.mr_n67376960)
print v(xbgr.mr_n67377072)
print v(xbgr.mr_n67377392)
print v(xbgr.mr_n67377504)
print v(xbgr.mr_n67377824)
print v(xbgr.mr_n67377936)
print v(xbgr.mr_n67378256)
print v(xbgr.mr_n67378368)
print v(xbgr.mr_n67378688)
print v(xbgr.mr_n67378800)
print v(xbgr.mr_n67379120)
print v(xbgr.mr_n67379232)
print v(xbgr.mr_n67379552)
print v(xbgr.mr_n67379664)
print v(xbgr.mr_n67379984)
print v(xbgr.mr_n67380096)
print v(xbgr.mr_n67380416)
print v(xbgr.mr_n67380528)
print v(xbgr.mr_n67380848)
print v(xbgr.mr_n67380960)
print v(xbgr.mr_n67381280)
print v(xbgr.mr_n67381392)
print v(xbgr.mr_n67381712)
print v(xbgr.mr_n67381824)
print v(xbgr.mr_n67382144)
print v(xbgr.mr_n67382256)
print v(xbgr.mr_n67382576)
print v(xbgr.mr_n67382688)
print v(xbgr.mr_n67383008)
print v(xbgr.mr_n67383120)
print v(xbgr.mr_n67383440)
print v(xbgr.mr_n67383552)
print v(xbgr.mr_n67383872)
print v(xbgr.mr_n67383984)
print v(xbgr.mr_n67384304)
print v(xbgr.mr_n67384416)
print v(xbgr.mr_n67384736)
print v(xbgr.mr_n67384848)
print v(xbgr.mr_n67385168)
print v(xbgr.mr_n67385280)
print v(xbgr.mr_n67385600)
print v(xbgr.mr_n67385712)
print v(xbgr.mr_n67386032)
print v(xbgr.mr_n67386144)
print v(xbgr.mr_n67386464)
print v(xbgr.mr_n67386576)
print v(xbgr.mr_n67386896)
print v(xbgr.mr_n67387008)
print v(xbgr.mr_n67387328)
print v(xbgr.mr_n67387440)
print v(xbgr.mr_n67387760)
print v(xbgr.mr_n67387872)
print v(xbgr.mr_n67388192)
print v(xbgr.mr_n67388304)
print v(xbgr.mr_n67388624)
print v(xbgr.mr_n67388736)
print v(xbgr.mr_n67389056)
print v(xbgr.mr_n67389168)
print v(xbgr.mr_n67389488)
print v(xbgr.mr_n67389600)
print v(xbgr.mr_n67389920)
print v(xbgr.mr_n67390032)
print v(xbgr.mr_n67390352)
print v(xbgr.mr_n67390464)
print v(xbgr.mr_n67390784)
print v(xbgr.mr_n67390896)
print v(xbgr.mr_n67391216)
print v(xbgr.mr_n67391328)
print v(xbgr.mr_n67391648)
print v(xbgr.mr_n67391760)
print v(xbgr.mr_n67392080)
print v(xbgr.mr_n67392192)
print v(xbgr.mr_n67392512)
print v(xbgr.mr_n67392624)
print v(xbgr.mr_n67392944)
print v(xbgr.mr_n67393056)
print v(xbgr.mr_n67393376)
print v(xbgr.mr_n67393488)
print v(xbgr.mr_n67393808)
print v(xbgr.mr_n67393920)
print v(xbgr.mr_n67394240)
print v(xbgr.mr_n67394352)
print v(xbgr.mr_n67394672)
print v(xbgr.mr_n67394784)
print v(xbgr.mr_n67395104)
print v(xbgr.mr_n67395216)
print v(xbgr.mr_n67395536)
print v(xbgr.mr_n67395648)
print v(xbgr.mr_n67395968)
print v(xbgr.mr_n67396080)
print v(xbgr.mr_n67396400)
print v(xbgr.mr_n67396512)
print v(xbgr.mr_n67396832)
print v(xbgr.mr_n67396944)
print v(xbgr.mr_n67397264)
print v(xbgr.mr_n67397376)
print v(xbgr.mr_n67397696)
print v(xbgr.mr_n67397808)
print v(xbgr.mr_n67398128)
print v(xbgr.mr_n67398240)
print v(xbgr.mr_n67398560)
print v(xbgr.mr_n67398672)
print v(xbgr.mr_n67398992)
print v(xbgr.mr_n67399104)
print v(xbgr.mr_n67399424)
print v(xbgr.mr_n67399536)
print v(xbgr.mr_n67399856)
print v(xbgr.mr_n67399968)
print v(xbgr.mr_n67400288)
print v(xbgr.mr_n67400400)
print v(xbgr.mr_n67400720)
print v(xbgr.mr_n67400832)
print v(xbgr.mr_n67401152)
print v(xbgr.mr_n67401264)
print v(xbgr.mr_n67401584)
print v(xbgr.mr_n67401696)
print v(xbgr.mr_n67402128)
print v(xbgr.mr_n67402448)
print v(xbgr.mr_n67402560)
print v(xbgr.mr_n67402992)
print v(xbgr.mr_n67403312)
print v(xbgr.mr_n67403424)
print v(xbgr.mr_n67403856)
print v(xbgr.mr_n67404176)
print v(xbgr.mr_n67405040)
print v(xbgr.mr_n67405904)
print v(xbgr.mr_n67406016)
print v(xbgr.mr_n67406336)
print v(xbgr.mr_n67406448)
print v(xbgr.mr_n67406768)
print v(xbgr.mr_n67406880)
print v(xbgr.mr_n67407200)
print v(xbgr.mr_n67407312)
print v(xbgr.mr_n67407632)
print v(xbgr.mr_n67407744)
print v(xbgr.mr_n67408064)
print v(xbgr.mr_n67408176)
print v(xbgr.mr_n67408496)
print v(xbgr.mr_n67409360)
print v(xbgr.mr_n67410224)
print v(xbgr.mr_n67411088)
print v(xbgr.mr_n67411200)
print v(xbgr.mr_n67411520)
print v(xbgr.mr_n67411632)
print v(xbgr.mr_n67411952)
print v(xbgr.mr_n67412064)
print v(xbgr.mr_n67412384)
print v(xbgr.mr_n67412496)
print v(xbgr.mr_n67412816)
print v(xbgr.mr_n67413680)
print v(xbgr.mr_n67414544)
print v(xbgr.mr_n67414656)
print v(xbgr.mr_n67414976)
print v(xbgr.mr_n67415088)
print v(xbgr.mr_n67415408)
print v(xbgr.mr_n67415520)
print v(xbgr.mr_n67415840)
print v(xbgr.mr_n67415952)
print v(xbgr.mr_n67416272)
print v(xbgr.mr_n67416384)
print v(xbgr.mr_n67416704)
print v(xbgr.mr_n67416816)
print v(xbgr.mr_n67417136)
print v(xbgr.mr_n67418000)
print v(xbgr.mr_n67418112)
print v(xbgr.mr_n67418544)
print v(xbgr.mr_n67418864)
print v(xbgr.mr_n67418976)
print v(xbgr.mr_n67419408)
print v(xbgr.mr_n67419728)
print v(xbgr.mr_n67419840)
print v(xbgr.mr_n67420272)
print v(xbgr.mr_n67420592)
print v(xbgr.mr_n67421456)
print v(xbgr.mr_n67422320)
print v(xbgr.mr_n67423184)
print v(xbgr.mr_n67424048)
print v(xbgr.mr_n67424912)
print v(xbgr.mr_n67425776)
print v(xbgr.mr_n67425888)
print v(xbgr.mr_n67426208)
print v(xbgr.mr_n67426320)
print v(xbgr.mr_n67426640)
print v(xbgr.mr_n67426752)
print v(xbgr.mr_n67427072)
print v(xbgr.mr_n67427184)
print v(xbgr.mr_n67427504)
print v(xbgr.mr_n67428368)
print v(xbgr.mr_n67429232)
print v(xbgr.mr_n67430096)
print v(xbgr.mr_n67430960)
print v(xbgr.mr_n67431072)
print v(xbgr.mr_n67431504)
print v(xbgr.mr_n67431824)
print v(xbgr.mr_n67431936)
print v(xbgr.mr_n67432368)
print v(xbgr.mr_n67432688)
print v(xbgr.mr_n67432800)
print v(xbgr.mr_n67433232)
print v(xbgr.mr_n67433552)
print v(xbgr.mr_n67434416)
print v(xbgr.mr_n67435280)
print v(xbgr.mr_n67436144)
print v(xbgr.mr_n67437008)
print v(xbgr.mr_n67437872)
print v(xbgr.mr_n67438736)
print v(xbgr.mr_n67438848)
print v(xbgr.mr_n67439168)
print v(xbgr.mr_n67439280)
print v(xbgr.mr_n67439600)
print v(xbgr.mr_n67439712)
print v(xbgr.mr_n67440032)
print v(xbgr.mr_n67440144)
print v(xbgr.mr_n67440464)
print v(xbgr.mr_n67441328)
print v(xbgr.mr_n67442192)
print v(xbgr.mr_n67443056)
print v(xbgr.mr_n67443168)
print v(xbgr.mr_n67443488)
print v(xbgr.mr_n67443600)
print v(xbgr.mr_n67443920)
print v(xbgr.mr_n67444032)
print v(xbgr.mr_n67444464)
print v(xbgr.mr_n67444896)
print v(xbgr.mr_n67445328)
print v(xbgr.mr_n67445648)
print v(xbgr.mr_n67445760)
print v(xbgr.mr_n67446080)
print v(xbgr.mr_n67446192)
print v(xbgr.mr_n67446512)
print v(xbgr.mr_n67446624)
print v(xbgr.mr_n67446944)
print v(xbgr.mr_n67447056)
print v(xbgr.mr_n67447376)
print v(xbgr.mr_n67447488)
print v(xbgr.mr_n67447808)
print v(xbgr.mr_n67447920)
print v(xbgr.mr_n67448240)
print v(xbgr.mr_n67448352)
print v(xbgr.mr_n67448784)
print v(xbgr.mr_n67449104)
print v(xbgr.mr_n67449536)
print v(xbgr.mr_n67449648)
print v(xbgr.mr_n67449968)
print v(xbgr.mr_n67450080)
print v(xbgr.mr_n67450400)
print v(xbgr.mr_n67450512)
print v(xbgr.mr_n67450832)
print v(xbgr.mr_n67450944)
print v(xbgr.mr_n67451264)
print v(xbgr.mr_n67451376)
print v(xbgr.mr_n67451696)
print v(xbgr.mr_n67451808)
print v(xbgr.mr_n67452128)
print v(xbgr.mr_n67452240)
print v(xbgr.mr_n67452672)
print v(xbgr.mr_n67452992)
print v(xbgr.mr_n67453104)
print v(xbgr.mr_n67453536)
print v(xbgr.mr_n67453856)
print v(xbgr.mr_n67453968)
print v(xbgr.mr_n67454288)
print v(xbgr.mr_n67454400)
print v(xbgr.mr_n67454720)
print v(xbgr.mr_n67454832)
print v(xbgr.mr_n67455264)
print v(xbgr.mr_n67455696)
print v(xbgr.mr_n67456016)
print v(xbgr.mr_n67456128)
print v(xbgr.mr_n67456448)
print v(xbgr.mr_n67456560)
print v(xbgr.mr_n67456880)
print v(xbgr.mr_n67456992)
print v(xbgr.mr_n67457312)
print v(xbgr.mr_n67457424)
print v(xbgr.mr_n67457744)
print v(xbgr.mr_n67457856)
print v(xbgr.mr_n67458176)
print v(xbgr.mr_n67458288)
print v(xbgr.mr_n67458608)
print v(xbgr.mr_n67458720)
print v(xbgr.mr_n67459040)
print v(xbgr.mr_n67459152)
print v(xbgr.mr_n67459472)
print v(xbgr.mr_n67459584)
print v(xbgr.mr_n67459904)
print v(xbgr.mr_n67460016)
print v(xbgr.mr_n67460336)
print v(xbgr.mr_n67460448)
print v(xbgr.mr_n67460768)
print v(xbgr.mr_n67461632)
print v(xbgr.mr_n67462496)
print v(xbgr.mr_n67462608)
print v(xbgr.mr_n67463040)
print v(xbgr.mr_n67463360)
print v(xbgr.mr_n67463472)
print v(xbgr.mr_n67464224)
print v(xbgr.mr_n67464656)
print v(xbgr.mr_n67464768)
print v(xbgr.mr_n67465088)
print v(xbgr.mr_n67465200)
print v(xbgr.mr_n67465520)
print v(xbgr.mr_n67465632)
print v(xbgr.mr_n67465952)
print v(xbgr.mr_n67466064)
print v(xbgr.mr_n67466384)
print v(xbgr.mr_n67467248)
print v(xbgr.mr_n67467680)
print v(xbgr.mr_n67467792)
print v(xbgr.mr_n67468112)
print v(xbgr.mr_n67468224)
print v(xbgr.mr_n67468544)
print v(xbgr.mr_n67469408)
print v(xbgr.mr_n67470704)
print v(xbgr.mr_n67471568)
print v(xbgr.mr_n67472432)
print v(xbgr.mr_n67472544)
print v(xbgr.mr_n67473296)
print v(xbgr.mr_n67473408)
print v(xbgr.mr_n67473840)
print v(xbgr.mr_n67474272)
print v(xbgr.mr_n67475024)
print v(xbgr.mr_n67475888)
print v(xbgr.mr_n67476752)
print v(xbgr.mr_n67476864)
print v(xbgr.mr_n67477184)
print v(xbgr.mr_n67477296)
print v(xbgr.mr_n67477728)
print v(xbgr.mr_n67478048)
print v(xbgr.mr_n67478160)
print v(xbgr.mr_n67478592)
print v(xbgr.mr_n67478912)
print v(xbgr.mr_n67479024)
print v(xbgr.mr_n67479344)
print v(xbgr.mr_n67479456)
print v(xbgr.mr_n67479776)
print v(xbgr.mr_n67480640)
print v(xbgr.mr_n67480752)
print v(xbgr.mr_n67481184)
print v(xbgr.mr_n67481504)
print v(xbgr.mr_n67482480)
print v(xbgr.mr_n67482800)
print v(xbgr.mr_n67482912)
print v(xbgr.mr_n67483344)
print v(xbgr.mr_n67483664)
print v(xbgr.mr_n67484096)
print v(xbgr.mr_n67484208)
print v(xbgr.mr_n67484528)
print v(xbgr.mr_n67484640)
print v(xbgr.mr_n67484960)
print v(xbgr.mr_n67485392)
print v(xbgr.mr_n67485504)
print v(xbgr.mr_n67485824)
print v(xbgr.mr_n67485936)
print v(xbgr.mr_n67486256)
print v(xbgr.mr_n67486368)
print v(xbgr.mr_n67486688)
print v(xbgr.mr_n67486800)
print v(xbgr.mr_n67487120)
print v(xbgr.mr_n67487232)
print v(xbgr.mr_n67487664)
print v(xbgr.mr_n67487984)
print v(xbgr.mr_n67488096)
print v(xbgr.mr_n67488416)
print v(xbgr.mr_n67488528)
print v(xbgr.mr_n67488848)
print v(xbgr.mr_n67489392)
print v(xbgr.mr_n67490144)
print v(xbgr.mr_n67491440)
print v(xbgr.mr_n67491552)
print v(xbgr.mr_n67491872)
print v(xbgr.mr_n67491984)
print v(xbgr.mr_n67492304)
print v(xbgr.mr_n67493168)
print v(xbgr.mr_n67494032)
print v(xbgr.mr_n67494896)
print v(xbgr.mr_n67495008)
print v(xbgr.mr_n67495328)
print v(xbgr.mr_n67495440)
print v(xbgr.mr_n67495760)
print v(xbgr.mr_n67495872)
print v(xbgr.mr_n67496192)
print v(xbgr.mr_n67496304)
print v(xbgr.mr_n67496624)
print v(xbgr.mr_n67496736)
print v(xbgr.mr_n67497056)
print v(xbgr.mr_n67497920)
print v(xbgr.mr_n67498784)
print v(xbgr.mr_n67499648)
print v(xbgr.mr_n67499760)
print v(xbgr.mr_n67500080)
print v(xbgr.mr_n67500192)
print v(xbgr.mr_n67500512)
print v(xbgr.mr_n67500624)
print v(xbgr.mr_n67500944)
print v(xbgr.mr_n67501056)
print v(xbgr.mr_n67501488)
print v(xbgr.mr_n67501808)
print v(xbgr.mr_n67501920)
print v(xbgr.mr_n67502240)
print v(xbgr.mr_n67502352)
print v(xbgr.mr_n67502672)
print v(xbgr.mr_n67502784)
print v(xbgr.mr_n67503104)
print v(xbgr.mr_n67503216)
print v(xbgr.mr_n67503968)
print v(xbgr.mr_n67504512)
print v(xbgr.mr_n67504944)
print v(xbgr.mr_n67505376)
print v(xbgr.mr_n67505808)
print v(xbgr.mr_n67506128)
print v(xbgr.mr_n67506240)
print v(xbgr.mr_n67506992)
print v(xbgr.mr_n67507856)
print v(xbgr.mr_n67508720)
print v(xbgr.mr_n67509584)
print v(xbgr.mr_n67510448)
print v(xbgr.mr_n67511312)
print v(xbgr.mr_n67512176)
print v(xbgr.mr_n67512288)
print v(xbgr.mr_n67512608)
print v(xbgr.mr_n67512720)
print v(xbgr.mr_n67513152)
print v(xbgr.mr_n67513472)
print v(xbgr.mr_n67513584)
print v(xbgr.mr_n67514016)
print v(xbgr.mr_n67514336)
print v(xbgr.mr_n67514448)
print v(xbgr.mr_n67514768)
print v(xbgr.mr_n67514880)
print v(xbgr.mr_n67515200)
print v(xbgr.mr_n67515312)
print v(xbgr.mr_n67515632)
print v(xbgr.mr_n67515744)
print v(xbgr.mr_n67516064)
print v(xbgr.mr_n67516176)
print v(xbgr.mr_n67516496)
print v(xbgr.mr_n67516608)
print v(xbgr.mr_n67516928)
print v(xbgr.mr_n67517792)
print v(xbgr.mr_n67518224)
print v(xbgr.mr_n67519200)
print v(xbgr.mr_n67519632)
print v(xbgr.mr_n67520064)
print v(xbgr.mr_n67520496)
print v(xbgr.mr_n67520816)
print v(xbgr.mr_n67521680)
print v(xbgr.mr_n67522544)
print v(xbgr.mr_n67523408)
print v(xbgr.mr_n67524272)
print v(xbgr.mr_n67525136)
print v(xbgr.mr_n67526000)
print v(xbgr.mr_n67527296)
print v(xbgr.mr_n67527728)
print v(xbgr.mr_n67529024)
print v(xbgr.mr_n67529136)
print v(xbgr.mr_n67529456)
print v(xbgr.mr_n67529568)
print v(xbgr.mr_n67529888)
print v(xbgr.mr_n67530000)
print v(xbgr.mr_n67530432)
print v(xbgr.mr_n67530864)
print v(xbgr.mr_n67531184)
print v(xbgr.mr_n67531296)
print v(xbgr.mr_n67531616)
print v(xbgr.mr_n67531728)
print v(xbgr.mr_n67532048)
print v(xbgr.mr_n67532160)
print v(xbgr.mr_n67532480)
print v(xbgr.mr_n67532592)
print v(xbgr.mr_n67533024)
print v(xbgr.mr_n67533344)
print v(xbgr.mr_n67534208)
print v(xbgr.mr_n67534320)
print v(xbgr.mr_n67534640)
print v(xbgr.mr_n67534752)
print v(xbgr.mr_n67535072)
print v(xbgr.mr_n67535184)
print v(xbgr.mr_n67535504)
print v(xbgr.mr_n67535616)
print v(xbgr.mr_n67535936)
print v(xbgr.mr_n67536800)
print v(xbgr.mr_n67537232)
print v(xbgr.mr_n67538528)
print v(xbgr.mr_n67538640)
print v(xbgr.mr_n67538960)
print v(xbgr.mr_n67539072)
print v(xbgr.mr_n67539392)
print v(xbgr.mr_n67539504)
print v(xbgr.mr_n67539824)
print v(xbgr.mr_n67540688)
print v(xbgr.mr_n67540800)
print v(xbgr.mr_n67541232)
print v(xbgr.mr_n67541552)
print v(xbgr.mr_n67541664)
print v(xbgr.mr_n67541984)
print v(xbgr.mr_n67542096)
print v(xbgr.mr_n67542416)
print v(xbgr.mr_n67542528)
print v(xbgr.mr_n67542848)
print v(xbgr.mr_n67542960)
print v(xbgr.mr_n67543392)
print v(xbgr.mr_n67543712)
print v(xbgr.mr_n67544576)
print v(xbgr.mr_n67544688)
print v(xbgr.mr_n67545008)
print v(xbgr.mr_n67545872)
print v(xbgr.mr_n67545984)
print v(xbgr.mr_n67546304)
print v(xbgr.mr_n67546416)
print v(xbgr.mr_n67546736)
print v(xbgr.mr_n67547280)
print v(xbgr.mr_n67547712)
print v(xbgr.mr_n67548032)
print v(xbgr.mr_n67548464)
print v(xbgr.mr_n67548576)
print v(xbgr.mr_n67548896)
print v(xbgr.mr_n67549008)
print v(xbgr.mr_n67549328)
print v(xbgr.mr_n67549440)
print v(xbgr.mr_n67549760)
print v(xbgr.mr_n67549872)
print v(xbgr.mr_n67550192)
print v(xbgr.mr_n67550304)
print v(xbgr.mr_n67551056)
print v(xbgr.mr_n67551168)
print v(xbgr.mr_n67551488)
print v(xbgr.mr_n67551600)
print v(xbgr.mr_n67551920)
print v(xbgr.mr_n67553216)
print v(xbgr.mr_n67553328)
print v(xbgr.mr_n67553648)
print v(xbgr.mr_n67553760)
print v(xbgr.mr_n67554080)
print v(xbgr.mr_n67555056)
print v(xbgr.mr_n67555376)
print v(xbgr.mr_n67556240)
print v(xbgr.mr_n67556672)
print v(xbgr.mr_n67556784)
print v(xbgr.mr_n67557104)
print v(xbgr.mr_n67557216)
print v(xbgr.mr_n67557536)
print v(xbgr.mr_n67557648)
print v(xbgr.mr_n67557968)
print v(xbgr.mr_n67558832)
print v(xbgr.mr_n67560128)
print v(xbgr.mr_n67560992)
print v(xbgr.mr_n67561968)
print v(xbgr.mr_n67562288)
print v(xbgr.mr_n67562400)
print v(xbgr.mr_n67562832)
print v(xbgr.mr_n67563152)
print v(xbgr.mr_n67563264)
print v(xbgr.mr_n67563584)
print v(xbgr.mr_n67563696)
print v(xbgr.mr_n67564016)
print v(xbgr.mr_n67564128)
print v(xbgr.mr_n67564448)
print v(xbgr.mr_n67564560)
print v(xbgr.mr_n67564880)
print v(xbgr.mr_n67564992)
print v(xbgr.mr_n67565312)
print v(xbgr.mr_n67565424)
print v(xbgr.mr_n67565744)
print v(xbgr.mr_n67565856)
print v(xbgr.mr_n67566176)
print v(xbgr.mr_n67566288)
print v(xbgr.mr_n67566720)
print v(xbgr.mr_n67567040)
print v(xbgr.mr_n67567152)
print v(xbgr.mr_n67567584)
print v(xbgr.mr_n67567904)
print v(xbgr.mr_n67568768)
print v(xbgr.mr_n67569632)
print v(xbgr.mr_n67570496)
print v(xbgr.mr_n67570608)
print v(xbgr.mr_n67570928)
print v(xbgr.mr_n67571040)
print v(xbgr.mr_n67571360)
print v(xbgr.mr_n67571472)
print v(xbgr.mr_n67571792)
print v(xbgr.mr_n67571904)
print v(xbgr.mr_n67572336)
print v(xbgr.mr_n67572768)
print v(xbgr.mr_n67573200)
print v(xbgr.mr_n67573632)
print v(xbgr.mr_n67573952)
print v(xbgr.mr_n67574064)
print v(xbgr.mr_n67574384)
print v(xbgr.mr_n67574496)
print v(xbgr.mr_n67574816)
print v(xbgr.mr_n67574928)
print v(xbgr.mr_n67575248)
print v(xbgr.mr_n67575360)
print v(xbgr.mr_n67575680)
print v(xbgr.mr_n67575792)
print v(xbgr.mr_n67576112)
print v(xbgr.mr_n67576224)
print v(xbgr.mr_n67576544)
print v(xbgr.mr_n67576656)
print v(xbgr.mr_n67577088)
print v(xbgr.mr_n67577408)
print v(xbgr.mr_n67577520)
print v(xbgr.mr_n67577840)
print v(xbgr.mr_n67578704)
print v(xbgr.mr_n67579440)
print v(xbgr.mr_n67580304)
print v(xbgr.mr_n67581168)
print v(xbgr.mr_n67582032)
print v(xbgr.mr_n67582896)
print v(xbgr.mr_n67583008)
print v(xbgr.mr_n67583440)
print v(xbgr.mr_n67583760)
print v(xbgr.mr_n67583872)
print v(xbgr.mr_n67584304)
print v(xbgr.mr_n67584624)
print v(xbgr.mr_n67584736)
print v(xbgr.mr_n67585056)
print v(xbgr.mr_n67585168)
print v(xbgr.mr_n67585488)
print v(xbgr.mr_n67585600)
print v(xbgr.mr_n67586032)
print v(xbgr.mr_n67586352)
print v(xbgr.mr_n67587216)
print v(xbgr.mr_n67587328)
print v(xbgr.mr_n67587648)
print v(xbgr.mr_n67587760)
print v(xbgr.mr_n67588080)
print v(xbgr.mr_n67588192)
print v(xbgr.mr_n67588512)
print v(xbgr.mr_n67588624)
print v(xbgr.mr_n67588944)
print v(xbgr.mr_n67589056)
print v(xbgr.mr_n67589376)
print v(xbgr.mr_n67589488)
print v(xbgr.mr_n67589808)
print v(xbgr.mr_n67589920)
print v(xbgr.mr_n67590240)
print v(xbgr.mr_n67590672)
print v(xbgr.mr_n67590784)
print v(xbgr.mr_n67591104)
print v(xbgr.mr_n67591216)
print v(xbgr.mr_n67591536)
print v(xbgr.mr_n67591648)
print v(xbgr.mr_n67591968)
print v(xbgr.mr_n67592080)
print v(xbgr.mr_n67592400)
print v(xbgr.mr_n67593696)
print v(xbgr.mr_n67594560)
print v(xbgr.mr_n67595104)
print v(xbgr.mr_n67595536)
print v(xbgr.mr_n67595856)
print v(xbgr.mr_n67595968)
print v(xbgr.mr_n67596288)
print v(xbgr.mr_n67596400)
print v(xbgr.mr_n67596720)
print v(xbgr.mr_n67596832)
print v(xbgr.mr_n67597152)
print v(xbgr.mr_n67597264)
print v(xbgr.mr_n67597584)
print v(xbgr.mr_n67597696)
print v(xbgr.mr_n67598016)
print v(xbgr.mr_n67598128)
print v(xbgr.mr_n67598448)
print v(xbgr.mr_n67598560)
print v(xbgr.mr_n67598880)
print v(xbgr.mr_n67598992)
print v(xbgr.mr_n67599312)
print v(xbgr.mr_n67599424)
print v(xbgr.mr_n67599744)
print v(xbgr.mr_n67600608)
print v(xbgr.mr_n67601472)
print v(xbgr.mr_n67601584)
print v(xbgr.mr_n67602016)
print v(xbgr.mr_n67602768)
print v(xbgr.mr_n67603632)
print v(xbgr.mr_n67604496)
print v(xbgr.mr_n67605472)
print v(xbgr.mr_n67605904)
print v(xbgr.mr_n67606224)
print v(xbgr.mr_n67606336)
print v(xbgr.mr_n67606656)
print v(xbgr.mr_n67606768)
print v(xbgr.mr_n67607088)
print v(xbgr.mr_n67607952)
print v(xbgr.mr_n67608816)
print v(xbgr.mr_n67608928)
print v(xbgr.mr_n67609248)
print v(xbgr.mr_n67609360)
print v(xbgr.mr_n67609680)
print v(xbgr.mr_n67609792)
print v(xbgr.mr_n67610112)
print v(xbgr.mr_n67610224)
print v(xbgr.mr_n67610544)
print v(xbgr.mr_n67610656)
print v(xbgr.mr_n67610976)
print v(xbgr.mr_n67611088)
print v(xbgr.mr_n67611408)
print v(xbgr.mr_n67611520)
print v(xbgr.mr_n67611840)
print v(xbgr.mr_n67611952)
print v(xbgr.mr_n67612272)
print v(xbgr.mr_n67612384)
print v(xbgr.mr_n67612816)
print v(xbgr.mr_n67613136)
print v(xbgr.mr_n67613568)
print v(xbgr.mr_n67613680)
print v(xbgr.mr_n67614432)
print v(xbgr.mr_n67614544)
print v(xbgr.mr_n67614976)
print v(xbgr.mr_n67615728)
print v(xbgr.mr_n67615840)
print v(xbgr.mr_n67616160)
print v(xbgr.mr_n67616272)
print v(xbgr.mr_n67616704)
print v(xbgr.mr_n67617136)
print v(xbgr.mr_n67617568)
print v(xbgr.mr_n67617888)
print v(xbgr.mr_n67618000)
print v(xbgr.mr_n67618320)
print v(xbgr.mr_n67618432)
print v(xbgr.mr_n67618864)
print v(xbgr.mr_n67619184)
print v(xbgr.mr_n67620048)
print v(xbgr.mr_n67620160)
print v(xbgr.mr_n67620480)
print v(xbgr.mr_n67620592)
print v(xbgr.mr_n67620912)
print v(xbgr.mr_n67621024)
print v(xbgr.mr_n67621344)
print v(xbgr.mr_n67621456)
print v(xbgr.mr_n67621776)
print v(xbgr.mr_n67621888)
print v(xbgr.mr_n67622208)
print v(xbgr.mr_n67622320)
print v(xbgr.mr_n67622640)
print v(xbgr.mr_n67623504)
print v(xbgr.mr_n67624368)
print v(xbgr.mr_n67624480)
print v(xbgr.mr_n67624800)
print v(xbgr.mr_n67624912)
print v(xbgr.mr_n67625232)
print v(xbgr.mr_n67625344)
print v(xbgr.mr_n67625664)
print v(xbgr.mr_n67625776)
print v(xbgr.mr_n67626096)
print v(xbgr.mr_n67626960)
print v(xbgr.mr_n67627824)
print v(xbgr.mr_n67628688)
print v(xbgr.mr_n67629552)
print v(xbgr.mr_n67630960)
print v(xbgr.mr_n67631280)
print v(xbgr.mr_n67632144)
print v(xbgr.mr_n67633008)
print v(xbgr.mr_n67633120)
print v(xbgr.mr_n67633552)
print v(xbgr.mr_n67633872)
print v(xbgr.mr_n67633984)
print v(xbgr.mr_n67634416)
print v(xbgr.mr_n67634736)
print v(xbgr.mr_n67635600)
print v(xbgr.mr_n67636464)
print v(xbgr.mr_n67637328)
print v(xbgr.mr_n67638192)
print v(xbgr.mr_n67638304)
print v(xbgr.mr_n67638624)
print v(xbgr.mr_n67638736)
print v(xbgr.mr_n67639056)
print v(xbgr.mr_n67639168)
print v(xbgr.mr_n67639488)
print v(xbgr.mr_n67639600)
print v(xbgr.mr_n67639920)
print v(xbgr.mr_n67640784)
print v(xbgr.mr_n67641648)
print v(xbgr.mr_n67641760)
print v(xbgr.mr_n67642080)
print v(xbgr.mr_n67642192)
print v(xbgr.mr_n67642624)
print v(xbgr.mr_n67643056)
print v(xbgr.mr_n67643376)
print v(xbgr.mr_n67643488)
print v(xbgr.mr_n67643808)
print v(xbgr.mr_n67643920)
print v(xbgr.mr_n67644240)
print v(xbgr.mr_n67644352)
print v(xbgr.mr_n67644672)
print v(xbgr.mr_n67644784)
print v(xbgr.mr_n67645104)
print v(xbgr.mr_n67645216)
print v(xbgr.mr_n67645648)
print v(xbgr.mr_n67645968)
print v(xbgr.mr_n67646080)
print v(xbgr.mr_n67646512)
print v(xbgr.mr_n67646832)
print v(xbgr.mr_n67647696)
print v(xbgr.mr_n67648560)
print v(xbgr.mr_n67649424)
print v(xbgr.mr_n67650288)
print v(xbgr.mr_n67650400)
print v(xbgr.mr_n67650720)
print v(xbgr.mr_n67650832)
print v(xbgr.mr_n67651152)
print v(xbgr.mr_n67651264)
print v(xbgr.mr_n67651584)
print v(xbgr.mr_n67651696)
print v(xbgr.mr_n67652016)
print v(xbgr.mr_n67652880)
print v(xbgr.mr_n67653744)
print v(xbgr.mr_n67653856)
print v(xbgr.mr_n67654176)
print v(xbgr.mr_n67654288)
print v(xbgr.mr_n67654720)
print v(xbgr.mr_n67655152)
print v(xbgr.mr_n67655472)
print v(xbgr.mr_n67655584)
print v(xbgr.mr_n67655904)
print v(xbgr.mr_n67656016)
print v(xbgr.mr_n67656336)
print v(xbgr.mr_n67656448)
print v(xbgr.mr_n67656768)
print v(xbgr.mr_n67656880)
print v(xbgr.mr_n67657200)
print v(xbgr.mr_n67657312)
print v(xbgr.mr_n67657744)
print v(xbgr.mr_n67658064)
print v(xbgr.mr_n67658176)
print v(xbgr.mr_n67658608)
print v(xbgr.mr_n67658928)
print v(xbgr.mr_n67659040)
print v(xbgr.mr_n67659472)
print v(xbgr.mr_n67659792)
print v(xbgr.mr_n67659904)
print v(xbgr.mr_n67660336)
print v(xbgr.mr_n67660656)
print v(xbgr.mr_n67661520)
print v(xbgr.mr_n67662384)
print v(xbgr.mr_n67663248)
print v(xbgr.mr_n67664112)
print v(xbgr.mr_n67664976)
print v(xbgr.mr_n67665840)
print v(xbgr.mr_n67665952)
print v(xbgr.mr_n67666272)
print v(xbgr.mr_n67666384)
print v(xbgr.mr_n67666704)
print v(xbgr.mr_n67666816)
print v(xbgr.mr_n67667136)
print v(xbgr.mr_n67667248)
print v(xbgr.mr_n67667568)
print v(xbgr.mr_n67667680)
print v(xbgr.mr_n67668000)
print v(xbgr.mr_n67668112)
print v(xbgr.mr_n67668432)
print v(xbgr.mr_n67668544)
print v(xbgr.mr_n67668864)
print v(xbgr.mr_n67668976)
print v(xbgr.mr_n67669296)
print v(xbgr.mr_n67669408)
print v(xbgr.mr_n67669728)
print v(xbgr.mr_n67669840)
print v(xbgr.mr_n67670272)
print v(xbgr.mr_n67670704)
print v(xbgr.mr_n67671024)
print v(xbgr.mr_n67671888)
print v(xbgr.mr_n67672752)
print v(xbgr.mr_n67672864)
print v(xbgr.mr_n67673184)
print v(xbgr.mr_n67673296)
print v(xbgr.mr_n67673616)
print v(xbgr.mr_n67673728)
print v(xbgr.mr_n67674048)
print v(xbgr.mr_n67674160)
print v(xbgr.mr_n67674480)
print v(xbgr.mr_n67674592)
print v(xbgr.mr_n67674912)
print v(xbgr.mr_n67675024)
print v(xbgr.mr_n67675344)
print v(xbgr.mr_n67675456)
print v(xbgr.mr_n67675776)
print v(xbgr.mr_n67675888)
print v(xbgr.mr_n67676320)
print v(xbgr.mr_n67676752)
print v(xbgr.mr_n67677072)
print v(xbgr.mr_n67677184)
print v(xbgr.mr_n67677504)
print v(xbgr.mr_n67677616)
print v(xbgr.mr_n67677936)
print v(xbgr.mr_n67678048)
print v(xbgr.mr_n67678368)
print v(xbgr.mr_n67678480)
print v(xbgr.mr_n67678800)
print v(xbgr.mr_n67678912)
print v(xbgr.mr_n67679232)
print v(xbgr.mr_n67679344)
print v(xbgr.mr_n67679664)
print v(xbgr.mr_n67680528)
print v(xbgr.mr_n67681392)
print v(xbgr.mr_n67682256)
print v(xbgr.mr_n67683120)
print v(xbgr.mr_n67683232)
print v(xbgr.mr_n67683664)
print v(xbgr.mr_n67683984)
print v(xbgr.mr_n67684096)
print v(xbgr.mr_n67684416)
print v(xbgr.mr_n67684528)
print v(xbgr.mr_n67684848)
print v(xbgr.mr_n67684960)
print v(xbgr.mr_n67685280)
print v(xbgr.mr_n67685392)
print v(xbgr.mr_n67685712)
print v(xbgr.mr_n67685824)
print v(xbgr.mr_n67686144)
print v(xbgr.mr_n67686256)
print v(xbgr.mr_n67686576)
print v(xbgr.mr_n67686688)
print v(xbgr.mr_n67687120)
print v(xbgr.mr_n67687440)
print v(xbgr.mr_n67688304)
print v(xbgr.mr_n67688416)
print v(xbgr.mr_n67688736)
print v(xbgr.mr_n67688848)
print v(xbgr.mr_n67689168)
print v(xbgr.mr_n67689280)
print v(xbgr.mr_n67689600)
print v(xbgr.mr_n67689712)
print v(xbgr.mr_n67690032)
print v(xbgr.mr_n67690144)
print v(xbgr.mr_n67690576)
print v(xbgr.mr_n67690896)
print v(xbgr.mr_n67691008)
print v(xbgr.mr_n67691440)
print v(xbgr.mr_n67691760)
print v(xbgr.mr_n67692624)
print v(xbgr.mr_n67693488)
print v(xbgr.mr_n67694352)
print v(xbgr.mr_n67695216)
print v(xbgr.mr_n67695328)
print v(xbgr.mr_n67695648)
print v(xbgr.mr_n67695760)
print v(xbgr.mr_n67696080)
print v(xbgr.mr_n67696192)
print v(xbgr.mr_n67696512)
print v(xbgr.mr_n67696624)
print v(xbgr.mr_n67696944)
print v(xbgr.mr_n67697056)
print v(xbgr.mr_n67697376)
print v(xbgr.mr_n67697488)
print v(xbgr.mr_n67697808)
print v(xbgr.mr_n67698672)
print v(xbgr.mr_n67699536)
print v(xbgr.mr_n67699648)
print v(xbgr.mr_n67699968)
print v(xbgr.mr_n67700080)
print v(xbgr.mr_n67700512)
print v(xbgr.mr_n67700944)
print v(xbgr.mr_n67701264)
print v(xbgr.mr_n67701376)
print v(xbgr.mr_n67701696)
print v(xbgr.mr_n67701808)
print v(xbgr.mr_n67702128)
print v(xbgr.mr_n67702240)
print v(xbgr.mr_n67702560)
print v(xbgr.mr_n67702672)
print v(xbgr.mr_n67702992)
print v(xbgr.mr_n67703856)
print v(xbgr.mr_n67704720)
print v(xbgr.mr_n67705584)
print v(xbgr.mr_n67706448)
print v(xbgr.mr_n67707312)
print v(xbgr.mr_n67707424)
print v(xbgr.mr_n67707744)
print v(xbgr.mr_n67707856)
print v(xbgr.mr_n67708176)
print v(xbgr.mr_n67708288)
print v(xbgr.mr_n67708608)
print v(xbgr.mr_n67708720)
print v(xbgr.mr_n67709040)
print v(xbgr.mr_n67709152)
print v(xbgr.mr_n67709584)
print v(xbgr.mr_n67709904)
print v(xbgr.mr_n67710016)
print v(xbgr.mr_n67710448)
print v(xbgr.mr_n67710768)
print v(xbgr.mr_n67710880)
print v(xbgr.mr_n67711312)
print v(xbgr.mr_n67711632)
print v(xbgr.mr_n67711744)
print v(xbgr.mr_n67712176)
print v(xbgr.mr_n67712496)
print v(xbgr.mr_n67713360)
print v(xbgr.mr_n67713472)
print v(xbgr.mr_n67713792)
print v(xbgr.mr_n67713904)
print v(xbgr.mr_n67714224)
print v(xbgr.mr_n67714336)
print v(xbgr.mr_n67714656)
print v(xbgr.mr_n67714768)
print v(xbgr.mr_n67715088)
print v(xbgr.mr_n67715952)
print v(xbgr.mr_n67716816)
print v(xbgr.mr_n67717680)
print v(xbgr.mr_n67718544)
print v(xbgr.mr_n67719408)
print v(xbgr.mr_n67719520)
print v(xbgr.mr_n67719840)
print v(xbgr.mr_n67719952)
print v(xbgr.mr_n67720272)
print v(xbgr.mr_n67720384)
print v(xbgr.mr_n67720704)
print v(xbgr.mr_n67720816)
print v(xbgr.mr_n67721248)
print v(xbgr.mr_n67721680)
print v(xbgr.mr_n67722000)
print v(xbgr.mr_n67722112)
print v(xbgr.mr_n67722432)
print v(xbgr.mr_n67722544)
print v(xbgr.mr_n67722864)
print v(xbgr.mr_n67723728)
print v(xbgr.mr_n67723840)
print v(xbgr.mr_n67724160)
print v(xbgr.mr_n67724272)
print v(xbgr.mr_n67724592)
print v(xbgr.mr_n67725456)
print v(xbgr.mr_n67726320)
print v(xbgr.mr_n67726432)
print v(xbgr.mr_n67726752)
print v(xbgr.mr_n67726864)
print v(xbgr.mr_n67727184)
print v(xbgr.mr_n67728048)
print v(xbgr.mr_n67728912)
print v(xbgr.mr_n67729776)
print v(xbgr.mr_n67729888)
print v(xbgr.mr_n67730208)
print v(xbgr.mr_n67730320)
print v(xbgr.mr_n67730640)
print v(xbgr.mr_n67730752)
print v(xbgr.mr_n67731072)
print v(xbgr.mr_n67731184)
print v(xbgr.mr_n67731504)
print v(xbgr.mr_n67731616)
print v(xbgr.mr_n67731936)
print v(xbgr.mr_n67732048)
print v(xbgr.mr_n67732368)
print v(xbgr.mr_n67732480)
print v(xbgr.mr_n67732800)
print v(xbgr.mr_n67732912)
print v(xbgr.mr_n67733232)
print v(xbgr.mr_n67733344)
print v(xbgr.mr_n67733664)
print v(xbgr.mr_n67733776)
print v(xbgr.mr_n67734096)
print v(xbgr.mr_n67734208)
print v(xbgr.mr_n67734528)
print v(xbgr.mr_n67734640)
print v(xbgr.mr_n67735072)
print v(xbgr.mr_n67735392)
print v(xbgr.mr_n67735504)
print v(xbgr.mr_n67735936)
print v(xbgr.mr_n67736256)
print v(xbgr.mr_n67736368)
print v(xbgr.mr_n67736800)
print v(xbgr.mr_n67737120)
print v(xbgr.mr_n67737984)
print v(xbgr.mr_n67738848)
print v(xbgr.mr_n67739712)
print v(xbgr.mr_n67739824)
print v(xbgr.mr_n67740144)
print v(xbgr.mr_n67740256)
print v(xbgr.mr_n67740576)
print v(xbgr.mr_n67741440)
print v(xbgr.mr_n67742304)
print v(xbgr.mr_n67743168)
print v(xbgr.mr_n67743280)
print v(xbgr.mr_n67743600)
print v(xbgr.mr_n67743712)
print v(xbgr.mr_n67744032)
print v(xbgr.mr_n67744144)
print v(xbgr.mr_n67744464)
print v(xbgr.mr_n67744576)
print v(xbgr.mr_n67744896)
print v(xbgr.mr_n67745008)
print v(xbgr.mr_n67745328)
print v(xbgr.mr_n67745440)
print v(xbgr.mr_n67745760)
print v(xbgr.mr_n67745872)
print v(xbgr.mr_n67746192)
print v(xbgr.mr_n67746304)
print v(xbgr.mr_n67746624)
print v(xbgr.mr_n67746736)
print v(xbgr.mr_n67747056)
print v(xbgr.mr_n67747168)
print v(xbgr.mr_n67747488)
print v(xbgr.mr_n67747600)
print v(xbgr.mr_n67747920)
print v(xbgr.mr_n67748032)
print v(xbgr.mr_n67748352)
print v(xbgr.mr_n67748464)
print v(xbgr.mr_n67748896)
print v(xbgr.mr_n67749216)
print v(xbgr.mr_n67750080)
print v(xbgr.mr_n67750944)
print v(xbgr.mr_n67751808)
print v(xbgr.mr_n67751920)
print v(xbgr.mr_n67752352)
print v(xbgr.mr_n67752672)
print v(xbgr.mr_n67752784)
print v(xbgr.mr_n67753216)
print v(xbgr.mr_n67753536)
print v(xbgr.mr_n67753648)
print v(xbgr.mr_n67753968)
print v(xbgr.mr_n67754080)
print v(xbgr.mr_n67754400)
print v(xbgr.mr_n67754512)
print v(xbgr.mr_n67754944)
print v(xbgr.mr_n67755376)
print v(xbgr.mr_n67755808)
print v(xbgr.mr_n67756128)
print v(xbgr.mr_n67756992)
print v(xbgr.mr_n67757856)
print v(xbgr.mr_n67758720)
print v(xbgr.mr_n67759584)
print v(xbgr.mr_n67760448)
print v(xbgr.mr_n67761312)
print v(xbgr.mr_n67761424)
print v(xbgr.mr_n67761744)
print v(xbgr.mr_n67761856)
print v(xbgr.mr_n67762176)
print v(xbgr.mr_n67762288)
print v(xbgr.mr_n67762608)
print v(xbgr.mr_n67762720)
print v(xbgr.mr_n67763040)
print v(xbgr.mr_n67763152)
print v(xbgr.mr_n67763472)
print v(xbgr.mr_n67763584)
print v(xbgr.mr_n67763904)
print v(xbgr.mr_n67764768)
print v(xbgr.mr_n67765632)
print v(xbgr.mr_n67766608)
print v(xbgr.mr_n67767040)
print v(xbgr.mr_n67767472)
print v(xbgr.mr_n67767792)
print v(xbgr.mr_n67767904)
print v(xbgr.mr_n67768224)
print v(xbgr.mr_n67768336)
print v(xbgr.mr_n67768656)
print v(xbgr.mr_n67768768)
print v(xbgr.mr_n67769200)
print v(xbgr.mr_n67769520)
print v(xbgr.mr_n67769632)
print v(xbgr.mr_n67769952)
print v(xbgr.mr_n67770064)
print v(xbgr.mr_n67770496)
print v(xbgr.mr_n67770816)
print v(xbgr.mr_n67770928)
print v(xbgr.mr_n67771360)
print v(xbgr.mr_n67771680)
print v(xbgr.mr_n67771792)
print v(xbgr.mr_n67772224)
print v(xbgr.mr_n67772544)
print v(xbgr.mr_n67773408)
print v(xbgr.mr_n67774272)
print v(xbgr.mr_n67774384)
print v(xbgr.mr_n67774704)
print v(xbgr.mr_n67774816)
print v(xbgr.mr_n67775136)
print v(xbgr.mr_n67775248)
print v(xbgr.mr_n67775568)
print v(xbgr.mr_n67775680)
print v(xbgr.mr_n67776112)
print v(xbgr.mr_n67776432)
print v(xbgr.mr_n67777296)
print v(xbgr.mr_n67777408)
print v(xbgr.mr_n67777728)
print v(xbgr.mr_n67777840)
print v(xbgr.mr_n67778160)
print v(xbgr.mr_n67778272)
print v(xbgr.mr_n67778592)
print v(xbgr.mr_n67779456)
print v(xbgr.mr_n67779888)
print v(xbgr.mr_n67780752)
print v(xbgr.mr_n67780864)
print v(xbgr.mr_n67781184)
print v(xbgr.mr_n67781296)
print v(xbgr.mr_n67781616)
print v(xbgr.mr_n67781728)
print v(xbgr.mr_n67782048)
print v(xbgr.mr_n67782160)
print v(xbgr.mr_n67782480)
print v(xbgr.mr_n67782592)
print v(xbgr.mr_n67783024)
print v(xbgr.mr_n67783776)
print v(xbgr.mr_n67784640)
print v(xbgr.mr_n67785072)
print v(xbgr.mr_n67785184)
print v(xbgr.mr_n67785504)
print v(xbgr.mr_n67785936)
print v(xbgr.mr_n67786800)
print v(xbgr.mr_n67787664)
print v(xbgr.mr_n67788528)
print v(xbgr.mr_n67789392)
print v(xbgr.mr_n67790688)
print v(xbgr.mr_n67791552)
print v(xbgr.mr_n67792528)
print v(xbgr.mr_n67792848)
print v(xbgr.mr_n67792960)
print v(xbgr.mr_n67793392)
print v(xbgr.mr_n67793712)
print v(xbgr.mr_n67794576)
print v(xbgr.mr_n67794688)
print v(xbgr.mr_n67795008)
print v(xbgr.mr_n67795120)
print v(xbgr.mr_n67795552)
print v(xbgr.mr_n67795872)
print v(xbgr.mr_n67795984)
print v(xbgr.mr_n67796304)
print v(xbgr.mr_n67796416)
print v(xbgr.mr_n67796736)
print v(xbgr.mr_n67796848)
print v(xbgr.mr_n67797168)
print v(xbgr.mr_n67797280)
print v(xbgr.mr_n67797712)
print v(xbgr.mr_n67798032)
print v(xbgr.mr_n67798144)
print v(xbgr.mr_n67798464)
print v(xbgr.mr_n67798576)
print v(xbgr.mr_n67798896)
print v(xbgr.mr_n67799760)
print v(xbgr.mr_n67799872)
print v(xbgr.mr_n67800624)
print v(xbgr.mr_n67800736)
print v(xbgr.mr_n67801056)
print v(xbgr.mr_n67801168)
print v(xbgr.mr_n67801488)
print v(xbgr.mr_n67801600)
print v(xbgr.mr_n67801920)
print v(xbgr.mr_n67802032)
print v(xbgr.mr_n67802352)
print v(xbgr.mr_n67802464)
print v(xbgr.mr_n67802784)
print v(xbgr.mr_n67802896)
print v(xbgr.mr_n67803216)
print v(xbgr.mr_n67803328)
print v(xbgr.mr_n67803648)
print v(xbgr.mr_n67803760)
print v(xbgr.mr_n67804080)
print v(xbgr.mr_n67804192)
print v(xbgr.mr_n67804512)
print v(xbgr.mr_n67804624)
print v(xbgr.mr_n67804944)
print v(xbgr.mr_n67805056)
print v(xbgr.mr_n67805376)
print v(xbgr.mr_n67805488)
print v(xbgr.mr_n67805808)
print v(xbgr.mr_n67805920)
print v(xbgr.mr_n67806352)
print v(xbgr.mr_n67806672)
print v(xbgr.mr_n67806784)
print v(xbgr.mr_n67807216)
print v(xbgr.mr_n67807536)
print v(xbgr.mr_n67807648)
print v(xbgr.mr_n67808080)
print v(xbgr.mr_n67808400)
print v(xbgr.mr_n67809264)
print v(xbgr.mr_n67810128)
print v(xbgr.mr_n67810992)
print v(xbgr.mr_n67811856)
print v(xbgr.mr_n67812720)
print v(xbgr.mr_n67813584)
print v(xbgr.mr_n67813696)
print v(xbgr.mr_n67814016)
print v(xbgr.mr_n67814128)
print v(xbgr.mr_n67814448)
print v(xbgr.mr_n67814560)
print v(xbgr.mr_n67814880)
print v(xbgr.mr_n67814992)
print v(xbgr.mr_n67815312)
print v(xbgr.mr_n67816176)
print v(xbgr.mr_n67817040)
print v(xbgr.mr_n67817904)
print v(xbgr.mr_n67818016)
print v(xbgr.mr_n67818336)
print v(xbgr.mr_n67818448)
print v(xbgr.mr_n67818768)
print v(xbgr.mr_n67818880)
print v(xbgr.mr_n67819312)
print v(xbgr.mr_n67819744)
print v(xbgr.mr_n67820176)
print v(xbgr.mr_n67820496)
print v(xbgr.mr_n67820608)
print v(xbgr.mr_n67820928)
print v(xbgr.mr_n67821040)
print v(xbgr.mr_n67821360)
print v(xbgr.mr_n67821472)
print v(xbgr.mr_n67821792)
print v(xbgr.mr_n67821904)
print v(xbgr.mr_n67822224)
print v(xbgr.mr_n67822336)
print v(xbgr.mr_n67822656)
print v(xbgr.mr_n67822768)
print v(xbgr.mr_n67823088)
print v(xbgr.mr_n67823200)
print v(xbgr.mr_n67823632)
print v(xbgr.mr_n67823952)
print v(xbgr.mr_n67824064)
print v(xbgr.mr_n67824496)
print v(xbgr.mr_n67824816)
print v(xbgr.mr_n67824928)
print v(xbgr.mr_n67825360)
print v(xbgr.mr_n67825680)
print v(xbgr.mr_n67826544)
print v(xbgr.mr_n67827408)
print v(xbgr.mr_n67828272)
print v(xbgr.mr_n67829136)
print v(xbgr.mr_n67830000)
print v(xbgr.mr_n67830864)
print v(xbgr.mr_n67830976)
print v(xbgr.mr_n67831296)
print v(xbgr.mr_n67831408)
print v(xbgr.mr_n67831728)
print v(xbgr.mr_n67831840)
print v(xbgr.mr_n67832160)
print v(xbgr.mr_n67832272)
print v(xbgr.mr_n67832592)
print v(xbgr.mr_n67833456)
print v(xbgr.mr_n67834320)
print v(xbgr.mr_n67835184)
print v(xbgr.mr_n67835296)
print v(xbgr.mr_n67835616)
print v(xbgr.mr_n67835728)
print v(xbgr.mr_n67836048)
print v(xbgr.mr_n67836160)
print v(xbgr.mr_n67836592)
print v(xbgr.mr_n67836912)
print v(xbgr.mr_n67837024)
print v(xbgr.mr_n67837456)
print v(xbgr.mr_n67837776)
print v(xbgr.mr_n67837888)
print v(xbgr.mr_n67838320)
print v(xbgr.mr_n67838640)
print v(xbgr.mr_n67838752)
print v(xbgr.mr_n67839072)
print v(xbgr.mr_n67839184)
print v(xbgr.mr_n67839504)
print v(xbgr.mr_n67839616)
print v(xbgr.mr_n67840048)
print v(xbgr.mr_n67840368)
print v(xbgr.mr_n67841232)
print v(xbgr.mr_n67842096)
print v(xbgr.mr_n67842960)
print v(xbgr.mr_n67843072)
print v(xbgr.mr_n67843392)
print v(xbgr.mr_n67843504)
print v(xbgr.mr_n67843824)
print v(xbgr.mr_n67844688)
print v(xbgr.mr_n67845552)
print v(xbgr.mr_n67846416)
print v(xbgr.mr_n67847280)
print v(xbgr.mr_n67847392)
print v(xbgr.mr_n67847712)
print v(xbgr.mr_n67847824)
print v(xbgr.mr_n67848144)
print v(xbgr.mr_n67849008)
print v(xbgr.mr_n67849552)
print v(xbgr.mr_n67849872)
print v(xbgr.mr_n67849984)
print v(xbgr.mr_n67850304)
print v(xbgr.mr_n67850416)
print v(xbgr.mr_n67850736)
print v(xbgr.mr_n67850848)
print v(xbgr.mr_n67851168)
print v(xbgr.mr_n67851280)
print v(xbgr.mr_n67851712)
print v(xbgr.mr_n67852464)
print v(xbgr.mr_n67853328)
print v(xbgr.mr_n67854192)
print v(xbgr.mr_n67855056)
print v(xbgr.mr_n67855168)
print v(xbgr.mr_n67855488)
print v(xbgr.mr_n67855600)
print v(xbgr.mr_n67855920)
print v(xbgr.mr_n67856032)
print v(xbgr.mr_n67856352)
print v(xbgr.mr_n67856464)
print v(xbgr.mr_n67856784)
print v(xbgr.mr_n67856896)
print v(xbgr.mr_n67857216)
print v(xbgr.mr_n67857328)
print v(xbgr.mr_n67857648)
print v(xbgr.mr_n67857760)
print v(xbgr.mr_n67858192)
print v(xbgr.mr_n67858512)
print v(xbgr.mr_n67858624)
print v(xbgr.mr_n67858944)
print v(xbgr.mr_n67859056)
print v(xbgr.mr_n67859376)
print v(xbgr.mr_n67859488)
print v(xbgr.mr_n67859808)
print v(xbgr.mr_n67859920)
print v(xbgr.mr_n67860240)
print v(xbgr.mr_n67860352)
print v(xbgr.mr_n67860784)
print v(xbgr.mr_n67861104)
print v(xbgr.mr_n67861968)
print v(xbgr.mr_n67862080)
print v(xbgr.mr_n67862400)
print v(xbgr.mr_n67862512)
print v(xbgr.mr_n67862944)
print v(xbgr.mr_n67863376)
print v(xbgr.mr_n67863696)
print v(xbgr.mr_n67863808)
print v(xbgr.mr_n67864128)
print v(xbgr.mr_n67864240)
print v(xbgr.mr_n67864560)
print v(xbgr.mr_n67864672)
print v(xbgr.mr_n67864992)
print v(xbgr.mr_n67865104)
print v(xbgr.mr_n67865424)
print v(xbgr.mr_n67865536)
print v(xbgr.mr_n67865968)
print v(xbgr.mr_n67866288)
print v(xbgr.mr_n67866400)
print v(xbgr.mr_n67866832)
print v(xbgr.mr_n67867152)
print v(xbgr.mr_n67868016)
print v(xbgr.mr_n67868880)
print v(xbgr.mr_n67869744)
print v(xbgr.mr_n67870608)
print v(xbgr.mr_n67870720)
print v(xbgr.mr_n67871040)
print v(xbgr.mr_n67871152)
print v(xbgr.mr_n67871472)
print v(xbgr.mr_n67871584)
print v(xbgr.mr_n67871904)
print v(xbgr.mr_n67872016)
print v(xbgr.mr_n67872336)
print v(xbgr.mr_n67873200)
print v(xbgr.mr_n67874064)
print v(xbgr.mr_n67874176)
print v(xbgr.mr_n67874496)
print v(xbgr.mr_n67874608)
print v(xbgr.mr_n67875040)
print v(xbgr.mr_n67875472)
print v(xbgr.mr_n67875792)
print v(xbgr.mr_n67875904)
print v(xbgr.mr_n67876224)
print v(xbgr.mr_n67876336)
print v(xbgr.mr_n67876656)
print v(xbgr.mr_n67876768)
print v(xbgr.mr_n67877088)
print v(xbgr.mr_n67877200)
print v(xbgr.mr_n67877520)
print v(xbgr.mr_n67878384)
print v(xbgr.mr_n67879248)
print v(xbgr.mr_n67880112)
print v(xbgr.mr_n67880976)
print v(xbgr.mr_n67881840)
print v(xbgr.mr_n67881952)
print v(xbgr.mr_n67882384)
print v(xbgr.mr_n67882704)
print v(xbgr.mr_n67882816)
print v(xbgr.mr_n67883248)
print v(xbgr.mr_n67883568)
print v(xbgr.mr_n67883680)
print v(xbgr.mr_n67884112)
print v(xbgr.mr_n67884432)
print v(xbgr.mr_n67884544)
print v(xbgr.mr_n67884864)
print v(xbgr.mr_n67884976)
print v(xbgr.mr_n67885296)
print v(xbgr.mr_n67885408)
print v(xbgr.mr_n67885728)
print v(xbgr.mr_n67885840)
print v(xbgr.mr_n67886160)
print v(xbgr.mr_n67886272)
print v(xbgr.mr_n67886592)
print v(xbgr.mr_n67886704)
print v(xbgr.mr_n67887024)
print v(xbgr.mr_n67887136)
print v(xbgr.mr_n67887456)
print v(xbgr.mr_n67887568)
print v(xbgr.mr_n67887888)
print v(xbgr.mr_n67888000)
print v(xbgr.mr_n67888320)
print v(xbgr.mr_n67888432)
print v(xbgr.mr_n67888752)
print v(xbgr.mr_n67888864)
print v(xbgr.mr_n67889184)
print v(xbgr.mr_n67889296)
print v(xbgr.mr_n67889616)
print v(xbgr.mr_n67890480)
print v(xbgr.mr_n67891344)
print v(xbgr.mr_n67892208)
print v(xbgr.mr_n67892320)
print v(xbgr.mr_n67892752)
print v(xbgr.mr_n67893072)
print v(xbgr.mr_n67893184)
print v(xbgr.mr_n67893504)
print v(xbgr.mr_n67893616)
print v(xbgr.mr_n67893936)
print v(xbgr.mr_n67894048)
print v(xbgr.mr_n67894368)
print v(xbgr.mr_n67894480)
print v(xbgr.mr_n67894912)
print v(xbgr.mr_n67895344)
print v(xbgr.mr_n67895776)
print v(xbgr.mr_n67896208)
print v(xbgr.mr_n67896528)
print v(xbgr.mr_n67896640)
print v(xbgr.mr_n67897072)
print v(xbgr.mr_n67897392)
print v(xbgr.mr_n67898256)
print v(xbgr.mr_n67898368)
print v(xbgr.mr_n67898688)
print v(xbgr.mr_n67898800)
print v(xbgr.mr_n67899120)
print v(xbgr.mr_n67899232)
print v(xbgr.mr_n67899552)
print v(xbgr.mr_n67900528)
print v(xbgr.mr_n67900960)
print v(xbgr.mr_n67901392)
print v(xbgr.mr_n67901712)
print v(xbgr.mr_n67902576)
print v(xbgr.mr_n67902688)
print v(xbgr.mr_n67903008)
print v(xbgr.mr_n67903120)
print v(xbgr.mr_n67903440)
print v(xbgr.mr_n67903552)
print v(xbgr.mr_n67903872)
print v(xbgr.mr_n67903984)
print v(xbgr.mr_n67904304)
print v(xbgr.mr_n67904416)
print v(xbgr.mr_n67904736)
print v(xbgr.mr_n67904848)
print v(xbgr.mr_n67905168)
print v(xbgr.mr_n67905280)
print v(xbgr.mr_n67905600)
print v(xbgr.mr_n67905712)
print v(xbgr.mr_n67906032)
print v(xbgr.mr_n67906896)
print v(xbgr.mr_n67907760)
print v(xbgr.mr_n67908624)
print v(xbgr.mr_n67909488)
print v(xbgr.mr_n67910352)
print v(xbgr.mr_n67911216)
print v(xbgr.mr_n67912080)
print v(xbgr.mr_n67912944)
print v(xbgr.mr_n67913808)
print v(xbgr.mr_n67914672)
print v(xbgr.mr_n67915536)
print v(xbgr.mr_n67916400)
print v(xbgr.mr_n67916512)
print v(xbgr.mr_n67916832)
print v(xbgr.mr_n67916944)
print v(xbgr.mr_n67917264)
print v(xbgr.mr_n67917376)
print v(xbgr.mr_n67917696)
print v(xbgr.mr_n67917808)
print v(xbgr.mr_n67918128)
print v(xbgr.mr_n67918240)
print v(xbgr.mr_n67918672)
print v(xbgr.mr_n67918992)
print v(xbgr.mr_n67919104)
print v(xbgr.mr_n67919536)
print v(xbgr.mr_n67919856)
print v(xbgr.mr_n67920720)
print v(xbgr.mr_n67921584)
print v(xbgr.mr_n67922448)
print v(xbgr.mr_n67923312)
print v(xbgr.mr_n67923424)
print v(xbgr.mr_n67923744)
print v(xbgr.mr_n67923856)
print v(xbgr.mr_n67924176)
print v(xbgr.mr_n67924288)
print v(xbgr.mr_n67924608)
print v(xbgr.mr_n67924720)
print v(xbgr.mr_n67925040)
print v(xbgr.mr_n67925152)
print v(xbgr.mr_n67925472)
print v(xbgr.mr_n67925584)
print v(xbgr.mr_n67925904)
print v(xbgr.mr_n67926016)
print v(xbgr.mr_n67926336)
print v(xbgr.mr_n67927200)
print v(xbgr.mr_n67928064)
print v(xbgr.mr_n67928176)
print v(xbgr.mr_n67928496)
print v(xbgr.mr_n67928608)
print v(xbgr.mr_n67929040)
print v(xbgr.mr_n67929472)
print v(xbgr.mr_n67929792)
print v(xbgr.mr_n67929904)
print v(xbgr.mr_n67930224)
print v(xbgr.mr_n67930336)
print v(xbgr.mr_n67930656)
print v(xbgr.mr_n67930768)
print v(xbgr.mr_n67931088)
print v(xbgr.mr_n67931200)
print v(xbgr.mr_n67931520)
print v(xbgr.mr_n67931632)
print v(xbgr.mr_n67932064)
print v(xbgr.mr_n67932384)
print v(xbgr.mr_n67932496)
print v(xbgr.mr_n67932928)
print v(xbgr.mr_n67933248)
print v(xbgr.mr_n67933360)
print v(xbgr.mr_n67933680)
print v(xbgr.mr_n67934544)
print v(xbgr.mr_n67935408)
print v(xbgr.mr_n67936272)
print v(xbgr.mr_n67937136)
print v(xbgr.mr_n67937248)
print v(xbgr.mr_n67937568)
print v(xbgr.mr_n67937680)
print v(xbgr.mr_n67938000)
print v(xbgr.mr_n67938112)
print v(xbgr.mr_n67938432)
print v(xbgr.mr_n67938544)
print v(xbgr.mr_n67938864)
print v(xbgr.mr_n67938976)
print v(xbgr.mr_n67939296)
print v(xbgr.mr_n67939408)
print v(xbgr.mr_n67939728)
print v(xbgr.mr_n67940592)
print v(xbgr.mr_n67941456)
print v(xbgr.mr_n67941568)
print v(xbgr.mr_n67942000)
print v(xbgr.mr_n67942320)
print v(xbgr.mr_n67942432)
print v(xbgr.mr_n67942752)
print v(xbgr.mr_n67942864)
print v(xbgr.mr_n67943184)
print v(xbgr.mr_n67943296)
print v(xbgr.mr_n67943616)
print v(xbgr.mr_n67943728)
print v(xbgr.mr_n67944048)
print v(xbgr.mr_n67944160)
print v(xbgr.mr_n67944480)
print v(xbgr.mr_n67944592)
print v(xbgr.mr_n67945024)
print v(xbgr.mr_n67945456)
print v(xbgr.mr_n67945888)
print v(xbgr.mr_n67946320)
print v(xbgr.mr_n67946640)
print v(xbgr.mr_n67947072)
print v(xbgr.mr_n67947184)
print v(xbgr.mr_n67947504)
print v(xbgr.mr_n67947616)
print v(xbgr.mr_n67947936)
print v(xbgr.mr_n67948048)
print v(xbgr.mr_n67948368)
print v(xbgr.mr_n67948480)
print v(xbgr.mr_n67948800)
print v(xbgr.mr_n67948912)
print v(xbgr.mr_n67949232)
print v(xbgr.mr_n67949344)
print v(xbgr.mr_n67950096)
print v(xbgr.mr_n67950208)
print v(xbgr.mr_n67950640)
print v(xbgr.mr_n67950960)
print v(xbgr.mr_n67951392)
print v(xbgr.mr_n67951504)
print v(xbgr.mr_n67951936)
print v(xbgr.mr_n67952256)
print v(xbgr.mr_n67952368)
print v(xbgr.mr_n67952800)
print v(xbgr.mr_n67953120)
print v(xbgr.mr_n67953232)
print v(xbgr.mr_n67953664)
print v(xbgr.mr_n67954416)
print v(xbgr.mr_n67955280)
print v(xbgr.mr_n67956144)
print v(xbgr.mr_n67957008)
print v(xbgr.mr_n67957872)
print v(xbgr.mr_n67958736)
print v(xbgr.mr_n67958848)
print v(xbgr.mr_n67959168)
print v(xbgr.mr_n67959280)
print v(xbgr.mr_n67959600)
print v(xbgr.mr_n67959712)
print v(xbgr.mr_n67960032)
print v(xbgr.mr_n67960144)
print v(xbgr.mr_n67960464)
print v(xbgr.mr_n67961328)
print v(xbgr.mr_n67962192)
print v(xbgr.mr_n67963056)
print v(xbgr.mr_n67963168)
print v(xbgr.mr_n67963488)
print v(xbgr.mr_n67963600)
print v(xbgr.mr_n67963920)
print v(xbgr.mr_n67964032)
print v(xbgr.mr_n67964352)
print v(xbgr.mr_n67964464)
print v(xbgr.mr_n67964784)
print v(xbgr.mr_n67964896)
print v(xbgr.mr_n67965216)
print v(xbgr.mr_n67965328)
print v(xbgr.mr_n67965648)
print v(xbgr.mr_n67965760)
print v(xbgr.mr_n67966080)
print v(xbgr.mr_n67966192)
print v(xbgr.mr_n67966512)
print v(xbgr.mr_n67967376)
print v(xbgr.mr_n67967808)
print v(xbgr.mr_n67968672)
print v(xbgr.mr_n67969104)
print v(xbgr.mr_n67969968)
print v(xbgr.mr_n67970832)
print v(xbgr.mr_n67972128)
print v(xbgr.mr_n67973424)
print v(xbgr.mr_n67973536)
print v(xbgr.mr_n67973856)
print v(xbgr.mr_n67973968)
print v(xbgr.mr_n67974400)
print v(xbgr.mr_n67974720)
print v(xbgr.mr_n67974832)
print v(xbgr.mr_n67975264)
print v(xbgr.mr_n67975584)
print v(xbgr.mr_n67975696)
print v(xbgr.mr_n67976016)
print v(xbgr.mr_n67976128)
print v(xbgr.mr_n67976448)
print v(xbgr.mr_n67976560)
print v(xbgr.mr_n67976992)
print v(xbgr.mr_n67977312)
print v(xbgr.mr_n67977424)
print v(xbgr.mr_n67977856)
print v(xbgr.mr_n67978176)
print v(xbgr.mr_n67978288)
print v(xbgr.mr_n67978720)
print v(xbgr.mr_n67979040)
print v(xbgr.mr_n67979152)
print v(xbgr.mr_n67979472)
print v(xbgr.mr_n67979904)
print v(xbgr.mr_n67980016)
print v(xbgr.mr_n67980336)
print v(xbgr.mr_n67980448)
print v(xbgr.mr_n67980768)
print v(xbgr.mr_n67980880)
print v(xbgr.mr_n67981200)
print v(xbgr.mr_n67981312)
print v(xbgr.mr_n67982064)
print v(xbgr.mr_n67982928)
print v(xbgr.mr_n67983792)
print v(xbgr.mr_n67983904)
print v(xbgr.mr_n67984224)
print v(xbgr.mr_n67984336)
print v(xbgr.mr_n67984656)
print v(xbgr.mr_n67984768)
print v(xbgr.mr_n67985088)
print v(xbgr.mr_n67985200)
print v(xbgr.mr_n67985952)
print v(xbgr.mr_n67986384)
print v(xbgr.mr_n67987248)
print v(xbgr.mr_n67988544)
print v(xbgr.mr_n67988976)
print v(xbgr.mr_n67989840)
print v(xbgr.mr_n67989952)
print v(xbgr.mr_n67990272)
print v(xbgr.mr_n67990384)
print v(xbgr.mr_n67990704)
print v(xbgr.mr_n67991568)
print v(xbgr.mr_n67992000)
print v(xbgr.mr_n67992112)
print v(xbgr.mr_n67992432)
print v(xbgr.mr_n67993296)
print v(xbgr.mr_n67994160)
print v(xbgr.mr_n67995024)
print v(xbgr.mr_n67995888)
print v(xbgr.mr_n67996000)
print v(xbgr.mr_n67996320)
print v(xbgr.mr_n67996432)
print v(xbgr.mr_n67996752)
print v(xbgr.mr_n67996864)
print v(xbgr.mr_n67997184)
print v(xbgr.mr_n67997296)
print v(xbgr.mr_n67998048)
print v(xbgr.mr_n67998912)
print v(xbgr.mr_n67999776)
print v(xbgr.mr_n67999888)
print v(xbgr.mr_n68000320)
print v(xbgr.mr_n68000752)
print v(xbgr.mr_n68001184)
print v(xbgr.mr_n68001504)
print v(xbgr.mr_n68001616)
print v(xbgr.mr_n68001936)
print v(xbgr.mr_n68002048)
print v(xbgr.mr_n68002368)
print v(xbgr.mr_n68002480)
print v(xbgr.mr_n68002800)
print v(xbgr.mr_n68002912)
print v(xbgr.mr_n68003232)
print v(xbgr.mr_n68003344)
print v(xbgr.mr_n68003664)
print v(xbgr.mr_n68003776)
print v(xbgr.mr_n68004096)
print v(xbgr.mr_n68004208)
print v(xbgr.mr_n68004528)
print v(xbgr.mr_n68004640)
print v(xbgr.mr_n68005824)
print v(xbgr.mr_n68006368)
print v(xbgr.mr_n68006800)
print v(xbgr.mr_n68007232)
print v(xbgr.mr_n68007984)
print v(xbgr.mr_n68008096)
print v(xbgr.mr_n68008416)
print v(xbgr.mr_n68008528)
print v(xbgr.mr_n68008848)
print v(xbgr.mr_n68008960)
print v(xbgr.mr_n68009280)
print v(xbgr.mr_n68009392)
print v(xbgr.mr_n68009712)
print v(xbgr.mr_n68009824)
print v(xbgr.mr_n68010144)
print v(xbgr.mr_n68010256)
print v(xbgr.mr_n68010688)
print v(xbgr.mr_n68011008)
print v(xbgr.mr_n68011120)
print v(xbgr.mr_n68011440)
print v(xbgr.mr_n68011552)
print v(xbgr.mr_n68011984)
print v(xbgr.mr_n68012304)
print v(xbgr.mr_n68012416)
print v(xbgr.mr_n68012736)
print v(xbgr.mr_n68012848)
print v(xbgr.mr_n68013168)
print v(xbgr.mr_n68013280)
print v(xbgr.mr_n68013600)
print v(xbgr.mr_n68013712)
print v(xbgr.mr_n68014032)
print v(xbgr.mr_n68014144)
print v(xbgr.mr_n68014464)
print v(xbgr.mr_n68014576)
print v(xbgr.mr_n68014896)
print v(xbgr.mr_n68015760)
print v(xbgr.mr_n68016304)
print v(xbgr.mr_n68016624)
print v(xbgr.mr_n68016736)
print v(xbgr.mr_n68017168)
print v(xbgr.mr_n68017488)
print v(xbgr.mr_n68017600)
print v(xbgr.mr_n68018352)
print v(xbgr.mr_n68019216)
print v(xbgr.mr_n68019328)
print v(xbgr.mr_n68019648)
print v(xbgr.mr_n68019760)
print v(xbgr.mr_n68020080)
print v(xbgr.mr_n68020192)
print v(xbgr.mr_n68020512)
print v(xbgr.mr_n68020944)
print v(xbgr.mr_n68021808)
print v(xbgr.mr_n68023104)
print v(xbgr.mr_n68024080)
print v(xbgr.mr_n68024400)
print v(xbgr.mr_n68024512)
print v(xbgr.mr_n68024832)
print v(xbgr.mr_n68024944)
print v(xbgr.mr_n68025264)
print v(xbgr.mr_n68026128)
print v(xbgr.mr_n68026240)
print v(xbgr.mr_n68026560)
print v(xbgr.mr_n68026672)
print v(xbgr.mr_n68026992)
print v(xbgr.mr_n68027104)
print v(xbgr.mr_n68027424)
print v(xbgr.mr_n68027536)
print v(xbgr.mr_n68027856)
print v(xbgr.mr_n68027968)
print v(xbgr.mr_n68028288)
print v(xbgr.mr_n68028832)
print v(xbgr.mr_n68029152)
print v(xbgr.mr_n68030448)
print v(xbgr.mr_n68031312)
print v(xbgr.mr_n68031856)
print v(xbgr.mr_n68032288)
print v(xbgr.mr_n68033040)
print v(xbgr.mr_n68033152)
print v(xbgr.mr_n68033472)
print v(xbgr.mr_n68033584)
print v(xbgr.mr_n68033904)
print v(xbgr.mr_n68034016)
print v(xbgr.mr_n68034336)
print v(xbgr.mr_n68034448)
print v(xbgr.mr_n68034768)
print v(xbgr.mr_n68034880)
print v(xbgr.mr_n68035200)
print v(xbgr.mr_n68035312)
print v(xbgr.mr_n68035744)
print v(xbgr.mr_n68036064)
print v(xbgr.mr_n68036176)
print v(xbgr.mr_n68036496)
print v(xbgr.mr_n68036608)
print v(xbgr.mr_n68036928)
print v(xbgr.mr_n68037040)
print v(xbgr.mr_n68037360)
print v(xbgr.mr_n68037472)
print v(xbgr.mr_n68037792)
print v(xbgr.mr_n68037904)
print v(xbgr.mr_n68038224)
print v(xbgr.mr_n68038336)
print v(xbgr.mr_n68038656)
print v(xbgr.mr_n68038768)
print v(xbgr.mr_n68039088)
print v(xbgr.mr_n68039200)
print v(xbgr.mr_n68039632)
print v(xbgr.mr_n68040064)
print v(xbgr.mr_n68040496)
print v(xbgr.mr_n68040816)
print v(xbgr.mr_n68040928)
print v(xbgr.mr_n68041248)
print v(xbgr.mr_n68041360)
print v(xbgr.mr_n68041680)
print v(xbgr.mr_n68041792)
print v(xbgr.mr_n68042112)
print v(xbgr.mr_n68042224)
print v(xbgr.mr_n68042544)
print v(xbgr.mr_n68042656)
print v(xbgr.mr_n68043088)
print v(xbgr.mr_n68043408)
print v(xbgr.mr_n68044272)
print v(xbgr.mr_n68045136)
print v(xbgr.mr_n68045248)
print v(xbgr.mr_n68045568)
print v(xbgr.mr_n68045680)
print v(xbgr.mr_n68046000)
print v(xbgr.mr_n68046112)
print v(xbgr.mr_n68046432)
print v(xbgr.mr_n68046544)
print v(xbgr.mr_n68046864)
print v(xbgr.mr_n68047840)
print v(xbgr.mr_n68048160)
print v(xbgr.mr_n68048272)
print v(xbgr.mr_n68048592)
print v(xbgr.mr_n68048704)
print v(xbgr.mr_n68049024)
print v(xbgr.mr_n68049136)
print v(xbgr.mr_n68049456)
print v(xbgr.mr_n68049568)
print v(xbgr.mr_n68049888)
print v(xbgr.mr_n68050000)
print v(xbgr.mr_n68050320)
print v(xbgr.mr_n68051184)
print v(xbgr.mr_n68052048)
print v(xbgr.mr_n68052912)
print v(xbgr.mr_n68053776)
print v(xbgr.mr_n68053888)
print v(xbgr.mr_n68054208)
print v(xbgr.mr_n68054320)
print v(xbgr.mr_n68054640)
print v(xbgr.mr_n68055616)
print v(xbgr.mr_n68056048)
print v(xbgr.mr_n68056368)
print v(xbgr.mr_n68057232)
print v(xbgr.mr_n68058096)
print v(xbgr.mr_n68058960)
print v(xbgr.mr_n68059824)
print v(xbgr.mr_n68059936)
print v(xbgr.mr_n68060368)
print v(xbgr.mr_n68060688)
print v(xbgr.mr_n68060800)
print v(xbgr.mr_n68061120)
print v(xbgr.mr_n68061232)
print v(xbgr.mr_n68061552)
print v(xbgr.mr_n68061664)
print v(xbgr.mr_n68062096)
print v(xbgr.mr_n68062416)
print v(xbgr.mr_n68062528)
print v(xbgr.mr_n68062960)
print v(xbgr.mr_n68063280)
print v(xbgr.mr_n68063392)
print v(xbgr.mr_n68063712)
print v(xbgr.mr_n68063824)
print v(xbgr.mr_n68064144)
print v(xbgr.mr_n68064256)
print v(xbgr.mr_n68064576)
print v(xbgr.mr_n68064688)
print v(xbgr.mr_n68065008)
print v(xbgr.mr_n68065120)
print v(xbgr.mr_n68065440)
print v(xbgr.mr_n68065552)
print v(xbgr.mr_n68065984)
print v(xbgr.mr_n68066304)
print v(xbgr.mr_n68067168)
print v(xbgr.mr_n68067712)
print v(xbgr.mr_n68068032)
print v(xbgr.mr_n68068144)
print v(xbgr.mr_n68068464)
print v(xbgr.mr_n68068576)
print v(xbgr.mr_n68068896)
print v(xbgr.mr_n68069008)
print v(xbgr.mr_n68069328)
print v(xbgr.mr_n68069440)
print v(xbgr.mr_n68069760)
print v(xbgr.mr_n68069872)
print v(xbgr.mr_n68070192)
print v(xbgr.mr_n68070304)
print v(xbgr.mr_n68070736)
print v(xbgr.mr_n68071056)
print v(xbgr.mr_n68071920)
print v(xbgr.mr_n68072352)
print v(xbgr.mr_n68073216)
print v(xbgr.mr_n68074080)
print v(xbgr.mr_n68075488)
print v(xbgr.mr_n68076352)
print v(xbgr.mr_n68076784)
print v(xbgr.mr_n68077104)
print v(xbgr.mr_n68077968)
print v(xbgr.mr_n68078080)
print v(xbgr.mr_n68078400)
print v(xbgr.mr_n68078512)
print v(xbgr.mr_n68078832)
print v(xbgr.mr_n68078944)
print v(xbgr.mr_n68079264)
print v(xbgr.mr_n68079376)
print v(xbgr.mr_n68079696)
print v(xbgr.mr_n68079808)
print v(xbgr.mr_n68080128)
print v(xbgr.mr_n68080240)
print v(xbgr.mr_n68080560)
print v(xbgr.mr_n68080672)
print v(xbgr.mr_n68080992)
print v(xbgr.mr_n68081856)
print v(xbgr.mr_n68082832)
print v(xbgr.mr_n68083264)
print v(xbgr.mr_n68083696)
print v(xbgr.mr_n68084016)
print v(xbgr.mr_n68084128)
print v(xbgr.mr_n68084448)
print v(xbgr.mr_n68084560)
print v(xbgr.mr_n68084880)
print v(xbgr.mr_n68085744)
print v(xbgr.mr_n68086608)
print v(xbgr.mr_n68087472)
print v(xbgr.mr_n68087584)
print v(xbgr.mr_n68087904)
print v(xbgr.mr_n68088016)
print v(xbgr.mr_n68088336)
print v(xbgr.mr_n68089200)
print v(xbgr.mr_n68090064)
print v(xbgr.mr_n68090928)
print v(xbgr.mr_n68091040)
print v(xbgr.mr_n68091360)
print v(xbgr.mr_n68091472)
print v(xbgr.mr_n68091792)
print v(xbgr.mr_n68091904)
print v(xbgr.mr_n68092224)
print v(xbgr.mr_n68092336)
print v(xbgr.mr_n68092656)
print v(xbgr.mr_n68093520)
print v(xbgr.mr_n68094384)
print v(xbgr.mr_n68094496)
print v(xbgr.mr_n68094816)
print v(xbgr.mr_n68094928)
print v(xbgr.mr_n68095248)
print v(xbgr.mr_n68095360)
print v(xbgr.mr_n68095680)
print v(xbgr.mr_n68095792)
print v(xbgr.mr_n68096112)
print v(xbgr.mr_n68096224)
print v(xbgr.mr_n68096656)
print v(xbgr.mr_n68096976)
print v(xbgr.mr_n68097088)
print v(xbgr.mr_n68097408)
print v(xbgr.mr_n68097520)
print v(xbgr.mr_n68097840)
print v(xbgr.mr_n68097952)
print v(xbgr.mr_n68098272)
print v(xbgr.mr_n68098384)
print v(xbgr.mr_n68098704)
print v(xbgr.mr_n68099568)
print v(xbgr.mr_n68099680)
print v(xbgr.mr_n68100112)
print v(xbgr.mr_n68100432)
print v(xbgr.mr_n68100544)
print v(xbgr.mr_n68100864)
print v(xbgr.mr_n68100976)
print v(xbgr.mr_n68101296)
print v(xbgr.mr_n68101408)
print v(xbgr.mr_n68101728)
print v(xbgr.mr_n68101840)
print v(xbgr.mr_n68102160)
print v(xbgr.mr_n68102272)
print v(xbgr.mr_n68102592)
print v(xbgr.mr_n68102704)
print v(xbgr.mr_n68103024)
print v(xbgr.mr_n68103456)
print v(xbgr.mr_n68103568)
print v(xbgr.mr_n68103888)
print v(xbgr.mr_n68104432)
print v(xbgr.mr_n68104752)
print v(xbgr.mr_n68104864)
print v(xbgr.mr_n68105296)
print v(xbgr.mr_n68105728)
print v(xbgr.mr_n68106160)
print v(xbgr.mr_n68106592)
print v(xbgr.mr_n68107024)
print v(xbgr.mr_n68107344)
print v(xbgr.mr_n68107456)
print v(xbgr.mr_n68107888)
print v(xbgr.mr_n68108208)
print v(xbgr.mr_n68108320)
print v(xbgr.mr_n68108752)
print v(xbgr.mr_n68109072)
print v(xbgr.mr_n68109936)
print v(xbgr.mr_n68111232)
print v(xbgr.mr_n68111776)
print v(xbgr.mr_n68112096)
print v(xbgr.mr_n68112640)
print v(xbgr.mr_n68112960)
print v(xbgr.mr_n68113072)
print v(xbgr.mr_n68113824)
print v(xbgr.mr_n68114256)
print v(xbgr.mr_n68115120)
print v(xbgr.mr_n68115984)
print v(xbgr.mr_n68117280)
print v(xbgr.mr_n68118144)
print v(xbgr.mr_n68118576)
print v(xbgr.mr_n68118688)
print v(xbgr.mr_n68119440)
print v(xbgr.mr_n68119552)
print v(xbgr.mr_n68119872)
print v(xbgr.mr_n68119984)
print v(xbgr.mr_n68120304)
print v(xbgr.mr_n68120416)
print v(xbgr.mr_n68121168)
print v(xbgr.mr_n68122464)
print v(xbgr.mr_n68123328)
print v(xbgr.mr_n68124192)
print v(xbgr.mr_n68124624)
print v(xbgr.mr_n68124736)
print v(xbgr.mr_n68125056)
print v(xbgr.mr_n68125168)
print v(xbgr.mr_n68125488)
print v(xbgr.mr_n68125600)
print v(xbgr.mr_n68125920)
print v(xbgr.mr_n68126032)
print v(xbgr.mr_n68126784)
print v(xbgr.mr_n68126896)
print v(xbgr.mr_n68127216)
print v(xbgr.mr_n68127328)
print v(xbgr.mr_n68127648)
print v(xbgr.mr_n68127760)
print v(xbgr.mr_n68128080)
print v(xbgr.mr_n68128944)
print v(xbgr.mr_n68129056)
print v(xbgr.mr_n68129376)
print v(xbgr.mr_n68129488)
print v(xbgr.mr_n68129920)
print v(xbgr.mr_n68130240)
print v(xbgr.mr_n68130352)
print v(xbgr.mr_n68130672)
print v(xbgr.mr_n68130784)
print v(xbgr.mr_n68131104)
print v(xbgr.mr_n68131216)
print v(xbgr.mr_n68131648)
print v(xbgr.mr_n68132080)
print v(xbgr.mr_n68132400)
print v(xbgr.mr_n68132512)
print v(xbgr.mr_n68132832)
print v(xbgr.mr_n68132944)
print v(xbgr.mr_n68133264)
print v(xbgr.mr_n68133376)
print v(xbgr.mr_n68133808)
print v(xbgr.mr_n68134128)
print v(xbgr.mr_n68134240)
print v(xbgr.mr_n68134672)
print v(xbgr.mr_n68134992)
print v(xbgr.mr_n68135104)
print v(xbgr.mr_n68135424)
print v(xbgr.mr_n68135536)
print v(xbgr.mr_n68135856)
print v(xbgr.mr_n68135968)
print v(xbgr.mr_n68136288)
print v(xbgr.mr_n68136400)
print v(xbgr.mr_n68136720)
print v(xbgr.mr_n68137584)
print v(xbgr.mr_n68138448)
print v(xbgr.mr_n68138560)
print v(xbgr.mr_n68138880)
print v(xbgr.mr_n68139424)
print v(xbgr.mr_n68139744)
print v(xbgr.mr_n68140176)
print v(xbgr.mr_n68141472)
print v(xbgr.mr_n68142768)
print v(xbgr.mr_n68142880)
print v(xbgr.mr_n68143200)
print v(xbgr.mr_n68143312)
print v(xbgr.mr_n68143632)
print v(xbgr.mr_n68143744)
print v(xbgr.mr_n68144064)
print v(xbgr.mr_n68144176)
print v(xbgr.mr_n68144496)
print v(xbgr.mr_n68144608)
print v(xbgr.mr_n68144928)
print v(xbgr.mr_n68145040)
print v(xbgr.mr_n68145360)
print v(xbgr.mr_n68145472)
print v(xbgr.mr_n68145904)
print v(xbgr.mr_n68146224)
print v(xbgr.mr_n68147088)
print v(xbgr.mr_n68147200)
print v(xbgr.mr_n68147520)
print v(xbgr.mr_n68147632)
print v(xbgr.mr_n68147952)
print v(xbgr.mr_n68148064)
print v(xbgr.mr_n68148384)
print v(xbgr.mr_n68148496)
print v(xbgr.mr_n68148816)
print v(xbgr.mr_n68149680)
print v(xbgr.mr_n68150544)
print v(xbgr.mr_n68151408)
print v(xbgr.mr_n68152272)
print v(xbgr.mr_n68153136)
print v(xbgr.mr_n68153248)
print v(xbgr.mr_n68153568)
print v(xbgr.mr_n68153680)
print v(xbgr.mr_n68154000)
print v(xbgr.mr_n68154112)
print v(xbgr.mr_n68154432)
print v(xbgr.mr_n68154544)
print v(xbgr.mr_n68154864)
print v(xbgr.mr_n68154976)
print v(xbgr.mr_n68155296)
print v(xbgr.mr_n68155408)
print v(xbgr.mr_n68155728)
print v(xbgr.mr_n68155840)
print v(xbgr.mr_n68156160)
print v(xbgr.mr_n68156272)
print v(xbgr.mr_n68156592)
print v(xbgr.mr_n68156704)
print v(xbgr.mr_n68157024)
print v(xbgr.mr_n68157136)
print v(xbgr.mr_n68157568)
print v(xbgr.mr_n68157888)
print v(xbgr.mr_n68158000)
print v(xbgr.mr_n68158320)
print v(xbgr.mr_n68158432)
print v(xbgr.mr_n68158864)
print v(xbgr.mr_n68159184)
print v(xbgr.mr_n68159296)
print v(xbgr.mr_n68159728)
print v(xbgr.mr_n68160048)
print v(xbgr.mr_n68160160)
print v(xbgr.mr_n68160592)
print v(xbgr.mr_n68161024)
print v(xbgr.mr_n68161344)
print v(xbgr.mr_n68161456)
print v(xbgr.mr_n68161888)
print v(xbgr.mr_n68162208)
print v(xbgr.mr_n68162320)
print v(xbgr.mr_n68162640)
print v(xbgr.mr_n68162752)
print v(xbgr.mr_n68163072)
print v(xbgr.mr_n68163184)
print v(xbgr.mr_n68163504)
print v(xbgr.mr_n68163616)
print v(xbgr.mr_n68163936)
print v(xbgr.mr_n68164048)
print v(xbgr.mr_n68164368)
print v(xbgr.mr_n68164480)
print v(xbgr.mr_n68164800)
print v(xbgr.mr_n68164912)
print v(xbgr.mr_n68165232)
print v(xbgr.mr_n68165344)
print v(xbgr.mr_n68165664)
print v(xbgr.mr_n68166528)
print v(xbgr.mr_n68166640)
print v(xbgr.mr_n68166960)
print v(xbgr.mr_n68167072)
print v(xbgr.mr_n68167392)
print v(xbgr.mr_n68168256)
print v(xbgr.mr_n68169120)
print v(xbgr.mr_n68169984)
print v(xbgr.mr_n68170848)
print v(xbgr.mr_n68171712)
print v(xbgr.mr_n68171824)
print v(xbgr.mr_n68172144)
print v(xbgr.mr_n68172256)
print v(xbgr.mr_n68172576)
print v(xbgr.mr_n68172688)
print v(xbgr.mr_n68173008)
print v(xbgr.mr_n68173872)
print v(xbgr.mr_n68174736)
print v(xbgr.mr_n68175600)
print v(xbgr.mr_n68176464)
print v(xbgr.mr_n68177328)
print v(xbgr.mr_n68178192)
print v(xbgr.mr_n68179056)
print v(xbgr.mr_n68179168)
print v(xbgr.mr_n68179488)
print v(xbgr.mr_n68179600)
print v(xbgr.mr_n68180032)
print v(xbgr.mr_n68180352)
print v(xbgr.mr_n68181216)
print v(xbgr.mr_n68181760)
print v(xbgr.mr_n68182192)
print v(xbgr.mr_n68182624)
print v(xbgr.mr_n68183376)
print v(xbgr.mr_n68184240)
print v(xbgr.mr_n68185104)
print v(xbgr.mr_n68185216)
print v(xbgr.mr_n68185536)
print v(xbgr.mr_n68185648)
print v(xbgr.mr_n68186080)
print v(xbgr.mr_n68186512)
print v(xbgr.mr_n68186832)
print v(xbgr.mr_n68187696)
print v(xbgr.mr_n68187808)
print v(xbgr.mr_n68188240)
print v(xbgr.mr_n68188560)
print v(xbgr.mr_n68188672)
print v(xbgr.mr_n68189104)
print v(xbgr.mr_n68189424)
print v(xbgr.mr_n68190288)
print v(xbgr.mr_n68190400)
print v(xbgr.mr_n68190720)
print v(xbgr.mr_n68191584)
print v(xbgr.mr_n68192448)
print v(xbgr.mr_n68192560)
print v(xbgr.mr_n68192880)
print v(xbgr.mr_n68192992)
print v(xbgr.mr_n68193312)
print v(xbgr.mr_n68194176)
print v(xbgr.mr_n68194608)
print v(xbgr.mr_n68194720)
print v(xbgr.mr_n68195152)
print v(xbgr.mr_n68195472)
print v(xbgr.mr_n68195584)
print v(xbgr.mr_n68196016)
print v(xbgr.mr_n68196768)
print v(xbgr.mr_n68196880)
print v(xbgr.mr_n68197200)
print v(xbgr.mr_n68197312)
print v(xbgr.mr_n68197632)
print v(xbgr.mr_n68197744)
print v(xbgr.mr_n68198064)
print v(xbgr.mr_n68198496)
print v(xbgr.mr_n68198608)
print v(xbgr.mr_n68199360)
print v(xbgr.mr_n68199792)
print v(xbgr.mr_n68199904)
print v(xbgr.mr_n68200768)
print v(xbgr.mr_n68201088)
print v(xbgr.mr_n68201200)
print v(xbgr.mr_n68201520)
print v(xbgr.mr_n68202384)
print v(xbgr.mr_n68203248)
print v(xbgr.mr_n68204112)
print v(xbgr.mr_n68204976)
print v(xbgr.mr_n68205088)
print v(xbgr.mr_n68205408)
print v(xbgr.mr_n68205520)
print v(xbgr.mr_n68205840)
print v(xbgr.mr_n68205952)
print v(xbgr.mr_n68206272)
print v(xbgr.mr_n68206384)
print v(xbgr.mr_n68206704)
print v(xbgr.mr_n68206816)
print v(xbgr.mr_n68207136)
print v(xbgr.mr_n68207248)
print v(xbgr.mr_n68207568)
print v(xbgr.mr_n68207680)
print v(xbgr.mr_n68208000)
print v(xbgr.mr_n68208112)
print v(xbgr.mr_n68208432)
print v(xbgr.mr_n68208544)
print v(xbgr.mr_n68208864)
print v(xbgr.mr_n68208976)
print v(xbgr.mr_n68209408)
print v(xbgr.mr_n68209840)
print v(xbgr.mr_n68210272)
print v(xbgr.mr_n68210592)
print v(xbgr.mr_n68210704)
print v(xbgr.mr_n68211024)
print v(xbgr.mr_n68211888)
print v(xbgr.mr_n68212000)
print v(xbgr.mr_n68212320)
print v(xbgr.mr_n68212432)
print v(xbgr.mr_n68212752)
print v(xbgr.mr_n68212864)
print v(xbgr.mr_n68213296)
print v(xbgr.mr_n68213616)
print v(xbgr.mr_n68213728)
print v(xbgr.mr_n68214048)
print v(xbgr.mr_n68214160)
print v(xbgr.mr_n68214592)
print v(xbgr.mr_n68214912)
print v(xbgr.mr_n68215344)
print v(xbgr.mr_n68215456)
print v(xbgr.mr_n68215776)
print v(xbgr.mr_n68215888)
print v(xbgr.mr_n68216208)
print v(xbgr.mr_n68216320)
print v(xbgr.mr_n68216640)
print v(xbgr.mr_n68216752)
print v(xbgr.mr_n68217184)
print v(xbgr.mr_n68217504)
print v(xbgr.mr_n68217616)
print v(xbgr.mr_n68217936)
print v(xbgr.mr_n68218048)
print v(xbgr.mr_n68218368)
print v(xbgr.mr_n68218480)
print v(xbgr.mr_n68218800)
print v(xbgr.mr_n68218912)
print v(xbgr.mr_n68219232)
print v(xbgr.mr_n68219344)
print v(xbgr.mr_n68219664)
print v(xbgr.mr_n68219776)
print v(xbgr.mr_n68220096)
print v(xbgr.mr_n68220208)
print v(xbgr.mr_n68220960)
print v(xbgr.mr_n68221392)
print v(xbgr.mr_n68222256)
print v(xbgr.mr_n68222368)
print v(xbgr.mr_n68222688)
print v(xbgr.mr_n68223232)
print v(xbgr.mr_n68223664)
print v(xbgr.mr_n68224096)
print v(xbgr.mr_n68224416)
print v(xbgr.mr_n68224848)
print v(xbgr.mr_n68225712)
print v(xbgr.mr_n68227872)
print v(xbgr.mr_n68228736)
print v(xbgr.mr_n68228848)
print v(xbgr.mr_n68229168)
print v(xbgr.mr_n68230032)
print v(xbgr.mr_n68230896)
print v(xbgr.mr_n68231008)
print v(xbgr.mr_n68231328)
print v(xbgr.mr_n68231440)
print v(xbgr.mr_n68231760)
print v(xbgr.mr_n68231872)
print v(xbgr.mr_n68232192)
print v(xbgr.mr_n68232304)
print v(xbgr.mr_n68232624)
print v(xbgr.mr_n68233488)
print v(xbgr.mr_n68234352)
print v(xbgr.mr_n68234464)
print v(xbgr.mr_n68234784)
print v(xbgr.mr_n68234896)
print v(xbgr.mr_n68235216)
print v(xbgr.mr_n68235328)
print v(xbgr.mr_n68235648)
print v(xbgr.mr_n68235760)
print v(xbgr.mr_n68236080)
print v(xbgr.mr_n68236192)
print v(xbgr.mr_n68236512)
print v(xbgr.mr_n68236624)
print v(xbgr.mr_n68236944)
print v(xbgr.mr_n68237056)
print v(xbgr.mr_n68237488)
print v(xbgr.mr_n68237808)
print v(xbgr.mr_n68237920)
print v(xbgr.mr_n68238352)
print v(xbgr.mr_n68238672)
print v(xbgr.mr_n68239216)
print v(xbgr.mr_n68240080)
print v(xbgr.mr_n68240400)
print v(xbgr.mr_n68240512)
print v(xbgr.mr_n68241696)
print v(xbgr.mr_n68241808)
print v(xbgr.mr_n68242128)
print v(xbgr.mr_n68242240)
print v(xbgr.mr_n68242560)
print v(xbgr.mr_n68242672)
print v(xbgr.mr_n68242992)
print v(xbgr.mr_n68243104)
print v(xbgr.mr_n68243424)
print v(xbgr.mr_n68244288)
print v(xbgr.mr_n68245152)
print v(xbgr.mr_n68245264)
print v(xbgr.mr_n68245696)
print v(xbgr.mr_n68246128)
print v(xbgr.mr_n68246560)
print v(xbgr.mr_n68246880)
print v(xbgr.mr_n68246992)
print v(xbgr.mr_n68247312)
print v(xbgr.mr_n68247424)
print v(xbgr.mr_n68247744)
print v(xbgr.mr_n68247856)
print v(xbgr.mr_n68248176)
print v(xbgr.mr_n68248288)
print v(xbgr.mr_n68248608)
print v(xbgr.mr_n68248720)
print v(xbgr.mr_n68249040)
print v(xbgr.mr_n68249152)
print v(xbgr.mr_n68249472)
print v(xbgr.mr_n68250336)
print v(xbgr.mr_n68250448)
print v(xbgr.mr_n68250768)
print v(xbgr.mr_n68250880)
print v(xbgr.mr_n68251200)
print v(xbgr.mr_n68251312)
print v(xbgr.mr_n68251632)
print v(xbgr.mr_n68251744)
print v(xbgr.mr_n68252064)
print v(xbgr.mr_n68252608)
print v(xbgr.mr_n68253360)
print v(xbgr.mr_n68254224)
print v(xbgr.mr_n68255088)
print v(xbgr.mr_n68255952)
print v(xbgr.mr_n68256816)
print v(xbgr.mr_n68257680)
print v(xbgr.mr_n68257792)
print v(xbgr.mr_n68258112)
print v(xbgr.mr_n68258224)
print v(xbgr.mr_n68258544)
print v(xbgr.mr_n68258656)
print v(xbgr.mr_n68258976)
print v(xbgr.mr_n68259088)
print v(xbgr.mr_n68259408)
print v(xbgr.mr_n68259520)
print v(xbgr.mr_n68259840)
print v(xbgr.mr_n68259952)
print v(xbgr.mr_n68260272)
print v(xbgr.mr_n68261136)
print v(xbgr.mr_n68262000)
print v(xbgr.mr_n68262864)
print v(xbgr.mr_n68263728)
print v(xbgr.mr_n68264592)
print v(xbgr.mr_n68265456)
print v(xbgr.mr_n68266320)
print v(xbgr.mr_n68266432)
print v(xbgr.mr_n68266752)
print v(xbgr.mr_n68266864)
print v(xbgr.mr_n68267184)
print v(xbgr.mr_n68267296)
print v(xbgr.mr_n68267616)
print v(xbgr.mr_n68267728)
print v(xbgr.mr_n68268048)
print v(xbgr.mr_n68268160)
print v(xbgr.mr_n68268480)
print v(xbgr.mr_n68268592)
print v(xbgr.mr_n68268912)
print v(xbgr.mr_n68269024)
print v(xbgr.mr_n68269456)
print v(xbgr.mr_n68269776)
print v(xbgr.mr_n68269888)
print v(xbgr.mr_n68270320)
print v(xbgr.mr_n68270640)
print v(xbgr.mr_n68270752)
print v(xbgr.mr_n68271184)
print v(xbgr.mr_n68271504)
print v(xbgr.mr_n68272368)
print v(xbgr.mr_n68273232)
print v(xbgr.mr_n68274096)
print v(xbgr.mr_n68274960)
print v(xbgr.mr_n68275824)
print v(xbgr.mr_n68276688)
print v(xbgr.mr_n68276800)
print v(xbgr.mr_n68277120)
print v(xbgr.mr_n68277232)
print v(xbgr.mr_n68277552)
print v(xbgr.mr_n68277664)
print v(xbgr.mr_n68277984)
print v(xbgr.mr_n68278096)
print v(xbgr.mr_n68278416)
print v(xbgr.mr_n68279280)
print v(xbgr.mr_n68280144)
print v(xbgr.mr_n68281008)
print v(xbgr.mr_n68281120)
print v(xbgr.mr_n68281552)
print v(xbgr.mr_n68281872)
print v(xbgr.mr_n68281984)
print v(xbgr.mr_n68282304)
print v(xbgr.mr_n68282416)
print v(xbgr.mr_n68282736)
print v(xbgr.mr_n68282848)
print v(xbgr.mr_n68283168)
print v(xbgr.mr_n68283280)
print v(xbgr.mr_n68283600)
print v(xbgr.mr_n68283712)
print v(xbgr.mr_n68284144)
print v(xbgr.mr_n68284464)
print v(xbgr.mr_n68284576)
print v(xbgr.mr_n68285008)
print v(xbgr.mr_n68285328)
print v(xbgr.mr_n68285440)
print v(xbgr.mr_n68285760)
print v(xbgr.mr_n68285872)
print v(xbgr.mr_n68286304)
print v(xbgr.mr_n68286736)
print v(xbgr.mr_n68287056)
print v(xbgr.mr_n68287168)
print v(xbgr.mr_n68287600)
print v(xbgr.mr_n68287920)
print v(xbgr.mr_n68288032)
print v(xbgr.mr_n68288464)
print v(xbgr.mr_n68288784)
print v(xbgr.mr_n68289648)
print v(xbgr.mr_n68290512)
print v(xbgr.mr_n68291376)
print v(xbgr.mr_n68292240)
print v(xbgr.mr_n68292352)
print v(xbgr.mr_n68292672)
print v(xbgr.mr_n68292784)
print v(xbgr.mr_n68293104)
print v(xbgr.mr_n68293216)
print v(xbgr.mr_n68293536)
print v(xbgr.mr_n68293648)
print v(xbgr.mr_n68293968)
print v(xbgr.mr_n68294832)
print v(xbgr.mr_n68295696)
print v(xbgr.mr_n68296560)
print v(xbgr.mr_n68297424)
print v(xbgr.mr_n68298288)
print v(xbgr.mr_n68299152)
print v(xbgr.mr_n68300016)
print v(xbgr.mr_n68300880)
print v(xbgr.mr_n68300992)
print v(xbgr.mr_n68301312)
print v(xbgr.mr_n68301424)
print v(xbgr.mr_n68301744)
print v(xbgr.mr_n68301856)
print v(xbgr.mr_n68302176)
print v(xbgr.mr_n68302288)
print v(xbgr.mr_n68302608)
print v(xbgr.mr_n68302720)
print v(xbgr.mr_n68303040)
print v(xbgr.mr_n68303152)
print v(xbgr.mr_n68303472)
print v(xbgr.mr_n68303584)
print v(xbgr.mr_n68303904)
print v(xbgr.mr_n68304016)
print v(xbgr.mr_n68304336)
print v(xbgr.mr_n68304448)
print v(xbgr.mr_n68304768)
print v(xbgr.mr_n68304880)
print v(xbgr.mr_n68305312)
print v(xbgr.mr_n68305632)
print v(xbgr.mr_n68305744)
print v(xbgr.mr_n68306064)
print v(xbgr.mr_n68306176)
print v(xbgr.mr_n68306496)
print v(xbgr.mr_n68306608)
print v(xbgr.mr_n68306928)
print v(xbgr.mr_n68307040)
print v(xbgr.mr_n68307360)
print v(xbgr.mr_n68307472)
print v(xbgr.mr_n68307904)
print v(xbgr.mr_n68308224)
print v(xbgr.mr_n68308336)
print v(xbgr.mr_n68308768)
print v(xbgr.mr_n68309088)
print v(xbgr.mr_n68309200)
print v(xbgr.mr_n68309520)
print v(xbgr.mr_n68310384)
print v(xbgr.mr_n68311248)
print v(xbgr.mr_n68311792)
print v(xbgr.mr_n68312544)
print v(xbgr.mr_n68312976)
print v(xbgr.mr_n68313088)
print v(xbgr.mr_n68313840)
print v(xbgr.mr_n68313952)
print v(xbgr.mr_n68314384)
print v(xbgr.mr_n68314816)
print v(xbgr.mr_n68315136)
print v(xbgr.mr_n68316000)
print v(xbgr.mr_n68316432)
print v(xbgr.mr_n68317296)
print v(xbgr.mr_n68317408)
print v(xbgr.mr_n68318160)
print v(xbgr.mr_n68319456)
print v(xbgr.mr_n68320320)
print v(xbgr.mr_n68320432)
print v(xbgr.mr_n68320752)
print v(xbgr.mr_n68320864)
print v(xbgr.mr_n68321184)
print v(xbgr.mr_n68321296)
print v(xbgr.mr_n68321616)
print v(xbgr.mr_n68321728)
print v(xbgr.mr_n68322048)
print v(xbgr.mr_n68322912)
print v(xbgr.mr_n68323776)
print v(xbgr.mr_n68324640)
print v(xbgr.mr_n68324752)
print v(xbgr.mr_n68325072)
print v(xbgr.mr_n68325184)
print v(xbgr.mr_n68325504)
print v(xbgr.mr_n68326368)
print v(xbgr.mr_n68326480)
print v(xbgr.mr_n68326800)
print v(xbgr.mr_n68326912)
print v(xbgr.mr_n68327232)
print v(xbgr.mr_n68327344)
print v(xbgr.mr_n68327664)
print v(xbgr.mr_n68327776)
print v(xbgr.mr_n68328096)
print v(xbgr.mr_n68328960)
print v(xbgr.mr_n68329824)
print v(xbgr.mr_n68329936)
print v(xbgr.mr_n68330256)
print v(xbgr.mr_n68330368)
print v(xbgr.mr_n68330688)
print v(xbgr.mr_n68330800)
print v(xbgr.mr_n68331120)
print v(xbgr.mr_n68331232)
print v(xbgr.mr_n68331552)
print v(xbgr.mr_n68331664)
print v(xbgr.mr_n68331984)
print v(xbgr.mr_n68332096)
print v(xbgr.mr_n68332848)
print v(xbgr.mr_n68333712)
print v(xbgr.mr_n68334576)
print v(xbgr.mr_n68334688)
print v(xbgr.mr_n68335008)
print v(xbgr.mr_n68335120)
print v(xbgr.mr_n68335440)
print v(xbgr.mr_n68335552)
print v(xbgr.mr_n68335872)
print v(xbgr.mr_n68335984)
print v(xbgr.mr_n68336416)
print v(xbgr.mr_n68336736)
print v(xbgr.mr_n68336848)
print v(xbgr.mr_n68337600)
print v(xbgr.mr_n68338464)
print v(xbgr.mr_n68339328)
print v(xbgr.mr_n68340192)
print v(xbgr.mr_n68340304)
print v(xbgr.mr_n68340624)
print v(xbgr.mr_n68340736)
print v(xbgr.mr_n68341056)
print v(xbgr.mr_n68341168)
print v(xbgr.mr_n68341488)
print v(xbgr.mr_n68341600)
print v(xbgr.mr_n68341920)
print v(xbgr.mr_n68342784)
print v(xbgr.mr_n68344080)
print v(xbgr.mr_n68344192)
print v(xbgr.mr_n68344512)
print v(xbgr.mr_n68344624)
print v(xbgr.mr_n68345056)
print v(xbgr.mr_n68345376)
print v(xbgr.mr_n68345488)
print v(xbgr.mr_n68345920)
print v(xbgr.mr_n68346240)
print v(xbgr.mr_n68346672)
print v(xbgr.mr_n68347536)
print v(xbgr.mr_n68348400)
print v(xbgr.mr_n68348512)
print v(xbgr.mr_n68348832)
print v(xbgr.mr_n68348944)
print v(xbgr.mr_n68349376)
print v(xbgr.mr_n68349696)
print v(xbgr.mr_n68349808)
print v(xbgr.mr_n68350128)
print v(xbgr.mr_n68350240)
print v(xbgr.mr_n68350560)
print v(xbgr.mr_n68350672)
print v(xbgr.mr_n68350992)
print v(xbgr.mr_n68351104)
print v(xbgr.mr_n68351536)
print v(xbgr.mr_n68351968)
print v(xbgr.mr_n68352400)
print v(xbgr.mr_n68352832)
print v(xbgr.mr_n68353152)
print v(xbgr.mr_n68353264)
print v(xbgr.mr_n68353696)
print v(xbgr.mr_n68354016)
print v(xbgr.mr_n68354880)
print v(xbgr.mr_n68355744)
print v(xbgr.mr_n68356176)
print v(xbgr.mr_n68357040)
print v(xbgr.mr_n68357472)
print v(xbgr.mr_n68357584)
print v(xbgr.mr_n68358336)
print v(xbgr.mr_n68359200)
print v(xbgr.mr_n68360064)
print v(xbgr.mr_n68360176)
print v(xbgr.mr_n68360608)
print v(xbgr.mr_n68360928)
print v(xbgr.mr_n68361792)
print v(xbgr.mr_n68361904)
print v(xbgr.mr_n68362224)
print v(xbgr.mr_n68362336)
print v(xbgr.mr_n68362656)
print v(xbgr.mr_n68362768)
print v(xbgr.mr_n68363088)
print v(xbgr.mr_n68363200)
print v(xbgr.mr_n68363520)
print v(xbgr.mr_n68363632)
print v(xbgr.mr_n68363952)
print v(xbgr.mr_n68364064)
print v(xbgr.mr_n68364384)
print v(xbgr.mr_n68364496)
print v(xbgr.mr_n68364816)
print v(xbgr.mr_n68364928)
print v(xbgr.mr_n68365248)
print v(xbgr.mr_n68365360)
print v(xbgr.mr_n68365680)
print v(xbgr.mr_n68365792)
print v(xbgr.mr_n68366544)
print v(xbgr.mr_n68367840)
print v(xbgr.mr_n68368704)
print v(xbgr.mr_n68370000)
print v(xbgr.mr_n68370112)
print v(xbgr.mr_n68370432)
print v(xbgr.mr_n68370544)
print v(xbgr.mr_n68370864)
print v(xbgr.mr_n68370976)
print v(xbgr.mr_n68371296)
print v(xbgr.mr_n68371408)
print v(xbgr.mr_n68372160)
print v(xbgr.mr_n68373024)
print v(xbgr.mr_n68373888)
print v(xbgr.mr_n68374752)
print v(xbgr.mr_n68374864)
print v(xbgr.mr_n68375184)
print v(xbgr.mr_n68375296)
print v(xbgr.mr_n68375616)
print v(xbgr.mr_n68375728)
print v(xbgr.mr_n68376048)
print v(xbgr.mr_n68376160)
print v(xbgr.mr_n68376480)
print v(xbgr.mr_n68376592)
print v(xbgr.mr_n68376912)
print v(xbgr.mr_n68377456)
print v(xbgr.mr_n68378208)
print v(xbgr.mr_n68379072)
print v(xbgr.mr_n68379184)
print v(xbgr.mr_n68379504)
print v(xbgr.mr_n68379616)
print v(xbgr.mr_n68380048)
print v(xbgr.mr_n68380368)
print v(xbgr.mr_n68380480)
print v(xbgr.mr_n68380800)
print v(xbgr.mr_n68380912)
print v(xbgr.mr_n68381232)
print v(xbgr.mr_n68381344)
print v(xbgr.mr_n68381664)
print v(xbgr.mr_n68381776)
print v(xbgr.mr_n68382096)
print v(xbgr.mr_n68382528)
print v(xbgr.mr_n68382640)
print v(xbgr.mr_n68382960)
print v(xbgr.mr_n68383072)
print v(xbgr.mr_n68383824)
print v(xbgr.mr_n68383936)
print v(xbgr.mr_n68384256)
print v(xbgr.mr_n68384368)
print v(xbgr.mr_n68385120)
print v(xbgr.mr_n68385984)
print v(xbgr.mr_n68386096)
print v(xbgr.mr_n68386416)
print v(xbgr.mr_n68387280)
print v(xbgr.mr_n68387824)
print v(xbgr.mr_n68388144)
print v(xbgr.mr_n68388688)
print v(xbgr.mr_n68389120)
print v(xbgr.mr_n68389440)
print v(xbgr.mr_n68389552)
print v(xbgr.mr_n68390304)
print v(xbgr.mr_n68390416)
print v(xbgr.mr_n68390736)
print v(xbgr.mr_n68390848)
print v(xbgr.mr_n68391168)
print v(xbgr.mr_n68392032)
print v(xbgr.mr_n68392464)
print v(xbgr.mr_n68392576)
print v(xbgr.mr_n68392896)
print v(xbgr.mr_n68393008)
print v(xbgr.mr_n68393328)
print v(xbgr.mr_n68393440)
print v(xbgr.mr_n68393760)
print v(xbgr.mr_n68393872)
print v(xbgr.mr_n68394192)
print v(xbgr.mr_n68394304)
print v(xbgr.mr_n68395488)
print v(xbgr.mr_n68395600)
print v(xbgr.mr_n68395920)
print v(xbgr.mr_n68396032)
print v(xbgr.mr_n68396352)
print v(xbgr.mr_n68396464)
print v(xbgr.mr_n68396784)
print v(xbgr.mr_n68397216)
print v(xbgr.mr_n68529600)
print v(xbgr.mr_n68529712)
print v(xbgr.mr_n68530032)
print v(xbgr.mr_n68530144)
print v(xbgr.mr_n68530464)
print v(xbgr.mr_n68530576)
print v(xbgr.mr_n68530896)
print v(xbgr.mr_n68531008)
print v(xbgr.mr_n68531328)
print v(xbgr.mr_n68531440)
print v(xbgr.mr_n68531760)
print v(xbgr.mr_n68531872)
print v(xbgr.mr_n68532192)
print v(xbgr.mr_n68532304)
print v(xbgr.mr_n68532624)
print v(xbgr.mr_n68532736)
print v(xbgr.mr_n68533056)
print v(xbgr.mr_n68533168)
print v(xbgr.mr_n68533488)
print v(xbgr.mr_n68533600)
print v(xbgr.mr_n68533920)
print v(xbgr.mr_n68534032)
print v(xbgr.mr_n68534352)
print v(xbgr.mr_n68534464)
print v(xbgr.mr_n68534784)
print v(xbgr.mr_n68534896)
print v(xbgr.mr_n68535216)
print v(xbgr.mr_n68535328)
print v(xbgr.mr_n68535648)
print v(xbgr.mr_n68535760)
print v(xbgr.mr_n68536080)
print v(xbgr.mr_n68536192)
print v(xbgr.mr_n68536512)
print v(xbgr.mr_n68536624)
print v(xbgr.mr_n68536944)
print v(xbgr.mr_n68537056)
print v(xbgr.mr_n68537376)
print v(xbgr.mr_n68537488)
print v(xbgr.mr_n68537808)
print v(xbgr.mr_n68537920)
print v(xbgr.mr_n68538240)
print v(xbgr.mr_n68538352)
print v(xbgr.mr_n68538672)
print v(xbgr.mr_n68538784)
print v(xbgr.mr_n68539104)
print v(xbgr.mr_n68539216)
print v(xbgr.mr_n68539536)
print v(xbgr.mr_n68539648)
print v(xbgr.mr_n68539968)
print v(xbgr.mr_n68540080)
print v(xbgr.mr_n68540400)
print v(xbgr.mr_n68540512)
print v(xbgr.mr_n68540832)
print v(xbgr.mr_n68540944)
print v(xbgr.mr_n68541264)
print v(xbgr.mr_n68541376)
print v(xbgr.mr_n68541696)
print v(xbgr.mr_n68541808)
print v(xbgr.mr_n68542128)
print v(xbgr.mr_n68542240)
print v(xbgr.mr_n68542560)
print v(xbgr.mr_n68542672)
print v(xbgr.mr_n68542992)
print v(xbgr.mr_n68543104)
print v(xbgr.mr_n68543424)
print v(xbgr.mr_n68543536)
print v(xbgr.mr_n68543856)
print v(xbgr.mr_n68543968)
print v(xbgr.mr_n68544288)
print v(xbgr.mr_n68544400)
print v(xbgr.mr_n68544720)
print v(xbgr.mr_n68544832)
print v(xbgr.mr_n68545152)
print v(xbgr.mr_n68545264)
print v(xbgr.mr_n68545584)
print v(xbgr.mr_n68545696)
print v(xbgr.mr_n68546016)
print v(xbgr.mr_n68546128)
print v(xbgr.mr_n68546448)
print v(xbgr.mr_n68546560)
print v(xbgr.mr_n68546880)
print v(xbgr.mr_n68546992)
print v(xbgr.mr_n68547312)
print v(xbgr.mr_n68547424)
print v(xbgr.mr_n68547744)
print v(xbgr.mr_n68547856)
print v(xbgr.mr_n68548176)
print v(xbgr.mr_n68548288)
print v(xbgr.mr_n68548608)
print v(xbgr.mr_n68548720)
print v(xbgr.mr_n68549040)
print v(xbgr.mr_n68549152)
print v(xbgr.mr_n68549472)
print v(xbgr.mr_n68549584)
print v(xbgr.mr_n68549904)
print v(xbgr.mr_n68550016)
print v(xbgr.mr_n68550336)
print v(xbgr.mr_n68550448)
print v(xbgr.mr_n68550768)
print v(xbgr.mr_n68550880)
print v(xbgr.mr_n68551200)
print v(xbgr.mr_n68551312)
print v(xbgr.mr_n68551632)
print v(xbgr.mr_n68551744)
print v(xbgr.mr_n68552064)
print v(xbgr.mr_n68552176)
print v(xbgr.mr_n68552496)
print v(xbgr.mr_n68552608)
print v(xbgr.mr_n68552928)
print v(xbgr.mr_n68553040)
print v(xbgr.mr_n68553360)
print v(xbgr.mr_n68553472)
print v(xbgr.mr_n68553792)
print v(xbgr.mr_n68553904)
print v(xbgr.mr_n68554224)
print v(xbgr.mr_n68554336)
print v(xbgr.mr_n68554656)
print v(xbgr.mr_n68554768)
print v(xbgr.mr_n68555088)
print v(xbgr.mr_n68555200)
print v(xbgr.mr_n68555520)
print v(xbgr.mr_n68555632)
print v(xbgr.mr_n68555952)
print v(xbgr.mr_n68556064)
print v(xbgr.mr_n68556384)
print v(xbgr.mr_n68556496)
print v(xbgr.mr_n68556816)
print v(xbgr.mr_n68556928)
print v(xbgr.mr_n68557248)
print v(xbgr.mr_n68557360)
print v(xbgr.mr_n68557680)
print v(xbgr.mr_n68557792)
print v(xbgr.mr_n68558112)
print v(xbgr.mr_n68558224)
print v(xbgr.mr_n68558544)
print v(xbgr.mr_n68558656)
print v(xbgr.mr_n68558976)
print v(xbgr.mr_n68559088)
print v(xbgr.mr_n68559408)
print v(xbgr.mr_n68559520)
print v(xbgr.mr_n68559840)
print v(xbgr.mr_n68559952)
print v(xbgr.mr_n68560272)
print v(xbgr.mr_n68560384)
print v(xbgr.mr_n68560704)
print v(xbgr.mr_n68560816)
print v(xbgr.mr_n68561136)
print v(xbgr.mr_n68561248)
print v(xbgr.mr_n68561568)
print v(xbgr.mr_n68561680)
print v(xbgr.mr_n68562000)
print v(xbgr.mr_n68562112)
print v(xbgr.mr_n68562432)
print v(xbgr.mr_n68562544)
print v(xbgr.mr_n68562864)
print v(xbgr.mr_n68562976)
print v(xbgr.mr_n68563296)
print v(xbgr.mr_n68563408)
print v(xbgr.mr_n68563728)
print v(xbgr.mr_n68563840)
print v(xbgr.mr_n68564160)
print v(xbgr.mr_n68564272)
print v(xbgr.mr_n68564592)
print v(xbgr.mr_n68564704)
print v(xbgr.mr_n68565024)
print v(xbgr.mr_n68565136)
print v(xbgr.mr_n68565456)
print v(xbgr.mr_n68565568)
print v(xbgr.mr_n68565888)
print v(xbgr.mr_n68566000)
print v(xbgr.mr_n68566320)
print v(xbgr.mr_n68566432)
print v(xbgr.mr_n68566752)
print v(xbgr.mr_n68566864)
print v(xbgr.mr_n68567184)
print v(xbgr.mr_n68567296)
print v(xbgr.mr_n68567616)
print v(xbgr.mr_n68567728)
print v(xbgr.mr_n68568048)
print v(xbgr.mr_n68568160)
print v(xbgr.mr_n68568480)
print v(xbgr.mr_n68568592)
print v(xbgr.mr_n68568912)
print v(xbgr.mr_n68569024)
print v(xbgr.mr_n68569344)
print v(xbgr.mr_n68569456)
print v(xbgr.mr_n68569776)
print v(xbgr.mr_n68569888)
print v(xbgr.mr_n68570208)
print v(xbgr.mr_n68570320)
print v(xbgr.mr_n68570640)
print v(xbgr.mr_n68570752)
print v(xbgr.mr_n68571072)
print v(xbgr.mr_n68571184)
print v(xbgr.mr_n68571504)
print v(xbgr.mr_n68571616)
print v(xbgr.mr_n68571936)
print v(xbgr.mr_n68572048)
print v(xbgr.mr_n68572368)
print v(xbgr.mr_n68572480)
print v(xbgr.mr_n68572800)
print v(xbgr.mr_n68572912)
print v(xbgr.mr_n68573232)
print v(xbgr.mr_n68573344)
print v(xbgr.mr_n68573664)
print v(xbgr.mr_n68573776)
print v(xbgr.mr_n68574096)
print v(xbgr.mr_n68574208)
print v(xbgr.mr_n68574528)
print v(xbgr.mr_n68574640)
print v(xbgr.mr_n68574960)
print v(xbgr.mr_n68575072)
print v(xbgr.mr_n68575392)
print v(xbgr.mr_n68575504)
print v(xbgr.mr_n68575824)
print v(xbgr.mr_n68575936)
print v(xbgr.mr_n68576256)
print v(xbgr.mr_n68576368)
print v(xbgr.mr_n68576688)
print v(xbgr.mr_n68576800)
print v(xbgr.mr_n68577120)
print v(xbgr.mr_n68577232)
print v(xbgr.mr_n68577552)
print v(xbgr.mr_n68577664)
print v(xbgr.mr_n68577984)
print v(xbgr.mr_n68578096)
print v(xbgr.mr_n68578416)
print v(xbgr.mr_n68578528)
print v(xbgr.mr_n68578848)
print v(xbgr.mr_n68578960)
print v(xbgr.mr_n68579280)
print v(xbgr.mr_n68579392)
print v(xbgr.mr_n68579712)
print v(xbgr.mr_n68579824)
print v(xbgr.mr_n68580144)
print v(xbgr.mr_n68580256)
print v(xbgr.mr_n68580576)
print v(xbgr.mr_n68580688)
print v(xbgr.mr_n68581008)
print v(xbgr.mr_n68581120)
print v(xbgr.mr_n68581440)
print v(xbgr.mr_n68581552)
print v(xbgr.mr_n68581872)
print v(xbgr.mr_n68581984)
print v(xbgr.mr_n68582304)
print v(xbgr.mr_n68582416)
print v(xbgr.mr_n68582736)
print v(xbgr.mr_n68582848)
print v(xbgr.mr_n68583168)
print v(xbgr.mr_n68583280)
print v(xbgr.mr_n68583600)
print v(xbgr.mr_n68583712)
print v(xbgr.mr_n68584032)
print v(xbgr.mr_n68584144)
print v(xbgr.mr_n68584464)
print v(xbgr.mr_n68584576)
print v(xbgr.mr_n68584896)
print v(xbgr.mr_n68585008)
print v(xbgr.mr_n68585328)
print v(xbgr.mr_n68585440)
print v(xbgr.mr_n68585760)
print v(xbgr.mr_n68585872)
print v(xbgr.mr_n68586192)
print v(xbgr.mr_n68586304)
print v(xbgr.mr_n68586624)
print v(xbgr.mr_n68586736)
print v(xbgr.mr_n68587056)
print v(xbgr.mr_n68587168)
print v(xbgr.mr_n68587488)
print v(xbgr.mr_n68587600)
print v(xbgr.mr_n68587920)
print v(xbgr.mr_n68588032)
print v(xbgr.mr_n68588352)
print v(xbgr.mr_n68588464)
print v(xbgr.mr_n68588784)
print v(xbgr.mr_n68588896)
print v(xbgr.mr_n68589216)
print v(xbgr.mr_n68589328)
print v(xbgr.mr_n68589648)
print v(xbgr.mr_n68589760)
print v(xbgr.mr_n68590080)
print v(xbgr.mr_n68590192)
print v(xbgr.mr_n68590512)
print v(xbgr.mr_n68590624)
print v(xbgr.mr_n68590944)
print v(xbgr.mr_n68591056)
print v(xbgr.mr_n68591376)
print v(xbgr.mr_n68591488)
print v(xbgr.mr_n68591808)
print v(xbgr.mr_n68591920)
print v(xbgr.mr_n68592240)
print v(xbgr.mr_n68592352)
print v(xbgr.mr_n68592672)
print v(xbgr.mr_n68592784)
print v(xbgr.mr_n68593104)
print v(xbgr.mr_n68593216)
print v(xbgr.mr_n68593536)
print v(xbgr.mr_n68593648)
print v(xbgr.mr_n68593968)
print v(xbgr.mr_n68594080)
print v(xbgr.mr_n68594400)
print v(xbgr.mr_n68594512)
print v(xbgr.mr_n68594832)
print v(xbgr.mr_n68594944)
print v(xbgr.mr_n68595264)
print v(xbgr.mr_n68595376)
print v(xbgr.mr_n68595696)
print v(xbgr.mr_n68595808)
print v(xbgr.mr_n68596128)
print v(xbgr.mr_n68596240)
print v(xbgr.mr_n68596560)
print v(xbgr.mr_n68596672)
print v(xbgr.mr_n68596992)
print v(xbgr.mr_n68597104)
print v(xbgr.mr_n68597424)
print v(xbgr.mr_n68597536)
print v(xbgr.mr_n68597856)
print v(xbgr.mr_n68597968)
print v(xbgr.mr_n68598288)
print v(xbgr.mr_n68598400)
print v(xbgr.mr_n68598720)
print v(xbgr.mr_n68598832)
print v(xbgr.mr_n68599152)
print v(xbgr.mr_n68599264)
print v(xbgr.mr_n68599584)
print v(xbgr.mr_n68599696)
print v(xbgr.mr_n68600016)
print v(xbgr.mr_n68600128)
print v(xbgr.mr_n68600448)
print v(xbgr.mr_n68600560)
print v(xbgr.mr_n68600880)
print v(xbgr.mr_n68600992)
print v(xbgr.mr_n68601312)
print v(xbgr.mr_n68601424)
print v(xbgr.mr_n68601744)
print v(xbgr.mr_n68601856)
print v(xbgr.mr_n68602176)
print v(xbgr.mr_n68602288)
print v(xbgr.mr_n68602608)
print v(xbgr.mr_n68602720)
print v(xbgr.mr_n68603040)
print v(xbgr.mr_n68603152)
print v(xbgr.mr_n68603472)
print v(xbgr.mr_n68603584)
print v(xbgr.mr_n68603904)
print v(xbgr.mr_n68604016)
print v(xbgr.mr_n68604336)
print v(xbgr.mr_n68604448)
print v(xbgr.mr_n68604768)
print v(xbgr.mr_n68604880)
print v(xbgr.mr_n68605200)
print v(xbgr.mr_n68605312)
print v(xbgr.mr_n68605632)
print v(xbgr.mr_n68605744)
print v(xbgr.mr_n68606064)
print v(xbgr.mr_n68606176)
print v(xbgr.mr_n68606496)
print v(xbgr.mr_n68606608)
print v(xbgr.mr_n68606928)
print v(xbgr.mr_n68607040)
print v(xbgr.mr_n68607360)
print v(xbgr.mr_n68607472)
print v(xbgr.mr_n68607792)
print v(xbgr.mr_n68607904)
print v(xbgr.mr_n68608224)
print v(xbgr.mr_n68608336)
print v(xbgr.mr_n68608656)
print v(xbgr.mr_n68608768)
print v(xbgr.mr_n68609088)
print v(xbgr.mr_n68609200)
print v(xbgr.mr_n68609520)
print v(xbgr.mr_n68609632)
print v(xbgr.mr_n68609952)
print v(xbgr.mr_n68610064)
print v(xbgr.mr_n68610384)
print v(xbgr.mr_n68610496)
print v(xbgr.mr_n68610816)
print v(xbgr.mr_n68610928)
print v(xbgr.mr_n68611248)
print v(xbgr.mr_n68611360)
print v(xbgr.mr_n68611680)
print v(xbgr.mr_n68611792)
print v(xbgr.mr_n68612112)
print v(xbgr.mr_n68612224)
print v(xbgr.mr_n68612528)
print v(xbgr.mr_n68612640)
print v(xbgr.mr_n68612960)
print v(xbgr.mr_n68613072)
print v(xbgr.mr_n68613392)
print v(xbgr.mr_n68613504)
print v(xbgr.mr_n68613824)
print v(xbgr.mr_n68613936)
print v(xbgr.mr_n68614256)
print v(xbgr.mr_n68614368)
print v(xbgr.mr_n68614688)
print v(xbgr.mr_n68614800)
print v(xbgr.mr_n68615120)
print v(xbgr.mr_n68615232)
print v(xbgr.mr_n68615552)
print v(xbgr.mr_n68615664)
print v(xbgr.mr_n68615984)
print v(xbgr.mr_n68616096)
print v(xbgr.mr_n68616416)
print v(xbgr.mr_n68616528)
print v(xbgr.mr_n68616848)
print v(xbgr.mr_n68616960)
print v(xbgr.mr_n68617280)
print v(xbgr.mr_n68617392)
print v(xbgr.mr_n68617712)
print v(xbgr.mr_n68617824)
print v(xbgr.mr_n68618144)
print v(xbgr.mr_n68618256)
print v(xbgr.mr_n68618576)
print v(xbgr.mr_n68618688)
print v(xbgr.mr_n68619008)
print v(xbgr.mr_n68619120)
print v(xbgr.mr_n68619440)
print v(xbgr.mr_n68619552)
print v(xbgr.mr_n68619872)
print v(xbgr.mr_n68619984)
print v(xbgr.mr_n68620304)
print v(xbgr.mr_n68620416)
print v(xbgr.mr_n68620736)
print v(xbgr.mr_n68620848)
print v(xbgr.mr_n68621168)
print v(xbgr.mr_n68621280)
print v(xbgr.mr_n68621600)
print v(xbgr.mr_n68621712)
print v(xbgr.mr_n68622032)
print v(xbgr.mr_n68622144)
print v(xbgr.mr_n68622464)
print v(xbgr.mr_n68622576)
print v(xbgr.mr_n68622896)
print v(xbgr.mr_n68623008)
print v(xbgr.mr_n68623328)
print v(xbgr.mr_n68623440)
print v(xbgr.mr_n68623760)
print v(xbgr.mr_n68623872)
print v(xbgr.mr_n68624192)
print v(xbgr.mr_n68624304)
print v(xbgr.mr_n68624624)
print v(xbgr.mr_n68624736)
print v(xbgr.mr_n68625056)
print v(xbgr.mr_n68625168)
print v(xbgr.mr_n68625488)
print v(xbgr.mr_n68625600)
print v(xbgr.mr_n68625920)
print v(xbgr.mr_n68626032)
print v(xbgr.mr_n68626352)
print v(xbgr.mr_n68626464)
print v(xbgr.mr_n68626784)
print v(xbgr.mr_n68626896)
print v(xbgr.mr_n68627216)
print v(xbgr.mr_n68627328)
print v(xbgr.mr_n68627648)
print v(xbgr.mr_n68627760)
print v(xbgr.mr_n68628080)
print v(xbgr.mr_n68628192)
print v(xbgr.mr_n68628512)
print v(xbgr.mr_n68628624)
print v(xbgr.mr_n68628944)
print v(xbgr.mr_n68629056)
print v(xbgr.mr_n68629376)
print v(xbgr.mr_n68629488)
print v(xbgr.mr_n68629808)
print v(xbgr.mr_n68629920)
print v(xbgr.mr_n68630240)
print v(xbgr.mr_n68630352)
print v(xbgr.mr_n68630672)
print v(xbgr.mr_n68630784)
print v(xbgr.mr_n68631104)
print v(xbgr.mr_n68631216)
print v(xbgr.mr_n68631536)
print v(xbgr.mr_n68631648)
print v(xbgr.mr_n68631968)
print v(xbgr.mr_n68632080)
print v(xbgr.mr_n68632400)
print v(xbgr.mr_n68632512)
print v(xbgr.mr_n68632832)
print v(xbgr.mr_n68632944)
print v(xbgr.mr_n68633264)
print v(xbgr.mr_n68633376)
print v(xbgr.mr_n68633696)
print v(xbgr.mr_n68633808)
print v(xbgr.mr_n68634128)
print v(xbgr.mr_n68634240)
print v(xbgr.mr_n68634560)
print v(xbgr.mr_n68634672)
print v(xbgr.mr_n68634992)
print v(xbgr.mr_n68635104)
print v(xbgr.mr_n68635424)
print v(xbgr.mr_n68635536)
print v(xbgr.mr_n68635856)
print v(xbgr.mr_n68635968)
print v(xbgr.mr_n68636288)
print v(xbgr.mr_n68636400)
print v(xbgr.mr_n68636720)
print v(xbgr.mr_n68636832)
print v(xbgr.mr_n68637152)
print v(xbgr.mr_n68637264)
print v(xbgr.mr_n68637584)
print v(xbgr.mr_n68637696)
print v(xbgr.mr_n68638016)
print v(xbgr.mr_n68638128)
print v(xbgr.mr_n68638448)
print v(xbgr.mr_n68638560)
print v(xbgr.mr_n68638880)
print v(xbgr.mr_n68638992)
print v(xbgr.mr_n68639312)
print v(xbgr.mr_n68639424)
print v(xbgr.mr_n68639744)
print v(xbgr.mr_n68639856)
print v(xbgr.mr_n68640176)
print v(xbgr.mr_n68640288)
print v(xbgr.mr_n68640608)
print v(xbgr.mr_n68640720)
print v(xbgr.mr_n68641040)
print v(xbgr.mr_n68641152)
print v(xbgr.mr_n68641472)
print v(xbgr.mr_n68641584)
print v(xbgr.mr_n68641904)
print v(xbgr.mr_n68642016)
print v(xbgr.mr_n68642336)
print v(xbgr.mr_n68642448)
print v(xbgr.mr_n68642768)
print v(xbgr.mr_n68642880)
print v(xbgr.mr_n68643200)
print v(xbgr.mr_n68643312)
print v(xbgr.mr_n68643632)
print v(xbgr.mr_n68643744)
print v(xbgr.mr_n68644064)
print v(xbgr.mr_n68644176)
print v(xbgr.mr_n68644496)
print v(xbgr.mr_n68644608)
print v(xbgr.mr_n68644928)
print v(xbgr.mr_n68645040)
print v(xbgr.mr_n68645360)
print v(xbgr.mr_n68645472)
print v(xbgr.mr_n68645792)
print v(xbgr.mr_n68645904)
print v(xbgr.mr_n68646224)
print v(xbgr.mr_n68646336)
print v(xbgr.mr_n68646656)
print v(xbgr.mr_n68646768)
print v(xbgr.mr_n68647088)
print v(xbgr.mr_n68647200)
print v(xbgr.mr_n68647520)
print v(xbgr.mr_n68647632)
print v(xbgr.mr_n68647952)
print v(xbgr.mr_n68648064)
print v(xbgr.mr_n68648384)
print v(xbgr.mr_n68648496)
print v(xbgr.mr_n68648816)
print v(xbgr.mr_n68648928)
print v(xbgr.mr_n68649248)
print v(xbgr.mr_n68649360)
print v(xbgr.mr_n68649680)
print v(xbgr.mr_n68649792)
print v(xbgr.mr_n68650112)
print v(xbgr.mr_n68650224)
print v(xbgr.mr_n68650544)
print v(xbgr.mr_n68650656)
print v(xbgr.mr_n68650976)
print v(xbgr.mr_n68651088)
print v(xbgr.mr_n68651408)
print v(xbgr.mr_n68651520)
print v(xbgr.mr_n68651840)
print v(xbgr.mr_n68651952)
print v(xbgr.mr_n68652272)
print v(xbgr.mr_n68652384)
print v(xbgr.mr_n68652704)
print v(xbgr.mr_n68652816)
print v(xbgr.mr_n68653136)
print v(xbgr.mr_n68653248)
print v(xbgr.mr_n68653568)
print v(xbgr.mr_n68653680)
print v(xbgr.mr_n68654000)
print v(xbgr.mr_n68654112)
print v(xbgr.mr_n68654432)
print v(xbgr.mr_n68654544)
print v(xbgr.mr_n68654864)
print v(xbgr.mr_n68654976)
print v(xbgr.mr_n68655296)
print v(xbgr.mr_n68655408)
print v(xbgr.mr_n68655728)
print v(xbgr.mr_n68655840)
print v(xbgr.mr_n68656160)
print v(xbgr.mr_n68656272)
print v(xbgr.mr_n68656592)
print v(xbgr.mr_n68656704)
print v(xbgr.mr_n68657024)
print v(xbgr.mr_n68657136)
print v(xbgr.mr_n68657456)
print v(xbgr.mr_n68657568)
print v(xbgr.mr_n68657888)
print v(xbgr.mr_n68658000)
print v(xbgr.mr_n68658320)
print v(xbgr.mr_n68658432)
print v(xbgr.mr_n68658752)
print v(xbgr.mr_n68658864)
print v(xbgr.mr_n68659184)
print v(xbgr.mr_n68659296)
print v(xbgr.mr_n68659616)
print v(xbgr.mr_n68659728)
print v(xbgr.mr_n68660048)
print v(xbgr.mr_n68660160)
print v(xbgr.mr_n68660480)
print v(xbgr.mr_n68660688)
print v(xbgr.mr_n68660928)
print v(xbgr.mr_n68661792)
print v(xbgr.mr_n68661904)
print v(xbgr.mr_n68662224)
print v(xbgr.mr_n68662336)
print v(xbgr.mr_n68662656)
print v(xbgr.mr_n68662768)
print v(xbgr.mr_n68663088)
print v(xbgr.mr_n68663200)
print v(xbgr.mr_n68663520)
print v(xbgr.mr_n68663632)
print v(xbgr.mr_n68663952)
print v(xbgr.mr_n68664064)
print v(xbgr.mr_n68664384)
print v(xbgr.mr_n68665248)
print v(xbgr.mr_n68666112)
print v(xbgr.mr_n68666976)
print v(xbgr.mr_n68667088)
print v(xbgr.mr_n68667840)
print v(xbgr.mr_n68667952)
print v(xbgr.mr_n68668272)
print v(xbgr.mr_n68669136)
print v(xbgr.mr_n68670000)
print v(xbgr.mr_n68670864)
print v(xbgr.mr_n68671728)
print v(xbgr.mr_n68672272)
print v(xbgr.mr_n68673024)
print v(xbgr.mr_n68673568)
print v(xbgr.mr_n68674000)
print v(xbgr.mr_n68674752)
print v(xbgr.mr_n68674864)
print v(xbgr.mr_n68675184)
print v(xbgr.mr_n68675296)
print v(xbgr.mr_n68675616)
print v(xbgr.mr_n68676480)
print v(xbgr.mr_n68677344)
print v(xbgr.mr_n68678208)
print v(xbgr.mr_n68678320)
print v(xbgr.mr_n68678640)
print v(xbgr.mr_n68678752)
print v(xbgr.mr_n68679184)
print v(xbgr.mr_n68679504)
print v(xbgr.mr_n68679616)
print v(xbgr.mr_n68679936)
print v(xbgr.mr_n68680800)
print v(xbgr.mr_n68680912)
print v(xbgr.mr_n68681344)
print v(xbgr.mr_n68681664)
print v(xbgr.mr_n68681776)
print v(xbgr.mr_n68682096)
print v(xbgr.mr_n68682208)
print v(xbgr.mr_n68682528)
print v(xbgr.mr_n68682640)
print v(xbgr.mr_n68682960)
print v(xbgr.mr_n68683072)
print v(xbgr.mr_n68683392)
print v(xbgr.mr_n68684368)
print v(xbgr.mr_n68684688)
print v(xbgr.mr_n68684800)
print v(xbgr.mr_n68685120)
print v(xbgr.mr_n68685232)
print v(xbgr.mr_n68685552)
print v(xbgr.mr_n68685664)
print v(xbgr.mr_n68685984)
print v(xbgr.mr_n68686096)
print v(xbgr.mr_n68686416)
print v(xbgr.mr_n68686848)
print v(xbgr.mr_n68687824)
print v(xbgr.mr_n68688144)
print v(xbgr.mr_n68689008)
print v(xbgr.mr_n68689872)
print v(xbgr.mr_n68689984)
print v(xbgr.mr_n68690736)
print v(xbgr.mr_n68691600)
print v(xbgr.mr_n68691712)
print v(xbgr.mr_n68692032)
print v(xbgr.mr_n68692896)
print v(xbgr.mr_n68693008)
print v(xbgr.mr_n68693328)
print v(xbgr.mr_n68693440)
print v(xbgr.mr_n68693760)
print v(xbgr.mr_n68694624)
print v(xbgr.mr_n68694736)
print v(xbgr.mr_n68695056)
print v(xbgr.mr_n68695168)
print v(xbgr.mr_n68695488)
print v(xbgr.mr_n68695600)
print v(xbgr.mr_n68695920)
print v(xbgr.mr_n68696032)
print v(xbgr.mr_n68696352)
print v(xbgr.mr_n68697328)
print v(xbgr.mr_n68697760)
print v(xbgr.mr_n68698080)
print v(xbgr.mr_n68698944)
print v(xbgr.mr_n68699808)
print v(xbgr.mr_n68699920)
print v(xbgr.mr_n68700240)
print v(xbgr.mr_n68700352)
print v(xbgr.mr_n68700672)
print v(xbgr.mr_n68700784)
print v(xbgr.mr_n68701104)
print v(xbgr.mr_n68701216)
print v(xbgr.mr_n68701648)
print v(xbgr.mr_n68702080)
print v(xbgr.mr_n68702400)
print v(xbgr.mr_n68702512)
print v(xbgr.mr_n68702832)
print v(xbgr.mr_n68702944)
print v(xbgr.mr_n68703264)
print v(xbgr.mr_n68703376)
print v(xbgr.mr_n68703696)
print v(xbgr.mr_n68703808)
print v(xbgr.mr_n68704128)
print v(xbgr.mr_n68704992)
print v(xbgr.mr_n68705856)
print v(xbgr.mr_n68705968)
print v(xbgr.mr_n68706288)
print v(xbgr.mr_n68707152)
print v(xbgr.mr_n68708016)
print v(xbgr.mr_n68708128)
print v(xbgr.mr_n68708448)
print v(xbgr.mr_n68708560)
print v(xbgr.mr_n68708992)
print v(xbgr.mr_n68709312)
print v(xbgr.mr_n68709424)
print v(xbgr.mr_n68709856)
print v(xbgr.mr_n68710176)
print v(xbgr.mr_n68710608)
print v(xbgr.mr_n68710720)
print v(xbgr.mr_n68711040)
print v(xbgr.mr_n68711152)
print v(xbgr.mr_n68711472)
print v(xbgr.mr_n68711904)
print v(xbgr.mr_n68712016)
print v(xbgr.mr_n68712768)
print v(xbgr.mr_n68712880)
print v(xbgr.mr_n68713200)
print v(xbgr.mr_n68713312)
print v(xbgr.mr_n68713632)
print v(xbgr.mr_n68714064)
print v(xbgr.mr_n68714176)
print v(xbgr.mr_n68714496)
print v(xbgr.mr_n68714928)
print v(xbgr.mr_n68715792)
print v(xbgr.mr_n68717520)
print v(xbgr.mr_n68717632)
print v(xbgr.mr_n68717952)
print v(xbgr.mr_n68718064)
print v(xbgr.mr_n68718384)
print v(xbgr.mr_n68718496)
print v(xbgr.mr_n68718928)
print v(xbgr.mr_n68719360)
print v(xbgr.mr_n68719680)
print v(xbgr.mr_n68719792)
print v(xbgr.mr_n68720112)
print v(xbgr.mr_n68721520)
print v(xbgr.mr_n68721840)
print v(xbgr.mr_n68722816)
print v(xbgr.mr_n68723136)
print v(xbgr.mr_n68723248)
print v(xbgr.mr_n68723568)
print v(xbgr.mr_n68723680)
print v(xbgr.mr_n68724112)
print v(xbgr.mr_n68724432)
print v(xbgr.mr_n68724544)
print v(xbgr.mr_n68724976)
print v(xbgr.mr_n68725296)
print v(xbgr.mr_n68725408)
print v(xbgr.mr_n68725728)
print v(xbgr.mr_n68725840)
print v(xbgr.mr_n68726160)
print v(xbgr.mr_n68727024)
print v(xbgr.mr_n68727456)
print v(xbgr.mr_n68728320)
print v(xbgr.mr_n68728432)
print v(xbgr.mr_n68728752)
print v(xbgr.mr_n68728864)
print v(xbgr.mr_n68729184)
print v(xbgr.mr_n68729296)
print v(xbgr.mr_n68730048)
print v(xbgr.mr_n68730480)
print v(xbgr.mr_n68730592)
print v(xbgr.mr_n68730912)
print v(xbgr.mr_n68731344)
print v(xbgr.mr_n68731456)
print v(xbgr.mr_n68731776)
print v(xbgr.mr_n68731888)
print v(xbgr.mr_n68732208)
print v(xbgr.mr_n68732320)
print v(xbgr.mr_n68732640)
print v(xbgr.mr_n68732752)
print v(xbgr.mr_n68733072)
print v(xbgr.mr_n68733184)
print v(xbgr.mr_n68733504)
print v(xbgr.mr_n68734912)
print v(xbgr.mr_n68735232)
print v(xbgr.mr_n68735344)
print v(xbgr.mr_n68735776)
print v(xbgr.mr_n68736096)
print v(xbgr.mr_n68736208)
print v(xbgr.mr_n68736528)
print v(xbgr.mr_n68736960)
print v(xbgr.mr_n68737824)
print v(xbgr.mr_n68738688)
print v(xbgr.mr_n68739552)
print v(xbgr.mr_n68740416)
print v(xbgr.mr_n68741280)
print v(xbgr.mr_n68742576)
print v(xbgr.mr_n68743008)
print v(xbgr.mr_n68743120)
print v(xbgr.mr_n68743440)
print v(xbgr.mr_n68743872)
print v(xbgr.mr_n68743984)
print v(xbgr.mr_n68744304)
print v(xbgr.mr_n68745168)
print v(xbgr.mr_n68745280)
print v(xbgr.mr_n68745600)
print v(xbgr.mr_n68745712)
print v(xbgr.mr_n68746032)
print v(xbgr.mr_n68746896)
print v(xbgr.mr_n68747008)
print v(xbgr.mr_n68747872)
print v(xbgr.mr_n68748304)
print v(xbgr.mr_n68748736)
print v(xbgr.mr_n68749488)
print v(xbgr.mr_n68749600)
print v(xbgr.mr_n68750032)
print v(xbgr.mr_n68750784)
print v(xbgr.mr_n68751216)
print v(xbgr.mr_n68751328)
print v(xbgr.mr_n68751760)
print v(xbgr.mr_n68752512)
print v(xbgr.mr_n68752624)
print v(xbgr.mr_n68752944)
print v(xbgr.mr_n68753056)
print v(xbgr.mr_n68753376)
print v(xbgr.mr_n68753488)
print v(xbgr.mr_n68753808)
print v(xbgr.mr_n68753920)
print v(xbgr.mr_n68754240)
print v(xbgr.mr_n68754352)
print v(xbgr.mr_n68754672)
print v(xbgr.mr_n68754784)
print v(xbgr.mr_n68755104)
print v(xbgr.mr_n68755216)
print v(xbgr.mr_n68755536)
print v(xbgr.mr_n68755648)
print v(xbgr.mr_n68755968)
print v(xbgr.mr_n68756080)
print v(xbgr.mr_n68756400)
print v(xbgr.mr_n68756512)
print v(xbgr.mr_n68756832)
print v(xbgr.mr_n68756944)
print v(xbgr.mr_n68757264)
print v(xbgr.mr_n68757376)
print v(xbgr.mr_n68757696)
print v(xbgr.mr_n68757808)
print v(xbgr.mr_n68758128)
print v(xbgr.mr_n68758240)
print v(xbgr.mr_n68758672)
print v(xbgr.mr_n68758992)
print v(xbgr.mr_n68759104)
print v(xbgr.mr_n68759536)
print v(xbgr.mr_n68759856)
print v(xbgr.mr_n68759968)
print v(xbgr.mr_n68760720)
print v(xbgr.mr_n68761152)
print v(xbgr.mr_n68762016)
print v(xbgr.mr_n68762880)
print v(xbgr.mr_n68763744)
print v(xbgr.mr_n68763856)
print v(xbgr.mr_n68764176)
print v(xbgr.mr_n68764288)
print v(xbgr.mr_n68764608)
print v(xbgr.mr_n68764720)
print v(xbgr.mr_n68765040)
print v(xbgr.mr_n68765152)
print v(xbgr.mr_n68765904)
print v(xbgr.mr_n68766768)
print v(xbgr.mr_n68767632)
print v(xbgr.mr_n68768496)
print v(xbgr.mr_n68769792)
print v(xbgr.mr_n68769904)
print v(xbgr.mr_n68770224)
print v(xbgr.mr_n68770336)
print v(xbgr.mr_n68770656)
print v(xbgr.mr_n68770768)
print v(xbgr.mr_n68771200)
print v(xbgr.mr_n68771632)
print v(xbgr.mr_n68772064)
print v(xbgr.mr_n68772384)
print v(xbgr.mr_n68772496)
print v(xbgr.mr_n68772928)
print v(xbgr.mr_n68773248)
print v(xbgr.mr_n68773360)
print v(xbgr.mr_n68773680)
print v(xbgr.mr_n68773792)
print v(xbgr.mr_n68774112)
print v(xbgr.mr_n68774224)
print v(xbgr.mr_n68774544)
print v(xbgr.mr_n68774656)
print v(xbgr.mr_n68774976)
print v(xbgr.mr_n68775088)
print v(xbgr.mr_n68775520)
print v(xbgr.mr_n68775840)
print v(xbgr.mr_n68775952)
print v(xbgr.mr_n68776384)
print v(xbgr.mr_n68776704)
print v(xbgr.mr_n68777136)
print v(xbgr.mr_n68777248)
print v(xbgr.mr_n68777680)
print v(xbgr.mr_n68778000)
print v(xbgr.mr_n68778112)
print v(xbgr.mr_n68778544)
print v(xbgr.mr_n68778864)
print v(xbgr.mr_n68778976)
print v(xbgr.mr_n68779408)
print v(xbgr.mr_n68779728)
print v(xbgr.mr_n68779840)
print v(xbgr.mr_n68780160)
print v(xbgr.mr_n68780272)
print v(xbgr.mr_n68780592)
print v(xbgr.mr_n68781456)
print v(xbgr.mr_n68782320)
print v(xbgr.mr_n68783184)
print v(xbgr.mr_n68784048)
print v(xbgr.mr_n68784912)
print v(xbgr.mr_n68785776)
print v(xbgr.mr_n68785888)
print v(xbgr.mr_n68786640)
print v(xbgr.mr_n68787504)
print v(xbgr.mr_n68788368)
print v(xbgr.mr_n68789232)
print v(xbgr.mr_n68790096)
print v(xbgr.mr_n68790960)
print v(xbgr.mr_n68791072)
print v(xbgr.mr_n68791392)
print v(xbgr.mr_n68791504)
print v(xbgr.mr_n68791824)
print v(xbgr.mr_n68791936)
print v(xbgr.mr_n68792256)
print v(xbgr.mr_n68792368)
print v(xbgr.mr_n68792688)
print v(xbgr.mr_n68793552)
print v(xbgr.mr_n68794416)
print v(xbgr.mr_n68795280)
print v(xbgr.mr_n68795392)
print v(xbgr.mr_n68795712)
print v(xbgr.mr_n68795824)
print v(xbgr.mr_n68796144)
print v(xbgr.mr_n68796256)
print v(xbgr.mr_n68796576)
print v(xbgr.mr_n68797440)
print v(xbgr.mr_n68798304)
print v(xbgr.mr_n68799168)
print v(xbgr.mr_n68799280)
print v(xbgr.mr_n68799600)
print v(xbgr.mr_n68799712)
print v(xbgr.mr_n68800032)
print v(xbgr.mr_n68800144)
print v(xbgr.mr_n68800576)
print v(xbgr.mr_n68801008)
print v(xbgr.mr_n68801440)
print v(xbgr.mr_n68801760)
print v(xbgr.mr_n68801872)
print v(xbgr.mr_n68802192)
print v(xbgr.mr_n68802304)
print v(xbgr.mr_n68802624)
print v(xbgr.mr_n68802736)
print v(xbgr.mr_n68803056)
print v(xbgr.mr_n68803168)
print v(xbgr.mr_n68803488)
print v(xbgr.mr_n68803600)
print v(xbgr.mr_n68803920)
print v(xbgr.mr_n68804032)
print v(xbgr.mr_n68804352)
print v(xbgr.mr_n68804464)
print v(xbgr.mr_n68804784)
print v(xbgr.mr_n68804896)
print v(xbgr.mr_n68805216)
print v(xbgr.mr_n68805328)
print v(xbgr.mr_n68805760)
print v(xbgr.mr_n68806080)
print v(xbgr.mr_n68806192)
print v(xbgr.mr_n68806512)
print v(xbgr.mr_n68806944)
print v(xbgr.mr_n68807056)
print v(xbgr.mr_n68807376)
print v(xbgr.mr_n68807488)
print v(xbgr.mr_n68807808)
print v(xbgr.mr_n68807920)
print v(xbgr.mr_n68808240)
print v(xbgr.mr_n68808352)
print v(xbgr.mr_n68809104)
print v(xbgr.mr_n68809216)
print v(xbgr.mr_n68809968)
print v(xbgr.mr_n68810832)
print v(xbgr.mr_n68810944)
print v(xbgr.mr_n68811264)
print v(xbgr.mr_n68811376)
print v(xbgr.mr_n68811696)
print v(xbgr.mr_n68811808)
print v(xbgr.mr_n68812128)
print v(xbgr.mr_n68812240)
print v(xbgr.mr_n68812672)
print v(xbgr.mr_n68813104)
print v(xbgr.mr_n68813424)
print v(xbgr.mr_n68813536)
print v(xbgr.mr_n68813856)
print v(xbgr.mr_n68813968)
print v(xbgr.mr_n68814288)
print v(xbgr.mr_n68815152)
print v(xbgr.mr_n68816448)
print v(xbgr.mr_n68817312)
print v(xbgr.mr_n68817424)
print v(xbgr.mr_n68817744)
print v(xbgr.mr_n68817856)
print v(xbgr.mr_n68818176)
print v(xbgr.mr_n68818288)
print v(xbgr.mr_n68818608)
print v(xbgr.mr_n68818720)
print v(xbgr.mr_n68819152)
print v(xbgr.mr_n68819472)
print v(xbgr.mr_n68819584)
print v(xbgr.mr_n68819904)
print v(xbgr.mr_n68820016)
print v(xbgr.mr_n68820336)
print v(xbgr.mr_n68820448)
print v(xbgr.mr_n68820880)
print v(xbgr.mr_n68821200)
print v(xbgr.mr_n68821312)
print v(xbgr.mr_n68821632)
print v(xbgr.mr_n68821744)
print v(xbgr.mr_n68822064)
print v(xbgr.mr_n68822928)
print v(xbgr.mr_n68823792)
print v(xbgr.mr_n68824656)
print v(xbgr.mr_n68825520)
print v(xbgr.mr_n68825632)
print v(xbgr.mr_n68825952)
print v(xbgr.mr_n68826064)
print v(xbgr.mr_n68826496)
print v(xbgr.mr_n68826928)
print v(xbgr.mr_n68827248)
print v(xbgr.mr_n68827360)
print v(xbgr.mr_n68827680)
print v(xbgr.mr_n68828544)
print v(xbgr.mr_n68829408)
print v(xbgr.mr_n68829520)
print v(xbgr.mr_n68829840)
print v(xbgr.mr_n68829952)
print v(xbgr.mr_n68830272)
print v(xbgr.mr_n68830384)
print v(xbgr.mr_n68830704)
print v(xbgr.mr_n68830816)
print v(xbgr.mr_n68831136)
print v(xbgr.mr_n68831248)
print v(xbgr.mr_n68831680)
print v(xbgr.mr_n68832000)
print v(xbgr.mr_n68832112)
print v(xbgr.mr_n68832864)
print v(xbgr.mr_n68833728)
print v(xbgr.mr_n68833840)
print v(xbgr.mr_n68834160)
print v(xbgr.mr_n68834272)
print v(xbgr.mr_n68834704)
print v(xbgr.mr_n68835024)
print v(xbgr.mr_n68835136)
print v(xbgr.mr_n68835456)
print v(xbgr.mr_n68835568)
print v(xbgr.mr_n68835888)
print v(xbgr.mr_n68836000)
print v(xbgr.mr_n68836320)
print v(xbgr.mr_n68836432)
print v(xbgr.mr_n68836752)
print v(xbgr.mr_n68836864)
print v(xbgr.mr_n68837184)
print v(xbgr.mr_n68838048)
print v(xbgr.mr_n68839024)
print v(xbgr.mr_n68839344)
print v(xbgr.mr_n68840208)
print v(xbgr.mr_n68841072)
print v(xbgr.mr_n68841936)
print v(xbgr.mr_n68842368)
print v(xbgr.mr_n68842800)
print v(xbgr.mr_n68842912)
print v(xbgr.mr_n68843232)
print v(xbgr.mr_n68843344)
print v(xbgr.mr_n68843664)
print v(xbgr.mr_n68843776)
print v(xbgr.mr_n68844096)
print v(xbgr.mr_n68844208)
print v(xbgr.mr_n68844528)
print v(xbgr.mr_n68844640)
print v(xbgr.mr_n68844960)
print v(xbgr.mr_n68845072)
print v(xbgr.mr_n68845392)
print v(xbgr.mr_n68846256)
print v(xbgr.mr_n68847120)
print v(xbgr.mr_n68847232)
print v(xbgr.mr_n68847552)
print v(xbgr.mr_n68847664)
print v(xbgr.mr_n68847984)
print v(xbgr.mr_n68848096)
print v(xbgr.mr_n68848416)
print v(xbgr.mr_n68848528)
print v(xbgr.mr_n68850144)
print v(xbgr.mr_n68851008)
print v(xbgr.mr_n68851120)
print v(xbgr.mr_n68851440)
print v(xbgr.mr_n68851552)
print v(xbgr.mr_n68851872)
print v(xbgr.mr_n68852304)
print v(xbgr.mr_n68852416)
print v(xbgr.mr_n68852736)
print v(xbgr.mr_n68852848)
print v(xbgr.mr_n68853168)
print v(xbgr.mr_n68853280)
print v(xbgr.mr_n68853712)
print v(xbgr.mr_n68854032)
print v(xbgr.mr_n68854144)
print v(xbgr.mr_n68854576)
print v(xbgr.mr_n68855328)
print v(xbgr.mr_n68856192)
print v(xbgr.mr_n68857488)
print v(xbgr.mr_n68857600)
print v(xbgr.mr_n68858032)
print v(xbgr.mr_n68858352)
print v(xbgr.mr_n68859216)
print v(xbgr.mr_n68860080)
print v(xbgr.mr_n68860512)
print v(xbgr.mr_n68861808)
print v(xbgr.mr_n68862672)
print v(xbgr.mr_n68863104)
print v(xbgr.mr_n68863968)
print v(xbgr.mr_n68865264)
print v(xbgr.mr_n68865376)
print v(xbgr.mr_n68865696)
print v(xbgr.mr_n68865808)
print v(xbgr.mr_n68866128)
print v(xbgr.mr_n68866240)
print v(xbgr.mr_n68866560)
print v(xbgr.mr_n68866672)
print v(xbgr.mr_n68866992)
print v(xbgr.mr_n68867104)
print v(xbgr.mr_n68867424)
print v(xbgr.mr_n68867536)
print v(xbgr.mr_n68867856)
print v(xbgr.mr_n68867968)
print v(xbgr.mr_n68868720)
print v(xbgr.mr_n68868832)
print v(xbgr.mr_n68869264)
print v(xbgr.mr_n68869584)
print v(xbgr.mr_n68869696)
print v(xbgr.mr_n68870016)
print v(xbgr.mr_n68870128)
print v(xbgr.mr_n68870448)
print v(xbgr.mr_n68870560)
print v(xbgr.mr_n68870880)
print v(xbgr.mr_n68870992)
print v(xbgr.mr_n68871312)
print v(xbgr.mr_n68871424)
print v(xbgr.mr_n68871856)
print v(xbgr.mr_n68872176)
print v(xbgr.mr_n68872720)
print v(xbgr.mr_n68873040)
print v(xbgr.mr_n68873152)
print v(xbgr.mr_n68873584)
print v(xbgr.mr_n68873904)
print v(xbgr.mr_n68874016)
print v(xbgr.mr_n68874448)
print v(xbgr.mr_n68874768)
print v(xbgr.mr_n68874880)
print v(xbgr.mr_n68875200)
print v(xbgr.mr_n68875312)
print v(xbgr.mr_n68875632)
print v(xbgr.mr_n68875744)
print v(xbgr.mr_n68876064)
print v(xbgr.mr_n68876176)
print v(xbgr.mr_n68876496)
print v(xbgr.mr_n68876608)
print v(xbgr.mr_n68876928)
print v(xbgr.mr_n68877040)
print v(xbgr.mr_n68877360)
print v(xbgr.mr_n68877472)
print v(xbgr.mr_n68877792)
print v(xbgr.mr_n68877904)
print v(xbgr.mr_n68878224)
print v(xbgr.mr_n68879088)
print v(xbgr.mr_n68879200)
print v(xbgr.mr_n68879520)
print v(xbgr.mr_n68879632)
print v(xbgr.mr_n68879952)
print v(xbgr.mr_n68880064)
print v(xbgr.mr_n68880384)
print v(xbgr.mr_n68880496)
print v(xbgr.mr_n68880816)
print v(xbgr.mr_n68881680)
print v(xbgr.mr_n68882544)
print v(xbgr.mr_n68883408)
print v(xbgr.mr_n68883952)
print v(xbgr.mr_n68884384)
print v(xbgr.mr_n68884704)
print v(xbgr.mr_n68884816)
print v(xbgr.mr_n68885136)
print v(xbgr.mr_n68885248)
print v(xbgr.mr_n68885568)
print v(xbgr.mr_n68885680)
print v(xbgr.mr_n68886000)
print v(xbgr.mr_n68886112)
print v(xbgr.mr_n68886432)
print v(xbgr.mr_n68887728)
print v(xbgr.mr_n68888592)
print v(xbgr.mr_n68889568)
print v(xbgr.mr_n68890000)
print v(xbgr.mr_n68890320)
print v(xbgr.mr_n68890752)
print v(xbgr.mr_n68891616)
print v(xbgr.mr_n68892480)
print v(xbgr.mr_n68892592)
print v(xbgr.mr_n68892912)
print v(xbgr.mr_n68893024)
print v(xbgr.mr_n68893344)
print v(xbgr.mr_n68893456)
print v(xbgr.mr_n68893776)
print v(xbgr.mr_n68893888)
print v(xbgr.mr_n68895072)
print v(xbgr.mr_n68895184)
print v(xbgr.mr_n68895504)
print v(xbgr.mr_n68895616)
print v(xbgr.mr_n68895936)
print v(xbgr.mr_n68896048)
print v(xbgr.mr_n68896480)
print v(xbgr.mr_n68896800)
print v(xbgr.mr_n68897232)
print v(xbgr.mr_n68897344)
print v(xbgr.mr_n68897776)
print v(xbgr.mr_n68898096)
print v(xbgr.mr_n68898960)
print v(xbgr.mr_n68899072)
print v(xbgr.mr_n68899504)
print v(xbgr.mr_n68899824)
print v(xbgr.mr_n68899936)
print v(xbgr.mr_n68900688)
print v(xbgr.mr_n68901232)
print v(xbgr.mr_n68901552)
print v(xbgr.mr_n68901664)
print v(xbgr.mr_n68901984)
print v(xbgr.mr_n68902096)
print v(xbgr.mr_n68902416)
print v(xbgr.mr_n68902528)
print v(xbgr.mr_n68902848)
print v(xbgr.mr_n68903280)
print v(xbgr.mr_n68903392)
print v(xbgr.mr_n68903712)
print v(xbgr.mr_n68903824)
print v(xbgr.mr_n68904144)
print v(xbgr.mr_n68904256)
print v(xbgr.mr_n68905008)
print v(xbgr.mr_n68905120)
print v(xbgr.mr_n68905552)
print v(xbgr.mr_n68905872)
print v(xbgr.mr_n68905984)
print v(xbgr.mr_n68906304)
print v(xbgr.mr_n68906416)
print v(xbgr.mr_n68906736)
print v(xbgr.mr_n68906848)
print v(xbgr.mr_n68907168)
print v(xbgr.mr_n68908032)
print v(xbgr.mr_n68908464)
print v(xbgr.mr_n68908896)
print v(xbgr.mr_n68909008)
print v(xbgr.mr_n68909328)
print v(xbgr.mr_n68909440)
print v(xbgr.mr_n68910192)
print v(xbgr.mr_n68910304)
print v(xbgr.mr_n68910624)
print v(xbgr.mr_n68910736)
print v(xbgr.mr_n68911488)
print v(xbgr.mr_n68912352)
print v(xbgr.mr_n68912464)
print v(xbgr.mr_n68912784)
print v(xbgr.mr_n68913648)
print v(xbgr.mr_n68913760)
print v(xbgr.mr_n68914080)
print v(xbgr.mr_n68914192)
print v(xbgr.mr_n68914512)
print v(xbgr.mr_n68914624)
print v(xbgr.mr_n68914944)
print v(xbgr.mr_n68915056)
print v(xbgr.mr_n68915376)
print v(xbgr.mr_n68915488)
print v(xbgr.mr_n68915808)
print v(xbgr.mr_n68915920)
print v(xbgr.mr_n68916240)
print v(xbgr.mr_n68916352)
print v(xbgr.mr_n68916784)
print v(xbgr.mr_n68917216)
print v(xbgr.mr_n68917536)
print v(xbgr.mr_n68917968)
print v(xbgr.mr_n68918080)
print v(xbgr.mr_n68919264)
print v(xbgr.mr_n68920992)
print v(xbgr.mr_n68921104)
print v(xbgr.mr_n68921536)
print v(xbgr.mr_n68921856)
print v(xbgr.mr_n68921968)
print v(xbgr.mr_n68922288)
print v(xbgr.mr_n68922400)
print v(xbgr.mr_n68922832)
print v(xbgr.mr_n68923152)
print v(xbgr.mr_n68923264)
print v(xbgr.mr_n68923584)
print v(xbgr.mr_n68924016)
print v(xbgr.mr_n68924128)
print v(xbgr.mr_n68924880)
print v(xbgr.mr_n68924992)
print v(xbgr.mr_n68925312)
print v(xbgr.mr_n68925424)
print v(xbgr.mr_n68925744)
print v(xbgr.mr_n68925856)
print v(xbgr.mr_n68926176)
print v(xbgr.mr_n68926288)
print v(xbgr.mr_n68926608)
print v(xbgr.mr_n68926720)
print v(xbgr.mr_n68927040)
print v(xbgr.mr_n68927904)
print v(xbgr.mr_n68928768)
print v(xbgr.mr_n68929632)
print v(xbgr.mr_n68929744)
print v(xbgr.mr_n68930064)
print v(xbgr.mr_n68930496)
print v(xbgr.mr_n68930608)
print v(xbgr.mr_n68930928)
print v(xbgr.mr_n68931040)
print v(xbgr.mr_n68931360)
print v(xbgr.mr_n68931472)
print v(xbgr.mr_n68931792)
print v(xbgr.mr_n68932656)
print v(xbgr.mr_n68933632)
print v(xbgr.mr_n68933952)
print v(xbgr.mr_n68934064)
print v(xbgr.mr_n68934384)
print v(xbgr.mr_n68934496)
print v(xbgr.mr_n68934816)
print v(xbgr.mr_n68934928)
print v(xbgr.mr_n68935248)
print v(xbgr.mr_n68935360)
print v(xbgr.mr_n68935680)
print v(xbgr.mr_n68936224)
print v(xbgr.mr_n68936656)
print v(xbgr.mr_n68937088)
print v(xbgr.mr_n68938272)
print v(xbgr.mr_n68938384)
print v(xbgr.mr_n68938704)
print v(xbgr.mr_n68938816)
print v(xbgr.mr_n68939136)
print v(xbgr.mr_n68940000)
print v(xbgr.mr_n68940112)
print v(xbgr.mr_n68940432)
print v(xbgr.mr_n68940544)
print v(xbgr.mr_n68940864)
print v(xbgr.mr_n68941296)
print v(xbgr.mr_n68942160)
print v(xbgr.mr_n68943456)
print v(xbgr.mr_n68943568)
print v(xbgr.mr_n68943888)
print v(xbgr.mr_n68944000)
print v(xbgr.mr_n68944320)
print v(xbgr.mr_n68944752)
print v(xbgr.mr_n68945616)
print v(xbgr.mr_n68946048)
print v(xbgr.mr_n68946160)
print v(xbgr.mr_n68946480)
print v(xbgr.mr_n68946592)
print v(xbgr.mr_n68946912)
print v(xbgr.mr_n68947024)
print v(xbgr.mr_n68947344)
print v(xbgr.mr_n68947456)
print v(xbgr.mr_n68948208)
print v(xbgr.mr_n68948320)
print v(xbgr.mr_n68949072)
print v(xbgr.mr_n68950048)
print v(xbgr.mr_n68950368)
print v(xbgr.mr_n68950480)
print v(xbgr.mr_n68950800)
print v(xbgr.mr_n68950912)
print v(xbgr.mr_n68951232)
print v(xbgr.mr_n68951664)
print v(xbgr.mr_n68952528)
print v(xbgr.mr_n68952640)
print v(xbgr.mr_n68952960)
print v(xbgr.mr_n68953072)
print v(xbgr.mr_n68953392)
print v(xbgr.mr_n68953504)
print v(xbgr.mr_n68953824)
print v(xbgr.mr_n68953936)
print v(xbgr.mr_n68954256)
print v(xbgr.mr_n68954368)
print v(xbgr.mr_n68954800)
print v(xbgr.mr_n68955552)
print v(xbgr.mr_n68956528)
print v(xbgr.mr_n68956960)
print v(xbgr.mr_n68957280)
print v(xbgr.mr_n68957712)
print v(xbgr.mr_n68958688)
print v(xbgr.mr_n68959120)
print v(xbgr.mr_n68959440)
print v(xbgr.mr_n68959872)
print v(xbgr.mr_n68959984)
print v(xbgr.mr_n68960304)
print v(xbgr.mr_n68960416)
print v(xbgr.mr_n68960736)
print v(xbgr.mr_n68960848)
print v(xbgr.mr_n68961168)
print v(xbgr.mr_n68961280)
print v(xbgr.mr_n68962032)
print v(xbgr.mr_n68962896)
print v(xbgr.mr_n68964192)
print v(xbgr.mr_n68964304)
print v(xbgr.mr_n68964624)
print v(xbgr.mr_n68964736)
print v(xbgr.mr_n68965056)
print v(xbgr.mr_n68965168)
print v(xbgr.mr_n68965488)
print v(xbgr.mr_n68965600)
print v(xbgr.mr_n68965920)
print v(xbgr.mr_n68966032)
print v(xbgr.mr_n68966352)
print v(xbgr.mr_n68966784)
print v(xbgr.mr_n68966896)
print v(xbgr.mr_n68967216)
print v(xbgr.mr_n68967328)
print v(xbgr.mr_n68967648)
print v(xbgr.mr_n68967760)
print v(xbgr.mr_n68968080)
print v(xbgr.mr_n68968192)
print v(xbgr.mr_n68968512)
print v(xbgr.mr_n68968624)
print v(xbgr.mr_n68968944)
print v(xbgr.mr_n68969056)
print v(xbgr.mr_n68969376)
print v(xbgr.mr_n68969488)
print v(xbgr.mr_n68969808)
print v(xbgr.mr_n68969920)
print v(xbgr.mr_n68970240)
print v(xbgr.mr_n68970352)
print v(xbgr.mr_n68970784)
print v(xbgr.mr_n68971104)
print v(xbgr.mr_n68971216)
print v(xbgr.mr_n68971648)
print v(xbgr.mr_n68972080)
print v(xbgr.mr_n68972400)
print v(xbgr.mr_n68972512)
print v(xbgr.mr_n68972832)
print v(xbgr.mr_n68972944)
print v(xbgr.mr_n68973264)
print v(xbgr.mr_n68973376)
print v(xbgr.mr_n68973696)
print v(xbgr.mr_n68973808)
print v(xbgr.mr_n68974560)
print v(xbgr.mr_n68974672)
print v(xbgr.mr_n68975104)
print v(xbgr.mr_n68975424)
print v(xbgr.mr_n68975968)
print v(xbgr.mr_n68976288)
print v(xbgr.mr_n68977152)
print v(xbgr.mr_n68977264)
print v(xbgr.mr_n68977584)
print v(xbgr.mr_n68978016)
print v(xbgr.mr_n68978448)
print v(xbgr.mr_n68978880)
print v(xbgr.mr_n68978992)
print v(xbgr.mr_n68979744)
print v(xbgr.mr_n68979856)
print v(xbgr.mr_n68980176)
print v(xbgr.mr_n68980288)
print v(xbgr.mr_n68980608)
print v(xbgr.mr_n68981040)
print v(xbgr.mr_n68981152)
print v(xbgr.mr_n68981472)
print v(xbgr.mr_n68981584)
print v(xbgr.mr_n68981904)
print v(xbgr.mr_n68982016)
print v(xbgr.mr_n68982336)
print v(xbgr.mr_n68982768)
print v(xbgr.mr_n68983632)
print v(xbgr.mr_n68984496)
print v(xbgr.mr_n68985792)
print v(xbgr.mr_n68986656)
print v(xbgr.mr_n68987520)
print v(xbgr.mr_n68988384)
print v(xbgr.mr_n68988496)
print v(xbgr.mr_n68988816)
print v(xbgr.mr_n68989680)
print v(xbgr.mr_n68990544)
print v(xbgr.mr_n68991408)
print v(xbgr.mr_n68991520)
print v(xbgr.mr_n68991840)
print v(xbgr.mr_n68991952)
print v(xbgr.mr_n68992272)
print v(xbgr.mr_n68992384)
print v(xbgr.mr_n68992704)
print v(xbgr.mr_n68992816)
print v(xbgr.mr_n68993136)
print v(xbgr.mr_n68993248)
print v(xbgr.mr_n68993568)
print v(xbgr.mr_n68993680)
print v(xbgr.mr_n68995296)
print v(xbgr.mr_n68996272)
print v(xbgr.mr_n68996704)
print v(xbgr.mr_n68997136)
print v(xbgr.mr_n68997456)
print v(xbgr.mr_n68997568)
print v(xbgr.mr_n68997888)
print v(xbgr.mr_n68998000)
print v(xbgr.mr_n68998320)
print v(xbgr.mr_n68998432)
print v(xbgr.mr_n68998752)
print v(xbgr.mr_n68998864)
print v(xbgr.mr_n68999184)
print v(xbgr.mr_n68999296)
print v(xbgr.mr_n68999616)
print v(xbgr.mr_n68999728)
print v(xbgr.mr_n69000048)
print v(xbgr.mr_n69000160)
print v(xbgr.mr_n69000592)
print v(xbgr.mr_n69000912)
print v(xbgr.mr_n69001024)
print v(xbgr.mr_n69001456)
print v(xbgr.mr_n69001888)
print v(xbgr.mr_n69003072)
print v(xbgr.mr_n69003184)
print v(xbgr.mr_n69003504)
print v(xbgr.mr_n69003616)
print v(xbgr.mr_n69003936)
print v(xbgr.mr_n69004048)
print v(xbgr.mr_n69004368)
print v(xbgr.mr_n69004480)
print v(xbgr.mr_n69004800)
print v(xbgr.mr_n69004912)
print v(xbgr.mr_n69005232)
print v(xbgr.mr_n69005664)
print v(xbgr.mr_n69005776)
print v(xbgr.mr_n69006096)
print v(xbgr.mr_n69006208)
print v(xbgr.mr_n69006528)
print v(xbgr.mr_n69006640)
print v(xbgr.mr_n69006960)
print v(xbgr.mr_n69007072)
print v(xbgr.mr_n69007504)
print v(xbgr.mr_n69007824)
print v(xbgr.mr_n69008256)
print v(xbgr.mr_n69009120)
print v(xbgr.mr_n69009232)
print v(xbgr.mr_n69009552)
print v(xbgr.mr_n69009984)
print v(xbgr.mr_n69010416)
print v(xbgr.mr_n69010960)
print v(xbgr.mr_n69011280)
print v(xbgr.mr_n69012144)
print v(xbgr.mr_n69012256)
print v(xbgr.mr_n69012576)
print v(xbgr.mr_n69012688)
print v(xbgr.mr_n69013120)
print v(xbgr.mr_n69013872)
print v(xbgr.mr_n69014304)
print v(xbgr.mr_n69014736)
print v(xbgr.mr_n69015168)
print v(xbgr.mr_n69015280)
print v(xbgr.mr_n69016464)
print v(xbgr.mr_n69017328)
print v(xbgr.mr_n69018304)
print v(xbgr.mr_n69018624)
print v(xbgr.mr_n69018736)
print v(xbgr.mr_n69019168)
print v(xbgr.mr_n69019488)
print v(xbgr.mr_n69019600)
print v(xbgr.mr_n69019920)
print v(xbgr.mr_n69020032)
print v(xbgr.mr_n69020352)
print v(xbgr.mr_n69020464)
print v(xbgr.mr_n69020784)
print v(xbgr.mr_n69020896)
print v(xbgr.mr_n69021216)
print v(xbgr.mr_n69021328)
print v(xbgr.mr_n69021648)
print v(xbgr.mr_n69021760)
print v(xbgr.mr_n69022192)
print v(xbgr.mr_n69022624)
print v(xbgr.mr_n69023056)
print v(xbgr.mr_n69023808)
print v(xbgr.mr_n69024240)
print v(xbgr.mr_n69025104)
print v(xbgr.mr_n69025968)
print v(xbgr.mr_n69027696)
print v(xbgr.mr_n69028560)
print v(xbgr.mr_n69028672)
print v(xbgr.mr_n69029424)
print v(xbgr.mr_n69029536)
print v(xbgr.mr_n69029856)
print v(xbgr.mr_n69029968)
print v(xbgr.mr_n69030288)
print v(xbgr.mr_n69030400)
print v(xbgr.mr_n69032448)
print v(xbgr.mr_n69032560)
print v(xbgr.mr_n69032880)
print v(xbgr.mr_n69032992)
print v(xbgr.mr_n69033312)
print v(xbgr.mr_n69033424)
print v(xbgr.mr_n69033744)
print v(xbgr.mr_n69033856)
print v(xbgr.mr_n69034176)
print v(xbgr.mr_n69034288)
print v(xbgr.mr_n69034608)
print v(xbgr.mr_n69034720)
print v(xbgr.mr_n69035040)
print v(xbgr.mr_n69035152)
print v(xbgr.mr_n69035584)
print v(xbgr.mr_n69035904)
print v(xbgr.mr_n69036016)
print v(xbgr.mr_n69036448)
print v(xbgr.mr_n69036768)
print v(xbgr.mr_n69036880)
print v(xbgr.mr_n69037312)
print v(xbgr.mr_n69037632)
print v(xbgr.mr_n69037744)
print v(xbgr.mr_n69038064)
print v(xbgr.mr_n69038176)
print v(xbgr.mr_n69038496)
print v(xbgr.mr_n69038608)
print v(xbgr.mr_n69038928)
print v(xbgr.mr_n69039040)
print v(xbgr.mr_n69039360)
print v(xbgr.mr_n69039472)
print v(xbgr.mr_n69039792)
print v(xbgr.mr_n69039904)
print v(xbgr.mr_n69040224)
print v(xbgr.mr_n69040336)
print v(xbgr.mr_n69040656)
print v(xbgr.mr_n69040768)
print v(xbgr.mr_n69041088)
print v(xbgr.mr_n69041200)
print v(xbgr.mr_n69041520)
print v(xbgr.mr_n69041632)
print v(xbgr.mr_n69041952)
print v(xbgr.mr_n69042064)
print v(xbgr.mr_n69042384)
print v(xbgr.mr_n69042496)
print v(xbgr.mr_n69042816)
print v(xbgr.mr_n69042928)
print v(xbgr.mr_n69043248)
print v(xbgr.mr_n69043360)
print v(xbgr.mr_n69043680)
print v(xbgr.mr_n69043792)
print v(xbgr.mr_n69044112)
print v(xbgr.mr_n69044224)
print v(xbgr.mr_n69044544)
print v(xbgr.mr_n69044656)
print v(xbgr.mr_n69044976)
print v(xbgr.mr_n69045088)
print v(xbgr.mr_n69045520)
print v(xbgr.mr_n69045840)
print v(xbgr.mr_n69045952)
print v(xbgr.mr_n69046384)
print v(xbgr.mr_n69046704)
print v(xbgr.mr_n69046816)
print v(xbgr.mr_n69047248)
print v(xbgr.mr_n69047568)
print v(xbgr.mr_n69048432)
print v(xbgr.mr_n69049296)
print v(xbgr.mr_n69050160)
print v(xbgr.mr_n69051024)
print v(xbgr.mr_n69051888)
print v(xbgr.mr_n69052752)
print v(xbgr.mr_n69052864)
print v(xbgr.mr_n69053184)
print v(xbgr.mr_n69053296)
print v(xbgr.mr_n69053616)
print v(xbgr.mr_n69053728)
print v(xbgr.mr_n69054048)
print v(xbgr.mr_n69054160)
print v(xbgr.mr_n69054480)
print v(xbgr.mr_n69054592)
print v(xbgr.mr_n69054912)
print v(xbgr.mr_n69055024)
print v(xbgr.mr_n69055344)
print v(xbgr.mr_n69056208)
print v(xbgr.mr_n69057072)
print v(xbgr.mr_n69057936)
print v(xbgr.mr_n69058048)
print v(xbgr.mr_n69058368)
print v(xbgr.mr_n69058480)
print v(xbgr.mr_n69058800)
print v(xbgr.mr_n69058912)
print v(xbgr.mr_n69059344)
print v(xbgr.mr_n69059776)
print v(xbgr.mr_n69060208)
print v(xbgr.mr_n69060528)
print v(xbgr.mr_n69060640)
print v(xbgr.mr_n69061072)
print v(xbgr.mr_n69061392)
print v(xbgr.mr_n69061504)
print v(xbgr.mr_n69061824)
print v(xbgr.mr_n69061936)
print v(xbgr.mr_n69062256)
print v(xbgr.mr_n69062368)
print v(xbgr.mr_n69062688)
print v(xbgr.mr_n69062800)
print v(xbgr.mr_n69063120)
print v(xbgr.mr_n69063232)
print v(xbgr.mr_n69063552)
print v(xbgr.mr_n69063664)
print v(xbgr.mr_n69064096)
print v(xbgr.mr_n69064528)
print v(xbgr.mr_n69064848)
print v(xbgr.mr_n69064960)
print v(xbgr.mr_n69065392)
print v(xbgr.mr_n69065712)
print v(xbgr.mr_n69065824)
print v(xbgr.mr_n69066256)
print v(xbgr.mr_n69066576)
print v(xbgr.mr_n69066688)
print v(xbgr.mr_n69067120)
print v(xbgr.mr_n69067440)
print v(xbgr.mr_n69068304)
print v(xbgr.mr_n69069168)
print v(xbgr.mr_n69070032)
print v(xbgr.mr_n69070896)
print v(xbgr.mr_n69071760)
print v(xbgr.mr_n69071872)
print v(xbgr.mr_n69072192)
print v(xbgr.mr_n69072304)
print v(xbgr.mr_n69072624)
print v(xbgr.mr_n69072736)
print v(xbgr.mr_n69073056)
print v(xbgr.mr_n69073168)
print v(xbgr.mr_n69073488)
print v(xbgr.mr_n69074352)
print v(xbgr.mr_n69075216)
print v(xbgr.mr_n69076080)
print v(xbgr.mr_n69076192)
print v(xbgr.mr_n69076512)
print v(xbgr.mr_n69076624)
print v(xbgr.mr_n69076944)
print v(xbgr.mr_n69077056)
print v(xbgr.mr_n69077376)
print v(xbgr.mr_n69077488)
print v(xbgr.mr_n69077808)
print v(xbgr.mr_n69077920)
print v(xbgr.mr_n69078240)
print v(xbgr.mr_n69078352)
print v(xbgr.mr_n69078672)
print v(xbgr.mr_n69079536)
print v(xbgr.mr_n69080400)
print v(xbgr.mr_n69081264)
print v(xbgr.mr_n69082128)
print v(xbgr.mr_n69082992)
print v(xbgr.mr_n69083856)
print v(xbgr.mr_n69084720)
print v(xbgr.mr_n69085584)
print v(xbgr.mr_n69086448)
print v(xbgr.mr_n69086560)
print v(xbgr.mr_n69086880)
print v(xbgr.mr_n69086992)
print v(xbgr.mr_n69087312)
print v(xbgr.mr_n69087424)
print v(xbgr.mr_n69087744)
print v(xbgr.mr_n69087856)
print v(xbgr.mr_n69088176)
print v(xbgr.mr_n69088288)
print v(xbgr.mr_n69088608)
print v(xbgr.mr_n69088720)
print v(xbgr.mr_n69089040)
print v(xbgr.mr_n69089152)
print v(xbgr.mr_n69089472)
print v(xbgr.mr_n69089584)
print v(xbgr.mr_n69089904)
print v(xbgr.mr_n69090016)
print v(xbgr.mr_n69090336)
print v(xbgr.mr_n69090448)
print v(xbgr.mr_n69090768)
print v(xbgr.mr_n69091632)
print v(xbgr.mr_n69091744)
print v(xbgr.mr_n69092064)
print v(xbgr.mr_n69092176)
print v(xbgr.mr_n69092496)
print v(xbgr.mr_n69092608)
print v(xbgr.mr_n69092928)
print v(xbgr.mr_n69093040)
print v(xbgr.mr_n69093360)
print v(xbgr.mr_n69093472)
print v(xbgr.mr_n69093792)
print v(xbgr.mr_n69093904)
print v(xbgr.mr_n69094224)
print v(xbgr.mr_n69094336)
print v(xbgr.mr_n69094656)
print v(xbgr.mr_n69094768)
print v(xbgr.mr_n69095088)
print v(xbgr.mr_n69095200)
print v(xbgr.mr_n69095520)
print v(xbgr.mr_n69095632)
print v(xbgr.mr_n69095952)
print v(xbgr.mr_n69096064)
print v(xbgr.mr_n69096496)
print v(xbgr.mr_n69096816)
print v(xbgr.mr_n69096928)
print v(xbgr.mr_n69097360)
print v(xbgr.mr_n69097680)
print v(xbgr.mr_n69097792)
print v(xbgr.mr_n69098224)
print v(xbgr.mr_n69098544)
print v(xbgr.mr_n69098656)
print v(xbgr.mr_n69099088)
print v(xbgr.mr_n69099408)
print v(xbgr.mr_n69099520)
print v(xbgr.mr_n69099840)
print v(xbgr.mr_n69099952)
print v(xbgr.mr_n69100384)
print v(xbgr.mr_n69100816)
print v(xbgr.mr_n69101136)
print v(xbgr.mr_n69101248)
print v(xbgr.mr_n69101568)
print v(xbgr.mr_n69101680)
print v(xbgr.mr_n69102000)
print v(xbgr.mr_n69102112)
print v(xbgr.mr_n69102432)
print v(xbgr.mr_n69102544)
print v(xbgr.mr_n69102864)
print v(xbgr.mr_n69102976)
print v(xbgr.mr_n69103408)
print v(xbgr.mr_n69103728)
print v(xbgr.mr_n69103840)
print v(xbgr.mr_n69104272)
print v(xbgr.mr_n69104592)
print v(xbgr.mr_n69105456)
print v(xbgr.mr_n69106320)
print v(xbgr.mr_n69107184)
print v(xbgr.mr_n69108048)
print v(xbgr.mr_n69108160)
print v(xbgr.mr_n69108480)
print v(xbgr.mr_n69108592)
print v(xbgr.mr_n69108912)
print v(xbgr.mr_n69109024)
print v(xbgr.mr_n69109344)
print v(xbgr.mr_n69109456)
print v(xbgr.mr_n69109776)
print v(xbgr.mr_n69110640)
print v(xbgr.mr_n69111504)
print v(xbgr.mr_n69111616)
print v(xbgr.mr_n69111936)
print v(xbgr.mr_n69112048)
print v(xbgr.mr_n69112480)
print v(xbgr.mr_n69112912)
print v(xbgr.mr_n69113232)
print v(xbgr.mr_n69113344)
print v(xbgr.mr_n69113664)
print v(xbgr.mr_n69113776)
print v(xbgr.mr_n69114096)
print v(xbgr.mr_n69114208)
print v(xbgr.mr_n69114528)
print v(xbgr.mr_n69114640)
print v(xbgr.mr_n69114960)
print v(xbgr.mr_n69115072)
print v(xbgr.mr_n69115504)
print v(xbgr.mr_n69115824)
print v(xbgr.mr_n69115936)
print v(xbgr.mr_n69116368)
print v(xbgr.mr_n69116688)
print v(xbgr.mr_n69116800)
print v(xbgr.mr_n69117120)
print v(xbgr.mr_n69117232)
print v(xbgr.mr_n69117552)
print v(xbgr.mr_n69117664)
print v(xbgr.mr_n69117984)
print v(xbgr.mr_n69118096)
print v(xbgr.mr_n69118416)
print v(xbgr.mr_n69118528)
print v(xbgr.mr_n69118848)
print v(xbgr.mr_n69118960)
print v(xbgr.mr_n69119280)
print v(xbgr.mr_n69119392)
print v(xbgr.mr_n69119712)
print v(xbgr.mr_n69119824)
print v(xbgr.mr_n69120144)
print v(xbgr.mr_n69120256)
print v(xbgr.mr_n69120576)
print v(xbgr.mr_n69120688)
print v(xbgr.mr_n69121008)
print v(xbgr.mr_n69121872)
print v(xbgr.mr_n69122736)
print v(xbgr.mr_n69123600)
print v(xbgr.mr_n69124464)
print v(xbgr.mr_n69124576)
print v(xbgr.mr_n69124896)
print v(xbgr.mr_n69125008)
print v(xbgr.mr_n69125328)
print v(xbgr.mr_n69125440)
print v(xbgr.mr_n69125760)
print v(xbgr.mr_n69125872)
print v(xbgr.mr_n69126304)
print v(xbgr.mr_n69126736)
print v(xbgr.mr_n69127168)
print v(xbgr.mr_n69127600)
print v(xbgr.mr_n69127920)
print v(xbgr.mr_n69128032)
print v(xbgr.mr_n69128352)
print v(xbgr.mr_n69128464)
print v(xbgr.mr_n69128784)
print v(xbgr.mr_n69128896)
print v(xbgr.mr_n69129216)
print v(xbgr.mr_n69129328)
print v(xbgr.mr_n69129648)
print v(xbgr.mr_n69130512)
print v(xbgr.mr_n69131376)
print v(xbgr.mr_n69131488)
print v(xbgr.mr_n69131920)
print v(xbgr.mr_n69132240)
print v(xbgr.mr_n69133104)
print v(xbgr.mr_n69133216)
print v(xbgr.mr_n69133536)
print v(xbgr.mr_n69133648)
print v(xbgr.mr_n69133968)
print v(xbgr.mr_n69134080)
print v(xbgr.mr_n69134400)
print v(xbgr.mr_n69134512)
print v(xbgr.mr_n69134832)
print v(xbgr.mr_n69135696)
print v(xbgr.mr_n69135808)
print v(xbgr.mr_n69136240)
print v(xbgr.mr_n69136560)
print v(xbgr.mr_n69136672)
print v(xbgr.mr_n69136992)
print v(xbgr.mr_n69137104)
print v(xbgr.mr_n69137424)
print v(xbgr.mr_n69137536)
print v(xbgr.mr_n69137856)
print v(xbgr.mr_n69137968)
print v(xbgr.mr_n69138288)
print v(xbgr.mr_n69139152)
print v(xbgr.mr_n69139584)
print v(xbgr.mr_n69139696)
print v(xbgr.mr_n69140016)
print v(xbgr.mr_n69140128)
print v(xbgr.mr_n69140448)
print v(xbgr.mr_n69140880)
print v(xbgr.mr_n69141744)
print v(xbgr.mr_n69142608)
print v(xbgr.mr_n69142720)
print v(xbgr.mr_n69143472)
print v(xbgr.mr_n69143584)
print v(xbgr.mr_n69143904)
print v(xbgr.mr_n69144016)
print v(xbgr.mr_n69144336)
print v(xbgr.mr_n69145200)
print v(xbgr.mr_n69146064)
print v(xbgr.mr_n69146176)
print v(xbgr.mr_n69146496)
print v(xbgr.mr_n69146608)
print v(xbgr.mr_n69146928)
print v(xbgr.mr_n69147792)
print v(xbgr.mr_n69147904)
print v(xbgr.mr_n69148224)
print v(xbgr.mr_n69148336)
print v(xbgr.mr_n69148656)
print v(xbgr.mr_n69148768)
print v(xbgr.mr_n69149088)
print v(xbgr.mr_n69149200)
print v(xbgr.mr_n69149520)
print v(xbgr.mr_n69149632)
print v(xbgr.mr_n69150384)
print v(xbgr.mr_n69151248)
print v(xbgr.mr_n69152112)
print v(xbgr.mr_n69152224)
print v(xbgr.mr_n69152544)
print v(xbgr.mr_n69152656)
print v(xbgr.mr_n69152976)
print v(xbgr.mr_n69153088)
print v(xbgr.mr_n69153408)
print v(xbgr.mr_n69153520)
print v(xbgr.mr_n69153840)
print v(xbgr.mr_n69153952)
print v(xbgr.mr_n69154272)
print v(xbgr.mr_n69154384)
print v(xbgr.mr_n69154704)
print v(xbgr.mr_n69154816)
print v(xbgr.mr_n69155248)
print v(xbgr.mr_n69155568)
print v(xbgr.mr_n69155680)
print v(xbgr.mr_n69156000)
print v(xbgr.mr_n69156112)
print v(xbgr.mr_n69156432)
print v(xbgr.mr_n69157296)
print v(xbgr.mr_n69158160)
print v(xbgr.mr_n69159024)
print v(xbgr.mr_n69159888)
print v(xbgr.mr_n69160320)
print v(xbgr.mr_n69160432)
print v(xbgr.mr_n69160752)
print v(xbgr.mr_n69160864)
print v(xbgr.mr_n69161184)
print v(xbgr.mr_n69161296)
print v(xbgr.mr_n69161728)
print v(xbgr.mr_n69162480)
print v(xbgr.mr_n69162592)
print v(xbgr.mr_n69162912)
print v(xbgr.mr_n69163024)
print v(xbgr.mr_n69163344)
print v(xbgr.mr_n69164208)
print v(xbgr.mr_n69165072)
print v(xbgr.mr_n69165184)
print v(xbgr.mr_n69165504)
print v(xbgr.mr_n69165616)
print v(xbgr.mr_n69165936)
print v(xbgr.mr_n69166800)
print v(xbgr.mr_n69167664)
print v(xbgr.mr_n69168528)
print v(xbgr.mr_n69168640)
print v(xbgr.mr_n69168960)
print v(xbgr.mr_n69169072)
print v(xbgr.mr_n69169392)
print v(xbgr.mr_n69170256)
print v(xbgr.mr_n69171120)
print v(xbgr.mr_n69171232)
print v(xbgr.mr_n69171552)
print v(xbgr.mr_n69171664)
print v(xbgr.mr_n69171984)
print v(xbgr.mr_n69172096)
print v(xbgr.mr_n69172416)
print v(xbgr.mr_n69172528)
print v(xbgr.mr_n69172848)
print v(xbgr.mr_n69172960)
print v(xbgr.mr_n69173280)
print v(xbgr.mr_n69173392)
print v(xbgr.mr_n69173712)
print v(xbgr.mr_n69173824)
print v(xbgr.mr_n69174144)
print v(xbgr.mr_n69174256)
print v(xbgr.mr_n69174576)
print v(xbgr.mr_n69174688)
print v(xbgr.mr_n69175008)
print v(xbgr.mr_n69175120)
print v(xbgr.mr_n69175440)
print v(xbgr.mr_n69175552)
print v(xbgr.mr_n69175872)
print v(xbgr.mr_n69175984)
print v(xbgr.mr_n69176304)
print v(xbgr.mr_n69176416)
print v(xbgr.mr_n69176736)
print v(xbgr.mr_n69176848)
print v(xbgr.mr_n69177168)
print v(xbgr.mr_n69177280)
print v(xbgr.mr_n69177600)
print v(xbgr.mr_n69177712)
print v(xbgr.mr_n69178032)
print v(xbgr.mr_n69178144)
print v(xbgr.mr_n69178464)
print v(xbgr.mr_n69178576)
print v(xbgr.mr_n69178896)
print v(xbgr.mr_n69179008)
print v(xbgr.mr_n69179328)
print v(xbgr.mr_n69179440)
print v(xbgr.mr_n69179760)
print v(xbgr.mr_n69179872)
print v(xbgr.mr_n69180192)
print v(xbgr.mr_n69180304)
print v(xbgr.mr_n69180624)
print v(xbgr.mr_n69180736)
print v(xbgr.mr_n69181056)
print v(xbgr.mr_n69181168)
print v(xbgr.mr_n69181488)
print v(xbgr.mr_n69181600)
print v(xbgr.mr_n69181920)
print v(xbgr.mr_n69182032)
print v(xbgr.mr_n69182464)
print v(xbgr.mr_n69182896)
print v(xbgr.mr_n69183328)
print v(xbgr.mr_n69183760)
print v(xbgr.mr_n69184192)
print v(xbgr.mr_n69184624)
print v(xbgr.mr_n69185056)
print v(xbgr.mr_n69185488)
print v(xbgr.mr_n69185920)
print v(xbgr.mr_n69186352)
print v(xbgr.mr_n69186784)
print v(xbgr.mr_n69187216)
print v(xbgr.mr_n69187648)
print v(xbgr.mr_n69188080)
print v(xbgr.mr_n69188512)
print v(xbgr.mr_n69188944)
print v(xbgr.mr_n69189376)
print v(xbgr.mr_n69189808)
print v(xbgr.mr_n69190240)
print v(xbgr.mr_n69190672)
print v(xbgr.mr_n69191104)
print v(xbgr.mr_n69191536)
print v(xbgr.mr_n69191968)
print v(xbgr.mr_n69192400)
print v(xbgr.mr_n69192832)
print v(xbgr.mr_n69193264)
print v(xbgr.mr_n69193584)
print v(xbgr.mr_n69193696)
print v(xbgr.mr_n69194016)
print v(xbgr.mr_n69194128)
print v(xbgr.mr_n69194448)
print v(xbgr.mr_n69194560)
print v(xbgr.mr_n69194880)
print v(xbgr.mr_n69194992)
print v(xbgr.mr_n69195312)
print v(xbgr.mr_n69195424)
print v(xbgr.mr_n69195744)
print v(xbgr.mr_n69195856)
print v(xbgr.mr_n69196176)
print v(xbgr.mr_n69196288)
print v(xbgr.mr_n69196608)
print v(xbgr.mr_n69196720)
print v(xbgr.mr_n69197040)
print v(xbgr.mr_n69197152)
print v(xbgr.mr_n69197472)
print v(xbgr.mr_n69197584)
print v(xbgr.mr_n69197904)
print v(xbgr.mr_n69198016)
print v(xbgr.mr_n69198336)
print v(xbgr.mr_n69198448)
print v(xbgr.mr_n69198768)
print v(xbgr.mr_n69198880)
print v(xbgr.mr_n69199200)
print v(xbgr.mr_n69199312)
print v(xbgr.mr_n69199632)
print v(xbgr.mr_n69199744)
print v(xbgr.mr_n69200064)
print v(xbgr.mr_n69200176)
print v(xbgr.mr_n69200496)
print v(xbgr.mr_n69200608)
print v(xbgr.mr_n69200928)
print v(xbgr.mr_n69201040)
print v(xbgr.mr_n69201360)
print v(xbgr.mr_n69201472)
print v(xbgr.mr_n69201792)
print v(xbgr.mr_n69201904)
print v(xbgr.mr_n69202224)
print v(xbgr.mr_n69202336)
print v(xbgr.mr_n69202656)
print v(xbgr.mr_n69202768)
print v(xbgr.mr_n69203088)
print v(xbgr.mr_n69203200)
print v(xbgr.mr_n69203520)
print v(xbgr.mr_n69203632)
print v(xbgr.mr_n69204064)
print v(xbgr.mr_n69204496)
print v(xbgr.mr_n69204928)
print v(xbgr.mr_n69205360)
print v(xbgr.mr_n69205680)
print v(xbgr.mr_n69205792)
print v(xbgr.mr_n69206112)
print v(xbgr.mr_n69206224)
print v(xbgr.mr_n69206656)
print v(xbgr.mr_n69207088)
print v(xbgr.mr_n69207520)
print v(xbgr.mr_n69207952)
print v(xbgr.mr_n69208384)
print v(xbgr.mr_n69208816)
print v(xbgr.mr_n69209248)
print v(xbgr.mr_n69209680)
print v(xbgr.mr_n69210112)
print v(xbgr.mr_n69210544)
print v(xbgr.mr_n69210976)
print v(xbgr.mr_n69211408)
print v(xbgr.mr_n69211840)
print v(xbgr.mr_n69212272)
print v(xbgr.mr_n69212704)
print v(xbgr.mr_n69213136)
print v(xbgr.mr_n69213568)
print v(xbgr.mr_n69214000)
print v(xbgr.mr_n69214432)
print v(xbgr.mr_n69214864)
print v(xbgr.mr_n69215296)
print v(xbgr.mr_n69215728)
print v(xbgr.mr_n69216048)
print v(xbgr.mr_n69216160)
print v(xbgr.mr_n69216592)
print v(xbgr.mr_n69216912)
print v(xbgr.mr_n69217024)
print v(xbgr.mr_n69217456)
print v(xbgr.mr_n69217776)
print v(xbgr.mr_n69217888)
print v(xbgr.mr_n69218320)
print v(xbgr.mr_n69218640)
print v(xbgr.mr_n69218752)
print v(xbgr.mr_n69219184)
print v(xbgr.mr_n69219504)
print v(xbgr.mr_n69219616)
print v(xbgr.mr_n69220048)
print v(xbgr.mr_n69220368)
print v(xbgr.mr_n69220480)
print v(xbgr.mr_n69220800)
print v(xbgr.mr_n69220912)
print v(xbgr.mr_n69221232)
print v(xbgr.mr_n69221344)
print v(xbgr.mr_n69221776)
print v(xbgr.mr_n69222208)
print v(xbgr.mr_n69222640)
print v(xbgr.mr_n69222960)
print v(xbgr.mr_n69223072)
print v(xbgr.mr_n69223392)
print v(xbgr.mr_n69223504)
print v(xbgr.mr_n69223824)
print v(xbgr.mr_n69223936)
print v(xbgr.mr_n69224256)
print v(xbgr.mr_n69224368)
print v(xbgr.mr_n69224688)
print v(xbgr.mr_n69224800)
print v(xbgr.mr_n69225120)
print v(xbgr.mr_n69225232)
print v(xbgr.mr_n69225552)
print v(xbgr.mr_n69225664)
print v(xbgr.mr_n69226096)
print v(xbgr.mr_n69226416)
print v(xbgr.mr_n69226528)
print v(xbgr.mr_n69226960)
print v(xbgr.mr_n69227280)
print v(xbgr.mr_n69227392)
print v(xbgr.mr_n69227824)
print v(xbgr.mr_n69228144)
print v(xbgr.mr_n69229008)
print v(xbgr.mr_n69229872)
print v(xbgr.mr_n69230736)
print v(xbgr.mr_n69231600)
print v(xbgr.mr_n69232464)
print v(xbgr.mr_n69233328)
print v(xbgr.mr_n69233440)
print v(xbgr.mr_n69233760)
print v(xbgr.mr_n69233872)
print v(xbgr.mr_n69234192)
print v(xbgr.mr_n69234304)
print v(xbgr.mr_n69234624)
print v(xbgr.mr_n69234736)
print v(xbgr.mr_n69235056)
print v(xbgr.mr_n69235920)
print v(xbgr.mr_n69236784)
print v(xbgr.mr_n69237648)
print v(xbgr.mr_n69237760)
print v(xbgr.mr_n69238080)
print v(xbgr.mr_n69238192)
print v(xbgr.mr_n69238512)
print v(xbgr.mr_n69238624)
print v(xbgr.mr_n69239056)
print v(xbgr.mr_n69239488)
print v(xbgr.mr_n69239920)
print v(xbgr.mr_n69240240)
print v(xbgr.mr_n69240352)
print v(xbgr.mr_n69240672)
print v(xbgr.mr_n69240784)
print v(xbgr.mr_n69241104)
print v(xbgr.mr_n69241216)
print v(xbgr.mr_n69241536)
print v(xbgr.mr_n69241648)
print v(xbgr.mr_n69241968)
print v(xbgr.mr_n69242080)
print v(xbgr.mr_n69242400)
print v(xbgr.mr_n69242512)
print v(xbgr.mr_n69242832)
print v(xbgr.mr_n69242944)
print v(xbgr.mr_n69243264)
print v(xbgr.mr_n69243376)
print v(xbgr.mr_n69243696)
print v(xbgr.mr_n69243808)
print v(xbgr.mr_n69244240)
print v(xbgr.mr_n69244560)
print v(xbgr.mr_n69244672)
print v(xbgr.mr_n69245104)
print v(xbgr.mr_n69245424)
print v(xbgr.mr_n69245536)
print v(xbgr.mr_n69245856)
print v(xbgr.mr_n69245968)
print v(xbgr.mr_n69246288)
print v(xbgr.mr_n69247152)
print v(xbgr.mr_n69248016)
print v(xbgr.mr_n69248128)
print v(xbgr.mr_n69248448)
print v(xbgr.mr_n69248560)
print v(xbgr.mr_n69248880)
print v(xbgr.mr_n69249744)
print v(xbgr.mr_n69250288)
print v(xbgr.mr_n69250720)
print v(xbgr.mr_n69251472)
print v(xbgr.mr_n69252336)
print v(xbgr.mr_n69252448)
print v(xbgr.mr_n69252768)
print v(xbgr.mr_n69252880)
print v(xbgr.mr_n69253200)
print v(xbgr.mr_n69253312)
print v(xbgr.mr_n69253632)
print v(xbgr.mr_n69253744)
print v(xbgr.mr_n69254064)
print v(xbgr.mr_n69254176)
print v(xbgr.mr_n69254496)
print v(xbgr.mr_n69254608)
print v(xbgr.mr_n69254928)
print v(xbgr.mr_n69255040)
print v(xbgr.mr_n69255360)
print v(xbgr.mr_n69255472)
print v(xbgr.mr_n69255792)
print v(xbgr.mr_n69256656)
print v(xbgr.mr_n69256768)
print v(xbgr.mr_n69257088)
print v(xbgr.mr_n69257200)
print v(xbgr.mr_n69257520)
print v(xbgr.mr_n69258384)
print v(xbgr.mr_n69259248)
print v(xbgr.mr_n69259360)
print v(xbgr.mr_n69259680)
print v(xbgr.mr_n69259792)
print v(xbgr.mr_n69260112)
print v(xbgr.mr_n69260224)
print v(xbgr.mr_n69260656)
print v(xbgr.mr_n69260976)
print v(xbgr.mr_n69261408)
print v(xbgr.mr_n69262704)
print v(xbgr.mr_n69262816)
print v(xbgr.mr_n69263136)
print v(xbgr.mr_n69263248)
print v(xbgr.mr_n69263568)
print v(xbgr.mr_n69263680)
print v(xbgr.mr_n69264000)
print v(xbgr.mr_n69264112)
print v(xbgr.mr_n69264432)
print v(xbgr.mr_n69264544)
print v(xbgr.mr_n69264976)
print v(xbgr.mr_n69265296)
print v(xbgr.mr_n69265408)
print v(xbgr.mr_n69265728)
print v(xbgr.mr_n69265840)
print v(xbgr.mr_n69266160)
print v(xbgr.mr_n69266272)
print v(xbgr.mr_n69266592)
print v(xbgr.mr_n69266704)
print v(xbgr.mr_n69267024)
print v(xbgr.mr_n69267888)
print v(xbgr.mr_n69268752)
print v(xbgr.mr_n69269616)
print v(xbgr.mr_n69270480)
print v(xbgr.mr_n69270592)
print v(xbgr.mr_n69270912)
print v(xbgr.mr_n69271024)
print v(xbgr.mr_n69271344)
print v(xbgr.mr_n69271456)
print v(xbgr.mr_n69271776)
print v(xbgr.mr_n69271888)
print v(xbgr.mr_n69272208)
print v(xbgr.mr_n69273072)
print v(xbgr.mr_n69273936)
print v(xbgr.mr_n69274800)
print v(xbgr.mr_n69275664)
print v(xbgr.mr_n69276096)
print v(xbgr.mr_n69276208)
print v(xbgr.mr_n69276528)
print v(xbgr.mr_n69276640)
print v(xbgr.mr_n69276960)
print v(xbgr.mr_n69277072)
print v(xbgr.mr_n69277392)
print v(xbgr.mr_n69277504)
print v(xbgr.mr_n69277824)
print v(xbgr.mr_n69277936)
print v(xbgr.mr_n69278256)
print v(xbgr.mr_n69278368)
print v(xbgr.mr_n69278688)
print v(xbgr.mr_n69278800)
print v(xbgr.mr_n69279120)
print v(xbgr.mr_n69279232)
print v(xbgr.mr_n69279664)
print v(xbgr.mr_n69279984)
print v(xbgr.mr_n69280096)
print v(xbgr.mr_n69280528)
print v(xbgr.mr_n69280848)
print v(xbgr.mr_n69280960)
print v(xbgr.mr_n69281392)
print v(xbgr.mr_n69281712)
print v(xbgr.mr_n69281824)
print v(xbgr.mr_n69282144)
print v(xbgr.mr_n69282256)
print v(xbgr.mr_n69282576)
print v(xbgr.mr_n69283440)
print v(xbgr.mr_n69284304)
print v(xbgr.mr_n69285168)
print v(xbgr.mr_n69286032)
print v(xbgr.mr_n69286896)
print v(xbgr.mr_n69287760)
print v(xbgr.mr_n69288624)
print v(xbgr.mr_n69289488)
print v(xbgr.mr_n69290352)
print v(xbgr.mr_n69290464)
print v(xbgr.mr_n69290784)
print v(xbgr.mr_n69290896)
print v(xbgr.mr_n69291216)
print v(xbgr.mr_n69292080)
print v(xbgr.mr_n69292192)
print v(xbgr.mr_n69292512)
print v(xbgr.mr_n69292624)
print v(xbgr.mr_n69292944)
print v(xbgr.mr_n69293056)
print v(xbgr.mr_n69293376)
print v(xbgr.mr_n69293488)
print v(xbgr.mr_n69293808)
print v(xbgr.mr_n69293920)
print v(xbgr.mr_n69294240)
print v(xbgr.mr_n69294352)
print v(xbgr.mr_n69294672)
print v(xbgr.mr_n69294784)
print v(xbgr.mr_n69295104)
print v(xbgr.mr_n69295216)
print v(xbgr.mr_n69295536)
print v(xbgr.mr_n69296400)
print v(xbgr.mr_n69297264)
print v(xbgr.mr_n69298128)
print v(xbgr.mr_n69298240)
print v(xbgr.mr_n69298560)
print v(xbgr.mr_n69299856)
print v(xbgr.mr_n69300720)
print v(xbgr.mr_n69301584)
print v(xbgr.mr_n69302448)
print v(xbgr.mr_n69302560)
print v(xbgr.mr_n69302880)
print v(xbgr.mr_n69302992)
print v(xbgr.mr_n69303424)
print v(xbgr.mr_n69303744)
print v(xbgr.mr_n69303856)
print v(xbgr.mr_n69304288)
print v(xbgr.mr_n69304608)
print v(xbgr.mr_n69304720)
print v(xbgr.mr_n69305152)
print v(xbgr.mr_n69305472)
print v(xbgr.mr_n69305584)
print v(xbgr.mr_n69306016)
print v(xbgr.mr_n69306336)
print v(xbgr.mr_n69306448)
print v(xbgr.mr_n69306880)
print v(xbgr.mr_n69307200)
print v(xbgr.mr_n69307312)
print v(xbgr.mr_n69307632)
print v(xbgr.mr_n69307744)
print v(xbgr.mr_n69308064)
print v(xbgr.mr_n69308176)
print v(xbgr.mr_n69308608)
print v(xbgr.mr_n69308928)
print v(xbgr.mr_n69309040)
print v(xbgr.mr_n69309360)
print v(xbgr.mr_n69309472)
print v(xbgr.mr_n69309792)
print v(xbgr.mr_n69309904)
print v(xbgr.mr_n69310224)
print v(xbgr.mr_n69310336)
print v(xbgr.mr_n69310656)
print v(xbgr.mr_n69310768)
print v(xbgr.mr_n69311088)
print v(xbgr.mr_n69311200)
print v(xbgr.mr_n69311520)
print v(xbgr.mr_n69311632)
print v(xbgr.mr_n69311952)
print v(xbgr.mr_n69312064)
print v(xbgr.mr_n69312496)
print v(xbgr.mr_n69312816)
print v(xbgr.mr_n69313792)
print v(xbgr.mr_n69314224)
print v(xbgr.mr_n69314544)
print v(xbgr.mr_n69315408)
print v(xbgr.mr_n69315520)
print v(xbgr.mr_n69315840)
print v(xbgr.mr_n69315952)
print v(xbgr.mr_n69316272)
print v(xbgr.mr_n69316384)
print v(xbgr.mr_n69316704)
print v(xbgr.mr_n69316816)
print v(xbgr.mr_n69317136)
print v(xbgr.mr_n69318000)
print v(xbgr.mr_n69318432)
print v(xbgr.mr_n69319296)
print v(xbgr.mr_n69320160)
print v(xbgr.mr_n69320272)
print v(xbgr.mr_n69320592)
print v(xbgr.mr_n69320704)
print v(xbgr.mr_n69321024)
print v(xbgr.mr_n69321136)
print v(xbgr.mr_n69321456)
print v(xbgr.mr_n69321568)
print v(xbgr.mr_n69322320)
print v(xbgr.mr_n69322432)
print v(xbgr.mr_n69322752)
print v(xbgr.mr_n69322864)
print v(xbgr.mr_n69323184)
print v(xbgr.mr_n69323296)
print v(xbgr.mr_n69323616)
print v(xbgr.mr_n69323728)
print v(xbgr.mr_n69324048)
print v(xbgr.mr_n69324592)
print v(xbgr.mr_n69324912)
print v(xbgr.mr_n69325024)
print v(xbgr.mr_n69325456)
print v(xbgr.mr_n69325776)
print v(xbgr.mr_n69325888)
print v(xbgr.mr_n69327072)
print v(xbgr.mr_n69327504)
print v(xbgr.mr_n69327616)
print v(xbgr.mr_n69327936)
print v(xbgr.mr_n69328048)
print v(xbgr.mr_n69328368)
print v(xbgr.mr_n69328480)
print v(xbgr.mr_n69328800)
print v(xbgr.mr_n69328912)
print v(xbgr.mr_n69329232)
print v(xbgr.mr_n69329344)
print v(xbgr.mr_n69329664)
print v(xbgr.mr_n69329776)
print v(xbgr.mr_n69330528)
print v(xbgr.mr_n69331392)
print v(xbgr.mr_n69331504)
print v(xbgr.mr_n69331824)
print v(xbgr.mr_n69331936)
print v(xbgr.mr_n69332256)
print v(xbgr.mr_n69332368)
print v(xbgr.mr_n69332688)
print v(xbgr.mr_n69332800)
print v(xbgr.mr_n69333120)
print v(xbgr.mr_n69333232)
print v(xbgr.mr_n69333552)
print v(xbgr.mr_n69333664)
print v(xbgr.mr_n69333984)
print v(xbgr.mr_n69334096)
print v(xbgr.mr_n69334416)
print v(xbgr.mr_n69334528)
print v(xbgr.mr_n69334848)
print v(xbgr.mr_n69335712)
print v(xbgr.mr_n69336576)
print v(xbgr.mr_n69337440)
print v(xbgr.mr_n69337552)
print v(xbgr.mr_n69337984)
print v(xbgr.mr_n69338416)
print v(xbgr.mr_n69338736)
print v(xbgr.mr_n69339168)
print v(xbgr.mr_n69339280)
print v(xbgr.mr_n69339600)
print v(xbgr.mr_n69339712)
print v(xbgr.mr_n69340464)
print v(xbgr.mr_n69341872)
print v(xbgr.mr_n69342192)
print v(xbgr.mr_n69342304)
print v(xbgr.mr_n69342624)
print v(xbgr.mr_n69342736)
print v(xbgr.mr_n69343056)
print v(xbgr.mr_n69343168)
print v(xbgr.mr_n69343600)
print v(xbgr.mr_n69343920)
print v(xbgr.mr_n69344032)
print v(xbgr.mr_n69344464)
print v(xbgr.mr_n69344784)
print v(xbgr.mr_n69345216)
print v(xbgr.mr_n69345648)
print v(xbgr.mr_n69345760)
print v(xbgr.mr_n69346080)
print v(xbgr.mr_n69346192)
print v(xbgr.mr_n69346512)
print v(xbgr.mr_n69346624)
print v(xbgr.mr_n69347376)
print v(xbgr.mr_n69348240)
print v(xbgr.mr_n69348352)
print v(xbgr.mr_n69348784)
print v(xbgr.mr_n69349104)
print v(xbgr.mr_n69349968)
print v(xbgr.mr_n69350832)
print v(xbgr.mr_n69352128)
print v(xbgr.mr_n69352560)
print v(xbgr.mr_n69352672)
print v(xbgr.mr_n69352992)
print v(xbgr.mr_n69353104)
print v(xbgr.mr_n69353424)
print v(xbgr.mr_n69353536)
print v(xbgr.mr_n69353856)
print v(xbgr.mr_n69353968)
print v(xbgr.mr_n69354288)
print v(xbgr.mr_n69354400)
print v(xbgr.mr_n69354720)
print v(xbgr.mr_n69354832)
print v(xbgr.mr_n69355152)
print v(xbgr.mr_n69355264)
print v(xbgr.mr_n69355584)
print v(xbgr.mr_n69355696)
print v(xbgr.mr_n69356448)
print v(xbgr.mr_n69357312)
print v(xbgr.mr_n69358176)
print v(xbgr.mr_n69358288)
print v(xbgr.mr_n69358608)
print v(xbgr.mr_n69358720)
print v(xbgr.mr_n69359040)
print v(xbgr.mr_n69359152)
print v(xbgr.mr_n69359472)
print v(xbgr.mr_n69360336)
print v(xbgr.mr_n69361200)
print v(xbgr.mr_n69362064)
print v(xbgr.mr_n69362928)
print v(xbgr.mr_n69363792)
print v(xbgr.mr_n69364656)
print v(xbgr.mr_n69364768)
print v(xbgr.mr_n69365088)
print v(xbgr.mr_n69365952)
print v(xbgr.mr_n69366064)
print v(xbgr.mr_n69366384)
print v(xbgr.mr_n69366496)
print v(xbgr.mr_n69366816)
print v(xbgr.mr_n69367680)
print v(xbgr.mr_n69368112)
print v(xbgr.mr_n69368224)
print v(xbgr.mr_n69368976)
print v(xbgr.mr_n69369088)
print v(xbgr.mr_n69369408)
print v(xbgr.mr_n69369520)
print v(xbgr.mr_n69369840)
print v(xbgr.mr_n69369952)
print v(xbgr.mr_n69370272)
print v(xbgr.mr_n69370384)
print v(xbgr.mr_n69370704)
print v(xbgr.mr_n69370816)
print v(xbgr.mr_n69371136)
print v(xbgr.mr_n69371248)
print v(xbgr.mr_n69371568)
print v(xbgr.mr_n69371680)
print v(xbgr.mr_n69372000)
print v(xbgr.mr_n69372112)
print v(xbgr.mr_n69372432)
print v(xbgr.mr_n69372544)
print v(xbgr.mr_n69372864)
print v(xbgr.mr_n69373408)
print v(xbgr.mr_n69374160)
print v(xbgr.mr_n69375024)
print v(xbgr.mr_n69375888)
print v(xbgr.mr_n69376000)
print v(xbgr.mr_n69376432)
print v(xbgr.mr_n69376752)
print v(xbgr.mr_n69377616)
print v(xbgr.mr_n69378480)
print v(xbgr.mr_n69379344)
print v(xbgr.mr_n69380208)
print v(xbgr.mr_n69381072)
print v(xbgr.mr_n69381936)
print v(xbgr.mr_n69382048)
print v(xbgr.mr_n69382368)
print v(xbgr.mr_n69382480)
print v(xbgr.mr_n69382800)
print v(xbgr.mr_n69383664)
print v(xbgr.mr_n69384528)
print v(xbgr.mr_n69384640)
print v(xbgr.mr_n69384960)
print v(xbgr.mr_n69385072)
print v(xbgr.mr_n69385392)
print v(xbgr.mr_n69385504)
print v(xbgr.mr_n69385824)
print v(xbgr.mr_n69385936)
print v(xbgr.mr_n69386256)
print v(xbgr.mr_n69386368)
print v(xbgr.mr_n69386688)
print v(xbgr.mr_n69386800)
print v(xbgr.mr_n69387120)
print v(xbgr.mr_n69387232)
print v(xbgr.mr_n69387552)
print v(xbgr.mr_n69388416)
print v(xbgr.mr_n69388528)
print v(xbgr.mr_n69388848)
print v(xbgr.mr_n69388960)
print v(xbgr.mr_n69389280)
print v(xbgr.mr_n69389392)
print v(xbgr.mr_n69389712)
print v(xbgr.mr_n69389824)
print v(xbgr.mr_n69390144)
print v(xbgr.mr_n69390256)
print v(xbgr.mr_n69390576)
print v(xbgr.mr_n69390688)
print v(xbgr.mr_n69391008)
print v(xbgr.mr_n69391120)
print v(xbgr.mr_n69391440)
print v(xbgr.mr_n69391552)
print v(xbgr.mr_n69391984)
print v(xbgr.mr_n69392416)
print v(xbgr.mr_n69392848)
print v(xbgr.mr_n69393168)
print v(xbgr.mr_n69393280)
print v(xbgr.mr_n69393600)
print v(xbgr.mr_n69393712)
print v(xbgr.mr_n69394032)
print v(xbgr.mr_n69394144)
print v(xbgr.mr_n69394464)
print v(xbgr.mr_n69394576)
print v(xbgr.mr_n69394896)
print v(xbgr.mr_n69395008)
print v(xbgr.mr_n69395328)
print v(xbgr.mr_n69395440)
print v(xbgr.mr_n69395760)
print v(xbgr.mr_n69395872)
print v(xbgr.mr_n69396192)
print v(xbgr.mr_n69396304)
print v(xbgr.mr_n69396624)
print v(xbgr.mr_n69396736)
print v(xbgr.mr_n69397056)
print v(xbgr.mr_n69397168)
print v(xbgr.mr_n69397488)
print v(xbgr.mr_n69397600)
print v(xbgr.mr_n69397920)
print v(xbgr.mr_n69398032)
print v(xbgr.mr_n69398352)
print v(xbgr.mr_n69398464)
print v(xbgr.mr_n69398784)
print v(xbgr.mr_n69398896)
print v(xbgr.mr_n69399216)
print v(xbgr.mr_n69399328)
print v(xbgr.mr_n69399648)
print v(xbgr.mr_n69399760)
print v(xbgr.mr_n69400192)
print v(xbgr.mr_n69400512)
print v(xbgr.mr_n69400624)
print v(xbgr.mr_n69401056)
print v(xbgr.mr_n69401488)
print v(xbgr.mr_n69401808)
print v(xbgr.mr_n69401920)
print v(xbgr.mr_n69402240)
print v(xbgr.mr_n69402352)
print v(xbgr.mr_n69402672)
print v(xbgr.mr_n69402784)
print v(xbgr.mr_n69403104)
print v(xbgr.mr_n69403216)
print v(xbgr.mr_n69403648)
print v(xbgr.mr_n69404080)
print v(xbgr.mr_n69404512)
print v(xbgr.mr_n69404944)
print v(xbgr.mr_n69405376)
print v(xbgr.mr_n69405808)
print v(xbgr.mr_n69406240)
print v(xbgr.mr_n69406672)
print v(xbgr.mr_n69406992)
print v(xbgr.mr_n69407104)
print v(xbgr.mr_n69407424)
print v(xbgr.mr_n69407536)
print v(xbgr.mr_n69407856)
print v(xbgr.mr_n69407968)
print v(xbgr.mr_n69408288)
print v(xbgr.mr_n69408400)
print v(xbgr.mr_n69408720)
print v(xbgr.mr_n69408832)
print v(xbgr.mr_n69409152)
print v(xbgr.mr_n69409264)
print v(xbgr.mr_n69409584)
print v(xbgr.mr_n69409696)
print v(xbgr.mr_n69410016)
print v(xbgr.mr_n69410128)
print v(xbgr.mr_n69410448)
print v(xbgr.mr_n69410560)
print v(xbgr.mr_n69410880)
print v(xbgr.mr_n69410992)
print v(xbgr.mr_n69411312)
print v(xbgr.mr_n69411424)
print v(xbgr.mr_n69411744)
print v(xbgr.mr_n69411856)
print v(xbgr.mr_n69412176)
print v(xbgr.mr_n69412288)
print v(xbgr.mr_n69412608)
print v(xbgr.mr_n69412720)
print v(xbgr.mr_n69413040)
print v(xbgr.mr_n69413152)
print v(xbgr.mr_n69413472)
print v(xbgr.mr_n69413584)
print v(xbgr.mr_n69413904)
print v(xbgr.mr_n69414016)
print v(xbgr.mr_n69414336)
print v(xbgr.mr_n69414448)
print v(xbgr.mr_n69414768)
print v(xbgr.mr_n69414880)
print v(xbgr.mr_n69415200)
print v(xbgr.mr_n69415312)
print v(xbgr.mr_n69415632)
print v(xbgr.mr_n69415744)
print v(xbgr.mr_n69416064)
print v(xbgr.mr_n69416176)
print v(xbgr.mr_n69416496)
print v(xbgr.mr_n69416608)
print v(xbgr.mr_n69416928)
print v(xbgr.mr_n69417040)
print v(xbgr.mr_n69417472)
print v(xbgr.mr_n69417904)
print v(xbgr.mr_n69418224)
print v(xbgr.mr_n69418336)
print v(xbgr.mr_n69418656)
print v(xbgr.mr_n69418768)
print v(xbgr.mr_n69419200)
print v(xbgr.mr_n69419632)
print v(xbgr.mr_n69420064)
print v(xbgr.mr_n69420496)
print v(xbgr.mr_n69420928)
print v(xbgr.mr_n69421360)
print v(xbgr.mr_n69421792)
print v(xbgr.mr_n69422224)
print v(xbgr.mr_n69422656)
print v(xbgr.mr_n69423088)
print v(xbgr.mr_n69423520)
print v(xbgr.mr_n69423952)
print v(xbgr.mr_n69424384)
print v(xbgr.mr_n69424816)
print v(xbgr.mr_n69425248)
print v(xbgr.mr_n69425680)
print v(xbgr.mr_n69426112)
print v(xbgr.mr_n69426544)
print v(xbgr.mr_n69426976)
print v(xbgr.mr_n69427408)
print v(xbgr.mr_n69427840)
print v(xbgr.mr_n69428272)
print v(xbgr.mr_n69428704)
print v(xbgr.mr_n69429136)
print v(xbgr.mr_n69429456)
print v(xbgr.mr_n69429568)
print v(xbgr.mr_n69429888)
print v(xbgr.mr_n69430000)
print v(xbgr.mr_n69430320)
print v(xbgr.mr_n69430432)
print v(xbgr.mr_n69430752)
print v(xbgr.mr_n69430864)
print v(xbgr.mr_n69431184)
print v(xbgr.mr_n69431296)
print v(xbgr.mr_n69431616)
print v(xbgr.mr_n69431728)
print v(xbgr.mr_n69432048)
print v(xbgr.mr_n69432160)
print v(xbgr.mr_n69432480)
print v(xbgr.mr_n69432592)
print v(xbgr.mr_n69432912)
print v(xbgr.mr_n69433024)
print v(xbgr.mr_n69433344)
print v(xbgr.mr_n69433456)
print v(xbgr.mr_n69433776)
print v(xbgr.mr_n69433888)
print v(xbgr.mr_n69434208)
print v(xbgr.mr_n69434320)
print v(xbgr.mr_n69434640)
print v(xbgr.mr_n69434752)
print v(xbgr.mr_n69435184)
print v(xbgr.mr_n69435616)
print v(xbgr.mr_n69436048)
print v(xbgr.mr_n69436480)
print v(xbgr.mr_n69436912)
print v(xbgr.mr_n69437344)
print v(xbgr.mr_n69437776)
print v(xbgr.mr_n69438208)
print v(xbgr.mr_n69438640)
print v(xbgr.mr_n69439072)
print v(xbgr.mr_n69439504)
print v(xbgr.mr_n69439936)
print v(xbgr.mr_n69440368)
print v(xbgr.mr_n69440688)
print v(xbgr.mr_n69440800)
print v(xbgr.mr_n69441120)
print v(xbgr.mr_n69441232)
print v(xbgr.mr_n69441552)
print v(xbgr.mr_n69441664)
print v(xbgr.mr_n69441984)
print v(xbgr.mr_n69442096)
print v(xbgr.mr_n69442416)
print v(xbgr.mr_n69442528)
print v(xbgr.mr_n69442848)
print v(xbgr.mr_n69442960)
print v(xbgr.mr_n69443280)
print v(xbgr.mr_n69443392)
print v(xbgr.mr_n69443712)
print v(xbgr.mr_n69443824)
print v(xbgr.mr_n69444144)
print v(xbgr.mr_n69444256)
print v(xbgr.mr_n69444576)
print v(xbgr.mr_n69444688)
print v(xbgr.mr_n69445008)
print v(xbgr.mr_n69445120)
print v(xbgr.mr_n69445440)
print v(xbgr.mr_n69445552)
print v(xbgr.mr_n69445872)
print v(xbgr.mr_n69445984)
print v(xbgr.mr_n69446416)
print v(xbgr.mr_n69446848)
print v(xbgr.mr_n69447280)
print v(xbgr.mr_n69447712)
print v(xbgr.mr_n69448144)
print v(xbgr.mr_n69448576)
print v(xbgr.mr_n69449008)
print v(xbgr.mr_n69449440)
print v(xbgr.mr_n69449872)
print v(xbgr.mr_n69450304)
print v(xbgr.mr_n69450736)
print v(xbgr.mr_n69451168)
print v(xbgr.mr_n69451600)
print v(xbgr.mr_n69451920)
print v(xbgr.mr_n69452032)
print v(xbgr.mr_n69452352)
print v(xbgr.mr_n69452464)
print v(xbgr.mr_n69452784)
print v(xbgr.mr_n69452896)
print v(xbgr.mr_n69453216)
print v(xbgr.mr_n69453328)
print v(xbgr.mr_n69453648)
print v(xbgr.mr_n69453760)
print v(xbgr.mr_n69454080)
print v(xbgr.mr_n69454192)
print v(xbgr.mr_n69454512)
print v(xbgr.mr_n69454624)
print v(xbgr.mr_n69454944)
print v(xbgr.mr_n69455056)
print v(xbgr.mr_n69455376)
print v(xbgr.mr_n69455488)
print v(xbgr.mr_n69455808)
print v(xbgr.mr_n69455920)
print v(xbgr.mr_n69456240)
print v(xbgr.mr_n69456352)
print v(xbgr.mr_n69456672)
print v(xbgr.mr_n69456784)
print v(xbgr.mr_n69457104)
print v(xbgr.mr_n69457216)
print v(xbgr.mr_n69457648)
print v(xbgr.mr_n69458080)
print v(xbgr.mr_n69458512)
print v(xbgr.mr_n69458944)
print v(xbgr.mr_n69459376)
print v(xbgr.mr_n69459808)
print v(xbgr.mr_n69460240)
print v(xbgr.mr_n69460672)
print v(xbgr.mr_n69461104)
print v(xbgr.mr_n69461536)
print v(xbgr.mr_n69461968)
print v(xbgr.mr_n69462400)
print v(xbgr.mr_n69462832)
print v(xbgr.mr_n69463152)
print v(xbgr.mr_n69463264)
print v(xbgr.mr_n69463584)
print v(xbgr.mr_n69463696)
print v(xbgr.mr_n69464016)
print v(xbgr.mr_n69464128)
print v(xbgr.mr_n69464448)
print v(xbgr.mr_n69464560)
print v(xbgr.mr_n69464880)
print v(xbgr.mr_n69464992)
print v(xbgr.mr_n69465312)
print v(xbgr.mr_n69465424)
print v(xbgr.mr_n69465744)
print v(xbgr.mr_n69465856)
print v(xbgr.mr_n69466288)
print v(xbgr.mr_n69466720)
print v(xbgr.mr_n69467152)
print v(xbgr.mr_n69467584)
print v(xbgr.mr_n69467904)
print v(xbgr.mr_n69468016)
print v(xbgr.mr_n69468336)
print v(xbgr.mr_n69468448)
print v(xbgr.mr_n69468768)
print v(xbgr.mr_n69468880)
print v(xbgr.mr_n69469200)
print v(xbgr.mr_n69469312)
print v(xbgr.mr_n69469632)
print v(xbgr.mr_n69469744)
print v(xbgr.mr_n69470064)
print v(xbgr.mr_n69470176)
print v(xbgr.mr_n69470608)
print v(xbgr.mr_n69471040)
print v(xbgr.mr_n69471472)
print v(xbgr.mr_n69471904)
print v(xbgr.mr_n69472336)
print v(xbgr.mr_n69472768)
print v(xbgr.mr_n69473200)
print v(xbgr.mr_n69473632)
print v(xbgr.mr_n69474064)
print v(xbgr.mr_n69474384)
print v(xbgr.mr_n69474496)
print v(xbgr.mr_n69474816)
print v(xbgr.mr_n69474928)
print v(xbgr.mr_n69475248)
print v(xbgr.mr_n69475360)
print v(xbgr.mr_n69475680)
print v(xbgr.mr_n69475792)
print v(xbgr.mr_n69476112)
print v(xbgr.mr_n69476224)
print v(xbgr.mr_n69476544)
print v(xbgr.mr_n69476656)
print v(xbgr.mr_n69476976)
print v(xbgr.mr_n69477088)
print v(xbgr.mr_n69477408)
print v(xbgr.mr_n69477520)
print v(xbgr.mr_n69477840)
print v(xbgr.mr_n69477952)
print v(xbgr.mr_n69478272)
print v(xbgr.mr_n69478384)
print v(xbgr.mr_n69478704)
print v(xbgr.mr_n69478816)
print v(xbgr.mr_n69479136)
print v(xbgr.mr_n69479248)
print v(xbgr.mr_n69479568)
print v(xbgr.mr_n69479680)
print v(xbgr.mr_n69480000)
print v(xbgr.mr_n69480112)
print v(xbgr.mr_n69480544)
print v(xbgr.mr_n69480976)
print v(xbgr.mr_n69481408)
print v(xbgr.mr_n69481840)
print v(xbgr.mr_n69482160)
print v(xbgr.mr_n69482272)
print v(xbgr.mr_n69482592)
print v(xbgr.mr_n69482704)
print v(xbgr.mr_n69483136)
print v(xbgr.mr_n69483568)
print v(xbgr.mr_n69484000)
print v(xbgr.mr_n69484432)
print v(xbgr.mr_n69484864)
print v(xbgr.mr_n69485296)
print v(xbgr.mr_n69485728)
print v(xbgr.mr_n69486160)
print v(xbgr.mr_n69486480)
print v(xbgr.mr_n69486592)
print v(xbgr.mr_n69486912)
print v(xbgr.mr_n69487024)
print v(xbgr.mr_n69487344)
print v(xbgr.mr_n69487456)
print v(xbgr.mr_n69487776)
print v(xbgr.mr_n69487888)
print v(xbgr.mr_n69488208)
print v(xbgr.mr_n69488320)
print v(xbgr.mr_n69488640)
print v(xbgr.mr_n69488752)
print v(xbgr.mr_n69489072)
print v(xbgr.mr_n69489184)
print v(xbgr.mr_n69489504)
print v(xbgr.mr_n69489616)
print v(xbgr.mr_n69489936)
print v(xbgr.mr_n69490048)
print v(xbgr.mr_n69490368)
print v(xbgr.mr_n69490480)
print v(xbgr.mr_n69490800)
print v(xbgr.mr_n69490912)
print v(xbgr.mr_n69491232)
print v(xbgr.mr_n69491344)
print v(xbgr.mr_n69491776)
print v(xbgr.mr_n69492208)
print v(xbgr.mr_n69492640)
print v(xbgr.mr_n69493072)
print v(xbgr.mr_n69493504)
print v(xbgr.mr_n69493936)
print v(xbgr.mr_n69494256)
print v(xbgr.mr_n69494368)
print v(xbgr.mr_n69494688)
print v(xbgr.mr_n69494800)
print v(xbgr.mr_n69495120)
print v(xbgr.mr_n69495232)
print v(xbgr.mr_n69495552)
print v(xbgr.mr_n69495664)
print v(xbgr.mr_n69495984)
print v(xbgr.mr_n69496096)
print v(xbgr.mr_n69496416)
print v(xbgr.mr_n69496528)
print v(xbgr.mr_n69496848)
print v(xbgr.mr_n69496960)
print v(xbgr.mr_n69497280)
print v(xbgr.mr_n69497392)
print v(xbgr.mr_n69497712)
print v(xbgr.mr_n69497824)
print v(xbgr.mr_n69498144)
print v(xbgr.mr_n69498256)
print v(xbgr.mr_n69498576)
print v(xbgr.mr_n69498688)
print v(xbgr.mr_n69499008)
print v(xbgr.mr_n69499120)
print v(xbgr.mr_n69499440)
print v(xbgr.mr_n69499552)
print v(xbgr.mr_n69499872)
print v(xbgr.mr_n69499984)
print v(xbgr.mr_n69500304)
print v(xbgr.mr_n69500416)
print v(xbgr.mr_n69500736)
print v(xbgr.mr_n69500848)
print v(xbgr.mr_n69501168)
print v(xbgr.mr_n69501280)
print v(xbgr.mr_n69501600)
print v(xbgr.mr_n69501712)
print v(xbgr.mr_n69502144)
print v(xbgr.mr_n69502576)
print v(xbgr.mr_n69502896)
print v(xbgr.mr_n69503008)
print v(xbgr.mr_n69503328)
print v(xbgr.mr_n69503440)
print v(xbgr.mr_n69503760)
print v(xbgr.mr_n69503872)
print v(xbgr.mr_n69504192)
print v(xbgr.mr_n69504304)
print v(xbgr.mr_n69504736)
print v(xbgr.mr_n69505168)
print v(xbgr.mr_n69505600)
print v(xbgr.mr_n69506032)
print v(xbgr.mr_n69506464)
print v(xbgr.mr_n69506896)
print v(xbgr.mr_n69507328)
print v(xbgr.mr_n69507760)
print v(xbgr.mr_n69508192)
print v(xbgr.mr_n69508624)
print v(xbgr.mr_n69509056)
print v(xbgr.mr_n69509488)
print v(xbgr.mr_n69509920)
print v(xbgr.mr_n69510352)
print v(xbgr.mr_n69510784)
print v(xbgr.mr_n69511216)
print v(xbgr.mr_n69511536)
print v(xbgr.mr_n69511648)
print v(xbgr.mr_n69511968)
print v(xbgr.mr_n69512080)
print v(xbgr.mr_n69512400)
print v(xbgr.mr_n69512512)
print v(xbgr.mr_n69512832)
print v(xbgr.mr_n69512944)
print v(xbgr.mr_n69513264)
print v(xbgr.mr_n69513376)
print v(xbgr.mr_n69513696)
print v(xbgr.mr_n69513808)
print v(xbgr.mr_n69514128)
print v(xbgr.mr_n69514240)
print v(xbgr.mr_n69514560)
print v(xbgr.mr_n69514672)
print v(xbgr.mr_n69514992)
print v(xbgr.mr_n69515104)
print v(xbgr.mr_n69515424)
print v(xbgr.mr_n69515536)
print v(xbgr.mr_n69515968)
print v(xbgr.mr_n69516400)
print v(xbgr.mr_n69516832)
print v(xbgr.mr_n69517264)
print v(xbgr.mr_n69517696)
print v(xbgr.mr_n69518128)
print v(xbgr.mr_n69518560)
print v(xbgr.mr_n69518992)
print v(xbgr.mr_n69519312)
print v(xbgr.mr_n69519424)
print v(xbgr.mr_n69519744)
print v(xbgr.mr_n69519856)
print v(xbgr.mr_n69520176)
print v(xbgr.mr_n69520288)
print v(xbgr.mr_n69520608)
print v(xbgr.mr_n69520720)
print v(xbgr.mr_n69521040)
print v(xbgr.mr_n69521152)
print v(xbgr.mr_n69521472)
print v(xbgr.mr_n69521584)
print v(xbgr.mr_n69521904)
print v(xbgr.mr_n69522016)
print v(xbgr.mr_n69522336)
print v(xbgr.mr_n69522448)
print v(xbgr.mr_n69522768)
print v(xbgr.mr_n69522880)
print v(xbgr.mr_n69523200)
print v(xbgr.mr_n69523312)
print v(xbgr.mr_n69523632)
print v(xbgr.mr_n69523744)
print v(xbgr.mr_n69524064)
print v(xbgr.mr_n69524176)
print v(xbgr.mr_n69524496)
print v(xbgr.mr_n69524608)
print v(xbgr.mr_n69524928)
print v(xbgr.mr_n69525040)
print v(xbgr.mr_n69525472)
print v(xbgr.mr_n69525904)
print v(xbgr.mr_n69526336)
print v(xbgr.mr_n69526768)
print v(xbgr.mr_n69527200)
print v(xbgr.mr_n69527632)
print v(xbgr.mr_n69528064)
print v(xbgr.mr_n69528496)
print v(xbgr.mr_n69528928)
print v(xbgr.mr_n69529360)
print v(xbgr.mr_n69529792)
print v(xbgr.mr_n69530224)
print v(xbgr.mr_n69530656)
print v(xbgr.mr_n69531088)
print v(xbgr.mr_n69531408)
print v(xbgr.mr_n69531520)
print v(xbgr.mr_n69531840)
print v(xbgr.mr_n69531952)
print v(xbgr.mr_n69532272)
print v(xbgr.mr_n69532384)
print v(xbgr.mr_n69532704)
print v(xbgr.mr_n69532816)
print v(xbgr.mr_n69533136)
print v(xbgr.mr_n69533248)
print v(xbgr.mr_n69533568)
print v(xbgr.mr_n69533680)
print v(xbgr.mr_n69534000)
print v(xbgr.mr_n69534112)
print v(xbgr.mr_n69534432)
print v(xbgr.mr_n69534544)
print v(xbgr.mr_n69534864)
print v(xbgr.mr_n69534976)
print v(xbgr.mr_n69535296)
print v(xbgr.mr_n69535408)
print v(xbgr.mr_n69535728)
print v(xbgr.mr_n69535840)
print v(xbgr.mr_n69536160)
print v(xbgr.mr_n69536272)
print v(xbgr.mr_n69536592)
print v(xbgr.mr_n69536704)
print v(xbgr.mr_n69537024)
print v(xbgr.mr_n69537136)
print v(xbgr.mr_n69537456)
print v(xbgr.mr_n69537568)
print v(xbgr.mr_n69537888)
print v(xbgr.mr_n69538000)
print v(xbgr.mr_n69538320)
print v(xbgr.mr_n69538432)
print v(xbgr.mr_n69538752)
print v(xbgr.mr_n69538864)
print v(xbgr.mr_n69539184)
print v(xbgr.mr_n69539296)
print v(xbgr.mr_n69539616)
print v(xbgr.mr_n69539728)
print v(xbgr.mr_n69540048)
print v(xbgr.mr_n69540160)
print v(xbgr.mr_n69540480)
print v(xbgr.mr_n69540592)
print v(xbgr.mr_n69540912)
print v(xbgr.mr_n69541024)
print v(xbgr.mr_n69541344)
print v(xbgr.mr_n69541456)
print v(xbgr.mr_n69541888)
print v(xbgr.mr_n69542320)
print v(xbgr.mr_n69542752)
print v(xbgr.mr_n69543184)
print v(xbgr.mr_n69543616)
print v(xbgr.mr_n69544048)
print v(xbgr.mr_n69544480)
print v(xbgr.mr_n69544912)
print v(xbgr.mr_n69545344)
print v(xbgr.mr_n69545776)
print v(xbgr.mr_n69546208)
print v(xbgr.mr_n69546640)
print v(xbgr.mr_n69547072)
print v(xbgr.mr_n69547504)
print v(xbgr.mr_n69547936)
print v(xbgr.mr_n69548368)
print v(xbgr.mr_n69548688)
print v(xbgr.mr_n69548800)
print v(xbgr.mr_n69549120)
print v(xbgr.mr_n69549232)
print v(xbgr.mr_n69549664)
print v(xbgr.mr_n69550096)
print v(xbgr.mr_n69550528)
print v(xbgr.mr_n69550960)
print v(xbgr.mr_n69551392)
print v(xbgr.mr_n69551824)
print v(xbgr.mr_n69552256)
print v(xbgr.mr_n69552688)
print v(xbgr.mr_n69553120)
print v(xbgr.mr_n69553552)
print v(xbgr.mr_n69553872)
print v(xbgr.mr_n69553984)
print v(xbgr.mr_n69554304)
print v(xbgr.mr_n69554416)
print v(xbgr.mr_n69554736)
print v(xbgr.mr_n69554848)
print v(xbgr.mr_n69555168)
print v(xbgr.mr_n69555280)
print v(xbgr.mr_n69555600)
print v(xbgr.mr_n69555712)
print v(xbgr.mr_n69556032)
print v(xbgr.mr_n69556144)
print v(xbgr.mr_n69556464)
print v(xbgr.mr_n69556576)
print v(xbgr.mr_n69556896)
print v(xbgr.mr_n69557008)
print v(xbgr.mr_n69557328)
print v(xbgr.mr_n69557440)
print v(xbgr.mr_n69557760)
print v(xbgr.mr_n69557872)
print v(xbgr.mr_n69558192)
print v(xbgr.mr_n69558304)
print v(xbgr.mr_n69558624)
print v(xbgr.mr_n69558736)
print v(xbgr.mr_n69559056)
print v(xbgr.mr_n69559168)
print v(xbgr.mr_n69559600)
print v(xbgr.mr_n69560032)
print v(xbgr.mr_n69560464)
print v(xbgr.mr_n69560896)
print v(xbgr.mr_n69561328)
print v(xbgr.mr_n69561760)
print v(xbgr.mr_n69562192)
print v(xbgr.mr_n69562624)
print v(xbgr.mr_n69563056)
print v(xbgr.mr_n69563488)
print v(xbgr.mr_n69563920)
print v(xbgr.mr_n69564352)
print v(xbgr.mr_n69564784)
print v(xbgr.mr_n69565104)
print v(xbgr.mr_n69565216)
print v(xbgr.mr_n69565536)
print v(xbgr.mr_n69565648)
print v(xbgr.mr_n69565968)
print v(xbgr.mr_n69566080)
print v(xbgr.mr_n69566400)
print v(xbgr.mr_n69566512)
print v(xbgr.mr_n69566832)
print v(xbgr.mr_n69566944)
print v(xbgr.mr_n69567264)
print v(xbgr.mr_n69567376)
print v(xbgr.mr_n69567696)
print v(xbgr.mr_n69567808)
print v(xbgr.mr_n69568128)
print v(xbgr.mr_n69568240)
print v(xbgr.mr_n69568560)
print v(xbgr.mr_n69568672)
print v(xbgr.mr_n69568992)
print v(xbgr.mr_n69569104)
print v(xbgr.mr_n69569424)
print v(xbgr.mr_n69569536)
print v(xbgr.mr_n69569856)
print v(xbgr.mr_n69569968)
print v(xbgr.mr_n69570288)
print v(xbgr.mr_n69570400)
print v(xbgr.mr_n69570832)
print v(xbgr.mr_n69571264)
print v(xbgr.mr_n69571696)
print v(xbgr.mr_n69572128)
print v(xbgr.mr_n69572560)
print v(xbgr.mr_n69572992)
print v(xbgr.mr_n69573424)
print v(xbgr.mr_n69573856)
print v(xbgr.mr_n69574288)
print v(xbgr.mr_n69574720)
print v(xbgr.mr_n69575152)
print v(xbgr.mr_n69575584)
print v(xbgr.mr_n69576016)
print v(xbgr.mr_n69576336)
print v(xbgr.mr_n69576448)
print v(xbgr.mr_n69576768)
print v(xbgr.mr_n69576880)
print v(xbgr.mr_n69577200)
print v(xbgr.mr_n69577312)
print v(xbgr.mr_n69577632)
print v(xbgr.mr_n69577744)
print v(xbgr.mr_n69578064)
print v(xbgr.mr_n69578176)
print v(xbgr.mr_n69578496)
print v(xbgr.mr_n69578608)
print v(xbgr.mr_n69578928)
print v(xbgr.mr_n69579040)
print v(xbgr.mr_n69579360)
print v(xbgr.mr_n69579472)
print v(xbgr.mr_n69579792)
print v(xbgr.mr_n69579904)
print v(xbgr.mr_n69580224)
print v(xbgr.mr_n69580336)
print v(xbgr.mr_n69580656)
print v(xbgr.mr_n69580768)
print v(xbgr.mr_n69581088)
print v(xbgr.mr_n69581200)
print v(xbgr.mr_n69581520)
print v(xbgr.mr_n69581632)
print v(xbgr.mr_n69582064)
print v(xbgr.mr_n69582496)
print v(xbgr.mr_n69582928)
print v(xbgr.mr_n69583360)
print v(xbgr.mr_n69583792)
print v(xbgr.mr_n69584224)
print v(xbgr.mr_n69584656)
print v(xbgr.mr_n69585088)
print v(xbgr.mr_n69585520)
print v(xbgr.mr_n69585952)
print v(xbgr.mr_n69586384)
print v(xbgr.mr_n69586816)
print v(xbgr.mr_n69587248)
print v(xbgr.mr_n69587568)
print v(xbgr.mr_n69587680)
print v(xbgr.mr_n69588000)
print v(xbgr.mr_n69588112)
print v(xbgr.mr_n69588432)
print v(xbgr.mr_n69588544)
print v(xbgr.mr_n69588864)
print v(xbgr.mr_n69588976)
print v(xbgr.mr_n69589296)
print v(xbgr.mr_n69589408)
print v(xbgr.mr_n69589728)
print v(xbgr.mr_n69589840)
print v(xbgr.mr_n69590160)
print v(xbgr.mr_n69590272)
print v(xbgr.mr_n69590592)
print v(xbgr.mr_n69590704)
print v(xbgr.mr_n69591024)
print v(xbgr.mr_n69591136)
print v(xbgr.mr_n69591456)
print v(xbgr.mr_n69591568)
print v(xbgr.mr_n69591888)
print v(xbgr.mr_n69592000)
print v(xbgr.mr_n69592320)
print v(xbgr.mr_n69592432)
print v(xbgr.mr_n69592752)
print v(xbgr.mr_n69592864)
print v(xbgr.mr_n69593296)
print v(xbgr.mr_n69593728)
print v(xbgr.mr_n69594160)
print v(xbgr.mr_n69594592)
print v(xbgr.mr_n69595024)
print v(xbgr.mr_n69595456)
print v(xbgr.mr_n69595888)
print v(xbgr.mr_n69596320)
print v(xbgr.mr_n69596752)
print v(xbgr.mr_n69597184)
print v(xbgr.mr_n69597616)
print v(xbgr.mr_n69598048)
print v(xbgr.mr_n69598480)
print v(xbgr.mr_n69598800)
print v(xbgr.mr_n69598912)
print v(xbgr.mr_n69599232)
print v(xbgr.mr_n69599344)
print v(xbgr.mr_n69599664)
print v(xbgr.mr_n69599776)
print v(xbgr.mr_n69600096)
print v(xbgr.mr_n69600208)
print v(xbgr.mr_n69600528)
print v(xbgr.mr_n69600640)
print v(xbgr.mr_n69601072)
print v(xbgr.mr_n69601504)
print v(xbgr.mr_n69601936)
print v(xbgr.mr_n69602368)
print v(xbgr.mr_n69602800)
print v(xbgr.mr_n69603120)
print v(xbgr.mr_n69603232)
print v(xbgr.mr_n69603552)
print v(xbgr.mr_n69603664)
print v(xbgr.mr_n69603984)
print v(xbgr.mr_n69604096)
print v(xbgr.mr_n69604416)
print v(xbgr.mr_n69604528)
print v(xbgr.mr_n69604848)
print v(xbgr.mr_n69604960)
print v(xbgr.mr_n69605280)
print v(xbgr.mr_n69605392)
print v(xbgr.mr_n69605712)
print v(xbgr.mr_n69605824)
print v(xbgr.mr_n69606144)
print v(xbgr.mr_n69606256)
print v(xbgr.mr_n69606688)
print v(xbgr.mr_n69607120)
print v(xbgr.mr_n69607552)
print v(xbgr.mr_n69607984)
print v(xbgr.mr_n69608416)
print v(xbgr.mr_n69608848)
print v(xbgr.mr_n69609280)
print v(xbgr.mr_n69609712)
print v(xbgr.mr_n69610032)
print v(xbgr.mr_n69610144)
print v(xbgr.mr_n69610464)
print v(xbgr.mr_n69610576)
print v(xbgr.mr_n69610896)
print v(xbgr.mr_n69611008)
print v(xbgr.mr_n69611328)
print v(xbgr.mr_n69611440)
print v(xbgr.mr_n69611760)
print v(xbgr.mr_n69611872)
print v(xbgr.mr_n69612192)
print v(xbgr.mr_n69612304)
print v(xbgr.mr_n69612624)
print v(xbgr.mr_n69612736)
print v(xbgr.mr_n69613056)
print v(xbgr.mr_n69613168)
print v(xbgr.mr_n69613600)
print v(xbgr.mr_n69614032)
print v(xbgr.mr_n69614464)
print v(xbgr.mr_n69614896)
print v(xbgr.mr_n69615328)
print v(xbgr.mr_n69615648)
print v(xbgr.mr_n69615760)
print v(xbgr.mr_n69616080)
print v(xbgr.mr_n69616192)
print v(xbgr.mr_n69616512)
print v(xbgr.mr_n69616624)
print v(xbgr.mr_n69616944)
print v(xbgr.mr_n69617056)
print v(xbgr.mr_n69617376)
print v(xbgr.mr_n69617488)
print v(xbgr.mr_n69617920)
print v(xbgr.mr_n69618352)
print v(xbgr.mr_n69618784)
print v(xbgr.mr_n69619216)
print v(xbgr.mr_n69619648)
print v(xbgr.mr_n69620080)
print v(xbgr.mr_n69620512)
print v(xbgr.mr_n69620944)
print v(xbgr.mr_n69621264)
print v(xbgr.mr_n69621376)
print v(xbgr.mr_n69621696)
print v(xbgr.mr_n69621808)
print v(xbgr.mr_n69622128)
print v(xbgr.mr_n69622240)
print v(xbgr.mr_n69622560)
print v(xbgr.mr_n69622672)
print v(xbgr.mr_n69622992)
print v(xbgr.mr_n69623104)
print v(xbgr.mr_n69623424)
print v(xbgr.mr_n69623536)
print v(xbgr.mr_n69623856)
print v(xbgr.mr_n69623968)
print v(xbgr.mr_n69624400)
print v(xbgr.mr_n69624832)
print v(xbgr.mr_n69625264)
print v(xbgr.mr_n69625696)
print v(xbgr.mr_n69626016)
print v(xbgr.mr_n69626128)
print v(xbgr.mr_n69626560)
print v(xbgr.mr_n69626992)
print v(xbgr.mr_n69627312)
print v(xbgr.mr_n69627424)
print v(xbgr.mr_n69627744)
print v(xbgr.mr_n69627856)
print v(xbgr.mr_n69628176)
print v(xbgr.mr_n69628288)
print v(xbgr.mr_n69628608)
print v(xbgr.mr_n69628720)
print v(xbgr.mr_n69629040)
print v(xbgr.mr_n69629152)
print v(xbgr.mr_n69629584)
print v(xbgr.mr_n69630016)
print v(xbgr.mr_n69630448)
print v(xbgr.mr_n69630880)
print v(xbgr.mr_n69631312)
print v(xbgr.mr_n69631744)
print v(xbgr.mr_n69632176)
print v(xbgr.mr_n69632496)
print v(xbgr.mr_n69632608)
print v(xbgr.mr_n69632928)
print v(xbgr.mr_n69633040)
print v(xbgr.mr_n69633360)
print v(xbgr.mr_n69633472)
print v(xbgr.mr_n69633792)
print v(xbgr.mr_n69633904)
print v(xbgr.mr_n69634224)
print v(xbgr.mr_n69634336)
print v(xbgr.mr_n69634656)
print v(xbgr.mr_n69634768)
print v(xbgr.mr_n69635088)
print v(xbgr.mr_n69635200)
print v(xbgr.mr_n69635520)
print v(xbgr.mr_n69635632)
print v(xbgr.mr_n69635952)
print v(xbgr.mr_n69636064)
print v(xbgr.mr_n69636384)
print v(xbgr.mr_n69636496)
print v(xbgr.mr_n69636816)
print v(xbgr.mr_n69636928)
print v(xbgr.mr_n69637248)
print v(xbgr.mr_n69637360)
print v(xbgr.mr_n69637680)
print v(xbgr.mr_n69637792)
print v(xbgr.mr_n69638224)
print v(xbgr.mr_n69638656)
print v(xbgr.mr_n69639088)
print v(xbgr.mr_n69639520)
print v(xbgr.mr_n69639952)
print v(xbgr.mr_n69640384)
print v(xbgr.mr_n69640816)
print v(xbgr.mr_n69641248)
print v(xbgr.mr_n69641680)
print v(xbgr.mr_n69642112)
print v(xbgr.mr_n69642544)
print v(xbgr.mr_n69642976)
print v(xbgr.mr_n69643408)
print v(xbgr.mr_n69643728)
print v(xbgr.mr_n69643840)
print v(xbgr.mr_n69644160)
print v(xbgr.mr_n69644272)
print v(xbgr.mr_n69644592)
print v(xbgr.mr_n69644704)
print v(xbgr.mr_n69645024)
print v(xbgr.mr_n69645136)
print v(xbgr.mr_n69645456)
print v(xbgr.mr_n69645568)
print v(xbgr.mr_n69645888)
print v(xbgr.mr_n69646000)
print v(xbgr.mr_n69646320)
print v(xbgr.mr_n69646432)
print v(xbgr.mr_n69646752)
print v(xbgr.mr_n69646864)
print v(xbgr.mr_n69647184)
print v(xbgr.mr_n69647296)
print v(xbgr.mr_n69647616)
print v(xbgr.mr_n69647728)
print v(xbgr.mr_n69648048)
print v(xbgr.mr_n69648160)
print v(xbgr.mr_n69648480)
print v(xbgr.mr_n69648592)
print v(xbgr.mr_n69648912)
print v(xbgr.mr_n69649024)
print v(xbgr.mr_n69649344)
print v(xbgr.mr_n69649456)
print v(xbgr.mr_n69649776)
print v(xbgr.mr_n69649888)
print v(xbgr.mr_n69650208)
print v(xbgr.mr_n69650320)
print v(xbgr.mr_n69650752)
print v(xbgr.mr_n69651184)
print v(xbgr.mr_n69651616)
print v(xbgr.mr_n69652048)
print v(xbgr.mr_n69652480)
print v(xbgr.mr_n69652912)
print v(xbgr.mr_n69653232)
print v(xbgr.mr_n69653344)
print v(xbgr.mr_n69653664)
print v(xbgr.mr_n69653776)
print v(xbgr.mr_n69654096)
print v(xbgr.mr_n69654208)
print v(xbgr.mr_n69654528)
print v(xbgr.mr_n69654640)
print v(xbgr.mr_n69654960)
print v(xbgr.mr_n69655072)
print v(xbgr.mr_n69655392)
print v(xbgr.mr_n69655504)
print v(xbgr.mr_n69655824)
print v(xbgr.mr_n69655936)
print v(xbgr.mr_n69656256)
print v(xbgr.mr_n69656368)
print v(xbgr.mr_n69656688)
print v(xbgr.mr_n69656800)
print v(xbgr.mr_n69657120)
print v(xbgr.mr_n69657232)
print v(xbgr.mr_n69657664)
print v(xbgr.mr_n69658096)
print v(xbgr.mr_n69658528)
print v(xbgr.mr_n69658960)
print v(xbgr.mr_n69659392)
print v(xbgr.mr_n69659824)
print v(xbgr.mr_n69660256)
print v(xbgr.mr_n69660688)
print v(xbgr.mr_n69661120)
print v(xbgr.mr_n69661552)
print v(xbgr.mr_n69661984)
print v(xbgr.mr_n69662416)
print v(xbgr.mr_n69662848)
print v(xbgr.mr_n69663280)
print v(xbgr.mr_n69663712)
print v(xbgr.mr_n69664144)
print v(xbgr.mr_n69664576)
print v(xbgr.mr_n69665008)
print v(xbgr.mr_n69665440)
print v(xbgr.mr_n69665872)
print v(xbgr.mr_n69666192)
print v(xbgr.mr_n69666304)
print v(xbgr.mr_n69666624)
print v(xbgr.mr_n69666736)
print v(xbgr.mr_n69667056)
print v(xbgr.mr_n69667168)
print v(xbgr.mr_n69667488)
print v(xbgr.mr_n69667600)
print v(xbgr.mr_n69667920)
print v(xbgr.mr_n69668032)
print v(xbgr.mr_n69668352)
print v(xbgr.mr_n69668464)
print v(xbgr.mr_n69668784)
print v(xbgr.mr_n69668896)
print v(xbgr.mr_n69669216)
print v(xbgr.mr_n69669328)
print v(xbgr.mr_n69669648)
print v(xbgr.mr_n69669760)
print v(xbgr.mr_n69670080)
print v(xbgr.mr_n69670192)
print v(xbgr.mr_n69670512)
print v(xbgr.mr_n69670624)
print v(xbgr.mr_n69670944)
print v(xbgr.mr_n69671056)
print v(xbgr.mr_n69671376)
print v(xbgr.mr_n69671488)
print v(xbgr.mr_n69671808)
print v(xbgr.mr_n69671920)
print v(xbgr.mr_n69672352)
print v(xbgr.mr_n69672784)
print v(xbgr.mr_n69673216)
print v(xbgr.mr_n69673648)
print v(xbgr.mr_n69673968)
print v(xbgr.mr_n69674080)
print v(xbgr.mr_n69674400)
print v(xbgr.mr_n69674512)
print v(xbgr.mr_n69674832)
print v(xbgr.mr_n69674944)
print v(xbgr.mr_n69675264)
print v(xbgr.mr_n69675376)
print v(xbgr.mr_n69675696)
print v(xbgr.mr_n69675808)
print v(xbgr.mr_n69676128)
print v(xbgr.mr_n69676240)
print v(xbgr.mr_n69676672)
print v(xbgr.mr_n69677104)
print v(xbgr.mr_n69677536)
print v(xbgr.mr_n69677968)
print v(xbgr.mr_n69678400)
print v(xbgr.mr_n69678832)
print v(xbgr.mr_n69679264)
print v(xbgr.mr_n69679696)
print v(xbgr.mr_n69680128)
print v(xbgr.mr_n69680560)
print v(xbgr.mr_n69680880)
print v(xbgr.mr_n69680992)
print v(xbgr.mr_n69681312)
print v(xbgr.mr_n69681424)
print v(xbgr.mr_n69681856)
print v(xbgr.mr_n69682288)
print v(xbgr.mr_n69682608)
print v(xbgr.mr_n69682720)
print v(xbgr.mr_n69683040)
print v(xbgr.mr_n69683152)
print v(xbgr.mr_n69683472)
print v(xbgr.mr_n69683584)
print v(xbgr.mr_n69683904)
print v(xbgr.mr_n69684016)
print v(xbgr.mr_n69684448)
print v(xbgr.mr_n69684880)
print v(xbgr.mr_n69685312)
print v(xbgr.mr_n69685744)
print v(xbgr.mr_n69686176)
print v(xbgr.mr_n69686608)
print v(xbgr.mr_n69687040)
print v(xbgr.mr_n69687472)
print v(xbgr.mr_n69687904)
print v(xbgr.mr_n69688336)
print v(xbgr.mr_n69688656)
print v(xbgr.mr_n69688768)
print v(xbgr.mr_n69689088)
print v(xbgr.mr_n69689200)
print v(xbgr.mr_n69689520)
print v(xbgr.mr_n69689632)
print v(xbgr.mr_n69689952)
print v(xbgr.mr_n69690064)
print v(xbgr.mr_n69690384)
print v(xbgr.mr_n69690496)
print v(xbgr.mr_n69690816)
print v(xbgr.mr_n69690928)
print v(xbgr.mr_n69691248)
print v(xbgr.mr_n69691360)
print v(xbgr.mr_n69691680)
print v(xbgr.mr_n69691792)
print v(xbgr.mr_n69692112)
print v(xbgr.mr_n69692224)
print v(xbgr.mr_n69692544)
print v(xbgr.mr_n69692656)
print v(xbgr.mr_n69692976)
print v(xbgr.mr_n69693088)
print v(xbgr.mr_n69693408)
print v(xbgr.mr_n69693520)
print v(xbgr.mr_n69693840)
print v(xbgr.mr_n69693952)
print v(xbgr.mr_n69694272)
print v(xbgr.mr_n69694384)
print v(xbgr.mr_n69694704)
print v(xbgr.mr_n69694816)
print v(xbgr.mr_n69695136)
print v(xbgr.mr_n69695248)
print v(xbgr.mr_n69695568)
print v(xbgr.mr_n69695680)
print v(xbgr.mr_n69696000)
print v(xbgr.mr_n69696112)
print v(xbgr.mr_n69696432)
print v(xbgr.mr_n69696544)
print v(xbgr.mr_n69696864)
print v(xbgr.mr_n69696976)
print v(xbgr.mr_n69697296)
print v(xbgr.mr_n69697408)
print v(xbgr.mr_n69697728)
print v(xbgr.mr_n69698160)
print v(xbgr.mr_n69698272)
print v(xbgr.mr_n69698592)
print v(xbgr.mr_n69699024)
print v(xbgr.mr_n69699136)
print v(xbgr.mr_n69699456)
print v(xbgr.mr_n69699888)
print v(xbgr.mr_n69700000)
print v(xbgr.mr_n69700320)
print v(xbgr.mr_n69700752)
print v(xbgr.mr_n69700864)
print v(xbgr.mr_n69701184)
print v(xbgr.mr_n69701616)
print v(xbgr.mr_n69701728)
print v(xbgr.mr_n69702048)
print v(xbgr.mr_n69702160)
print v(xbgr.mr_n69702480)
print v(xbgr.mr_n69702592)
print v(xbgr.mr_n69702912)
print v(xbgr.mr_n69703024)
print v(xbgr.mr_n69703344)
print v(xbgr.mr_n69703456)
print v(xbgr.mr_n69703776)
print v(xbgr.mr_n69703888)
print v(xbgr.mr_n69704208)
print v(xbgr.mr_n69704320)
print v(xbgr.mr_n69704640)
print v(xbgr.mr_n69704752)
print v(xbgr.mr_n69705072)
print v(xbgr.mr_n69705184)
print v(xbgr.mr_n69705504)
print v(xbgr.mr_n69705616)
print v(xbgr.mr_n69705936)
print v(xbgr.mr_n69706048)
print v(xbgr.mr_n69706368)
print v(xbgr.mr_n69706480)
print v(xbgr.mr_n69706800)
print v(xbgr.mr_n69706912)
print v(xbgr.mr_n69707232)
print v(xbgr.mr_n69707344)
print v(xbgr.mr_n69707664)
print v(xbgr.mr_n69707776)
print v(xbgr.mr_n69708096)
print v(xbgr.mr_n69708208)
print v(xbgr.mr_n69708528)
print v(xbgr.mr_n69708640)
print v(xbgr.mr_n69708960)
print v(xbgr.mr_n69709072)
print v(xbgr.mr_n69709392)
print v(xbgr.mr_n69709504)
print v(xbgr.mr_n69709824)
print v(xbgr.mr_n69709936)
print v(xbgr.mr_n69710256)
print v(xbgr.mr_n69710368)
print v(xbgr.mr_n69710688)
print v(xbgr.mr_n69710800)
print v(xbgr.mr_n69711120)
print v(xbgr.mr_n69711232)
print v(xbgr.mr_n69711552)
print v(xbgr.mr_n69711664)
print v(xbgr.mr_n69711984)
print v(xbgr.mr_n69712096)
print v(xbgr.mr_n69712416)
print v(xbgr.mr_n69712528)
print v(xbgr.mr_n69712848)
print v(xbgr.mr_n69712960)
print v(xbgr.mr_n69713280)
print v(xbgr.mr_n69713392)
print v(xbgr.mr_n69713712)
print v(xbgr.mr_n69713824)
print v(xbgr.mr_n69714144)
print v(xbgr.mr_n69714256)
print v(xbgr.mr_n69714576)
print v(xbgr.mr_n69714688)
print v(xbgr.mr_n69715008)
print v(xbgr.mr_n69715120)
print v(xbgr.mr_n69715440)
print v(xbgr.mr_n69715552)
print v(xbgr.mr_n69715872)
print v(xbgr.mr_n69715984)
print v(xbgr.mr_n69716304)
print v(xbgr.mr_n69716416)
print v(xbgr.mr_n69716736)
print v(xbgr.mr_n69716848)
print v(xbgr.mr_n69717168)
print v(xbgr.mr_n69717280)
print v(xbgr.mr_n69717600)
print v(xbgr.mr_n69717712)
print v(xbgr.mr_n69718032)
print v(xbgr.mr_n69718144)
print v(xbgr.mr_n69718464)
print v(xbgr.mr_n69718576)
print v(xbgr.mr_n69718896)
print v(xbgr.mr_n69719008)
print v(xbgr.mr_n69719328)
print v(xbgr.mr_n69719440)
print v(xbgr.mr_n69719760)
print v(xbgr.mr_n69719872)
print v(xbgr.mr_n69720192)
print v(xbgr.mr_n69720304)
print v(xbgr.mr_n69720624)
print v(xbgr.mr_n69720736)
print v(xbgr.mr_n69721056)
print v(xbgr.mr_n69721168)
print v(xbgr.mr_n69721488)
print v(xbgr.mr_n69721600)
print v(xbgr.mr_n69721920)
print v(xbgr.mr_n69722032)
print v(xbgr.mr_n69722352)
print v(xbgr.mr_n69722464)
print v(xbgr.mr_n69722784)
print v(xbgr.mr_n69722896)
print v(xbgr.mr_n69723216)
print v(xbgr.mr_n69723328)
print v(xbgr.mr_n69723648)
print v(xbgr.mr_n69723760)
print v(xbgr.mr_n69724080)
print v(xbgr.mr_n69724192)
print v(xbgr.mr_n69724512)
print v(xbgr.mr_n69724624)
print v(xbgr.mr_n69724944)
print v(xbgr.mr_n69725056)
print v(xbgr.mr_n69725376)
print v(xbgr.mr_n69725488)
print v(xbgr.mr_n69725808)
print v(xbgr.mr_n69725920)
print v(xbgr.mr_n69726240)
print v(xbgr.mr_n69726352)
print v(xbgr.mr_n69726672)
print v(xbgr.mr_n69726784)
print v(xbgr.mr_n69727104)
print v(xbgr.mr_n69727216)
print v(xbgr.mr_n69727536)
print v(xbgr.mr_n69727648)
print v(xbgr.mr_n69727968)
print v(xbgr.mr_n69728080)
print v(xbgr.mr_n69728400)
print v(xbgr.mr_n69728512)
print v(xbgr.mr_n69728832)
print v(xbgr.mr_n69728944)
print v(xbgr.mr_n69729264)
print v(xbgr.mr_n69729376)
print v(xbgr.mr_n69729696)
print v(xbgr.mr_n69729808)
print v(xbgr.mr_n69730128)
print v(xbgr.mr_n69730240)
print v(xbgr.mr_n69730560)
print v(xbgr.mr_n69730672)
print v(xbgr.mr_n69730992)
print v(xbgr.mr_n69731104)
print v(xbgr.mr_n69731424)
print v(xbgr.mr_n69731536)
print v(xbgr.mr_n69731856)
print v(xbgr.mr_n69731968)
print v(xbgr.mr_n69732288)
print v(xbgr.mr_n69732400)
print v(xbgr.mr_n69732720)
print v(xbgr.mr_n69733152)
print v(xbgr.mr_n69733264)
print v(xbgr.mr_n69733584)
print v(xbgr.mr_n69734016)
print v(xbgr.mr_n69734128)
print v(xbgr.mr_n69734448)
print v(xbgr.mr_n69734880)
print v(xbgr.mr_n69734992)
print v(xbgr.mr_n69735312)
print v(xbgr.mr_n69735744)
print v(xbgr.mr_n69735856)
print v(xbgr.mr_n69736176)
print v(xbgr.mr_n69736288)
print v(xbgr.mr_n69736608)
print v(xbgr.mr_n69736720)
print v(xbgr.mr_n69737040)
print v(xbgr.mr_n69737152)
print v(xbgr.mr_n69737472)
print v(xbgr.mr_n69737904)
print v(xbgr.mr_n69738016)
print v(xbgr.mr_n69738336)
print v(xbgr.mr_n69738768)
print v(xbgr.mr_n69738880)
print v(xbgr.mr_n69739200)
print v(xbgr.mr_n69739632)
print v(xbgr.mr_n69739744)
print v(xbgr.mr_n69740064)
print v(xbgr.mr_n69740496)
print v(xbgr.mr_n69740608)
print v(xbgr.mr_n69740928)
print v(xbgr.mr_n69741040)
print v(xbgr.mr_n69741360)
print v(xbgr.mr_n69741472)
print v(xbgr.mr_n69741792)
print v(xbgr.mr_n69741904)
print v(xbgr.mr_n69742224)
print v(xbgr.mr_n69742336)
print v(xbgr.mr_n69742656)
print v(xbgr.mr_n69742768)
print v(xbgr.mr_n69743088)
print v(xbgr.mr_n69743200)
print v(xbgr.mr_n69743520)
print v(xbgr.mr_n69743632)
print v(xbgr.mr_n69743952)
print v(xbgr.mr_n69744064)
print v(xbgr.mr_n69744384)
print v(xbgr.mr_n69744496)
print v(xbgr.mr_n69744816)
print v(xbgr.mr_n69744928)
print v(xbgr.mr_n69745248)
print v(xbgr.mr_n69745360)
print v(xbgr.mr_n69745680)
print v(xbgr.mr_n69745792)
print v(xbgr.mr_n69746112)
print v(xbgr.mr_n69746224)
print v(xbgr.mr_n69746544)
print v(xbgr.mr_n69746656)
print v(xbgr.mr_n69746976)
print v(xbgr.mr_n69747088)
print v(xbgr.mr_n69747408)
print v(xbgr.mr_n69747520)
print v(xbgr.mr_n69747840)
print v(xbgr.mr_n69747952)
print v(xbgr.mr_n69748272)
print v(xbgr.mr_n69748384)
print v(xbgr.mr_n69748704)
print v(xbgr.mr_n69748816)
print v(xbgr.mr_n69749136)
print v(xbgr.mr_n69749248)
print v(xbgr.mr_n69749568)
print v(xbgr.mr_n69749680)
print v(xbgr.mr_n69750000)
print v(xbgr.mr_n69750112)
print v(xbgr.mr_n69750432)
print v(xbgr.mr_n69750544)
print v(xbgr.mr_n69750864)
print v(xbgr.mr_n69750976)
print v(xbgr.mr_n69751296)
print v(xbgr.mr_n69751408)
print v(xbgr.mr_n69751728)
print v(xbgr.mr_n69751840)
print v(xbgr.mr_n69752160)
print v(xbgr.mr_n69752272)
print v(xbgr.mr_n69752704)
print v(xbgr.mr_n69753136)
print v(xbgr.mr_n69753568)
print v(xbgr.mr_n69754000)
print v(xbgr.mr_n69754432)
print v(xbgr.mr_n69754864)
print v(xbgr.mr_n69755296)
print v(xbgr.mr_n69755728)
print v(xbgr.mr_n69756160)
print v(xbgr.mr_n69756592)
print v(xbgr.mr_n69757024)
print v(xbgr.mr_n69757456)
print v(xbgr.mr_n69757888)
print v(xbgr.mr_n69758320)
print v(xbgr.mr_n69758752)
print v(xbgr.mr_n69759184)
print v(xbgr.mr_n69759616)
print v(xbgr.mr_n69760048)
print v(xbgr.mr_n69760480)
print v(xbgr.mr_n69760912)
print v(xbgr.mr_n69761344)
print v(xbgr.mr_n69761776)
print v(xbgr.mr_n69762208)
print v(xbgr.mr_n69762640)
print v(xbgr.mr_n69763072)
print v(xbgr.mr_n69763504)
print v(xbgr.mr_n69763824)
print v(xbgr.mr_n69763936)
print v(xbgr.mr_n69764256)
print v(xbgr.mr_n69764368)
print v(xbgr.mr_n69764688)
print v(xbgr.mr_n69764800)
print v(xbgr.mr_n69765120)
print v(xbgr.mr_n69765232)
print v(xbgr.mr_n69765552)
print v(xbgr.mr_n69765664)
print v(xbgr.mr_n69765984)
print v(xbgr.mr_n69766096)
print v(xbgr.mr_n69766416)
print v(xbgr.mr_n69766528)
print v(xbgr.mr_n69766848)
print v(xbgr.mr_n69766960)
print v(xbgr.mr_n69767280)
print v(xbgr.mr_n69767392)
print v(xbgr.mr_n69767712)
print v(xbgr.mr_n69767824)
print v(xbgr.mr_n69768144)
print v(xbgr.mr_n69768256)
print v(xbgr.mr_n69768576)
print v(xbgr.mr_n69768688)
print v(xbgr.mr_n69769008)
print v(xbgr.mr_n69769120)
print v(xbgr.mr_n69769440)
print v(xbgr.mr_n69769552)
print v(xbgr.mr_n69769872)
print v(xbgr.mr_n69769984)
print v(xbgr.mr_n69770304)
print v(xbgr.mr_n69770416)
print v(xbgr.mr_n69770736)
print v(xbgr.mr_n69770848)
print v(xbgr.mr_n69771168)
print v(xbgr.mr_n69771280)
print v(xbgr.mr_n69771600)
print v(xbgr.mr_n69771712)
print v(xbgr.mr_n69772032)
print v(xbgr.mr_n69772144)
print v(xbgr.mr_n69772576)
print v(xbgr.mr_n69773008)
print v(xbgr.mr_n69773440)
print v(xbgr.mr_n69773872)
print v(xbgr.mr_n69774304)
print v(xbgr.mr_n69774736)
print v(xbgr.mr_n69775168)
print v(xbgr.mr_n69775600)
print v(xbgr.mr_n69776032)
print v(xbgr.mr_n69776464)
print v(xbgr.mr_n69776896)
print v(xbgr.mr_n69777328)
print v(xbgr.mr_n69777648)
print v(xbgr.mr_n69777760)
print v(xbgr.mr_n69778080)
print v(xbgr.mr_n69778192)
print v(xbgr.mr_n69778624)
print v(xbgr.mr_n69779056)
print v(xbgr.mr_n69779488)
print v(xbgr.mr_n69779920)
print v(xbgr.mr_n69780352)
print v(xbgr.mr_n69780784)
print v(xbgr.mr_n69781216)
print v(xbgr.mr_n69781648)
print v(xbgr.mr_n69782080)
print v(xbgr.mr_n69782512)
print v(xbgr.mr_n69782832)
print v(xbgr.mr_n69782944)
print v(xbgr.mr_n69783264)
print v(xbgr.mr_n69783376)
print v(xbgr.mr_n69783696)
print v(xbgr.mr_n69783808)
print v(xbgr.mr_n69784128)
print v(xbgr.mr_n69784240)
print v(xbgr.mr_n69784560)
print v(xbgr.mr_n69784672)
print v(xbgr.mr_n69784992)
print v(xbgr.mr_n69785104)
print v(xbgr.mr_n69785424)
print v(xbgr.mr_n69785536)
print v(xbgr.mr_n69785856)
print v(xbgr.mr_n69785968)
print v(xbgr.mr_n69786288)
print v(xbgr.mr_n69786400)
print v(xbgr.mr_n69786720)
print v(xbgr.mr_n69786832)
print v(xbgr.mr_n69787152)
print v(xbgr.mr_n69787264)
print v(xbgr.mr_n69787584)
print v(xbgr.mr_n69787696)
print v(xbgr.mr_n69788016)
print v(xbgr.mr_n69788128)
print v(xbgr.mr_n69788448)
print v(xbgr.mr_n69788560)
print v(xbgr.mr_n69788880)
print v(xbgr.mr_n69788992)
print v(xbgr.mr_n69789312)
print v(xbgr.mr_n69789424)
print v(xbgr.mr_n69789744)
print v(xbgr.mr_n69789856)
print v(xbgr.mr_n69790176)
print v(xbgr.mr_n69790288)
print v(xbgr.mr_n69790608)
print v(xbgr.mr_n69790720)
print v(xbgr.mr_n69791040)
print v(xbgr.mr_n69791152)
print v(xbgr.mr_n69791472)
print v(xbgr.mr_n69791584)
print v(xbgr.mr_n69791904)
print v(xbgr.mr_n69792016)
print v(xbgr.mr_n69792336)
print v(xbgr.mr_n69792448)
print v(xbgr.mr_n69792768)
print v(xbgr.mr_n69792880)
print v(xbgr.mr_n69793200)
print v(xbgr.mr_n69793312)
print v(xbgr.mr_n69793632)
print v(xbgr.mr_n69793744)
print v(xbgr.mr_n69794064)
print v(xbgr.mr_n69794496)
print v(xbgr.mr_n69794608)
print v(xbgr.mr_n69794928)
print v(xbgr.mr_n69795360)
print v(xbgr.mr_n69795472)
print v(xbgr.mr_n69795792)
print v(xbgr.mr_n69796224)
print v(xbgr.mr_n69796336)
print v(xbgr.mr_n69796656)
print v(xbgr.mr_n69797088)
print v(xbgr.mr_n69797200)
print v(xbgr.mr_n69797520)
print v(xbgr.mr_n69797952)
print v(xbgr.mr_n69798064)
print v(xbgr.mr_n69798384)
print v(xbgr.mr_n69798496)
print v(xbgr.mr_n69798816)
print v(xbgr.mr_n69798928)
print v(xbgr.mr_n69799248)
print v(xbgr.mr_n69799360)
print v(xbgr.mr_n69799680)
print v(xbgr.mr_n69799792)
print v(xbgr.mr_n69800112)
print v(xbgr.mr_n69800224)
print v(xbgr.mr_n69800544)
print v(xbgr.mr_n69800656)
print v(xbgr.mr_n69800976)
print v(xbgr.mr_n69801088)
print v(xbgr.mr_n69801408)
print v(xbgr.mr_n69801520)
print v(xbgr.mr_n69801840)
print v(xbgr.mr_n69801952)
print v(xbgr.mr_n69802272)
print v(xbgr.mr_n69802384)
print v(xbgr.mr_n69802704)
print v(xbgr.mr_n69802816)
print v(xbgr.mr_n69803136)
print v(xbgr.mr_n69803248)
print v(xbgr.mr_n69803568)
print v(xbgr.mr_n69803680)
print v(xbgr.mr_n69804000)
print v(xbgr.mr_n69804112)
print v(xbgr.mr_n69804432)
print v(xbgr.mr_n69804544)
print v(xbgr.mr_n69804864)
print v(xbgr.mr_n69804976)
print v(xbgr.mr_n69805296)
print v(xbgr.mr_n69805408)
print v(xbgr.mr_n69805728)
print v(xbgr.mr_n69805840)
print v(xbgr.mr_n69806160)
print v(xbgr.mr_n69806272)
print v(xbgr.mr_n69806592)
print v(xbgr.mr_n69806704)
print v(xbgr.mr_n69807024)
print v(xbgr.mr_n69807136)
print v(xbgr.mr_n69807456)
print v(xbgr.mr_n69807568)
print v(xbgr.mr_n69807888)
print v(xbgr.mr_n69808000)
print v(xbgr.mr_n69808320)
print v(xbgr.mr_n69808432)
print v(xbgr.mr_n69808752)
print v(xbgr.mr_n69808864)
print v(xbgr.mr_n69809184)
print v(xbgr.mr_n69809296)
print v(xbgr.mr_n69809616)
print v(xbgr.mr_n69809728)
print v(xbgr.mr_n69810048)
print v(xbgr.mr_n69810160)
print v(xbgr.mr_n69810480)
print v(xbgr.mr_n69810592)
print v(xbgr.mr_n69810912)
print v(xbgr.mr_n69811024)
print v(xbgr.mr_n69811344)
print v(xbgr.mr_n69811456)
print v(xbgr.mr_n69811776)
print v(xbgr.mr_n69811888)
print v(xbgr.mr_n69812208)
print v(xbgr.mr_n69812320)
print v(xbgr.mr_n69812640)
print v(xbgr.mr_n69812752)
print v(xbgr.mr_n69813072)
print v(xbgr.mr_n69813184)
print v(xbgr.mr_n69813504)
print v(xbgr.mr_n69813616)
print v(xbgr.mr_n69813936)
print v(xbgr.mr_n69814048)
print v(xbgr.mr_n69814368)
print v(xbgr.mr_n69814480)
print v(xbgr.mr_n69814800)
print v(xbgr.mr_n69814912)
print v(xbgr.mr_n69815232)
print v(xbgr.mr_n69815344)
print v(xbgr.mr_n69815664)
print v(xbgr.mr_n69815776)
print v(xbgr.mr_n69816096)
print v(xbgr.mr_n69816208)
print v(xbgr.mr_n69816528)
print v(xbgr.mr_n69816960)
print v(xbgr.mr_n69817072)
print v(xbgr.mr_n69817392)
print v(xbgr.mr_n69817504)
print v(xbgr.mr_n69817824)
print v(xbgr.mr_n69817936)
print v(xbgr.mr_n69818256)
print v(xbgr.mr_n69818688)
print v(xbgr.mr_n69818800)
print v(xbgr.mr_n69819120)
print v(xbgr.mr_n69819552)
print v(xbgr.mr_n69819664)
print v(xbgr.mr_n69819984)
print v(xbgr.mr_n69820096)
print v(xbgr.mr_n69820416)
print v(xbgr.mr_n69820528)
print v(xbgr.mr_n69820848)
print v(xbgr.mr_n69820960)
print v(xbgr.mr_n69821280)
print v(xbgr.mr_n69821392)
print v(xbgr.mr_n69821712)
print v(xbgr.mr_n69821824)
print v(xbgr.mr_n69822144)
print v(xbgr.mr_n69822256)
print v(xbgr.mr_n69822576)
print v(xbgr.mr_n69822688)
print v(xbgr.mr_n69823008)
print v(xbgr.mr_n69823120)
print v(xbgr.mr_n69823440)
print v(xbgr.mr_n69823552)
print v(xbgr.mr_n69823872)
print v(xbgr.mr_n69823984)
print v(xbgr.mr_n69824304)
print v(xbgr.mr_n69824416)
print v(xbgr.mr_n69824736)
print v(xbgr.mr_n69824848)
print v(xbgr.mr_n69825168)
print v(xbgr.mr_n69825600)
print v(xbgr.mr_n69825712)
print v(xbgr.mr_n69826032)
print v(xbgr.mr_n69826144)
print v(xbgr.mr_n69826464)
print v(xbgr.mr_n69826576)
print v(xbgr.mr_n69826896)
print v(xbgr.mr_n69827008)
print v(xbgr.mr_n69827328)
print v(xbgr.mr_n69827440)
print v(xbgr.mr_n69827760)
print v(xbgr.mr_n69827872)
print v(xbgr.mr_n69828192)
print v(xbgr.mr_n69828304)
print v(xbgr.mr_n69828624)
print v(xbgr.mr_n69828736)
print v(xbgr.mr_n69829056)
print v(xbgr.mr_n69829168)
print v(xbgr.mr_n69829488)
print v(xbgr.mr_n69829600)
print v(xbgr.mr_n69829920)
print v(xbgr.mr_n69830032)
print v(xbgr.mr_n69830352)
print v(xbgr.mr_n69830464)
print v(xbgr.mr_n69830784)
print v(xbgr.mr_n69830896)
print v(xbgr.mr_n69831216)
print v(xbgr.mr_n69831328)
print v(xbgr.mr_n69831648)
print v(xbgr.mr_n69831760)
print v(xbgr.mr_n69832080)
print v(xbgr.mr_n69832192)
print v(xbgr.mr_n69832512)
print v(xbgr.mr_n69832624)
print v(xbgr.mr_n69832944)
print v(xbgr.mr_n69833056)
print v(xbgr.mr_n69833376)
print v(xbgr.mr_n69833488)
print v(xbgr.mr_n69833808)
print v(xbgr.mr_n69833920)
print v(xbgr.mr_n69834240)
print v(xbgr.mr_n69834352)
print v(xbgr.mr_n69834672)
print v(xbgr.mr_n69834784)
print v(xbgr.mr_n69835104)
print v(xbgr.mr_n69835216)
print v(xbgr.mr_n69835536)
print v(xbgr.mr_n69835648)
print v(xbgr.mr_n69835968)
print v(xbgr.mr_n69836080)
print v(xbgr.mr_n69836400)
print v(xbgr.mr_n69836512)
print v(xbgr.mr_n69836832)
print v(xbgr.mr_n69836944)
print v(xbgr.mr_n69837264)
print v(xbgr.mr_n69837376)
print v(xbgr.mr_n69837696)
print v(xbgr.mr_n69837808)
print v(xbgr.mr_n69838128)
print v(xbgr.mr_n69838240)
print v(xbgr.mr_n69838560)
print v(xbgr.mr_n69838672)
print v(xbgr.mr_n69838992)
print v(xbgr.mr_n69839104)
print v(xbgr.mr_n69839424)
print v(xbgr.mr_n69839536)
print v(xbgr.mr_n69839856)
print v(xbgr.mr_n69839968)
print v(xbgr.mr_n69840288)
print v(xbgr.mr_n69840400)
print v(xbgr.mr_n69840720)
print v(xbgr.mr_n69840832)
print v(xbgr.mr_n69841152)
print v(xbgr.mr_n69841264)
print v(xbgr.mr_n69841584)
print v(xbgr.mr_n69841696)
print v(xbgr.mr_n69842016)
print v(xbgr.mr_n69842128)
print v(xbgr.mr_n69842448)
print v(xbgr.mr_n69842560)
print v(xbgr.mr_n69842880)
print v(xbgr.mr_n69842992)
print v(xbgr.mr_n69843312)
print v(xbgr.mr_n69843424)
print v(xbgr.mr_n69843744)
print v(xbgr.mr_n69843856)
print v(xbgr.mr_n69844176)
print v(xbgr.mr_n69844288)
print v(xbgr.mr_n69844608)
print v(xbgr.mr_n69844720)
print v(xbgr.mr_n69845040)
print v(xbgr.mr_n69845152)
print v(xbgr.mr_n69845472)
print v(xbgr.mr_n69845584)
print v(xbgr.mr_n69845904)
print v(xbgr.mr_n69846016)
print v(xbgr.mr_n69846336)
print v(xbgr.mr_n69846448)
print v(xbgr.mr_n69846768)
print v(xbgr.mr_n69846880)
print v(xbgr.mr_n69847312)
print v(xbgr.mr_n69847744)
print v(xbgr.mr_n69848176)
print v(xbgr.mr_n69848608)
print v(xbgr.mr_n69849040)
print v(xbgr.mr_n69849472)
print v(xbgr.mr_n69849904)
print v(xbgr.mr_n69850336)
print v(xbgr.mr_n69850656)
print v(xbgr.mr_n69850768)
print v(xbgr.mr_n69851088)
print v(xbgr.mr_n69851200)
print v(xbgr.mr_n69851520)
print v(xbgr.mr_n69851632)
print v(xbgr.mr_n69851952)
print v(xbgr.mr_n69852064)
print v(xbgr.mr_n69852384)
print v(xbgr.mr_n69852496)
print v(xbgr.mr_n69852816)
print v(xbgr.mr_n69852928)
print v(xbgr.mr_n69853248)
print v(xbgr.mr_n69853360)
print v(xbgr.mr_n69853680)
print v(xbgr.mr_n69853792)
print v(xbgr.mr_n69854224)
print v(xbgr.mr_n69854656)
print v(xbgr.mr_n69855088)
print v(xbgr.mr_n69855520)
print v(xbgr.mr_n69855952)
print v(xbgr.mr_n69856384)
print v(xbgr.mr_n69856704)
print v(xbgr.mr_n69856816)
print v(xbgr.mr_n69857248)
print v(xbgr.mr_n69857680)
print v(xbgr.mr_n69858112)
print v(xbgr.mr_n69858544)
print v(xbgr.mr_n69858976)
print v(xbgr.mr_n69859408)
print v(xbgr.mr_n69859840)
print v(xbgr.mr_n69860272)
print v(xbgr.mr_n69860704)
print v(xbgr.mr_n69861136)
print v(xbgr.mr_n69861568)
print v(xbgr.mr_n69862000)
print v(xbgr.mr_n69862320)
print v(xbgr.mr_n69862432)
print v(xbgr.mr_n69862752)
print v(xbgr.mr_n69862864)
print v(xbgr.mr_n69863184)
print v(xbgr.mr_n69863296)
print v(xbgr.mr_n69863616)
print v(xbgr.mr_n69863728)
print v(xbgr.mr_n69864048)
print v(xbgr.mr_n69864160)
print v(xbgr.mr_n69864480)
print v(xbgr.mr_n69864592)
print v(xbgr.mr_n69864912)
print v(xbgr.mr_n69865024)
print v(xbgr.mr_n69865344)
print v(xbgr.mr_n69865456)
print v(xbgr.mr_n69865776)
print v(xbgr.mr_n69865888)
print v(xbgr.mr_n69866208)
print v(xbgr.mr_n69866320)
print v(xbgr.mr_n69866640)
print v(xbgr.mr_n69866752)
print v(xbgr.mr_n69867072)
print v(xbgr.mr_n69867184)
print v(xbgr.mr_n69867504)
print v(xbgr.mr_n69867616)
print v(xbgr.mr_n69867936)
print v(xbgr.mr_n69868048)
print v(xbgr.mr_n69868368)
print v(xbgr.mr_n69868480)
print v(xbgr.mr_n69868800)
print v(xbgr.mr_n69868912)
print v(xbgr.mr_n69869232)
print v(xbgr.mr_n69869344)
print v(xbgr.mr_n69869664)
print v(xbgr.mr_n69869776)
print v(xbgr.mr_n69870096)
print v(xbgr.mr_n69870208)
print v(xbgr.mr_n69870528)
print v(xbgr.mr_n69870640)
print v(xbgr.mr_n69870960)
print v(xbgr.mr_n69871072)
print v(xbgr.mr_n69871504)
print v(xbgr.mr_n69871936)
print v(xbgr.mr_n69872368)
print v(xbgr.mr_n69872800)
print v(xbgr.mr_n69873232)
print v(xbgr.mr_n69873664)
print v(xbgr.mr_n69874096)
print v(xbgr.mr_n69874528)
print v(xbgr.mr_n69874960)
print v(xbgr.mr_n69875392)
print v(xbgr.mr_n69875824)
print v(xbgr.mr_n69876256)
print v(xbgr.mr_n69876688)
print v(xbgr.mr_n69877120)
print v(xbgr.mr_n69877552)
print v(xbgr.mr_n69877984)
print v(xbgr.mr_n69878416)
print v(xbgr.mr_n69878848)
print v(xbgr.mr_n69879280)
print v(xbgr.mr_n69879600)
print v(xbgr.mr_n69879712)
print v(xbgr.mr_n69880032)
print v(xbgr.mr_n69880144)
print v(xbgr.mr_n69880464)
print v(xbgr.mr_n69880576)
print v(xbgr.mr_n69880896)
print v(xbgr.mr_n69881008)
print v(xbgr.mr_n69881328)
print v(xbgr.mr_n69881440)
print v(xbgr.mr_n69881872)
print v(xbgr.mr_n69882304)
print v(xbgr.mr_n69882736)
print v(xbgr.mr_n69883168)
print v(xbgr.mr_n69883600)
print v(xbgr.mr_n69884032)
print v(xbgr.mr_n69884464)
print v(xbgr.mr_n69884784)
print v(xbgr.mr_n69884896)
print v(xbgr.mr_n69885216)
print v(xbgr.mr_n69885328)
print v(xbgr.mr_n69885648)
print v(xbgr.mr_n69885760)
print v(xbgr.mr_n69886080)
print v(xbgr.mr_n69886192)
print v(xbgr.mr_n69886512)
print v(xbgr.mr_n69886624)
print v(xbgr.mr_n69886944)
print v(xbgr.mr_n69887056)
print v(xbgr.mr_n69887376)
print v(xbgr.mr_n69887488)
print v(xbgr.mr_n69887808)
print v(xbgr.mr_n69887920)
print v(xbgr.mr_n69888240)
print v(xbgr.mr_n69888352)
print v(xbgr.mr_n69888672)
print v(xbgr.mr_n69888784)
print v(xbgr.mr_n69889104)
print v(xbgr.mr_n69889216)
print v(xbgr.mr_n69889536)
print v(xbgr.mr_n69889648)
print v(xbgr.mr_n69889968)
print v(xbgr.mr_n69890080)
print v(xbgr.mr_n69890512)
print v(xbgr.mr_n69890944)
print v(xbgr.mr_n69891376)
print v(xbgr.mr_n69891808)
print v(xbgr.mr_n69892240)
print v(xbgr.mr_n69892672)
print v(xbgr.mr_n69893104)
print v(xbgr.mr_n69893536)
print v(xbgr.mr_n69893968)
print v(xbgr.mr_n69894400)
print v(xbgr.mr_n69894832)
print v(xbgr.mr_n69895264)
print v(xbgr.mr_n69895696)
print v(xbgr.mr_n69896016)
print v(xbgr.mr_n69896128)
print v(xbgr.mr_n69896448)
print v(xbgr.mr_n69896560)
print v(xbgr.mr_n69896880)
print v(xbgr.mr_n69896992)
print v(xbgr.mr_n69897312)
print v(xbgr.mr_n69897424)
print v(xbgr.mr_n69897744)
print v(xbgr.mr_n69897856)
print v(xbgr.mr_n69898176)
print v(xbgr.mr_n69898288)
print v(xbgr.mr_n69898608)
print v(xbgr.mr_n69898720)
print v(xbgr.mr_n69899040)
print v(xbgr.mr_n69899152)
print v(xbgr.mr_n69899472)
print v(xbgr.mr_n69899584)
print v(xbgr.mr_n69899904)
print v(xbgr.mr_n69900016)
print v(xbgr.mr_n69900336)
print v(xbgr.mr_n69900448)
print v(xbgr.mr_n69900768)
print v(xbgr.mr_n69900880)
print v(xbgr.mr_n69901312)
print v(xbgr.mr_n69901744)
print v(xbgr.mr_n69902176)
print v(xbgr.mr_n69902608)
print v(xbgr.mr_n69903040)
print v(xbgr.mr_n69903472)
print v(xbgr.mr_n69903904)
print v(xbgr.mr_n69904336)
print v(xbgr.mr_n69904768)
print v(xbgr.mr_n69905200)
print v(xbgr.mr_n69905632)
print v(xbgr.mr_n69906064)
print v(xbgr.mr_n69906384)
print v(xbgr.mr_n69906496)
print v(xbgr.mr_n69906928)
print v(xbgr.mr_n69907248)
print v(xbgr.mr_n69907360)
print v(xbgr.mr_n69907680)
print v(xbgr.mr_n69907792)
print v(xbgr.mr_n69908112)
print v(xbgr.mr_n69908224)
print v(xbgr.mr_n69908544)
print v(xbgr.mr_n69908656)
print v(xbgr.mr_n69908976)
print v(xbgr.mr_n69909088)
print v(xbgr.mr_n69909520)
print v(xbgr.mr_n69909952)
print v(xbgr.mr_n69910272)
print v(xbgr.mr_n69910384)
print v(xbgr.mr_n69910704)
print v(xbgr.mr_n69910816)
print v(xbgr.mr_n69911136)
print v(xbgr.mr_n69911248)
print v(xbgr.mr_n69911568)
print v(xbgr.mr_n69911680)
print v(xbgr.mr_n69912000)
print v(xbgr.mr_n69912112)
print v(xbgr.mr_n69912432)
print v(xbgr.mr_n69912544)
print v(xbgr.mr_n69912864)
print v(xbgr.mr_n69912976)
print v(xbgr.mr_n69913296)
print v(xbgr.mr_n69913408)
print v(xbgr.mr_n69913840)
print v(xbgr.mr_n69914272)
print v(xbgr.mr_n69914704)
print v(xbgr.mr_n69915136)
print v(xbgr.mr_n69915568)
print v(xbgr.mr_n69916000)
print v(xbgr.mr_n69916432)
print v(xbgr.mr_n69916864)
print v(xbgr.mr_n69917296)
print v(xbgr.mr_n69917728)
print v(xbgr.mr_n69918160)
print v(xbgr.mr_n69918480)
print v(xbgr.mr_n69918592)
print v(xbgr.mr_n69918912)
print v(xbgr.mr_n69919024)
print v(xbgr.mr_n69919344)
print v(xbgr.mr_n69919456)
print v(xbgr.mr_n69919888)
print v(xbgr.mr_n69920320)
print v(xbgr.mr_n69920640)
print v(xbgr.mr_n69920752)
print v(xbgr.mr_n69921072)
print v(xbgr.mr_n69921184)
print v(xbgr.mr_n69921504)
print v(xbgr.mr_n69921616)
print v(xbgr.mr_n69921936)
print v(xbgr.mr_n69922048)
print v(xbgr.mr_n69922480)
print v(xbgr.mr_n69922800)
print v(xbgr.mr_n69922912)
print v(xbgr.mr_n69923232)
print v(xbgr.mr_n69923344)
print v(xbgr.mr_n69923664)
print v(xbgr.mr_n69923776)
print v(xbgr.mr_n69924096)
print v(xbgr.mr_n69924208)
print v(xbgr.mr_n69924528)
print v(xbgr.mr_n69924640)
print v(xbgr.mr_n69924960)
print v(xbgr.mr_n69925072)
print v(xbgr.mr_n69925504)
print v(xbgr.mr_n69925936)
print v(xbgr.mr_n69926368)
print v(xbgr.mr_n69926800)
print v(xbgr.mr_n69927232)
print v(xbgr.mr_n69927664)
print v(xbgr.mr_n69928096)
print v(xbgr.mr_n69928528)
print v(xbgr.mr_n69928960)
print v(xbgr.mr_n69929392)
print v(xbgr.mr_n69929712)
print v(xbgr.mr_n69929824)
print v(xbgr.mr_n69930144)
print v(xbgr.mr_n69930256)
print v(xbgr.mr_n69930576)
print v(xbgr.mr_n69930688)
print v(xbgr.mr_n69931008)
print v(xbgr.mr_n69931120)
print v(xbgr.mr_n69931440)
print v(xbgr.mr_n69931552)
print v(xbgr.mr_n69931872)
print v(xbgr.mr_n69931984)
print v(xbgr.mr_n69932304)
print v(xbgr.mr_n69932416)
print v(xbgr.mr_n69932736)
print v(xbgr.mr_n69932848)
print v(xbgr.mr_n69933168)
print v(xbgr.mr_n69933280)
print v(xbgr.mr_n69933600)
print v(xbgr.mr_n69933712)
print v(xbgr.mr_n69934032)
print v(xbgr.mr_n69934144)
print v(xbgr.mr_n69934464)
print v(xbgr.mr_n69934576)
print v(xbgr.mr_n69934896)
print v(xbgr.mr_n69935008)
print v(xbgr.mr_n69935440)
print v(xbgr.mr_n69935872)
print v(xbgr.mr_n69936304)
print v(xbgr.mr_n69936736)
print v(xbgr.mr_n69937168)
print v(xbgr.mr_n69937600)
print v(xbgr.mr_n69938032)
print v(xbgr.mr_n69938464)
print v(xbgr.mr_n69938896)
print v(xbgr.mr_n69939328)
print v(xbgr.mr_n69939760)
print v(xbgr.mr_n69940192)
print v(xbgr.mr_n69940624)
print v(xbgr.mr_n69940944)
print v(xbgr.mr_n69941056)
print v(xbgr.mr_n69941376)
print v(xbgr.mr_n69941488)
print v(xbgr.mr_n69941808)
print v(xbgr.mr_n69941920)
print v(xbgr.mr_n69942240)
print v(xbgr.mr_n69942352)
print v(xbgr.mr_n69942672)
print v(xbgr.mr_n69942784)
print v(xbgr.mr_n69943104)
print v(xbgr.mr_n69943216)
print v(xbgr.mr_n69943536)
print v(xbgr.mr_n69943648)
print v(xbgr.mr_n69943968)
print v(xbgr.mr_n69944080)
print v(xbgr.mr_n69944400)
print v(xbgr.mr_n69944512)
print v(xbgr.mr_n69944832)
print v(xbgr.mr_n69944944)
print v(xbgr.mr_n69945264)
print v(xbgr.mr_n69945376)
print v(xbgr.mr_n69945696)
print v(xbgr.mr_n69945808)
print v(xbgr.mr_n69946128)
print v(xbgr.mr_n69946240)
print v(xbgr.mr_n69946672)
print v(xbgr.mr_n69947104)
print v(xbgr.mr_n69947536)
print v(xbgr.mr_n69947968)
print v(xbgr.mr_n69948400)
print v(xbgr.mr_n69948832)
print v(xbgr.mr_n69949264)
print v(xbgr.mr_n69949696)
print v(xbgr.mr_n69950128)
print v(xbgr.mr_n69950560)
print v(xbgr.mr_n69950992)
print v(xbgr.mr_n69951424)
print v(xbgr.mr_n69951856)
print v(xbgr.mr_n69952176)
print v(xbgr.mr_n69952288)
print v(xbgr.mr_n69952608)
print v(xbgr.mr_n69952720)
print v(xbgr.mr_n69953040)
print v(xbgr.mr_n69953152)
print v(xbgr.mr_n69953472)
print v(xbgr.mr_n69953584)
print v(xbgr.mr_n69953904)
print v(xbgr.mr_n69954016)
print v(xbgr.mr_n69954336)
print v(xbgr.mr_n69954448)
print v(xbgr.mr_n69954768)
print v(xbgr.mr_n69954880)
print v(xbgr.mr_n69955200)
print v(xbgr.mr_n69955312)
print v(xbgr.mr_n69955632)
print v(xbgr.mr_n69955744)
print v(xbgr.mr_n69956064)
print v(xbgr.mr_n69956176)
print v(xbgr.mr_n69956496)
print v(xbgr.mr_n69956608)
print v(xbgr.mr_n69956928)
print v(xbgr.mr_n69957040)
print v(xbgr.mr_n69957360)
print v(xbgr.mr_n69957472)
print v(xbgr.mr_n69957904)
print v(xbgr.mr_n69958336)
print v(xbgr.mr_n69958768)
print v(xbgr.mr_n69959200)
print v(xbgr.mr_n69959632)
print v(xbgr.mr_n69960064)
print v(xbgr.mr_n69960496)
print v(xbgr.mr_n69960928)
print v(xbgr.mr_n69961360)
print v(xbgr.mr_n69961792)
print v(xbgr.mr_n69962224)
print v(xbgr.mr_n69962656)
print v(xbgr.mr_n69963088)
print v(xbgr.mr_n69963408)
print v(xbgr.mr_n69963520)
print v(xbgr.mr_n69963840)
print v(xbgr.mr_n69963952)
print v(xbgr.mr_n69964384)
print v(xbgr.mr_n69964704)
print v(xbgr.mr_n69964816)
print v(xbgr.mr_n69965136)
print v(xbgr.mr_n69965248)
print v(xbgr.mr_n69965568)
print v(xbgr.mr_n69965680)
print v(xbgr.mr_n69966000)
print v(xbgr.mr_n69966112)
print v(xbgr.mr_n69966544)
print v(xbgr.mr_n69966976)
print v(xbgr.mr_n69967408)
print v(xbgr.mr_n69967840)
print v(xbgr.mr_n69968160)
print v(xbgr.mr_n69968272)
print v(xbgr.mr_n69968592)
print v(xbgr.mr_n69968704)
print v(xbgr.mr_n69969136)
print v(xbgr.mr_n69969568)
print v(xbgr.mr_n69969888)
print v(xbgr.mr_n69970000)
print v(xbgr.mr_n69970320)
print v(xbgr.mr_n69970432)
print v(xbgr.mr_n69970752)
print v(xbgr.mr_n69970864)
print v(xbgr.mr_n69971184)
print v(xbgr.mr_n69971296)
print v(xbgr.mr_n69971616)
print v(xbgr.mr_n69971728)
print v(xbgr.mr_n69972160)
print v(xbgr.mr_n69972592)
print v(xbgr.mr_n69973024)
print v(xbgr.mr_n69973456)
print v(xbgr.mr_n69973888)
print v(xbgr.mr_n69974320)
print v(xbgr.mr_n69974640)
print v(xbgr.mr_n69974752)
print v(xbgr.mr_n69975072)
print v(xbgr.mr_n69975184)
print v(xbgr.mr_n69975504)
print v(xbgr.mr_n69975616)
print v(xbgr.mr_n69975936)
print v(xbgr.mr_n69976048)
print v(xbgr.mr_n69976368)
print v(xbgr.mr_n69976480)
print v(xbgr.mr_n69976800)
print v(xbgr.mr_n69976912)
print v(xbgr.mr_n69977232)
print v(xbgr.mr_n69977344)
print v(xbgr.mr_n69977664)
print v(xbgr.mr_n69977776)
print v(xbgr.mr_n69978096)
print v(xbgr.mr_n69978208)
print v(xbgr.mr_n69978528)
print v(xbgr.mr_n69978640)
print v(xbgr.mr_n69978960)
print v(xbgr.mr_n69979072)
print v(xbgr.mr_n69979392)
print v(xbgr.mr_n69979504)
print v(xbgr.mr_n69979936)
print v(xbgr.mr_n69980368)
print v(xbgr.mr_n69980800)
print v(xbgr.mr_n69981232)
print v(xbgr.mr_n69981664)
print v(xbgr.mr_n69982096)
print v(xbgr.mr_n69982528)
print v(xbgr.mr_n69982960)
print v(xbgr.mr_n69983280)
print v(xbgr.mr_n69983392)
print v(xbgr.mr_n69983712)
print v(xbgr.mr_n69983824)
print v(xbgr.mr_n69984144)
print v(xbgr.mr_n69984256)
print v(xbgr.mr_n69984576)
print v(xbgr.mr_n69984688)
print v(xbgr.mr_n69985008)
print v(xbgr.mr_n69985120)
print v(xbgr.mr_n69985440)
print v(xbgr.mr_n69985552)
print v(xbgr.mr_n69985872)
print v(xbgr.mr_n69985984)
print v(xbgr.mr_n69986304)
print v(xbgr.mr_n69986416)
print v(xbgr.mr_n69986848)
print v(xbgr.mr_n69987280)
print v(xbgr.mr_n69987600)
print v(xbgr.mr_n69987712)
print v(xbgr.mr_n69988032)
print v(xbgr.mr_n69988144)
print v(xbgr.mr_n69988464)
print v(xbgr.mr_n69988576)
print v(xbgr.mr_n69988896)
print v(xbgr.mr_n69989008)
print v(xbgr.mr_n69989328)
print v(xbgr.mr_n69989440)
print v(xbgr.mr_n69989760)
print v(xbgr.mr_n69989872)
print v(xbgr.mr_n69990304)
print v(xbgr.mr_n69990736)
print v(xbgr.mr_n69991168)
print v(xbgr.mr_n69991600)
print v(xbgr.mr_n69992032)
print v(xbgr.mr_n69992464)
print v(xbgr.mr_n69992896)
print v(xbgr.mr_n69993328)
print v(xbgr.mr_n69993760)
print v(xbgr.mr_n69994192)
print v(xbgr.mr_n69994624)
print v(xbgr.mr_n69995056)
print v(xbgr.mr_n69995488)
print v(xbgr.mr_n69995920)
print v(xbgr.mr_n69996352)
print v(xbgr.mr_n69996784)
print v(xbgr.mr_n69997104)
print v(xbgr.mr_n69997216)
print v(xbgr.mr_n69997536)
print v(xbgr.mr_n69997648)
print v(xbgr.mr_n69997968)
print v(xbgr.mr_n69998080)
print v(xbgr.mr_n69998400)
print v(xbgr.mr_n69998512)
print v(xbgr.mr_n69998832)
print v(xbgr.mr_n69998944)
print v(xbgr.mr_n69999264)
print v(xbgr.mr_n69999376)
print v(xbgr.mr_n69999696)
print v(xbgr.mr_n69999808)
print v(xbgr.mr_n70000128)
print v(xbgr.mr_n70000240)
print v(xbgr.mr_n70000560)
print v(xbgr.mr_n70000672)
print v(xbgr.mr_n70000992)
print v(xbgr.mr_n70001104)
print v(xbgr.mr_n70001424)
print v(xbgr.mr_n70001536)
print v(xbgr.mr_n70001856)
print v(xbgr.mr_n70001968)
print v(xbgr.mr_n70002288)
print v(xbgr.mr_n70002400)
print v(xbgr.mr_n70002720)
print v(xbgr.mr_n70002832)
print v(xbgr.mr_n70003152)
print v(xbgr.mr_n70003264)
print v(xbgr.mr_n70003584)
print v(xbgr.mr_n70003696)
print v(xbgr.mr_n70004016)
print v(xbgr.mr_n70004128)
print v(xbgr.mr_n70004448)
print v(xbgr.mr_n70004560)
print v(xbgr.mr_n70004880)
print v(xbgr.mr_n70004992)
print v(xbgr.mr_n70005312)
print v(xbgr.mr_n70005424)
print v(xbgr.mr_n70005856)
print v(xbgr.mr_n70006288)
print v(xbgr.mr_n70006720)
print v(xbgr.mr_n70007152)
print v(xbgr.mr_n70007584)
print v(xbgr.mr_n70008016)
print v(xbgr.mr_n70008336)
print v(xbgr.mr_n70008448)
print v(xbgr.mr_n70008768)
print v(xbgr.mr_n70008880)
print v(xbgr.mr_n70009200)
print v(xbgr.mr_n70009312)
print v(xbgr.mr_n70009632)
print v(xbgr.mr_n70009744)
print v(xbgr.mr_n70010064)
print v(xbgr.mr_n70010176)
print v(xbgr.mr_n70010496)
print v(xbgr.mr_n70010608)
print v(xbgr.mr_n70011040)
print v(xbgr.mr_n70011472)
print v(xbgr.mr_n70011904)
print v(xbgr.mr_n70012336)
print v(xbgr.mr_n70012768)
print v(xbgr.mr_n70013200)
print v(xbgr.mr_n70013632)
print v(xbgr.mr_n70014064)
print v(xbgr.mr_n70014496)
print v(xbgr.mr_n70014928)
print v(xbgr.mr_n70015360)
print v(xbgr.mr_n70015792)
print v(xbgr.mr_n70016224)
print v(xbgr.mr_n70016656)
print v(xbgr.mr_n70017088)
print v(xbgr.mr_n70017520)
print v(xbgr.mr_n70017952)
print v(xbgr.mr_n70018384)
print v(xbgr.mr_n70018816)
print v(xbgr.mr_n70019248)
print v(xbgr.mr_n70019568)
print v(xbgr.mr_n70019680)
print v(xbgr.mr_n70020000)
print v(xbgr.mr_n70020112)
print v(xbgr.mr_n70020432)
print v(xbgr.mr_n70020544)
print v(xbgr.mr_n70020864)
print v(xbgr.mr_n70020976)
print v(xbgr.mr_n70021296)
print v(xbgr.mr_n70021408)
print v(xbgr.mr_n70021728)
print v(xbgr.mr_n70021840)
print v(xbgr.mr_n70022160)
print v(xbgr.mr_n70022272)
print v(xbgr.mr_n70022592)
print v(xbgr.mr_n70022704)
print v(xbgr.mr_n70023024)
print v(xbgr.mr_n70023136)
print v(xbgr.mr_n70023456)
print v(xbgr.mr_n70023568)
print v(xbgr.mr_n70023888)
print v(xbgr.mr_n70024000)
print v(xbgr.mr_n70024320)
print v(xbgr.mr_n70024432)
print v(xbgr.mr_n70024752)
print v(xbgr.mr_n70024864)
print v(xbgr.mr_n70025184)
print v(xbgr.mr_n70025296)
print v(xbgr.mr_n70025616)
print v(xbgr.mr_n70025728)
print v(xbgr.mr_n70026048)
print v(xbgr.mr_n70026160)
print v(xbgr.mr_n70026480)
print v(xbgr.mr_n70026592)
print v(xbgr.mr_n70026912)
print v(xbgr.mr_n70027024)
print v(xbgr.mr_n70027344)
print v(xbgr.mr_n70027456)
print v(xbgr.mr_n70027776)
print v(xbgr.mr_n70027888)
print v(xbgr.mr_n70028208)
print v(xbgr.mr_n70028320)
print v(xbgr.mr_n70028640)
print v(xbgr.mr_n70028752)
print v(xbgr.mr_n70029072)
print v(xbgr.mr_n70029184)
print v(xbgr.mr_n70029504)
print v(xbgr.mr_n70029616)
print v(xbgr.mr_n70029936)
print v(xbgr.mr_n70030048)
print v(xbgr.mr_n70030368)
print v(xbgr.mr_n70030480)
print v(xbgr.mr_n70030800)
print v(xbgr.mr_n70030912)
print v(xbgr.mr_n70031232)
print v(xbgr.mr_n70031344)
print v(xbgr.mr_n70031664)
print v(xbgr.mr_n70031776)
print v(xbgr.mr_n70032096)
print v(xbgr.mr_n70032208)
print v(xbgr.mr_n70032528)
print v(xbgr.mr_n70032640)
print v(xbgr.mr_n70032960)
print v(xbgr.mr_n70033072)
print v(xbgr.mr_n70033504)
print v(xbgr.mr_n70033936)
print v(xbgr.mr_n70034256)
print v(xbgr.mr_n70034368)
print v(xbgr.mr_n70034688)
print v(xbgr.mr_n70034800)
print v(xbgr.mr_n70035120)
print v(xbgr.mr_n70035232)
print v(xbgr.mr_n70035552)
print v(xbgr.mr_n70035664)
print v(xbgr.mr_n70035984)
print v(xbgr.mr_n70036096)
print v(xbgr.mr_n70036416)
print v(xbgr.mr_n70036528)
print v(xbgr.mr_n70036848)
print v(xbgr.mr_n70036960)
print v(xbgr.mr_n70037280)
print v(xbgr.mr_n70037392)
print v(xbgr.mr_n70037712)
print v(xbgr.mr_n70037824)
print v(xbgr.mr_n70038144)
print v(xbgr.mr_n70038256)
print v(xbgr.mr_n70038688)
print v(xbgr.mr_n70039120)
print v(xbgr.mr_n70039552)
print v(xbgr.mr_n70039872)
print v(xbgr.mr_n70039984)
print v(xbgr.mr_n70040304)
print v(xbgr.mr_n70040416)
print v(xbgr.mr_n70040848)
print v(xbgr.mr_n70041280)
print v(xbgr.mr_n70041712)
print v(xbgr.mr_n70042144)
print v(xbgr.mr_n70042576)
print v(xbgr.mr_n70043008)
print v(xbgr.mr_n70043440)
print v(xbgr.mr_n70043872)
print v(xbgr.mr_n70044304)
print v(xbgr.mr_n70044736)
print v(xbgr.mr_n70045168)
print v(xbgr.mr_n70045488)
print v(xbgr.mr_n70045600)
print v(xbgr.mr_n70045920)
print v(xbgr.mr_n70046032)
print v(xbgr.mr_n70046352)
print v(xbgr.mr_n70046464)
print v(xbgr.mr_n70046784)
print v(xbgr.mr_n70046896)
print v(xbgr.mr_n70047216)
print v(xbgr.mr_n70047328)
print v(xbgr.mr_n70047648)
print v(xbgr.mr_n70047760)
print v(xbgr.mr_n70048080)
print v(xbgr.mr_n70048192)
print v(xbgr.mr_n70048512)
print v(xbgr.mr_n70048624)
print v(xbgr.mr_n70049056)
print v(xbgr.mr_n70049488)
print v(xbgr.mr_n70049920)
print v(xbgr.mr_n70050352)
print v(xbgr.mr_n70050784)
print v(xbgr.mr_n70051216)
print v(xbgr.mr_n70051648)
print v(xbgr.mr_n70052080)
print v(xbgr.mr_n70052512)
print v(xbgr.mr_n70052944)
print v(xbgr.mr_n70053376)
print v(xbgr.mr_n70053808)
print v(xbgr.mr_n70054240)
print v(xbgr.mr_n70054672)
print v(xbgr.mr_n70055104)
print v(xbgr.mr_n70055536)
print v(xbgr.mr_n70055968)
print v(xbgr.mr_n70056400)
print v(xbgr.mr_n70056832)
print v(xbgr.mr_n70057264)
print v(xbgr.mr_n70057584)
print v(xbgr.mr_n70057696)
print v(xbgr.mr_n70058016)
print v(xbgr.mr_n70058128)
print v(xbgr.mr_n70058448)
print v(xbgr.mr_n70058560)
print v(xbgr.mr_n70058880)
print v(xbgr.mr_n70058992)
print v(xbgr.mr_n70059312)
print v(xbgr.mr_n70059424)
print v(xbgr.mr_n70059744)
print v(xbgr.mr_n70059856)
print v(xbgr.mr_n70060176)
print v(xbgr.mr_n70060288)
print v(xbgr.mr_n70060608)
print v(xbgr.mr_n70060720)
print v(xbgr.mr_n70061040)
print v(xbgr.mr_n70061152)
print v(xbgr.mr_n70061472)
print v(xbgr.mr_n70061584)
print v(xbgr.mr_n70061904)
print v(xbgr.mr_n70062016)
print v(xbgr.mr_n70062336)
print v(xbgr.mr_n70062448)
print v(xbgr.mr_n70062768)
print v(xbgr.mr_n70062880)
print v(xbgr.mr_n70063312)
print v(xbgr.mr_n70063744)
print v(xbgr.mr_n70064176)
print v(xbgr.mr_n70064608)
print v(xbgr.mr_n70065040)
print v(xbgr.mr_n70065472)
print v(xbgr.mr_n70065904)
print v(xbgr.mr_n70066336)
print v(xbgr.mr_n70066768)
print v(xbgr.mr_n70067200)
print v(xbgr.mr_n70067632)
print v(xbgr.mr_n70068064)
print v(xbgr.mr_n70068496)
print v(xbgr.mr_n70068816)
print v(xbgr.mr_n70068928)
print v(xbgr.mr_n70069248)
print v(xbgr.mr_n70069360)
print v(xbgr.mr_n70069680)
print v(xbgr.mr_n70069792)
print v(xbgr.mr_n70070112)
print v(xbgr.mr_n70070224)
print v(xbgr.mr_n70070544)
print v(xbgr.mr_n70070656)
print v(xbgr.mr_n70070976)
print v(xbgr.mr_n70071088)
print v(xbgr.mr_n70071408)
print v(xbgr.mr_n70071520)
print v(xbgr.mr_n70071840)
print v(xbgr.mr_n70071952)
print v(xbgr.mr_n70072272)
print v(xbgr.mr_n70072384)
print v(xbgr.mr_n70072704)
print v(xbgr.mr_n70072816)
print v(xbgr.mr_n70073136)
print v(xbgr.mr_n70073248)
print v(xbgr.mr_n70073568)
print v(xbgr.mr_n70073680)
print v(xbgr.mr_n70074112)
print v(xbgr.mr_n70074432)
print v(xbgr.mr_n70074544)
print v(xbgr.mr_n70074976)
print v(xbgr.mr_n70075408)
print v(xbgr.mr_n70075840)
print v(xbgr.mr_n70076272)
print v(xbgr.mr_n70076704)
print v(xbgr.mr_n70077136)
print v(xbgr.mr_n70077568)
print v(xbgr.mr_n70078000)
print v(xbgr.mr_n70078432)
print v(xbgr.mr_n70078864)
print v(xbgr.mr_n70079296)
print v(xbgr.mr_n70079728)
print v(xbgr.mr_n70080048)
print v(xbgr.mr_n70080160)
print v(xbgr.mr_n70080480)
print v(xbgr.mr_n70080592)
print v(xbgr.mr_n70080912)
print v(xbgr.mr_n70081024)
print v(xbgr.mr_n70081344)
print v(xbgr.mr_n70081456)
print v(xbgr.mr_n70081776)
print v(xbgr.mr_n70081888)
print v(xbgr.mr_n70082208)
print v(xbgr.mr_n70082320)
print v(xbgr.mr_n70082640)
print v(xbgr.mr_n70082752)
print v(xbgr.mr_n70083072)
print v(xbgr.mr_n70083184)
print v(xbgr.mr_n70083504)
print v(xbgr.mr_n70083616)
print v(xbgr.mr_n70083936)
print v(xbgr.mr_n70084048)
print v(xbgr.mr_n70084368)
print v(xbgr.mr_n70084480)
print v(xbgr.mr_n70084912)
print v(xbgr.mr_n70085344)
print v(xbgr.mr_n70085776)
print v(xbgr.mr_n70086096)
print v(xbgr.mr_n70086208)
print v(xbgr.mr_n70086528)
print v(xbgr.mr_n70086640)
print v(xbgr.mr_n70087072)
print v(xbgr.mr_n70087504)
print v(xbgr.mr_n70087936)
print v(xbgr.mr_n70088368)
print v(xbgr.mr_n70088800)
print v(xbgr.mr_n70089232)
print v(xbgr.mr_n70089664)
print v(xbgr.mr_n70090096)
print v(xbgr.mr_n70090528)
print v(xbgr.mr_n70090960)
print v(xbgr.mr_n70091280)
print v(xbgr.mr_n70091392)
print v(xbgr.mr_n70091712)
print v(xbgr.mr_n70091824)
print v(xbgr.mr_n70092144)
print v(xbgr.mr_n70092256)
print v(xbgr.mr_n70092576)
print v(xbgr.mr_n70092688)
print v(xbgr.mr_n70093008)
print v(xbgr.mr_n70093120)
print v(xbgr.mr_n70093440)
print v(xbgr.mr_n70093552)
print v(xbgr.mr_n70093872)
print v(xbgr.mr_n70093984)
print v(xbgr.mr_n70094304)
print v(xbgr.mr_n70094416)
print v(xbgr.mr_n70094736)
print v(xbgr.mr_n70094848)
print v(xbgr.mr_n70095168)
print v(xbgr.mr_n70095280)
print v(xbgr.mr_n70095600)
print v(xbgr.mr_n70095712)
print v(xbgr.mr_n70096032)
print v(xbgr.mr_n70096144)
print v(xbgr.mr_n70096576)
print v(xbgr.mr_n70097008)
print v(xbgr.mr_n70097440)
print v(xbgr.mr_n70097872)
print v(xbgr.mr_n70098304)
print v(xbgr.mr_n70098736)
print v(xbgr.mr_n70099168)
print v(xbgr.mr_n70099488)
print v(xbgr.mr_n70099600)
print v(xbgr.mr_n70100032)
print v(xbgr.mr_n70100464)
print v(xbgr.mr_n70100896)
print v(xbgr.mr_n70101328)
print v(xbgr.mr_n70101760)
print v(xbgr.mr_n70102192)
print v(xbgr.mr_n70102512)
print v(xbgr.mr_n70102624)
print v(xbgr.mr_n70102944)
print v(xbgr.mr_n70103056)
print v(xbgr.mr_n70103376)
print v(xbgr.mr_n70103488)
print v(xbgr.mr_n70103808)
print v(xbgr.mr_n70103920)
print v(xbgr.mr_n70104240)
print v(xbgr.mr_n70104352)
print v(xbgr.mr_n70104672)
print v(xbgr.mr_n70104784)
print v(xbgr.mr_n70105104)
print v(xbgr.mr_n70105216)
print v(xbgr.mr_n70105536)
print v(xbgr.mr_n70105648)
print v(xbgr.mr_n70105968)
print v(xbgr.mr_n70106080)
print v(xbgr.mr_n70106400)
print v(xbgr.mr_n70106512)
print v(xbgr.mr_n70106832)
print v(xbgr.mr_n70106944)
print v(xbgr.mr_n70107264)
print v(xbgr.mr_n70107376)
print v(xbgr.mr_n70107696)
print v(xbgr.mr_n70107808)
print v(xbgr.mr_n70108128)
print v(xbgr.mr_n70108240)
print v(xbgr.mr_n70108560)
print v(xbgr.mr_n70108672)
print v(xbgr.mr_n70108992)
print v(xbgr.mr_n70109104)
print v(xbgr.mr_n70109424)
print v(xbgr.mr_n70109536)
print v(xbgr.mr_n70109856)
print v(xbgr.mr_n70109968)
print v(xbgr.mr_n70110288)
print v(xbgr.mr_n70110400)
print v(xbgr.mr_n70110720)
print v(xbgr.mr_n70110832)
print v(xbgr.mr_n70111152)
print v(xbgr.mr_n70111264)
print v(xbgr.mr_n70111584)
print v(xbgr.mr_n70111696)
print v(xbgr.mr_n70112016)
print v(xbgr.mr_n70112128)
print v(xbgr.mr_n70112448)
print v(xbgr.mr_n70112560)
print v(xbgr.mr_n70112992)
print v(xbgr.mr_n70113424)
print v(xbgr.mr_n70113856)
print v(xbgr.mr_n70114176)
print v(xbgr.mr_n70114288)
print v(xbgr.mr_n70114608)
print v(xbgr.mr_n70114720)
print v(xbgr.mr_n70115152)
print v(xbgr.mr_n70115584)
print v(xbgr.mr_n70116016)
print v(xbgr.mr_n70116448)
print v(xbgr.mr_n70116880)
print v(xbgr.mr_n70117312)
print v(xbgr.mr_n70117744)
print v(xbgr.mr_n70118176)
print v(xbgr.mr_n70118608)
print v(xbgr.mr_n70119040)
print v(xbgr.mr_n70119472)
print v(xbgr.mr_n70119904)
print v(xbgr.mr_n70120336)
print v(xbgr.mr_n70120768)
print v(xbgr.mr_n70121200)
print v(xbgr.mr_n70121632)
print v(xbgr.mr_n70122064)
print v(xbgr.mr_n70122496)
print v(xbgr.mr_n70122928)
print v(xbgr.mr_n70123360)
print v(xbgr.mr_n70123792)
print v(xbgr.mr_n70124224)
print v(xbgr.mr_n70124656)
print v(xbgr.mr_n70124976)
print v(xbgr.mr_n70125088)
print v(xbgr.mr_n70125408)
print v(xbgr.mr_n70125520)
print v(xbgr.mr_n70125840)
print v(xbgr.mr_n70125952)
print v(xbgr.mr_n70126272)
print v(xbgr.mr_n70126384)
print v(xbgr.mr_n70126704)
print v(xbgr.mr_n70126816)
print v(xbgr.mr_n70127136)
print v(xbgr.mr_n70127248)
print v(xbgr.mr_n70127568)
print v(xbgr.mr_n70127680)
print v(xbgr.mr_n70128000)
print v(xbgr.mr_n70128112)
print v(xbgr.mr_n70128432)
print v(xbgr.mr_n70128544)
print v(xbgr.mr_n70128864)
print v(xbgr.mr_n70128976)
print v(xbgr.mr_n70129296)
print v(xbgr.mr_n70129408)
print v(xbgr.mr_n70129728)
print v(xbgr.mr_n70129840)
print v(xbgr.mr_n70130160)
print v(xbgr.mr_n70130272)
print v(xbgr.mr_n70130592)
print v(xbgr.mr_n70130704)
print v(xbgr.mr_n70131136)
print v(xbgr.mr_n70131568)
print v(xbgr.mr_n70131888)
print v(xbgr.mr_n70132000)
print v(xbgr.mr_n70132320)
print v(xbgr.mr_n70132432)
print v(xbgr.mr_n70132752)
print v(xbgr.mr_n70132864)
print v(xbgr.mr_n70133184)
print v(xbgr.mr_n70133296)
print v(xbgr.mr_n70133728)
print v(xbgr.mr_n70134160)
print v(xbgr.mr_n70134480)
print v(xbgr.mr_n70134592)
print v(xbgr.mr_n70134912)
print v(xbgr.mr_n70135024)
print v(xbgr.mr_n70135344)
print v(xbgr.mr_n70135456)
print v(xbgr.mr_n70135776)
print v(xbgr.mr_n70135888)
print v(xbgr.mr_n70136208)
print v(xbgr.mr_n70136320)
print v(xbgr.mr_n70136640)
print v(xbgr.mr_n70136752)
print v(xbgr.mr_n70137072)
print v(xbgr.mr_n70137184)
print v(xbgr.mr_n70137504)
print v(xbgr.mr_n70137616)
print v(xbgr.mr_n70138048)
print v(xbgr.mr_n70138480)
print v(xbgr.mr_n70138912)
print v(xbgr.mr_n70139344)
print v(xbgr.mr_n70139776)
print v(xbgr.mr_n70140208)
print v(xbgr.mr_n70140640)
print v(xbgr.mr_n70141072)
print v(xbgr.mr_n70141504)
print v(xbgr.mr_n70141936)
print v(xbgr.mr_n70142256)
print v(xbgr.mr_n70142368)
print v(xbgr.mr_n70142688)
print v(xbgr.mr_n70142800)
print v(xbgr.mr_n70143120)
print v(xbgr.mr_n70143232)
print v(xbgr.mr_n70143552)
print v(xbgr.mr_n70143664)
print v(xbgr.mr_n70148720)
print v(xbgr.mr_n70148832)
print v(xbgr.mr_n70149168)
print v(xbgr.mr_n70149280)
print v(xbgr.mr_n70149600)
print v(xbgr.mr_n70149712)
print v(xbgr.mr_n70150080)
print v(xbgr.mr_n70150192)
print v(xbgr.mr_n70150512)
print v(xbgr.mr_n70150624)
print v(xbgr.mr_n70150944)
print v(xbgr.mr_n70151056)
print v(xbgr.mr_n70151296)
print v(xbgr.mr_n70151408)
print v(xbgr.mr_n70151728)
print v(xbgr.mr_n70151840)
print v(xbgr.mr_n70152160)
print v(xbgr.mr_n70152272)
print v(xbgr.mr_n70152592)
print v(xbgr.mr_n70152704)
print v(xbgr.mr_n70153024)
print v(xbgr.mr_n70153136)
print v(xbgr.mr_n70153456)
print v(xbgr.mr_n70153568)
print v(xbgr.mr_n70153888)
print v(xbgr.mr_n70154000)
print v(xbgr.mr_n70154320)
print v(xbgr.mr_n70154432)
print v(xbgr.mr_n70154752)
print v(xbgr.mr_n70154864)
print v(xbgr.mr_n70155184)
print v(xbgr.mr_n70155296)
print v(xbgr.mr_n70155616)
print v(xbgr.mr_n70155728)
print v(xbgr.mr_n70156048)
print v(xbgr.mr_n70156160)
print v(xbgr.mr_n70156480)
print v(xbgr.mr_n70156592)
print v(xbgr.mr_n70156912)
print v(xbgr.mr_n70157024)
print v(xbgr.mr_n70157344)
print v(xbgr.mr_n70157456)
print v(xbgr.mr_n70157776)
print v(xbgr.mr_n70157888)
print v(xbgr.mr_n70158208)
print v(xbgr.mr_n70158320)
print v(xbgr.mr_n70158640)
print v(xbgr.mr_n70158752)
print v(xbgr.mr_n70159072)
print v(xbgr.mr_n70159184)
print v(xbgr.mr_n70159504)
print v(xbgr.mr_n70159616)
print v(xbgr.mr_n70159936)
print v(xbgr.mr_n70160048)
print v(xbgr.mr_n70160368)
print v(xbgr.mr_n70160480)
print v(xbgr.mr_n70160800)
print v(xbgr.mr_n70160912)
print v(xbgr.mr_n70161232)
print v(xbgr.mr_n70161344)
print v(xbgr.mr_n70161664)
print v(xbgr.mr_n70161776)
print v(xbgr.mr_n70162096)
print v(xbgr.mr_n70162208)
print v(xbgr.mr_n70162528)
print v(xbgr.mr_n70162640)
print v(xbgr.mr_n70162960)
print v(xbgr.mr_n70163072)
print v(xbgr.mr_n70163392)
print v(xbgr.mr_n70163504)
print v(xbgr.mr_n70163824)
print v(xbgr.mr_n70163936)
print v(xbgr.mr_n70164256)
print v(xbgr.mr_n70164368)
print v(xbgr.mr_n70164688)
print v(xbgr.mr_n70164800)
print v(xbgr.mr_n70165120)
print v(xbgr.mr_n70165232)
print v(xbgr.mr_n70165552)
print v(xbgr.mr_n70165664)
print v(xbgr.mr_n70165984)
print v(xbgr.mr_n70166096)
print v(xbgr.mr_n70166416)
print v(xbgr.mr_n70166528)
print v(xbgr.mr_n70166848)
print v(xbgr.mr_n70166960)
print v(xbgr.mr_n70167280)
print v(xbgr.mr_n70167392)
print v(xbgr.mr_n70167712)
print v(xbgr.mr_n70167824)
print v(xbgr.mr_n70168144)
print v(xbgr.mr_n70168256)
print v(xbgr.mr_n70168576)
print v(xbgr.mr_n70168688)
print v(xbgr.mr_n70169008)
print v(xbgr.mr_n70169120)
print v(xbgr.mr_n70169440)
print v(xbgr.mr_n70169552)
print v(xbgr.mr_n70169872)
print v(xbgr.mr_n70169984)
print v(xbgr.mr_n70170304)
print v(xbgr.mr_n70170416)
print v(xbgr.mr_n70170736)
print v(xbgr.mr_n70170848)
print v(xbgr.mr_n70171168)
print v(xbgr.mr_n70171280)
print v(xbgr.mr_n70171600)
print v(xbgr.mr_n70171712)
print v(xbgr.mr_n70172032)
print v(xbgr.mr_n70172144)
print v(xbgr.mr_n70172464)
print v(xbgr.mr_n70172576)
print v(xbgr.mr_n70172896)
print v(xbgr.mr_n70173008)
print v(xbgr.mr_n70173328)
print v(xbgr.mr_n70173440)
print v(xbgr.mr_n70173760)
print v(xbgr.mr_n70173872)
print v(xbgr.mr_n70174192)
print v(xbgr.mr_n70174304)
print v(xbgr.mr_n70174624)
print v(xbgr.mr_n70174736)
print v(xbgr.mr_n70175056)
print v(xbgr.mr_n70175168)
print v(xbgr.mr_n70175488)
print v(xbgr.mr_n70175600)
print v(xbgr.mr_n70175920)
print v(xbgr.mr_n70176032)
print v(xbgr.mr_n70176352)
print v(xbgr.mr_n70176464)
print v(xbgr.mr_n70176784)
print v(xbgr.mr_n70176896)
print v(xbgr.mr_n70177216)
print v(xbgr.mr_n70177328)
print v(xbgr.mr_n70177648)
print v(xbgr.mr_n70177760)
print v(xbgr.mr_n70178080)
print v(xbgr.mr_n70178192)
print v(xbgr.mr_n70178512)
print v(xbgr.mr_n70178624)
print v(xbgr.mr_n70178848)
print v(xbgr.mr_n70178960)
print v(xbgr.mr_n70179216)
print v(xbgr.mr_n70179328)
print v(xbgr.mr_n70179584)
print v(xbgr.mr_n70179696)
print v(xbgr.mr_n70179952)
print v(xbgr.mr_n70180064)
print v(xbgr.mr_n70180320)
print v(xbgr.mr_n70180432)
print v(xbgr.mr_n70180688)
print v(xbgr.mr_n70180800)
print v(xbgr.mr_n70181056)
print v(xbgr.mr_n70181168)
print v(xbgr.mr_n70181424)
print v(xbgr.mr_n70181536)
print v(xbgr.mr_n70181792)
print v(xbgr.mr_n70181904)
print v(xbgr.mr_n70182160)
print v(xbgr.mr_n70182272)
print v(xbgr.mr_n70182592)
print v(xbgr.mr_n70182704)
print v(xbgr.mr_n70183024)
print v(xbgr.mr_n70183136)
print v(xbgr.mr_n70183456)
print v(xbgr.mr_n70183568)
print v(xbgr.mr_n70183888)
print v(xbgr.mr_n70184000)
print v(xbgr.mr_n70184320)
print v(xbgr.mr_n70184432)
print v(xbgr.mr_n70184752)
print v(xbgr.mr_n70184864)
print v(xbgr.mr_n70185184)
print v(xbgr.mr_n70185296)
print v(xbgr.mr_n70185616)
print v(xbgr.mr_n70185728)
print v(xbgr.mr_n70186048)
print v(xbgr.mr_n70186160)
print v(xbgr.mr_n70186480)
print v(xbgr.mr_n70186592)
print v(xbgr.mr_n70186912)
print v(xbgr.mr_n70187024)
print v(xbgr.mr_n70187344)
print v(xbgr.mr_n70187456)
print v(xbgr.mr_n70187776)
print v(xbgr.mr_n70187888)
print v(xbgr.mr_n70188208)
print v(xbgr.mr_n70188320)
print v(xbgr.mr_n70188640)
print v(xbgr.mr_n70188752)
print v(xbgr.mr_n70189072)
print v(xbgr.mr_n70189184)
print v(xbgr.mr_n70189504)
print v(xbgr.mr_n70189616)
print v(xbgr.mr_n70189936)
print v(xbgr.mr_n70190048)
print v(xbgr.mr_n70190368)
print v(xbgr.mr_n70190480)
print v(xbgr.mr_n70190800)
print v(xbgr.mr_n70190912)
print v(xbgr.mr_n70191232)
print v(xbgr.mr_n70191344)
print v(xbgr.mr_n70191664)
print v(xbgr.mr_n70191776)
print v(xbgr.mr_n70192096)
print v(xbgr.mr_n70192208)
print v(xbgr.mr_n70192528)
print v(xbgr.mr_n70192640)
print v(xbgr.mr_n70192960)
print v(xbgr.mr_n70193072)
print v(xbgr.mr_n70193392)
print v(xbgr.mr_n70193504)
print v(xbgr.mr_n70193824)
print v(xbgr.mr_n70193936)
print v(xbgr.mr_n70194256)
print v(xbgr.mr_n70194368)
print v(xbgr.mr_n70194688)
print v(xbgr.mr_n70194800)
print v(xbgr.mr_n70195120)
print v(xbgr.mr_n70195232)
print v(xbgr.mr_n70195552)
print v(xbgr.mr_n70195664)
print v(xbgr.mr_n70195984)
print v(xbgr.mr_n70196096)
print v(xbgr.mr_n70196416)
print v(xbgr.mr_n70196528)
print v(xbgr.mr_n70196848)
print v(xbgr.mr_n70196960)
print v(xbgr.mr_n70197280)
print v(xbgr.mr_n70197392)
print v(xbgr.mr_n70197712)
print v(xbgr.mr_n70197824)
print v(xbgr.mr_n70198144)
print v(xbgr.mr_n70198256)
print v(xbgr.mr_n70198576)
print v(xbgr.mr_n70198688)
print v(xbgr.mr_n70199008)
print v(xbgr.mr_n70199120)
print v(xbgr.mr_n70199440)
print v(xbgr.mr_n70199552)
print v(xbgr.mr_n70199872)
print v(xbgr.mr_n70199984)
print v(xbgr.mr_n70200304)
print v(xbgr.mr_n70200416)
print v(xbgr.mr_n70200736)
print v(xbgr.mr_n70200848)
print v(xbgr.mr_n70201168)
print v(xbgr.mr_n70201280)
print v(xbgr.mr_n70201600)
print v(xbgr.mr_n70201712)
print v(xbgr.mr_n70202032)
print v(xbgr.mr_n70202144)
print v(xbgr.mr_n70202464)
print v(xbgr.mr_n70202576)
print v(xbgr.mr_n70202896)
print v(xbgr.mr_n70203008)
print v(xbgr.mr_n70203328)
print v(xbgr.mr_n70203440)
print v(xbgr.mr_n70203760)
print v(xbgr.mr_n70203872)
print v(xbgr.mr_n70204192)
print v(xbgr.mr_n70204304)
print v(xbgr.mr_n70204624)
print v(xbgr.mr_n70204736)
print v(xbgr.mr_n70205056)
print v(xbgr.mr_n70205168)
print v(xbgr.mr_n70205488)
print v(xbgr.mr_n70205600)
print v(xbgr.mr_n70205920)
print v(xbgr.mr_n70206032)
print v(xbgr.mr_n70206352)
print v(xbgr.mr_n70206464)
print v(xbgr.mr_n70206784)
print v(xbgr.mr_n70206896)
print v(xbgr.mr_n70207216)
print v(xbgr.mr_n70207328)
print v(xbgr.mr_n70207648)
print v(xbgr.mr_n70207760)
print v(xbgr.mr_n70208080)
print v(xbgr.mr_n70208192)
print v(xbgr.mr_n70208512)
print v(xbgr.mr_n70208624)
print v(xbgr.mr_n70208944)
print v(xbgr.mr_n70209056)
print v(xbgr.mr_n70209376)
print v(xbgr.mr_n70209488)
print v(xbgr.mr_n70209808)
print v(xbgr.mr_n70209920)
print v(xbgr.mr_n70210128)
print v(xbgr.mr_n70210240)
print v(xbgr.mr_n70210560)
print v(xbgr.mr_n70210672)
print v(xbgr.mr_n70210992)
print v(xbgr.mr_n70211104)
print v(xbgr.mr_n70211424)
print v(xbgr.mr_n70211536)
print v(xbgr.mr_n70211856)
print v(xbgr.mr_n70211968)
print v(xbgr.mr_n70212288)
print v(xbgr.mr_n70212400)
print v(xbgr.mr_n70212720)
print v(xbgr.mr_n70212832)
print v(xbgr.mr_n70213152)
print v(xbgr.mr_n70213264)
print v(xbgr.mr_n70213584)
print v(xbgr.mr_n70213696)
print v(xbgr.mr_n70214016)
print v(xbgr.mr_n70214128)
print v(xbgr.mr_n70214448)
print v(xbgr.mr_n70214560)
print v(xbgr.mr_n70214880)
print v(xbgr.mr_n70214992)
print v(xbgr.mr_n70215312)
print v(xbgr.mr_n70215424)
print v(xbgr.mr_n70215744)
print v(xbgr.mr_n70215856)
print v(xbgr.mr_n70216176)
print v(xbgr.mr_n70216288)
print v(xbgr.mr_n70216608)
print v(xbgr.mr_n70216720)
print v(xbgr.mr_n70217040)
print v(xbgr.mr_n70217152)
print v(xbgr.mr_n70217472)
print v(xbgr.mr_n70217584)
print v(xbgr.mr_n70217904)
print v(xbgr.mr_n70218016)
print v(xbgr.mr_n70218336)
print v(xbgr.mr_n70218448)
print v(xbgr.mr_n70218768)
print v(xbgr.mr_n70218880)
print v(xbgr.mr_n70219200)
print v(xbgr.mr_n70219312)
print v(xbgr.mr_n70219632)
print v(xbgr.mr_n70219744)
print v(xbgr.mr_n70220064)
print v(xbgr.mr_n70220176)
print v(xbgr.mr_n70220496)
print v(xbgr.mr_n70220608)
print v(xbgr.mr_n70220928)
print v(xbgr.mr_n70221040)
print v(xbgr.mr_n70221360)
print v(xbgr.mr_n70221472)
print v(xbgr.mr_n70221792)
print v(xbgr.mr_n70221904)
print v(xbgr.mr_n70222224)
print v(xbgr.mr_n70222336)
print v(xbgr.mr_n70222656)
print v(xbgr.mr_n70222768)
print v(xbgr.mr_n70223088)
print v(xbgr.mr_n70223200)
print v(xbgr.mr_n70223520)
print v(xbgr.mr_n70223632)
print v(xbgr.mr_n70223952)
print v(xbgr.mr_n70224064)
print v(xbgr.mr_n70224384)
print v(xbgr.mr_n70224496)
print v(xbgr.mr_n70224816)
print v(xbgr.mr_n70224928)
print v(xbgr.mr_n70225248)
print v(xbgr.mr_n70225360)
print v(xbgr.mr_n70225680)
print v(xbgr.mr_n70225792)
print v(xbgr.mr_n70226112)
print v(xbgr.mr_n70226224)
print v(xbgr.mr_n70226544)
print v(xbgr.mr_n70226656)
print v(xbgr.mr_n70226976)
print v(xbgr.mr_n70227088)
print v(xbgr.mr_n70227408)
print v(xbgr.mr_n70227520)
print v(xbgr.mr_n70227840)
print v(xbgr.mr_n70227952)
print v(xbgr.mr_n70228272)
print v(xbgr.mr_n70228384)
print v(xbgr.mr_n70228704)
print v(xbgr.mr_n70228816)
print v(xbgr.mr_n70229136)
print v(xbgr.mr_n70229248)
print v(xbgr.mr_n70229568)
print v(xbgr.mr_n70229680)
print v(xbgr.mr_n70230000)
print v(xbgr.mr_n70230112)
print v(xbgr.mr_n70230432)
print v(xbgr.mr_n70230544)
print v(xbgr.mr_n70230864)
print v(xbgr.mr_n70230976)
print v(xbgr.mr_n70231296)
print v(xbgr.mr_n70231408)
print v(xbgr.mr_n70231728)
print v(xbgr.mr_n70231840)
print v(xbgr.mr_n70232160)
print v(xbgr.mr_n70232272)
print v(xbgr.mr_n70232592)
print v(xbgr.mr_n70232704)
print v(xbgr.mr_n70233024)
print v(xbgr.mr_n70233136)
print v(xbgr.mr_n70233456)
print v(xbgr.mr_n70233568)
print v(xbgr.mr_n70233888)
print v(xbgr.mr_n70234000)
print v(xbgr.mr_n70234320)
print v(xbgr.mr_n70234432)
print v(xbgr.mr_n70234752)
print v(xbgr.mr_n70234864)
print v(xbgr.mr_n70235184)
print v(xbgr.mr_n70235296)
print v(xbgr.mr_n70235616)
print v(xbgr.mr_n70235728)
print v(xbgr.mr_n70236048)
print v(xbgr.mr_n70236160)
print v(xbgr.mr_n70236480)
print v(xbgr.mr_n70236592)
print v(xbgr.mr_n70236912)
print v(xbgr.mr_n70237024)
print v(xbgr.mr_n70237344)
print v(xbgr.mr_n70237456)
print v(xbgr.mr_n70237776)
print v(xbgr.mr_n70237888)
print v(xbgr.mr_n70238208)
print v(xbgr.mr_n70238320)
print v(xbgr.mr_n70238640)
print v(xbgr.mr_n70238752)
print v(xbgr.mr_n70239072)
print v(xbgr.mr_n70239184)
print v(xbgr.mr_n70239504)
print v(xbgr.mr_n70239616)
print v(xbgr.mr_n70239936)
print v(xbgr.mr_n70240048)
print v(xbgr.mr_n70240368)
print v(xbgr.mr_n70240480)
print v(xbgr.mr_n70240800)
print v(xbgr.mr_n70240912)
print v(xbgr.mr_n70241232)
print v(xbgr.mr_n70241344)
print v(xbgr.mr_n70241664)
print v(xbgr.mr_n70241776)
print v(xbgr.mr_n70242096)
print v(xbgr.mr_n70242208)
print v(xbgr.mr_n70242528)
print v(xbgr.mr_n70242640)
print v(xbgr.mr_n70242960)
print v(xbgr.mr_n70243072)
print v(xbgr.mr_n70243392)
print v(xbgr.mr_n70243504)
print v(xbgr.mr_n70243824)
print v(xbgr.mr_n70243936)
print v(xbgr.mr_n70244256)
print v(xbgr.mr_n70244368)
print v(xbgr.mr_n70244688)
print v(xbgr.mr_n70244800)
print v(xbgr.mr_n70245120)
print v(xbgr.mr_n70245232)
print v(xbgr.mr_n70245552)
print v(xbgr.mr_n70245664)
print v(xbgr.mr_n70245984)
print v(xbgr.mr_n70246096)
print v(xbgr.mr_n70246416)
print v(xbgr.mr_n70246528)
print v(xbgr.mr_n70246848)
print v(xbgr.mr_n70246960)
print v(xbgr.mr_n70247280)
print v(xbgr.mr_n70247392)
print v(xbgr.mr_n70247712)
print v(xbgr.mr_n70247824)
print v(xbgr.mr_n70248144)
print v(xbgr.mr_n70248256)
print v(xbgr.mr_n70248576)
print v(xbgr.mr_n70248688)
print v(xbgr.mr_n70249008)
print v(xbgr.mr_n70249120)
print v(xbgr.mr_n70249440)
print v(xbgr.mr_n70249552)
print v(xbgr.mr_n70249872)
print v(xbgr.mr_n70249984)
print v(xbgr.mr_n70250304)
print v(xbgr.mr_n70250416)
print v(xbgr.mr_n70250736)
print v(xbgr.mr_n70250848)
print v(xbgr.mr_n70251168)
print v(xbgr.mr_n70251280)
print v(xbgr.mr_n70251600)
print v(xbgr.mr_n70251712)
print v(xbgr.mr_n70252032)
print v(xbgr.mr_n70252144)
print v(xbgr.mr_n70252464)
print v(xbgr.mr_n70252576)
print v(xbgr.mr_n70252896)
print v(xbgr.mr_n70253008)
print v(xbgr.mr_n70253328)
print v(xbgr.mr_n70253440)
print v(xbgr.mr_n70253760)
print v(xbgr.mr_n70253872)
print v(xbgr.mr_n70254192)
print v(xbgr.mr_n70254304)
print v(xbgr.mr_n70254624)
print v(xbgr.mr_n70254736)
print v(xbgr.mr_n70255056)
print v(xbgr.mr_n70255168)
print v(xbgr.mr_n70255488)
print v(xbgr.mr_n70255600)
print v(xbgr.mr_n70255920)
print v(xbgr.mr_n70256032)
print v(xbgr.mr_n70256352)
print v(xbgr.mr_n70256464)
print v(xbgr.mr_n70256784)
print v(xbgr.mr_n70256896)
print v(xbgr.mr_n70257216)
print v(xbgr.mr_n70257328)
print v(xbgr.mr_n70257648)
print v(xbgr.mr_n70257760)
print v(xbgr.mr_n70258080)
print v(xbgr.mr_n70258192)
print v(xbgr.mr_n70258512)
print v(xbgr.mr_n70258624)
print v(xbgr.mr_n70258944)
print v(xbgr.mr_n70259056)
print v(xbgr.mr_n70259376)
print v(xbgr.mr_n70259488)
print v(xbgr.mr_n70259808)
print v(xbgr.mr_n70259920)
print v(xbgr.mr_n70260240)
print v(xbgr.mr_n70260352)
print v(xbgr.mr_n70260672)
print v(xbgr.mr_n70260784)
print v(xbgr.mr_n70261104)
print v(xbgr.mr_n70261216)
print v(xbgr.mr_n70261536)
print v(xbgr.mr_n70261648)
print v(xbgr.mr_n70261968)
print v(xbgr.mr_n70262080)
print v(xbgr.mr_n70262400)
print v(xbgr.mr_n70262512)
print v(xbgr.mr_n70262832)
print v(xbgr.mr_n70262944)
print v(xbgr.mr_n70263264)
print v(xbgr.mr_n70263376)
print v(xbgr.mr_n70263696)
print v(xbgr.mr_n70263808)
print v(xbgr.mr_n70264128)
print v(xbgr.mr_n70264240)
print v(xbgr.mr_n70264560)
print v(xbgr.mr_n70264672)
print v(xbgr.mr_n70264992)
print v(xbgr.mr_n70265104)
print v(xbgr.mr_n70265424)
print v(xbgr.mr_n70265536)
print v(xbgr.mr_n70265856)
print v(xbgr.mr_n70265968)
print v(xbgr.mr_n70266288)
print v(xbgr.mr_n70266400)
print v(xbgr.mr_n70266720)
print v(xbgr.mr_n70266832)
print v(xbgr.mr_n70267152)
print v(xbgr.mr_n70267264)
print v(xbgr.mr_n70267584)
print v(xbgr.mr_n70267696)
print v(xbgr.mr_n70268016)
print v(xbgr.mr_n70268128)
print v(xbgr.mr_n70268448)
print v(xbgr.mr_n70268560)
print v(xbgr.mr_n70268880)
print v(xbgr.mr_n70268992)
print v(xbgr.mr_n70269312)
print v(xbgr.mr_n70269424)
print v(xbgr.mr_n70269744)
print v(xbgr.mr_n70269856)
print v(xbgr.mr_n70270176)
print v(xbgr.mr_n70270288)
print v(xbgr.mr_n70270608)
print v(xbgr.mr_n70270720)
print v(xbgr.mr_n70271040)
print v(xbgr.mr_n70271152)
print v(xbgr.mr_n70271680)
print v(xbgr.mr_n70271792)
print v(xbgr.mr_n70272112)
print v(xbgr.mr_n70272224)
print v(xbgr.mr_n70272544)
print v(xbgr.mr_n70272656)
print v(xbgr.mr_n70272976)
print v(xbgr.mr_n70273088)
print v(xbgr.mr_n70273408)
print v(xbgr.mr_n70273520)
print v(xbgr.mr_n70273840)
print v(xbgr.mr_n70273952)
print v(xbgr.mr_n70274272)
print v(xbgr.mr_n70274384)
print v(xbgr.mr_n70274704)
print v(xbgr.mr_n70274816)
print v(xbgr.mr_n70275136)
print v(xbgr.mr_n70275248)
print v(xbgr.mr_n70275568)
print v(xbgr.mr_n70275680)
print v(xbgr.mr_n70276000)
print v(xbgr.mr_n70276112)
print v(xbgr.mr_n70276432)
print v(xbgr.mr_n70276544)
print v(xbgr.mr_n70276864)
print v(xbgr.mr_n70276976)
print v(xbgr.mr_n70277296)
print v(xbgr.mr_n70277408)
print v(xbgr.mr_n70277728)
print v(xbgr.mr_n70277840)
print v(xbgr.mr_n70278160)
print v(xbgr.mr_n70278272)
print v(xbgr.mr_n70278592)
print v(xbgr.mr_n70278704)
print v(xbgr.mr_n70279024)
print v(xbgr.mr_n70279136)
print v(xbgr.mr_n70279456)
print v(xbgr.mr_n70279568)
print v(xbgr.mr_n70279888)
print v(xbgr.mr_n70280000)
print v(xbgr.mr_n70280320)
print v(xbgr.mr_n70280432)
print v(xbgr.mr_n70280752)
print v(xbgr.mr_n70280864)
print v(xbgr.mr_n70281184)
print v(xbgr.mr_n70281296)
print v(xbgr.mr_n70281616)
print v(xbgr.mr_n70281728)
print v(xbgr.mr_n70282048)
print v(xbgr.mr_n70282160)
print v(xbgr.mr_n70282480)
print v(xbgr.mr_n70282592)
print v(xbgr.mr_n70282912)
print v(xbgr.mr_n70283024)
print v(xbgr.mr_n70283344)
print v(xbgr.mr_n70283456)
print v(xbgr.mr_n70283776)
print v(xbgr.mr_n70283888)
print v(xbgr.mr_n70284208)
print v(xbgr.mr_n70284320)
print v(xbgr.mr_n70284640)
print v(xbgr.mr_n70284752)
print v(xbgr.mr_n70285072)
print v(xbgr.mr_n70285184)
print v(xbgr.mr_n70285504)
print v(xbgr.mr_n70285616)
print v(xbgr.mr_n70285936)
print v(xbgr.mr_n70286048)
print v(xbgr.mr_n70286368)
print v(xbgr.mr_n70286480)
print v(xbgr.mr_n70286800)
print v(xbgr.mr_n70286912)
print v(xbgr.mr_n70287232)
print v(xbgr.mr_n70287344)
print v(xbgr.mr_n70287664)
print v(xbgr.mr_n70287776)
print v(xbgr.mr_n70288096)
print v(xbgr.mr_n70288208)
print v(xbgr.mr_n70288528)
print v(xbgr.mr_n70288640)
print v(xbgr.mr_n70288960)
print v(xbgr.mr_n70289072)
print v(xbgr.mr_n70289392)
print v(xbgr.mr_n70289504)
print v(xbgr.mr_n70289824)
print v(xbgr.mr_n70289936)
print v(xbgr.mr_n70290256)
print v(xbgr.mr_n70290368)
print v(xbgr.mr_n70290688)
print v(xbgr.mr_n70290800)
print v(xbgr.mr_n70291120)
print v(xbgr.mr_n70291232)
print v(xbgr.mr_n70291552)
print v(xbgr.mr_n70291664)
print v(xbgr.mr_n70291984)
print v(xbgr.mr_n70292096)
print v(xbgr.mr_n70292416)
print v(xbgr.mr_n70292528)
print v(xbgr.mr_n70292848)
print v(xbgr.mr_n70292960)
print v(xbgr.mr_n70293280)
print v(xbgr.mr_n70293392)
print v(xbgr.mr_n70293712)
print v(xbgr.mr_n70293824)
print v(xbgr.mr_n70294144)
print v(xbgr.mr_n70294256)
print v(xbgr.mr_n70294576)
print v(xbgr.mr_n70294688)
print v(xbgr.mr_n70295008)
print v(xbgr.mr_n70295120)
print v(xbgr.mr_n70295440)
print v(xbgr.mr_n70295552)
print v(xbgr.mr_n70295872)
print v(xbgr.mr_n70295984)
print v(xbgr.mr_n70296304)
print v(xbgr.mr_n70296416)
print v(xbgr.mr_n70296736)
print v(xbgr.mr_n70296848)
print v(xbgr.mr_n70297168)
print v(xbgr.mr_n70297280)
print v(xbgr.mr_n70297600)
print v(xbgr.mr_n70297712)
print v(xbgr.mr_n70298032)
print v(xbgr.mr_n70298144)
print v(xbgr.mr_n70298464)
print v(xbgr.mr_n70298576)
print v(xbgr.mr_n70298896)
print v(xbgr.mr_n70299008)
print v(xbgr.mr_n70299328)
print v(xbgr.mr_n70299440)
print v(xbgr.mr_n70299760)
print v(xbgr.mr_n70299872)
print v(xbgr.mr_n70300192)
print v(xbgr.mr_n70300304)
print v(xbgr.mr_n70300624)
print v(xbgr.mr_n70300736)
print v(xbgr.mr_n70301056)
print v(xbgr.mr_n70301168)
print v(xbgr.mr_n70301488)
print v(xbgr.mr_n70301600)
print v(xbgr.mr_n70301920)
print v(xbgr.mr_n70302032)
print v(xbgr.mr_n70302352)
print v(xbgr.mr_n70302464)
print v(xbgr.mr_n70302784)
print v(xbgr.mr_n70302896)
print v(xbgr.mr_n70303216)
print v(xbgr.mr_n70303328)
print v(xbgr.mr_n70303648)
print v(xbgr.mr_n70303760)
print v(xbgr.mr_n70304080)
print v(xbgr.mr_n70304192)
print v(xbgr.mr_n70304512)
print v(xbgr.mr_n70304624)
print v(xbgr.mr_n70304944)
print v(xbgr.mr_n70305056)
print v(xbgr.mr_n70305376)
print v(xbgr.mr_n70305488)
print v(xbgr.mr_n70305808)
print v(xbgr.mr_n70305920)
print v(xbgr.mr_n70306240)
print v(xbgr.mr_n70306352)
print v(xbgr.mr_n70306672)
print v(xbgr.mr_n70306784)
print v(xbgr.mr_n70307104)
print v(xbgr.mr_n70307216)
print v(xbgr.mr_n70307536)
print v(xbgr.mr_n70307648)
print v(xbgr.mr_n70307968)
print v(xbgr.mr_n70308080)
print v(xbgr.mr_n70308400)
print v(xbgr.mr_n70308512)
print v(xbgr.mr_n70308832)
print v(xbgr.mr_n70308944)
print v(xbgr.mr_n70309264)
print v(xbgr.mr_n70309376)
print v(xbgr.mr_n70309696)
print v(xbgr.mr_n70309808)
print v(xbgr.mr_n70310128)
print v(xbgr.mr_n70310240)
print v(xbgr.mr_n70310560)
print v(xbgr.mr_n70310672)
print v(xbgr.mr_n70310992)
print v(xbgr.mr_n70311104)
print v(xbgr.mr_n70573584)
print v(xbgr.mr_n70573824)
print v(xbgr.mr_n70573936)
print v(xbgr.mr_n70574256)
print v(xbgr.mr_n70574368)
print v(xbgr.mr_n70574688)
print v(xbgr.mr_n70574800)
print v(xbgr.mr_n70575120)
print v(xbgr.mr_n70575232)
print v(xbgr.mr_n70575552)
print v(xbgr.mr_n70575664)
print v(xbgr.mr_n70575984)
print v(xbgr.mr_n70576096)
print v(xbgr.mr_n70576416)
print v(xbgr.mr_n70576528)
print v(xbgr.mr_n70576848)
print v(xbgr.mr_n70576960)
print v(xbgr.mr_n70577280)
print v(xbgr.mr_n70577392)
print v(xbgr.mr_n70577712)
print v(xbgr.mr_n70577824)
print v(xbgr.mr_n70578144)
print v(xbgr.mr_n70578256)
print v(xbgr.mr_n70578576)
print v(xbgr.mr_n70578688)
print v(xbgr.mr_n70579008)
print v(xbgr.mr_n70579120)
print v(xbgr.mr_n70579440)
print v(xbgr.mr_n70579552)
print v(xbgr.mr_n70579872)
print v(xbgr.mr_n70579984)
print v(xbgr.mr_n70580304)
print v(xbgr.mr_n70580416)
print v(xbgr.mr_n70580736)
print v(xbgr.mr_n70580848)
print v(xbgr.mr_n70581168)
print v(xbgr.mr_n70581280)
print v(xbgr.mr_n70581600)
print v(xbgr.mr_n70581712)
print v(xbgr.mr_n70582032)
print v(xbgr.mr_n70582144)
print v(xbgr.mr_n70582464)
print v(xbgr.mr_n70582576)
print v(xbgr.mr_n70582896)
print v(xbgr.mr_n70583008)
print v(xbgr.mr_n70583328)
print v(xbgr.mr_n70583440)
print v(xbgr.mr_n70583760)
print v(xbgr.mr_n70583872)
print v(xbgr.mr_n70584192)
print v(xbgr.mr_n70584304)
print v(xbgr.mr_n70584624)
print v(xbgr.mr_n70584736)
print v(xbgr.mr_n70585056)
print v(xbgr.mr_n70585168)
print v(xbgr.mr_n70585488)
print v(xbgr.mr_n70585600)
print v(xbgr.mr_n70585920)
print v(xbgr.mr_n70586032)
print v(xbgr.mr_n70586352)
print v(xbgr.mr_n70586464)
print v(xbgr.mr_n70586784)
print v(xbgr.mr_n70586896)
print v(xbgr.mr_n70587216)
print v(xbgr.mr_n70587328)
print v(xbgr.mr_n70587648)
print v(xbgr.mr_n70587760)
print v(xbgr.mr_n70588080)
print v(xbgr.mr_n70588192)
print v(xbgr.mr_n70588512)
print v(xbgr.mr_n70588624)
print v(xbgr.mr_n70588944)
print v(xbgr.mr_n70589056)
print v(xbgr.mr_n70589376)
print v(xbgr.mr_n70589488)
print v(xbgr.mr_n70589808)
print v(xbgr.mr_n70589920)
print v(xbgr.mr_n70590240)
print v(xbgr.mr_n70590352)
print v(xbgr.mr_n70590672)
print v(xbgr.mr_n70590784)
print v(xbgr.mr_n70591104)
print v(xbgr.mr_n70591216)
print v(xbgr.mr_n70591536)
print v(xbgr.mr_n70591648)
print v(xbgr.mr_n70591968)
print v(xbgr.mr_n70592080)
print v(xbgr.mr_n70592400)
print v(xbgr.mr_n70592512)
print v(xbgr.mr_n70592832)
print v(xbgr.mr_n70592944)
print v(xbgr.mr_n70593264)
print v(xbgr.mr_n70593376)
print v(xbgr.mr_n70593696)
print v(xbgr.mr_n70593808)
print v(xbgr.mr_n70594128)
print v(xbgr.mr_n70594240)
print v(xbgr.mr_n70594560)
print v(xbgr.mr_n70594672)
print v(xbgr.mr_n70594992)
print v(xbgr.mr_n70595104)
print v(xbgr.mr_n70595424)
print v(xbgr.mr_n70595536)
print v(xbgr.mr_n70595856)
print v(xbgr.mr_n70595968)
print v(xbgr.mr_n70596288)
print v(xbgr.mr_n70596400)
print v(xbgr.mr_n70596720)
print v(xbgr.mr_n70596832)
print v(xbgr.mr_n70597152)
print v(xbgr.mr_n70597264)
print v(xbgr.mr_n70597584)
print v(xbgr.mr_n70597696)
print v(xbgr.mr_n70598016)
print v(xbgr.mr_n70598128)
print v(xbgr.mr_n70598448)
print v(xbgr.mr_n70598560)
print v(xbgr.mr_n70598880)
print v(xbgr.mr_n70598992)
print v(xbgr.mr_n70599312)
print v(xbgr.mr_n70599424)
print v(xbgr.mr_n70599744)
print v(xbgr.mr_n70599856)
print v(xbgr.mr_n70600176)
print v(xbgr.mr_n70600288)
print v(xbgr.mr_n70600608)
print v(xbgr.mr_n70600720)
print v(xbgr.mr_n70601040)
print v(xbgr.mr_n70601152)
print v(xbgr.mr_n70601472)
print v(xbgr.mr_n70601584)
print v(xbgr.mr_n70601904)
print v(xbgr.mr_n70602016)
print v(xbgr.mr_n70602336)
print v(xbgr.mr_n70602448)
print v(xbgr.mr_n70602768)
print v(xbgr.mr_n70602880)
print v(xbgr.mr_n70603200)
print v(xbgr.mr_n70603312)
print v(xbgr.mr_n70603632)
print v(xbgr.mr_n70603744)
print v(xbgr.mr_n70604064)
print v(xbgr.mr_n70604176)
print v(xbgr.mr_n70604496)
print v(xbgr.mr_n70604608)
print v(xbgr.mr_n70604928)
print v(xbgr.mr_n70605040)
print v(xbgr.mr_n70605360)
print v(xbgr.mr_n70605472)
print v(xbgr.mr_n70605792)
print v(xbgr.mr_n70605904)
print v(xbgr.mr_n70606224)
print v(xbgr.mr_n70606336)
print v(xbgr.mr_n70606656)
print v(xbgr.mr_n70606768)
print v(xbgr.mr_n70607088)
print v(xbgr.mr_n70607200)
print v(xbgr.mr_n70607520)
print v(xbgr.mr_n70607632)
print v(xbgr.mr_n70607952)
print v(xbgr.mr_n70608064)
print v(xbgr.mr_n70608384)
print v(xbgr.mr_n70608496)
print v(xbgr.mr_n70608816)
print v(xbgr.mr_n70608928)
print v(xbgr.mr_n70609248)
print v(xbgr.mr_n70609360)
print v(xbgr.mr_n70609680)
print v(xbgr.mr_n70609792)
print v(xbgr.mr_n70610112)
print v(xbgr.mr_n70610224)
print v(xbgr.mr_n70610544)
print v(xbgr.mr_n70610656)
print v(xbgr.mr_n70610976)
print v(xbgr.mr_n70611088)
print v(xbgr.mr_n70611408)
print v(xbgr.mr_n70611520)
print v(xbgr.mr_n70611840)
print v(xbgr.mr_n70611952)
print v(xbgr.mr_n70612272)
print v(xbgr.mr_n70612384)
print v(xbgr.mr_n70612704)
print v(xbgr.mr_n70612816)
print v(xbgr.mr_n70613136)
print v(xbgr.mr_n70613248)
print v(xbgr.mr_n70613568)
print v(xbgr.mr_n70613680)
print v(xbgr.mr_n70614000)
print v(xbgr.mr_n70614112)
print v(xbgr.mr_n70614432)
print v(xbgr.mr_n70614544)
print v(xbgr.mr_n70614864)
print v(xbgr.mr_n70614976)
print v(xbgr.mr_n70615296)
print v(xbgr.mr_n70615408)
print v(xbgr.mr_n70615728)
print v(xbgr.mr_n70615840)
print v(xbgr.mr_n70616160)
print v(xbgr.mr_n70616272)
print v(xbgr.mr_n70616592)
print v(xbgr.mr_n70616704)
print v(xbgr.mr_n70617024)
print v(xbgr.mr_n70617136)
print v(xbgr.mr_n70617456)
print v(xbgr.mr_n70617568)
print v(xbgr.mr_n70617888)
print v(xbgr.mr_n70618000)
print v(xbgr.mr_n70618320)
print v(xbgr.mr_n70618432)
print v(xbgr.mr_n70618752)
print v(xbgr.mr_n70618864)
print v(xbgr.mr_n70619184)
print v(xbgr.mr_n70619296)
print v(xbgr.mr_n70619616)
print v(xbgr.mr_n70619728)
print v(xbgr.mr_n70620048)
print v(xbgr.mr_n70620160)
print v(xbgr.mr_n70620480)
print v(xbgr.mr_n70620592)
print v(xbgr.mr_n70620912)
print v(xbgr.mr_n70621024)
print v(xbgr.mr_n70621344)
print v(xbgr.mr_n70621456)
print v(xbgr.mr_n70621776)
print v(xbgr.mr_n70621888)
print v(xbgr.mr_n70622208)
print v(xbgr.mr_n70622320)
print v(xbgr.mr_n70622640)
print v(xbgr.mr_n70622752)
print v(xbgr.mr_n70623072)
print v(xbgr.mr_n70623184)
print v(xbgr.mr_n70623504)
print v(xbgr.mr_n70623616)
print v(xbgr.mr_n70623936)
print v(xbgr.mr_n70624048)
print v(xbgr.mr_n70624368)
print v(xbgr.mr_n70624480)
print v(xbgr.mr_n70624800)
print v(xbgr.mr_n70624912)
print v(xbgr.mr_n70625232)
print v(xbgr.mr_n70625344)
print v(xbgr.mr_n70625664)
print v(xbgr.mr_n70625776)
print v(xbgr.mr_n70626096)
print v(xbgr.mr_n70626208)
print v(xbgr.mr_n70626528)
print v(xbgr.mr_n70626640)
print v(xbgr.mr_n70626960)
print v(xbgr.mr_n70627072)
print v(xbgr.mr_n70627392)
print v(xbgr.mr_n70627504)
print v(xbgr.mr_n70627824)
print v(xbgr.mr_n70627936)
print v(xbgr.mr_n70628256)
print v(xbgr.mr_n70628368)
print v(xbgr.mr_n70628688)
print v(xbgr.mr_n70628800)
print v(xbgr.mr_n70629120)
print v(xbgr.mr_n70629232)
print v(xbgr.mr_n70629552)
print v(xbgr.mr_n70629664)
print v(xbgr.mr_n70629984)
print v(xbgr.mr_n70630096)
print v(xbgr.mr_n70630416)
print v(xbgr.mr_n70630528)
print v(xbgr.mr_n70630848)
print v(xbgr.mr_n70630960)
print v(xbgr.mr_n70631280)
print v(xbgr.mr_n70631392)
print v(xbgr.mr_n70631712)
print v(xbgr.mr_n70631824)
print v(xbgr.mr_n70632144)
print v(xbgr.mr_n70632256)
print v(xbgr.mr_n70632576)
print v(xbgr.mr_n70632688)
print v(xbgr.mr_n70633008)
print v(xbgr.mr_n70633120)
print v(xbgr.mr_n70633440)
print v(xbgr.mr_n70633552)
print v(xbgr.mr_n70633872)
print v(xbgr.mr_n70633984)
print v(xbgr.mr_n70634304)
print v(xbgr.mr_n70634416)
print v(xbgr.mr_n70634736)
print v(xbgr.mr_n70634848)
print v(xbgr.mr_n70635168)
print v(xbgr.mr_n70635280)
print v(xbgr.mr_n70635600)
print v(xbgr.mr_n70635712)
print v(xbgr.mr_n70636032)
print v(xbgr.mr_n70636144)
print v(xbgr.mr_n70636464)
print v(xbgr.mr_n70636576)
print v(xbgr.mr_n70636896)
print v(xbgr.mr_n70637008)
print v(xbgr.mr_n70637328)
print v(xbgr.mr_n70637440)
print v(xbgr.mr_n70637760)
print v(xbgr.mr_n70637872)
print v(xbgr.mr_n70638192)
print v(xbgr.mr_n70638304)
print v(xbgr.mr_n70638624)
print v(xbgr.mr_n70638736)
print v(xbgr.mr_n70639056)
print v(xbgr.mr_n70639168)
print v(xbgr.mr_n70639488)
print v(xbgr.mr_n70639600)
print v(xbgr.mr_n70639920)
print v(xbgr.mr_n70640032)
print v(xbgr.mr_n70640352)
print v(xbgr.mr_n70640464)
print v(xbgr.mr_n70640784)
print v(xbgr.mr_n70640896)
print v(xbgr.mr_n70641216)
print v(xbgr.mr_n70641328)
print v(xbgr.mr_n70641648)
print v(xbgr.mr_n70641760)
print v(xbgr.mr_n70642080)
print v(xbgr.mr_n70642192)
print v(xbgr.mr_n70642512)
print v(xbgr.mr_n70642624)
print v(xbgr.mr_n70642944)
print v(xbgr.mr_n70643056)
print v(xbgr.mr_n70643376)
print v(xbgr.mr_n70643488)
print v(xbgr.mr_n70643808)
print v(xbgr.mr_n70643920)
print v(xbgr.mr_n70644240)
print v(xbgr.mr_n70644352)
print v(xbgr.mr_n70644672)
print v(xbgr.mr_n70644784)
print v(xbgr.mr_n70645104)
print v(xbgr.mr_n70645216)
print v(xbgr.mr_n70645536)
print v(xbgr.mr_n70645648)
print v(xbgr.mr_n70645968)
print v(xbgr.mr_n70646080)
print v(xbgr.mr_n70646400)
print v(xbgr.mr_n70646512)
print v(xbgr.mr_n70646832)
print v(xbgr.mr_n70646944)
print v(xbgr.mr_n70647264)
print v(xbgr.mr_n70647376)
print v(xbgr.mr_n70647696)
print v(xbgr.mr_n70647808)
print v(xbgr.mr_n70648128)
print v(xbgr.mr_n70648240)
print v(xbgr.mr_n70648560)
print v(xbgr.mr_n70648672)
print v(xbgr.mr_n70648992)
print v(xbgr.mr_n70649104)
print v(xbgr.mr_n70649424)
print v(xbgr.mr_n70649536)
print v(xbgr.mr_n70649856)
print v(xbgr.mr_n70649968)
print v(xbgr.mr_n70650288)
print v(xbgr.mr_n70650400)
print v(xbgr.mr_n70650720)
print v(xbgr.mr_n70650832)
print v(xbgr.mr_n70651152)
print v(xbgr.mr_n70651264)
print v(xbgr.mr_n70651584)
print v(xbgr.mr_n70651696)
print v(xbgr.mr_n70652016)
print v(xbgr.mr_n70652128)
print v(xbgr.mr_n70652448)
print v(xbgr.mr_n70652560)
print v(xbgr.mr_n70652880)
print v(xbgr.mr_n70652992)
print v(xbgr.mr_n70653312)
print v(xbgr.mr_n70653424)
print v(xbgr.mr_n70653744)
print v(xbgr.mr_n70653856)
print v(xbgr.mr_n70654176)
print v(xbgr.mr_n70654288)
print v(xbgr.mr_n70654608)
print v(xbgr.mr_n70654720)
print v(xbgr.mr_n70655040)
print v(xbgr.mr_n70655152)
print v(xbgr.mr_n70655472)
print v(xbgr.mr_n70655584)
print v(xbgr.mr_n70655904)
print v(xbgr.mr_n70656016)
print v(xbgr.mr_n70656336)
print v(xbgr.mr_n70656448)
print v(xbgr.mr_n70656768)
print v(xbgr.mr_n70656880)
print v(xbgr.mr_n70657200)
print v(xbgr.mr_n70657312)
print v(xbgr.mr_n70657632)
print v(xbgr.mr_n70657744)
print v(xbgr.mr_n70658064)
print v(xbgr.mr_n70658176)
print v(xbgr.mr_n70658496)
print v(xbgr.mr_n70658608)
print v(xbgr.mr_n70658928)
print v(xbgr.mr_n70659040)
print v(xbgr.mr_n70659360)
print v(xbgr.mr_n70659472)
print v(xbgr.mr_n70659792)
print v(xbgr.mr_n70659904)
print v(xbgr.mr_n70660224)
print v(xbgr.mr_n70660336)
print v(xbgr.mr_n70660656)
print v(xbgr.mr_n70660768)
print v(xbgr.mr_n70661088)
print v(xbgr.mr_n70661200)
print v(xbgr.mr_n70661520)
print v(xbgr.mr_n70661632)
print v(xbgr.mr_n70661952)
print v(xbgr.mr_n70662064)
print v(xbgr.mr_n70662384)
print v(xbgr.mr_n70662496)
print v(xbgr.mr_n70662816)
print v(xbgr.mr_n70662928)
print v(xbgr.mr_n70663248)
print v(xbgr.mr_n70663360)
print v(xbgr.mr_n70663680)
print v(xbgr.mr_n70663792)
print v(xbgr.mr_n70664112)
print v(xbgr.mr_n70664224)
print v(xbgr.mr_n70664544)
print v(xbgr.mr_n70664656)
print v(xbgr.mr_n70664976)
print v(xbgr.mr_n70665088)
print v(xbgr.mr_n70665408)
print v(xbgr.mr_n70665520)
print v(xbgr.mr_n70665840)
print v(xbgr.mr_n70665952)
print v(xbgr.mr_n70666272)
print v(xbgr.mr_n70666384)
print v(xbgr.mr_n70666704)
print v(xbgr.mr_n70666816)
print v(xbgr.mr_n70667136)
print v(xbgr.mr_n70667248)
print v(xbgr.mr_n70667568)
print v(xbgr.mr_n70667680)
print v(xbgr.mr_n70668000)
print v(xbgr.mr_n70668112)
print v(xbgr.mr_n70668432)
print v(xbgr.mr_n70668544)
print v(xbgr.mr_n70668864)
print v(xbgr.mr_n70668976)
print v(xbgr.mr_n70669296)
print v(xbgr.mr_n70669408)
print v(xbgr.mr_n70669728)
print v(xbgr.mr_n70669840)
print v(xbgr.mr_n70670160)
print v(xbgr.mr_n70670272)
print v(xbgr.mr_n70670592)
print v(xbgr.mr_n70670704)
print v(xbgr.mr_n70671024)
print v(xbgr.mr_n70671136)
print v(xbgr.mr_n70671456)
print v(xbgr.mr_n70671568)
print v(xbgr.mr_n70671888)
print v(xbgr.mr_n70672000)
print v(xbgr.mr_n70672320)
print v(xbgr.mr_n70672432)
print v(xbgr.mr_n70672752)
print v(xbgr.mr_n70672864)
print v(xbgr.mr_n70673184)
print v(xbgr.mr_n70673296)
print v(xbgr.mr_n70673616)
print v(xbgr.mr_n70673728)
print v(xbgr.mr_n70674048)
print v(xbgr.mr_n70674160)
print v(xbgr.mr_n70674480)
print v(xbgr.mr_n70674592)
print v(xbgr.mr_n70674912)
print v(xbgr.mr_n70675024)
print v(xbgr.mr_n70675344)
print v(xbgr.mr_n70675456)
print v(xbgr.mr_n70675776)
print v(xbgr.mr_n70675888)
print v(xbgr.mr_n70676208)
print v(xbgr.mr_n70676320)
print v(xbgr.mr_n70676640)
print v(xbgr.mr_n70676752)
print v(xbgr.mr_n70677072)
print v(xbgr.mr_n70677184)
print v(xbgr.mr_n70677504)
print v(xbgr.mr_n70677616)
print v(xbgr.mr_n70677936)
print v(xbgr.mr_n70678048)
print v(xbgr.mr_n70678368)
print v(xbgr.mr_n70678480)
print v(xbgr.mr_n70678800)
print v(xbgr.mr_n70678912)
print v(xbgr.mr_n70679232)
print v(xbgr.mr_n70679344)
print v(xbgr.mr_n70679664)
print v(xbgr.mr_n70679776)
print v(xbgr.mr_n70680096)
print v(xbgr.mr_n70680208)
print v(xbgr.mr_n70680528)
print v(xbgr.mr_n70680640)
print v(xbgr.mr_n70680960)
print v(xbgr.mr_n70681072)
print v(xbgr.mr_n70681392)
print v(xbgr.mr_n70681504)
print v(xbgr.mr_n70681824)
print v(xbgr.mr_n70681936)
print v(xbgr.mr_n70682256)
print v(xbgr.mr_n70682368)
print v(xbgr.mr_n70682688)
print v(xbgr.mr_n70682800)
print v(xbgr.mr_n70683120)
print v(xbgr.mr_n70683232)
print v(xbgr.mr_n70683552)
print v(xbgr.mr_n70683664)
print v(xbgr.mr_n70683984)
print v(xbgr.mr_n70684096)
print v(xbgr.mr_n70684416)
print v(xbgr.mr_n70684528)
print v(xbgr.mr_n70684848)
print v(xbgr.mr_n70684960)
print v(xbgr.mr_n70685280)
print v(xbgr.mr_n70685392)
print v(xbgr.mr_n70685712)
print v(xbgr.mr_n70685824)
print v(xbgr.mr_n70686144)
print v(xbgr.mr_n70686256)
print v(xbgr.mr_n70686576)
print v(xbgr.mr_n70686688)
print v(xbgr.mr_n70687008)
print v(xbgr.mr_n70687120)
print v(xbgr.mr_n70687440)
print v(xbgr.mr_n70687552)
print v(xbgr.mr_n70687872)
print v(xbgr.mr_n70687984)
print v(xbgr.mr_n70688304)
print v(xbgr.mr_n70688416)
print v(xbgr.mr_n70688736)
print v(xbgr.mr_n70688848)
print v(xbgr.mr_n70689168)
print v(xbgr.mr_n70689280)
print v(xbgr.mr_n70689600)
print v(xbgr.mr_n70689712)
print v(xbgr.mr_n70690032)
print v(xbgr.mr_n70690144)
print v(xbgr.mr_n70690464)
print v(xbgr.mr_n70690576)
print v(xbgr.mr_n70690896)
print v(xbgr.mr_n70691008)
print v(xbgr.mr_n70691328)
print v(xbgr.mr_n70691440)
print v(xbgr.mr_n70691760)
print v(xbgr.mr_n70691872)
print v(xbgr.mr_n70692192)
print v(xbgr.mr_n70692304)
print v(xbgr.mr_n70692624)
print v(xbgr.mr_n70692736)
print v(xbgr.mr_n70693056)
print v(xbgr.mr_n70693168)
print v(xbgr.mr_n70693488)
print v(xbgr.mr_n70693600)
print v(xbgr.mr_n70693920)
print v(xbgr.mr_n70694032)
print v(xbgr.mr_n70694352)
print v(xbgr.mr_n70694464)
print v(xbgr.mr_n70694784)
print v(xbgr.mr_n70694896)
print v(xbgr.mr_n70695216)
print v(xbgr.mr_n70695328)
print v(xbgr.mr_n70695648)
print v(xbgr.mr_n70695760)
print v(xbgr.mr_n70696080)
print v(xbgr.mr_n70696192)
print v(xbgr.mr_n70696512)
print v(xbgr.mr_n70696624)
print v(xbgr.mr_n70696944)
print v(xbgr.mr_n70697056)
print v(xbgr.mr_n70697376)
print v(xbgr.mr_n70697488)
print v(xbgr.mr_n70697808)
print v(xbgr.mr_n70697920)
print v(xbgr.mr_n70698240)
print v(xbgr.mr_n70698352)
print v(xbgr.mr_n70698672)
print v(xbgr.mr_n70698784)
print v(xbgr.mr_n70699104)
print v(xbgr.mr_n70699216)
print v(xbgr.mr_n70699536)
print v(xbgr.mr_n70699648)
print v(xbgr.mr_n70699968)
print v(xbgr.mr_n70700080)
print v(xbgr.mr_n70700400)
print v(xbgr.mr_n70700512)
print v(xbgr.mr_n70700832)
print v(xbgr.mr_n70700944)
print v(xbgr.mr_n70701264)
print v(xbgr.mr_n70701376)
print v(xbgr.mr_n70701696)
print v(xbgr.mr_n70701808)
print v(xbgr.mr_n70702128)
print v(xbgr.mr_n70702240)
print v(xbgr.mr_n70702560)
print v(xbgr.mr_n70702672)
print v(xbgr.mr_n70702992)
print v(xbgr.mr_n70703104)
print v(xbgr.mr_n70703424)
print v(xbgr.mr_n70703536)
print v(xbgr.mr_n70703856)
print v(xbgr.mr_n70703968)
print v(xbgr.mr_n70704288)
print v(xbgr.mr_n70704400)
print v(xbgr.mr_n70704720)
print v(xbgr.mr_n70704832)
print v(xbgr.mr_n70705152)
print v(xbgr.mr_n70705264)
print v(xbgr.mr_n70705584)
print v(xbgr.mr_n70705696)
print v(xbgr.mr_n70706016)
print v(xbgr.mr_n70706128)
print v(xbgr.mr_n70706448)
print v(xbgr.mr_n70706560)
print v(xbgr.mr_n70706880)
print v(xbgr.mr_n70706992)
print v(xbgr.mr_n70707312)
print v(xbgr.mr_n70707424)
print v(xbgr.mr_n70707744)
print v(xbgr.mr_n70707856)
print v(xbgr.mr_n70708176)
print v(xbgr.mr_n70708288)
print v(xbgr.mr_n70708608)
print v(xbgr.mr_n70708720)
print v(xbgr.mr_n70709040)
print v(xbgr.mr_n70709152)
print v(xbgr.mr_n70709472)
print v(xbgr.mr_n70709584)
print v(xbgr.mr_n70709904)
print v(xbgr.mr_n70710016)
print v(xbgr.mr_n70710336)
print v(xbgr.mr_n70710448)
print v(xbgr.mr_n70710768)
print v(xbgr.mr_n70710880)
print v(xbgr.mr_n70711200)
print v(xbgr.mr_n70711312)
print v(xbgr.mr_n70711632)
print v(xbgr.mr_n70711744)
print v(xbgr.mr_n70712064)
print v(xbgr.mr_n70712176)
print v(xbgr.mr_n70712496)
print v(xbgr.mr_n70712608)
print v(xbgr.mr_n70712928)
print v(xbgr.mr_n70713040)
print v(xbgr.mr_n70713360)
print v(xbgr.mr_n70713472)
print v(xbgr.mr_n70713792)
print v(xbgr.mr_n70713904)
print v(xbgr.mr_n70714224)
print v(xbgr.mr_n70714336)
print v(xbgr.mr_n70714656)
print v(xbgr.mr_n70714768)
print v(xbgr.mr_n70715088)
print v(xbgr.mr_n70715200)
print v(xbgr.mr_n70715520)
print v(xbgr.mr_n70715632)
print v(xbgr.mr_n70715952)
print v(xbgr.mr_n70716064)
print v(xbgr.mr_n70716384)
print v(xbgr.mr_n70716496)
print v(xbgr.mr_n70716816)
print v(xbgr.mr_n70716928)
print v(xbgr.mr_n70717248)
print v(xbgr.mr_n70717360)
print v(xbgr.mr_n70717680)
print v(xbgr.mr_n70717792)
print v(xbgr.mr_n70718112)
print v(xbgr.mr_n70718224)
print v(xbgr.mr_n70718544)
print v(xbgr.mr_n70718656)
print v(xbgr.mr_n70718976)
print v(xbgr.mr_n70719088)
print v(xbgr.mr_n70719408)
print v(xbgr.mr_n70719520)
print v(xbgr.mr_n70719840)
print v(xbgr.mr_n70719952)
print v(xbgr.mr_n70720272)
print v(xbgr.mr_n70720384)
print v(xbgr.mr_n70720704)
print v(xbgr.mr_n70720816)
print v(xbgr.mr_n70721136)
print v(xbgr.mr_n70721248)
print v(xbgr.mr_n70721568)
print v(xbgr.mr_n70721680)
print v(xbgr.mr_n70722000)
print v(xbgr.mr_n70722112)
print v(xbgr.mr_n70722432)
print v(xbgr.mr_n70722544)
print v(xbgr.mr_n70722864)
print v(xbgr.mr_n70722976)
print v(xbgr.mr_n70723296)
print v(xbgr.mr_n70723408)
print v(xbgr.mr_n70723728)
print v(xbgr.mr_n70723840)
print v(xbgr.mr_n70724160)
print v(xbgr.mr_n70724272)
print v(xbgr.mr_n70724592)
print v(xbgr.mr_n70724704)
print v(xbgr.mr_n70725024)
print v(xbgr.mr_n70725136)
print v(xbgr.mr_n70725456)
print v(xbgr.mr_n70725568)
print v(xbgr.mr_n70725888)
print v(xbgr.mr_n70726000)
print v(xbgr.mr_n70726320)
print v(xbgr.mr_n70726432)
print v(xbgr.mr_n70726752)
print v(xbgr.mr_n70726864)
print v(xbgr.mr_n70727184)
print v(xbgr.mr_n70727296)
print v(xbgr.mr_n70727616)
print v(xbgr.mr_n70727728)
print v(xbgr.mr_n70728048)
print v(xbgr.mr_n70728160)
print v(xbgr.mr_n70728480)
print v(xbgr.mr_n70728592)
print v(xbgr.mr_n70728912)
print v(xbgr.mr_n70729024)
print v(xbgr.mr_n70729344)
print v(xbgr.mr_n70729456)
print v(xbgr.mr_n70729776)
print v(xbgr.mr_n70729888)
print v(xbgr.mr_n70730208)
print v(xbgr.mr_n70730320)
print v(xbgr.mr_n70730640)
print v(xbgr.mr_n70730752)
print v(xbgr.mr_n70731072)
print v(xbgr.mr_n70731184)
print v(xbgr.mr_n70731504)
print v(xbgr.mr_n70731616)
print v(xbgr.mr_n70731936)
print v(xbgr.mr_n70732048)
print v(xbgr.mr_n70732368)
print v(xbgr.mr_n70732480)
print v(xbgr.mr_n70732800)
print v(xbgr.mr_n70732912)
print v(xbgr.mr_n70733232)
print v(xbgr.mr_n70733344)
print v(xbgr.mr_n70733664)
print v(xbgr.mr_n70733776)
print v(xbgr.mr_n70734096)
print v(xbgr.mr_n70734208)
print v(xbgr.mr_n70734528)
print v(xbgr.mr_n70734640)
print v(xbgr.mr_n70734960)
print v(xbgr.mr_n70735072)
print v(xbgr.mr_n70735392)
print v(xbgr.mr_n70735504)
print v(xbgr.mr_n70735824)
print v(xbgr.mr_n70735936)
print v(xbgr.mr_n70736256)
print v(xbgr.mr_n70736368)
print v(xbgr.mr_n70736688)
print v(xbgr.mr_n70736800)
print v(xbgr.mr_n70737120)
print v(xbgr.mr_n70737232)
print v(xbgr.mr_n70737552)
print v(xbgr.mr_n70737664)
print v(xbgr.mr_n70737984)
print v(xbgr.mr_n70738096)
print v(xbgr.mr_n70738416)
print v(xbgr.mr_n70738528)
print v(xbgr.mr_n70738848)
print v(xbgr.mr_n70738960)
print v(xbgr.mr_n70739280)
print v(xbgr.mr_n70739392)
print v(xbgr.mr_n70739712)
print v(xbgr.mr_n70739824)
print v(xbgr.mr_n70740144)
print v(xbgr.mr_n70740256)
print v(xbgr.mr_n70740576)
print v(xbgr.mr_n70740688)
print v(xbgr.mr_n70741008)
print v(xbgr.mr_n70741120)
print v(xbgr.mr_n70741440)
print v(xbgr.mr_n70741552)
print v(xbgr.mr_n70741872)
print v(xbgr.mr_n70741984)
print v(xbgr.mr_n70742304)
print v(xbgr.mr_n70742416)
print v(xbgr.mr_n70742736)
print v(xbgr.mr_n70742848)
print v(xbgr.mr_n70743168)
print v(xbgr.mr_n70743280)
print v(xbgr.mr_n70743600)
print v(xbgr.mr_n70743712)
print v(xbgr.mr_n70744032)
print v(xbgr.mr_n70744144)
print v(xbgr.mr_n70744464)
print v(xbgr.mr_n70744576)
print v(xbgr.mr_n70744896)
print v(xbgr.mr_n70745008)
print v(xbgr.mr_n70745328)
print v(xbgr.mr_n70745440)
print v(xbgr.mr_n70745760)
print v(xbgr.mr_n70745872)
print v(xbgr.mr_n70746192)
print v(xbgr.mr_n70746304)
print v(xbgr.mr_n70746624)
print v(xbgr.mr_n70746736)
print v(xbgr.mr_n70747056)
print v(xbgr.mr_n70747168)
print v(xbgr.mr_n70747488)
print v(xbgr.mr_n70747600)
print v(xbgr.mr_n70747920)
print v(xbgr.mr_n70748032)
print v(xbgr.mr_n70748352)
print v(xbgr.mr_n70748464)
print v(xbgr.mr_n70748784)
print v(xbgr.mr_n70748896)
print v(xbgr.mr_n70749216)
print v(xbgr.mr_n70749328)
print v(xbgr.mr_n70749648)
print v(xbgr.mr_n70749760)
print v(xbgr.mr_n70750080)
print v(xbgr.mr_n70750192)
print v(xbgr.mr_n70750512)
print v(xbgr.mr_n70750624)
print v(xbgr.mr_n70750944)
print v(xbgr.mr_n70751056)
print v(xbgr.mr_n70751376)
print v(xbgr.mr_n70751488)
print v(xbgr.mr_n70751808)
print v(xbgr.mr_n70751920)
print v(xbgr.mr_n70752240)
print v(xbgr.mr_n70752352)
print v(xbgr.mr_n70752672)
print v(xbgr.mr_n70752784)
print v(xbgr.mr_n70753104)
print v(xbgr.mr_n70753216)
print v(xbgr.mr_n70753536)
print v(xbgr.mr_n70753648)
print v(xbgr.mr_n70753968)
print v(xbgr.mr_n70754080)
print v(xbgr.mr_n70754400)
print v(xbgr.mr_n70754512)
print v(xbgr.mr_n70754832)
print v(xbgr.mr_n70754944)
print v(xbgr.mr_n70755264)
print v(xbgr.mr_n70755376)
print v(xbgr.mr_n70755696)
print v(xbgr.mr_n70755808)
print v(xbgr.mr_n70756128)
print v(xbgr.mr_n70756240)
print v(xbgr.mr_n70756560)
print v(xbgr.mr_n70756672)
print v(xbgr.mr_n70756992)
print v(xbgr.mr_n70757104)
print v(xbgr.mr_n70757424)
print v(xbgr.mr_n70757536)
print v(xbgr.mr_n70757856)
print v(xbgr.mr_n70757968)
print v(xbgr.mr_n70758288)
print v(xbgr.mr_n70758400)
print v(xbgr.mr_n70758720)
print v(xbgr.mr_n70758832)
print v(xbgr.mr_n70759152)
print v(xbgr.mr_n70759264)
print v(xbgr.mr_n70759584)
print v(xbgr.mr_n70759696)
print v(xbgr.mr_n70760016)
print v(xbgr.mr_n70760128)
print v(xbgr.mr_n70760448)
print v(xbgr.mr_n70760560)
print v(xbgr.mr_n70760880)
print v(xbgr.mr_n70760992)
print v(xbgr.mr_n70761312)
print v(xbgr.mr_n70761424)
print v(xbgr.mr_n70761744)
print v(xbgr.mr_n70761856)
print v(xbgr.mr_n70762176)
print v(xbgr.mr_n70762288)
print v(xbgr.mr_n70762608)
print v(xbgr.mr_n70762720)
print v(xbgr.mr_n70763040)
print v(xbgr.mr_n70763152)
print v(xbgr.mr_n70763472)
print v(xbgr.mr_n70763584)
print v(xbgr.mr_n70763904)
print v(xbgr.mr_n70764016)
print v(xbgr.mr_n70764336)
print v(xbgr.mr_n70764448)
print v(xbgr.mr_n70764768)
print v(xbgr.mr_n70764880)
print v(xbgr.mr_n70765200)
print v(xbgr.mr_n70765312)
print v(xbgr.mr_n70765632)
print v(xbgr.mr_n70765744)
print v(xbgr.mr_n70766064)
print v(xbgr.mr_n70766176)
print v(xbgr.mr_n70766496)
print v(xbgr.mr_n70766608)
print v(xbgr.mr_n70766928)
print v(xbgr.mr_n70767040)
print v(xbgr.mr_n70767360)
print v(xbgr.mr_n70767472)
print v(xbgr.mr_n70767792)
print v(xbgr.mr_n70767904)
print v(xbgr.mr_n70768224)
print v(xbgr.mr_n70768336)
print v(xbgr.mr_n70768656)
print v(xbgr.mr_n70768768)
print v(xbgr.mr_n70769088)
print v(xbgr.mr_n70769200)
print v(xbgr.mr_n70769520)
print v(xbgr.mr_n70769632)
print v(xbgr.mr_n70769952)
print v(xbgr.mr_n70770064)
print v(xbgr.mr_n70770384)
print v(xbgr.mr_n70770496)
print v(xbgr.mr_n70770816)
print v(xbgr.mr_n70770928)
print v(xbgr.mr_n70771232)
print v(xbgr.mr_n70771344)
print v(xbgr.mr_n70771664)
print v(xbgr.mr_n70771776)
print v(xbgr.mr_n70772096)
print v(xbgr.mr_n70772208)
print v(xbgr.mr_n70772528)
print v(xbgr.mr_n70772640)
print v(xbgr.mr_n70772960)
print v(xbgr.mr_n70773072)
print v(xbgr.mr_n70773392)
print v(xbgr.mr_n70773504)
print v(xbgr.mr_n70773824)
print v(xbgr.mr_n70773936)
print v(xbgr.mr_n70774256)
print v(xbgr.mr_n70774368)
print v(xbgr.mr_n70774688)
print v(xbgr.mr_n70774800)
print v(xbgr.mr_n70775120)
print v(xbgr.mr_n70775232)
print v(xbgr.mr_n70775552)
print v(xbgr.mr_n70775664)
print v(xbgr.mr_n70775984)
print v(xbgr.mr_n70776096)
print v(xbgr.mr_n70776416)
print v(xbgr.mr_n70776528)
print v(xbgr.mr_n70776848)
print v(xbgr.mr_n70776960)
print v(xbgr.mr_n70777280)
print v(xbgr.mr_n70777392)
print v(xbgr.mr_n70777712)
print v(xbgr.mr_n70777824)
print v(xbgr.mr_n70778144)
print v(xbgr.mr_n70778256)
print v(xbgr.mr_n70778576)
print v(xbgr.mr_n70778688)
print v(xbgr.mr_n70779008)
print v(xbgr.mr_n70779120)
print v(xbgr.mr_n70779440)
print v(xbgr.mr_n70779552)
print v(xbgr.mr_n70779872)
print v(xbgr.mr_n70779984)
print v(xbgr.mr_n70780304)
print v(xbgr.mr_n70780416)
print v(xbgr.mr_n70780736)
print v(xbgr.mr_n70780848)
print v(xbgr.mr_n70781168)
print v(xbgr.mr_n70781280)
print v(xbgr.mr_n70781600)
print v(xbgr.mr_n70781712)
print v(xbgr.mr_n70782032)
print v(xbgr.mr_n70782144)
print v(xbgr.mr_n70782464)
print v(xbgr.mr_n70782576)
print v(xbgr.mr_n70782896)
print v(xbgr.mr_n70783008)
print v(xbgr.mr_n70783328)
print v(xbgr.mr_n70783440)
print v(xbgr.mr_n70783760)
print v(xbgr.mr_n70783872)
print v(xbgr.mr_n70784192)
print v(xbgr.mr_n70784304)
print v(xbgr.mr_n70784624)
print v(xbgr.mr_n70784736)
print v(xbgr.mr_n70785056)
print v(xbgr.mr_n70785168)
print v(xbgr.mr_n70785488)
print v(xbgr.mr_n70785600)
print v(xbgr.mr_n70785920)
print v(xbgr.mr_n70786032)
print v(xbgr.mr_n70786352)
print v(xbgr.mr_n70786464)
print v(xbgr.mr_n70786784)
print v(xbgr.mr_n70786896)
print v(xbgr.mr_n70787216)
print v(xbgr.mr_n70787328)
print v(xbgr.mr_n70787648)
print v(xbgr.mr_n70787760)
print v(xbgr.mr_n70788080)
print v(xbgr.mr_n70788192)
print v(xbgr.mr_n70788512)
print v(xbgr.mr_n70788624)
print v(xbgr.mr_n70788944)
print v(xbgr.mr_n70789056)
print v(xbgr.mr_n70789376)
print v(xbgr.mr_n70789488)
print v(xbgr.mr_n70789808)
print v(xbgr.mr_n70789920)
print v(xbgr.mr_n70790240)
print v(xbgr.mr_n70790352)
print v(xbgr.mr_n70790672)
print v(xbgr.mr_n70790784)
print v(xbgr.mr_n70791104)
print v(xbgr.mr_n70791216)
print v(xbgr.mr_n70791536)
print v(xbgr.mr_n70791648)
print v(xbgr.mr_n70791968)
print v(xbgr.mr_n70792080)
print v(xbgr.mr_n70792400)
print v(xbgr.mr_n70792512)
print v(xbgr.mr_n70792832)
print v(xbgr.mr_n70792944)
print v(xbgr.mr_n70793264)
print v(xbgr.mr_n70793376)
print v(xbgr.mr_n70793696)
print v(xbgr.mr_n70793808)
print v(xbgr.mr_n70794128)
print v(xbgr.mr_n70794240)
print v(xbgr.mr_n70794560)
print v(xbgr.mr_n70794672)
print v(xbgr.mr_n70794992)
print v(xbgr.mr_n70795104)
print v(xbgr.mr_n70795424)
print v(xbgr.mr_n70795536)
print v(xbgr.mr_n70795856)
print v(xbgr.mr_n70795968)
print v(xbgr.mr_n70796288)
print v(xbgr.mr_n70796400)
print v(xbgr.mr_n70796720)
print v(xbgr.mr_n70796832)
print v(xbgr.mr_n70797152)
print v(xbgr.mr_n70797264)
print v(xbgr.mr_n70797584)
print v(xbgr.mr_n70797696)
print v(xbgr.mr_n70798016)
print v(xbgr.mr_n70798128)
print v(xbgr.mr_n70798448)
print v(xbgr.mr_n70798560)
print v(xbgr.mr_n70798880)
print v(xbgr.mr_n70798992)
print v(xbgr.mr_n70799312)
print v(xbgr.mr_n70799424)
print v(xbgr.mr_n70799744)
print v(xbgr.mr_n70799856)
print v(xbgr.mr_n70800176)
print v(xbgr.mr_n70800288)
print v(xbgr.mr_n70800608)
print v(xbgr.mr_n70800720)
print v(xbgr.mr_n70801040)
print v(xbgr.mr_n70801152)
print v(xbgr.mr_n70801472)
print v(xbgr.mr_n70801584)
print v(xbgr.mr_n70801904)
print v(xbgr.mr_n70802016)
print v(xbgr.mr_n70802336)
print v(xbgr.mr_n70802448)
print v(xbgr.mr_n70802768)
print v(xbgr.mr_n70802880)
print v(xbgr.mr_n70803200)
print v(xbgr.mr_n70803312)
print v(xbgr.mr_n70803632)
print v(xbgr.mr_n70803744)
print v(xbgr.mr_n70804064)
print v(xbgr.mr_n70804176)
print v(xbgr.mr_n70804496)
print v(xbgr.mr_n70804608)
print v(xbgr.mr_n70804928)
print v(xbgr.mr_n70805040)
print v(xbgr.mr_n70805360)
print v(xbgr.mr_n70805472)
print v(xbgr.mr_n70805792)
print v(xbgr.mr_n70805904)
print v(xbgr.mr_n70806224)
print v(xbgr.mr_n70806336)
print v(xbgr.mr_n70806656)
print v(xbgr.mr_n70806768)
print v(xbgr.mr_n70807088)
print v(xbgr.mr_n70807200)
print v(xbgr.mr_n70807520)
print v(xbgr.mr_n70807632)
print v(xbgr.mr_n70807952)
print v(xbgr.mr_n70808064)
print v(xbgr.mr_n70808384)
print v(xbgr.mr_n70808496)
print v(xbgr.mr_n70808816)
print v(xbgr.mr_n70808928)
print v(xbgr.mr_n70809248)
print v(xbgr.mr_n70809360)
print v(xbgr.mr_n70809680)
print v(xbgr.mr_n70809792)
print v(xbgr.mr_n70810112)
print v(xbgr.mr_n70810224)
print v(xbgr.mr_n70810544)
print v(xbgr.mr_n70810656)
print v(xbgr.mr_n70810976)
print v(xbgr.mr_n70811088)
print v(xbgr.mr_n70811408)
print v(xbgr.mr_n70811520)
print v(xbgr.mr_n70811840)
print v(xbgr.mr_n70811952)
print v(xbgr.mr_n70812272)
print v(xbgr.mr_n70812384)
print v(xbgr.mr_n70812704)
print v(xbgr.mr_n70812816)
print v(xbgr.mr_n70813136)
print v(xbgr.mr_n70813248)
print v(xbgr.mr_n70813568)
print v(xbgr.mr_n70813680)
print v(xbgr.mr_n70814000)
print v(xbgr.mr_n70814112)
print v(xbgr.mr_n70814432)
print v(xbgr.mr_n70814544)
print v(xbgr.mr_n70814864)
print v(xbgr.mr_n70814976)
print v(xbgr.mr_n70815296)
print v(xbgr.mr_n70815408)
print v(xbgr.mr_n70815728)
print v(xbgr.mr_n70815840)
print v(xbgr.mr_n70816160)
print v(xbgr.mr_n70816272)
print v(xbgr.mr_n70816592)
print v(xbgr.mr_n70816704)
print v(xbgr.mr_n70817024)
print v(xbgr.mr_n70817136)
print v(xbgr.mr_n70817456)
print v(xbgr.mr_n70817568)
print v(xbgr.mr_n70817888)
print v(xbgr.mr_n70818000)
print v(xbgr.mr_n70818320)
print v(xbgr.mr_n70818432)
print v(xbgr.mr_n70818752)
print v(xbgr.mr_n70818864)
print v(xbgr.mr_n70819184)
print v(xbgr.mr_n70819296)
print v(xbgr.mr_n70819616)
print v(xbgr.mr_n70819728)
print v(xbgr.mr_n70820048)
print v(xbgr.mr_n70820160)
print v(xbgr.mr_n70820480)
print v(xbgr.mr_n70820592)
print v(xbgr.mr_n70820912)
print v(xbgr.mr_n70821024)
print v(xbgr.mr_n70821344)
print v(xbgr.mr_n70821456)
print v(xbgr.mr_n70821776)
print v(xbgr.mr_n70821888)
print v(xbgr.mr_n70822208)
print v(xbgr.mr_n70822320)
print v(xbgr.mr_n70822640)
print v(xbgr.mr_n70822752)
print v(xbgr.mr_n70823072)
print v(xbgr.mr_n70823184)
print v(xbgr.mr_n70823504)
print v(xbgr.mr_n70823616)
print v(xbgr.mr_n70823936)
print v(xbgr.mr_n70824048)
print v(xbgr.mr_n70824368)
print v(xbgr.mr_n70824480)
print v(xbgr.mr_n70824800)
print v(xbgr.mr_n70824912)
print v(xbgr.mr_n70825232)
print v(xbgr.mr_n70825344)
print v(xbgr.mr_n70825664)
print v(xbgr.mr_n70825776)
print v(xbgr.mr_n70826096)
print v(xbgr.mr_n70826208)
print v(xbgr.mr_n70826528)
print v(xbgr.mr_n70826640)
print v(xbgr.mr_n70826960)
print v(xbgr.mr_n70827072)
print v(xbgr.mr_n70827392)
print v(xbgr.mr_n70827504)
print v(xbgr.mr_n70827824)
print v(xbgr.mr_n70827936)
print v(xbgr.mr_n70828256)
print v(xbgr.mr_n70828368)
print v(xbgr.mr_n70828688)
print v(xbgr.mr_n70828800)
print v(xbgr.mr_n70829120)
print v(xbgr.mr_n70829232)
print v(xbgr.mr_n70829552)
print v(xbgr.mr_n70829664)
print v(xbgr.mr_n70829984)
print v(xbgr.mr_n70830096)
print v(xbgr.mr_n70830416)
print v(xbgr.mr_n70830528)
print v(xbgr.mr_n70830848)
print v(xbgr.mr_n70830960)
print v(xbgr.mr_n70831280)
print v(xbgr.mr_n70831392)
print v(xbgr.mr_n70831712)
print v(xbgr.mr_n70831824)
print v(xbgr.mr_n70832144)
print v(xbgr.mr_n70832256)
print v(xbgr.mr_n70832576)
print v(xbgr.mr_n70832688)
print v(xbgr.mr_n70833008)
print v(xbgr.mr_n70833120)
print v(xbgr.mr_n70833440)
print v(xbgr.mr_n70833552)
print v(xbgr.mr_n70833872)
print v(xbgr.mr_n70833984)
print v(xbgr.mr_n70834304)
print v(xbgr.mr_n70834416)
print v(xbgr.mr_n70834736)
print v(xbgr.mr_n70834848)
print v(xbgr.mr_n70835168)
print v(xbgr.mr_n70835280)
print v(xbgr.mr_n70835600)
print v(xbgr.mr_n70835712)
print v(xbgr.mr_n70836032)
print v(xbgr.mr_n70836144)
print v(xbgr.mr_n70836464)
print v(xbgr.mr_n70836576)
print v(xbgr.mr_n70836896)
print v(xbgr.mr_n70837008)
print v(xbgr.mr_n70837328)
print v(xbgr.mr_n70837440)
print v(xbgr.mr_n70837760)
print v(xbgr.mr_n70837872)
print v(xbgr.mr_n70838192)
print v(xbgr.mr_n70838304)
print v(xbgr.mr_n70838624)
print v(xbgr.mr_n70838736)
print v(xbgr.mr_n70839056)
print v(xbgr.mr_n70839168)
print v(xbgr.mr_n70839488)
print v(xbgr.mr_n70839600)
print v(xbgr.mr_n70839920)
print v(xbgr.mr_n70840032)
print v(xbgr.mr_n70840352)
print v(xbgr.mr_n70840464)
print v(xbgr.mr_n70840784)
print v(xbgr.mr_n70840896)
print v(xbgr.mr_n70841216)
print v(xbgr.mr_n70841328)
print v(xbgr.mr_n70841648)
print v(xbgr.mr_n70841760)
print v(xbgr.mr_n70842080)
print v(xbgr.mr_n70842192)
print v(xbgr.mr_n70842512)
print v(xbgr.mr_n70842624)
print v(xbgr.mr_n70842944)
print v(xbgr.mr_n70843056)
print v(xbgr.mr_n70843376)
print v(xbgr.mr_n70843488)
print v(xbgr.mr_n70843808)
print v(xbgr.mr_n70843920)
print v(xbgr.mr_n70844240)
print v(xbgr.mr_n70844352)
print v(xbgr.mr_n70844672)
print v(xbgr.mr_n70844784)
print v(xbgr.mr_n70845104)
print v(xbgr.mr_n70845216)
print v(xbgr.mr_n70845536)
print v(xbgr.mr_n70845648)
print v(xbgr.mr_n70845968)
print v(xbgr.mr_n70846080)
print v(xbgr.mr_n70846400)
print v(xbgr.mr_n70846512)
print v(xbgr.mr_n70846832)
print v(xbgr.mr_n70846944)
print v(xbgr.mr_n70847264)
print v(xbgr.mr_n70847376)
print v(xbgr.mr_n70847696)
print v(xbgr.mr_n70847808)
print v(xbgr.mr_n70848128)
print v(xbgr.mr_n70848240)
print v(xbgr.mr_n70848560)
print v(xbgr.mr_n70848672)
print v(xbgr.mr_n70848992)
print v(xbgr.mr_n70849104)
print v(xbgr.mr_n70849424)
print v(xbgr.mr_n70849536)
print v(xbgr.mr_n70849856)
print v(xbgr.mr_n70849968)
print v(xbgr.mr_n70850288)
print v(xbgr.mr_n70850400)
print v(xbgr.mr_n70850720)
print v(xbgr.mr_n70850832)
print v(xbgr.mr_n70851152)
print v(xbgr.mr_n70851264)
print v(xbgr.mr_n70851584)
print v(xbgr.mr_n70851696)
print v(xbgr.mr_n70852016)
print v(xbgr.mr_n70852128)
print v(xbgr.mr_n70852448)
print v(xbgr.mr_n70852560)
print v(xbgr.mr_n70852880)
print v(xbgr.mr_n70852992)
print v(xbgr.mr_n70853312)
print v(xbgr.mr_n70853424)
print v(xbgr.mr_n70853744)
print v(xbgr.mr_n70853856)
print v(xbgr.mr_n70854176)
print v(xbgr.mr_n70854288)
print v(xbgr.mr_n70854608)
print v(xbgr.mr_n70854720)
print v(xbgr.mr_n70855040)
print v(xbgr.mr_n70855152)
print v(xbgr.mr_n70855472)
print v(xbgr.mr_n70855584)
print v(xbgr.mr_n70855904)
print v(xbgr.mr_n70856016)
print v(xbgr.mr_n70856336)
print v(xbgr.mr_n70856448)
print v(xbgr.mr_n70856768)
print v(xbgr.mr_n70856880)
print v(xbgr.mr_n70857200)
print v(xbgr.mr_n70857312)
print v(xbgr.mr_n70857632)
print v(xbgr.mr_n70857744)
print v(xbgr.mr_n70858064)
print v(xbgr.mr_n70858176)
print v(xbgr.mr_n70858496)
print v(xbgr.mr_n70858608)
print v(xbgr.mr_n70858928)
print v(xbgr.mr_n70859040)
print v(xbgr.mr_n70859360)
print v(xbgr.mr_n70859472)
print v(xbgr.mr_n70859792)
print v(xbgr.mr_n70859904)
print v(xbgr.mr_n70860224)
print v(xbgr.mr_n70860336)
print v(xbgr.mr_n70860656)
print v(xbgr.mr_n70860768)
print v(xbgr.mr_n70861088)
print v(xbgr.mr_n70861200)
print v(xbgr.mr_n70861520)
print v(xbgr.mr_n70861632)
print v(xbgr.mr_n70861952)
print v(xbgr.mr_n70862064)
print v(xbgr.mr_n70862384)
print v(xbgr.mr_n70862496)
print v(xbgr.mr_n70862816)
print v(xbgr.mr_n70862928)
print v(xbgr.mr_n70863248)
print v(xbgr.mr_n70863360)
print v(xbgr.mr_n70863680)
print v(xbgr.mr_n70863792)
print v(xbgr.mr_n70864112)
print v(xbgr.mr_n70864224)
print v(xbgr.mr_n70864544)
print v(xbgr.mr_n70864656)
print v(xbgr.mr_n70864976)
print v(xbgr.mr_n70865088)
print v(xbgr.mr_n70865408)
print v(xbgr.mr_n70865520)
print v(xbgr.mr_n70865840)
print v(xbgr.mr_n70865952)
print v(xbgr.mr_n70866272)
print v(xbgr.mr_n70866384)
print v(xbgr.mr_n70866704)
print v(xbgr.mr_n70866816)
print v(xbgr.mr_n70867136)
print v(xbgr.mr_n70867248)
print v(xbgr.mr_n70867568)
print v(xbgr.mr_n70867680)
print v(xbgr.mr_n70868000)
print v(xbgr.mr_n70868112)
print v(xbgr.mr_n70868432)
print v(xbgr.mr_n70868544)
print v(xbgr.mr_n70868864)
print v(xbgr.mr_n70868976)
print v(xbgr.mr_n70869296)
print v(xbgr.mr_n70869408)
print v(xbgr.mr_n70869728)
print v(xbgr.mr_n70869840)
print v(xbgr.mr_n70870160)
print v(xbgr.mr_n70870272)
print v(xbgr.mr_n70870592)
print v(xbgr.mr_n70870704)
print v(xbgr.mr_n70871024)
print v(xbgr.mr_n70871136)
print v(xbgr.mr_n70871456)
print v(xbgr.mr_n70871568)
print v(xbgr.mr_n70871888)
print v(xbgr.mr_n70872000)
print v(xbgr.mr_n70872320)
print v(xbgr.mr_n70872432)
print v(xbgr.mr_n70872752)
print v(xbgr.mr_n70872864)
print v(xbgr.mr_n70873184)
print v(xbgr.mr_n70873296)
print v(xbgr.mr_n70873616)
print v(xbgr.mr_n70873728)
print v(xbgr.mr_n70874048)
print v(xbgr.mr_n70874160)
print v(xbgr.mr_n70874480)
print v(xbgr.mr_n70874592)
print v(xbgr.mr_n70874912)
print v(xbgr.mr_n70875024)
print v(xbgr.mr_n70875344)
print v(xbgr.mr_n70875456)
print v(xbgr.mr_n70875776)
print v(xbgr.mr_n70875888)
print v(xbgr.mr_n70876208)
print v(xbgr.mr_n70876320)
print v(xbgr.mr_n70876640)
print v(xbgr.mr_n70876752)
print v(xbgr.mr_n70877072)
print v(xbgr.mr_n70877184)
print v(xbgr.mr_n70877504)
print v(xbgr.mr_n70877616)
print v(xbgr.mr_n70877936)
print v(xbgr.mr_n70878048)
print v(xbgr.mr_n70878368)
print v(xbgr.mr_n70878480)
print v(xbgr.mr_n70878800)
print v(xbgr.mr_n70878912)
print v(xbgr.mr_n70879232)
print v(xbgr.mr_n70879344)
print v(xbgr.mr_n70879664)
print v(xbgr.mr_n70879776)
print v(xbgr.mr_n70880096)
print v(xbgr.mr_n70880208)
print v(xbgr.mr_n70880528)
print v(xbgr.mr_n70880640)
print v(xbgr.mr_n70880960)
print v(xbgr.mr_n70881072)
print v(xbgr.mr_n70881392)
print v(xbgr.mr_n70881504)
print v(xbgr.mr_n70881824)
print v(xbgr.mr_n70881936)
print v(xbgr.mr_n70882256)
print v(xbgr.mr_n70882368)
print v(xbgr.mr_n70882688)
print v(xbgr.mr_n70882800)
print v(xbgr.mr_n70883120)
print v(xbgr.mr_n70883232)
print v(xbgr.mr_n70883552)
print v(xbgr.mr_n70883664)
print v(xbgr.mr_n70883984)
print v(xbgr.mr_n70884096)
print v(xbgr.mr_n70884416)
print v(xbgr.mr_n70884528)
print v(xbgr.mr_n70884848)
print v(xbgr.mr_n70884960)
print v(xbgr.mr_n70885280)
print v(xbgr.mr_n70885392)
print v(xbgr.mr_n70885712)
print v(xbgr.mr_n70885824)
print v(xbgr.mr_n70886144)
print v(xbgr.mr_n70886256)
print v(xbgr.mr_n70886576)
print v(xbgr.mr_n70886688)
print v(xbgr.mr_n70887008)
print v(xbgr.mr_n70887120)
print v(xbgr.mr_n70887440)
print v(xbgr.mr_n70887552)
print v(xbgr.mr_n70887872)
print v(xbgr.mr_n70887984)
print v(xbgr.mr_n70888304)
print v(xbgr.mr_n70888416)
print v(xbgr.mr_n70888736)
print v(xbgr.mr_n70888848)
print v(xbgr.mr_n70889168)
print v(xbgr.mr_n70889280)
print v(xbgr.mr_n70889600)
print v(xbgr.mr_n70889712)
print v(xbgr.mr_n70890032)
print v(xbgr.mr_n70890144)
print v(xbgr.mr_n70890464)
print v(xbgr.mr_n70890576)
print v(xbgr.mr_n70890896)
print v(xbgr.mr_n70891008)
print v(xbgr.mr_n70891328)
print v(xbgr.mr_n70891440)
print v(xbgr.mr_n70891760)
print v(xbgr.mr_n70891872)
print v(xbgr.mr_n70892192)
print v(xbgr.mr_n70892304)
print v(xbgr.mr_n70892624)
print v(xbgr.mr_n70892736)
print v(xbgr.mr_n70893056)
print v(xbgr.mr_n70893168)
print v(xbgr.mr_n70893488)
print v(xbgr.mr_n70893600)
print v(xbgr.mr_n70893920)
print v(xbgr.mr_n70894032)
print v(xbgr.mr_n70894352)
print v(xbgr.mr_n70894464)
print v(xbgr.mr_n70894784)
print v(xbgr.mr_n70894896)
print v(xbgr.mr_n70895216)
print v(xbgr.mr_n70895328)
print v(xbgr.mr_n70895648)
print v(xbgr.mr_n70895760)
print v(xbgr.mr_n70896080)
print v(xbgr.mr_n70896192)
print v(xbgr.mr_n70896512)
print v(xbgr.mr_n70896624)
print v(xbgr.mr_n70896944)
print v(xbgr.mr_n70897056)
print v(xbgr.mr_n70897376)
print v(xbgr.mr_n70897488)
print v(xbgr.mr_n70897808)
print v(xbgr.mr_n70897920)
print v(xbgr.mr_n70898240)
print v(xbgr.mr_n70898352)
print v(xbgr.mr_n70898672)
print v(xbgr.mr_n70898784)
print v(xbgr.mr_n70899104)
print v(xbgr.mr_n70899216)
print v(xbgr.mr_n70899536)
print v(xbgr.mr_n70899648)
print v(xbgr.mr_n70899968)
print v(xbgr.mr_n70900080)
print v(xbgr.mr_n70900400)
print v(xbgr.mr_n70900512)
print v(xbgr.mr_n70900832)
print v(xbgr.mr_n70900944)
print v(xbgr.mr_n70901264)
print v(xbgr.mr_n70901376)
print v(xbgr.mr_n70901696)
print v(xbgr.mr_n70901808)
print v(xbgr.mr_n70902128)
print v(xbgr.mr_n70902240)
print v(xbgr.mr_n70902560)
print v(xbgr.mr_n70902672)
print v(xbgr.mr_n70902992)
print v(xbgr.mr_n70903104)
print v(xbgr.mr_n70903424)
print v(xbgr.mr_n70903536)
print v(xbgr.mr_n70903856)
print v(xbgr.mr_n70903968)
print v(xbgr.mr_n70904288)
print v(xbgr.mr_n70904400)
print v(xbgr.mr_n70904720)
print v(xbgr.mr_n70904832)
print v(xbgr.mr_n70905152)
print v(xbgr.mr_n70905264)
print v(xbgr.mr_n70905584)
print v(xbgr.mr_n70905696)
print v(xbgr.mr_n70906016)
print v(xbgr.mr_n70906128)
print v(xbgr.mr_n70906448)
print v(xbgr.mr_n70906560)
print v(xbgr.mr_n70906880)
print v(xbgr.mr_n70906992)
print v(xbgr.mr_n70907312)
print v(xbgr.mr_n70907424)
print v(xbgr.mr_n70907744)
print v(xbgr.mr_n70907856)
print v(xbgr.mr_n70908176)
print v(xbgr.mr_n70908288)
print v(xbgr.mr_n70908608)
print v(xbgr.mr_n70908720)
print v(xbgr.mr_n70909040)
print v(xbgr.mr_n70909152)
print v(xbgr.mr_n70909472)
print v(xbgr.mr_n70909584)
print v(xbgr.mr_n70909904)
print v(xbgr.mr_n70910016)
print v(xbgr.mr_n70910336)
print v(xbgr.mr_n70910448)
print v(xbgr.mr_n70910768)
print v(xbgr.mr_n70910880)
print v(xbgr.mr_n70911200)
print v(xbgr.mr_n70911312)
print v(xbgr.mr_n70911632)
print v(xbgr.mr_n70911744)
print v(xbgr.mr_n70912064)
print v(xbgr.mr_n70912176)
print v(xbgr.mr_n70912496)
print v(xbgr.mr_n70912608)
print v(xbgr.mr_n70912928)
print v(xbgr.mr_n70913040)
print v(xbgr.mr_n70913360)
print v(xbgr.mr_n70913472)
print v(xbgr.mr_n70913792)
print v(xbgr.mr_n70913904)
print v(xbgr.mr_n70914224)
print v(xbgr.mr_n70914336)
print v(xbgr.mr_n70914656)
print v(xbgr.mr_n70914768)
print v(xbgr.mr_n70915088)
print v(xbgr.mr_n70915200)
print v(xbgr.mr_n70915520)
print v(xbgr.mr_n70915632)
print v(xbgr.mr_n70915952)
print v(xbgr.mr_n70916064)
print v(xbgr.mr_n70916384)
print v(xbgr.mr_n70916496)
print v(xbgr.mr_n70916816)
print v(xbgr.mr_n70916928)
print v(xbgr.mr_n70917248)
print v(xbgr.mr_n70917360)
print v(xbgr.mr_n70917680)
print v(xbgr.mr_n70917792)
print v(xbgr.mr_n70918112)
print v(xbgr.mr_n70918224)
print v(xbgr.mr_n70918544)
print v(xbgr.mr_n70918656)
print v(xbgr.mr_n70918976)
print v(xbgr.mr_n70919088)
print v(xbgr.mr_n70919408)
print v(xbgr.mr_n70919520)
print v(xbgr.mr_n70919840)
print v(xbgr.mr_n70919952)
print v(xbgr.mr_n70920272)
print v(xbgr.mr_n70920384)
print v(xbgr.mr_n70920704)
print v(xbgr.mr_n70920816)
print v(xbgr.mr_n70921136)
print v(xbgr.mr_n70921248)
print v(xbgr.mr_n70921568)
print v(xbgr.mr_n70921680)
print v(xbgr.mr_n70922000)
print v(xbgr.mr_n70922112)
print v(xbgr.mr_n70922432)
print v(xbgr.mr_n70922544)
print v(xbgr.mr_n70922864)
print v(xbgr.mr_n70922976)
print v(xbgr.mr_n70923296)
print v(xbgr.mr_n70923408)
print v(xbgr.mr_n70923728)
print v(xbgr.mr_n70923840)
print v(xbgr.mr_n70924160)
print v(xbgr.mr_n70924272)
print v(xbgr.mr_n70924592)
print v(xbgr.mr_n70924704)
print v(xbgr.mr_n70925024)
print v(xbgr.mr_n70925136)
print v(xbgr.mr_n70925456)
print v(xbgr.mr_n70925568)
print v(xbgr.mr_n70925888)
print v(xbgr.mr_n70926000)
print v(xbgr.mr_n70926320)
print v(xbgr.mr_n70926432)
print v(xbgr.mr_n70926752)
print v(xbgr.mr_n70926864)
print v(xbgr.mr_n70927184)
print v(xbgr.mr_n70927296)
print v(xbgr.mr_n70927616)
print v(xbgr.mr_n70927728)
print v(xbgr.mr_n70928048)
print v(xbgr.mr_n70928160)
print v(xbgr.mr_n70928480)
print v(xbgr.mr_n70928592)
print v(xbgr.mr_n70928912)
print v(xbgr.mr_n70929024)
print v(xbgr.mr_n70929344)
print v(xbgr.mr_n70929456)
print v(xbgr.mr_n70929776)
print v(xbgr.mr_n70929888)
print v(xbgr.mr_n70930208)
print v(xbgr.mr_n70930320)
print v(xbgr.mr_n70930640)
print v(xbgr.mr_n70930752)
print v(xbgr.mr_n70931072)
print v(xbgr.mr_n70931184)
print v(xbgr.mr_n70931504)
print v(xbgr.mr_n70931616)
print v(xbgr.mr_n70931936)
print v(xbgr.mr_n70932048)
print v(xbgr.mr_n70932368)
print v(xbgr.mr_n70932480)
print v(xbgr.mr_n70932800)
print v(xbgr.mr_n70932912)
print v(xbgr.mr_n70933232)
print v(xbgr.mr_n70933344)
print v(xbgr.mr_n70933664)
print v(xbgr.mr_n70933776)
print v(xbgr.mr_n70934096)
print v(xbgr.mr_n70934208)
print v(xbgr.mr_n70934528)
print v(xbgr.mr_n70934640)
print v(xbgr.mr_n70934960)
print v(xbgr.mr_n70935072)
print v(xbgr.mr_n70935392)
print v(xbgr.mr_n70935504)
print v(xbgr.mr_n70935824)
print v(xbgr.mr_n70935936)
print v(xbgr.mr_n70936256)
print v(xbgr.mr_n70936368)
print v(xbgr.mr_n70936688)
print v(xbgr.mr_n70936800)
print v(xbgr.mr_n70937120)
print v(xbgr.mr_n70937232)
print v(xbgr.mr_n70937552)
print v(xbgr.mr_n70937664)
print v(xbgr.mr_n70937984)
print v(xbgr.mr_n70938096)
print v(xbgr.mr_n70938416)
print v(xbgr.mr_n70938528)
print v(xbgr.mr_n70938848)
print v(xbgr.mr_n70938960)
print v(xbgr.mr_n70939280)
print v(xbgr.mr_n70939392)
print v(xbgr.mr_n70939712)
print v(xbgr.mr_n70939824)
print v(xbgr.mr_n70940144)
print v(xbgr.mr_n70940256)
print v(xbgr.mr_n70940576)
print v(xbgr.mr_n70940688)
print v(xbgr.mr_n70941008)
print v(xbgr.mr_n70941120)
print v(xbgr.mr_n70941440)
print v(xbgr.mr_n70941552)
print v(xbgr.mr_n70941872)
print v(xbgr.mr_n70941984)
print v(xbgr.mr_n70942304)
print v(xbgr.mr_n70942416)
print v(xbgr.mr_n70942736)
print v(xbgr.mr_n70942848)
print v(xbgr.mr_n70943168)
print v(xbgr.mr_n70943280)
print v(xbgr.mr_n70943600)
print v(xbgr.mr_n70943712)
print v(xbgr.mr_n70944032)
print v(xbgr.mr_n70944144)
print v(xbgr.mr_n70944464)
print v(xbgr.mr_n70944576)
print v(xbgr.mr_n70944896)
print v(xbgr.mr_n70945008)
print v(xbgr.mr_n70945328)
print v(xbgr.mr_n70945440)
print v(xbgr.mr_n70945760)
print v(xbgr.mr_n70945872)
print v(xbgr.mr_n70946192)
print v(xbgr.mr_n70946304)
print v(xbgr.mr_n70946624)
print v(xbgr.mr_n70946736)
print v(xbgr.mr_n70947056)
print v(xbgr.mr_n70947168)
print v(xbgr.mr_n70947488)
print v(xbgr.mr_n70947600)
print v(xbgr.mr_n70947920)
print v(xbgr.mr_n70948032)
print v(xbgr.mr_n70948352)
print v(xbgr.mr_n70948464)
print v(xbgr.mr_n70948784)
print v(xbgr.mr_n70948896)
print v(xbgr.mr_n70949216)
print v(xbgr.mr_n70949328)
print v(xbgr.mr_n70949648)
print v(xbgr.mr_n70949760)
print v(xbgr.mr_n70950080)
print v(xbgr.mr_n70950192)
print v(xbgr.mr_n70950512)
print v(xbgr.mr_n70950624)
print v(xbgr.mr_n70950944)
print v(xbgr.mr_n70951056)
print v(xbgr.mr_n70951376)
print v(xbgr.mr_n70951488)
print v(xbgr.mr_n70951808)
print v(xbgr.mr_n70951920)
print v(xbgr.mr_n70952240)
print v(xbgr.mr_n70952352)
print v(xbgr.mr_n70952672)
print v(xbgr.mr_n70952784)
print v(xbgr.mr_n70953104)
print v(xbgr.mr_n70953216)
print v(xbgr.mr_n70953536)
print v(xbgr.mr_n70953648)
print v(xbgr.mr_n70953968)
print v(xbgr.mr_n70954080)
print v(xbgr.mr_n70954400)
print v(xbgr.mr_n70954512)
print v(xbgr.mr_n70954832)
print v(xbgr.mr_n70954944)
print v(xbgr.mr_n70955264)
print v(xbgr.mr_n70955376)
print v(xbgr.mr_n70955696)
print v(xbgr.mr_n70955808)
print v(xbgr.mr_n70956128)
print v(xbgr.mr_n70956240)
print v(xbgr.mr_n70956560)
print v(xbgr.mr_n70956672)
print v(xbgr.mr_n70956992)
print v(xbgr.mr_n70957104)
print v(xbgr.mr_n70957424)
print v(xbgr.mr_n70957536)
print v(xbgr.mr_n70957856)
print v(xbgr.mr_n70957968)
print v(xbgr.mr_n70958288)
print v(xbgr.mr_n70958400)
print v(xbgr.mr_n70958720)
print v(xbgr.mr_n70958832)
print v(xbgr.mr_n70959152)
print v(xbgr.mr_n70959264)
print v(xbgr.mr_n70959584)
print v(xbgr.mr_n70959696)
print v(xbgr.mr_n70960016)
print v(xbgr.mr_n70960128)
print v(xbgr.mr_n70960448)
print v(xbgr.mr_n70960560)
print v(xbgr.mr_n70960880)
print v(xbgr.mr_n70960992)
print v(xbgr.mr_n70961312)
print v(xbgr.mr_n70961424)
print v(xbgr.mr_n70961744)
print v(xbgr.mr_n70961856)
print v(xbgr.mr_n70962176)
print v(xbgr.mr_n70962288)
print v(xbgr.mr_n70962608)
print v(xbgr.mr_n70962720)
print v(xbgr.mr_n70963040)
print v(xbgr.mr_n70963152)
print v(xbgr.mr_n70963472)
print v(xbgr.mr_n70963584)
print v(xbgr.mr_n70963904)
print v(xbgr.mr_n70964016)
print v(xbgr.mr_n70964336)
print v(xbgr.mr_n70964448)
print v(xbgr.mr_n70964768)
print v(xbgr.mr_n70964880)
print v(xbgr.mr_n70965200)
print v(xbgr.mr_n70965312)
print v(xbgr.mr_n70965632)
print v(xbgr.mr_n70965744)
print v(xbgr.mr_n70966064)
print v(xbgr.mr_n70966176)
print v(xbgr.mr_n70966496)
print v(xbgr.mr_n70966608)
print v(xbgr.mr_n70966928)
print v(xbgr.mr_n70967040)
print v(xbgr.mr_n70967360)
print v(xbgr.mr_n70967472)
print v(xbgr.mr_n70967792)
print v(xbgr.mr_n70967904)
print v(xbgr.mr_n70968224)
print v(xbgr.mr_n70968336)
print v(xbgr.mr_n70968656)
print v(xbgr.mr_n70968768)
print v(xbgr.mr_n70969088)
print v(xbgr.mr_n70969200)
print v(xbgr.mr_n70969520)
print v(xbgr.mr_n70969632)
print v(xbgr.mr_n70969952)
print v(xbgr.mr_n70970064)
print v(xbgr.mr_n70970384)
print v(xbgr.mr_n70970496)
print v(xbgr.mr_n70970816)
print v(xbgr.mr_n70970928)
print v(xbgr.mr_n70971248)
print v(xbgr.mr_n70971360)
print v(xbgr.mr_n70971680)
print v(xbgr.mr_n70971792)
print v(xbgr.mr_n70972112)
print v(xbgr.mr_n70972224)
print v(xbgr.mr_n70972544)
print v(xbgr.mr_n70972656)
print v(xbgr.mr_n70972976)
print v(xbgr.mr_n70973088)
print v(xbgr.mr_n70973408)
print v(xbgr.mr_n70973520)
print v(xbgr.mr_n70973840)
print v(xbgr.mr_n70973952)
print v(xbgr.mr_n70974272)
print v(xbgr.mr_n70974384)
print v(xbgr.mr_n70974704)
print v(xbgr.mr_n70974816)
print v(xbgr.mr_n70975136)
print v(xbgr.mr_n70975248)
print v(xbgr.mr_n70975568)
print v(xbgr.mr_n70975680)
print v(xbgr.mr_n70976000)
print v(xbgr.mr_n70976112)
print v(xbgr.mr_n70976432)
print v(xbgr.mr_n70976544)
print v(xbgr.mr_n70976864)
print v(xbgr.mr_n70976976)
print v(xbgr.mr_n70977296)
print v(xbgr.mr_n70977408)
print v(xbgr.mr_n70977728)
print v(xbgr.mr_n70977840)
print v(xbgr.mr_n70978160)
print v(xbgr.mr_n70978272)
print v(xbgr.mr_n70978592)
print v(xbgr.mr_n70978704)
print v(xbgr.mr_n70979024)
print v(xbgr.mr_n70979136)
print v(xbgr.mr_n70979456)
print v(xbgr.mr_n70979568)
print v(xbgr.mr_n70979888)
print v(xbgr.mr_n70980000)
print v(xbgr.mr_n70980320)
print v(xbgr.mr_n70980432)
print v(xbgr.mr_n70980752)
print v(xbgr.mr_n70980864)
print v(xbgr.mr_n70981184)
print v(xbgr.mr_n70981296)
print v(xbgr.mr_n70981616)
print v(xbgr.mr_n70981728)
print v(xbgr.mr_n70982048)
print v(xbgr.mr_n70982160)
print v(xbgr.mr_n70982480)
print v(xbgr.mr_n70982592)
print v(xbgr.mr_n70982912)
print v(xbgr.mr_n70983024)
print v(xbgr.mr_n70983344)
print v(xbgr.mr_n70983456)
print v(xbgr.mr_n70983776)
print v(xbgr.mr_n70983888)
print v(xbgr.mr_n70984208)
print v(xbgr.mr_n70984320)
print v(xbgr.mr_n70984640)
print v(xbgr.mr_n70984752)
print v(xbgr.mr_n70985072)
print v(xbgr.mr_n70985184)
print v(xbgr.mr_n70985504)
print v(xbgr.mr_n70985616)
print v(xbgr.mr_n70985936)
print v(xbgr.mr_n70986048)
print v(xbgr.mr_n70986368)
print v(xbgr.mr_n70986480)
print v(xbgr.mr_n70986800)
print v(xbgr.mr_n70986912)
print v(xbgr.mr_n70987232)
print v(xbgr.mr_n70987344)
print v(xbgr.mr_n70987664)
print v(xbgr.mr_n70987776)
print v(xbgr.mr_n70988096)
print v(xbgr.mr_n70988208)
print v(xbgr.mr_n70988528)
print v(xbgr.mr_n70988640)
print v(xbgr.mr_n70988960)
print v(xbgr.mr_n70989072)
print v(xbgr.mr_n70989392)
print v(xbgr.mr_n70989504)
print v(xbgr.mr_n70989824)
print v(xbgr.mr_n70989936)
print v(xbgr.mr_n70990256)
print v(xbgr.mr_n70990368)
print v(xbgr.mr_n70990688)
print v(xbgr.mr_n70990800)
print v(xbgr.mr_n70991120)
print v(xbgr.mr_n70991232)
print v(xbgr.mr_n70991552)
print v(xbgr.mr_n70991664)
print v(xbgr.mr_n70991984)
print v(xbgr.mr_n70992096)
print v(xbgr.mr_n70992416)
print v(xbgr.mr_n70992528)
print v(xbgr.mr_n70992848)
print v(xbgr.mr_n70992960)
print v(xbgr.mr_n70993280)
print v(xbgr.mr_n70993392)
print v(xbgr.mr_n70993712)
print v(xbgr.mr_n70993824)
print v(xbgr.mr_n70994144)
print v(xbgr.mr_n70994256)
print v(xbgr.mr_n70994576)
print v(xbgr.mr_n70994688)
print v(xbgr.mr_n70995008)
print v(xbgr.mr_n70995120)
print v(xbgr.mr_n70995440)
print v(xbgr.mr_n70995552)
print v(xbgr.mr_n70995872)
print v(xbgr.mr_n70995984)
print v(xbgr.mr_n70996304)
print v(xbgr.mr_n70996416)
print v(xbgr.mr_n70996736)
print v(xbgr.mr_n70996848)
print v(xbgr.mr_n70997168)
print v(xbgr.mr_n70997280)
print v(xbgr.mr_n70997600)
print v(xbgr.mr_n70997712)
print v(xbgr.mr_n70998032)
print v(xbgr.mr_n70998144)
print v(xbgr.mr_n70998464)
print v(xbgr.mr_n70998576)
print v(xbgr.mr_n70998896)
print v(xbgr.mr_n70999008)
print v(xbgr.mr_n70999328)
print v(xbgr.mr_n70999440)
print v(xbgr.mr_n70999760)
print v(xbgr.mr_n70999872)
print v(xbgr.mr_n71000192)
print v(xbgr.mr_n71000304)
print v(xbgr.mr_n71000624)
print v(xbgr.mr_n71000736)
print v(xbgr.mr_n71001056)
print v(xbgr.mr_n71001168)
print v(xbgr.mr_n71001488)
print v(xbgr.mr_n71001600)
print v(xbgr.mr_n71001920)
print v(xbgr.mr_n71002032)
print v(xbgr.mr_n71002352)
print v(xbgr.mr_n71002464)
print v(xbgr.mr_n71002784)
print v(xbgr.mr_n71002896)
print v(xbgr.mr_n71003216)
print v(xbgr.mr_n71003328)
print v(xbgr.mr_n71003648)
print v(xbgr.mr_n71003760)
print v(xbgr.mr_n71004080)
print v(xbgr.mr_n71004192)
print v(xbgr.mr_n71004512)
print v(xbgr.mr_n71004624)
print v(xbgr.mr_n71004944)
print v(xbgr.mr_n71005056)
print v(xbgr.mr_n71005376)
print v(xbgr.mr_n71005488)
print v(xbgr.mr_n71005808)
print v(xbgr.mr_n71005920)
print v(xbgr.mr_n71006240)
print v(xbgr.mr_n71006352)
print v(xbgr.mr_n71006672)
print v(xbgr.mr_n71006784)
print v(xbgr.mr_n71007104)
print v(xbgr.mr_n71007216)
print v(xbgr.mr_n71007536)
print v(xbgr.mr_n71007648)
print v(xbgr.mr_n71007968)
print v(xbgr.mr_n71008080)
print v(xbgr.mr_n71008400)
print v(xbgr.mr_n71008512)
print v(xbgr.mr_n71008832)
print v(xbgr.mr_n71008944)
print v(xbgr.mr_n71009264)
print v(xbgr.mr_n71009376)
print v(xbgr.mr_n71009696)
print v(xbgr.mr_n71009808)
print v(xbgr.mr_n71010128)
print v(xbgr.mr_n71010240)
print v(xbgr.mr_n71010560)
print v(xbgr.mr_n71010672)
print v(xbgr.mr_n71010992)
print v(xbgr.mr_n71011104)
print v(xbgr.mr_n71011424)
print v(xbgr.mr_n71011536)
print v(xbgr.mr_n71011856)
print v(xbgr.mr_n71011968)
print v(xbgr.mr_n71012288)
print v(xbgr.mr_n71012400)
print v(xbgr.mr_n71012720)
print v(xbgr.mr_n71012832)
print v(xbgr.mr_n71013152)
print v(xbgr.mr_n71013264)
print v(xbgr.mr_n71013584)
print v(xbgr.mr_n71013696)
print v(xbgr.mr_n71014016)
print v(xbgr.mr_n71014128)
print v(xbgr.mr_n71014448)
print v(xbgr.mr_n71014560)
print v(xbgr.mr_n71014880)
print v(xbgr.mr_n71014992)
print v(xbgr.mr_n71015312)
print v(xbgr.mr_n71015424)
print v(xbgr.mr_n71015744)
print v(xbgr.mr_n71015856)
print v(xbgr.mr_n71016176)
print v(xbgr.mr_n71016288)
print v(xbgr.mr_n71016608)
print v(xbgr.mr_n71016720)
print v(xbgr.mr_n71017040)
print v(xbgr.mr_n71017152)
print v(xbgr.mr_n71017472)
print v(xbgr.mr_n71017584)
print v(xbgr.mr_n71017904)
print v(xbgr.mr_n71018016)
print v(xbgr.mr_n71018336)
print v(xbgr.mr_n71018448)
print v(xbgr.mr_n71018768)
print v(xbgr.mr_n71018880)
print v(xbgr.mr_n71019200)
print v(xbgr.mr_n71019312)
print v(xbgr.mr_n71019632)
print v(xbgr.mr_n71019744)
print v(xbgr.mr_n71020064)
print v(xbgr.mr_n71020176)
print v(xbgr.mr_n71020496)
print v(xbgr.mr_n71020608)
print v(xbgr.mr_n71020928)
print v(xbgr.mr_n71021040)
print v(xbgr.mr_n71021360)
print v(xbgr.mr_n71021472)
print v(xbgr.mr_n71021792)
print v(xbgr.mr_n71021904)
print v(xbgr.mr_n71022224)
print v(xbgr.mr_n71022336)
print v(xbgr.mr_n71022656)
print v(xbgr.mr_n71022768)
print v(xbgr.mr_n71023088)
print v(xbgr.mr_n71023200)
print v(xbgr.mr_n71023520)
print v(xbgr.mr_n71023632)
print v(xbgr.mr_n71023952)
print v(xbgr.mr_n71024064)
print v(xbgr.mr_n71024384)
print v(xbgr.mr_n71024496)
print v(xbgr.mr_n71024816)
print v(xbgr.mr_n71024928)
print v(xbgr.mr_n71025248)
print v(xbgr.mr_n71025360)
print v(xbgr.mr_n71025680)
print v(xbgr.mr_n71025792)
print v(xbgr.mr_n71026112)
print v(xbgr.mr_n71026224)
print v(xbgr.mr_n71026544)
print v(xbgr.mr_n71026656)
print v(xbgr.mr_n71026976)
print v(xbgr.mr_n71027088)
print v(xbgr.mr_n71027408)
print v(xbgr.mr_n71027520)
print v(xbgr.mr_n71027840)
print v(xbgr.mr_n71027952)
print v(xbgr.mr_n71028272)
print v(xbgr.mr_n71028384)
print v(xbgr.mr_n71028704)
print v(xbgr.mr_n71028816)
print v(xbgr.mr_n71029136)
print v(xbgr.mr_n71029248)
print v(xbgr.mr_n71029568)
print v(xbgr.mr_n71029680)
print v(xbgr.mr_n71030000)
print v(xbgr.mr_n71030112)
print v(xbgr.mr_n71030432)
print v(xbgr.mr_n71030544)
print v(xbgr.mr_n71030864)
print v(xbgr.mr_n71030976)
print v(xbgr.mr_n71031296)
print v(xbgr.mr_n71031408)
print v(xbgr.mr_n71031728)
print v(xbgr.mr_n71031840)
print v(xbgr.mr_n71032160)
print v(xbgr.mr_n71032272)
print v(xbgr.mr_n71032592)
print v(xbgr.mr_n71032704)
print v(xbgr.mr_n71033024)
print v(xbgr.mr_n71033136)
print v(xbgr.mr_n71033456)
print v(xbgr.mr_n71033568)
print v(xbgr.mr_n71033888)
print v(xbgr.mr_n71034000)
print v(xbgr.mr_n71034320)
print v(xbgr.mr_n71034432)
print v(xbgr.mr_n71034752)
print v(xbgr.mr_n71034864)
print v(xbgr.mr_n71035184)
print v(xbgr.mr_n71035296)
print v(xbgr.mr_n71035616)
print v(xbgr.mr_n71035728)
print v(xbgr.mr_n71036048)
print v(xbgr.mr_n71036160)
print v(xbgr.mr_n71036480)
print v(xbgr.mr_n71036592)
print v(xbgr.mr_n71036912)
print v(xbgr.mr_n71037024)
print v(xbgr.mr_n71037344)
print v(xbgr.mr_n71037456)
print v(xbgr.mr_n71037776)
print v(xbgr.mr_n71037888)
print v(xbgr.mr_n71038208)
print v(xbgr.mr_n71038320)
print v(xbgr.mr_n71038640)
print v(xbgr.mr_n71038752)
print v(xbgr.mr_n71039072)
print v(xbgr.mr_n71039184)
print v(xbgr.mr_n71039504)
print v(xbgr.mr_n71039616)
print v(xbgr.mr_n71039936)
print v(xbgr.mr_n71040048)
print v(xbgr.mr_n71040368)
print v(xbgr.mr_n71040480)
print v(xbgr.mr_n71040800)
print v(xbgr.mr_n71040912)
print v(xbgr.mr_n71041232)
print v(xbgr.mr_n71041344)
print v(xbgr.mr_n71041664)
print v(xbgr.mr_n71041776)
print v(xbgr.mr_n71042096)
print v(xbgr.mr_n71042208)
print v(xbgr.mr_n71042528)
print v(xbgr.mr_n71042640)
print v(xbgr.mr_n71042960)
print v(xbgr.mr_n71043072)
print v(xbgr.mr_n71043392)
print v(xbgr.mr_n71043504)
print v(xbgr.mr_n71043824)
print v(xbgr.mr_n71043936)
print v(xbgr.mr_n71044256)
print v(xbgr.mr_n71044368)
print v(xbgr.mr_n71044688)
print v(xbgr.mr_n71044800)
print v(xbgr.mr_n71045120)
print v(xbgr.mr_n71045232)
print v(xbgr.mr_n71045552)
print v(xbgr.mr_n71045664)
print v(xbgr.mr_n71045984)
print v(xbgr.mr_n71046096)
print v(xbgr.mr_n71046416)
print v(xbgr.mr_n71046528)
print v(xbgr.mr_n71046848)
print v(xbgr.mr_n71046960)
print v(xbgr.mr_n71047280)
print v(xbgr.mr_n71047392)
print v(xbgr.mr_n71047712)
print v(xbgr.mr_n71047824)
print v(xbgr.mr_n71048144)
print v(xbgr.mr_n71048256)
print v(xbgr.mr_n71048576)
print v(xbgr.mr_n71048688)
print v(xbgr.mr_n71049008)
print v(xbgr.mr_n71049120)
print v(xbgr.mr_n71049440)
print v(xbgr.mr_n71049552)
print v(xbgr.mr_n71049872)
print v(xbgr.mr_n71049984)
print v(xbgr.mr_n71050304)
print v(xbgr.mr_n71050416)
print v(xbgr.mr_n71050736)
print v(xbgr.mr_n71050848)
print v(xbgr.mr_n71051168)
print v(xbgr.mr_n71051280)
print v(xbgr.mr_n71051600)
print v(xbgr.mr_n71051712)
print v(xbgr.mr_n71052032)
print v(xbgr.mr_n71052144)
print v(xbgr.mr_n71052464)
print v(xbgr.mr_n71052576)
print v(xbgr.mr_n71052896)
print v(xbgr.mr_n71053008)
print v(xbgr.mr_n71053328)
print v(xbgr.mr_n71053440)
print v(xbgr.mr_n71053760)
print v(xbgr.mr_n71053872)
print v(xbgr.mr_n71054192)
print v(xbgr.mr_n71054304)
print v(xbgr.mr_n71054624)
print v(xbgr.mr_n71054736)
print v(xbgr.mr_n71055056)
print v(xbgr.mr_n71055168)
print v(xbgr.mr_n71055488)
print v(xbgr.mr_n71055600)
print v(xbgr.mr_n71055920)
print v(xbgr.mr_n71056032)
print v(xbgr.mr_n71056352)
print v(xbgr.mr_n71056464)
print v(xbgr.mr_n71056784)
print v(xbgr.mr_n71056896)
print v(xbgr.mr_n71057216)
print v(xbgr.mr_n71057328)
print v(xbgr.mr_n71057648)
print v(xbgr.mr_n71057760)
print v(xbgr.mr_n71058080)
print v(xbgr.mr_n71058192)
print v(xbgr.mr_n71058512)
print v(xbgr.mr_n71058624)
print v(xbgr.mr_n71058944)
print v(xbgr.mr_n71059056)
print v(xbgr.mr_n71059376)
print v(xbgr.mr_n71059488)
print v(xbgr.mr_n71059808)
print v(xbgr.mr_n71059920)
print v(xbgr.mr_n71060240)
print v(xbgr.mr_n71060352)
print v(xbgr.mr_n71060672)
print v(xbgr.mr_n71060784)
print v(xbgr.mr_n71061104)
print v(xbgr.mr_n71061216)
print v(xbgr.mr_n71061536)
print v(xbgr.mr_n71061648)
print v(xbgr.mr_n71061968)
print v(xbgr.mr_n71062080)
print v(xbgr.mr_n71062400)
print v(xbgr.mr_n71062512)
print v(xbgr.mr_n71062832)
print v(xbgr.mr_n71062944)
print v(xbgr.mr_n71063264)
print v(xbgr.mr_n71063376)
print v(xbgr.mr_n71063696)
print v(xbgr.mr_n71063808)
print v(xbgr.mr_n71064128)
print v(xbgr.mr_n71064240)
print v(xbgr.mr_n71064560)
print v(xbgr.mr_n71064672)
print v(xbgr.mr_n71064992)
print v(xbgr.mr_n71065104)
print v(xbgr.mr_n71065424)
print v(xbgr.mr_n71065536)
print v(xbgr.mr_n71065856)
print v(xbgr.mr_n71065968)
print v(xbgr.mr_n71066288)
print v(xbgr.mr_n71066400)
print v(xbgr.mr_n71066720)
print v(xbgr.mr_n71066832)
print v(xbgr.mr_n71067152)
print v(xbgr.mr_n71067264)
print v(xbgr.mr_n71067584)
print v(xbgr.mr_n71067696)
print v(xbgr.mr_n71068016)
print v(xbgr.mr_n71068128)
print v(xbgr.mr_n71068448)
print v(xbgr.mr_n71068560)
print v(xbgr.mr_n71068880)
print v(xbgr.mr_n71068992)
print v(xbgr.mr_n71069312)
print v(xbgr.mr_n71069424)
print v(xbgr.mr_n71069744)
print v(xbgr.mr_n71069856)
print v(xbgr.mr_n71070176)
print v(xbgr.mr_n71070288)
print v(xbgr.mr_n71070608)
print v(xbgr.mr_n71070720)
print v(xbgr.mr_n71071040)
print v(xbgr.mr_n71071152)
print v(xbgr.mr_n71071472)
print v(xbgr.mr_n71071584)
print v(xbgr.mr_n71071904)
print v(xbgr.mr_n71072016)
print v(xbgr.mr_n71072336)
print v(xbgr.mr_n71072448)
print v(xbgr.mr_n71072768)
print v(xbgr.mr_n71072880)
print v(xbgr.mr_n71073200)
print v(xbgr.mr_n71073312)
print v(xbgr.mr_n71073632)
print v(xbgr.mr_n71073744)
print v(xbgr.mr_n71074064)
print v(xbgr.mr_n71074176)
print v(xbgr.mr_n71074496)
print v(xbgr.mr_n71074608)
print v(xbgr.mr_n71074928)
print v(xbgr.mr_n71075040)
print v(xbgr.mr_n71075360)
print v(xbgr.mr_n71075472)
print v(xbgr.mr_n71075792)
print v(xbgr.mr_n71075904)
print v(xbgr.mr_n71076224)
print v(xbgr.mr_n71076336)
print v(xbgr.mr_n71076656)
print v(xbgr.mr_n71076768)
print v(xbgr.mr_n71077088)
print v(xbgr.mr_n71077200)
print v(xbgr.mr_n71077520)
print v(xbgr.mr_n71077632)
print v(xbgr.mr_n71077952)
print v(xbgr.mr_n71078064)
print v(xbgr.mr_n71078384)
print v(xbgr.mr_n71078496)
print v(xbgr.mr_n71078816)
print v(xbgr.mr_n71078928)
print v(xbgr.mr_n71079248)
print v(xbgr.mr_n71079360)
print v(xbgr.mr_n71079680)
print v(xbgr.mr_n71079792)
print v(xbgr.mr_n71080112)
print v(xbgr.mr_n71080224)
print v(xbgr.mr_n71080544)
print v(xbgr.mr_n71080656)
print v(xbgr.mr_n71080976)
print v(xbgr.mr_n71081088)
print v(xbgr.mr_n71081408)
print v(xbgr.mr_n71081520)
print v(xbgr.mr_n71081840)
print v(xbgr.mr_n71081952)
print v(xbgr.mr_n71082272)
print v(xbgr.mr_n71082384)
print v(xbgr.mr_n71082704)
print v(xbgr.mr_n71082816)
print v(xbgr.mr_n71083136)
print v(xbgr.mr_n71083248)
print v(xbgr.mr_n71083568)
print v(xbgr.mr_n71083680)
print v(xbgr.mr_n71084000)
print v(xbgr.mr_n71084112)
print v(xbgr.mr_n71084432)
print v(xbgr.mr_n71084544)
print v(xbgr.mr_n71084864)
print v(xbgr.mr_n71084976)
print v(xbgr.mr_n71085296)
print v(xbgr.mr_n71085408)
print v(xbgr.mr_n71085728)
print v(xbgr.mr_n71085840)
print v(xbgr.mr_n71086160)
print v(xbgr.mr_n71086272)
print v(xbgr.mr_n71086592)
print v(xbgr.mr_n71086704)
print v(xbgr.mr_n71087024)
print v(xbgr.mr_n71087136)
print v(xbgr.mr_n71087456)
print v(xbgr.mr_n71087568)
print v(xbgr.mr_n71087888)
print v(xbgr.mr_n71088000)
print v(xbgr.mr_n71088320)
print v(xbgr.mr_n71088432)
print v(xbgr.mr_n71088752)
print v(xbgr.mr_n71088864)
print v(xbgr.mr_n71089184)
print v(xbgr.mr_n71089296)
print v(xbgr.mr_n71089616)
print v(xbgr.mr_n71089728)
print v(xbgr.mr_n71090048)
print v(xbgr.mr_n71090160)
print v(xbgr.mr_n71090480)
print v(xbgr.mr_n71090592)
print v(xbgr.mr_n71090912)
print v(xbgr.mr_n71091024)
print v(xbgr.mr_n71091344)
print v(xbgr.mr_n71091456)
print v(xbgr.mr_n71091776)
print v(xbgr.mr_n71091888)
print v(xbgr.mr_n71092208)
print v(xbgr.mr_n71092320)
print v(xbgr.mr_n71092640)
print v(xbgr.mr_n71092752)
print v(xbgr.mr_n71093072)
print v(xbgr.mr_n71093184)
print v(xbgr.mr_n71093504)
print v(xbgr.mr_n71093616)
print v(xbgr.mr_n71093936)
print v(xbgr.mr_n71094048)
print v(xbgr.mr_n71094368)
print v(xbgr.mr_n71094480)
print v(xbgr.mr_n71094800)
print v(xbgr.mr_n71094912)
print v(xbgr.mr_n71095232)
print v(xbgr.mr_n71095344)
print v(xbgr.mr_n71095664)
print v(xbgr.mr_n71095776)
print v(xbgr.mr_n71096096)
print v(xbgr.mr_n71096208)
print v(xbgr.mr_n71096528)
print v(xbgr.mr_n71096640)
print v(xbgr.mr_n71096960)
print v(xbgr.mr_n71097072)
print v(xbgr.mr_n71097392)
print v(xbgr.mr_n71097504)
print v(xbgr.mr_n71097824)
print v(xbgr.mr_n71097936)
print v(xbgr.mr_n71098256)
print v(xbgr.mr_n71098368)
print v(xbgr.mr_n71098688)
print v(xbgr.mr_n71098800)
print v(xbgr.mr_n71099120)
print v(xbgr.mr_n71099232)
print v(xbgr.mr_n71099552)
print v(xbgr.mr_n71099664)
print v(xbgr.mr_n71099984)
print v(xbgr.mr_n71100096)
print v(xbgr.mr_n71100416)
print v(xbgr.mr_n71100528)
print v(xbgr.mr_n71100848)
print v(xbgr.mr_n71100960)
print v(xbgr.mr_n71101280)
print v(xbgr.mr_n71101392)
print v(xbgr.mr_n71101712)
print v(xbgr.mr_n71101824)
print v(xbgr.mr_n71102144)
print v(xbgr.mr_n71102256)
print v(xbgr.mr_n71102576)
print v(xbgr.mr_n71102688)
print v(xbgr.mr_n71103008)
print v(xbgr.mr_n71103120)
print v(xbgr.mr_n71103440)
print v(xbgr.mr_n71103552)
print v(xbgr.mr_n71103872)
print v(xbgr.mr_n71103984)
print v(xbgr.mr_n71104304)
print v(xbgr.mr_n71104416)
print v(xbgr.mr_n71104736)
print v(xbgr.mr_n71104848)
print v(xbgr.mr_n71105168)
print v(xbgr.mr_n71105280)
print v(xbgr.mr_n71105600)
print v(xbgr.mr_n71105712)
print v(xbgr.mr_n71106032)
print v(xbgr.mr_n71106144)
print v(xbgr.mr_n71106464)
print v(xbgr.mr_n71106576)
print v(xbgr.mr_n71106896)
print v(xbgr.mr_n71107008)
print v(xbgr.mr_n71107328)
print v(xbgr.mr_n71107440)
print v(xbgr.mr_n71107760)
print v(xbgr.mr_n71107872)
print v(xbgr.mr_n71108192)
print v(xbgr.mr_n71108304)
print v(xbgr.mr_n71108624)
print v(xbgr.mr_n71108736)
print v(xbgr.mr_n71109056)
print v(xbgr.mr_n71109168)
print v(xbgr.mr_n71109488)
print v(xbgr.mr_n71109600)
print v(xbgr.mr_n71109920)
print v(xbgr.mr_n71110032)
print v(xbgr.mr_n71110352)
print v(xbgr.mr_n71110464)
print v(xbgr.mr_n71110784)
print v(xbgr.mr_n71110896)
print v(xbgr.mr_n71111216)
print v(xbgr.mr_n71111328)
print v(xbgr.mr_n71111648)
print v(xbgr.mr_n71111760)
print v(xbgr.mr_n71112080)
print v(xbgr.mr_n71112192)
print v(xbgr.mr_n71112512)
print v(xbgr.mr_n71112624)
print v(xbgr.mr_n71112944)
print v(xbgr.mr_n71113056)
print v(xbgr.mr_n71113376)
print v(xbgr.mr_n71113488)
print v(xbgr.mr_n71113808)
print v(xbgr.mr_n71113920)
print v(xbgr.mr_n71114240)
print v(xbgr.mr_n71114352)
print v(xbgr.mr_n71114672)
print v(xbgr.mr_n71114784)
print v(xbgr.mr_n71115104)
print v(xbgr.mr_n71115216)
print v(xbgr.mr_n71115536)
print v(xbgr.mr_n71115648)
print v(xbgr.mr_n71115968)
print v(xbgr.mr_n71116080)
print v(xbgr.mr_n71116400)
print v(xbgr.mr_n71116512)
print v(xbgr.mr_n71116832)
print v(xbgr.mr_n71116944)
print v(xbgr.mr_n71117264)
print v(xbgr.mr_n71117376)
print v(xbgr.mr_n71117696)
print v(xbgr.mr_n71117808)
print v(xbgr.mr_n71118128)
print v(xbgr.mr_n71118240)
print v(xbgr.mr_n71118560)
print v(xbgr.mr_n71118672)
print v(xbgr.mr_n71118992)
print v(xbgr.mr_n71119104)
print v(xbgr.mr_n71119424)
print v(xbgr.mr_n71119536)
print v(xbgr.mr_n71119856)
print v(xbgr.mr_n71119968)
print v(xbgr.mr_n71120288)
print v(xbgr.mr_n71120400)
print v(xbgr.mr_n71120720)
print v(xbgr.mr_n71120832)
print v(xbgr.mr_n71121152)
print v(xbgr.mr_n71121264)
print v(xbgr.mr_n71121584)
print v(xbgr.mr_n71121696)
print v(xbgr.mr_n71122016)
print v(xbgr.mr_n71122128)
print v(xbgr.mr_n71122448)
print v(xbgr.mr_n71122560)
print v(xbgr.mr_n71122880)
print v(xbgr.mr_n71122992)
print v(xbgr.mr_n71123312)
print v(xbgr.mr_n71123424)
print v(xbgr.mr_n71123744)
print v(xbgr.mr_n71123856)
print v(xbgr.mr_n71124176)
print v(xbgr.mr_n71124288)
print v(xbgr.mr_n71124608)
print v(xbgr.mr_n71124720)
print v(xbgr.mr_n71125040)
print v(xbgr.mr_n71125152)
print v(xbgr.mr_n71125472)
print v(xbgr.mr_n71125584)
print v(xbgr.mr_n71125904)
print v(xbgr.mr_n71126016)
print v(xbgr.mr_n71126336)
print v(xbgr.mr_n71126448)
print v(xbgr.mr_n71126768)
print v(xbgr.mr_n71126880)
print v(xbgr.mr_n71127200)
print v(xbgr.mr_n71127312)
print v(xbgr.mr_n71127632)
print v(xbgr.mr_n71127744)
print v(xbgr.mr_n71128064)
print v(xbgr.mr_n71128176)
print v(xbgr.mr_n71128496)
print v(xbgr.mr_n71128608)
print v(xbgr.mr_n71128928)
print v(xbgr.mr_n71129040)
print v(xbgr.mr_n71129360)
print v(xbgr.mr_n71129472)
print v(xbgr.mr_n71129792)
print v(xbgr.mr_n71129904)
print v(xbgr.mr_n71130224)
print v(xbgr.mr_n71130336)
print v(xbgr.mr_n71130656)
print v(xbgr.mr_n71130768)
print v(xbgr.mr_n71131088)
print v(xbgr.mr_n71131200)
print v(xbgr.mr_n71131520)
print v(xbgr.mr_n71131632)
print v(xbgr.mr_n71131952)
print v(xbgr.mr_n71132064)
print v(xbgr.mr_n71132384)
print v(xbgr.mr_n71132496)
print v(xbgr.mr_n71132816)
print v(xbgr.mr_n71132928)
print v(xbgr.mr_n71133248)
print v(xbgr.mr_n71133360)
print v(xbgr.mr_n71133680)
print v(xbgr.mr_n71133792)
print v(xbgr.mr_n71134112)
print v(xbgr.mr_n71134224)
print v(xbgr.mr_n71134544)
print v(xbgr.mr_n71134656)
print v(xbgr.mr_n71134976)
print v(xbgr.mr_n71135088)
print v(xbgr.mr_n71135408)
print v(xbgr.mr_n71135520)
print v(xbgr.mr_n71135840)
print v(xbgr.mr_n71135952)
print v(xbgr.mr_n71136272)
print v(xbgr.mr_n71136384)
print v(xbgr.mr_n71136704)
print v(xbgr.mr_n71136816)
print v(xbgr.mr_n71137136)
print v(xbgr.mr_n71137248)
print v(xbgr.mr_n71137568)
print v(xbgr.mr_n71137680)
print v(xbgr.mr_n71138000)
print v(xbgr.mr_n71138112)
print v(xbgr.mr_n71138432)
print v(xbgr.mr_n71138544)
print v(xbgr.mr_n71138864)
print v(xbgr.mr_n71138976)
print v(xbgr.mr_n71139296)
print v(xbgr.mr_n71139408)
print v(xbgr.mr_n71139728)
print v(xbgr.mr_n71139840)
print v(xbgr.mr_n71140160)
print v(xbgr.mr_n71140272)
print v(xbgr.mr_n71140592)
print v(xbgr.mr_n71140704)
print v(xbgr.mr_n71141024)
print v(xbgr.mr_n71141136)
print v(xbgr.mr_n71141456)
print v(xbgr.mr_n71141568)
print v(xbgr.mr_n71141888)
print v(xbgr.mr_n71142000)
print v(xbgr.mr_n71142320)
print v(xbgr.mr_n71142432)
print v(xbgr.mr_n71142752)
print v(xbgr.mr_n71142864)
print v(xbgr.mr_n71143184)
print v(xbgr.mr_n71143296)
print v(xbgr.mr_n71143616)
print v(xbgr.mr_n71143728)
print v(xbgr.mr_n71144048)
print v(xbgr.mr_n71144160)
print v(xbgr.mr_n71144480)
print v(xbgr.mr_n71144592)
print v(xbgr.mr_n71144912)
print v(xbgr.mr_n71145024)
print v(xbgr.mr_n71145344)
print v(xbgr.mr_n71145456)
print v(xbgr.mr_n71145776)
print v(xbgr.mr_n71145888)
print v(xbgr.mr_n71146208)
print v(xbgr.mr_n71146320)
print v(xbgr.mr_n71146640)
print v(xbgr.mr_n71146752)
print v(xbgr.mr_n71147072)
print v(xbgr.mr_n71147184)
print v(xbgr.mr_n71147504)
print v(xbgr.mr_n71147616)
print v(xbgr.mr_n71147936)
print v(xbgr.mr_n71148048)
print v(xbgr.mr_n71148368)
print v(xbgr.mr_n71148480)
print v(xbgr.mr_n71148912)
print v(xbgr.mr_n71149232)
print v(xbgr.mr_n71149344)
print v(xbgr.mr_n71149664)
print v(xbgr.mr_n71149776)
print v(xbgr.mr_n71150096)
print v(xbgr.mr_n71150208)
print v(xbgr.mr_n71150528)
print v(xbgr.mr_n71150640)
print v(xbgr.mr_n71150960)
print v(xbgr.mr_n71151072)
print v(xbgr.mr_n71151392)
print v(xbgr.mr_n71151504)
print v(xbgr.mr_n71151824)
print v(xbgr.mr_n71151936)
print v(xbgr.mr_n71152256)
print v(xbgr.mr_n71152368)
print v(xbgr.mr_n71152688)
print v(xbgr.mr_n71152800)
print v(xbgr.mr_n71153120)
print v(xbgr.mr_n71153232)
print v(xbgr.mr_n71153552)
print v(xbgr.mr_n71153664)
print v(xbgr.mr_n71153984)
print v(xbgr.mr_n71154096)
print v(xbgr.mr_n71154416)
print v(xbgr.mr_n71154528)
print v(xbgr.mr_n71154960)
print v(xbgr.mr_n71155280)
print v(xbgr.mr_n71155392)
print v(xbgr.mr_n71155712)
print v(xbgr.mr_n71155824)
print v(xbgr.mr_n71156144)
print v(xbgr.mr_n71156256)
print v(xbgr.mr_n71156576)
print v(xbgr.mr_n71156688)
print v(xbgr.mr_n71157008)
print v(xbgr.mr_n71157120)
print v(xbgr.mr_n71157440)
print v(xbgr.mr_n71157552)
print v(xbgr.mr_n71157872)
print v(xbgr.mr_n71157984)
print v(xbgr.mr_n71158304)
print v(xbgr.mr_n71158416)
print v(xbgr.mr_n71158736)
print v(xbgr.mr_n71158848)
print v(xbgr.mr_n71159168)
print v(xbgr.mr_n71159280)
print v(xbgr.mr_n71159600)
print v(xbgr.mr_n71159712)
print v(xbgr.mr_n71160032)
print v(xbgr.mr_n71160144)
print v(xbgr.mr_n71160464)
print v(xbgr.mr_n71160576)
print v(xbgr.mr_n71160896)
print v(xbgr.mr_n71161008)
print v(xbgr.mr_n71161328)
print v(xbgr.mr_n71161440)
print v(xbgr.mr_n71161760)
print v(xbgr.mr_n71161872)
print v(xbgr.mr_n71162192)
print v(xbgr.mr_n71162304)
print v(xbgr.mr_n71162624)
print v(xbgr.mr_n71162736)
print v(xbgr.mr_n71163056)
print v(xbgr.mr_n71163168)
print v(xbgr.mr_n71163488)
print v(xbgr.mr_n71163600)
print v(xbgr.mr_n71163920)
print v(xbgr.mr_n71164032)
print v(xbgr.mr_n71164352)
print v(xbgr.mr_n71164464)
print v(xbgr.mr_n71164784)
print v(xbgr.mr_n71164896)
print v(xbgr.mr_n71165216)
print v(xbgr.mr_n71165328)
print v(xbgr.mr_n71165648)
print v(xbgr.mr_n71165760)
print v(xbgr.mr_n71166080)
print v(xbgr.mr_n71166192)
print v(xbgr.mr_n71166512)
print v(xbgr.mr_n71166624)
print v(xbgr.mr_n71166944)
print v(xbgr.mr_n71167056)
print v(xbgr.mr_n71167376)
print v(xbgr.mr_n71167488)
print v(xbgr.mr_n71167808)
print v(xbgr.mr_n71167920)
print v(xbgr.mr_n71168240)
print v(xbgr.mr_n71168352)
print v(xbgr.mr_n71168672)
print v(xbgr.mr_n71168784)
print v(xbgr.mr_n71169104)
print v(xbgr.mr_n71169216)
print v(xbgr.mr_n71169536)
print v(xbgr.mr_n71169648)
print v(xbgr.mr_n71169968)
print v(xbgr.mr_n71170080)
print v(xbgr.mr_n71170400)
print v(xbgr.mr_n71170512)
print v(xbgr.mr_n71170832)
print v(xbgr.mr_n71170944)
print v(xbgr.mr_n71171264)
print v(xbgr.mr_n71171376)
print v(xbgr.mr_n71171696)
print v(xbgr.mr_n71171808)
print v(xbgr.mr_n71172128)
print v(xbgr.mr_n71172240)
print v(xbgr.mr_n71172560)
print v(xbgr.mr_n71172672)
print v(xbgr.mr_n71172992)
print v(xbgr.mr_n71173104)
print v(xbgr.mr_n71173424)
print v(xbgr.mr_n71173536)
print v(xbgr.mr_n71173856)
print v(xbgr.mr_n71173968)
print v(xbgr.mr_n71174288)
print v(xbgr.mr_n71174400)
print v(xbgr.mr_n71174720)
print v(xbgr.mr_n71174832)
print v(xbgr.mr_n71175152)
print v(xbgr.mr_n71175264)
print v(xbgr.mr_n71175584)
print v(xbgr.mr_n71175696)
print v(xbgr.mr_n71176016)
print v(xbgr.mr_n71176128)
print v(xbgr.mr_n71176448)
print v(xbgr.mr_n71176560)
print v(xbgr.mr_n71176880)
print v(xbgr.mr_n71176992)
print v(xbgr.mr_n71177312)
print v(xbgr.mr_n71177424)
print v(xbgr.mr_n71177744)
print v(xbgr.mr_n71177856)
print v(xbgr.mr_n71178176)
print v(xbgr.mr_n71178288)
print v(xbgr.mr_n71178608)
print v(xbgr.mr_n71178720)
print v(xbgr.mr_n71179040)
print v(xbgr.mr_n71179152)
print v(xbgr.mr_n71179472)
print v(xbgr.mr_n71179584)
print v(xbgr.mr_n71179904)
print v(xbgr.mr_n71180016)
print v(xbgr.mr_n71180336)
print v(xbgr.mr_n71180448)
print v(xbgr.mr_n71180768)
print v(xbgr.mr_n71180880)
print v(xbgr.mr_n71181200)
print v(xbgr.mr_n71181312)
print v(xbgr.mr_n71181632)
print v(xbgr.mr_n71181744)
print v(xbgr.mr_n71182064)
print v(xbgr.mr_n71182176)
print v(xbgr.mr_n71182496)
print v(xbgr.mr_n71182608)
print v(xbgr.mr_n71182928)
print v(xbgr.mr_n71183040)
print v(xbgr.mr_n71183360)
print v(xbgr.mr_n71183472)
print v(xbgr.mr_n71183792)
print v(xbgr.mr_n71183904)
print v(xbgr.mr_n71184224)
print v(xbgr.mr_n71184336)
print v(xbgr.mr_n71184656)
print v(xbgr.mr_n71184768)
print v(xbgr.mr_n71185088)
print v(xbgr.mr_n71185200)
print v(xbgr.mr_n71185520)
print v(xbgr.mr_n71185632)
print v(xbgr.mr_n71185952)
print v(xbgr.mr_n71186064)
print v(xbgr.mr_n71186384)
print v(xbgr.mr_n71186496)
print v(xbgr.mr_n71186816)
print v(xbgr.mr_n71186928)
print v(xbgr.mr_n71187248)
print v(xbgr.mr_n71187360)
print v(xbgr.mr_n71187792)
print v(xbgr.mr_n71188112)
print v(xbgr.mr_n71188224)
print v(xbgr.mr_n71188544)
print v(xbgr.mr_n71188656)
print v(xbgr.mr_n71188976)
print v(xbgr.mr_n71189088)
print v(xbgr.mr_n71189520)
print v(xbgr.mr_n71189840)
print v(xbgr.mr_n71189952)
print v(xbgr.mr_n71190272)
print v(xbgr.mr_n71190384)
print v(xbgr.mr_n71190704)
print v(xbgr.mr_n71190816)
print v(xbgr.mr_n71191248)
print v(xbgr.mr_n71191568)
print v(xbgr.mr_n71191680)
print v(xbgr.mr_n71192000)
print v(xbgr.mr_n71192112)
print v(xbgr.mr_n71192432)
print v(xbgr.mr_n71192544)
print v(xbgr.mr_n71192864)
print v(xbgr.mr_n71192976)
print v(xbgr.mr_n71193296)
print v(xbgr.mr_n71193408)
print v(xbgr.mr_n71193728)
print v(xbgr.mr_n71193840)
print v(xbgr.mr_n71194160)
print v(xbgr.mr_n71194272)
print v(xbgr.mr_n71194592)
print v(xbgr.mr_n71194704)
print v(xbgr.mr_n71195024)
print v(xbgr.mr_n71195136)
print v(xbgr.mr_n71195456)
print v(xbgr.mr_n71195568)
print v(xbgr.mr_n71195888)
print v(xbgr.mr_n71196000)
print v(xbgr.mr_n71196320)
print v(xbgr.mr_n71196432)
print v(xbgr.mr_n71196752)
print v(xbgr.mr_n71196864)
print v(xbgr.mr_n71197184)
print v(xbgr.mr_n71197296)
print v(xbgr.mr_n71197616)
print v(xbgr.mr_n71197728)
print v(xbgr.mr_n71198048)
print v(xbgr.mr_n71198160)
print v(xbgr.mr_n71198480)
print v(xbgr.mr_n71198592)
print v(xbgr.mr_n71198912)
print v(xbgr.mr_n71199024)
print v(xbgr.mr_n71199344)
print v(xbgr.mr_n71199456)
print v(xbgr.mr_n71199776)
print v(xbgr.mr_n71199888)
print v(xbgr.mr_n71200208)
print v(xbgr.mr_n71200320)
print v(xbgr.mr_n71200640)
print v(xbgr.mr_n71200752)
print v(xbgr.mr_n71201072)
print v(xbgr.mr_n71201184)
print v(xbgr.mr_n71201504)
print v(xbgr.mr_n71201616)
print v(xbgr.mr_n71201936)
print v(xbgr.mr_n71202048)
print v(xbgr.mr_n71202368)
print v(xbgr.mr_n71202480)
print v(xbgr.mr_n71202800)
print v(xbgr.mr_n71202912)
print v(xbgr.mr_n71203232)
print v(xbgr.mr_n71203344)
print v(xbgr.mr_n71203664)
print v(xbgr.mr_n71203776)
print v(xbgr.mr_n71204096)
print v(xbgr.mr_n71204208)
print v(xbgr.mr_n71204528)
print v(xbgr.mr_n71204640)
print v(xbgr.mr_n71204960)
print v(xbgr.mr_n71205072)
print v(xbgr.mr_n71205392)
print v(xbgr.mr_n71205504)
print v(xbgr.mr_n71205824)
print v(xbgr.mr_n71205936)
print v(xbgr.mr_n71206256)
print v(xbgr.mr_n71206368)
print v(xbgr.mr_n71206688)
print v(xbgr.mr_n71206800)
print v(xbgr.mr_n71207120)
print v(xbgr.mr_n71207232)
print v(xbgr.mr_n71207552)
print v(xbgr.mr_n71207664)
print v(xbgr.mr_n71207984)
print v(xbgr.mr_n71208096)
print v(xbgr.mr_n71208416)
print v(xbgr.mr_n71208528)
print v(xbgr.mr_n71208848)
print v(xbgr.mr_n71208960)
print v(xbgr.mr_n71209280)
print v(xbgr.mr_n71209392)
print v(xbgr.mr_n71209712)
print v(xbgr.mr_n71209824)
print v(xbgr.mr_n71210144)
print v(xbgr.mr_n71210256)
print v(xbgr.mr_n71210576)
print v(xbgr.mr_n71210688)
print v(xbgr.mr_n71211008)
print v(xbgr.mr_n71211120)
print v(xbgr.mr_n71211552)
print v(xbgr.mr_n71211984)
print v(xbgr.mr_n71212416)
print v(xbgr.mr_n71212848)
print v(xbgr.mr_n71213280)
print v(xbgr.mr_n71213712)
print v(xbgr.mr_n71214144)
print v(xbgr.mr_n71214576)
print v(xbgr.mr_n71215008)
print v(xbgr.mr_n71215440)
print v(xbgr.mr_n71215872)
print v(xbgr.mr_n71216304)
print v(xbgr.mr_n71216736)
print v(xbgr.mr_n71217168)
print v(xbgr.mr_n71217600)
print v(xbgr.mr_n71218032)
print v(xbgr.mr_n71218464)
print v(xbgr.mr_n71218896)
print v(xbgr.mr_n71219328)
print v(xbgr.mr_n71219760)
print v(xbgr.mr_n71220192)
print v(xbgr.mr_n71220624)
print v(xbgr.mr_n71221056)
print v(xbgr.mr_n71221488)
print v(xbgr.mr_n71221920)
print v(xbgr.mr_n71222352)
print v(xbgr.mr_n71222784)
print v(xbgr.mr_n71223216)
print v(xbgr.mr_n71223648)
print v(xbgr.mr_n71224080)
print v(xbgr.mr_n71224512)
print v(xbgr.mr_n71224944)
print v(xbgr.mr_n71225376)
print v(xbgr.mr_n71225808)
print v(xbgr.mr_n71226240)
print v(xbgr.mr_n71226672)
print v(xbgr.mr_n71227104)
print v(xbgr.mr_n71227536)
print v(xbgr.mr_n71227968)
print v(xbgr.mr_n71228400)
print v(xbgr.mr_n71228832)
print v(xbgr.mr_n71229264)
print v(xbgr.mr_n71229696)
print v(xbgr.mr_n71230128)
print v(xbgr.mr_n71230560)
print v(xbgr.mr_n71230992)
print v(xbgr.mr_n71231424)
print v(xbgr.mr_n71231856)
print v(xbgr.mr_n71232288)
print v(xbgr.mr_n71232720)
print v(xbgr.mr_n71233152)
print v(xbgr.mr_n71233584)
print v(xbgr.mr_n71234016)
print v(xbgr.mr_n71234448)
print v(xbgr.mr_n71234880)
print v(xbgr.mr_n71235312)
print v(xbgr.mr_n71235744)
print v(xbgr.mr_n71236176)
print v(xbgr.mr_n71236608)
print v(xbgr.mr_n71237040)
print v(xbgr.mr_n71237472)
print v(xbgr.mr_n71237904)
print v(xbgr.mr_n71238336)
print v(xbgr.mr_n71238768)
print v(xbgr.mr_n71239200)
print v(xbgr.mr_n71239632)
print v(xbgr.mr_n71240064)
print v(xbgr.mr_n71240496)
print v(xbgr.mr_n71240928)
print v(xbgr.mr_n71241360)
print v(xbgr.mr_n71241792)
print v(xbgr.mr_n71242224)
print v(xbgr.mr_n71242656)
print v(xbgr.mr_n71243088)
print v(xbgr.mr_n71243520)
print v(xbgr.mr_n71243952)
print v(xbgr.mr_n71244384)
print v(xbgr.mr_n71244816)
print v(xbgr.mr_n71245248)
print v(xbgr.mr_n71245680)
print v(xbgr.mr_n71246000)
print v(xbgr.mr_n71246112)
print v(xbgr.mr_n71246544)
print v(xbgr.mr_n71246864)
print v(xbgr.mr_n71246976)
print v(xbgr.mr_n71247296)
print v(xbgr.mr_n71247408)
print v(xbgr.mr_n71247728)
print v(xbgr.mr_n71247840)
print v(xbgr.mr_n71248160)
print v(xbgr.mr_n71248272)
print v(xbgr.mr_n71248592)
print v(xbgr.mr_n71248704)
print v(xbgr.mr_n71249024)
print v(xbgr.mr_n71249136)
print v(xbgr.mr_n71249456)
print v(xbgr.mr_n71249568)
print v(xbgr.mr_n71249888)
print v(xbgr.mr_n71250000)
print v(xbgr.mr_n71250320)
print v(xbgr.mr_n71250432)
print v(xbgr.mr_n71250752)
print v(xbgr.mr_n71250864)
print v(xbgr.mr_n71251296)
print v(xbgr.mr_n71251728)
print v(xbgr.mr_n71252160)
print v(xbgr.mr_n71252592)
print v(xbgr.mr_n71253024)
print v(xbgr.mr_n71253456)
print v(xbgr.mr_n71253888)
print v(xbgr.mr_n71254320)
print v(xbgr.mr_n71254752)
print v(xbgr.mr_n71255184)
print v(xbgr.mr_n71255616)
print v(xbgr.mr_n71256048)
print v(xbgr.mr_n71256480)
print v(xbgr.mr_n71256912)
print v(xbgr.mr_n71257344)
print v(xbgr.mr_n71257776)
print v(xbgr.mr_n71258208)
print v(xbgr.mr_n71258640)
print v(xbgr.mr_n71259072)
print v(xbgr.mr_n71259504)
print v(xbgr.mr_n71259936)
print v(xbgr.mr_n71260368)
print v(xbgr.mr_n71260800)
print v(xbgr.mr_n71261232)
print v(xbgr.mr_n71261664)
print v(xbgr.mr_n71262096)
print v(xbgr.mr_n71262528)
print v(xbgr.mr_n71262800)
print v(xbgr.mr_n71262912)
print v(xbgr.mr_n71263232)
print v(xbgr.mr_n71263344)
print v(xbgr.mr_n71263664)
print v(xbgr.mr_n71263776)
print v(xbgr.mr_n71264096)
print v(xbgr.mr_n71264208)
print v(xbgr.mr_n71264528)
print v(xbgr.mr_n71264640)
print v(xbgr.mr_n71264960)
print v(xbgr.mr_n71265072)
print v(xbgr.mr_n71265392)
print v(xbgr.mr_n71265504)
print v(xbgr.mr_n71265824)
print v(xbgr.mr_n71265936)
print v(xbgr.mr_n71266256)
print v(xbgr.mr_n71266368)
print v(xbgr.mr_n71266688)
print v(xbgr.mr_n71266800)
print v(xbgr.mr_n71267120)
print v(xbgr.mr_n71267232)
print v(xbgr.mr_n71267552)
print v(xbgr.mr_n71267664)
print v(xbgr.mr_n71267984)
print v(xbgr.mr_n71268096)
print v(xbgr.mr_n71268416)
print v(xbgr.mr_n71268528)
print v(xbgr.mr_n71268848)
print v(xbgr.mr_n71268960)
print v(xbgr.mr_n71269280)
print v(xbgr.mr_n71269392)
print v(xbgr.mr_n71269712)
print v(xbgr.mr_n71269824)
print v(xbgr.mr_n71270144)
print v(xbgr.mr_n71270256)
print v(xbgr.mr_n71270576)
print v(xbgr.mr_n71270688)
print v(xbgr.mr_n71271008)
print v(xbgr.mr_n71271120)
print v(xbgr.mr_n71271440)
print v(xbgr.mr_n71271552)
print v(xbgr.mr_n71271872)
print v(xbgr.mr_n71271984)
print v(xbgr.mr_n71272304)
print v(xbgr.mr_n71272416)
print v(xbgr.mr_n71272736)
print v(xbgr.mr_n71272848)
print v(xbgr.mr_n71273168)
print v(xbgr.mr_n71273280)
print v(xbgr.mr_n71273600)
print v(xbgr.mr_n71273712)
print v(xbgr.mr_n71274032)
print v(xbgr.mr_n71274144)
print v(xbgr.mr_n71274464)
print v(xbgr.mr_n71274576)
print v(xbgr.mr_n71274896)
print v(xbgr.mr_n71275008)
print v(xbgr.mr_n71275328)
print v(xbgr.mr_n71275440)
print v(xbgr.mr_n71275760)
print v(xbgr.mr_n71275872)
print v(xbgr.mr_n71276192)
print v(xbgr.mr_n71276304)
print v(xbgr.mr_n71276624)
print v(xbgr.mr_n71276736)
print v(xbgr.mr_n71277056)
print v(xbgr.mr_n71277168)
print v(xbgr.mr_n71277488)
print v(xbgr.mr_n71277600)
print v(xbgr.mr_n71277920)
print v(xbgr.mr_n71278032)
print v(xbgr.mr_n71278352)
print v(xbgr.mr_n71278464)
print v(xbgr.mr_n71278784)
print v(xbgr.mr_n71278896)
print v(xbgr.mr_n71279216)
print v(xbgr.mr_n71279328)
print v(xbgr.mr_n71279648)
print v(xbgr.mr_n71279760)
print v(xbgr.mr_n71280080)
print v(xbgr.mr_n71280192)
print v(xbgr.mr_n71280512)
print v(xbgr.mr_n71280624)
print v(xbgr.mr_n71280944)
print v(xbgr.mr_n71281056)
print v(xbgr.mr_n71281376)
print v(xbgr.mr_n71281488)
print v(xbgr.mr_n71281808)
print v(xbgr.mr_n71281920)
print v(xbgr.mr_n71282240)
print v(xbgr.mr_n71282352)
print v(xbgr.mr_n71282672)
print v(xbgr.mr_n71282784)
print v(xbgr.mr_n71283104)
print v(xbgr.mr_n71283216)
print v(xbgr.mr_n71283536)
print v(xbgr.mr_n71283648)
print v(xbgr.mr_n71283968)
print v(xbgr.mr_n71284080)
print v(xbgr.mr_n71284400)
print v(xbgr.mr_n71284512)
print v(xbgr.mr_n71284832)
print v(xbgr.mr_n71284944)
print v(xbgr.mr_n71285264)
print v(xbgr.mr_n71285376)
print v(xbgr.mr_n71285696)
print v(xbgr.mr_n71285808)
print v(xbgr.mr_n71286128)
print v(xbgr.mr_n71286240)
print v(xbgr.mr_n71286560)
print v(xbgr.mr_n71286672)
print v(xbgr.mr_n71286992)
print v(xbgr.mr_n71287104)
print v(xbgr.mr_n71287424)
print v(xbgr.mr_n71287536)
print v(xbgr.mr_n71287856)
print v(xbgr.mr_n71287968)
print v(xbgr.mr_n71288288)
print v(xbgr.mr_n71288400)
print v(xbgr.mr_n71288720)
print v(xbgr.mr_n71288832)
print v(xbgr.mr_n71289152)
print v(xbgr.mr_n71289264)
print v(xbgr.mr_n71289584)
print v(xbgr.mr_n71289696)
print v(xbgr.mr_n71290016)
print v(xbgr.mr_n71290128)
print v(xbgr.mr_n71290448)
print v(xbgr.mr_n71290560)
print v(xbgr.mr_n71290880)
print v(xbgr.mr_n71290992)
print v(xbgr.mr_n71291312)
print v(xbgr.mr_n71291424)
print v(xbgr.mr_n71291744)
print v(xbgr.mr_n71291856)
print v(xbgr.mr_n71292176)
print v(xbgr.mr_n71292288)
print v(xbgr.mr_n71292608)
print v(xbgr.mr_n71292720)
print v(xbgr.mr_n71293040)
print v(xbgr.mr_n71293152)
print v(xbgr.mr_n71293472)
print v(xbgr.mr_n71293584)
print v(xbgr.mr_n71293904)
print v(xbgr.mr_n71294016)
print v(xbgr.mr_n71294336)
print v(xbgr.mr_n71294448)
print v(xbgr.mr_n71294768)
print v(xbgr.mr_n71294880)
print v(xbgr.mr_n71295200)
print v(xbgr.mr_n71295312)
print v(xbgr.mr_n71295632)
print v(xbgr.mr_n71295744)
print v(xbgr.mr_n71296064)
print v(xbgr.mr_n71296176)
print v(xbgr.mr_n71296496)
print v(xbgr.mr_n71296608)
print v(xbgr.mr_n71296928)
print v(xbgr.mr_n71297040)
print v(xbgr.mr_n71297360)
print v(xbgr.mr_n71297472)
print v(xbgr.mr_n71297792)
print v(xbgr.mr_n71297904)
print v(xbgr.mr_n71298224)
print v(xbgr.mr_n71298336)
print v(xbgr.mr_n71298656)
print v(xbgr.mr_n71298768)
print v(xbgr.mr_n71299088)
print v(xbgr.mr_n71299200)
print v(xbgr.mr_n71299520)
print v(xbgr.mr_n71299632)
print v(xbgr.mr_n71299952)
print v(xbgr.mr_n71300064)
print v(xbgr.mr_n71300384)
print v(xbgr.mr_n71300496)
print v(xbgr.mr_n71300816)
print v(xbgr.mr_n71300928)
print v(xbgr.mr_n71301248)
print v(xbgr.mr_n71301360)
print v(xbgr.mr_n71301680)
print v(xbgr.mr_n71301792)
print v(xbgr.mr_n71302112)
print v(xbgr.mr_n71302224)
print v(xbgr.mr_n71302544)
print v(xbgr.mr_n71302656)
print v(xbgr.mr_n71302976)
print v(xbgr.mr_n71303088)
print v(xbgr.mr_n71303408)
print v(xbgr.mr_n71303520)
print v(xbgr.mr_n71303840)
print v(xbgr.mr_n71303952)
print v(xbgr.mr_n71304272)
print v(xbgr.mr_n71304384)
print v(xbgr.mr_n71304704)
print v(xbgr.mr_n71304816)
print v(xbgr.mr_n71305136)
print v(xbgr.mr_n71305248)
print v(xbgr.mr_n71305568)
print v(xbgr.mr_n71305680)
print v(xbgr.mr_n71306000)
print v(xbgr.mr_n71306112)
print v(xbgr.mr_n71306432)
print v(xbgr.mr_n71306544)
print v(xbgr.mr_n71306864)
print v(xbgr.mr_n71306976)
print v(xbgr.mr_n71307296)
print v(xbgr.mr_n71307408)
print v(xbgr.mr_n71307728)
print v(xbgr.mr_n71307840)
print v(xbgr.mr_n71308160)
print v(xbgr.mr_n71308272)
print v(xbgr.mr_n71308592)
print v(xbgr.mr_n71308704)
print v(xbgr.mr_n71309024)
print v(xbgr.mr_n71309136)
print v(xbgr.mr_n71309456)
print v(xbgr.mr_n71309568)
print v(xbgr.mr_n71309888)
print v(xbgr.mr_n71310000)
print v(xbgr.mr_n71310320)
print v(xbgr.mr_n71310432)
print v(xbgr.mr_n71310752)
print v(xbgr.mr_n71310864)
print v(xbgr.mr_n71311184)
print v(xbgr.mr_n71311296)
print v(xbgr.mr_n71311616)
print v(xbgr.mr_n71311728)
print v(xbgr.mr_n71312048)
print v(xbgr.mr_n71312160)
print v(xbgr.mr_n71312480)
print v(xbgr.mr_n71312592)
print v(xbgr.mr_n71312912)
print v(xbgr.mr_n71313024)
print v(xbgr.mr_n71313344)
print v(xbgr.mr_n71313456)
print v(xbgr.mr_n71313776)
print v(xbgr.mr_n71313888)
print v(xbgr.mr_n71314208)
print v(xbgr.mr_n71314320)
print v(xbgr.mr_n71314640)
print v(xbgr.mr_n71314752)
print v(xbgr.mr_n71315072)
print v(xbgr.mr_n71315184)
print v(xbgr.mr_n71315504)
print v(xbgr.mr_n71315616)
print v(xbgr.mr_n71315936)
print v(xbgr.mr_n71316048)
print v(xbgr.mr_n71316368)
print v(xbgr.mr_n71316480)
print v(xbgr.mr_n71316800)
print v(xbgr.mr_n71316912)
print v(xbgr.mr_n71317232)
print v(xbgr.mr_n71317344)
print v(xbgr.mr_n71317664)
print v(xbgr.mr_n71317776)
print v(xbgr.mr_n71318096)
print v(xbgr.mr_n71318208)
print v(xbgr.mr_n71318528)
print v(xbgr.mr_n71318640)
print v(xbgr.mr_n71318960)
print v(xbgr.mr_n71319072)
print v(xbgr.mr_n71319392)
print v(xbgr.mr_n71319504)
print v(xbgr.mr_n71319824)
print v(xbgr.mr_n71319936)
print v(xbgr.mr_n71320256)
print v(xbgr.mr_n71320368)
print v(xbgr.mr_n71320688)
print v(xbgr.mr_n71320800)
print v(xbgr.mr_n71321120)
print v(xbgr.mr_n71321232)
print v(xbgr.mr_n71321552)
print v(xbgr.mr_n71321664)
print v(xbgr.mr_n71321984)
print v(xbgr.mr_n71322096)
print v(xbgr.mr_n71322416)
print v(xbgr.mr_n71322528)
print v(xbgr.mr_n71322848)
print v(xbgr.mr_n71322960)
print v(xbgr.mr_n71323280)
print v(xbgr.mr_n71323392)
print v(xbgr.mr_n71323712)
print v(xbgr.mr_n71323824)
print v(xbgr.mr_n71324144)
print v(xbgr.mr_n71324256)
print v(xbgr.mr_n71324576)
print v(xbgr.mr_n71324688)
print v(xbgr.mr_n71325008)
print v(xbgr.mr_n71325120)
print v(xbgr.mr_n71325440)
print v(xbgr.mr_n71325552)
print v(xbgr.mr_n71325872)
print v(xbgr.mr_n71325984)
print v(xbgr.mr_n71326304)
print v(xbgr.mr_n71326416)
print v(xbgr.mr_n71326736)
print v(xbgr.mr_n71326848)
print v(xbgr.mr_n71327168)
print v(xbgr.mr_n71327280)
print v(xbgr.mr_n71327600)
print v(xbgr.mr_n71327712)
print v(xbgr.mr_n71328032)
print v(xbgr.mr_n71328144)
print v(xbgr.mr_n71328464)
print v(xbgr.mr_n71328576)
print v(xbgr.mr_n71328896)
print v(xbgr.mr_n71329008)
print v(xbgr.mr_n71329328)
print v(xbgr.mr_n71329440)
print v(xbgr.mr_n71329760)
print v(xbgr.mr_n71329872)
print v(xbgr.mr_n71330192)
print v(xbgr.mr_n71330304)
print v(xbgr.mr_n71330624)
print v(xbgr.mr_n71330736)
print v(xbgr.mr_n71331056)
print v(xbgr.mr_n71331168)
print v(xbgr.mr_n71331488)
print v(xbgr.mr_n71331600)
print v(xbgr.mr_n71331920)
print v(xbgr.mr_n71332032)
print v(xbgr.mr_n71332352)
print v(xbgr.mr_n71332464)
print v(xbgr.mr_n71332784)
print v(xbgr.mr_n71332896)
print v(xbgr.mr_n71333216)
print v(xbgr.mr_n71333328)
print v(xbgr.mr_n71333648)
print v(xbgr.mr_n71333760)
print v(xbgr.mr_n71334080)
print v(xbgr.mr_n71334192)
print v(xbgr.mr_n71334512)
print v(xbgr.mr_n71334624)
print v(xbgr.mr_n71334944)
print v(xbgr.mr_n71335056)
print v(xbgr.mr_n71335376)
print v(xbgr.mr_n71335488)
print v(xbgr.mr_n71335808)
print v(xbgr.mr_n71335920)
print v(xbgr.mr_n71336240)
print v(xbgr.mr_n71336352)
print v(xbgr.mr_n71336672)
print v(xbgr.mr_n71336784)
print v(xbgr.mr_n71337104)
print v(xbgr.mr_n71337216)
print v(xbgr.mr_n71337536)
print v(xbgr.mr_n71337648)
print v(xbgr.mr_n71337968)
print v(xbgr.mr_n71338080)
print v(xbgr.mr_n71338400)
print v(xbgr.mr_n71338512)
print v(xbgr.mr_n71338832)
print v(xbgr.mr_n71338944)
print v(xbgr.mr_n71339264)
print v(xbgr.mr_n71339376)
print v(xbgr.mr_n71339696)
print v(xbgr.mr_n71339808)
print v(xbgr.mr_n71340128)
print v(xbgr.mr_n71340240)
print v(xbgr.mr_n71340560)
print v(xbgr.mr_n71340672)
print v(xbgr.mr_n71340992)
print v(xbgr.mr_n71341104)
print v(xbgr.mr_n71341424)
print v(xbgr.mr_n71341536)
print v(xbgr.mr_n71341856)
print v(xbgr.mr_n71341968)
print v(xbgr.mr_n71342288)
print v(xbgr.mr_n71342400)
print v(xbgr.mr_n71342720)
print v(xbgr.mr_n71342832)
print v(xbgr.mr_n71343152)
print v(xbgr.mr_n71343264)
print v(xbgr.mr_n71343584)
print v(xbgr.mr_n71343696)
print v(xbgr.mr_n71344016)
print v(xbgr.mr_n71344128)
print v(xbgr.mr_n71344448)
print v(xbgr.mr_n71344560)
print v(xbgr.mr_n71344880)
print v(xbgr.mr_n71344992)
print v(xbgr.mr_n71345312)
print v(xbgr.mr_n71345424)
print v(xbgr.mr_n71345744)
print v(xbgr.mr_n71345856)
print v(xbgr.mr_n71346176)
print v(xbgr.mr_n71346288)
print v(xbgr.mr_n71346608)
print v(xbgr.mr_n71346720)
print v(xbgr.mr_n71347040)
print v(xbgr.mr_n71347152)
print v(xbgr.mr_n71347584)
print v(xbgr.mr_n71347904)
print v(xbgr.mr_n71348016)
print v(xbgr.mr_n71348336)
print v(xbgr.mr_n71348448)
print v(xbgr.mr_n71348768)
print v(xbgr.mr_n71348880)
print v(xbgr.mr_n71349312)
print v(xbgr.mr_n71349632)
print v(xbgr.mr_n71349744)
print v(xbgr.mr_n71350064)
print v(xbgr.mr_n71350176)
print v(xbgr.mr_n71350496)
print v(xbgr.mr_n71350608)
print v(xbgr.mr_n71351040)
print v(xbgr.mr_n71351360)
print v(xbgr.mr_n71351472)
print v(xbgr.mr_n71351792)
print v(xbgr.mr_n71351904)
print v(xbgr.mr_n71352224)
print v(xbgr.mr_n71352336)
print v(xbgr.mr_n71352768)
print v(xbgr.mr_n71353088)
print v(xbgr.mr_n71353200)
print v(xbgr.mr_n71353520)
print v(xbgr.mr_n71353632)
print v(xbgr.mr_n71353952)
print v(xbgr.mr_n71354064)
print v(xbgr.mr_n71354496)
print v(xbgr.mr_n71354816)
print v(xbgr.mr_n71354928)
print v(xbgr.mr_n71355248)
print v(xbgr.mr_n71355360)
print v(xbgr.mr_n71355680)
print v(xbgr.mr_n71355792)
print v(xbgr.mr_n71356224)
print v(xbgr.mr_n71356544)
print v(xbgr.mr_n71356656)
print v(xbgr.mr_n71356976)
print v(xbgr.mr_n71357088)
print v(xbgr.mr_n71357408)
print v(xbgr.mr_n71357520)
print v(xbgr.mr_n71357952)
print v(xbgr.mr_n71358272)
print v(xbgr.mr_n71358384)
print v(xbgr.mr_n71358704)
print v(xbgr.mr_n71358816)
print v(xbgr.mr_n71359136)
print v(xbgr.mr_n71359248)
print v(xbgr.mr_n71359680)
print v(xbgr.mr_n71360000)
print v(xbgr.mr_n71360112)
print v(xbgr.mr_n71360432)
print v(xbgr.mr_n71360544)
print v(xbgr.mr_n71360864)
print v(xbgr.mr_n71360976)
print v(xbgr.mr_n71361296)
print v(xbgr.mr_n71361408)
print v(xbgr.mr_n71361728)
print v(xbgr.mr_n71361840)
print v(xbgr.mr_n71362160)
print v(xbgr.mr_n71362272)
print v(xbgr.mr_n71362592)
print v(xbgr.mr_n71362704)
print v(xbgr.mr_n71363024)
print v(xbgr.mr_n71363136)
print v(xbgr.mr_n71363456)
print v(xbgr.mr_n71363568)
print v(xbgr.mr_n71363888)
print v(xbgr.mr_n71364000)
print v(xbgr.mr_n71364320)
print v(xbgr.mr_n71364432)
print v(xbgr.mr_n71364752)
print v(xbgr.mr_n71364864)
print v(xbgr.mr_n71365184)
print v(xbgr.mr_n71365296)
print v(xbgr.mr_n71365616)
print v(xbgr.mr_n71365728)
print v(xbgr.mr_n71366048)
print v(xbgr.mr_n71366160)
print v(xbgr.mr_n71366480)
print v(xbgr.mr_n71366592)
print v(xbgr.mr_n71366912)
print v(xbgr.mr_n71367024)
print v(xbgr.mr_n71367344)
print v(xbgr.mr_n71367456)
print v(xbgr.mr_n71367776)
print v(xbgr.mr_n71367888)
print v(xbgr.mr_n71368208)
print v(xbgr.mr_n71368320)
print v(xbgr.mr_n71368640)
print v(xbgr.mr_n71368752)
print v(xbgr.mr_n71369072)
print v(xbgr.mr_n71369184)
print v(xbgr.mr_n71369504)
print v(xbgr.mr_n71369616)
print v(xbgr.mr_n71369936)
print v(xbgr.mr_n71370048)
print v(xbgr.mr_n71370368)
print v(xbgr.mr_n71370480)
print v(xbgr.mr_n71370800)
print v(xbgr.mr_n71370912)
print v(xbgr.mr_n71371232)
print v(xbgr.mr_n71371344)
print v(xbgr.mr_n71371664)
print v(xbgr.mr_n71371776)
print v(xbgr.mr_n71372096)
print v(xbgr.mr_n71372208)
print v(xbgr.mr_n71372528)
print v(xbgr.mr_n71372640)
print v(xbgr.mr_n71372960)
print v(xbgr.mr_n71373072)
print v(xbgr.mr_n71373392)
print v(xbgr.mr_n71373504)
print v(xbgr.mr_n71373824)
print v(xbgr.mr_n71373936)
print v(xbgr.mr_n71374256)
print v(xbgr.mr_n71374368)
print v(xbgr.mr_n71374688)
print v(xbgr.mr_n71374800)
print v(xbgr.mr_n71375120)
print v(xbgr.mr_n71375232)
print v(xbgr.mr_n71375552)
print v(xbgr.mr_n71375664)
print v(xbgr.mr_n71375984)
print v(xbgr.mr_n71376096)
print v(xbgr.mr_n71376416)
print v(xbgr.mr_n71376528)
print v(xbgr.mr_n71376848)
print v(xbgr.mr_n71376960)
print v(xbgr.mr_n71377280)
print v(xbgr.mr_n71377392)
print v(xbgr.mr_n71377712)
print v(xbgr.mr_n71377824)
print v(xbgr.mr_n71378144)
print v(xbgr.mr_n71378256)
print v(xbgr.mr_n71378576)
print v(xbgr.mr_n71378688)
print v(xbgr.mr_n71379008)
print v(xbgr.mr_n71379120)
print v(xbgr.mr_n71379440)
print v(xbgr.mr_n71379552)
print v(xbgr.mr_n71379872)
print v(xbgr.mr_n71379984)
print v(xbgr.mr_n71380304)
print v(xbgr.mr_n71380416)
print v(xbgr.mr_n71380736)
print v(xbgr.mr_n71380848)
print v(xbgr.mr_n71381168)
print v(xbgr.mr_n71381280)
print v(xbgr.mr_n71381600)
print v(xbgr.mr_n71381712)
print v(xbgr.mr_n71382032)
print v(xbgr.mr_n71382144)
print v(xbgr.mr_n71382464)
print v(xbgr.mr_n71382576)
print v(xbgr.mr_n71382896)
print v(xbgr.mr_n71383008)
print v(xbgr.mr_n71383328)
print v(xbgr.mr_n71383440)
print v(xbgr.mr_n71383760)
print v(xbgr.mr_n71383872)
print v(xbgr.mr_n71384192)
print v(xbgr.mr_n71384304)
print v(xbgr.mr_n71384624)
print v(xbgr.mr_n71384736)
print v(xbgr.mr_n71385056)
print v(xbgr.mr_n71385168)
print v(xbgr.mr_n71385488)
print v(xbgr.mr_n71385600)
print v(xbgr.mr_n71385920)
print v(xbgr.mr_n71386032)
print v(xbgr.mr_n71386352)
print v(xbgr.mr_n71386464)
print v(xbgr.mr_n71386784)
print v(xbgr.mr_n71386896)
print v(xbgr.mr_n71387216)
print v(xbgr.mr_n71387328)
print v(xbgr.mr_n71387648)
print v(xbgr.mr_n71387760)
print v(xbgr.mr_n71388080)
print v(xbgr.mr_n71388192)
print v(xbgr.mr_n71388512)
print v(xbgr.mr_n71388624)
print v(xbgr.mr_n71388944)
print v(xbgr.mr_n71389056)
print v(xbgr.mr_n71389376)
print v(xbgr.mr_n71389488)
print v(xbgr.mr_n71389920)
print v(xbgr.mr_n71390240)
print v(xbgr.mr_n71390352)
print v(xbgr.mr_n71390672)
print v(xbgr.mr_n71390784)
print v(xbgr.mr_n71391104)
print v(xbgr.mr_n71391216)
print v(xbgr.mr_n71391648)
print v(xbgr.mr_n71391968)
print v(xbgr.mr_n71392080)
print v(xbgr.mr_n71392400)
print v(xbgr.mr_n71392512)
print v(xbgr.mr_n71392832)
print v(xbgr.mr_n71392944)
print v(xbgr.mr_n71393376)
print v(xbgr.mr_n71393696)
print v(xbgr.mr_n71393808)
print v(xbgr.mr_n71394128)
print v(xbgr.mr_n71394240)
print v(xbgr.mr_n71394560)
print v(xbgr.mr_n71394672)
print v(xbgr.mr_n71394992)
print v(xbgr.mr_n71395104)
print v(xbgr.mr_n71395424)
print v(xbgr.mr_n71395536)
print v(xbgr.mr_n71395856)
print v(xbgr.mr_n71395968)
print v(xbgr.mr_n71396288)
print v(xbgr.mr_n71396400)
print v(xbgr.mr_n71396720)
print v(xbgr.mr_n71396832)
print v(xbgr.mr_n71397152)
print v(xbgr.mr_n71397264)
print v(xbgr.mr_n71397696)
print v(xbgr.mr_n71398016)
print v(xbgr.mr_n71398128)
print v(xbgr.mr_n71398560)
print v(xbgr.mr_n71398880)
print v(xbgr.mr_n71398992)
print v(xbgr.mr_n71399424)
print v(xbgr.mr_n71399744)
print v(xbgr.mr_n71399856)
print v(xbgr.mr_n71400176)
print v(xbgr.mr_n71400288)
print v(xbgr.mr_n71400608)
print v(xbgr.mr_n71400720)
print v(xbgr.mr_n71401152)
print v(xbgr.mr_n71401472)
print v(xbgr.mr_n71401584)
print v(xbgr.mr_n71401904)
print v(xbgr.mr_n71402016)
print v(xbgr.mr_n71402336)
print v(xbgr.mr_n71402448)
print v(xbgr.mr_n71402768)
print v(xbgr.mr_n71402880)
print v(xbgr.mr_n71403200)
print v(xbgr.mr_n71403312)
print v(xbgr.mr_n71403744)
print v(xbgr.mr_n71404064)
print v(xbgr.mr_n71404176)
print v(xbgr.mr_n71404496)
print v(xbgr.mr_n71404608)
print v(xbgr.mr_n71404928)
print v(xbgr.mr_n71405040)
print v(xbgr.mr_n71405360)
print v(xbgr.mr_n71405472)
print v(xbgr.mr_n71405792)
print v(xbgr.mr_n71405904)
print v(xbgr.mr_n71406224)
print v(xbgr.mr_n71406336)
print v(xbgr.mr_n71406656)
print v(xbgr.mr_n71406768)
print v(xbgr.mr_n71407088)
print v(xbgr.mr_n71407200)
print v(xbgr.mr_n71407520)
print v(xbgr.mr_n71407632)
print v(xbgr.mr_n71407952)
print v(xbgr.mr_n71408064)
print v(xbgr.mr_n71408384)
print v(xbgr.mr_n71408496)
print v(xbgr.mr_n71408816)
print v(xbgr.mr_n71408928)
print v(xbgr.mr_n71409248)
print v(xbgr.mr_n71409360)
print v(xbgr.mr_n71409680)
print v(xbgr.mr_n71409792)
print v(xbgr.mr_n71410112)
print v(xbgr.mr_n71410224)
print v(xbgr.mr_n71410544)
print v(xbgr.mr_n71410656)
print v(xbgr.mr_n71410976)
print v(xbgr.mr_n71411088)
print v(xbgr.mr_n71411408)
print v(xbgr.mr_n71411520)
print v(xbgr.mr_n71411840)
print v(xbgr.mr_n71411952)
print v(xbgr.mr_n71412272)
print v(xbgr.mr_n71412384)
print v(xbgr.mr_n71412704)
print v(xbgr.mr_n71412816)
print v(xbgr.mr_n71413136)
print v(xbgr.mr_n71413248)
print v(xbgr.mr_n71413568)
print v(xbgr.mr_n71413680)
print v(xbgr.mr_n71414000)
print v(xbgr.mr_n71414112)
print v(xbgr.mr_n71414432)
print v(xbgr.mr_n71414544)
print v(xbgr.mr_n71414864)
print v(xbgr.mr_n71414976)
print v(xbgr.mr_n71415296)
print v(xbgr.mr_n71415408)
print v(xbgr.mr_n71415728)
print v(xbgr.mr_n71415840)
print v(xbgr.mr_n71416160)
print v(xbgr.mr_n71416272)
print v(xbgr.mr_n71416592)
print v(xbgr.mr_n71416704)
print v(xbgr.mr_n71417024)
print v(xbgr.mr_n71417136)
print v(xbgr.mr_n71417456)
print v(xbgr.mr_n71417568)
print v(xbgr.mr_n71417888)
print v(xbgr.mr_n71418000)
print v(xbgr.mr_n71418320)
print v(xbgr.mr_n71418432)
print v(xbgr.mr_n71418752)
print v(xbgr.mr_n71418864)
print v(xbgr.mr_n71419184)
print v(xbgr.mr_n71419296)
print v(xbgr.mr_n71419616)
print v(xbgr.mr_n71419728)
print v(xbgr.mr_n71420048)
print v(xbgr.mr_n71420160)
print v(xbgr.mr_n71420480)
print v(xbgr.mr_n71420592)
print v(xbgr.mr_n71420912)
print v(xbgr.mr_n71421024)
print v(xbgr.mr_n71421344)
print v(xbgr.mr_n71421456)
print v(xbgr.mr_n71421776)
print v(xbgr.mr_n71421888)
print v(xbgr.mr_n71422208)
print v(xbgr.mr_n71422320)
print v(xbgr.mr_n71422640)
print v(xbgr.mr_n71422752)
print v(xbgr.mr_n71423072)
print v(xbgr.mr_n71423184)
print v(xbgr.mr_n71423504)
print v(xbgr.mr_n71423616)
print v(xbgr.mr_n71423936)
print v(xbgr.mr_n71424048)
print v(xbgr.mr_n71424368)
print v(xbgr.mr_n71424480)
print v(xbgr.mr_n71424800)
print v(xbgr.mr_n71424912)
print v(xbgr.mr_n71425232)
print v(xbgr.mr_n71425344)
print v(xbgr.mr_n71425664)
print v(xbgr.mr_n71425776)
print v(xbgr.mr_n71426096)
print v(xbgr.mr_n71426208)
print v(xbgr.mr_n71426528)
print v(xbgr.mr_n71426640)
print v(xbgr.mr_n71426960)
print v(xbgr.mr_n71427072)
print v(xbgr.mr_n71427392)
print v(xbgr.mr_n71427504)
print v(xbgr.mr_n71427824)
print v(xbgr.mr_n71427936)
print v(xbgr.mr_n71428256)
print v(xbgr.mr_n71428368)
print v(xbgr.mr_n71428688)
print v(xbgr.mr_n71428800)
print v(xbgr.mr_n71429120)
print v(xbgr.mr_n71429232)
print v(xbgr.mr_n71429552)
print v(xbgr.mr_n71429664)
print v(xbgr.mr_n71429984)
print v(xbgr.mr_n71430096)
print v(xbgr.mr_n71430416)
print v(xbgr.mr_n71430528)
print v(xbgr.mr_n71430848)
print v(xbgr.mr_n71430960)
print v(xbgr.mr_n71431280)
print v(xbgr.mr_n71431392)
print v(xbgr.mr_n71431712)
print v(xbgr.mr_n71431824)
print v(xbgr.mr_n71432144)
print v(xbgr.mr_n71432256)
print v(xbgr.mr_n71432576)
print v(xbgr.mr_n71432688)
print v(xbgr.mr_n71433008)
print v(xbgr.mr_n71433120)
print v(xbgr.mr_n71433440)
print v(xbgr.mr_n71433552)
print v(xbgr.mr_n71433872)
print v(xbgr.mr_n71433984)
print v(xbgr.mr_n71434304)
print v(xbgr.mr_n71434416)
print v(xbgr.mr_n71434736)
print v(xbgr.mr_n71434848)
print v(xbgr.mr_n71435168)
print v(xbgr.mr_n71435280)
print v(xbgr.mr_n71435600)
print v(xbgr.mr_n71435712)
print v(xbgr.mr_n71436032)
print v(xbgr.mr_n71436144)
print v(xbgr.mr_n71436464)
print v(xbgr.mr_n71436576)
print v(xbgr.mr_n71436896)
print v(xbgr.mr_n71437008)
print v(xbgr.mr_n71437328)
print v(xbgr.mr_n71437440)
print v(xbgr.mr_n71437760)
print v(xbgr.mr_n71437872)
print v(xbgr.mr_n71438192)
print v(xbgr.mr_n71438304)
print v(xbgr.mr_n71438624)
print v(xbgr.mr_n71438736)
print v(xbgr.mr_n71439056)
print v(xbgr.mr_n71439168)
print v(xbgr.mr_n71439488)
print v(xbgr.mr_n71439600)
print v(xbgr.mr_n71439920)
print v(xbgr.mr_n71440032)
print v(xbgr.mr_n71440352)
print v(xbgr.mr_n71440464)
print v(xbgr.mr_n71440784)
print v(xbgr.mr_n71440896)
print v(xbgr.mr_n71441216)
print v(xbgr.mr_n71441328)
print v(xbgr.mr_n71441648)
print v(xbgr.mr_n71441760)
print v(xbgr.mr_n71442080)
print v(xbgr.mr_n71442192)
print v(xbgr.mr_n71442512)
print v(xbgr.mr_n71442624)
print v(xbgr.mr_n71442944)
print v(xbgr.mr_n71443056)
print v(xbgr.mr_n71443376)
print v(xbgr.mr_n71443488)
print v(xbgr.mr_n71443808)
print v(xbgr.mr_n71443920)
print v(xbgr.mr_n71444240)
print v(xbgr.mr_n71444352)
print v(xbgr.mr_n71444672)
print v(xbgr.mr_n71444784)
print v(xbgr.mr_n71445104)
print v(xbgr.mr_n71445216)
print v(xbgr.mr_n71445536)
print v(xbgr.mr_n71445648)
print v(xbgr.mr_n71445968)
print v(xbgr.mr_n71446080)
print v(xbgr.mr_n71446400)
print v(xbgr.mr_n71446512)
print v(xbgr.mr_n71446832)
print v(xbgr.mr_n71446944)
print v(xbgr.mr_n71447264)
print v(xbgr.mr_n71447376)
print v(xbgr.mr_n71447696)
print v(xbgr.mr_n71447808)
print v(xbgr.mr_n71448128)
print v(xbgr.mr_n71448240)
print v(xbgr.mr_n71448560)
print v(xbgr.mr_n71448672)
print v(xbgr.mr_n71448992)
print v(xbgr.mr_n71449104)
print v(xbgr.mr_n71449424)
print v(xbgr.mr_n71449536)
print v(xbgr.mr_n71449856)
print v(xbgr.mr_n71449968)
print v(xbgr.mr_n71450288)
print v(xbgr.mr_n71450400)
print v(xbgr.mr_n71450720)
print v(xbgr.mr_n71450832)
print v(xbgr.mr_n71451152)
print v(xbgr.mr_n71451264)
print v(xbgr.mr_n71451584)
print v(xbgr.mr_n71451696)
print v(xbgr.mr_n71452016)
print v(xbgr.mr_n71452128)
print v(xbgr.mr_n71452448)
print v(xbgr.mr_n71452560)
print v(xbgr.mr_n71452880)
print v(xbgr.mr_n71452992)
print v(xbgr.mr_n71453312)
print v(xbgr.mr_n71453424)
print v(xbgr.mr_n71453744)
print v(xbgr.mr_n71453856)
print v(xbgr.mr_n71454176)
print v(xbgr.mr_n71454288)
print v(xbgr.mr_n71454608)
print v(xbgr.mr_n71454720)
print v(xbgr.mr_n71455040)
print v(xbgr.mr_n71455152)
print v(xbgr.mr_n71455472)
print v(xbgr.mr_n71455584)
print v(xbgr.mr_n71455904)
print v(xbgr.mr_n71456016)
print v(xbgr.mr_n71456336)
print v(xbgr.mr_n71456448)
print v(xbgr.mr_n71456768)
print v(xbgr.mr_n71456880)
print v(xbgr.mr_n71457200)
print v(xbgr.mr_n71457312)
print v(xbgr.mr_n71457632)
print v(xbgr.mr_n71457744)
print v(xbgr.mr_n71458064)
print v(xbgr.mr_n71458176)
print v(xbgr.mr_n71458496)
print v(xbgr.mr_n71458608)
print v(xbgr.mr_n71458928)
print v(xbgr.mr_n71459040)
print v(xbgr.mr_n71459360)
print v(xbgr.mr_n71459472)
print v(xbgr.mr_n71459792)
print v(xbgr.mr_n71459904)
print v(xbgr.mr_n71460224)
print v(xbgr.mr_n71460336)
print v(xbgr.mr_n71460656)
print v(xbgr.mr_n71460768)
print v(xbgr.mr_n71461088)
print v(xbgr.mr_n71461200)
print v(xbgr.mr_n71461520)
print v(xbgr.mr_n71461632)
print v(xbgr.mr_n71461952)
print v(xbgr.mr_n71462064)
print v(xbgr.mr_n71462384)
print v(xbgr.mr_n71462496)
print v(xbgr.mr_n71462816)
print v(xbgr.mr_n71462928)
print v(xbgr.mr_n71463248)
print v(xbgr.mr_n71463360)
print v(xbgr.mr_n71463680)
print v(xbgr.mr_n71463792)
print v(xbgr.mr_n71464112)
print v(xbgr.mr_n71464224)
print v(xbgr.mr_n71464544)
print v(xbgr.mr_n71464656)
print v(xbgr.mr_n71464976)
print v(xbgr.mr_n71465088)
print v(xbgr.mr_n71465408)
print v(xbgr.mr_n71465520)
print v(xbgr.mr_n71465840)
print v(xbgr.mr_n71465952)
print v(xbgr.mr_n71466272)
print v(xbgr.mr_n71466384)
print v(xbgr.mr_n71466704)
print v(xbgr.mr_n71466816)
print v(xbgr.mr_n71467136)
print v(xbgr.mr_n71467248)
print v(xbgr.mr_n71467568)
print v(xbgr.mr_n71467680)
print v(xbgr.mr_n71468000)
print v(xbgr.mr_n71468112)
print v(xbgr.mr_n71468432)
print v(xbgr.mr_n71468544)
print v(xbgr.mr_n71468864)
print v(xbgr.mr_n71468976)
print v(xbgr.mr_n71469296)
print v(xbgr.mr_n71469408)
print v(xbgr.mr_n71469728)
print v(xbgr.mr_n71469840)
print v(xbgr.mr_n71470160)
print v(xbgr.mr_n71470272)
print v(xbgr.mr_n71470592)
print v(xbgr.mr_n71470704)
print v(xbgr.mr_n71471024)
print v(xbgr.mr_n71471136)
print v(xbgr.mr_n71471456)
print v(xbgr.mr_n71471568)
print v(xbgr.mr_n71471888)
print v(xbgr.mr_n71472000)
print v(xbgr.mr_n71472320)
print v(xbgr.mr_n71472432)
print v(xbgr.mr_n71472752)
print v(xbgr.mr_n71472864)
print v(xbgr.mr_n71473184)
print v(xbgr.mr_n71473296)
print v(xbgr.mr_n71473616)
print v(xbgr.mr_n71473728)
print v(xbgr.mr_n71474048)
print v(xbgr.mr_n71474160)
print v(xbgr.mr_n71474480)
print v(xbgr.mr_n71474592)
print v(xbgr.mr_n71474912)
print v(xbgr.mr_n71475024)
print v(xbgr.mr_n71475344)
print v(xbgr.mr_n71475456)
print v(xbgr.mr_n71475776)
print v(xbgr.mr_n71475888)
print v(xbgr.mr_n71476208)
print v(xbgr.mr_n71476320)
print v(xbgr.mr_n71476640)
print v(xbgr.mr_n71476752)
print v(xbgr.mr_n71477072)
print v(xbgr.mr_n71477184)
print v(xbgr.mr_n71477504)
print v(xbgr.mr_n71477616)
print v(xbgr.mr_n71477936)
print v(xbgr.mr_n71478048)
print v(xbgr.mr_n71478368)
print v(xbgr.mr_n71478480)
print v(xbgr.mr_n71478912)
print v(xbgr.mr_n71479232)
print v(xbgr.mr_n71479344)
print v(xbgr.mr_n71479776)
print v(xbgr.mr_n71480096)
print v(xbgr.mr_n71480208)
print v(xbgr.mr_n71480640)
print v(xbgr.mr_n71480960)
print v(xbgr.mr_n71481824)
print v(xbgr.mr_n71481936)
print v(xbgr.mr_n71482368)
print v(xbgr.mr_n71482688)
print v(xbgr.mr_n71482800)
print v(xbgr.mr_n71483120)
print v(xbgr.mr_n71483232)
print v(xbgr.mr_n71483552)
print v(xbgr.mr_n71483664)
print v(xbgr.mr_n71483984)
print v(xbgr.mr_n71484096)
print v(xbgr.mr_n71484416)
print v(xbgr.mr_n71484528)
print v(xbgr.mr_n71484848)
print v(xbgr.mr_n71484960)
print v(xbgr.mr_n71485280)
print v(xbgr.mr_n71485392)
print v(xbgr.mr_n71485712)
print v(xbgr.mr_n71485824)
print v(xbgr.mr_n71486144)
print v(xbgr.mr_n71487008)
print v(xbgr.mr_n71487872)
print v(xbgr.mr_n71487984)
print v(xbgr.mr_n71488304)
print v(xbgr.mr_n71488416)
print v(xbgr.mr_n71488736)
print v(xbgr.mr_n71489600)
print v(xbgr.mr_n71489712)
print v(xbgr.mr_n71490032)
print v(xbgr.mr_n71490144)
print v(xbgr.mr_n71490464)
print v(xbgr.mr_n71490576)
print v(xbgr.mr_n71490896)
print v(xbgr.mr_n71491008)
print v(xbgr.mr_n71491328)
print v(xbgr.mr_n71491440)
print v(xbgr.mr_n71491760)
print v(xbgr.mr_n71491872)
print v(xbgr.mr_n71492192)
print v(xbgr.mr_n71492304)
print v(xbgr.mr_n71492624)
print v(xbgr.mr_n71492736)
print v(xbgr.mr_n71493056)
print v(xbgr.mr_n71493168)
print v(xbgr.mr_n71493488)
print v(xbgr.mr_n71493600)
print v(xbgr.mr_n71493920)
print v(xbgr.mr_n71494032)
print v(xbgr.mr_n71494352)
print v(xbgr.mr_n71494464)
print v(xbgr.mr_n71494784)
print v(xbgr.mr_n71494896)
print v(xbgr.mr_n71495216)
print v(xbgr.mr_n71495328)
print v(xbgr.mr_n71495648)
print v(xbgr.mr_n71495760)
print v(xbgr.mr_n71496080)
print v(xbgr.mr_n71496192)
print v(xbgr.mr_n71496512)
print v(xbgr.mr_n71496624)
print v(xbgr.mr_n71496944)
print v(xbgr.mr_n71497056)
print v(xbgr.mr_n71497376)
print v(xbgr.mr_n71497488)
print v(xbgr.mr_n71497808)
print v(xbgr.mr_n71497920)
print v(xbgr.mr_n71498240)
print v(xbgr.mr_n71498352)
print v(xbgr.mr_n71498672)
print v(xbgr.mr_n71498784)
print v(xbgr.mr_n71499104)
print v(xbgr.mr_n71499216)
print v(xbgr.mr_n71499536)
print v(xbgr.mr_n71499648)
print v(xbgr.mr_n71499968)
print v(xbgr.mr_n71500080)
print v(xbgr.mr_n71500512)
print v(xbgr.mr_n71500832)
print v(xbgr.mr_n71500944)
print v(xbgr.mr_n71501264)
print v(xbgr.mr_n71501376)
print v(xbgr.mr_n71501696)
print v(xbgr.mr_n71501808)
print v(xbgr.mr_n71502128)
print v(xbgr.mr_n71502240)
print v(xbgr.mr_n71502560)
print v(xbgr.mr_n71502672)
print v(xbgr.mr_n71502992)
print v(xbgr.mr_n71503104)
print v(xbgr.mr_n71503424)
print v(xbgr.mr_n71503536)
print v(xbgr.mr_n71503856)
print v(xbgr.mr_n71503968)
print v(xbgr.mr_n71504288)
print v(xbgr.mr_n71504400)
print v(xbgr.mr_n71504720)
print v(xbgr.mr_n71504832)
print v(xbgr.mr_n71505152)
print v(xbgr.mr_n71505264)
print v(xbgr.mr_n71505584)
print v(xbgr.mr_n71505696)
print v(xbgr.mr_n71506016)
print v(xbgr.mr_n71506128)
print v(xbgr.mr_n71506448)
print v(xbgr.mr_n71506560)
print v(xbgr.mr_n71506880)
print v(xbgr.mr_n71507744)
print v(xbgr.mr_n71507856)
print v(xbgr.mr_n71508176)
print v(xbgr.mr_n71508288)
print v(xbgr.mr_n71508608)
print v(xbgr.mr_n71508720)
print v(xbgr.mr_n71509040)
print v(xbgr.mr_n71509152)
print v(xbgr.mr_n71509472)
print v(xbgr.mr_n71509584)
print v(xbgr.mr_n71509904)
print v(xbgr.mr_n71510016)
print v(xbgr.mr_n71510336)
print v(xbgr.mr_n71510448)
print v(xbgr.mr_n71510768)
print v(xbgr.mr_n71510880)
print v(xbgr.mr_n71511200)
print v(xbgr.mr_n71511312)
print v(xbgr.mr_n71511632)
print v(xbgr.mr_n71511744)
print v(xbgr.mr_n71512064)
print v(xbgr.mr_n71512176)
print v(xbgr.mr_n71512496)
print v(xbgr.mr_n71512608)
print v(xbgr.mr_n71512928)
print v(xbgr.mr_n71513040)
print v(xbgr.mr_n71513360)
print v(xbgr.mr_n71513472)
print v(xbgr.mr_n71513792)
print v(xbgr.mr_n71513904)
print v(xbgr.mr_n71514224)
print v(xbgr.mr_n71514336)
print v(xbgr.mr_n71514656)
print v(xbgr.mr_n71514768)
print v(xbgr.mr_n71515088)
print v(xbgr.mr_n71515200)
print v(xbgr.mr_n71515520)
print v(xbgr.mr_n71515632)
print v(xbgr.mr_n71515952)
print v(xbgr.mr_n71516064)
print v(xbgr.mr_n71516384)
print v(xbgr.mr_n71516496)
print v(xbgr.mr_n71516816)
print v(xbgr.mr_n71516928)
print v(xbgr.mr_n71517248)
print v(xbgr.mr_n71517360)
print v(xbgr.mr_n71517680)
print v(xbgr.mr_n71517792)
print v(xbgr.mr_n71518112)
print v(xbgr.mr_n71518224)
print v(xbgr.mr_n71518544)
print v(xbgr.mr_n71518656)
print v(xbgr.mr_n71518976)
print v(xbgr.mr_n71519088)
print v(xbgr.mr_n71519408)
print v(xbgr.mr_n71519520)
print v(xbgr.mr_n71519840)
print v(xbgr.mr_n71519952)
print v(xbgr.mr_n71520272)
print v(xbgr.mr_n71520384)
print v(xbgr.mr_n71520704)
print v(xbgr.mr_n71520816)
print v(xbgr.mr_n71521136)
print v(xbgr.mr_n71521248)
print v(xbgr.mr_n71521568)
print v(xbgr.mr_n71521680)
print v(xbgr.mr_n71522000)
print v(xbgr.mr_n71522112)
print v(xbgr.mr_n71522432)
print v(xbgr.mr_n71522544)
print v(xbgr.mr_n71522864)
print v(xbgr.mr_n71522976)
print v(xbgr.mr_n71523296)
print v(xbgr.mr_n71523408)
print v(xbgr.mr_n71523728)
print v(xbgr.mr_n71523840)
print v(xbgr.mr_n71524160)
print v(xbgr.mr_n71524272)
print v(xbgr.mr_n71524592)
print v(xbgr.mr_n71524704)
print v(xbgr.mr_n71525024)
print v(xbgr.mr_n71525136)
print v(xbgr.mr_n71525456)
print v(xbgr.mr_n71525568)
print v(xbgr.mr_n71525888)
print v(xbgr.mr_n71526000)
print v(xbgr.mr_n71526320)
print v(xbgr.mr_n71526432)
print v(xbgr.mr_n71526752)
print v(xbgr.mr_n71526864)
print v(xbgr.mr_n71527184)
print v(xbgr.mr_n71527296)
print v(xbgr.mr_n71527616)
print v(xbgr.mr_n71527728)
print v(xbgr.mr_n71528048)
print v(xbgr.mr_n71528160)
print v(xbgr.mr_n71528480)
print v(xbgr.mr_n71528592)
print v(xbgr.mr_n71528912)
print v(xbgr.mr_n71529024)
print v(xbgr.mr_n71529344)
print v(xbgr.mr_n71529456)
print v(xbgr.mr_n71529776)
print v(xbgr.mr_n71529888)
print v(xbgr.mr_n71530208)
print v(xbgr.mr_n71530320)
print v(xbgr.mr_n71530640)
print v(xbgr.mr_n71530752)
print v(xbgr.mr_n71531072)
print v(xbgr.mr_n71531184)
print v(xbgr.mr_n71531504)
print v(xbgr.mr_n71531616)
print v(xbgr.mr_n71531936)
print v(xbgr.mr_n71532048)
print v(xbgr.mr_n71532368)
print v(xbgr.mr_n71532480)
print v(xbgr.mr_n71532800)
print v(xbgr.mr_n71532912)
print v(xbgr.mr_n71533232)
print v(xbgr.mr_n71533344)
print v(xbgr.mr_n71533664)
print v(xbgr.mr_n71533776)
print v(xbgr.mr_n71534096)
print v(xbgr.mr_n71534208)
print v(xbgr.mr_n71534528)
print v(xbgr.mr_n71534640)
print v(xbgr.mr_n71534960)
print v(xbgr.mr_n71535072)
print v(xbgr.mr_n71535392)
print v(xbgr.mr_n71535504)
print v(xbgr.mr_n71535824)
print v(xbgr.mr_n71535936)
print v(xbgr.mr_n71536256)
print v(xbgr.mr_n71536368)
print v(xbgr.mr_n71536688)
print v(xbgr.mr_n71536800)
print v(xbgr.mr_n71537120)
print v(xbgr.mr_n71537232)
print v(xbgr.mr_n71537552)
print v(xbgr.mr_n71537664)
print v(xbgr.mr_n71537984)
print v(xbgr.mr_n71538096)
print v(xbgr.mr_n71538416)
print v(xbgr.mr_n71538528)
print v(xbgr.mr_n71538848)
print v(xbgr.mr_n71538960)
print v(xbgr.mr_n71539280)
print v(xbgr.mr_n71539392)
print v(xbgr.mr_n71539712)
print v(xbgr.mr_n71539824)
print v(xbgr.mr_n71540144)
print v(xbgr.mr_n71540256)
print v(xbgr.mr_n71540576)
print v(xbgr.mr_n71540688)
print v(xbgr.mr_n71541008)
print v(xbgr.mr_n71541120)
print v(xbgr.mr_n71541440)
print v(xbgr.mr_n71541552)
print v(xbgr.mr_n71541872)
print v(xbgr.mr_n71541984)
print v(xbgr.mr_n71542304)
print v(xbgr.mr_n71542416)
print v(xbgr.mr_n71542736)
print v(xbgr.mr_n71542848)
print v(xbgr.mr_n71543168)
print v(xbgr.mr_n71543280)
print v(xbgr.mr_n71543600)
print v(xbgr.mr_n71543712)
print v(xbgr.mr_n71544032)
print v(xbgr.mr_n71544144)
print v(xbgr.mr_n71544464)
print v(xbgr.mr_n71544576)
print v(xbgr.mr_n71544896)
print v(xbgr.mr_n71545008)
print v(xbgr.mr_n71545328)
print v(xbgr.mr_n71545440)
print v(xbgr.mr_n71545760)
print v(xbgr.mr_n71545872)
print v(xbgr.mr_n71546192)
print v(xbgr.mr_n71546304)
print v(xbgr.mr_n71546624)
print v(xbgr.mr_n71546736)
print v(xbgr.mr_n71547056)
print v(xbgr.mr_n71547168)
print v(xbgr.mr_n71547488)
print v(xbgr.mr_n71547600)
print v(xbgr.mr_n71547920)
print v(xbgr.mr_n71548032)
print v(xbgr.mr_n71548352)
print v(xbgr.mr_n71548464)
print v(xbgr.mr_n71548784)
print v(xbgr.mr_n71548896)
print v(xbgr.mr_n71549216)
print v(xbgr.mr_n71549328)
print v(xbgr.mr_n71549648)
print v(xbgr.mr_n71549760)
print v(xbgr.mr_n71550080)
print v(xbgr.mr_n71550192)
print v(xbgr.mr_n71550512)
print v(xbgr.mr_n71550624)
print v(xbgr.mr_n71550944)
print v(xbgr.mr_n71551056)
print v(xbgr.mr_n71551376)
print v(xbgr.mr_n71551488)
print v(xbgr.mr_n71551808)
print v(xbgr.mr_n71551920)
print v(xbgr.mr_n71552240)
print v(xbgr.mr_n71552352)
print v(xbgr.mr_n71552672)
print v(xbgr.mr_n71552784)
print v(xbgr.mr_n71553104)
print v(xbgr.mr_n71553216)
print v(xbgr.mr_n71553536)
print v(xbgr.mr_n71553648)
print v(xbgr.mr_n71553968)
print v(xbgr.mr_n71554080)
print v(xbgr.mr_n71554400)
print v(xbgr.mr_n71554512)
print v(xbgr.mr_n71554832)
print v(xbgr.mr_n71554944)
print v(xbgr.mr_n71555264)
print v(xbgr.mr_n71555376)
print v(xbgr.mr_n71555696)
print v(xbgr.mr_n71555808)
print v(xbgr.mr_n71556128)
print v(xbgr.mr_n71556240)
print v(xbgr.mr_n71556560)
print v(xbgr.mr_n71556672)
print v(xbgr.mr_n71556992)
print v(xbgr.mr_n71557104)
print v(xbgr.mr_n71557424)
print v(xbgr.mr_n71557536)
print v(xbgr.mr_n71557856)
print v(xbgr.mr_n71557968)
print v(xbgr.mr_n71558288)
print v(xbgr.mr_n71558400)
print v(xbgr.mr_n71558720)
print v(xbgr.mr_n71558832)
print v(xbgr.mr_n71559152)
print v(xbgr.mr_n71559264)
print v(xbgr.mr_n71559584)
print v(xbgr.mr_n71559696)
print v(xbgr.mr_n71560016)
print v(xbgr.mr_n71560128)
print v(xbgr.mr_n71560448)
print v(xbgr.mr_n71560560)
print v(xbgr.mr_n71560880)
print v(xbgr.mr_n71560992)
print v(xbgr.mr_n71561312)
print v(xbgr.mr_n71561424)
print v(xbgr.mr_n71561744)
print v(xbgr.mr_n71561856)
print v(xbgr.mr_n71562176)
print v(xbgr.mr_n71562288)
print v(xbgr.mr_n71562608)
print v(xbgr.mr_n71562720)
print v(xbgr.mr_n71563040)
print v(xbgr.mr_n71563152)
print v(xbgr.mr_n71563472)
print v(xbgr.mr_n71563584)
print v(xbgr.mr_n71563904)
print v(xbgr.mr_n71564016)
print v(xbgr.mr_n71564336)
print v(xbgr.mr_n71564448)
print v(xbgr.mr_n71564768)
print v(xbgr.mr_n71564880)
print v(xbgr.mr_n71565200)
print v(xbgr.mr_n71565312)
print v(xbgr.mr_n71565632)
print v(xbgr.mr_n71565744)
print v(xbgr.mr_n71566064)
print v(xbgr.mr_n71566176)
print v(xbgr.mr_n71566496)
print v(xbgr.mr_n71566608)
print v(xbgr.mr_n71566928)
print v(xbgr.mr_n71567040)
print v(xbgr.mr_n71567360)
print v(xbgr.mr_n71567472)
print v(xbgr.mr_n71567792)
print v(xbgr.mr_n71567904)
print v(xbgr.mr_n71568224)
print v(xbgr.mr_n71568336)
print v(xbgr.mr_n71568656)
print v(xbgr.mr_n71568768)
print v(xbgr.mr_n71569088)
print v(xbgr.mr_n71569200)
print v(xbgr.mr_n71569520)
print v(xbgr.mr_n71569632)
print v(xbgr.mr_n71569952)
print v(xbgr.mr_n71570064)
print v(xbgr.mr_n71570384)
print v(xbgr.mr_n71570496)
print v(xbgr.mr_n71570816)
print v(xbgr.mr_n71570928)
print v(xbgr.mr_n71571248)
print v(xbgr.mr_n71571360)
print v(xbgr.mr_n71571680)
print v(xbgr.mr_n71571792)
print v(xbgr.mr_n71572112)
print v(xbgr.mr_n71572224)
print v(xbgr.mr_n71572544)
print v(xbgr.mr_n71572656)
print v(xbgr.mr_n71572976)
print v(xbgr.mr_n71573088)
print v(xbgr.mr_n71573408)
print v(xbgr.mr_n71573520)
print v(xbgr.mr_n71573840)
print v(xbgr.mr_n71573952)
print v(xbgr.mr_n71574272)
print v(xbgr.mr_n71574384)
print v(xbgr.mr_n71574704)
print v(xbgr.mr_n71574816)
print v(xbgr.mr_n71575136)
print v(xbgr.mr_n71575248)
print v(xbgr.mr_n71575568)
print v(xbgr.mr_n71575680)
print v(xbgr.mr_n71576000)
print v(xbgr.mr_n71576112)
print v(xbgr.mr_n71576432)
print v(xbgr.mr_n71576544)
print v(xbgr.mr_n71576864)
print v(xbgr.mr_n71576976)
print v(xbgr.mr_n71577296)
print v(xbgr.mr_n71577408)
print v(xbgr.mr_n71577728)
print v(xbgr.mr_n71577840)
print v(xbgr.mr_n71578160)
print v(xbgr.mr_n71578272)
print v(xbgr.mr_n71578592)
print v(xbgr.mr_n71578704)
print v(xbgr.mr_n71579024)
print v(xbgr.mr_n71579136)
print v(xbgr.mr_n71579456)
print v(xbgr.mr_n71579568)
print v(xbgr.mr_n71579888)
print v(xbgr.mr_n71580000)
print v(xbgr.mr_n71580320)
print v(xbgr.mr_n71580432)
print v(xbgr.mr_n71580752)
print v(xbgr.mr_n71580864)
print v(xbgr.mr_n71581184)
print v(xbgr.mr_n71581296)
print v(xbgr.mr_n71581616)
print v(xbgr.mr_n71581728)
print v(xbgr.mr_n71582048)
print v(xbgr.mr_n71582160)
print v(xbgr.mr_n71582480)
print v(xbgr.mr_n71582592)
print v(xbgr.mr_n71582912)
print v(xbgr.mr_n71583024)
print v(xbgr.mr_n71583344)
print v(xbgr.mr_n71583456)
print v(xbgr.mr_n71583776)
print v(xbgr.mr_n71583888)
print v(xbgr.mr_n71584208)
print v(xbgr.mr_n71584320)
print v(xbgr.mr_n71584640)
print v(xbgr.mr_n71584752)
print v(xbgr.mr_n71585072)
print v(xbgr.mr_n71585184)
print v(xbgr.mr_n71585504)
print v(xbgr.mr_n71585616)
print v(xbgr.mr_n71585936)
print v(xbgr.mr_n71586048)
print v(xbgr.mr_n71586368)
print v(xbgr.mr_n71586480)
print v(xbgr.mr_n71586800)
print v(xbgr.mr_n71586912)
print v(xbgr.mr_n71587232)
print v(xbgr.mr_n71587344)
print v(xbgr.mr_n71587664)
print v(xbgr.mr_n71587776)
print v(xbgr.mr_n71588096)
print v(xbgr.mr_n71588208)
print v(xbgr.mr_n71588528)
print v(xbgr.mr_n71588640)
print v(xbgr.mr_n71588960)
print v(xbgr.mr_n71589072)
print v(xbgr.mr_n71589392)
print v(xbgr.mr_n71589504)
print v(xbgr.mr_n71589824)
print v(xbgr.mr_n71589936)
print v(xbgr.mr_n71590256)
print v(xbgr.mr_n71590368)
print v(xbgr.mr_n71590688)
print v(xbgr.mr_n71590800)
print v(xbgr.mr_n71591120)
print v(xbgr.mr_n71591232)
print v(xbgr.mr_n71591552)
print v(xbgr.mr_n71591664)
print v(xbgr.mr_n71591984)
print v(xbgr.mr_n71592096)
print v(xbgr.mr_n71592416)
print v(xbgr.mr_n71592528)
print v(xbgr.mr_n71592848)
print v(xbgr.mr_n71592960)
print v(xbgr.mr_n71593280)
print v(xbgr.mr_n71593392)
print v(xbgr.mr_n71593712)
print v(xbgr.mr_n71593824)
print v(xbgr.mr_n71594144)
print v(xbgr.mr_n71594256)
print v(xbgr.mr_n71594576)
print v(xbgr.mr_n71594688)
print v(xbgr.mr_n71595008)
print v(xbgr.mr_n71595120)
print v(xbgr.mr_n71595440)
print v(xbgr.mr_n71595552)
print v(xbgr.mr_n71595872)
print v(xbgr.mr_n71595984)
print v(xbgr.mr_n71596304)
print v(xbgr.mr_n71596416)
print v(xbgr.mr_n71596736)
print v(xbgr.mr_n71596848)
print v(xbgr.mr_n71597168)
print v(xbgr.mr_n71597280)
print v(xbgr.mr_n71597600)
print v(xbgr.mr_n71597712)
print v(xbgr.mr_n71598032)
print v(xbgr.mr_n71598144)
print v(xbgr.mr_n71598464)
print v(xbgr.mr_n71598576)
print v(xbgr.mr_n71598896)
print v(xbgr.mr_n71599008)
print v(xbgr.mr_n71599328)
print v(xbgr.mr_n71599440)
print v(xbgr.mr_n71599760)
print v(xbgr.mr_n71599872)
print v(xbgr.mr_n71600192)
print v(xbgr.mr_n71600304)
print v(xbgr.mr_n71600624)
print v(xbgr.mr_n71600736)
print v(xbgr.mr_n71601056)
print v(xbgr.mr_n71601168)
print v(xbgr.mr_n71601488)
print v(xbgr.mr_n71601600)
print v(xbgr.mr_n71601920)
print v(xbgr.mr_n71602032)
print v(xbgr.mr_n71602352)
print v(xbgr.mr_n71602464)
print v(xbgr.mr_n71602784)
print v(xbgr.mr_n71602896)
print v(xbgr.mr_n71603216)
print v(xbgr.mr_n71603328)
print v(xbgr.mr_n71603648)
print v(xbgr.mr_n71603760)
print v(xbgr.mr_n71604080)
print v(xbgr.mr_n71604192)
print v(xbgr.mr_n71604512)
print v(xbgr.mr_n71604624)
print v(xbgr.mr_n71604944)
print v(xbgr.mr_n71605056)
print v(xbgr.mr_n71605376)
print v(xbgr.mr_n71605488)
print v(xbgr.mr_n71605808)
print v(xbgr.mr_n71605920)
print v(xbgr.mr_n71606240)
print v(xbgr.mr_n71606352)
print v(xbgr.mr_n71606672)
print v(xbgr.mr_n71606784)
print v(xbgr.mr_n71607104)
print v(xbgr.mr_n71607216)
print v(xbgr.mr_n71607536)
print v(xbgr.mr_n71607648)
print v(xbgr.mr_n71607968)
print v(xbgr.mr_n71608080)
print v(xbgr.mr_n71608400)
print v(xbgr.mr_n71608512)
print v(xbgr.mr_n71608832)
print v(xbgr.mr_n71608944)
print v(xbgr.mr_n71609264)
print v(xbgr.mr_n71609376)
print v(xbgr.mr_n71609696)
print v(xbgr.mr_n71609808)
print v(xbgr.mr_n71610128)
print v(xbgr.mr_n71610240)
print v(xbgr.mr_n71610560)
print v(xbgr.mr_n71610672)
print v(xbgr.mr_n71610992)
print v(xbgr.mr_n71611104)
print v(xbgr.mr_n71611424)
print v(xbgr.mr_n71611536)
print v(xbgr.mr_n71611856)
print v(xbgr.mr_n71611968)
print v(xbgr.mr_n71612288)
print v(xbgr.mr_n71612400)
print v(xbgr.mr_n71612720)
print v(xbgr.mr_n71612832)
print v(xbgr.mr_n71613152)
print v(xbgr.mr_n71613264)
print v(xbgr.mr_n71613584)
print v(xbgr.mr_n71613696)
print v(xbgr.mr_n71614016)
print v(xbgr.mr_n71614128)
print v(xbgr.mr_n71614448)
print v(xbgr.mr_n71614560)
print v(xbgr.mr_n71614880)
print v(xbgr.mr_n71614992)
print v(xbgr.mr_n71615312)
print v(xbgr.mr_n71615424)
print v(xbgr.mr_n71615744)
print v(xbgr.mr_n71615856)
print v(xbgr.mr_n71616176)
print v(xbgr.mr_n71616288)
print v(xbgr.mr_n71616608)
print v(xbgr.mr_n71616720)
print v(xbgr.mr_n71617040)
print v(xbgr.mr_n71617152)
print v(xbgr.mr_n71617472)
print v(xbgr.mr_n71617584)
print v(xbgr.mr_n71617904)
print v(xbgr.mr_n71618016)
print v(xbgr.mr_n71618336)
print v(xbgr.mr_n71618448)
print v(xbgr.mr_n71618768)
print v(xbgr.mr_n71618880)
print v(xbgr.mr_n71619200)
print v(xbgr.mr_n71619312)
print v(xbgr.mr_n71619632)
print v(xbgr.mr_n71619744)
print v(xbgr.mr_n71620064)
print v(xbgr.mr_n71620176)
print v(xbgr.mr_n71620496)
print v(xbgr.mr_n71620608)
print v(xbgr.mr_n71620928)
print v(xbgr.mr_n71621040)
print v(xbgr.mr_n71621360)
print v(xbgr.mr_n71621472)
print v(xbgr.mr_n71621792)
print v(xbgr.mr_n71621904)
print v(xbgr.mr_n71622224)
print v(xbgr.mr_n71622336)
print v(xbgr.mr_n71622656)
print v(xbgr.mr_n71622768)
print v(xbgr.mr_n71623088)
print v(xbgr.mr_n71623200)
print v(xbgr.mr_n71623520)
print v(xbgr.mr_n71623632)
print v(xbgr.mr_n71623952)
print v(xbgr.mr_n71624064)
print v(xbgr.mr_n71624384)
print v(xbgr.mr_n71624496)
print v(xbgr.mr_n71624816)
print v(xbgr.mr_n71624928)
print v(xbgr.mr_n71625248)
print v(xbgr.mr_n71625360)
print v(xbgr.mr_n71625680)
print v(xbgr.mr_n71625792)
print v(xbgr.mr_n71626112)
print v(xbgr.mr_n71626224)
print v(xbgr.mr_n71626544)
print v(xbgr.mr_n71626656)
print v(xbgr.mr_n71626976)
print v(xbgr.mr_n71627088)
print v(xbgr.mr_n71627408)
print v(xbgr.mr_n71627520)
print v(xbgr.mr_n71627840)
print v(xbgr.mr_n71627952)
print v(xbgr.mr_n71628272)
print v(xbgr.mr_n71628384)
print v(xbgr.mr_n71628704)
print v(xbgr.mr_n71628816)
print v(xbgr.mr_n71629136)
print v(xbgr.mr_n71629248)
print v(xbgr.mr_n71629568)
print v(xbgr.mr_n71629680)
print v(xbgr.mr_n71630000)
print v(xbgr.mr_n71630112)
print v(xbgr.mr_n71630432)
print v(xbgr.mr_n71630544)
print v(xbgr.mr_n71630864)
print v(xbgr.mr_n71630976)
print v(xbgr.mr_n71631296)
print v(xbgr.mr_n71631408)
print v(xbgr.mr_n71631728)
print v(xbgr.mr_n71631840)
print v(xbgr.mr_n71632160)
print v(xbgr.mr_n71632272)
print v(xbgr.mr_n71632592)
print v(xbgr.mr_n71632704)
print v(xbgr.mr_n71633024)
print v(xbgr.mr_n71633136)
print v(xbgr.mr_n71633456)
print v(xbgr.mr_n71633568)
print v(xbgr.mr_n71633888)
print v(xbgr.mr_n71634000)
print v(xbgr.mr_n71634320)
print v(xbgr.mr_n71634432)
print v(xbgr.mr_n71634752)
print v(xbgr.mr_n71634864)
print v(xbgr.mr_n71635184)
print v(xbgr.mr_n71635296)
print v(xbgr.mr_n71635616)
print v(xbgr.mr_n71635728)
print v(xbgr.mr_n71636048)
print v(xbgr.mr_n71636160)
print v(xbgr.mr_n71636480)
print v(xbgr.mr_n71636592)
print v(xbgr.mr_n71636912)
print v(xbgr.mr_n71637024)
print v(xbgr.mr_n71637344)
print v(xbgr.mr_n71637456)
print v(xbgr.mr_n71637776)
print v(xbgr.mr_n71637888)
print v(xbgr.mr_n71638208)
print v(xbgr.mr_n71638320)
print v(xbgr.mr_n71638640)
print v(xbgr.mr_n71638752)
print v(xbgr.mr_n71639072)
print v(xbgr.mr_n71639184)
print v(xbgr.mr_n71639504)
print v(xbgr.mr_n71639616)
print v(xbgr.mr_n71639936)
print v(xbgr.mr_n71640048)
print v(xbgr.mr_n71640368)
print v(xbgr.mr_n71640480)
print v(xbgr.mr_n71640800)
print v(xbgr.mr_n71640912)
print v(xbgr.mr_n71641232)
print v(xbgr.mr_n71641344)
print v(xbgr.mr_n71641664)
print v(xbgr.mr_n71641776)
print v(xbgr.mr_n71642096)
print v(xbgr.mr_n71642208)
print v(xbgr.mr_n71642528)
print v(xbgr.mr_n71642640)
print v(xbgr.mr_n71642960)
print v(xbgr.mr_n71643072)
print v(xbgr.mr_n71643392)
print v(xbgr.mr_n71643504)
print v(xbgr.mr_n71643824)
print v(xbgr.mr_n71643936)
print v(xbgr.mr_n71644256)
print v(xbgr.mr_n71644368)
print v(xbgr.mr_n71644688)
print v(xbgr.mr_n71644800)
print v(xbgr.mr_n71645120)
print v(xbgr.mr_n71645232)
print v(xbgr.mr_n71645552)
print v(xbgr.mr_n71645664)
print v(xbgr.mr_n71645984)
print v(xbgr.mr_n71646096)
print v(xbgr.mr_n71646416)
print v(xbgr.mr_n71646528)
print v(xbgr.mr_n71646848)
print v(xbgr.mr_n71646960)
print v(xbgr.mr_n71647280)
print v(xbgr.mr_n71647392)
print v(xbgr.mr_n71647712)
print v(xbgr.mr_n71647824)
print v(xbgr.mr_n71648144)
print v(xbgr.mr_n71648256)
print v(xbgr.mr_n71648576)
print v(xbgr.mr_n71648688)
print v(xbgr.mr_n71649008)
print v(xbgr.mr_n71649120)
print v(xbgr.mr_n71649440)
print v(xbgr.mr_n71649552)
print v(xbgr.mr_n71649872)
print v(xbgr.mr_n71649984)
print v(xbgr.mr_n71650304)
print v(xbgr.mr_n71650416)
print v(xbgr.mr_n71650736)
print v(xbgr.mr_n71650848)
print v(xbgr.mr_n71651168)
print v(xbgr.mr_n71651280)
print v(xbgr.mr_n71651600)
print v(xbgr.mr_n71651712)
print v(xbgr.mr_n71652032)
print v(xbgr.mr_n71652144)
print v(xbgr.mr_n71652464)
print v(xbgr.mr_n71652576)
print v(xbgr.mr_n71652896)
print v(xbgr.mr_n71653008)
print v(xbgr.mr_n71653328)
print v(xbgr.mr_n71653440)
print v(xbgr.mr_n71653760)
print v(xbgr.mr_n71653872)
print v(xbgr.mr_n71654192)
print v(xbgr.mr_n71654304)
print v(xbgr.mr_n71654624)
print v(xbgr.mr_n71654736)
print v(xbgr.mr_n71655056)
print v(xbgr.mr_n71655168)
print v(xbgr.mr_n71655488)
print v(xbgr.mr_n71655600)
print v(xbgr.mr_n71655920)
print v(xbgr.mr_n71656032)
print v(xbgr.mr_n71656352)
print v(xbgr.mr_n71656464)
print v(xbgr.mr_n71656784)
print v(xbgr.mr_n71656896)
print v(xbgr.mr_n71657216)
print v(xbgr.mr_n71657328)
print v(xbgr.mr_n71657648)
print v(xbgr.mr_n71657760)
print v(xbgr.mr_n71658080)
print v(xbgr.mr_n71658192)
print v(xbgr.mr_n71658512)
print v(xbgr.mr_n71658624)
print v(xbgr.mr_n71658944)
print v(xbgr.mr_n71659056)
print v(xbgr.mr_n71659376)
print v(xbgr.mr_n71659488)
print v(xbgr.mr_n71659808)
print v(xbgr.mr_n71659920)
print v(xbgr.mr_n71660240)
print v(xbgr.mr_n71660352)
print v(xbgr.mr_n71660672)
print v(xbgr.mr_n71660784)
print v(xbgr.mr_n71661104)
print v(xbgr.mr_n71661216)
print v(xbgr.mr_n71661536)
print v(xbgr.mr_n71661648)
print v(xbgr.mr_n71661968)
print v(xbgr.mr_n71662080)
print v(xbgr.mr_n71662400)
print v(xbgr.mr_n71662512)
print v(xbgr.mr_n71662832)
print v(xbgr.mr_n71662944)
print v(xbgr.mr_n71663264)
print v(xbgr.mr_n71663376)
print v(xbgr.mr_n71663696)
print v(xbgr.mr_n71663808)
print v(xbgr.mr_n71664128)
print v(xbgr.mr_n71664240)
print v(xbgr.mr_n71664560)
print v(xbgr.mr_n71664672)
print v(xbgr.mr_n71664992)
print v(xbgr.mr_n71665104)
print v(xbgr.mr_n71665424)
print v(xbgr.mr_n71665536)
print v(xbgr.mr_n71665856)
print v(xbgr.mr_n71665968)
print v(xbgr.mr_n71666288)
print v(xbgr.mr_n71666400)
print v(xbgr.mr_n71666720)
print v(xbgr.mr_n71666832)
print v(xbgr.mr_n71667152)
print v(xbgr.mr_n71667264)
print v(xbgr.mr_n71667584)
print v(xbgr.mr_n71667696)
print v(xbgr.mr_n71668016)
print v(xbgr.mr_n71668128)
print v(xbgr.mr_n71668448)
print v(xbgr.mr_n71668560)
print v(xbgr.mr_n71668880)
print v(xbgr.mr_n71668992)
print v(xbgr.mr_n71669312)
print v(xbgr.mr_n71669424)
print v(xbgr.mr_n71669744)
print v(xbgr.mr_n71669856)
print v(xbgr.mr_n71670176)
print v(xbgr.mr_n71670288)
print v(xbgr.mr_n71670608)
print v(xbgr.mr_n71670720)
print v(xbgr.mr_n71671040)
print v(xbgr.mr_n71671152)
print v(xbgr.mr_n71671472)
print v(xbgr.mr_n71671584)
print v(xbgr.mr_n71671904)
print v(xbgr.mr_n71672016)
print v(xbgr.mr_n71672336)
print v(xbgr.mr_n71672448)
print v(xbgr.mr_n71672768)
print v(xbgr.mr_n71672880)
print v(xbgr.mr_n71673200)
print v(xbgr.mr_n71673312)
print v(xbgr.mr_n71673632)
print v(xbgr.mr_n71673744)
print v(xbgr.mr_n71674064)
print v(xbgr.mr_n71674176)
print v(xbgr.mr_n71674496)
print v(xbgr.mr_n71674608)
print v(xbgr.mr_n71674928)
print v(xbgr.mr_n71675040)
print v(xbgr.mr_n71675360)
print v(xbgr.mr_n71675472)
print v(xbgr.mr_n71675792)
print v(xbgr.mr_n71675904)
print v(xbgr.mr_n71676224)
print v(xbgr.mr_n71676336)
print v(xbgr.mr_n71676656)
print v(xbgr.mr_n71676768)
print v(xbgr.mr_n71677088)
print v(xbgr.mr_n71677200)
print v(xbgr.mr_n71677520)
print v(xbgr.mr_n71677632)
print v(xbgr.mr_n71677952)
print v(xbgr.mr_n71678064)
print v(xbgr.mr_n71678384)
print v(xbgr.mr_n71678496)
print v(xbgr.mr_n71678816)
print v(xbgr.mr_n71678928)
print v(xbgr.mr_n71679360)
print v(xbgr.mr_n71679680)
print v(xbgr.mr_n71679792)
print v(xbgr.mr_n71680112)
print v(xbgr.mr_n71680224)
print v(xbgr.mr_n71680544)
print v(xbgr.mr_n71680656)
print v(xbgr.mr_n71680976)
print v(xbgr.mr_n71681088)
print v(xbgr.mr_n71681408)
print v(xbgr.mr_n71682272)
print v(xbgr.mr_n71682384)
print v(xbgr.mr_n71682704)
print v(xbgr.mr_n71682816)
print v(xbgr.mr_n71683136)
print v(xbgr.mr_n71683248)
print v(xbgr.mr_n71683568)
print v(xbgr.mr_n71683680)
print v(xbgr.mr_n71684000)
print v(xbgr.mr_n71684112)
print v(xbgr.mr_n71684432)
print v(xbgr.mr_n71684544)
print v(xbgr.mr_n71684864)
print v(xbgr.mr_n71684976)
print v(xbgr.mr_n71685296)
print v(xbgr.mr_n71685408)
print v(xbgr.mr_n71685728)
print v(xbgr.mr_n71685840)
print v(xbgr.mr_n71686160)
print v(xbgr.mr_n71686272)
print v(xbgr.mr_n71686592)
print v(xbgr.mr_n71686704)
print v(xbgr.mr_n71687136)
print v(xbgr.mr_n71687456)
print v(xbgr.mr_n71687568)
print v(xbgr.mr_n71687888)
print v(xbgr.mr_n71688000)
print v(xbgr.mr_n71688320)
print v(xbgr.mr_n71688432)
print v(xbgr.mr_n71688752)
print v(xbgr.mr_n71688864)
print v(xbgr.mr_n71689184)
print v(xbgr.mr_n71689296)
print v(xbgr.mr_n71689616)
print v(xbgr.mr_n71689728)
print v(xbgr.mr_n71690048)
print v(xbgr.mr_n71690160)
print v(xbgr.mr_n71690480)
print v(xbgr.mr_n71690592)
print v(xbgr.mr_n71690912)
print v(xbgr.mr_n71691024)
print v(xbgr.mr_n71691344)
print v(xbgr.mr_n71691456)
print v(xbgr.mr_n71691776)
print v(xbgr.mr_n71691888)
print v(xbgr.mr_n71692208)
print v(xbgr.mr_n71692320)
print v(xbgr.mr_n71692640)
print v(xbgr.mr_n71692752)
print v(xbgr.mr_n71693072)
print v(xbgr.mr_n71693184)
print v(xbgr.mr_n71693504)
print v(xbgr.mr_n71693616)
print v(xbgr.mr_n71693936)
print v(xbgr.mr_n71694048)
print v(xbgr.mr_n71694368)
print v(xbgr.mr_n71694480)
print v(xbgr.mr_n71694800)
print v(xbgr.mr_n71694912)
print v(xbgr.mr_n71695232)
print v(xbgr.mr_n71695344)
print v(xbgr.mr_n71695664)
print v(xbgr.mr_n71695776)
print v(xbgr.mr_n71696096)
print v(xbgr.mr_n71696208)
print v(xbgr.mr_n71696528)
print v(xbgr.mr_n71696640)
print v(xbgr.mr_n71696960)
print v(xbgr.mr_n71697072)
print v(xbgr.mr_n71697392)
print v(xbgr.mr_n71697504)
print v(xbgr.mr_n71697824)
print v(xbgr.mr_n71697936)
print v(xbgr.mr_n71698256)
print v(xbgr.mr_n71698368)
print v(xbgr.mr_n71698688)
print v(xbgr.mr_n71698800)
print v(xbgr.mr_n71699120)
print v(xbgr.mr_n71699232)
print v(xbgr.mr_n71699552)
print v(xbgr.mr_n71699664)
print v(xbgr.mr_n71699984)
print v(xbgr.mr_n71700096)
print v(xbgr.mr_n71700416)
print v(xbgr.mr_n71700528)
print v(xbgr.mr_n71700848)
print v(xbgr.mr_n71700960)
print v(xbgr.mr_n71701280)
print v(xbgr.mr_n71701392)
print v(xbgr.mr_n71701712)
print v(xbgr.mr_n71701824)
print v(xbgr.mr_n71702144)
print v(xbgr.mr_n71702256)
print v(xbgr.mr_n71702576)
print v(xbgr.mr_n71702688)
print v(xbgr.mr_n71703008)
print v(xbgr.mr_n71703120)
print v(xbgr.mr_n71703440)
print v(xbgr.mr_n71703552)
print v(xbgr.mr_n71703872)
print v(xbgr.mr_n71704736)
print v(xbgr.mr_n71704848)
print v(xbgr.mr_n71705168)
print v(xbgr.mr_n71705280)
print v(xbgr.mr_n71705600)
print v(xbgr.mr_n71705712)
print v(xbgr.mr_n71706032)
print v(xbgr.mr_n71706144)
print v(xbgr.mr_n71706464)
print v(xbgr.mr_n71706576)
print v(xbgr.mr_n71706896)
print v(xbgr.mr_n71707008)
print v(xbgr.mr_n71707328)
print v(xbgr.mr_n71707440)
print v(xbgr.mr_n71707760)
print v(xbgr.mr_n71707872)
print v(xbgr.mr_n71708192)
print v(xbgr.mr_n71708304)
print v(xbgr.mr_n71708624)
print v(xbgr.mr_n71708736)
print v(xbgr.mr_n71709056)
print v(xbgr.mr_n71709168)
print v(xbgr.mr_n71709488)
print v(xbgr.mr_n71709600)
print v(xbgr.mr_n71709920)
print v(xbgr.mr_n71710032)
print v(xbgr.mr_n71710352)
print v(xbgr.mr_n71710464)
print v(xbgr.mr_n71710784)
print v(xbgr.mr_n71710896)
print v(xbgr.mr_n71711216)
print v(xbgr.mr_n71711328)
print v(xbgr.mr_n71711648)
print v(xbgr.mr_n71711760)
print v(xbgr.mr_n71712080)
print v(xbgr.mr_n71712192)
print v(xbgr.mr_n71712512)
print v(xbgr.mr_n71712624)
print v(xbgr.mr_n71712944)
print v(xbgr.mr_n71713056)
print v(xbgr.mr_n71713376)
print v(xbgr.mr_n71713488)
print v(xbgr.mr_n71713808)
print v(xbgr.mr_n71713920)
print v(xbgr.mr_n71714240)
print v(xbgr.mr_n71714352)
print v(xbgr.mr_n71714672)
print v(xbgr.mr_n71714784)
print v(xbgr.mr_n71715104)
print v(xbgr.mr_n71715216)
print v(xbgr.mr_n71715536)
print v(xbgr.mr_n71715648)
print v(xbgr.mr_n71715968)
print v(xbgr.mr_n71716080)
print v(xbgr.mr_n71716400)
print v(xbgr.mr_n71716512)
print v(xbgr.mr_n71716832)
print v(xbgr.mr_n71716944)
print v(xbgr.mr_n71717264)
print v(xbgr.mr_n71717376)
print v(xbgr.mr_n71717696)
print v(xbgr.mr_n71717808)
print v(xbgr.mr_n71718128)
print v(xbgr.mr_n71718240)
print v(xbgr.mr_n71718560)
print v(xbgr.mr_n71718672)
print v(xbgr.mr_n71718992)
print v(xbgr.mr_n71719104)
print v(xbgr.mr_n71719424)
print v(xbgr.mr_n71719536)
print v(xbgr.mr_n71719856)
print v(xbgr.mr_n71719968)
print v(xbgr.mr_n71720288)
print v(xbgr.mr_n71720400)
print v(xbgr.mr_n71720720)
print v(xbgr.mr_n71720832)
print v(xbgr.mr_n71721152)
print v(xbgr.mr_n71721264)
print v(xbgr.mr_n71721584)
print v(xbgr.mr_n71721696)
print v(xbgr.mr_n71722016)
print v(xbgr.mr_n71722128)
print v(xbgr.mr_n71722448)
print v(xbgr.mr_n71722560)
print v(xbgr.mr_n71722880)
print v(xbgr.mr_n71722992)
print v(xbgr.mr_n71723312)
print v(xbgr.mr_n71723424)
print v(xbgr.mr_n71723744)
print v(xbgr.mr_n71723856)
print v(xbgr.mr_n71724176)
print v(xbgr.mr_n71724288)
print v(xbgr.mr_n71724608)
print v(xbgr.mr_n71724720)
print v(xbgr.mr_n71725040)
print v(xbgr.mr_n71725152)
print v(xbgr.mr_n71725472)
print v(xbgr.mr_n71725584)
print v(xbgr.mr_n71725904)
print v(xbgr.mr_n71726016)
print v(xbgr.mr_n71726336)
print v(xbgr.mr_n71726448)
print v(xbgr.mr_n71726768)
print v(xbgr.mr_n71726880)
print v(xbgr.mr_n71727200)
print v(xbgr.mr_n71727312)
print v(xbgr.mr_n71727632)
print v(xbgr.mr_n71727744)
print v(xbgr.mr_n71728064)
print v(xbgr.mr_n71728176)
print v(xbgr.mr_n71728496)
print v(xbgr.mr_n71728608)
print v(xbgr.mr_n71728928)
print v(xbgr.mr_n71729040)
print v(xbgr.mr_n71729360)
print v(xbgr.mr_n71729472)
print v(xbgr.mr_n71729792)
print v(xbgr.mr_n71729904)
print v(xbgr.mr_n71730224)
print v(xbgr.mr_n71730336)
print v(xbgr.mr_n71730656)
print v(xbgr.mr_n71730768)
print v(xbgr.mr_n71731088)
print v(xbgr.mr_n71731200)
print v(xbgr.mr_n71731520)
print v(xbgr.mr_n71731632)
print v(xbgr.mr_n71731952)
print v(xbgr.mr_n71732064)
print v(xbgr.mr_n71732384)
print v(xbgr.mr_n71732496)
print v(xbgr.mr_n71732816)
print v(xbgr.mr_n71732928)
print v(xbgr.mr_n71733248)
print v(xbgr.mr_n71733360)
print v(xbgr.mr_n71733680)
print v(xbgr.mr_n71733792)
print v(xbgr.mr_n71734112)
print v(xbgr.mr_n71734224)
print v(xbgr.mr_n71734544)
print v(xbgr.mr_n71734656)
print v(xbgr.mr_n71734976)
print v(xbgr.mr_n71735088)
print v(xbgr.mr_n71735408)
print v(xbgr.mr_n71735520)
print v(xbgr.mr_n71735840)
print v(xbgr.mr_n71735952)
print v(xbgr.mr_n71736272)
print v(xbgr.mr_n71736384)
print v(xbgr.mr_n71736704)
print v(xbgr.mr_n71736816)
print v(xbgr.mr_n71737136)
print v(xbgr.mr_n71737248)
print v(xbgr.mr_n71737568)
print v(xbgr.mr_n71737680)
print v(xbgr.mr_n71738000)
print v(xbgr.mr_n71738112)
print v(xbgr.mr_n71738432)
print v(xbgr.mr_n71738544)
print v(xbgr.mr_n71738864)
print v(xbgr.mr_n71738976)
print v(xbgr.mr_n71739296)
print v(xbgr.mr_n71739408)
print v(xbgr.mr_n71739728)
print v(xbgr.mr_n71739840)
print v(xbgr.mr_n71740160)
print v(xbgr.mr_n71740272)
print v(xbgr.mr_n71740592)
print v(xbgr.mr_n71740704)
print v(xbgr.mr_n71741024)
print v(xbgr.mr_n71741136)
print v(xbgr.mr_n71741456)
print v(xbgr.mr_n71741568)
print v(xbgr.mr_n71741888)
print v(xbgr.mr_n71742000)
print v(xbgr.mr_n71742320)
print v(xbgr.mr_n71742432)
print v(xbgr.mr_n71742752)
print v(xbgr.mr_n71742864)
print v(xbgr.mr_n71743184)
print v(xbgr.mr_n71743296)
print v(xbgr.mr_n71743616)
print v(xbgr.mr_n71743728)
print v(xbgr.mr_n71744048)
print v(xbgr.mr_n71744160)
print v(xbgr.mr_n71744480)
print v(xbgr.mr_n71744592)
print v(xbgr.mr_n71744912)
print v(xbgr.mr_n71745024)
print v(xbgr.mr_n71745344)
print v(xbgr.mr_n71745456)
print v(xbgr.mr_n71745776)
print v(xbgr.mr_n71745888)
print v(xbgr.mr_n71746208)
print v(xbgr.mr_n71746320)
print v(xbgr.mr_n71746640)
print v(xbgr.mr_n71746752)
print v(xbgr.mr_n71747072)
print v(xbgr.mr_n71747184)
print v(xbgr.mr_n71747504)
print v(xbgr.mr_n71747616)
print v(xbgr.mr_n71747936)
print v(xbgr.mr_n71748048)
print v(xbgr.mr_n71748368)
print v(xbgr.mr_n71748480)
print v(xbgr.mr_n71748800)
print v(xbgr.mr_n71748912)
print v(xbgr.mr_n71749232)
print v(xbgr.mr_n71749344)
print v(xbgr.mr_n71749664)
print v(xbgr.mr_n71749776)
print v(xbgr.mr_n71750096)
print v(xbgr.mr_n71750208)
print v(xbgr.mr_n71750528)
print v(xbgr.mr_n71750640)
print v(xbgr.mr_n71750960)
print v(xbgr.mr_n71751072)
print v(xbgr.mr_n71751392)
print v(xbgr.mr_n71751504)
print v(xbgr.mr_n71751824)
print v(xbgr.mr_n71751936)
print v(xbgr.mr_n71752256)
print v(xbgr.mr_n71752368)
print v(xbgr.mr_n71752688)
print v(xbgr.mr_n71752800)
print v(xbgr.mr_n71753120)
print v(xbgr.mr_n71753232)
print v(xbgr.mr_n71753552)
print v(xbgr.mr_n71753664)
print v(xbgr.mr_n71753984)
print v(xbgr.mr_n71754096)
print v(xbgr.mr_n71754416)
print v(xbgr.mr_n71754528)
print v(xbgr.mr_n71754848)
print v(xbgr.mr_n71754960)
print v(xbgr.mr_n71755280)
print v(xbgr.mr_n71755392)
print v(xbgr.mr_n71755712)
print v(xbgr.mr_n71755824)
print v(xbgr.mr_n71756144)
print v(xbgr.mr_n71756256)
print v(xbgr.mr_n71756576)
print v(xbgr.mr_n71756688)
print v(xbgr.mr_n71757008)
print v(xbgr.mr_n71757120)
print v(xbgr.mr_n71757440)
print v(xbgr.mr_n71757552)
print v(xbgr.mr_n71757872)
print v(xbgr.mr_n71757984)
print v(xbgr.mr_n71758304)
print v(xbgr.mr_n71758416)
print v(xbgr.mr_n71758736)
print v(xbgr.mr_n71758848)
print v(xbgr.mr_n71759168)
print v(xbgr.mr_n71759280)
print v(xbgr.mr_n71759600)
print v(xbgr.mr_n71759712)
print v(xbgr.mr_n71760032)
print v(xbgr.mr_n71760144)
print v(xbgr.mr_n71760464)
print v(xbgr.mr_n71760576)
print v(xbgr.mr_n71760896)
print v(xbgr.mr_n71761008)
print v(xbgr.mr_n71761328)
print v(xbgr.mr_n71761440)
print v(xbgr.mr_n71761760)
print v(xbgr.mr_n71761872)
print v(xbgr.mr_n71762192)
print v(xbgr.mr_n71762304)
print v(xbgr.mr_n71762624)
print v(xbgr.mr_n71762736)
print v(xbgr.mr_n71763056)
print v(xbgr.mr_n71763168)
print v(xbgr.mr_n71763488)
print v(xbgr.mr_n71763600)
print v(xbgr.mr_n71763920)
print v(xbgr.mr_n71764032)
print v(xbgr.mr_n71764352)
print v(xbgr.mr_n71764464)
print v(xbgr.mr_n71764784)
print v(xbgr.mr_n71764896)
print v(xbgr.mr_n71765216)
print v(xbgr.mr_n71765328)
print v(xbgr.mr_n71765648)
print v(xbgr.mr_n71765760)
print v(xbgr.mr_n71766080)
print v(xbgr.mr_n71766192)
print v(xbgr.mr_n71766512)
print v(xbgr.mr_n71766624)
print v(xbgr.mr_n71766944)
print v(xbgr.mr_n71767056)
print v(xbgr.mr_n71767376)
print v(xbgr.mr_n71767488)
print v(xbgr.mr_n71767808)
print v(xbgr.mr_n71767920)
print v(xbgr.mr_n71768240)
print v(xbgr.mr_n71768352)
print v(xbgr.mr_n71768672)
print v(xbgr.mr_n71768784)
print v(xbgr.mr_n71769104)
print v(xbgr.mr_n71769216)
print v(xbgr.mr_n71769536)
print v(xbgr.mr_n71769648)
print v(xbgr.mr_n71769968)
print v(xbgr.mr_n71770080)
print v(xbgr.mr_n71770400)
print v(xbgr.mr_n71770512)
print v(xbgr.mr_n71770832)
print v(xbgr.mr_n71770944)
print v(xbgr.mr_n71771264)
print v(xbgr.mr_n71771376)
print v(xbgr.mr_n71771696)
print v(xbgr.mr_n71771808)
print v(xbgr.mr_n71772128)
print v(xbgr.mr_n71772240)
print v(xbgr.mr_n71772560)
print v(xbgr.mr_n71772672)
print v(xbgr.mr_n71772992)
print v(xbgr.mr_n71773104)
print v(xbgr.mr_n71773424)
print v(xbgr.mr_n71773536)
print v(xbgr.mr_n71773856)
print v(xbgr.mr_n71773968)
print v(xbgr.mr_n71774288)
print v(xbgr.mr_n71774400)
print v(xbgr.mr_n71774720)
print v(xbgr.mr_n71774832)
print v(xbgr.mr_n71775152)
print v(xbgr.mr_n71775264)
print v(xbgr.mr_n71775584)
print v(xbgr.mr_n71775696)
print v(xbgr.mr_n71776016)
print v(xbgr.mr_n71776128)
print v(xbgr.mr_n71776448)
print v(xbgr.mr_n71776560)
print v(xbgr.mr_n71776880)
print v(xbgr.mr_n71776992)
print v(xbgr.mr_n71777312)
print v(xbgr.mr_n71777424)
print v(xbgr.mr_n71777744)
print v(xbgr.mr_n71777856)
print v(xbgr.mr_n71778176)
print v(xbgr.mr_n71778288)
print v(xbgr.mr_n71778608)
print v(xbgr.mr_n71778720)
print v(xbgr.mr_n71779040)
print v(xbgr.mr_n71779152)
print v(xbgr.mr_n71779472)
print v(xbgr.mr_n71779584)
print v(xbgr.mr_n71779904)
print v(xbgr.mr_n71780016)
print v(xbgr.mr_n71780336)
print v(xbgr.mr_n71780448)
print v(xbgr.mr_n71780768)
print v(xbgr.mr_n71780880)
print v(xbgr.mr_n71781200)
print v(xbgr.mr_n71781312)
print v(xbgr.mr_n71781632)
print v(xbgr.mr_n71781744)
print v(xbgr.mr_n71782064)
print v(xbgr.mr_n71782176)
print v(xbgr.mr_n71782496)
print v(xbgr.mr_n71782608)
print v(xbgr.mr_n71782928)
print v(xbgr.mr_n71783040)
print v(xbgr.mr_n71783360)
print v(xbgr.mr_n71783472)
print v(xbgr.mr_n71783792)
print v(xbgr.mr_n71783904)
print v(xbgr.mr_n71784224)
print v(xbgr.mr_n71784336)
print v(xbgr.mr_n71784656)
print v(xbgr.mr_n71784768)
print v(xbgr.mr_n71785088)
print v(xbgr.mr_n71785200)
print v(xbgr.mr_n71785520)
print v(xbgr.mr_n71785632)
print v(xbgr.mr_n71785952)
print v(xbgr.mr_n71786064)
print v(xbgr.mr_n71786384)
print v(xbgr.mr_n71786496)
print v(xbgr.mr_n71786816)
print v(xbgr.mr_n71786928)
print v(xbgr.mr_n71787248)
print v(xbgr.mr_n71787360)
print v(xbgr.mr_n71787680)
print v(xbgr.mr_n71787792)
print v(xbgr.mr_n71788112)
print v(xbgr.mr_n71788224)
print v(xbgr.mr_n71788544)
print v(xbgr.mr_n71788656)
print v(xbgr.mr_n71788976)
print v(xbgr.mr_n71789088)
print v(xbgr.mr_n71789408)
print v(xbgr.mr_n71789520)
print v(xbgr.mr_n71789840)
print v(xbgr.mr_n71789952)
print v(xbgr.mr_n71790272)
print v(xbgr.mr_n71790384)
print v(xbgr.mr_n71790704)
print v(xbgr.mr_n71790816)
print v(xbgr.mr_n71791136)
print v(xbgr.mr_n71791248)
print v(xbgr.mr_n71791568)
print v(xbgr.mr_n71791680)
print v(xbgr.mr_n71792000)
print v(xbgr.mr_n71792112)
print v(xbgr.mr_n71792432)
print v(xbgr.mr_n71792544)
print v(xbgr.mr_n71792864)
print v(xbgr.mr_n71792976)
print v(xbgr.mr_n71793296)
print v(xbgr.mr_n71793408)
print v(xbgr.mr_n71793728)
print v(xbgr.mr_n71793840)
print v(xbgr.mr_n71794160)
print v(xbgr.mr_n71794272)
print v(xbgr.mr_n71794592)
print v(xbgr.mr_n71794704)
print v(xbgr.mr_n71795024)
print v(xbgr.mr_n71795136)
print v(xbgr.mr_n71795456)
print v(xbgr.mr_n71795568)
print v(xbgr.mr_n71795888)
print v(xbgr.mr_n71796000)
print v(xbgr.mr_n71796320)
print v(xbgr.mr_n71796432)
print v(xbgr.mr_n71796752)
print v(xbgr.mr_n71796864)
print v(xbgr.mr_n71797184)
print v(xbgr.mr_n71797296)
print v(xbgr.mr_n71797616)
print v(xbgr.mr_n71797728)
print v(xbgr.mr_n71798048)
print v(xbgr.mr_n71798160)
print v(xbgr.mr_n71798480)
print v(xbgr.mr_n71798592)
print v(xbgr.mr_n71798912)
print v(xbgr.mr_n71799024)
print v(xbgr.mr_n71799344)
print v(xbgr.mr_n71799456)
print v(xbgr.mr_n71799776)
print v(xbgr.mr_n71799888)
print v(xbgr.mr_n71800208)
print v(xbgr.mr_n71800320)
print v(xbgr.mr_n71800640)
print v(xbgr.mr_n71800752)
print v(xbgr.mr_n71801072)
print v(xbgr.mr_n71801184)
print v(xbgr.mr_n71801504)
print v(xbgr.mr_n71801616)
print v(xbgr.mr_n71801936)
print v(xbgr.mr_n71802048)
print v(xbgr.mr_n71802368)
print v(xbgr.mr_n71802480)
print v(xbgr.mr_n71802800)
print v(xbgr.mr_n71802912)
print v(xbgr.mr_n71803232)
print v(xbgr.mr_n71803344)
print v(xbgr.mr_n71803664)
print v(xbgr.mr_n71803776)
print v(xbgr.mr_n71804096)
print v(xbgr.mr_n71804208)
print v(xbgr.mr_n71804528)
print v(xbgr.mr_n71804640)
print v(xbgr.mr_n71804960)
print v(xbgr.mr_n71805072)
print v(xbgr.mr_n71805392)
print v(xbgr.mr_n71805504)
print v(xbgr.mr_n71805824)
print v(xbgr.mr_n71805936)
print v(xbgr.mr_n71806256)
print v(xbgr.mr_n71806368)
print v(xbgr.mr_n71806688)
print v(xbgr.mr_n71806800)
print v(xbgr.mr_n71807120)
print v(xbgr.mr_n71807232)
print v(xbgr.mr_n71807552)
print v(xbgr.mr_n71807664)
print v(xbgr.mr_n71807984)
print v(xbgr.mr_n71808096)
print v(xbgr.mr_n71808416)
print v(xbgr.mr_n71808528)
print v(xbgr.mr_n71808848)
print v(xbgr.mr_n71808960)
print v(xbgr.mr_n71809280)
print v(xbgr.mr_n71809392)
print v(xbgr.mr_n71809712)
print v(xbgr.mr_n71809824)
print v(xbgr.mr_n71810144)
print v(xbgr.mr_n71810256)
print v(xbgr.mr_n71810576)
print v(xbgr.mr_n71810688)
print v(xbgr.mr_n71811008)
print v(xbgr.mr_n71811120)
print v(xbgr.mr_n71811440)
print v(xbgr.mr_n71811552)
print v(xbgr.mr_n71811872)
print v(xbgr.mr_n71811984)
print v(xbgr.mr_n71812304)
print v(xbgr.mr_n71812416)
print v(xbgr.mr_n71812736)
print v(xbgr.mr_n71812848)
print v(xbgr.mr_n71813168)
print v(xbgr.mr_n71813280)
print v(xbgr.mr_n71813600)
print v(xbgr.mr_n71813712)
print v(xbgr.mr_n71814032)
print v(xbgr.mr_n71814144)
print v(xbgr.mr_n71814464)
print v(xbgr.mr_n71814576)
print v(xbgr.mr_n71814896)
print v(xbgr.mr_n71815008)
print v(xbgr.mr_n71815328)
print v(xbgr.mr_n71815440)
print v(xbgr.mr_n71815760)
print v(xbgr.mr_n71815872)
print v(xbgr.mr_n71816192)
print v(xbgr.mr_n71816304)
print v(xbgr.mr_n71816624)
print v(xbgr.mr_n71816736)
print v(xbgr.mr_n71817056)
print v(xbgr.mr_n71817168)
print v(xbgr.mr_n71817488)
print v(xbgr.mr_n71817600)
print v(xbgr.mr_n71817920)
print v(xbgr.mr_n71818032)
print v(xbgr.mr_n71818352)
print v(xbgr.mr_n71818464)
print v(xbgr.mr_n71818784)
print v(xbgr.mr_n71818896)
print v(xbgr.mr_n71819216)
print v(xbgr.mr_n71819328)
print v(xbgr.mr_n71819648)
print v(xbgr.mr_n71819760)
print v(xbgr.mr_n71820080)
print v(xbgr.mr_n71820192)
print v(xbgr.mr_n71820512)
print v(xbgr.mr_n71820624)
print v(xbgr.mr_n71820944)
print v(xbgr.mr_n71821056)
print v(xbgr.mr_n71821376)
print v(xbgr.mr_n71821488)
print v(xbgr.mr_n71821808)
print v(xbgr.mr_n71821920)
print v(xbgr.mr_n71822240)
print v(xbgr.mr_n71822352)
print v(xbgr.mr_n71822672)
print v(xbgr.mr_n71822784)
print v(xbgr.mr_n71823104)
print v(xbgr.mr_n71823216)
print v(xbgr.mr_n71823536)
print v(xbgr.mr_n71823648)
print v(xbgr.mr_n71823968)
print v(xbgr.mr_n71824080)
print v(xbgr.mr_n71824400)
print v(xbgr.mr_n71824512)
print v(xbgr.mr_n71824832)
print v(xbgr.mr_n71824944)
print v(xbgr.mr_n71825264)
print v(xbgr.mr_n71825376)
print v(xbgr.mr_n71825696)
print v(xbgr.mr_n71825808)
print v(xbgr.mr_n71826128)
print v(xbgr.mr_n71826240)
print v(xbgr.mr_n71826560)
print v(xbgr.mr_n71826672)
print v(xbgr.mr_n71826992)
print v(xbgr.mr_n71827104)
print v(xbgr.mr_n71827424)
print v(xbgr.mr_n71827536)
print v(xbgr.mr_n71827856)
print v(xbgr.mr_n71827968)
print v(xbgr.mr_n71828288)
print v(xbgr.mr_n71828400)
print v(xbgr.mr_n71828720)
print v(xbgr.mr_n71828832)
print v(xbgr.mr_n71829152)
print v(xbgr.mr_n71829264)
print v(xbgr.mr_n71829584)
print v(xbgr.mr_n71829696)
print v(xbgr.mr_n71830016)
print v(xbgr.mr_n71830128)
print v(xbgr.mr_n71830448)
print v(xbgr.mr_n71830560)
print v(xbgr.mr_n71830880)
print v(xbgr.mr_n71830992)
print v(xbgr.mr_n71831424)
print v(xbgr.mr_n71831744)
print v(xbgr.mr_n71831856)
print v(xbgr.mr_n71832176)
print v(xbgr.mr_n71832288)
print v(xbgr.mr_n71832608)
print v(xbgr.mr_n71832720)
print v(xbgr.mr_n71833152)
print v(xbgr.mr_n71833472)
print v(xbgr.mr_n71833584)
print v(xbgr.mr_n71833904)
print v(xbgr.mr_n71834016)
print v(xbgr.mr_n71834336)
print v(xbgr.mr_n71834448)
print v(xbgr.mr_n71834768)
print v(xbgr.mr_n71834880)
print v(xbgr.mr_n71835200)
print v(xbgr.mr_n71835312)
print v(xbgr.mr_n71835632)
print v(xbgr.mr_n71835744)
print v(xbgr.mr_n71836064)
print v(xbgr.mr_n71836176)
print v(xbgr.mr_n71836496)
print v(xbgr.mr_n71836608)
print v(xbgr.mr_n71836928)
print v(xbgr.mr_n71837040)
print v(xbgr.mr_n71837360)
print v(xbgr.mr_n71837472)
print v(xbgr.mr_n71837792)
print v(xbgr.mr_n71837904)
print v(xbgr.mr_n71838224)
print v(xbgr.mr_n71838336)
print v(xbgr.mr_n71838656)
print v(xbgr.mr_n71838768)
print v(xbgr.mr_n71839088)
print v(xbgr.mr_n71839200)
print v(xbgr.mr_n71839520)
print v(xbgr.mr_n71839632)
print v(xbgr.mr_n71840064)
print v(xbgr.mr_n71840384)
print v(xbgr.mr_n71840496)
print v(xbgr.mr_n71840816)
print v(xbgr.mr_n71840928)
print v(xbgr.mr_n71841248)
print v(xbgr.mr_n71841360)
print v(xbgr.mr_n71841680)
print v(xbgr.mr_n71841792)
print v(xbgr.mr_n71842112)
print v(xbgr.mr_n71842224)
print v(xbgr.mr_n71842544)
print v(xbgr.mr_n71842656)
print v(xbgr.mr_n71842976)
print v(xbgr.mr_n71843088)
print v(xbgr.mr_n71843520)
print v(xbgr.mr_n71843840)
print v(xbgr.mr_n71843952)
print v(xbgr.mr_n71844272)
print v(xbgr.mr_n71844384)
print v(xbgr.mr_n71844704)
print v(xbgr.mr_n71844816)
print v(xbgr.mr_n71845136)
print v(xbgr.mr_n71845248)
print v(xbgr.mr_n71845568)
print v(xbgr.mr_n71845680)
print v(xbgr.mr_n71846000)
print v(xbgr.mr_n71846112)
print v(xbgr.mr_n71846432)
print v(xbgr.mr_n71846544)
print v(xbgr.mr_n71846864)
print v(xbgr.mr_n71846976)
print v(xbgr.mr_n71847296)
print v(xbgr.mr_n71847408)
print v(xbgr.mr_n71847728)
print v(xbgr.mr_n71847840)
print v(xbgr.mr_n71848160)
print v(xbgr.mr_n71848272)
print v(xbgr.mr_n71848592)
print v(xbgr.mr_n71848704)
print v(xbgr.mr_n71849024)
print v(xbgr.mr_n71849136)
print v(xbgr.mr_n71849568)
print v(xbgr.mr_n71849888)
print v(xbgr.mr_n71850000)
print v(xbgr.mr_n71850320)
print v(xbgr.mr_n71850432)
print v(xbgr.mr_n71850752)
print v(xbgr.mr_n71850864)
print v(xbgr.mr_n71851296)
print v(xbgr.mr_n71851616)
print v(xbgr.mr_n71851728)
print v(xbgr.mr_n71852048)
print v(xbgr.mr_n71852160)
print v(xbgr.mr_n71852480)
print v(xbgr.mr_n71852592)
print v(xbgr.mr_n71852912)
print v(xbgr.mr_n71853024)
print v(xbgr.mr_n71853344)
print v(xbgr.mr_n71853456)
print v(xbgr.mr_n71853888)
print v(xbgr.mr_n71854208)
print v(xbgr.mr_n71854320)
print v(xbgr.mr_n71854640)
print v(xbgr.mr_n71854752)
print v(xbgr.mr_n71855072)
print v(xbgr.mr_n71855184)
print v(xbgr.mr_n71855504)
print v(xbgr.mr_n71855616)
print v(xbgr.mr_n71855936)
print v(xbgr.mr_n71856048)
print v(xbgr.mr_n71856368)
print v(xbgr.mr_n71856480)
print v(xbgr.mr_n71856800)
print v(xbgr.mr_n71856912)
print v(xbgr.mr_n71857232)
print v(xbgr.mr_n71857344)
print v(xbgr.mr_n71857664)
print v(xbgr.mr_n71857776)
print v(xbgr.mr_n71858096)
print v(xbgr.mr_n71858208)
print v(xbgr.mr_n71858528)
print v(xbgr.mr_n71858640)
print v(xbgr.mr_n71858960)
print v(xbgr.mr_n71859072)
print v(xbgr.mr_n71859392)
print v(xbgr.mr_n71859504)
print v(xbgr.mr_n71859936)
print v(xbgr.mr_n71860256)
print v(xbgr.mr_n71860368)
print v(xbgr.mr_n71860688)
print v(xbgr.mr_n71860800)
print v(xbgr.mr_n71861120)
print v(xbgr.mr_n71861232)
print v(xbgr.mr_n71861664)
print v(xbgr.mr_n71861984)
print v(xbgr.mr_n71862096)
print v(xbgr.mr_n71862528)
print v(xbgr.mr_n71862848)
print v(xbgr.mr_n71862960)
print v(xbgr.mr_n71863280)
print v(xbgr.mr_n71863392)
print v(xbgr.mr_n71863712)
print v(xbgr.mr_n71863824)
print v(xbgr.mr_n71864256)
print v(xbgr.mr_n71864576)
print v(xbgr.mr_n71864688)
print v(xbgr.mr_n71865008)
print v(xbgr.mr_n71865120)
print v(xbgr.mr_n71865440)
print v(xbgr.mr_n71865552)
print v(xbgr.mr_n71865872)
print v(xbgr.mr_n71865984)
print v(xbgr.mr_n71866304)
print v(xbgr.mr_n71866416)
print v(xbgr.mr_n71866736)
print v(xbgr.mr_n71866848)
print v(xbgr.mr_n71867168)
print v(xbgr.mr_n71867280)
print v(xbgr.mr_n71867600)
print v(xbgr.mr_n71867712)
print v(xbgr.mr_n71868032)
print v(xbgr.mr_n71868144)
print v(xbgr.mr_n71868576)
print v(xbgr.mr_n71868896)
print v(xbgr.mr_n71869008)
print v(xbgr.mr_n71869328)
print v(xbgr.mr_n71869440)
print v(xbgr.mr_n71869760)
print v(xbgr.mr_n71869872)
print v(xbgr.mr_n71870192)
print v(xbgr.mr_n71870304)
print v(xbgr.mr_n71870624)
print v(xbgr.mr_n71870736)
print v(xbgr.mr_n71871056)
print v(xbgr.mr_n71871168)
print v(xbgr.mr_n71871488)
print v(xbgr.mr_n71871600)
print v(xbgr.mr_n71871920)
print v(xbgr.mr_n71872032)
print v(xbgr.mr_n71872352)
print v(xbgr.mr_n71872464)
print v(xbgr.mr_n71872784)
print v(xbgr.mr_n71872896)
print v(xbgr.mr_n71873216)
print v(xbgr.mr_n71873328)
print v(xbgr.mr_n71873648)
print v(xbgr.mr_n71873760)
print v(xbgr.mr_n71874080)
print v(xbgr.mr_n71874192)
print v(xbgr.mr_n71874512)
print v(xbgr.mr_n71874624)
print v(xbgr.mr_n71874944)
print v(xbgr.mr_n71875056)
print v(xbgr.mr_n71875376)
print v(xbgr.mr_n71875488)
print v(xbgr.mr_n71875808)
print v(xbgr.mr_n71875920)
print v(xbgr.mr_n71876240)
print v(xbgr.mr_n71876352)
print v(xbgr.mr_n71876672)
print v(xbgr.mr_n71876784)
print v(xbgr.mr_n71877104)
print v(xbgr.mr_n71877216)
print v(xbgr.mr_n71877536)
print v(xbgr.mr_n71877648)
print v(xbgr.mr_n71877968)
print v(xbgr.mr_n71878080)
print v(xbgr.mr_n71878400)
print v(xbgr.mr_n71878512)
print v(xbgr.mr_n71878832)
print v(xbgr.mr_n71878944)
print v(xbgr.mr_n71879264)
print v(xbgr.mr_n71879376)
print v(xbgr.mr_n71879696)
print v(xbgr.mr_n71879808)
print v(xbgr.mr_n71880128)
print v(xbgr.mr_n71880240)
print v(xbgr.mr_n71880560)
print v(xbgr.mr_n71880672)
print v(xbgr.mr_n71880992)
print v(xbgr.mr_n71881104)
print v(xbgr.mr_n71881424)
print v(xbgr.mr_n71881536)
print v(xbgr.mr_n71881856)
print v(xbgr.mr_n71881968)
print v(xbgr.mr_n71882288)
print v(xbgr.mr_n71882400)
print v(xbgr.mr_n71882720)
print v(xbgr.mr_n71882832)
print v(xbgr.mr_n71883152)
print v(xbgr.mr_n71883264)
print v(xbgr.mr_n71883584)
print v(xbgr.mr_n71883696)
print v(xbgr.mr_n71884016)
print v(xbgr.mr_n71884128)
print v(xbgr.mr_n71884448)
print v(xbgr.mr_n71884560)
print v(xbgr.mr_n71884880)
print v(xbgr.mr_n71884992)
print v(xbgr.mr_n71885312)
print v(xbgr.mr_n71885424)
print v(xbgr.mr_n71885744)
print v(xbgr.mr_n71885856)
print v(xbgr.mr_n71886176)
print v(xbgr.mr_n71886288)
print v(xbgr.mr_n71886608)
print v(xbgr.mr_n71886720)
print v(xbgr.mr_n71887040)
print v(xbgr.mr_n71887152)
print v(xbgr.mr_n71887472)
print v(xbgr.mr_n71887584)
print v(xbgr.mr_n71887904)
print v(xbgr.mr_n71888016)
print v(xbgr.mr_n71888336)
print v(xbgr.mr_n71888448)
print v(xbgr.mr_n71888768)
print v(xbgr.mr_n71888880)
print v(xbgr.mr_n71889200)
print v(xbgr.mr_n71889312)
print v(xbgr.mr_n71889632)
print v(xbgr.mr_n71889744)
print v(xbgr.mr_n71890064)
print v(xbgr.mr_n71890176)
print v(xbgr.mr_n71890496)
print v(xbgr.mr_n71890608)
print v(xbgr.mr_n71890928)
print v(xbgr.mr_n71891040)
print v(xbgr.mr_n71891360)
print v(xbgr.mr_n71891472)
print v(xbgr.mr_n71891792)
print v(xbgr.mr_n71891904)
print v(xbgr.mr_n71892224)
print v(xbgr.mr_n71892336)
print v(xbgr.mr_n71892656)
print v(xbgr.mr_n71892768)
print v(xbgr.mr_n71893088)
print v(xbgr.mr_n71893200)
print v(xbgr.mr_n71893520)
print v(xbgr.mr_n71893632)
print v(xbgr.mr_n71893952)
print v(xbgr.mr_n71894064)
print v(xbgr.mr_n71894384)
print v(xbgr.mr_n71894496)
print v(xbgr.mr_n71894816)
print v(xbgr.mr_n71894928)
print v(xbgr.mr_n71895248)
print v(xbgr.mr_n71895360)
print v(xbgr.mr_n71895680)
print v(xbgr.mr_n71895792)
print v(xbgr.mr_n71896112)
print v(xbgr.mr_n71896224)
print v(xbgr.mr_n71896544)
print v(xbgr.mr_n71896656)
print v(xbgr.mr_n71896976)
print v(xbgr.mr_n71897088)
print v(xbgr.mr_n71897408)
print v(xbgr.mr_n71897520)
print v(xbgr.mr_n71897840)
print v(xbgr.mr_n71897952)
print v(xbgr.mr_n71898272)
print v(xbgr.mr_n71898384)
print v(xbgr.mr_n71898704)
print v(xbgr.mr_n71898816)
print v(xbgr.mr_n71899136)
print v(xbgr.mr_n71899248)
print v(xbgr.mr_n71899568)
print v(xbgr.mr_n71899680)
print v(xbgr.mr_n71900000)
print v(xbgr.mr_n71900112)
print v(xbgr.mr_n71900432)
print v(xbgr.mr_n71900544)
print v(xbgr.mr_n71900864)
print v(xbgr.mr_n71900976)
print v(xbgr.mr_n71901296)
print v(xbgr.mr_n71901408)
print v(xbgr.mr_n71901728)
print v(xbgr.mr_n71901840)
print v(xbgr.mr_n71902160)
print v(xbgr.mr_n71902272)
print v(xbgr.mr_n71902592)
print v(xbgr.mr_n71902704)
print v(xbgr.mr_n71903024)
print v(xbgr.mr_n71903136)
print v(xbgr.mr_n71903456)
print v(xbgr.mr_n71903568)
print v(xbgr.mr_n71903888)
print v(xbgr.mr_n71904000)
print v(xbgr.mr_n71904320)
print v(xbgr.mr_n71904432)
print v(xbgr.mr_n71904752)
print v(xbgr.mr_n71904864)
print v(xbgr.mr_n71905184)
print v(xbgr.mr_n71905296)
print v(xbgr.mr_n71905616)
print v(xbgr.mr_n71905728)
print v(xbgr.mr_n71906048)
print v(xbgr.mr_n71906160)
print v(xbgr.mr_n71906480)
print v(xbgr.mr_n71906592)
print v(xbgr.mr_n71906912)
print v(xbgr.mr_n71907024)
print v(xbgr.mr_n71907344)
print v(xbgr.mr_n71907456)
print v(xbgr.mr_n71907776)
print v(xbgr.mr_n71907888)
print v(xbgr.mr_n71908208)
print v(xbgr.mr_n71908320)
print v(xbgr.mr_n71908640)
print v(xbgr.mr_n71908752)
print v(xbgr.mr_n71909072)
print v(xbgr.mr_n71909184)
print v(xbgr.mr_n71909504)
print v(xbgr.mr_n71909616)
print v(xbgr.mr_n71909936)
print v(xbgr.mr_n71910048)
print v(xbgr.mr_n71910368)
print v(xbgr.mr_n71910480)
print v(xbgr.mr_n71910800)
print v(xbgr.mr_n71910912)
print v(xbgr.mr_n71911232)
print v(xbgr.mr_n71911344)
print v(xbgr.mr_n71911664)
print v(xbgr.mr_n71911776)
print v(xbgr.mr_n71912096)
print v(xbgr.mr_n71912208)
print v(xbgr.mr_n71912528)
print v(xbgr.mr_n71912640)
print v(xbgr.mr_n71912960)
print v(xbgr.mr_n71913072)
print v(xbgr.mr_n71913392)
print v(xbgr.mr_n71913504)
print v(xbgr.mr_n71913824)
print v(xbgr.mr_n71913936)
print v(xbgr.mr_n71914256)
print v(xbgr.mr_n71914368)
print v(xbgr.mr_n71914688)
print v(xbgr.mr_n71914800)
print v(xbgr.mr_n71915120)
print v(xbgr.mr_n71915232)
print v(xbgr.mr_n71915552)
print v(xbgr.mr_n71915664)
print v(xbgr.mr_n71915984)
print v(xbgr.mr_n71916096)
print v(xbgr.mr_n71916416)
print v(xbgr.mr_n71916528)
print v(xbgr.mr_n71916848)
print v(xbgr.mr_n71916960)
print v(xbgr.mr_n71917280)
print v(xbgr.mr_n71917392)
print v(xbgr.mr_n71917712)
print v(xbgr.mr_n71917824)
print v(xbgr.mr_n71918144)
print v(xbgr.mr_n71918256)
print v(xbgr.mr_n71918576)
print v(xbgr.mr_n71918688)
print v(xbgr.mr_n71919008)
print v(xbgr.mr_n71919120)
print v(xbgr.mr_n71919440)
print v(xbgr.mr_n71919552)
print v(xbgr.mr_n71919872)
print v(xbgr.mr_n71919984)
print v(xbgr.mr_n71920304)
print v(xbgr.mr_n71920416)
print v(xbgr.mr_n71920736)
print v(xbgr.mr_n71920848)
print v(xbgr.mr_n71921168)
print v(xbgr.mr_n71921280)
print v(xbgr.mr_n71921600)
print v(xbgr.mr_n71921712)
print v(xbgr.mr_n71922032)
print v(xbgr.mr_n71922144)
print v(xbgr.mr_n71922464)
print v(xbgr.mr_n71922576)
print v(xbgr.mr_n71922896)
print v(xbgr.mr_n71923008)
print v(xbgr.mr_n71923328)
print v(xbgr.mr_n71923440)
print v(xbgr.mr_n71923760)
print v(xbgr.mr_n71923872)
print v(xbgr.mr_n71924192)
print v(xbgr.mr_n71924304)
print v(xbgr.mr_n71924624)
print v(xbgr.mr_n71924736)
print v(xbgr.mr_n71925056)
print v(xbgr.mr_n71925168)
print v(xbgr.mr_n71925488)
print v(xbgr.mr_n71925600)
print v(xbgr.mr_n71925920)
print v(xbgr.mr_n71926032)
print v(xbgr.mr_n71926352)
print v(xbgr.mr_n71926464)
print v(xbgr.mr_n71926784)
print v(xbgr.mr_n71926896)
print v(xbgr.mr_n71927216)
print v(xbgr.mr_n71927328)
print v(xbgr.mr_n71927648)
print v(xbgr.mr_n71927760)
print v(xbgr.mr_n71928080)
print v(xbgr.mr_n71928192)
print v(xbgr.mr_n71928512)
print v(xbgr.mr_n71928624)
print v(xbgr.mr_n71928944)
print v(xbgr.mr_n71929056)
print v(xbgr.mr_n71929376)
print v(xbgr.mr_n71929488)
print v(xbgr.mr_n71929808)
print v(xbgr.mr_n71929920)
print v(xbgr.mr_n71930240)
print v(xbgr.mr_n71930352)
print v(xbgr.mr_n71930672)
print v(xbgr.mr_n71930784)
print v(xbgr.mr_n71931104)
print v(xbgr.mr_n71931216)
print v(xbgr.mr_n71931536)
print v(xbgr.mr_n71931648)
print v(xbgr.mr_n71931968)
print v(xbgr.mr_n71932080)
print v(xbgr.mr_n71932400)
print v(xbgr.mr_n71932512)
print v(xbgr.mr_n71932832)
print v(xbgr.mr_n71932944)
print v(xbgr.mr_n71933264)
print v(xbgr.mr_n71933376)
print v(xbgr.mr_n71933696)
print v(xbgr.mr_n71933808)
print v(xbgr.mr_n71934128)
print v(xbgr.mr_n71934240)
print v(xbgr.mr_n71934560)
print v(xbgr.mr_n71934672)
print v(xbgr.mr_n71934992)
print v(xbgr.mr_n71935104)
print v(xbgr.mr_n71935424)
print v(xbgr.mr_n71935536)
print v(xbgr.mr_n71935856)
print v(xbgr.mr_n71935968)
print v(xbgr.mr_n71936288)
print v(xbgr.mr_n71936400)
print v(xbgr.mr_n71936720)
print v(xbgr.mr_n71936832)
print v(xbgr.mr_n71937152)
print v(xbgr.mr_n71937264)
print v(xbgr.mr_n71937584)
print v(xbgr.mr_n71937696)
print v(xbgr.mr_n71938016)
print v(xbgr.mr_n71938128)
print v(xbgr.mr_n71938448)
print v(xbgr.mr_n71938560)
print v(xbgr.mr_n71938880)
print v(xbgr.mr_n71938992)
print v(xbgr.mr_n71939312)
print v(xbgr.mr_n71939424)
print v(xbgr.mr_n71939744)
print v(xbgr.mr_n71939856)
print v(xbgr.mr_n71940176)
print v(xbgr.mr_n71940288)
print v(xbgr.mr_n71940608)
print v(xbgr.mr_n71940720)
print v(xbgr.mr_n71941040)
print v(xbgr.mr_n71941152)
print v(xbgr.mr_n71941472)
print v(xbgr.mr_n71941584)
print v(xbgr.mr_n71941904)
print v(xbgr.mr_n71942016)
print v(xbgr.mr_n71942336)
print v(xbgr.mr_n71942448)
print v(xbgr.mr_n71942768)
print v(xbgr.mr_n71942880)
print v(xbgr.mr_n71943200)
print v(xbgr.mr_n71943312)
print v(xbgr.mr_n71943632)
print v(xbgr.mr_n71943744)
print v(xbgr.mr_n71944064)
print v(xbgr.mr_n71944176)
print v(xbgr.mr_n71944496)
print v(xbgr.mr_n71944608)
print v(xbgr.mr_n71944928)
print v(xbgr.mr_n71945040)
print v(xbgr.mr_n71945360)
print v(xbgr.mr_n71945472)
print v(xbgr.mr_n71945792)
print v(xbgr.mr_n71945904)
print v(xbgr.mr_n71946224)
print v(xbgr.mr_n71946336)
print v(xbgr.mr_n71946656)
print v(xbgr.mr_n71946768)
print v(xbgr.mr_n71947088)
print v(xbgr.mr_n71947200)
print v(xbgr.mr_n71947520)
print v(xbgr.mr_n71947632)
print v(xbgr.mr_n71947952)
print v(xbgr.mr_n71948064)
print v(xbgr.mr_n71948384)
print v(xbgr.mr_n71948496)
print v(xbgr.mr_n71948816)
print v(xbgr.mr_n71948928)
print v(xbgr.mr_n71949248)
print v(xbgr.mr_n71949360)
print v(xbgr.mr_n71949680)
print v(xbgr.mr_n71949792)
print v(xbgr.mr_n71950112)
print v(xbgr.mr_n71950224)
print v(xbgr.mr_n71950544)
print v(xbgr.mr_n71950656)
print v(xbgr.mr_n71950976)
print v(xbgr.mr_n71951088)
print v(xbgr.mr_n71951408)
print v(xbgr.mr_n71951520)
print v(xbgr.mr_n71951840)
print v(xbgr.mr_n71951952)
print v(xbgr.mr_n71952272)
print v(xbgr.mr_n71952384)
print v(xbgr.mr_n71952704)
print v(xbgr.mr_n71952816)
print v(xbgr.mr_n71953136)
print v(xbgr.mr_n71953248)
print v(xbgr.mr_n71953568)
print v(xbgr.mr_n71953680)
print v(xbgr.mr_n71954000)
print v(xbgr.mr_n71954112)
print v(xbgr.mr_n71954432)
print v(xbgr.mr_n71954544)
print v(xbgr.mr_n71954864)
print v(xbgr.mr_n71954976)
print v(xbgr.mr_n71955296)
print v(xbgr.mr_n71955408)
print v(xbgr.mr_n71955728)
print v(xbgr.mr_n71955840)
print v(xbgr.mr_n71956160)
print v(xbgr.mr_n71956272)
print v(xbgr.mr_n71956592)
print v(xbgr.mr_n71956704)
print v(xbgr.mr_n71957024)
print v(xbgr.mr_n71957136)
print v(xbgr.mr_n71957456)
print v(xbgr.mr_n71957568)
print v(xbgr.mr_n71957888)
print v(xbgr.mr_n71958000)
print v(xbgr.mr_n71958320)
print v(xbgr.mr_n71958432)
print v(xbgr.mr_n71958752)
print v(xbgr.mr_n71958864)
print v(xbgr.mr_n71959184)
print v(xbgr.mr_n71959296)
print v(xbgr.mr_n71959616)
print v(xbgr.mr_n71959728)
print v(xbgr.mr_n71960048)
print v(xbgr.mr_n71960160)
print v(xbgr.mr_n71960480)
print v(xbgr.mr_n71960592)
print v(xbgr.mr_n71960912)
print v(xbgr.mr_n71961024)
print v(xbgr.mr_n71961344)
print v(xbgr.mr_n71961456)
print v(xbgr.mr_n71961776)
print v(xbgr.mr_n71961888)
print v(xbgr.mr_n71962208)
print v(xbgr.mr_n71962320)
print v(xbgr.mr_n71962640)
print v(xbgr.mr_n71962752)
print v(xbgr.mr_n71963072)
print v(xbgr.mr_n71963184)
print v(xbgr.mr_n71963504)
print v(xbgr.mr_n71963616)
print v(xbgr.mr_n71963936)
print v(xbgr.mr_n71964048)
print v(xbgr.mr_n71964368)
print v(xbgr.mr_n71964480)
print v(xbgr.mr_n71964800)
print v(xbgr.mr_n71964912)
print v(xbgr.mr_n71965232)
print v(xbgr.mr_n71965344)
print v(xbgr.mr_n71965664)
print v(xbgr.mr_n71965776)
print v(xbgr.mr_n71966096)
print v(xbgr.mr_n71966208)
print v(xbgr.mr_n71966528)
print v(xbgr.mr_n71966640)
print v(xbgr.mr_n71966960)
print v(xbgr.mr_n71967072)
print v(xbgr.mr_n71967392)
print v(xbgr.mr_n71967504)
print v(xbgr.mr_n71967824)
print v(xbgr.mr_n71967936)
print v(xbgr.mr_n71968256)
print v(xbgr.mr_n71968368)
print v(xbgr.mr_n71968688)
print v(xbgr.mr_n71968800)
print v(xbgr.mr_n71969120)
print v(xbgr.mr_n71969232)
print v(xbgr.mr_n71969552)
print v(xbgr.mr_n71969664)
print v(xbgr.mr_n71969984)
print v(xbgr.mr_n71970096)
print v(xbgr.mr_n71970416)
print v(xbgr.mr_n71970528)
print v(xbgr.mr_n71970848)
print v(xbgr.mr_n71970960)
print v(xbgr.mr_n71971280)
print v(xbgr.mr_n71971392)
print v(xbgr.mr_n71971712)
print v(xbgr.mr_n71971824)
print v(xbgr.mr_n71972144)
print v(xbgr.mr_n71972256)
print v(xbgr.mr_n71972576)
print v(xbgr.mr_n71972688)
print v(xbgr.mr_n71973120)
print v(xbgr.mr_n71973440)
print v(xbgr.mr_n71973552)
print v(xbgr.mr_n71973872)
print v(xbgr.mr_n71973984)
print v(xbgr.mr_n71974304)
print v(xbgr.mr_n71974416)
print v(xbgr.mr_n71974736)
print v(xbgr.mr_n71974848)
print v(xbgr.mr_n71975168)
print v(xbgr.mr_n71975280)
print v(xbgr.mr_n71975712)
print v(xbgr.mr_n71976032)
print v(xbgr.mr_n71976144)
print v(xbgr.mr_n71976464)
print v(xbgr.mr_n71976576)
print v(xbgr.mr_n71976896)
print v(xbgr.mr_n71977008)
print v(xbgr.mr_n71977328)
print v(xbgr.mr_n71977440)
print v(xbgr.mr_n71977760)
print v(xbgr.mr_n71977872)
print v(xbgr.mr_n71978304)
print v(xbgr.mr_n71978624)
print v(xbgr.mr_n71978736)
print v(xbgr.mr_n71979056)
print v(xbgr.mr_n71979168)
print v(xbgr.mr_n71979488)
print v(xbgr.mr_n71979600)
print v(xbgr.mr_n71979920)
print v(xbgr.mr_n71980032)
print v(xbgr.mr_n71980352)
print v(xbgr.mr_n71980464)
print v(xbgr.mr_n71980784)
print v(xbgr.mr_n71980896)
print v(xbgr.mr_n71981216)
print v(xbgr.mr_n71981328)
print v(xbgr.mr_n71981760)
print v(xbgr.mr_n71982080)
print v(xbgr.mr_n71982192)
print v(xbgr.mr_n71982624)
print v(xbgr.mr_n71982944)
print v(xbgr.mr_n71983056)
print v(xbgr.mr_n71983376)
print v(xbgr.mr_n71983488)
print v(xbgr.mr_n71983808)
print v(xbgr.mr_n71983920)
print v(xbgr.mr_n71984240)
print v(xbgr.mr_n71984352)
print v(xbgr.mr_n71984672)
print v(xbgr.mr_n71984784)
print v(xbgr.mr_n71985216)
print v(xbgr.mr_n71985536)
print v(xbgr.mr_n71985648)
print v(xbgr.mr_n71986080)
print v(xbgr.mr_n71986400)
print v(xbgr.mr_n71986512)
print v(xbgr.mr_n71986832)
print v(xbgr.mr_n71986944)
print v(xbgr.mr_n71987264)
print v(xbgr.mr_n71987376)
print v(xbgr.mr_n71987696)
print v(xbgr.mr_n71987808)
print v(xbgr.mr_n71988128)
print v(xbgr.mr_n71988240)
print v(xbgr.mr_n71988560)
print v(xbgr.mr_n71988672)
print v(xbgr.mr_n71988992)
print v(xbgr.mr_n71989104)
print v(xbgr.mr_n71989424)
print v(xbgr.mr_n71989536)
print v(xbgr.mr_n71989856)
print v(xbgr.mr_n71989968)
print v(xbgr.mr_n71990288)
print v(xbgr.mr_n71990400)
print v(xbgr.mr_n71990720)
print v(xbgr.mr_n71990832)
print v(xbgr.mr_n71991152)
print v(xbgr.mr_n71991264)
print v(xbgr.mr_n71991584)
print v(xbgr.mr_n71991696)
print v(xbgr.mr_n71992016)
print v(xbgr.mr_n71992128)
print v(xbgr.mr_n71992448)
print v(xbgr.mr_n71992560)
print v(xbgr.mr_n71992880)
print v(xbgr.mr_n71992992)
print v(xbgr.mr_n71993312)
print v(xbgr.mr_n71993424)
print v(xbgr.mr_n71993744)
print v(xbgr.mr_n71993856)
print v(xbgr.mr_n71994176)
print v(xbgr.mr_n71994288)
print v(xbgr.mr_n71994608)
print v(xbgr.mr_n71994720)
print v(xbgr.mr_n71995040)
print v(xbgr.mr_n71995152)
print v(xbgr.mr_n71995472)
print v(xbgr.mr_n71995584)
print v(xbgr.mr_n71995904)
print v(xbgr.mr_n71996016)
print v(xbgr.mr_n71996336)
print v(xbgr.mr_n71996448)
print v(xbgr.mr_n71996768)
print v(xbgr.mr_n71996880)
print v(xbgr.mr_n71997200)
print v(xbgr.mr_n71997312)
print v(xbgr.mr_n71997632)
print v(xbgr.mr_n71997744)
print v(xbgr.mr_n71998064)
print v(xbgr.mr_n71998176)
print v(xbgr.mr_n71998496)
print v(xbgr.mr_n71998608)
print v(xbgr.mr_n71998928)
print v(xbgr.mr_n71999040)
print v(xbgr.mr_n71999360)
print v(xbgr.mr_n71999472)
print v(xbgr.mr_n71999792)
print v(xbgr.mr_n71999904)
print v(xbgr.mr_n72000224)
print v(xbgr.mr_n72000336)
print v(xbgr.mr_n72000656)
print v(xbgr.mr_n72000768)
print v(xbgr.mr_n72001088)
print v(xbgr.mr_n72001200)
print v(xbgr.mr_n72001520)
print v(xbgr.mr_n72001632)
print v(xbgr.mr_n72001952)
print v(xbgr.mr_n72002064)
print v(xbgr.mr_n72002384)
print v(xbgr.mr_n72002496)
print v(xbgr.mr_n72002816)
print v(xbgr.mr_n72002928)
print v(xbgr.mr_n72003248)
print v(xbgr.mr_n72003360)
print v(xbgr.mr_n72003680)
print v(xbgr.mr_n72003792)
print v(xbgr.mr_n72004112)
print v(xbgr.mr_n72004224)
print v(xbgr.mr_n72004544)
print v(xbgr.mr_n72004656)
print v(xbgr.mr_n72004976)
print v(xbgr.mr_n72005088)
print v(xbgr.mr_n72005408)
print v(xbgr.mr_n72005520)
print v(xbgr.mr_n72005840)
print v(xbgr.mr_n72005952)
print v(xbgr.mr_n72006272)
print v(xbgr.mr_n72006384)
print v(xbgr.mr_n72006704)
print v(xbgr.mr_n72006816)
print v(xbgr.mr_n72007136)
print v(xbgr.mr_n72007248)
print v(xbgr.mr_n72007568)
print v(xbgr.mr_n72007680)
print v(xbgr.mr_n72008000)
print v(xbgr.mr_n72008112)
print v(xbgr.mr_n72008432)
print v(xbgr.mr_n72008544)
print v(xbgr.mr_n72008864)
print v(xbgr.mr_n72008976)
print v(xbgr.mr_n72009296)
print v(xbgr.mr_n72009408)
print v(xbgr.mr_n72009728)
print v(xbgr.mr_n72009840)
print v(xbgr.mr_n72010160)
print v(xbgr.mr_n72010272)
print v(xbgr.mr_n72010592)
print v(xbgr.mr_n72010704)
print v(xbgr.mr_n72011024)
print v(xbgr.mr_n72011136)
print v(xbgr.mr_n72011456)
print v(xbgr.mr_n72011568)
print v(xbgr.mr_n72011888)
print v(xbgr.mr_n72012000)
print v(xbgr.mr_n72012320)
print v(xbgr.mr_n72012432)
print v(xbgr.mr_n72012752)
print v(xbgr.mr_n72012864)
print v(xbgr.mr_n72013184)
print v(xbgr.mr_n72013296)
print v(xbgr.mr_n72013616)
print v(xbgr.mr_n72013728)
print v(xbgr.mr_n72014048)
print v(xbgr.mr_n72014160)
print v(xbgr.mr_n72014480)
print v(xbgr.mr_n72014592)
print v(xbgr.mr_n72014912)
print v(xbgr.mr_n72015024)
print v(xbgr.mr_n72015344)
print v(xbgr.mr_n72015456)
print v(xbgr.mr_n72015776)
print v(xbgr.mr_n72015888)
print v(xbgr.mr_n72016208)
print v(xbgr.mr_n72016320)
print v(xbgr.mr_n72016640)
print v(xbgr.mr_n72016752)
print v(xbgr.mr_n72017072)
print v(xbgr.mr_n72017184)
print v(xbgr.mr_n72017504)
print v(xbgr.mr_n72017616)
print v(xbgr.mr_n72017936)
print v(xbgr.mr_n72018048)
print v(xbgr.mr_n72018368)
print v(xbgr.mr_n72018480)
print v(xbgr.mr_n72018800)
print v(xbgr.mr_n72018912)
print v(xbgr.mr_n72019232)
print v(xbgr.mr_n72019344)
print v(xbgr.mr_n72019776)
print v(xbgr.mr_n72020096)
print v(xbgr.mr_n72020208)
print v(xbgr.mr_n72020528)
print v(xbgr.mr_n72020640)
print v(xbgr.mr_n72020960)
print v(xbgr.mr_n72021072)
print v(xbgr.mr_n72021504)
print v(xbgr.mr_n72021824)
print v(xbgr.mr_n72021936)
print v(xbgr.mr_n72022368)
print v(xbgr.mr_n72022688)
print v(xbgr.mr_n72022800)
print v(xbgr.mr_n72023120)
print v(xbgr.mr_n72023232)
print v(xbgr.mr_n72023552)
print v(xbgr.mr_n72023664)
print v(xbgr.mr_n72023984)
print v(xbgr.mr_n72024096)
print v(xbgr.mr_n72024416)
print v(xbgr.mr_n72024528)
print v(xbgr.mr_n72024848)
print v(xbgr.mr_n72024960)
print v(xbgr.mr_n72025280)
print v(xbgr.mr_n72025392)
print v(xbgr.mr_n72025712)
print v(xbgr.mr_n72025824)
print v(xbgr.mr_n72026144)
print v(xbgr.mr_n72026256)
print v(xbgr.mr_n72026576)
print v(xbgr.mr_n72026688)
print v(xbgr.mr_n72027008)
print v(xbgr.mr_n72027120)
print v(xbgr.mr_n72027440)
print v(xbgr.mr_n72027552)
print v(xbgr.mr_n72027872)
print v(xbgr.mr_n72027984)
print v(xbgr.mr_n72028304)
print v(xbgr.mr_n72028416)
print v(xbgr.mr_n72028736)
print v(xbgr.mr_n72028848)
print v(xbgr.mr_n72029168)
print v(xbgr.mr_n72029280)
print v(xbgr.mr_n72029600)
print v(xbgr.mr_n72029712)
print v(xbgr.mr_n72030032)
print v(xbgr.mr_n72030144)
print v(xbgr.mr_n72030464)
print v(xbgr.mr_n72030576)
print v(xbgr.mr_n72030896)
print v(xbgr.mr_n72031008)
print v(xbgr.mr_n72031328)
print v(xbgr.mr_n72031440)
print v(xbgr.mr_n72031760)
print v(xbgr.mr_n72031872)
print v(xbgr.mr_n72032192)
print v(xbgr.mr_n72032304)
print v(xbgr.mr_n72032624)
print v(xbgr.mr_n72032736)
print v(xbgr.mr_n72033056)
print v(xbgr.mr_n72033168)
print v(xbgr.mr_n72033488)
print v(xbgr.mr_n72033600)
print v(xbgr.mr_n72033920)
print v(xbgr.mr_n72034032)
print v(xbgr.mr_n72034464)
print v(xbgr.mr_n72034784)
print v(xbgr.mr_n72034896)
print v(xbgr.mr_n72035216)
print v(xbgr.mr_n72035328)
print v(xbgr.mr_n72035648)
print v(xbgr.mr_n72035760)
print v(xbgr.mr_n72036080)
print v(xbgr.mr_n72036192)
print v(xbgr.mr_n72036512)
print v(xbgr.mr_n72036624)
print v(xbgr.mr_n72036944)
print v(xbgr.mr_n72037056)
print v(xbgr.mr_n72037376)
print v(xbgr.mr_n72037488)
print v(xbgr.mr_n72037808)
print v(xbgr.mr_n72037920)
print v(xbgr.mr_n72038240)
print v(xbgr.mr_n72038352)
print v(xbgr.mr_n72038784)
print v(xbgr.mr_n72039104)
print v(xbgr.mr_n72039216)
print v(xbgr.mr_n72039536)
print v(xbgr.mr_n72039648)
print v(xbgr.mr_n72039968)
print v(xbgr.mr_n72040080)
print v(xbgr.mr_n72040512)
print v(xbgr.mr_n72040832)
print v(xbgr.mr_n72040944)
print v(xbgr.mr_n72041264)
print v(xbgr.mr_n72041376)
print v(xbgr.mr_n72041696)
print v(xbgr.mr_n72041808)
print v(xbgr.mr_n72042128)
print v(xbgr.mr_n72042240)
print v(xbgr.mr_n72042560)
print v(xbgr.mr_n72042672)
print v(xbgr.mr_n72043104)
print v(xbgr.mr_n72043424)
print v(xbgr.mr_n72043536)
print v(xbgr.mr_n72043856)
print v(xbgr.mr_n72043968)
print v(xbgr.mr_n72044288)
print v(xbgr.mr_n72044400)
print v(xbgr.mr_n72044720)
print v(xbgr.mr_n72044832)
print v(xbgr.mr_n72045152)
print v(xbgr.mr_n72045264)
print v(xbgr.mr_n72045584)
print v(xbgr.mr_n72045696)
print v(xbgr.mr_n72046016)
print v(xbgr.mr_n72046128)
print v(xbgr.mr_n72046448)
print v(xbgr.mr_n72046560)
print v(xbgr.mr_n72046880)
print v(xbgr.mr_n72046992)
print v(xbgr.mr_n72047312)
print v(xbgr.mr_n72047424)
print v(xbgr.mr_n72047744)
print v(xbgr.mr_n72047856)
print v(xbgr.mr_n72048176)
print v(xbgr.mr_n72048288)
print v(xbgr.mr_n72048608)
print v(xbgr.mr_n72048720)
print v(xbgr.mr_n72049040)
print v(xbgr.mr_n72049152)
print v(xbgr.mr_n72049472)
print v(xbgr.mr_n72049584)
print v(xbgr.mr_n72049904)
print v(xbgr.mr_n72050016)
print v(xbgr.mr_n72050336)
print v(xbgr.mr_n72050448)
print v(xbgr.mr_n72050768)
print v(xbgr.mr_n72050880)
print v(xbgr.mr_n72051200)
print v(xbgr.mr_n72051312)
print v(xbgr.mr_n72051632)
print v(xbgr.mr_n72051744)
print v(xbgr.mr_n72052064)
print v(xbgr.mr_n72052176)
print v(xbgr.mr_n72052496)
print v(xbgr.mr_n72052608)
print v(xbgr.mr_n72052928)
print v(xbgr.mr_n72053040)
print v(xbgr.mr_n72053360)
print v(xbgr.mr_n72053472)
print v(xbgr.mr_n72053792)
print v(xbgr.mr_n72053904)
print v(xbgr.mr_n72054224)
print v(xbgr.mr_n72054336)
print v(xbgr.mr_n72054656)
print v(xbgr.mr_n72054768)
print v(xbgr.mr_n72055088)
print v(xbgr.mr_n72055200)
print v(xbgr.mr_n72055520)
print v(xbgr.mr_n72055632)
print v(xbgr.mr_n72055952)
print v(xbgr.mr_n72056064)
print v(xbgr.mr_n72056384)
print v(xbgr.mr_n72056496)
print v(xbgr.mr_n72056816)
print v(xbgr.mr_n72056928)
print v(xbgr.mr_n72057248)
print v(xbgr.mr_n72057360)
print v(xbgr.mr_n72057680)
print v(xbgr.mr_n72057792)
print v(xbgr.mr_n72058112)
print v(xbgr.mr_n72058224)
print v(xbgr.mr_n72058544)
print v(xbgr.mr_n72058656)
print v(xbgr.mr_n72058976)
print v(xbgr.mr_n72059088)
print v(xbgr.mr_n72059408)
print v(xbgr.mr_n72059520)
print v(xbgr.mr_n72059840)
print v(xbgr.mr_n72059952)
print v(xbgr.mr_n72060272)
print v(xbgr.mr_n72060384)
print v(xbgr.mr_n72060704)
print v(xbgr.mr_n72060816)
print v(xbgr.mr_n72061136)
print v(xbgr.mr_n72061248)
print v(xbgr.mr_n72061568)
print v(xbgr.mr_n72061680)
print v(xbgr.mr_n72062000)
print v(xbgr.mr_n72062112)
print v(xbgr.mr_n72062432)
print v(xbgr.mr_n72062544)
print v(xbgr.mr_n72062864)
print v(xbgr.mr_n72062976)
print v(xbgr.mr_n72063296)
print v(xbgr.mr_n72063408)
print v(xbgr.mr_n72063728)
print v(xbgr.mr_n72063840)
print v(xbgr.mr_n72064160)
print v(xbgr.mr_n72064272)
print v(xbgr.mr_n72064592)
print v(xbgr.mr_n72064704)
print v(xbgr.mr_n72065024)
print v(xbgr.mr_n72065136)
print v(xbgr.mr_n72065456)
print v(xbgr.mr_n72065568)
print v(xbgr.mr_n72065888)
print v(xbgr.mr_n72066000)
print v(xbgr.mr_n72066320)
print v(xbgr.mr_n72066432)
print v(xbgr.mr_n72066752)
print v(xbgr.mr_n72066864)
print v(xbgr.mr_n72067184)
print v(xbgr.mr_n72067296)
print v(xbgr.mr_n72067616)
print v(xbgr.mr_n72067728)
print v(xbgr.mr_n72068048)
print v(xbgr.mr_n72068160)
print v(xbgr.mr_n72068480)
print v(xbgr.mr_n72068592)
print v(xbgr.mr_n72068912)
print v(xbgr.mr_n72069024)
print v(xbgr.mr_n72069344)
print v(xbgr.mr_n72069456)
print v(xbgr.mr_n72069776)
print v(xbgr.mr_n72069888)
print v(xbgr.mr_n72070208)
print v(xbgr.mr_n72070320)
print v(xbgr.mr_n72070640)
print v(xbgr.mr_n72070752)
print v(xbgr.mr_n72071072)
print v(xbgr.mr_n72071184)
print v(xbgr.mr_n72071504)
print v(xbgr.mr_n72071616)
print v(xbgr.mr_n72071936)
print v(xbgr.mr_n72072048)
print v(xbgr.mr_n72072368)
print v(xbgr.mr_n72072480)
print v(xbgr.mr_n72072800)
print v(xbgr.mr_n72072912)
print v(xbgr.mr_n72073344)
print v(xbgr.mr_n72073664)
print v(xbgr.mr_n72073776)
print v(xbgr.mr_n72074096)
print v(xbgr.mr_n72074208)
print v(xbgr.mr_n72074528)
print v(xbgr.mr_n72074640)
print v(xbgr.mr_n72075072)
print v(xbgr.mr_n72075392)
print v(xbgr.mr_n72075504)
print v(xbgr.mr_n72075936)
print v(xbgr.mr_n72076256)
print v(xbgr.mr_n72076368)
print v(xbgr.mr_n72076688)
print v(xbgr.mr_n72076800)
print v(xbgr.mr_n72077120)
print v(xbgr.mr_n72077232)
print v(xbgr.mr_n72077552)
print v(xbgr.mr_n72077664)
print v(xbgr.mr_n72077984)
print v(xbgr.mr_n72078096)
print v(xbgr.mr_n72078416)
print v(xbgr.mr_n72078528)
print v(xbgr.mr_n72078848)
print v(xbgr.mr_n72078960)
print v(xbgr.mr_n72079280)
print v(xbgr.mr_n72079392)
print v(xbgr.mr_n72079712)
print v(xbgr.mr_n72079824)
print v(xbgr.mr_n72080144)
print v(xbgr.mr_n72080256)
print v(xbgr.mr_n72080576)
print v(xbgr.mr_n72080688)
print v(xbgr.mr_n72081008)
print v(xbgr.mr_n72081120)
print v(xbgr.mr_n72081440)
print v(xbgr.mr_n72081552)
print v(xbgr.mr_n72081872)
print v(xbgr.mr_n72081984)
print v(xbgr.mr_n72082304)
print v(xbgr.mr_n72082416)
print v(xbgr.mr_n72082736)
print v(xbgr.mr_n72082848)
print v(xbgr.mr_n72083168)
print v(xbgr.mr_n72083280)
print v(xbgr.mr_n72083600)
print v(xbgr.mr_n72083712)
print v(xbgr.mr_n72084032)
print v(xbgr.mr_n72084144)
print v(xbgr.mr_n72084464)
print v(xbgr.mr_n72084576)
print v(xbgr.mr_n72084896)
print v(xbgr.mr_n72085008)
print v(xbgr.mr_n72085328)
print v(xbgr.mr_n72085440)
print v(xbgr.mr_n72085760)
print v(xbgr.mr_n72085872)
print v(xbgr.mr_n72086192)
print v(xbgr.mr_n72086304)
print v(xbgr.mr_n72086624)
print v(xbgr.mr_n72086736)
print v(xbgr.mr_n72087056)
print v(xbgr.mr_n72087168)
print v(xbgr.mr_n72087488)
print v(xbgr.mr_n72087600)
print v(xbgr.mr_n72087920)
print v(xbgr.mr_n72088032)
print v(xbgr.mr_n72088352)
print v(xbgr.mr_n72088464)
print v(xbgr.mr_n72088784)
print v(xbgr.mr_n72088896)
print v(xbgr.mr_n72089216)
print v(xbgr.mr_n72089328)
print v(xbgr.mr_n72089648)
print v(xbgr.mr_n72089760)
print v(xbgr.mr_n72090080)
print v(xbgr.mr_n72090192)
print v(xbgr.mr_n72090512)
print v(xbgr.mr_n72090624)
print v(xbgr.mr_n72090944)
print v(xbgr.mr_n72091056)
print v(xbgr.mr_n72091376)
print v(xbgr.mr_n72091488)
print v(xbgr.mr_n72091808)
print v(xbgr.mr_n72091920)
print v(xbgr.mr_n72092240)
print v(xbgr.mr_n72092352)
print v(xbgr.mr_n72092672)
print v(xbgr.mr_n72092784)
print v(xbgr.mr_n72093104)
print v(xbgr.mr_n72093216)
print v(xbgr.mr_n72093536)
print v(xbgr.mr_n72093648)
print v(xbgr.mr_n72093968)
print v(xbgr.mr_n72094080)
print v(xbgr.mr_n72094400)
print v(xbgr.mr_n72094512)
print v(xbgr.mr_n72094832)
print v(xbgr.mr_n72094944)
print v(xbgr.mr_n72095264)
print v(xbgr.mr_n72095376)
print v(xbgr.mr_n72095696)
print v(xbgr.mr_n72095808)
print v(xbgr.mr_n72096128)
print v(xbgr.mr_n72096240)
print v(xbgr.mr_n72096560)
print v(xbgr.mr_n72096672)
print v(xbgr.mr_n72096992)
print v(xbgr.mr_n72097104)
print v(xbgr.mr_n72097424)
print v(xbgr.mr_n72097536)
print v(xbgr.mr_n72097856)
print v(xbgr.mr_n72097968)
print v(xbgr.mr_n72098288)
print v(xbgr.mr_n72098400)
print v(xbgr.mr_n72098720)
print v(xbgr.mr_n72098832)
print v(xbgr.mr_n72099152)
print v(xbgr.mr_n72099264)
print v(xbgr.mr_n72099584)
print v(xbgr.mr_n72099696)
print v(xbgr.mr_n72100016)
print v(xbgr.mr_n72100128)
print v(xbgr.mr_n72100448)
print v(xbgr.mr_n72100560)
print v(xbgr.mr_n72100880)
print v(xbgr.mr_n72100992)
print v(xbgr.mr_n72101312)
print v(xbgr.mr_n72101424)
print v(xbgr.mr_n72101744)
print v(xbgr.mr_n72101856)
print v(xbgr.mr_n72102176)
print v(xbgr.mr_n72102288)
print v(xbgr.mr_n72102608)
print v(xbgr.mr_n72102720)
print v(xbgr.mr_n72103040)
print v(xbgr.mr_n72103152)
print v(xbgr.mr_n72103472)
print v(xbgr.mr_n72103584)
print v(xbgr.mr_n72103904)
print v(xbgr.mr_n72104016)
print v(xbgr.mr_n72104336)
print v(xbgr.mr_n72104448)
print v(xbgr.mr_n72104768)
print v(xbgr.mr_n72104880)
print v(xbgr.mr_n72105200)
print v(xbgr.mr_n72105312)
print v(xbgr.mr_n72105632)
print v(xbgr.mr_n72105744)
print v(xbgr.mr_n72106064)
print v(xbgr.mr_n72106176)
print v(xbgr.mr_n72106496)
print v(xbgr.mr_n72106608)
print v(xbgr.mr_n72106928)
print v(xbgr.mr_n72107040)
print v(xbgr.mr_n72107360)
print v(xbgr.mr_n72107472)
print v(xbgr.mr_n72107792)
print v(xbgr.mr_n72107904)
print v(xbgr.mr_n72108224)
print v(xbgr.mr_n72108336)
print v(xbgr.mr_n72108656)
print v(xbgr.mr_n72108768)
print v(xbgr.mr_n72109088)
print v(xbgr.mr_n72109200)
print v(xbgr.mr_n72109520)
print v(xbgr.mr_n72109632)
print v(xbgr.mr_n72109952)
print v(xbgr.mr_n72110064)
print v(xbgr.mr_n72110384)
print v(xbgr.mr_n72110496)
print v(xbgr.mr_n72110816)
print v(xbgr.mr_n72110928)
print v(xbgr.mr_n72111248)
print v(xbgr.mr_n72111360)
print v(xbgr.mr_n72111680)
print v(xbgr.mr_n72111792)
print v(xbgr.mr_n72112112)
print v(xbgr.mr_n72112224)
print v(xbgr.mr_n72112544)
print v(xbgr.mr_n72112656)
print v(xbgr.mr_n72112976)
print v(xbgr.mr_n72113088)
print v(xbgr.mr_n72113408)
print v(xbgr.mr_n72113520)
print v(xbgr.mr_n72113840)
print v(xbgr.mr_n72113952)
print v(xbgr.mr_n72114272)
print v(xbgr.mr_n72114384)
print v(xbgr.mr_n72114704)
print v(xbgr.mr_n72114816)
print v(xbgr.mr_n72115136)
print v(xbgr.mr_n72115248)
print v(xbgr.mr_n72115568)
print v(xbgr.mr_n72115680)
print v(xbgr.mr_n72116000)
print v(xbgr.mr_n72116112)
print v(xbgr.mr_n72116432)
print v(xbgr.mr_n72116544)
print v(xbgr.mr_n72116864)
print v(xbgr.mr_n72116976)
print v(xbgr.mr_n72117296)
print v(xbgr.mr_n72117408)
print v(xbgr.mr_n72117728)
print v(xbgr.mr_n72117840)
print v(xbgr.mr_n72118160)
print v(xbgr.mr_n72118272)
print v(xbgr.mr_n72118592)
print v(xbgr.mr_n72118704)
print v(xbgr.mr_n72119024)
print v(xbgr.mr_n72119136)
print v(xbgr.mr_n72119456)
print v(xbgr.mr_n72119568)
print v(xbgr.mr_n72119888)
print v(xbgr.mr_n72120000)
print v(xbgr.mr_n72120320)
print v(xbgr.mr_n72120432)
print v(xbgr.mr_n72120752)
print v(xbgr.mr_n72120864)
print v(xbgr.mr_n72121184)
print v(xbgr.mr_n72121296)
print v(xbgr.mr_n72121616)
print v(xbgr.mr_n72121728)
print v(xbgr.mr_n72122048)
print v(xbgr.mr_n72122160)
print v(xbgr.mr_n72122480)
print v(xbgr.mr_n72122592)
print v(xbgr.mr_n72122912)
print v(xbgr.mr_n72123024)
print v(xbgr.mr_n72123344)
print v(xbgr.mr_n72123456)
print v(xbgr.mr_n72123776)
print v(xbgr.mr_n72123888)
print v(xbgr.mr_n72124208)
print v(xbgr.mr_n72124320)
print v(xbgr.mr_n72124640)
print v(xbgr.mr_n72124752)
print v(xbgr.mr_n72125072)
print v(xbgr.mr_n72125184)
print v(xbgr.mr_n72125504)
print v(xbgr.mr_n72125616)
print v(xbgr.mr_n72125936)
print v(xbgr.mr_n72126048)
print v(xbgr.mr_n72126368)
print v(xbgr.mr_n72126480)
print v(xbgr.mr_n72126800)
print v(xbgr.mr_n72126912)
print v(xbgr.mr_n72127232)
print v(xbgr.mr_n72127344)
print v(xbgr.mr_n72127664)
print v(xbgr.mr_n72127776)
print v(xbgr.mr_n72128096)
print v(xbgr.mr_n72128208)
print v(xbgr.mr_n72128528)
print v(xbgr.mr_n72128640)
print v(xbgr.mr_n72128960)
print v(xbgr.mr_n72129072)
print v(xbgr.mr_n72129392)
print v(xbgr.mr_n72129504)
print v(xbgr.mr_n72129824)
print v(xbgr.mr_n72129936)
print v(xbgr.mr_n72130256)
print v(xbgr.mr_n72130368)
print v(xbgr.mr_n72130688)
print v(xbgr.mr_n72130800)
print v(xbgr.mr_n72131120)
print v(xbgr.mr_n72131232)
print v(xbgr.mr_n72131552)
print v(xbgr.mr_n72131664)
print v(xbgr.mr_n72131984)
print v(xbgr.mr_n72132096)
print v(xbgr.mr_n72132416)
print v(xbgr.mr_n72132528)
print v(xbgr.mr_n72132848)
print v(xbgr.mr_n72132960)
print v(xbgr.mr_n72133280)
print v(xbgr.mr_n72133392)
print v(xbgr.mr_n72133712)
print v(xbgr.mr_n72133824)
print v(xbgr.mr_n72134144)
print v(xbgr.mr_n72134256)
print v(xbgr.mr_n72134576)
print v(xbgr.mr_n72134688)
print v(xbgr.mr_n72135008)
print v(xbgr.mr_n72135120)
print v(xbgr.mr_n72135440)
print v(xbgr.mr_n72135552)
print v(xbgr.mr_n72135872)
print v(xbgr.mr_n72135984)
print v(xbgr.mr_n72136304)
print v(xbgr.mr_n72136416)
print v(xbgr.mr_n72136736)
print v(xbgr.mr_n72136848)
print v(xbgr.mr_n72137168)
print v(xbgr.mr_n72137280)
print v(xbgr.mr_n72137600)
print v(xbgr.mr_n72137712)
print v(xbgr.mr_n72138032)
print v(xbgr.mr_n72138144)
print v(xbgr.mr_n72138464)
print v(xbgr.mr_n72138576)
print v(xbgr.mr_n72138896)
print v(xbgr.mr_n72139008)
print v(xbgr.mr_n72139328)
print v(xbgr.mr_n72139440)
print v(xbgr.mr_n72139760)
print v(xbgr.mr_n72139872)
print v(xbgr.mr_n72140192)
print v(xbgr.mr_n72140304)
print v(xbgr.mr_n72140624)
print v(xbgr.mr_n72140736)
print v(xbgr.mr_n72141056)
print v(xbgr.mr_n72141168)
print v(xbgr.mr_n72141488)
print v(xbgr.mr_n72141600)
print v(xbgr.mr_n72141920)
print v(xbgr.mr_n72142032)
print v(xbgr.mr_n72142352)
print v(xbgr.mr_n72142464)
print v(xbgr.mr_n72142784)
print v(xbgr.mr_n72142896)
print v(xbgr.mr_n72143216)
print v(xbgr.mr_n72143328)
print v(xbgr.mr_n72143648)
print v(xbgr.mr_n72143760)
print v(xbgr.mr_n72144080)
print v(xbgr.mr_n72144192)
print v(xbgr.mr_n72144512)
print v(xbgr.mr_n72144624)
print v(xbgr.mr_n72144944)
print v(xbgr.mr_n72145056)
print v(xbgr.mr_n72145376)
print v(xbgr.mr_n72145488)
print v(xbgr.mr_n72145808)
print v(xbgr.mr_n72145920)
print v(xbgr.mr_n72146240)
print v(xbgr.mr_n72146352)
print v(xbgr.mr_n72146672)
print v(xbgr.mr_n72146784)
print v(xbgr.mr_n72147104)
print v(xbgr.mr_n72147216)
print v(xbgr.mr_n72147536)
print v(xbgr.mr_n72147648)
print v(xbgr.mr_n72147968)
print v(xbgr.mr_n72148080)
print v(xbgr.mr_n72148400)
print v(xbgr.mr_n72148512)
print v(xbgr.mr_n72148832)
print v(xbgr.mr_n72148944)
print v(xbgr.mr_n72149264)
print v(xbgr.mr_n72149376)
print v(xbgr.mr_n72149696)
print v(xbgr.mr_n72149808)
print v(xbgr.mr_n72150128)
print v(xbgr.mr_n72150240)
print v(xbgr.mr_n72150560)
print v(xbgr.mr_n72150672)
print v(xbgr.mr_n72150992)
print v(xbgr.mr_n72151104)
print v(xbgr.mr_n72151424)
print v(xbgr.mr_n72151536)
print v(xbgr.mr_n72151856)
print v(xbgr.mr_n72151968)
print v(xbgr.mr_n72152288)
print v(xbgr.mr_n72152400)
print v(xbgr.mr_n72152720)
print v(xbgr.mr_n72152832)
print v(xbgr.mr_n72153152)
print v(xbgr.mr_n72153264)
print v(xbgr.mr_n72153584)
print v(xbgr.mr_n72153696)
print v(xbgr.mr_n72154016)
print v(xbgr.mr_n72154128)
print v(xbgr.mr_n72154448)
print v(xbgr.mr_n72154560)
print v(xbgr.mr_n72154880)
print v(xbgr.mr_n72154992)
print v(xbgr.mr_n72155312)
print v(xbgr.mr_n72155424)
print v(xbgr.mr_n72155744)
print v(xbgr.mr_n72155856)
print v(xbgr.mr_n72156176)
print v(xbgr.mr_n72156288)
print v(xbgr.mr_n72156608)
print v(xbgr.mr_n72156720)
print v(xbgr.mr_n72157040)
print v(xbgr.mr_n72157152)
print v(xbgr.mr_n72157472)
print v(xbgr.mr_n72157584)
print v(xbgr.mr_n72157904)
print v(xbgr.mr_n72158016)
print v(xbgr.mr_n72158336)
print v(xbgr.mr_n72158448)
print v(xbgr.mr_n72158768)
print v(xbgr.mr_n72158880)
print v(xbgr.mr_n72159200)
print v(xbgr.mr_n72159312)
print v(xbgr.mr_n72159632)
print v(xbgr.mr_n72159744)
print v(xbgr.mr_n72160064)
print v(xbgr.mr_n72160176)
print v(xbgr.mr_n72160496)
print v(xbgr.mr_n72160608)
print v(xbgr.mr_n72160928)
print v(xbgr.mr_n72161040)
print v(xbgr.mr_n72161360)
print v(xbgr.mr_n72161472)
print v(xbgr.mr_n72161792)
print v(xbgr.mr_n72161904)
print v(xbgr.mr_n72162224)
print v(xbgr.mr_n72162336)
print v(xbgr.mr_n72162656)
print v(xbgr.mr_n72162768)
print v(xbgr.mr_n72163088)
print v(xbgr.mr_n72163200)
print v(xbgr.mr_n72163520)
print v(xbgr.mr_n72163632)
print v(xbgr.mr_n72163952)
print v(xbgr.mr_n72164064)
print v(xbgr.mr_n72164384)
print v(xbgr.mr_n72164496)
print v(xbgr.mr_n72164816)
print v(xbgr.mr_n72164928)
print v(xbgr.mr_n72165248)
print v(xbgr.mr_n72165360)
print v(xbgr.mr_n72165680)
print v(xbgr.mr_n72165792)
print v(xbgr.mr_n72166112)
print v(xbgr.mr_n72166224)
print v(xbgr.mr_n72232096)
print v(xbgr.mr_n72232208)
print v(xbgr.mr_n72232528)
print v(xbgr.mr_n72232640)
print v(xbgr.mr_n72232960)
print v(xbgr.mr_n72233072)
print v(xbgr.mr_n72233504)
print v(xbgr.mr_n72233824)
print v(xbgr.mr_n72233936)
print v(xbgr.mr_n72234256)
print v(xbgr.mr_n72234368)
print v(xbgr.mr_n72234800)
print v(xbgr.mr_n72235232)
print v(xbgr.mr_n72235552)
print v(xbgr.mr_n72235664)
print v(xbgr.mr_n72235984)
print v(xbgr.mr_n72236096)
print v(xbgr.mr_n72236416)
print v(xbgr.mr_n72236528)
print v(xbgr.mr_n72236848)
print v(xbgr.mr_n72236960)
print v(xbgr.mr_n72237280)
print v(xbgr.mr_n72237392)
print v(xbgr.mr_n72237712)
print v(xbgr.mr_n72237824)
print v(xbgr.mr_n72238144)
print v(xbgr.mr_n72238256)
print v(xbgr.mr_n72238576)
print v(xbgr.mr_n72238688)
print v(xbgr.mr_n72239008)
print v(xbgr.mr_n72239120)
print v(xbgr.mr_n72239440)
print v(xbgr.mr_n72239552)
print v(xbgr.mr_n72239872)
print v(xbgr.mr_n72239984)
print v(xbgr.mr_n72240304)
print v(xbgr.mr_n72240416)
print v(xbgr.mr_n72240848)
print v(xbgr.mr_n72241168)
print v(xbgr.mr_n72241280)
print v(xbgr.mr_n72241600)
print v(xbgr.mr_n72241712)
print v(xbgr.mr_n72242032)
print v(xbgr.mr_n72242144)
print v(xbgr.mr_n72242464)
print v(xbgr.mr_n72242576)
print v(xbgr.mr_n72242896)
print v(xbgr.mr_n72243008)
print v(xbgr.mr_n72243328)
print v(xbgr.mr_n72243440)
print v(xbgr.mr_n72243760)
print v(xbgr.mr_n72243872)
print v(xbgr.mr_n72244192)
print v(xbgr.mr_n72244304)
print v(xbgr.mr_n72244624)
print v(xbgr.mr_n72244736)
print v(xbgr.mr_n72245056)
print v(xbgr.mr_n72245168)
print v(xbgr.mr_n72245600)
print v(xbgr.mr_n72246032)
print v(xbgr.mr_n72246352)
print v(xbgr.mr_n72246464)
print v(xbgr.mr_n72246784)
print v(xbgr.mr_n72246896)
print v(xbgr.mr_n72247216)
print v(xbgr.mr_n72247328)
print v(xbgr.mr_n72247648)
print v(xbgr.mr_n72247760)
print v(xbgr.mr_n72248080)
print v(xbgr.mr_n72248192)
print v(xbgr.mr_n72248512)
print v(xbgr.mr_n72248624)
print v(xbgr.mr_n72248944)
print v(xbgr.mr_n72249056)
print v(xbgr.mr_n72249376)
print v(xbgr.mr_n72249488)
print v(xbgr.mr_n72249808)
print v(xbgr.mr_n72249920)
print v(xbgr.mr_n72250240)
print v(xbgr.mr_n72250352)
print v(xbgr.mr_n72250672)
print v(xbgr.mr_n72250784)
print v(xbgr.mr_n72251104)
print v(xbgr.mr_n72251216)
print v(xbgr.mr_n72251536)
print v(xbgr.mr_n72251648)
print v(xbgr.mr_n72251968)
print v(xbgr.mr_n72252080)
print v(xbgr.mr_n72252400)
print v(xbgr.mr_n72252512)
print v(xbgr.mr_n72252832)
print v(xbgr.mr_n72252944)
print v(xbgr.mr_n72253264)
print v(xbgr.mr_n72253376)
print v(xbgr.mr_n72253696)
print v(xbgr.mr_n72253808)
print v(xbgr.mr_n72254128)
print v(xbgr.mr_n72254240)
print v(xbgr.mr_n72254560)
print v(xbgr.mr_n72254672)
print v(xbgr.mr_n72254992)
print v(xbgr.mr_n72255104)
print v(xbgr.mr_n72255424)
print v(xbgr.mr_n72255536)
print v(xbgr.mr_n72255856)
print v(xbgr.mr_n72255968)
print v(xbgr.mr_n72256288)
print v(xbgr.mr_n72256400)
print v(xbgr.mr_n72256720)
print v(xbgr.mr_n72256832)
print v(xbgr.mr_n72257152)
print v(xbgr.mr_n72257264)
print v(xbgr.mr_n72257584)
print v(xbgr.mr_n72257696)
print v(xbgr.mr_n72258016)
print v(xbgr.mr_n72258128)
print v(xbgr.mr_n72258448)
print v(xbgr.mr_n72258560)
print v(xbgr.mr_n72258880)
print v(xbgr.mr_n72258992)
print v(xbgr.mr_n72259312)
print v(xbgr.mr_n72259424)
print v(xbgr.mr_n72259744)
print v(xbgr.mr_n72259856)
print v(xbgr.mr_n72260176)
print v(xbgr.mr_n72260288)
print v(xbgr.mr_n72260608)
print v(xbgr.mr_n72260720)
print v(xbgr.mr_n72261040)
print v(xbgr.mr_n72261152)
print v(xbgr.mr_n72261472)
print v(xbgr.mr_n72261584)
print v(xbgr.mr_n72261904)
print v(xbgr.mr_n72262016)
print v(xbgr.mr_n72262336)
print v(xbgr.mr_n72262448)
print v(xbgr.mr_n72262768)
print v(xbgr.mr_n72262880)
print v(xbgr.mr_n72263200)
print v(xbgr.mr_n72263312)
print v(xbgr.mr_n72263632)
print v(xbgr.mr_n72263744)
print v(xbgr.mr_n72264064)
print v(xbgr.mr_n72264176)
print v(xbgr.mr_n72264496)
print v(xbgr.mr_n72264608)
print v(xbgr.mr_n72264928)
print v(xbgr.mr_n72265040)
print v(xbgr.mr_n72265360)
print v(xbgr.mr_n72265472)
print v(xbgr.mr_n72265792)
print v(xbgr.mr_n72265904)
print v(xbgr.mr_n72266224)
print v(xbgr.mr_n72266336)
print v(xbgr.mr_n72266656)
print v(xbgr.mr_n72266768)
print v(xbgr.mr_n72267088)
print v(xbgr.mr_n72267200)
print v(xbgr.mr_n72267520)
print v(xbgr.mr_n72267632)
print v(xbgr.mr_n72267952)
print v(xbgr.mr_n72268064)
print v(xbgr.mr_n72268384)
print v(xbgr.mr_n72268496)
print v(xbgr.mr_n72268816)
print v(xbgr.mr_n72268928)
print v(xbgr.mr_n72269248)
print v(xbgr.mr_n72269360)
print v(xbgr.mr_n72269680)
print v(xbgr.mr_n72269792)
print v(xbgr.mr_n72270112)
print v(xbgr.mr_n72270224)
print v(xbgr.mr_n72270544)
print v(xbgr.mr_n72270656)
print v(xbgr.mr_n72270976)
print v(xbgr.mr_n72271088)
print v(xbgr.mr_n72271408)
print v(xbgr.mr_n72271520)
print v(xbgr.mr_n72271840)
print v(xbgr.mr_n72271952)
print v(xbgr.mr_n72272272)
print v(xbgr.mr_n72272384)
print v(xbgr.mr_n72272704)
print v(xbgr.mr_n72272816)
print v(xbgr.mr_n72273136)
print v(xbgr.mr_n72273248)
print v(xbgr.mr_n72273568)
print v(xbgr.mr_n72273680)
print v(xbgr.mr_n72274000)
print v(xbgr.mr_n72274112)
print v(xbgr.mr_n72274432)
print v(xbgr.mr_n72274544)
print v(xbgr.mr_n72274864)
print v(xbgr.mr_n72274976)
print v(xbgr.mr_n72275296)
print v(xbgr.mr_n72275408)
print v(xbgr.mr_n72275728)
print v(xbgr.mr_n72275840)
print v(xbgr.mr_n72276160)
print v(xbgr.mr_n72276272)
print v(xbgr.mr_n72276592)
print v(xbgr.mr_n72276704)
print v(xbgr.mr_n72277024)
print v(xbgr.mr_n72277136)
print v(xbgr.mr_n72277456)
print v(xbgr.mr_n72277568)
print v(xbgr.mr_n72277888)
print v(xbgr.mr_n72278000)
print v(xbgr.mr_n72278320)
print v(xbgr.mr_n72278432)
print v(xbgr.mr_n72278752)
print v(xbgr.mr_n72278864)
print v(xbgr.mr_n72279184)
print v(xbgr.mr_n72279296)
print v(xbgr.mr_n72279616)
print v(xbgr.mr_n72279728)
print v(xbgr.mr_n72280048)
print v(xbgr.mr_n72280160)
print v(xbgr.mr_n72280480)
print v(xbgr.mr_n72280592)
print v(xbgr.mr_n72280912)
print v(xbgr.mr_n72281024)
print v(xbgr.mr_n72281344)
print v(xbgr.mr_n72281456)
print v(xbgr.mr_n72281776)
print v(xbgr.mr_n72281888)
print v(xbgr.mr_n72282208)
print v(xbgr.mr_n72282320)
print v(xbgr.mr_n72282640)
print v(xbgr.mr_n72282752)
print v(xbgr.mr_n72283072)
print v(xbgr.mr_n72283184)
print v(xbgr.mr_n72283504)
print v(xbgr.mr_n72283616)
print v(xbgr.mr_n72283936)
print v(xbgr.mr_n72284048)
print v(xbgr.mr_n72284368)
print v(xbgr.mr_n72284480)
print v(xbgr.mr_n72284800)
print v(xbgr.mr_n72284912)
print v(xbgr.mr_n72285232)
print v(xbgr.mr_n72285344)
print v(xbgr.mr_n72285664)
print v(xbgr.mr_n72285776)
print v(xbgr.mr_n72286096)
print v(xbgr.mr_n72286208)
print v(xbgr.mr_n72286528)
print v(xbgr.mr_n72286640)
print v(xbgr.mr_n72286960)
print v(xbgr.mr_n72287072)
print v(xbgr.mr_n72287392)
print v(xbgr.mr_n72287504)
print v(xbgr.mr_n72287824)
print v(xbgr.mr_n72287936)
print v(xbgr.mr_n72288256)
print v(xbgr.mr_n72288368)
print v(xbgr.mr_n72288688)
print v(xbgr.mr_n72288800)
print v(xbgr.mr_n72289120)
print v(xbgr.mr_n72289232)
print v(xbgr.mr_n72289552)
print v(xbgr.mr_n72289664)
print v(xbgr.mr_n72289984)
print v(xbgr.mr_n72290096)
print v(xbgr.mr_n72290416)
print v(xbgr.mr_n72290528)
print v(xbgr.mr_n72290848)
print v(xbgr.mr_n72290960)
print v(xbgr.mr_n72291280)
print v(xbgr.mr_n72291392)
print v(xbgr.mr_n72291712)
print v(xbgr.mr_n72291824)
print v(xbgr.mr_n72292144)
print v(xbgr.mr_n72292256)
print v(xbgr.mr_n72292576)
print v(xbgr.mr_n72292688)
print v(xbgr.mr_n72293008)
print v(xbgr.mr_n72293120)
print v(xbgr.mr_n72293440)
print v(xbgr.mr_n72293552)
print v(xbgr.mr_n72293872)
print v(xbgr.mr_n72293984)
print v(xbgr.mr_n72294304)
print v(xbgr.mr_n72294416)
print v(xbgr.mr_n72294736)
print v(xbgr.mr_n72294848)
print v(xbgr.mr_n72295168)
print v(xbgr.mr_n72295280)
print v(xbgr.mr_n72295600)
print v(xbgr.mr_n72295712)
print v(xbgr.mr_n72296032)
print v(xbgr.mr_n72296144)
print v(xbgr.mr_n72296464)
print v(xbgr.mr_n72296576)
print v(xbgr.mr_n72296896)
print v(xbgr.mr_n72297008)
print v(xbgr.mr_n72297328)
print v(xbgr.mr_n72297440)
print v(xbgr.mr_n72297760)
print v(xbgr.mr_n72297872)
print v(xbgr.mr_n72298192)
print v(xbgr.mr_n72298304)
print v(xbgr.mr_n72298624)
print v(xbgr.mr_n72298736)
print v(xbgr.mr_n72299056)
print v(xbgr.mr_n72299168)
print v(xbgr.mr_n72299488)
print v(xbgr.mr_n72299600)
print v(xbgr.mr_n72299920)
print v(xbgr.mr_n72300032)
print v(xbgr.mr_n72300352)
print v(xbgr.mr_n72300464)
print v(xbgr.mr_n72300784)
print v(xbgr.mr_n72300896)
print v(xbgr.mr_n72301216)
print v(xbgr.mr_n72301328)
print v(xbgr.mr_n72301648)
print v(xbgr.mr_n72301760)
print v(xbgr.mr_n72302080)
print v(xbgr.mr_n72302192)
print v(xbgr.mr_n72302512)
print v(xbgr.mr_n72302624)
print v(xbgr.mr_n72302944)
print v(xbgr.mr_n72303056)
print v(xbgr.mr_n72303376)
print v(xbgr.mr_n72303488)
print v(xbgr.mr_n72303808)
print v(xbgr.mr_n72303920)
print v(xbgr.mr_n72304240)
print v(xbgr.mr_n72304352)
print v(xbgr.mr_n72304672)
print v(xbgr.mr_n72304784)
print v(xbgr.mr_n72305104)
print v(xbgr.mr_n72305216)
print v(xbgr.mr_n72305536)
print v(xbgr.mr_n72305648)
print v(xbgr.mr_n72305968)
print v(xbgr.mr_n72306080)
print v(xbgr.mr_n72306400)
print v(xbgr.mr_n72306512)
print v(xbgr.mr_n72306832)
print v(xbgr.mr_n72306944)
print v(xbgr.mr_n72307264)
print v(xbgr.mr_n72307376)
print v(xbgr.mr_n72307696)
print v(xbgr.mr_n72307808)
print v(xbgr.mr_n72308128)
print v(xbgr.mr_n72308240)
print v(xbgr.mr_n72308560)
print v(xbgr.mr_n72308672)
print v(xbgr.mr_n72308992)
print v(xbgr.mr_n72309104)
print v(xbgr.mr_n72309424)
print v(xbgr.mr_n72309536)
print v(xbgr.mr_n72309856)
print v(xbgr.mr_n72309968)
print v(xbgr.mr_n72310288)
print v(xbgr.mr_n72310400)
print v(xbgr.mr_n72310720)
print v(xbgr.mr_n72310832)
print v(xbgr.mr_n72311152)
print v(xbgr.mr_n72311264)
print v(xbgr.mr_n72311584)
print v(xbgr.mr_n72311696)
print v(xbgr.mr_n72312016)
print v(xbgr.mr_n72312128)
print v(xbgr.mr_n72312448)
print v(xbgr.mr_n72312560)
print v(xbgr.mr_n72312880)
print v(xbgr.mr_n72312992)
print v(xbgr.mr_n72313312)
print v(xbgr.mr_n72313424)
print v(xbgr.mr_n72313744)
print v(xbgr.mr_n72313856)
print v(xbgr.mr_n72314288)
print v(xbgr.mr_n72314608)
print v(xbgr.mr_n72314720)
print v(xbgr.mr_n72315040)
print v(xbgr.mr_n72315152)
print v(xbgr.mr_n72315472)
print v(xbgr.mr_n72315584)
print v(xbgr.mr_n72315904)
print v(xbgr.mr_n72316016)
print v(xbgr.mr_n72316336)
print v(xbgr.mr_n72317200)
print v(xbgr.mr_n72317312)
print v(xbgr.mr_n72317632)
print v(xbgr.mr_n72317744)
print v(xbgr.mr_n72318064)
print v(xbgr.mr_n72318176)
print v(xbgr.mr_n72318496)
print v(xbgr.mr_n72318608)
print v(xbgr.mr_n72318928)
print v(xbgr.mr_n72319040)
print v(xbgr.mr_n72319472)
print v(xbgr.mr_n72319792)
print v(xbgr.mr_n72319904)
print v(xbgr.mr_n72320224)
print v(xbgr.mr_n72320336)
print v(xbgr.mr_n72320656)
print v(xbgr.mr_n72320768)
print v(xbgr.mr_n72321088)
print v(xbgr.mr_n72321200)
print v(xbgr.mr_n72321520)
print v(xbgr.mr_n72321632)
print v(xbgr.mr_n72322064)
print v(xbgr.mr_n72322384)
print v(xbgr.mr_n72323248)
print v(xbgr.mr_n72323360)
print v(xbgr.mr_n72323792)
print v(xbgr.mr_n72324112)
print v(xbgr.mr_n72324976)
print v(xbgr.mr_n72325088)
print v(xbgr.mr_n72325520)
print v(xbgr.mr_n72325840)
print v(xbgr.mr_n72325952)
print v(xbgr.mr_n72326272)
print v(xbgr.mr_n72326384)
print v(xbgr.mr_n72326704)
print v(xbgr.mr_n72326816)
print v(xbgr.mr_n72327136)
print v(xbgr.mr_n72327248)
print v(xbgr.mr_n72327568)
print v(xbgr.mr_n72327680)
print v(xbgr.mr_n72328000)
print v(xbgr.mr_n72328112)
print v(xbgr.mr_n72328432)
print v(xbgr.mr_n72329296)
print v(xbgr.mr_n72329408)
print v(xbgr.mr_n72329728)
print v(xbgr.mr_n72329840)
print v(xbgr.mr_n72330160)
print v(xbgr.mr_n72331024)
print v(xbgr.mr_n72331136)
print v(xbgr.mr_n72331456)
print v(xbgr.mr_n72331568)
print v(xbgr.mr_n72331888)
print v(xbgr.mr_n72332000)
print v(xbgr.mr_n72332320)
print v(xbgr.mr_n72332432)
print v(xbgr.mr_n72332752)
print v(xbgr.mr_n72332864)
print v(xbgr.mr_n72333184)
print v(xbgr.mr_n72333296)
print v(xbgr.mr_n72333616)
print v(xbgr.mr_n72333728)
print v(xbgr.mr_n72334048)
print v(xbgr.mr_n72334160)
print v(xbgr.mr_n72334480)
print v(xbgr.mr_n72334592)
print v(xbgr.mr_n72334912)
print v(xbgr.mr_n72335024)
print v(xbgr.mr_n72335344)
print v(xbgr.mr_n72335456)
print v(xbgr.mr_n72335776)
print v(xbgr.mr_n72335888)
print v(xbgr.mr_n72336208)
print v(xbgr.mr_n72336320)
print v(xbgr.mr_n72336640)
print v(xbgr.mr_n72336752)
print v(xbgr.mr_n72337072)
print v(xbgr.mr_n72337184)
print v(xbgr.mr_n72337504)
print v(xbgr.mr_n72337616)
print v(xbgr.mr_n72337936)
print v(xbgr.mr_n72338048)
print v(xbgr.mr_n72338368)
print v(xbgr.mr_n72338480)
print v(xbgr.mr_n72338800)
print v(xbgr.mr_n72338912)
print v(xbgr.mr_n72339232)
print v(xbgr.mr_n72339344)
print v(xbgr.mr_n72339664)
print v(xbgr.mr_n72339776)
print v(xbgr.mr_n72340096)
print v(xbgr.mr_n72340208)
print v(xbgr.mr_n72340528)
print v(xbgr.mr_n72340640)
print v(xbgr.mr_n72340960)
print v(xbgr.mr_n72341072)
print v(xbgr.mr_n72341392)
print v(xbgr.mr_n72341504)
print v(xbgr.mr_n72341824)
print v(xbgr.mr_n72341936)
print v(xbgr.mr_n72342368)
print v(xbgr.mr_n72342800)
print v(xbgr.mr_n72343232)
print v(xbgr.mr_n72343664)
print v(xbgr.mr_n72344096)
print v(xbgr.mr_n72344528)
print v(xbgr.mr_n72344960)
print v(xbgr.mr_n72345392)
print v(xbgr.mr_n72345824)
print v(xbgr.mr_n72346256)
print v(xbgr.mr_n72346688)
print v(xbgr.mr_n72347120)
print v(xbgr.mr_n72347552)
print v(xbgr.mr_n72347984)
print v(xbgr.mr_n72348416)
print v(xbgr.mr_n72348848)
print v(xbgr.mr_n72349280)
print v(xbgr.mr_n72349712)
print v(xbgr.mr_n72350144)
print v(xbgr.mr_n72350576)
print v(xbgr.mr_n72351008)
print v(xbgr.mr_n72351440)
print v(xbgr.mr_n72351760)
print v(xbgr.mr_n72351872)
print v(xbgr.mr_n72352304)
print v(xbgr.mr_n72352736)
print v(xbgr.mr_n72353168)
print v(xbgr.mr_n72353600)
print v(xbgr.mr_n72354032)
print v(xbgr.mr_n72354464)
print v(xbgr.mr_n72354896)
print v(xbgr.mr_n72355328)
print v(xbgr.mr_n72355760)
print v(xbgr.mr_n72356192)
print v(xbgr.mr_n72356624)
print v(xbgr.mr_n72357056)
print v(xbgr.mr_n72357488)
print v(xbgr.mr_n72357920)
print v(xbgr.mr_n72358352)
print v(xbgr.mr_n72358784)
print v(xbgr.mr_n72359216)
print v(xbgr.mr_n72359648)
print v(xbgr.mr_n72360080)
print v(xbgr.mr_n72360512)
print v(xbgr.mr_n72360944)
print v(xbgr.mr_n72361376)
print v(xbgr.mr_n72361808)
print v(xbgr.mr_n72362240)
print v(xbgr.mr_n72362672)
print v(xbgr.mr_n72363104)
print v(xbgr.mr_n72363536)
print v(xbgr.mr_n72363968)
print v(xbgr.mr_n72364400)
print v(xbgr.mr_n72364832)
print v(xbgr.mr_n72365264)
print v(xbgr.mr_n72365696)
print v(xbgr.mr_n72366128)
print v(xbgr.mr_n72366560)
print v(xbgr.mr_n72366992)
print v(xbgr.mr_n72367424)
print v(xbgr.mr_n72367856)
print v(xbgr.mr_n72368288)
print v(xbgr.mr_n72368720)
print v(xbgr.mr_n72369152)
print v(xbgr.mr_n72369584)
print v(xbgr.mr_n72370016)
print v(xbgr.mr_n72370448)
print v(xbgr.mr_n72370880)
print v(xbgr.mr_n72371312)
print v(xbgr.mr_n72371744)
print v(xbgr.mr_n72372176)
print v(xbgr.mr_n72372608)
print v(xbgr.mr_n72373040)
print v(xbgr.mr_n72373472)
print v(xbgr.mr_n72373904)
print v(xbgr.mr_n72374336)
print v(xbgr.mr_n72374768)
print v(xbgr.mr_n72375200)
print v(xbgr.mr_n72375632)
print v(xbgr.mr_n72376064)
print v(xbgr.mr_n72376496)
print v(xbgr.mr_n72376928)
print v(xbgr.mr_n72377360)
print v(xbgr.mr_n72377792)
print v(xbgr.mr_n72378224)
print v(xbgr.mr_n72378656)
print v(xbgr.mr_n72379088)
print v(xbgr.mr_n72379408)
print v(xbgr.mr_n72379520)
print v(xbgr.mr_n72379840)
print v(xbgr.mr_n72379952)
print v(xbgr.mr_n72380272)
print v(xbgr.mr_n72380384)
print v(xbgr.mr_n72380704)
print v(xbgr.mr_n72380816)
print v(xbgr.mr_n72381136)
print v(xbgr.mr_n72381248)
print v(xbgr.mr_n72381568)
print v(xbgr.mr_n72381680)
print v(xbgr.mr_n72382000)
print v(xbgr.mr_n72382112)
print v(xbgr.mr_n72382432)
print v(xbgr.mr_n72382544)
print v(xbgr.mr_n72382864)
print v(xbgr.mr_n72382976)
print v(xbgr.mr_n72383296)
print v(xbgr.mr_n72383408)
print v(xbgr.mr_n72383728)
print v(xbgr.mr_n72383840)
print v(xbgr.mr_n72384160)
print v(xbgr.mr_n72384272)
print v(xbgr.mr_n72384592)
print v(xbgr.mr_n72385024)
print v(xbgr.mr_n72385136)
print v(xbgr.mr_n72385456)
print v(xbgr.mr_n72385568)
print v(xbgr.mr_n72385888)
print v(xbgr.mr_n72386000)
print v(xbgr.mr_n72386320)
print v(xbgr.mr_n72386432)
print v(xbgr.mr_n72386752)
print v(xbgr.mr_n72386864)
print v(xbgr.mr_n72387184)
print v(xbgr.mr_n72387296)
print v(xbgr.mr_n72387616)
print v(xbgr.mr_n72387728)
print v(xbgr.mr_n72388048)
print v(xbgr.mr_n72388160)
print v(xbgr.mr_n72388480)
print v(xbgr.mr_n72388592)
print v(xbgr.mr_n72388912)
print v(xbgr.mr_n72389024)
print v(xbgr.mr_n72389344)
print v(xbgr.mr_n72389456)
print v(xbgr.mr_n72389888)
print v(xbgr.mr_n72390320)
print v(xbgr.mr_n72390752)
print v(xbgr.mr_n72391184)
print v(xbgr.mr_n72391616)
print v(xbgr.mr_n72392048)
print v(xbgr.mr_n72392480)
print v(xbgr.mr_n72392912)
print v(xbgr.mr_n72393344)
print v(xbgr.mr_n72393776)
print v(xbgr.mr_n72394208)
print v(xbgr.mr_n72394640)
print v(xbgr.mr_n72395072)
print v(xbgr.mr_n72395504)
print v(xbgr.mr_n72395936)
print v(xbgr.mr_n72396368)
print v(xbgr.mr_n72396800)
print v(xbgr.mr_n72397232)
print v(xbgr.mr_n72397664)
print v(xbgr.mr_n72398096)
print v(xbgr.mr_n72398528)
print v(xbgr.mr_n72398960)
print v(xbgr.mr_n72399392)
print v(xbgr.mr_n72399824)
print v(xbgr.mr_n72400256)
print v(xbgr.mr_n72400688)
print v(xbgr.mr_n72401120)
print v(xbgr.mr_n72401552)
print v(xbgr.mr_n72401984)
print v(xbgr.mr_n72402416)
print v(xbgr.mr_n72402848)
print v(xbgr.mr_n72403280)
print v(xbgr.mr_n72403712)
print v(xbgr.mr_n72404144)
print v(xbgr.mr_n72404576)
print v(xbgr.mr_n72405008)
print v(xbgr.mr_n72405440)
print v(xbgr.mr_n72405872)
print v(xbgr.mr_n72406304)
print v(xbgr.mr_n72406736)
print v(xbgr.mr_n72407168)
print v(xbgr.mr_n72407600)
print v(xbgr.mr_n72408032)
print v(xbgr.mr_n72408464)
print v(xbgr.mr_n72408896)
print v(xbgr.mr_n72409328)
print v(xbgr.mr_n72409760)
print v(xbgr.mr_n72410192)
print v(xbgr.mr_n72410624)
print v(xbgr.mr_n72411056)
print v(xbgr.mr_n72411488)
print v(xbgr.mr_n72411920)
print v(xbgr.mr_n72412352)
print v(xbgr.mr_n72412784)
print v(xbgr.mr_n72413216)
print v(xbgr.mr_n72413648)
print v(xbgr.mr_n72414080)
print v(xbgr.mr_n72414512)
print v(xbgr.mr_n72414944)
print v(xbgr.mr_n72415376)
print v(xbgr.mr_n72415808)
print v(xbgr.mr_n72416240)
print v(xbgr.mr_n72416672)
print v(xbgr.mr_n72417104)
print v(xbgr.mr_n72417536)
print v(xbgr.mr_n72417968)
print v(xbgr.mr_n72418400)
print v(xbgr.mr_n72418832)
print v(xbgr.mr_n72419264)
print v(xbgr.mr_n72419696)
print v(xbgr.mr_n72420128)
print v(xbgr.mr_n72420560)
print v(xbgr.mr_n72420992)
print v(xbgr.mr_n72421424)
print v(xbgr.mr_n72421856)
print v(xbgr.mr_n72422288)
print v(xbgr.mr_n72422720)
print v(xbgr.mr_n72423152)
print v(xbgr.mr_n72423584)
print v(xbgr.mr_n72424016)
print v(xbgr.mr_n72424448)
print v(xbgr.mr_n72424880)
print v(xbgr.mr_n72425312)
print v(xbgr.mr_n72425744)
print v(xbgr.mr_n72426176)
print v(xbgr.mr_n72426608)
print v(xbgr.mr_n72426928)
print v(xbgr.mr_n72427040)
print v(xbgr.mr_n72427360)
print v(xbgr.mr_n72427472)
print v(xbgr.mr_n72427792)
print v(xbgr.mr_n72427904)
print v(xbgr.mr_n72428224)
print v(xbgr.mr_n72428336)
print v(xbgr.mr_n72428656)
print v(xbgr.mr_n72428768)
print v(xbgr.mr_n72429088)
print v(xbgr.mr_n72429200)
print v(xbgr.mr_n72429520)
print v(xbgr.mr_n72429632)
print v(xbgr.mr_n72429952)
print v(xbgr.mr_n72430064)
print v(xbgr.mr_n72430384)
print v(xbgr.mr_n72430496)
print v(xbgr.mr_n72430816)
print v(xbgr.mr_n72430928)
print v(xbgr.mr_n72431248)
print v(xbgr.mr_n72431360)
print v(xbgr.mr_n72431680)
print v(xbgr.mr_n72431792)
print v(xbgr.mr_n72432112)
print v(xbgr.mr_n72432224)
print v(xbgr.mr_n72432544)
print v(xbgr.mr_n72432656)
print v(xbgr.mr_n72432976)
print v(xbgr.mr_n72433088)
print v(xbgr.mr_n72433408)
print v(xbgr.mr_n72433520)
print v(xbgr.mr_n72433840)
print v(xbgr.mr_n72433952)
print v(xbgr.mr_n72434272)
print v(xbgr.mr_n72434384)
print v(xbgr.mr_n72434704)
print v(xbgr.mr_n72435248)
print v(xbgr.mr_n72435568)
print v(xbgr.mr_n72436000)
print v(xbgr.mr_n72436112)
print v(xbgr.mr_n72436432)
print v(xbgr.mr_n72436544)
print v(xbgr.mr_n72436976)
print v(xbgr.mr_n72437296)
print v(xbgr.mr_n72438160)
print v(xbgr.mr_n72438272)
print v(xbgr.mr_n72438704)
print v(xbgr.mr_n72439024)
print v(xbgr.mr_n72439888)
print v(xbgr.mr_n72440000)
print v(xbgr.mr_n72440432)
print v(xbgr.mr_n72440752)
print v(xbgr.mr_n72440864)
print v(xbgr.mr_n72441296)
print v(xbgr.mr_n72441728)
print v(xbgr.mr_n72442048)
print v(xbgr.mr_n72442912)
print v(xbgr.mr_n72443888)
print v(xbgr.mr_n72444208)
print v(xbgr.mr_n72444320)
print v(xbgr.mr_n72444752)
print v(xbgr.mr_n72445072)
print v(xbgr.mr_n72445184)
print v(xbgr.mr_n72445616)
print v(xbgr.mr_n72445936)
print v(xbgr.mr_n72446048)
print v(xbgr.mr_n72446368)
print v(xbgr.mr_n72446480)
print v(xbgr.mr_n72446800)
print v(xbgr.mr_n72446912)
print v(xbgr.mr_n72447232)
print v(xbgr.mr_n72447344)
print v(xbgr.mr_n72447664)
print v(xbgr.mr_n72447776)
print v(xbgr.mr_n72448096)
print v(xbgr.mr_n72448208)
print v(xbgr.mr_n72448528)
print v(xbgr.mr_n72448640)
print v(xbgr.mr_n72448960)
print v(xbgr.mr_n72449072)
print v(xbgr.mr_n72449392)
print v(xbgr.mr_n72449504)
print v(xbgr.mr_n72449824)
print v(xbgr.mr_n72449936)
print v(xbgr.mr_n72450256)
print v(xbgr.mr_n72450368)
print v(xbgr.mr_n72450688)
print v(xbgr.mr_n72450800)
print v(xbgr.mr_n72451120)
print v(xbgr.mr_n72451984)
print v(xbgr.mr_n72452848)
print v(xbgr.mr_n72453280)
print v(xbgr.mr_n72453712)
print v(xbgr.mr_n72454144)
print v(xbgr.mr_n72454576)
print v(xbgr.mr_n72455008)
print v(xbgr.mr_n72455440)
print v(xbgr.mr_n72455872)
print v(xbgr.mr_n72456304)
print v(xbgr.mr_n72456736)
print v(xbgr.mr_n72457168)
print v(xbgr.mr_n72457600)
print v(xbgr.mr_n72458032)
print v(xbgr.mr_n72458144)
print v(xbgr.mr_n72458464)
print v(xbgr.mr_n72458576)
print v(xbgr.mr_n72458896)
print v(xbgr.mr_n72459008)
print v(xbgr.mr_n72459328)
print v(xbgr.mr_n72459440)
print v(xbgr.mr_n72459760)
print v(xbgr.mr_n72459872)
print v(xbgr.mr_n72460192)
print v(xbgr.mr_n72460304)
print v(xbgr.mr_n72460624)
print v(xbgr.mr_n72460736)
print v(xbgr.mr_n72461056)
print v(xbgr.mr_n72461168)
print v(xbgr.mr_n72461488)
print v(xbgr.mr_n72461600)
print v(xbgr.mr_n72461920)
print v(xbgr.mr_n72462032)
print v(xbgr.mr_n72462352)
print v(xbgr.mr_n72462464)
print v(xbgr.mr_n72462784)
print v(xbgr.mr_n72462896)
print v(xbgr.mr_n72463216)
print v(xbgr.mr_n72463648)
print v(xbgr.mr_n72463760)
print v(xbgr.mr_n72464080)
print v(xbgr.mr_n72464192)
print v(xbgr.mr_n72464512)
print v(xbgr.mr_n72464624)
print v(xbgr.mr_n72464944)
print v(xbgr.mr_n72465056)
print v(xbgr.mr_n72465376)
print v(xbgr.mr_n72465488)
print v(xbgr.mr_n72465808)
print v(xbgr.mr_n72465920)
print v(xbgr.mr_n72466240)
print v(xbgr.mr_n72466352)
print v(xbgr.mr_n72466672)
print v(xbgr.mr_n72466784)
print v(xbgr.mr_n72467104)
print v(xbgr.mr_n72467216)
print v(xbgr.mr_n72467536)
print v(xbgr.mr_n72467648)
print v(xbgr.mr_n72467968)
print v(xbgr.mr_n72468400)
print v(xbgr.mr_n72468512)
print v(xbgr.mr_n72468832)
print v(xbgr.mr_n72468944)
print v(xbgr.mr_n72469264)
print v(xbgr.mr_n72469376)
print v(xbgr.mr_n72469696)
print v(xbgr.mr_n72469808)
print v(xbgr.mr_n72470128)
print v(xbgr.mr_n72470240)
print v(xbgr.mr_n72470560)
print v(xbgr.mr_n72470672)
print v(xbgr.mr_n72470992)
print v(xbgr.mr_n72471104)
print v(xbgr.mr_n72471424)
print v(xbgr.mr_n72471536)
print v(xbgr.mr_n72471856)
print v(xbgr.mr_n72471968)
print v(xbgr.mr_n72472288)
print v(xbgr.mr_n72472400)
print v(xbgr.mr_n72472720)
print v(xbgr.mr_n72472832)
print v(xbgr.mr_n72473152)
print v(xbgr.mr_n72473264)
print v(xbgr.mr_n72473584)
print v(xbgr.mr_n72473696)
print v(xbgr.mr_n72474016)
print v(xbgr.mr_n72474128)
print v(xbgr.mr_n72474448)
print v(xbgr.mr_n72474560)
print v(xbgr.mr_n72474880)
print v(xbgr.mr_n72474992)
print v(xbgr.mr_n72475312)
print v(xbgr.mr_n72475424)
print v(xbgr.mr_n72475744)
print v(xbgr.mr_n72475856)
print v(xbgr.mr_n72476176)
print v(xbgr.mr_n72476288)
print v(xbgr.mr_n72476608)
print v(xbgr.mr_n72476720)
print v(xbgr.mr_n72477040)
print v(xbgr.mr_n72477152)
print v(xbgr.mr_n72477472)
print v(xbgr.mr_n72477584)
print v(xbgr.mr_n72477904)
print v(xbgr.mr_n72478016)
print v(xbgr.mr_n72478336)
print v(xbgr.mr_n72478448)
print v(xbgr.mr_n72478768)
print v(xbgr.mr_n72478880)
print v(xbgr.mr_n72479200)
print v(xbgr.mr_n72479312)
print v(xbgr.mr_n72479632)
print v(xbgr.mr_n72479744)
print v(xbgr.mr_n72480064)
print v(xbgr.mr_n72480176)
print v(xbgr.mr_n72480496)
print v(xbgr.mr_n72480608)
print v(xbgr.mr_n72480928)
print v(xbgr.mr_n72481040)
print v(xbgr.mr_n72481360)
print v(xbgr.mr_n72481472)
print v(xbgr.mr_n72481792)
print v(xbgr.mr_n72481904)
print v(xbgr.mr_n72482224)
print v(xbgr.mr_n72482336)
print v(xbgr.mr_n72482656)
print v(xbgr.mr_n72482768)
print v(xbgr.mr_n72483088)
print v(xbgr.mr_n72483200)
print v(xbgr.mr_n72483520)
print v(xbgr.mr_n72483632)
print v(xbgr.mr_n72483952)
print v(xbgr.mr_n72484064)
print v(xbgr.mr_n72484384)
print v(xbgr.mr_n72484496)
print v(xbgr.mr_n72484816)
print v(xbgr.mr_n72484928)
print v(xbgr.mr_n72485248)
print v(xbgr.mr_n72485360)
print v(xbgr.mr_n72485680)
print v(xbgr.mr_n72485792)
print v(xbgr.mr_n72486112)
print v(xbgr.mr_n72486224)
print v(xbgr.mr_n72486544)
print v(xbgr.mr_n72486656)
print v(xbgr.mr_n72486976)
print v(xbgr.mr_n72487088)
print v(xbgr.mr_n72487408)
print v(xbgr.mr_n72487520)
print v(xbgr.mr_n72487840)
print v(xbgr.mr_n72487952)
print v(xbgr.mr_n72488272)
print v(xbgr.mr_n72488384)
print v(xbgr.mr_n72488704)
print v(xbgr.mr_n72488816)
print v(xbgr.mr_n72489136)
print v(xbgr.mr_n72489248)
print v(xbgr.mr_n72489568)
print v(xbgr.mr_n72489680)
print v(xbgr.mr_n72490000)
print v(xbgr.mr_n72490112)
print v(xbgr.mr_n72490432)
print v(xbgr.mr_n72490544)
print v(xbgr.mr_n72490864)
print v(xbgr.mr_n72490976)
print v(xbgr.mr_n72491296)
print v(xbgr.mr_n72491408)
print v(xbgr.mr_n72491728)
print v(xbgr.mr_n72491840)
print v(xbgr.mr_n72492160)
print v(xbgr.mr_n72492272)
print v(xbgr.mr_n72492592)
print v(xbgr.mr_n72492704)
print v(xbgr.mr_n72493024)
print v(xbgr.mr_n72493136)
print v(xbgr.mr_n72493456)
print v(xbgr.mr_n72493568)
print v(xbgr.mr_n72493888)
print v(xbgr.mr_n72494000)
print v(xbgr.mr_n72494320)
print v(xbgr.mr_n72494432)
print v(xbgr.mr_n72494752)
print v(xbgr.mr_n72494864)
print v(xbgr.mr_n72495184)
print v(xbgr.mr_n72495616)
print v(xbgr.mr_n72495728)
print v(xbgr.mr_n72496048)
print v(xbgr.mr_n72496160)
print v(xbgr.mr_n72496480)
print v(xbgr.mr_n72496592)
print v(xbgr.mr_n72496912)
print v(xbgr.mr_n72497024)
print v(xbgr.mr_n72497344)
print v(xbgr.mr_n72497456)
print v(xbgr.mr_n72497776)
print v(xbgr.mr_n72497888)
print v(xbgr.mr_n72498208)
print v(xbgr.mr_n72498320)
print v(xbgr.mr_n72498640)
print v(xbgr.mr_n72498752)
print v(xbgr.mr_n72499072)
print v(xbgr.mr_n72499184)
print v(xbgr.mr_n72499504)
print v(xbgr.mr_n72499616)
print v(xbgr.mr_n72499936)
print v(xbgr.mr_n72500048)
print v(xbgr.mr_n72500368)
print v(xbgr.mr_n72500480)
print v(xbgr.mr_n72500800)
print v(xbgr.mr_n72500912)
print v(xbgr.mr_n72501232)
print v(xbgr.mr_n72501344)
print v(xbgr.mr_n72501664)
print v(xbgr.mr_n72501776)
print v(xbgr.mr_n72502096)
print v(xbgr.mr_n72502208)
print v(xbgr.mr_n72502528)
print v(xbgr.mr_n72502640)
print v(xbgr.mr_n72502960)
print v(xbgr.mr_n72503072)
print v(xbgr.mr_n72503392)
print v(xbgr.mr_n72503936)
print v(xbgr.mr_n72504256)
print v(xbgr.mr_n72504368)
print v(xbgr.mr_n72504688)
print v(xbgr.mr_n72504800)
print v(xbgr.mr_n72505232)
print v(xbgr.mr_n72505664)
print v(xbgr.mr_n72506096)
print v(xbgr.mr_n72506528)
print v(xbgr.mr_n72506960)
print v(xbgr.mr_n72507392)
print v(xbgr.mr_n72507824)
print v(xbgr.mr_n72508256)
print v(xbgr.mr_n72508688)
print v(xbgr.mr_n72509120)
print v(xbgr.mr_n72509552)
print v(xbgr.mr_n72509984)
print v(xbgr.mr_n72510416)
print v(xbgr.mr_n72510848)
print v(xbgr.mr_n72511280)
print v(xbgr.mr_n72511712)
print v(xbgr.mr_n72512144)
print v(xbgr.mr_n72512576)
print v(xbgr.mr_n72513008)
print v(xbgr.mr_n72513440)
print v(xbgr.mr_n72513872)
print v(xbgr.mr_n72514304)
print v(xbgr.mr_n72514736)
print v(xbgr.mr_n72515168)
print v(xbgr.mr_n72515600)
print v(xbgr.mr_n72516032)
print v(xbgr.mr_n72516464)
print v(xbgr.mr_n72516896)
print v(xbgr.mr_n72517328)
print v(xbgr.mr_n72517760)
print v(xbgr.mr_n72518192)
print v(xbgr.mr_n72518624)
print v(xbgr.mr_n72519056)
print v(xbgr.mr_n72519488)
print v(xbgr.mr_n72519920)
print v(xbgr.mr_n72520352)
print v(xbgr.mr_n72520784)
print v(xbgr.mr_n72521216)
print v(xbgr.mr_n72521648)
print v(xbgr.mr_n72522080)
print v(xbgr.mr_n72522512)
print v(xbgr.mr_n72522944)
print v(xbgr.mr_n72523376)
print v(xbgr.mr_n72523808)
print v(xbgr.mr_n72524240)
print v(xbgr.mr_n72524672)
print v(xbgr.mr_n72525104)
print v(xbgr.mr_n72525536)
print v(xbgr.mr_n72525968)
print v(xbgr.mr_n72526400)
print v(xbgr.mr_n72526832)
print v(xbgr.mr_n72527264)
print v(xbgr.mr_n72527696)
print v(xbgr.mr_n72528128)
print v(xbgr.mr_n72528560)
print v(xbgr.mr_n72528992)
print v(xbgr.mr_n72529424)
print v(xbgr.mr_n72529856)
print v(xbgr.mr_n72530288)
print v(xbgr.mr_n72530720)
print v(xbgr.mr_n72531152)
print v(xbgr.mr_n72531584)
print v(xbgr.mr_n72532016)
print v(xbgr.mr_n72532448)
print v(xbgr.mr_n72532880)
print v(xbgr.mr_n72533312)
print v(xbgr.mr_n72533744)
print v(xbgr.mr_n72534176)
print v(xbgr.mr_n72534608)
print v(xbgr.mr_n72535040)
print v(xbgr.mr_n72535472)
print v(xbgr.mr_n72535904)
print v(xbgr.mr_n72536336)
print v(xbgr.mr_n72536768)
print v(xbgr.mr_n72537200)
print v(xbgr.mr_n72537632)
print v(xbgr.mr_n72538064)
print v(xbgr.mr_n72538496)
print v(xbgr.mr_n72538928)
print v(xbgr.mr_n72539360)
print v(xbgr.mr_n72539792)
print v(xbgr.mr_n72540224)
print v(xbgr.mr_n72540656)
print v(xbgr.mr_n72541088)
print v(xbgr.mr_n72541520)
print v(xbgr.mr_n72541952)
print v(xbgr.mr_n72542384)
print v(xbgr.mr_n72542816)
print v(xbgr.mr_n72543248)
print v(xbgr.mr_n72543680)
print v(xbgr.mr_n72544112)
print v(xbgr.mr_n72544544)
print v(xbgr.mr_n72544976)
print v(xbgr.mr_n72545408)
print v(xbgr.mr_n72545840)
print v(xbgr.mr_n72546272)
print v(xbgr.mr_n72546704)
print v(xbgr.mr_n72547136)
print v(xbgr.mr_n72547568)
print v(xbgr.mr_n72548000)
print v(xbgr.mr_n72548432)
print v(xbgr.mr_n72548864)
print v(xbgr.mr_n72549296)
print v(xbgr.mr_n72549728)
print v(xbgr.mr_n72550160)
print v(xbgr.mr_n72550480)
print v(xbgr.mr_n72550592)
print v(xbgr.mr_n72550912)
print v(xbgr.mr_n72551024)
print v(xbgr.mr_n72551344)
print v(xbgr.mr_n72551456)
print v(xbgr.mr_n72551776)
print v(xbgr.mr_n72551888)
print v(xbgr.mr_n72552208)
print v(xbgr.mr_n72552320)
print v(xbgr.mr_n72552640)
print v(xbgr.mr_n72552752)
print v(xbgr.mr_n72553072)
print v(xbgr.mr_n72553184)
print v(xbgr.mr_n72553504)
print v(xbgr.mr_n72553616)
print v(xbgr.mr_n72553936)
print v(xbgr.mr_n72554048)
print v(xbgr.mr_n72554368)
print v(xbgr.mr_n72554480)
print v(xbgr.mr_n72554800)
print v(xbgr.mr_n72554912)
print v(xbgr.mr_n72555232)
print v(xbgr.mr_n72555344)
print v(xbgr.mr_n72555664)
print v(xbgr.mr_n72555776)
print v(xbgr.mr_n72556096)
print v(xbgr.mr_n72556208)
print v(xbgr.mr_n72556528)
print v(xbgr.mr_n72556640)
print v(xbgr.mr_n72556960)
print v(xbgr.mr_n72557072)
print v(xbgr.mr_n72557392)
print v(xbgr.mr_n72557504)
print v(xbgr.mr_n72557824)
print v(xbgr.mr_n72557936)
print v(xbgr.mr_n72558256)
print v(xbgr.mr_n72558368)
print v(xbgr.mr_n72558688)
print v(xbgr.mr_n72558800)
print v(xbgr.mr_n72559120)
print v(xbgr.mr_n72559232)
print v(xbgr.mr_n72559552)
print v(xbgr.mr_n72559664)
print v(xbgr.mr_n72559984)
print v(xbgr.mr_n72560096)
print v(xbgr.mr_n72560416)
print v(xbgr.mr_n72560528)
print v(xbgr.mr_n72560848)
print v(xbgr.mr_n72560960)
print v(xbgr.mr_n72561280)
print v(xbgr.mr_n72561392)
print v(xbgr.mr_n72561712)
print v(xbgr.mr_n72561824)
print v(xbgr.mr_n72562144)
print v(xbgr.mr_n72562256)
print v(xbgr.mr_n72562576)
print v(xbgr.mr_n72562688)
print v(xbgr.mr_n72563008)
print v(xbgr.mr_n72563120)
print v(xbgr.mr_n72563440)
print v(xbgr.mr_n72563552)
print v(xbgr.mr_n72563872)
print v(xbgr.mr_n72563984)
print v(xbgr.mr_n72564304)
print v(xbgr.mr_n72564416)
print v(xbgr.mr_n72564736)
print v(xbgr.mr_n72564848)
print v(xbgr.mr_n72565168)
print v(xbgr.mr_n72565280)
print v(xbgr.mr_n72565600)
print v(xbgr.mr_n72565712)
print v(xbgr.mr_n72566032)
print v(xbgr.mr_n72566144)
print v(xbgr.mr_n72566464)
print v(xbgr.mr_n72566576)
print v(xbgr.mr_n72566896)
print v(xbgr.mr_n72567008)
print v(xbgr.mr_n72567328)
print v(xbgr.mr_n72567440)
print v(xbgr.mr_n72567760)
print v(xbgr.mr_n72567872)
print v(xbgr.mr_n72568192)
print v(xbgr.mr_n72568304)
print v(xbgr.mr_n72568624)
print v(xbgr.mr_n72569056)
print v(xbgr.mr_n72569168)
print v(xbgr.mr_n72569488)
print v(xbgr.mr_n72569600)
print v(xbgr.mr_n72569920)
print v(xbgr.mr_n72570032)
print v(xbgr.mr_n72570352)
print v(xbgr.mr_n72570464)
print v(xbgr.mr_n72570784)
print v(xbgr.mr_n72570896)
print v(xbgr.mr_n72571216)
print v(xbgr.mr_n72571328)
print v(xbgr.mr_n72571648)
print v(xbgr.mr_n72571760)
print v(xbgr.mr_n72572080)
print v(xbgr.mr_n72572192)
print v(xbgr.mr_n72572512)
print v(xbgr.mr_n72572624)
print v(xbgr.mr_n72572944)
print v(xbgr.mr_n72573056)
print v(xbgr.mr_n72573376)
print v(xbgr.mr_n72573488)
print v(xbgr.mr_n72573808)
print v(xbgr.mr_n72573920)
print v(xbgr.mr_n72574240)
print v(xbgr.mr_n72574352)
print v(xbgr.mr_n72574672)
print v(xbgr.mr_n72574784)
print v(xbgr.mr_n72575104)
print v(xbgr.mr_n72575216)
print v(xbgr.mr_n72575536)
print v(xbgr.mr_n72575648)
print v(xbgr.mr_n72575968)
print v(xbgr.mr_n72576080)
print v(xbgr.mr_n72576400)
print v(xbgr.mr_n72576512)
print v(xbgr.mr_n72576832)
print v(xbgr.mr_n72576944)
print v(xbgr.mr_n72577264)
print v(xbgr.mr_n72577376)
print v(xbgr.mr_n72577696)
print v(xbgr.mr_n72577808)
print v(xbgr.mr_n72578128)
print v(xbgr.mr_n72578240)
print v(xbgr.mr_n72578560)
print v(xbgr.mr_n72578672)
print v(xbgr.mr_n72578992)
print v(xbgr.mr_n72579104)
print v(xbgr.mr_n72579424)
print v(xbgr.mr_n72579536)
print v(xbgr.mr_n72579856)
print v(xbgr.mr_n72579968)
print v(xbgr.mr_n72580288)
print v(xbgr.mr_n72580400)
print v(xbgr.mr_n72580720)
print v(xbgr.mr_n72580832)
print v(xbgr.mr_n72581152)
print v(xbgr.mr_n72581264)
print v(xbgr.mr_n72581584)
print v(xbgr.mr_n72581696)
print v(xbgr.mr_n72582016)
print v(xbgr.mr_n72582128)
print v(xbgr.mr_n72582448)
print v(xbgr.mr_n72582560)
print v(xbgr.mr_n72582880)
print v(xbgr.mr_n72582992)
print v(xbgr.mr_n72583312)
print v(xbgr.mr_n72583424)
print v(xbgr.mr_n72583744)
print v(xbgr.mr_n72583856)
print v(xbgr.mr_n72584176)
print v(xbgr.mr_n72584288)
print v(xbgr.mr_n72584608)
print v(xbgr.mr_n72584720)
print v(xbgr.mr_n72585040)
print v(xbgr.mr_n72585152)
print v(xbgr.mr_n72585472)
print v(xbgr.mr_n72585584)
print v(xbgr.mr_n72585904)
print v(xbgr.mr_n72586016)
print v(xbgr.mr_n72586336)
print v(xbgr.mr_n72586448)
print v(xbgr.mr_n72586768)
print v(xbgr.mr_n72586880)
print v(xbgr.mr_n72587200)
print v(xbgr.mr_n72587312)
print v(xbgr.mr_n72587632)
print v(xbgr.mr_n72587744)
print v(xbgr.mr_n72588064)
print v(xbgr.mr_n72588176)
print v(xbgr.mr_n72588496)
print v(xbgr.mr_n72588608)
print v(xbgr.mr_n72588928)
print v(xbgr.mr_n72589040)
print v(xbgr.mr_n72589360)
print v(xbgr.mr_n72589472)
print v(xbgr.mr_n72589792)
print v(xbgr.mr_n72589904)
print v(xbgr.mr_n72590224)
print v(xbgr.mr_n72590336)
print v(xbgr.mr_n72590656)
print v(xbgr.mr_n72590768)
print v(xbgr.mr_n72591088)
print v(xbgr.mr_n72591200)
print v(xbgr.mr_n72591520)
print v(xbgr.mr_n72591632)
print v(xbgr.mr_n72591952)
print v(xbgr.mr_n72592064)
print v(xbgr.mr_n72592384)
print v(xbgr.mr_n72592496)
print v(xbgr.mr_n72592816)
print v(xbgr.mr_n72592928)
print v(xbgr.mr_n72593248)
print v(xbgr.mr_n72593360)
print v(xbgr.mr_n72593680)
print v(xbgr.mr_n72593792)
print v(xbgr.mr_n72594112)
print v(xbgr.mr_n72594224)
print v(xbgr.mr_n72594544)
print v(xbgr.mr_n72594656)
print v(xbgr.mr_n72594976)
print v(xbgr.mr_n72595088)
print v(xbgr.mr_n72595408)
print v(xbgr.mr_n72595520)
print v(xbgr.mr_n72595840)
print v(xbgr.mr_n72595952)
print v(xbgr.mr_n72596272)
print v(xbgr.mr_n72596384)
print v(xbgr.mr_n72596704)
print v(xbgr.mr_n72596816)
print v(xbgr.mr_n72597136)
print v(xbgr.mr_n72597248)
print v(xbgr.mr_n72597568)
print v(xbgr.mr_n72597680)
print v(xbgr.mr_n72598000)
print v(xbgr.mr_n72598112)
print v(xbgr.mr_n72598432)
print v(xbgr.mr_n72598544)
print v(xbgr.mr_n72598864)
print v(xbgr.mr_n72598976)
print v(xbgr.mr_n72599296)
print v(xbgr.mr_n72599408)
print v(xbgr.mr_n72599728)
print v(xbgr.mr_n72599840)
print v(xbgr.mr_n72600160)
print v(xbgr.mr_n72600272)
print v(xbgr.mr_n72600592)
print v(xbgr.mr_n72600704)
print v(xbgr.mr_n72601024)
print v(xbgr.mr_n72601136)
print v(xbgr.mr_n72601456)
print v(xbgr.mr_n72601568)
print v(xbgr.mr_n72601888)
print v(xbgr.mr_n72602000)
print v(xbgr.mr_n72602320)
print v(xbgr.mr_n72602432)
print v(xbgr.mr_n72602752)
print v(xbgr.mr_n72602864)
print v(xbgr.mr_n72603184)
print v(xbgr.mr_n72603296)
print v(xbgr.mr_n72603616)
print v(xbgr.mr_n72603728)
print v(xbgr.mr_n72604048)
print v(xbgr.mr_n72604160)
print v(xbgr.mr_n72604480)
print v(xbgr.mr_n72604592)
print v(xbgr.mr_n72604912)
print v(xbgr.mr_n72605024)
print v(xbgr.mr_n72605344)
print v(xbgr.mr_n72605456)
print v(xbgr.mr_n72605776)
print v(xbgr.mr_n72605888)
print v(xbgr.mr_n72606208)
print v(xbgr.mr_n72606320)
print v(xbgr.mr_n72606640)
print v(xbgr.mr_n72606752)
print v(xbgr.mr_n72607072)
print v(xbgr.mr_n72607184)
print v(xbgr.mr_n72607504)
print v(xbgr.mr_n72607616)
print v(xbgr.mr_n72607936)
print v(xbgr.mr_n72608048)
print v(xbgr.mr_n72608368)
print v(xbgr.mr_n72608480)
print v(xbgr.mr_n72608800)
print v(xbgr.mr_n72608912)
print v(xbgr.mr_n72609232)
print v(xbgr.mr_n72609344)
print v(xbgr.mr_n72609664)
print v(xbgr.mr_n72609776)
print v(xbgr.mr_n72610096)
print v(xbgr.mr_n72610208)
print v(xbgr.mr_n72610528)
print v(xbgr.mr_n72610640)
print v(xbgr.mr_n72610960)
print v(xbgr.mr_n72611072)
print v(xbgr.mr_n72611392)
print v(xbgr.mr_n72611504)
print v(xbgr.mr_n72611824)
print v(xbgr.mr_n72611936)
print v(xbgr.mr_n72612256)
print v(xbgr.mr_n72612368)
print v(xbgr.mr_n72612688)
print v(xbgr.mr_n72612800)
print v(xbgr.mr_n72613120)
print v(xbgr.mr_n72613232)
print v(xbgr.mr_n72613552)
print v(xbgr.mr_n72613664)
print v(xbgr.mr_n72613984)
print v(xbgr.mr_n72614096)
print v(xbgr.mr_n72614416)
print v(xbgr.mr_n72614528)
print v(xbgr.mr_n72614848)
print v(xbgr.mr_n72614960)
print v(xbgr.mr_n72615280)
print v(xbgr.mr_n72615392)
print v(xbgr.mr_n72615712)
print v(xbgr.mr_n72615824)
print v(xbgr.mr_n72616144)
print v(xbgr.mr_n72616256)
print v(xbgr.mr_n72616576)
print v(xbgr.mr_n72616688)
print v(xbgr.mr_n72617008)
print v(xbgr.mr_n72617120)
print v(xbgr.mr_n72617440)
print v(xbgr.mr_n72617552)
print v(xbgr.mr_n72617872)
print v(xbgr.mr_n72617984)
print v(xbgr.mr_n72618304)
print v(xbgr.mr_n72618416)
print v(xbgr.mr_n72618736)
print v(xbgr.mr_n72619168)
print v(xbgr.mr_n72619280)
print v(xbgr.mr_n72619600)
print v(xbgr.mr_n72619712)
print v(xbgr.mr_n72620032)
print v(xbgr.mr_n72620144)
print v(xbgr.mr_n72620464)
print v(xbgr.mr_n72620576)
print v(xbgr.mr_n72620896)
print v(xbgr.mr_n72621008)
print v(xbgr.mr_n72621328)
print v(xbgr.mr_n72621440)
print v(xbgr.mr_n72621760)
print v(xbgr.mr_n72621872)
print v(xbgr.mr_n72622192)
print v(xbgr.mr_n72622304)
print v(xbgr.mr_n72622624)
print v(xbgr.mr_n72622736)
print v(xbgr.mr_n72623056)
print v(xbgr.mr_n72623168)
print v(xbgr.mr_n72623488)
print v(xbgr.mr_n72623600)
print v(xbgr.mr_n72623920)
print v(xbgr.mr_n72624032)
print v(xbgr.mr_n72624352)
print v(xbgr.mr_n72624464)
print v(xbgr.mr_n72624784)
print v(xbgr.mr_n72624896)
print v(xbgr.mr_n72625216)
print v(xbgr.mr_n72625328)
print v(xbgr.mr_n72625648)
print v(xbgr.mr_n72625760)
print v(xbgr.mr_n72626080)
print v(xbgr.mr_n72626192)
print v(xbgr.mr_n72626512)
print v(xbgr.mr_n72626624)
print v(xbgr.mr_n72626944)
print v(xbgr.mr_n72627056)
print v(xbgr.mr_n72627376)
print v(xbgr.mr_n72627488)
print v(xbgr.mr_n72627808)
print v(xbgr.mr_n72627920)
print v(xbgr.mr_n72628240)
print v(xbgr.mr_n72628352)
print v(xbgr.mr_n72628672)
print v(xbgr.mr_n72628784)
print v(xbgr.mr_n72629104)
print v(xbgr.mr_n72629216)
print v(xbgr.mr_n72629536)
print v(xbgr.mr_n72629648)
print v(xbgr.mr_n72629968)
print v(xbgr.mr_n72630080)
print v(xbgr.mr_n72630400)
print v(xbgr.mr_n72630512)
print v(xbgr.mr_n72630832)
print v(xbgr.mr_n72630944)
print v(xbgr.mr_n72631264)
print v(xbgr.mr_n72631376)
print v(xbgr.mr_n72631696)
print v(xbgr.mr_n72631808)
print v(xbgr.mr_n72632128)
print v(xbgr.mr_n72632240)
print v(xbgr.mr_n72632560)
print v(xbgr.mr_n72632672)
print v(xbgr.mr_n72632992)
print v(xbgr.mr_n72633104)
print v(xbgr.mr_n72633424)
print v(xbgr.mr_n72633536)
print v(xbgr.mr_n72633856)
print v(xbgr.mr_n72633968)
print v(xbgr.mr_n72634288)
print v(xbgr.mr_n72634400)
print v(xbgr.mr_n72634720)
print v(xbgr.mr_n72634832)
print v(xbgr.mr_n72635152)
print v(xbgr.mr_n72635264)
print v(xbgr.mr_n72635584)
print v(xbgr.mr_n72635696)
print v(xbgr.mr_n72636016)
print v(xbgr.mr_n72636128)
print v(xbgr.mr_n72636448)
print v(xbgr.mr_n72636560)
print v(xbgr.mr_n72636880)
print v(xbgr.mr_n72636992)
print v(xbgr.mr_n72637312)
print v(xbgr.mr_n72637424)
print v(xbgr.mr_n72637744)
print v(xbgr.mr_n72637856)
print v(xbgr.mr_n72638176)
print v(xbgr.mr_n72638288)
print v(xbgr.mr_n72638608)
print v(xbgr.mr_n72638720)
print v(xbgr.mr_n72639040)
print v(xbgr.mr_n72639152)
print v(xbgr.mr_n72639472)
print v(xbgr.mr_n72639904)
print v(xbgr.mr_n72640016)
print v(xbgr.mr_n72640336)
print v(xbgr.mr_n72640448)
print v(xbgr.mr_n72640768)
print v(xbgr.mr_n72640880)
print v(xbgr.mr_n72641200)
print v(xbgr.mr_n72641312)
print v(xbgr.mr_n72641632)
print v(xbgr.mr_n72641744)
print v(xbgr.mr_n72642064)
print v(xbgr.mr_n72642176)
print v(xbgr.mr_n72642608)
print v(xbgr.mr_n72643040)
print v(xbgr.mr_n72643360)
print v(xbgr.mr_n72643472)
print v(xbgr.mr_n72643792)
print v(xbgr.mr_n72643904)
print v(xbgr.mr_n72644224)
print v(xbgr.mr_n72644336)
print v(xbgr.mr_n72644656)
print v(xbgr.mr_n72644768)
print v(xbgr.mr_n72645088)
print v(xbgr.mr_n72645200)
print v(xbgr.mr_n72645520)
print v(xbgr.mr_n72645632)
print v(xbgr.mr_n72645952)
print v(xbgr.mr_n72646064)
print v(xbgr.mr_n72646384)
print v(xbgr.mr_n72646496)
print v(xbgr.mr_n72646816)
print v(xbgr.mr_n72646928)
print v(xbgr.mr_n72647248)
print v(xbgr.mr_n72647360)
print v(xbgr.mr_n72647680)
print v(xbgr.mr_n72647792)
print v(xbgr.mr_n72648112)
print v(xbgr.mr_n72648224)
print v(xbgr.mr_n72648544)
print v(xbgr.mr_n72648656)
print v(xbgr.mr_n72648976)
print v(xbgr.mr_n72649088)
print v(xbgr.mr_n72649408)
print v(xbgr.mr_n72649520)
print v(xbgr.mr_n72649840)
print v(xbgr.mr_n72649952)
print v(xbgr.mr_n72650272)
print v(xbgr.mr_n72650384)
print v(xbgr.mr_n72650704)
print v(xbgr.mr_n72650816)
print v(xbgr.mr_n72651136)
print v(xbgr.mr_n72651248)
print v(xbgr.mr_n72651568)
print v(xbgr.mr_n72651680)
print v(xbgr.mr_n72652000)
print v(xbgr.mr_n72652112)
print v(xbgr.mr_n72652432)
print v(xbgr.mr_n72652544)
print v(xbgr.mr_n72652864)
print v(xbgr.mr_n72652976)
print v(xbgr.mr_n72653296)
print v(xbgr.mr_n72653408)
print v(xbgr.mr_n72653728)
print v(xbgr.mr_n72653840)
print v(xbgr.mr_n72654160)
print v(xbgr.mr_n72654272)
print v(xbgr.mr_n72654592)
print v(xbgr.mr_n72654704)
print v(xbgr.mr_n72655024)
print v(xbgr.mr_n72655136)
print v(xbgr.mr_n72655456)
print v(xbgr.mr_n72655568)
print v(xbgr.mr_n72655888)
print v(xbgr.mr_n72656000)
print v(xbgr.mr_n72656320)
print v(xbgr.mr_n72656432)
print v(xbgr.mr_n72656752)
print v(xbgr.mr_n72656864)
print v(xbgr.mr_n72657184)
print v(xbgr.mr_n72657296)
print v(xbgr.mr_n72657616)
print v(xbgr.mr_n72657728)
print v(xbgr.mr_n72658048)
print v(xbgr.mr_n72658160)
print v(xbgr.mr_n72658480)
print v(xbgr.mr_n72658592)
print v(xbgr.mr_n72658912)
print v(xbgr.mr_n72659024)
print v(xbgr.mr_n72659344)
print v(xbgr.mr_n72659456)
print v(xbgr.mr_n72659776)
print v(xbgr.mr_n72659888)
print v(xbgr.mr_n72660208)
print v(xbgr.mr_n72660320)
print v(xbgr.mr_n72660640)
print v(xbgr.mr_n72660752)
print v(xbgr.mr_n72661072)
print v(xbgr.mr_n72661184)
print v(xbgr.mr_n72661504)
print v(xbgr.mr_n72661616)
print v(xbgr.mr_n72661936)
print v(xbgr.mr_n72662048)
print v(xbgr.mr_n72662368)
print v(xbgr.mr_n72662480)
print v(xbgr.mr_n72662800)
print v(xbgr.mr_n72662912)
print v(xbgr.mr_n72663232)
print v(xbgr.mr_n72663344)
print v(xbgr.mr_n72663664)
print v(xbgr.mr_n72663776)
print v(xbgr.mr_n72664096)
print v(xbgr.mr_n72664208)
print v(xbgr.mr_n72664528)
print v(xbgr.mr_n72664640)
print v(xbgr.mr_n72664960)
print v(xbgr.mr_n72665072)
print v(xbgr.mr_n72665392)
print v(xbgr.mr_n72665504)
print v(xbgr.mr_n72665824)
print v(xbgr.mr_n72665936)
print v(xbgr.mr_n72666256)
print v(xbgr.mr_n72666368)
print v(xbgr.mr_n72666688)
print v(xbgr.mr_n72666800)
print v(xbgr.mr_n72667120)
print v(xbgr.mr_n72667232)
print v(xbgr.mr_n72667552)
print v(xbgr.mr_n72667664)
print v(xbgr.mr_n72667984)
print v(xbgr.mr_n72668096)
print v(xbgr.mr_n72668416)
print v(xbgr.mr_n72668528)
print v(xbgr.mr_n72668848)
print v(xbgr.mr_n72668960)
print v(xbgr.mr_n72669280)
print v(xbgr.mr_n72669392)
print v(xbgr.mr_n72669712)
print v(xbgr.mr_n72669824)
print v(xbgr.mr_n72670144)
print v(xbgr.mr_n72670256)
print v(xbgr.mr_n72670576)
print v(xbgr.mr_n72670688)
print v(xbgr.mr_n72671008)
print v(xbgr.mr_n72671120)
print v(xbgr.mr_n72671440)
print v(xbgr.mr_n72671552)
print v(xbgr.mr_n72671872)
print v(xbgr.mr_n72671984)
print v(xbgr.mr_n72672304)
print v(xbgr.mr_n72672416)
print v(xbgr.mr_n72672736)
print v(xbgr.mr_n72672848)
print v(xbgr.mr_n72673168)
print v(xbgr.mr_n72673280)
print v(xbgr.mr_n72673600)
print v(xbgr.mr_n72673712)
print v(xbgr.mr_n72674032)
print v(xbgr.mr_n72674144)
print v(xbgr.mr_n72674464)
print v(xbgr.mr_n72674576)
print v(xbgr.mr_n72674896)
print v(xbgr.mr_n72675008)
print v(xbgr.mr_n72675328)
print v(xbgr.mr_n72675440)
print v(xbgr.mr_n72675760)
print v(xbgr.mr_n72675872)
print v(xbgr.mr_n72676192)
print v(xbgr.mr_n72676304)
print v(xbgr.mr_n72676624)
print v(xbgr.mr_n72676736)
print v(xbgr.mr_n72677056)
print v(xbgr.mr_n72677168)
print v(xbgr.mr_n72677488)
print v(xbgr.mr_n72677600)
print v(xbgr.mr_n72677920)
print v(xbgr.mr_n72678032)
print v(xbgr.mr_n72678352)
print v(xbgr.mr_n72678464)
print v(xbgr.mr_n72678784)
print v(xbgr.mr_n72678896)
print v(xbgr.mr_n72679216)
print v(xbgr.mr_n72679328)
print v(xbgr.mr_n72679648)
print v(xbgr.mr_n72679760)
print v(xbgr.mr_n72680080)
print v(xbgr.mr_n72680192)
print v(xbgr.mr_n72680512)
print v(xbgr.mr_n72680624)
print v(xbgr.mr_n72680944)
print v(xbgr.mr_n72681056)
print v(xbgr.mr_n72681376)
print v(xbgr.mr_n72681488)
print v(xbgr.mr_n72681808)
print v(xbgr.mr_n72681920)
print v(xbgr.mr_n72682240)
print v(xbgr.mr_n72682352)
print v(xbgr.mr_n72682672)
print v(xbgr.mr_n72682784)
print v(xbgr.mr_n72683104)
print v(xbgr.mr_n72683216)
print v(xbgr.mr_n72683536)
print v(xbgr.mr_n72683648)
print v(xbgr.mr_n72683968)
print v(xbgr.mr_n72684080)
print v(xbgr.mr_n72684400)
print v(xbgr.mr_n72684512)
print v(xbgr.mr_n72684832)
print v(xbgr.mr_n72684944)
print v(xbgr.mr_n72685264)
print v(xbgr.mr_n72685376)
print v(xbgr.mr_n72685696)
print v(xbgr.mr_n72685808)
print v(xbgr.mr_n72686128)
print v(xbgr.mr_n72686240)
print v(xbgr.mr_n72686560)
print v(xbgr.mr_n72686672)
print v(xbgr.mr_n72686992)
print v(xbgr.mr_n72687104)
print v(xbgr.mr_n72687424)
print v(xbgr.mr_n72687536)
print v(xbgr.mr_n72687856)
print v(xbgr.mr_n72687968)
print v(xbgr.mr_n72688288)
print v(xbgr.mr_n72688400)
print v(xbgr.mr_n72688720)
print v(xbgr.mr_n72688832)
print v(xbgr.mr_n72689152)
print v(xbgr.mr_n72689264)
print v(xbgr.mr_n72689584)
print v(xbgr.mr_n72689696)
print v(xbgr.mr_n72690016)
print v(xbgr.mr_n72690128)
print v(xbgr.mr_n72690448)
print v(xbgr.mr_n72690560)
print v(xbgr.mr_n72690880)
print v(xbgr.mr_n72690992)
print v(xbgr.mr_n72691312)
print v(xbgr.mr_n72691424)
print v(xbgr.mr_n72691744)
print v(xbgr.mr_n72691856)
print v(xbgr.mr_n72692176)
print v(xbgr.mr_n72692288)
print v(xbgr.mr_n72692608)
print v(xbgr.mr_n72692720)
print v(xbgr.mr_n72693040)
print v(xbgr.mr_n72693152)
print v(xbgr.mr_n72693472)
print v(xbgr.mr_n72693584)
print v(xbgr.mr_n72693904)
print v(xbgr.mr_n72694016)
print v(xbgr.mr_n72694336)
print v(xbgr.mr_n72694448)
print v(xbgr.mr_n72694768)
print v(xbgr.mr_n72694880)
print v(xbgr.mr_n72695200)
print v(xbgr.mr_n72695312)
print v(xbgr.mr_n72695632)
print v(xbgr.mr_n72695744)
print v(xbgr.mr_n72696064)
print v(xbgr.mr_n72696176)
print v(xbgr.mr_n72696496)
print v(xbgr.mr_n72696608)
print v(xbgr.mr_n72696928)
print v(xbgr.mr_n72697040)
print v(xbgr.mr_n72697360)
print v(xbgr.mr_n72697472)
print v(xbgr.mr_n72697792)
print v(xbgr.mr_n72697904)
print v(xbgr.mr_n72698224)
print v(xbgr.mr_n72698336)
print v(xbgr.mr_n72698656)
print v(xbgr.mr_n72698768)
print v(xbgr.mr_n72699200)
print v(xbgr.mr_n72699632)
print v(xbgr.mr_n72700064)
print v(xbgr.mr_n72700496)
print v(xbgr.mr_n72700928)
print v(xbgr.mr_n72701360)
print v(xbgr.mr_n72701792)
print v(xbgr.mr_n72702224)
print v(xbgr.mr_n72702656)
print v(xbgr.mr_n72703088)
print v(xbgr.mr_n72703520)
print v(xbgr.mr_n72703952)
print v(xbgr.mr_n72704384)
print v(xbgr.mr_n72704816)
print v(xbgr.mr_n72705248)
print v(xbgr.mr_n72705680)
print v(xbgr.mr_n72706112)
print v(xbgr.mr_n72706544)
print v(xbgr.mr_n72706976)
print v(xbgr.mr_n72707408)
print v(xbgr.mr_n72707840)
print v(xbgr.mr_n72708272)
print v(xbgr.mr_n72708704)
print v(xbgr.mr_n72709136)
print v(xbgr.mr_n72709568)
print v(xbgr.mr_n72710000)
print v(xbgr.mr_n72710432)
print v(xbgr.mr_n72710864)
print v(xbgr.mr_n72711296)
print v(xbgr.mr_n72711728)
print v(xbgr.mr_n72712160)
print v(xbgr.mr_n72712592)
print v(xbgr.mr_n72713024)
print v(xbgr.mr_n72713456)
print v(xbgr.mr_n72713888)
print v(xbgr.mr_n72714320)
print v(xbgr.mr_n72714752)
print v(xbgr.mr_n72715184)
print v(xbgr.mr_n72715616)
print v(xbgr.mr_n72716048)
print v(xbgr.mr_n72716480)
print v(xbgr.mr_n72716912)
print v(xbgr.mr_n72717344)
print v(xbgr.mr_n72717776)
print v(xbgr.mr_n72718208)
print v(xbgr.mr_n72718640)
print v(xbgr.mr_n72719072)
print v(xbgr.mr_n72719504)
print v(xbgr.mr_n72719936)
print v(xbgr.mr_n72720368)
print v(xbgr.mr_n72720800)
print v(xbgr.mr_n72721232)
print v(xbgr.mr_n72721664)
print v(xbgr.mr_n72722096)
print v(xbgr.mr_n72722528)
print v(xbgr.mr_n72722960)
print v(xbgr.mr_n72723392)
print v(xbgr.mr_n72723824)
print v(xbgr.mr_n72724256)
print v(xbgr.mr_n72724688)
print v(xbgr.mr_n72725120)
print v(xbgr.mr_n72725552)
print v(xbgr.mr_n72725984)
print v(xbgr.mr_n72726416)
print v(xbgr.mr_n72726848)
print v(xbgr.mr_n72727280)
print v(xbgr.mr_n72727712)
print v(xbgr.mr_n72728144)
print v(xbgr.mr_n72728576)
print v(xbgr.mr_n72729008)
print v(xbgr.mr_n72729440)
print v(xbgr.mr_n72729872)
print v(xbgr.mr_n72730304)
print v(xbgr.mr_n72730736)
print v(xbgr.mr_n72731168)
print v(xbgr.mr_n72731600)
print v(xbgr.mr_n72732032)
print v(xbgr.mr_n72732464)
print v(xbgr.mr_n72732896)
print v(xbgr.mr_n72733328)
print v(xbgr.mr_n72733760)
print v(xbgr.mr_n72734192)
print v(xbgr.mr_n72734624)
print v(xbgr.mr_n72735056)
print v(xbgr.mr_n72735488)
print v(xbgr.mr_n72735920)
print v(xbgr.mr_n72736352)
print v(xbgr.mr_n72736784)
print v(xbgr.mr_n72737216)
print v(xbgr.mr_n72737648)
print v(xbgr.mr_n72738080)
print v(xbgr.mr_n72738512)
print v(xbgr.mr_n72738944)
print v(xbgr.mr_n72739376)
print v(xbgr.mr_n72739808)
print v(xbgr.mr_n72740240)
print v(xbgr.mr_n72740672)
print v(xbgr.mr_n72741104)
print v(xbgr.mr_n72741424)
print v(xbgr.mr_n72741536)
print v(xbgr.mr_n72741856)
print v(xbgr.mr_n72741968)
print v(xbgr.mr_n72742288)
print v(xbgr.mr_n72742400)
print v(xbgr.mr_n72742720)
print v(xbgr.mr_n72742832)
print v(xbgr.mr_n72743152)
print v(xbgr.mr_n72743264)
print v(xbgr.mr_n72743584)
print v(xbgr.mr_n72743696)
print v(xbgr.mr_n72744016)
print v(xbgr.mr_n72744128)
print v(xbgr.mr_n72744448)
print v(xbgr.mr_n72744560)
print v(xbgr.mr_n72744880)
print v(xbgr.mr_n72744992)
print v(xbgr.mr_n72745312)
print v(xbgr.mr_n72745424)
print v(xbgr.mr_n72745744)
print v(xbgr.mr_n72745856)
print v(xbgr.mr_n72746176)
print v(xbgr.mr_n72746288)
print v(xbgr.mr_n72746608)
print v(xbgr.mr_n72746720)
print v(xbgr.mr_n72747040)
print v(xbgr.mr_n72747152)
print v(xbgr.mr_n72747472)
print v(xbgr.mr_n72747584)
print v(xbgr.mr_n72747904)
print v(xbgr.mr_n72748016)
print v(xbgr.mr_n72748336)
print v(xbgr.mr_n72748448)
print v(xbgr.mr_n72748768)
print v(xbgr.mr_n72748880)
print v(xbgr.mr_n72749200)
print v(xbgr.mr_n72749312)
print v(xbgr.mr_n72749632)
print v(xbgr.mr_n72749744)
print v(xbgr.mr_n72750064)
print v(xbgr.mr_n72750176)
print v(xbgr.mr_n72750496)
print v(xbgr.mr_n72750608)
print v(xbgr.mr_n72750928)
print v(xbgr.mr_n72751040)
print v(xbgr.mr_n72751360)
print v(xbgr.mr_n72751472)
print v(xbgr.mr_n72751792)
print v(xbgr.mr_n72751904)
print v(xbgr.mr_n72752224)
print v(xbgr.mr_n72752336)
print v(xbgr.mr_n72752656)
print v(xbgr.mr_n72752768)
print v(xbgr.mr_n72753088)
print v(xbgr.mr_n72753200)
print v(xbgr.mr_n72753520)
print v(xbgr.mr_n72753632)
print v(xbgr.mr_n72753952)
print v(xbgr.mr_n72754064)
print v(xbgr.mr_n72754384)
print v(xbgr.mr_n72754496)
print v(xbgr.mr_n72754816)
print v(xbgr.mr_n72754928)
print v(xbgr.mr_n72755248)
print v(xbgr.mr_n72755360)
print v(xbgr.mr_n72755680)
print v(xbgr.mr_n72755792)
print v(xbgr.mr_n72756112)
print v(xbgr.mr_n72756224)
print v(xbgr.mr_n72756544)
print v(xbgr.mr_n72756656)
print v(xbgr.mr_n72756976)
print v(xbgr.mr_n72757088)
print v(xbgr.mr_n72757408)
print v(xbgr.mr_n72757520)
print v(xbgr.mr_n72757840)
print v(xbgr.mr_n72757952)
print v(xbgr.mr_n72758272)
print v(xbgr.mr_n72758384)
print v(xbgr.mr_n72758704)
print v(xbgr.mr_n72758816)
print v(xbgr.mr_n72759136)
print v(xbgr.mr_n72759248)
print v(xbgr.mr_n72759568)
print v(xbgr.mr_n72759680)
print v(xbgr.mr_n72760000)
print v(xbgr.mr_n72760112)
print v(xbgr.mr_n72760432)
print v(xbgr.mr_n72760544)
print v(xbgr.mr_n72760864)
print v(xbgr.mr_n72760976)
print v(xbgr.mr_n72761296)
print v(xbgr.mr_n72761408)
print v(xbgr.mr_n72761728)
print v(xbgr.mr_n72761840)
print v(xbgr.mr_n72762160)
print v(xbgr.mr_n72762272)
print v(xbgr.mr_n72762592)
print v(xbgr.mr_n72762704)
print v(xbgr.mr_n72763024)
print v(xbgr.mr_n72763136)
print v(xbgr.mr_n72763456)
print v(xbgr.mr_n72763568)
print v(xbgr.mr_n72763888)
print v(xbgr.mr_n72764000)
print v(xbgr.mr_n72764320)
print v(xbgr.mr_n72764432)
print v(xbgr.mr_n72764752)
print v(xbgr.mr_n72764864)
print v(xbgr.mr_n72765184)
print v(xbgr.mr_n72765296)
print v(xbgr.mr_n72765616)
print v(xbgr.mr_n72765728)
print v(xbgr.mr_n72766048)
print v(xbgr.mr_n72766160)
print v(xbgr.mr_n72766480)
print v(xbgr.mr_n72766592)
print v(xbgr.mr_n72766912)
print v(xbgr.mr_n72767024)
print v(xbgr.mr_n72767344)
print v(xbgr.mr_n72767456)
print v(xbgr.mr_n72767776)
print v(xbgr.mr_n72767888)
print v(xbgr.mr_n72768208)
print v(xbgr.mr_n72768320)
print v(xbgr.mr_n72768640)
print v(xbgr.mr_n72768752)
print v(xbgr.mr_n72769072)
print v(xbgr.mr_n72769184)
print v(xbgr.mr_n72769504)
print v(xbgr.mr_n72769616)
print v(xbgr.mr_n72769936)
print v(xbgr.mr_n72770048)
print v(xbgr.mr_n72770368)
print v(xbgr.mr_n72770480)
print v(xbgr.mr_n72770800)
print v(xbgr.mr_n72770912)
print v(xbgr.mr_n72771232)
print v(xbgr.mr_n72771344)
print v(xbgr.mr_n72771664)
print v(xbgr.mr_n72771776)
print v(xbgr.mr_n72772096)
print v(xbgr.mr_n72772208)
print v(xbgr.mr_n72772528)
print v(xbgr.mr_n72772640)
print v(xbgr.mr_n72772960)
print v(xbgr.mr_n72773072)
print v(xbgr.mr_n72773392)
print v(xbgr.mr_n72773504)
print v(xbgr.mr_n72773824)
print v(xbgr.mr_n72773936)
print v(xbgr.mr_n72774256)
print v(xbgr.mr_n72774368)
print v(xbgr.mr_n72774688)
print v(xbgr.mr_n72774800)
print v(xbgr.mr_n72775120)
print v(xbgr.mr_n72775232)
print v(xbgr.mr_n72775552)
print v(xbgr.mr_n72775664)
print v(xbgr.mr_n72775984)
print v(xbgr.mr_n72776096)
print v(xbgr.mr_n72776416)
print v(xbgr.mr_n72776528)
print v(xbgr.mr_n72776848)
print v(xbgr.mr_n72776960)
print v(xbgr.mr_n72777280)
print v(xbgr.mr_n72777392)
print v(xbgr.mr_n72777712)
print v(xbgr.mr_n72777824)
print v(xbgr.mr_n72778144)
print v(xbgr.mr_n72778256)
print v(xbgr.mr_n72778576)
print v(xbgr.mr_n72778688)
print v(xbgr.mr_n72779008)
print v(xbgr.mr_n72779120)
print v(xbgr.mr_n72779440)
print v(xbgr.mr_n72779552)
print v(xbgr.mr_n72779872)
print v(xbgr.mr_n72779984)
print v(xbgr.mr_n72780304)
print v(xbgr.mr_n72780416)
print v(xbgr.mr_n72780736)
print v(xbgr.mr_n72780848)
print v(xbgr.mr_n72781168)
print v(xbgr.mr_n72781280)
print v(xbgr.mr_n72781600)
print v(xbgr.mr_n72781712)
print v(xbgr.mr_n72782032)
print v(xbgr.mr_n72782144)
print v(xbgr.mr_n72782464)
print v(xbgr.mr_n72782576)
print v(xbgr.mr_n72782896)
print v(xbgr.mr_n72783008)
print v(xbgr.mr_n72783328)
print v(xbgr.mr_n72783440)
print v(xbgr.mr_n72783760)
print v(xbgr.mr_n72783872)
print v(xbgr.mr_n72784192)
print v(xbgr.mr_n72784304)
print v(xbgr.mr_n72784624)
print v(xbgr.mr_n72784736)
print v(xbgr.mr_n72785056)
print v(xbgr.mr_n72785168)
print v(xbgr.mr_n72785488)
print v(xbgr.mr_n72785600)
print v(xbgr.mr_n72785920)
print v(xbgr.mr_n72786032)
print v(xbgr.mr_n72786352)
print v(xbgr.mr_n72786464)
print v(xbgr.mr_n72786784)
print v(xbgr.mr_n72786896)
print v(xbgr.mr_n72787216)
print v(xbgr.mr_n72787328)
print v(xbgr.mr_n72787648)
print v(xbgr.mr_n72787760)
print v(xbgr.mr_n72788080)
print v(xbgr.mr_n72788192)
print v(xbgr.mr_n72788512)
print v(xbgr.mr_n72788624)
print v(xbgr.mr_n72788944)
print v(xbgr.mr_n72789056)
print v(xbgr.mr_n72789376)
print v(xbgr.mr_n72789488)
print v(xbgr.mr_n72789808)
print v(xbgr.mr_n72789920)
print v(xbgr.mr_n72790240)
print v(xbgr.mr_n72790352)
print v(xbgr.mr_n72790672)
print v(xbgr.mr_n72790784)
print v(xbgr.mr_n72791104)
print v(xbgr.mr_n72791216)
print v(xbgr.mr_n72791536)
print v(xbgr.mr_n72791648)
print v(xbgr.mr_n72791968)
print v(xbgr.mr_n72792080)
print v(xbgr.mr_n72792400)
print v(xbgr.mr_n72792512)
print v(xbgr.mr_n72792832)
print v(xbgr.mr_n72792944)
print v(xbgr.mr_n72793264)
print v(xbgr.mr_n72793376)
print v(xbgr.mr_n72793696)
print v(xbgr.mr_n72793808)
print v(xbgr.mr_n72794128)
print v(xbgr.mr_n72794240)
print v(xbgr.mr_n72794560)
print v(xbgr.mr_n72794672)
print v(xbgr.mr_n72794992)
print v(xbgr.mr_n72795104)
print v(xbgr.mr_n72795424)
print v(xbgr.mr_n72795536)
print v(xbgr.mr_n72795856)
print v(xbgr.mr_n72795968)
print v(xbgr.mr_n72796288)
print v(xbgr.mr_n72796400)
print v(xbgr.mr_n72796720)
print v(xbgr.mr_n72796832)
print v(xbgr.mr_n72797152)
print v(xbgr.mr_n72797264)
print v(xbgr.mr_n72797584)
print v(xbgr.mr_n72797696)
print v(xbgr.mr_n72798016)
print v(xbgr.mr_n72798128)
print v(xbgr.mr_n72798448)
print v(xbgr.mr_n72798560)
print v(xbgr.mr_n72798880)
print v(xbgr.mr_n72798992)
print v(xbgr.mr_n72799312)
print v(xbgr.mr_n72799424)
print v(xbgr.mr_n72799744)
print v(xbgr.mr_n72799856)
print v(xbgr.mr_n72800176)
print v(xbgr.mr_n72800288)
print v(xbgr.mr_n72800608)
print v(xbgr.mr_n72800720)
print v(xbgr.mr_n72801040)
print v(xbgr.mr_n72801152)
print v(xbgr.mr_n72801472)
print v(xbgr.mr_n72801584)
print v(xbgr.mr_n72801904)
print v(xbgr.mr_n72802016)
print v(xbgr.mr_n72802336)
print v(xbgr.mr_n72802448)
print v(xbgr.mr_n72802768)
print v(xbgr.mr_n72802880)
print v(xbgr.mr_n72803200)
print v(xbgr.mr_n72803312)
print v(xbgr.mr_n72803632)
print v(xbgr.mr_n72803744)
print v(xbgr.mr_n72804064)
print v(xbgr.mr_n72804176)
print v(xbgr.mr_n72804608)
print v(xbgr.mr_n72805040)
print v(xbgr.mr_n72805472)
print v(xbgr.mr_n72805904)
print v(xbgr.mr_n72806336)
print v(xbgr.mr_n72806768)
print v(xbgr.mr_n72807200)
print v(xbgr.mr_n72807632)
print v(xbgr.mr_n72808064)
print v(xbgr.mr_n72808496)
print v(xbgr.mr_n72808928)
print v(xbgr.mr_n72809360)
print v(xbgr.mr_n72809792)
print v(xbgr.mr_n72810224)
print v(xbgr.mr_n72810656)
print v(xbgr.mr_n72811088)
print v(xbgr.mr_n72811520)
print v(xbgr.mr_n72811952)
print v(xbgr.mr_n72812384)
print v(xbgr.mr_n72812816)
print v(xbgr.mr_n72813248)
print v(xbgr.mr_n72813680)
print v(xbgr.mr_n72814112)
print v(xbgr.mr_n72814544)
print v(xbgr.mr_n72814976)
print v(xbgr.mr_n72815408)
print v(xbgr.mr_n72815840)
print v(xbgr.mr_n72816272)
print v(xbgr.mr_n72816704)
print v(xbgr.mr_n72817136)
print v(xbgr.mr_n72817568)
print v(xbgr.mr_n72818000)
print v(xbgr.mr_n72818432)
print v(xbgr.mr_n72818864)
print v(xbgr.mr_n72819296)
print v(xbgr.mr_n72819728)
print v(xbgr.mr_n72820160)
print v(xbgr.mr_n72820592)
print v(xbgr.mr_n72821024)
print v(xbgr.mr_n72821456)
print v(xbgr.mr_n72821888)
print v(xbgr.mr_n72822320)
print v(xbgr.mr_n72822752)
print v(xbgr.mr_n72823184)
print v(xbgr.mr_n72823616)
print v(xbgr.mr_n72824048)
print v(xbgr.mr_n72824480)
print v(xbgr.mr_n72824912)
print v(xbgr.mr_n72825344)
print v(xbgr.mr_n72825776)
print v(xbgr.mr_n72826208)
print v(xbgr.mr_n72826640)
print v(xbgr.mr_n72827072)
print v(xbgr.mr_n72827504)
print v(xbgr.mr_n72827936)
print v(xbgr.mr_n72828368)
print v(xbgr.mr_n72828800)
print v(xbgr.mr_n72829232)
print v(xbgr.mr_n72829664)
print v(xbgr.mr_n72830096)
print v(xbgr.mr_n72830528)
print v(xbgr.mr_n72830960)
print v(xbgr.mr_n72831392)
print v(xbgr.mr_n72831824)
print v(xbgr.mr_n72832256)
print v(xbgr.mr_n72832688)
print v(xbgr.mr_n72833120)
print v(xbgr.mr_n72833552)
print v(xbgr.mr_n72833984)
print v(xbgr.mr_n72834416)
print v(xbgr.mr_n72834848)
print v(xbgr.mr_n72835280)
print v(xbgr.mr_n72835712)
print v(xbgr.mr_n72836144)
print v(xbgr.mr_n72836576)
print v(xbgr.mr_n72837008)
print v(xbgr.mr_n72837440)
print v(xbgr.mr_n72837872)
print v(xbgr.mr_n72838304)
print v(xbgr.mr_n72838736)
print v(xbgr.mr_n72839168)
print v(xbgr.mr_n72839600)
print v(xbgr.mr_n72840032)
print v(xbgr.mr_n72840464)
print v(xbgr.mr_n72840896)
print v(xbgr.mr_n72841328)
print v(xbgr.mr_n72841760)
print v(xbgr.mr_n72842192)
print v(xbgr.mr_n72842624)
print v(xbgr.mr_n72843056)
print v(xbgr.mr_n72843488)
print v(xbgr.mr_n72843920)
print v(xbgr.mr_n72844352)
print v(xbgr.mr_n72844784)
print v(xbgr.mr_n72845216)
print v(xbgr.mr_n72845648)
print v(xbgr.mr_n72846080)
print v(xbgr.mr_n72846512)
print v(xbgr.mr_n72846944)
print v(xbgr.mr_n72847376)
print v(xbgr.mr_n72847808)
print v(xbgr.mr_n72848240)
print v(xbgr.mr_n72848672)
print v(xbgr.mr_n72849104)
print v(xbgr.mr_n72849536)
print v(xbgr.mr_n72849968)
print v(xbgr.mr_n72850400)
print v(xbgr.mr_n72850832)
print v(xbgr.mr_n72851264)
print v(xbgr.mr_n72851696)
print v(xbgr.mr_n72852128)
print v(xbgr.mr_n72852560)
print v(xbgr.mr_n72852992)
print v(xbgr.mr_n72853424)
print v(xbgr.mr_n72853856)
print v(xbgr.mr_n72854288)
print v(xbgr.mr_n72854720)
print v(xbgr.mr_n72855152)
print v(xbgr.mr_n72855584)
print v(xbgr.mr_n72856016)
print v(xbgr.mr_n72856448)
print v(xbgr.mr_n72856880)
print v(xbgr.mr_n72857312)
print v(xbgr.mr_n72857744)
print v(xbgr.mr_n72858176)
print v(xbgr.mr_n72858608)
print v(xbgr.mr_n72859040)
print v(xbgr.mr_n72859472)
print v(xbgr.mr_n72859904)
print v(xbgr.mr_n72860336)
print v(xbgr.mr_n72860768)
print v(xbgr.mr_n72861200)
print v(xbgr.mr_n72861632)
print v(xbgr.mr_n72862064)
print v(xbgr.mr_n72862496)
print v(xbgr.mr_n72862928)
print v(xbgr.mr_n72863360)
print v(xbgr.mr_n72863792)
print v(xbgr.mr_n72864224)
print v(xbgr.mr_n72864656)
print v(xbgr.mr_n72865088)
print v(xbgr.mr_n72865520)
print v(xbgr.mr_n72865952)
print v(xbgr.mr_n72866384)
print v(xbgr.mr_n72866816)
print v(xbgr.mr_n72867248)
print v(xbgr.mr_n72867680)
print v(xbgr.mr_n72868112)
print v(xbgr.mr_n72868544)
print v(xbgr.mr_n72868976)
print v(xbgr.mr_n72869408)
print v(xbgr.mr_n72869840)
print v(xbgr.mr_n72870272)
print v(xbgr.mr_n72870704)
print v(xbgr.mr_n72871136)
print v(xbgr.mr_n72871568)
print v(xbgr.mr_n72872000)
print v(xbgr.mr_n72872432)
print v(xbgr.mr_n72872864)
print v(xbgr.mr_n72873296)
print v(xbgr.mr_n72873728)
print v(xbgr.mr_n72874160)
print v(xbgr.mr_n72874592)
print v(xbgr.mr_n72875024)
print v(xbgr.mr_n72875456)
print v(xbgr.mr_n72875888)
print v(xbgr.mr_n72876320)
print v(xbgr.mr_n72876752)
print v(xbgr.mr_n72877184)
print v(xbgr.mr_n72877616)
print v(xbgr.mr_n72878048)
print v(xbgr.mr_n72878480)
print v(xbgr.mr_n72878912)
print v(xbgr.mr_n72879344)
print v(xbgr.mr_n72879776)
print v(xbgr.mr_n72880208)
print v(xbgr.mr_n72880640)
print v(xbgr.mr_n72881072)
print v(xbgr.mr_n72881504)
print v(xbgr.mr_n72881936)
print v(xbgr.mr_n72882368)
print v(xbgr.mr_n72882800)
print v(xbgr.mr_n72883232)
print v(xbgr.mr_n72883664)
print v(xbgr.mr_n72884096)
print v(xbgr.mr_n72884528)
print v(xbgr.mr_n72884960)
print v(xbgr.mr_n72885392)
print v(xbgr.mr_n72885824)
print v(xbgr.mr_n72886256)
print v(xbgr.mr_n72886688)
print v(xbgr.mr_n72887120)
print v(xbgr.mr_n72887552)
print v(xbgr.mr_n72887984)
print v(xbgr.mr_n72888416)
print v(xbgr.mr_n72888848)
print v(xbgr.mr_n72889280)
print v(xbgr.mr_n72889712)
print v(xbgr.mr_n72890144)
print v(xbgr.mr_n72890576)
print v(xbgr.mr_n72891008)
print v(xbgr.mr_n72891440)
print v(xbgr.mr_n72891872)
print v(xbgr.mr_n72892304)
print v(xbgr.mr_n72892736)
print v(xbgr.mr_n72893168)
print v(xbgr.mr_n72893600)
print v(xbgr.mr_n72894032)
print v(xbgr.mr_n72894464)
print v(xbgr.mr_n72894896)
print v(xbgr.mr_n72895328)
print v(xbgr.mr_n72895760)
print v(xbgr.mr_n72896192)
print v(xbgr.mr_n72896624)
print v(xbgr.mr_n72896944)
print v(xbgr.mr_n72897056)
print v(xbgr.mr_n72897376)
print v(xbgr.mr_n72897488)
print v(xbgr.mr_n72897808)
print v(xbgr.mr_n72897920)
print v(xbgr.mr_n72898240)
print v(xbgr.mr_n72898352)
print v(xbgr.mr_n72898672)
print v(xbgr.mr_n72898784)
print v(xbgr.mr_n72899104)
print v(xbgr.mr_n72899216)
print v(xbgr.mr_n72899536)
print v(xbgr.mr_n72899648)
print v(xbgr.mr_n72899968)
print v(xbgr.mr_n72900080)
print v(xbgr.mr_n72900400)
print v(xbgr.mr_n72900512)
print v(xbgr.mr_n72900832)
print v(xbgr.mr_n72900944)
print v(xbgr.mr_n72901264)
print v(xbgr.mr_n72901376)
print v(xbgr.mr_n72901696)
print v(xbgr.mr_n72901808)
print v(xbgr.mr_n72902128)
print v(xbgr.mr_n72902240)
print v(xbgr.mr_n72902560)
print v(xbgr.mr_n72902672)
print v(xbgr.mr_n72902992)
print v(xbgr.mr_n72903104)
print v(xbgr.mr_n72903424)
print v(xbgr.mr_n72903536)
print v(xbgr.mr_n72903856)
print v(xbgr.mr_n72903968)
print v(xbgr.mr_n72904288)
print v(xbgr.mr_n72904400)
print v(xbgr.mr_n72904720)
print v(xbgr.mr_n72904832)
print v(xbgr.mr_n72905152)
print v(xbgr.mr_n72905264)
print v(xbgr.mr_n72905584)
print v(xbgr.mr_n72905696)
print v(xbgr.mr_n72906016)
print v(xbgr.mr_n72906128)
print v(xbgr.mr_n72906448)
print v(xbgr.mr_n72906560)
print v(xbgr.mr_n72906880)
print v(xbgr.mr_n72906992)
print v(xbgr.mr_n72907312)
print v(xbgr.mr_n72907424)
print v(xbgr.mr_n72907744)
print v(xbgr.mr_n72907856)
print v(xbgr.mr_n72908176)
print v(xbgr.mr_n72908288)
print v(xbgr.mr_n72908608)
print v(xbgr.mr_n72908720)
print v(xbgr.mr_n72909040)
print v(xbgr.mr_n72909152)
print v(xbgr.mr_n72909472)
print v(xbgr.mr_n72909584)
print v(xbgr.mr_n72909904)
print v(xbgr.mr_n72910016)
print v(xbgr.mr_n72910336)
print v(xbgr.mr_n72910448)
print v(xbgr.mr_n72910768)
print v(xbgr.mr_n72910880)
print v(xbgr.mr_n72911200)
print v(xbgr.mr_n72911312)
print v(xbgr.mr_n72911632)
print v(xbgr.mr_n72911744)
print v(xbgr.mr_n72912064)
print v(xbgr.mr_n72912176)
print v(xbgr.mr_n72912496)
print v(xbgr.mr_n72912608)
print v(xbgr.mr_n72912928)
print v(xbgr.mr_n72913040)
print v(xbgr.mr_n72913360)
print v(xbgr.mr_n72913472)
print v(xbgr.mr_n72913792)
print v(xbgr.mr_n72913904)
print v(xbgr.mr_n72914224)
print v(xbgr.mr_n72914336)
print v(xbgr.mr_n72914656)
print v(xbgr.mr_n72914768)
print v(xbgr.mr_n72915088)
print v(xbgr.mr_n72915200)
print v(xbgr.mr_n72915520)
print v(xbgr.mr_n72915632)
print v(xbgr.mr_n72915952)
print v(xbgr.mr_n72916064)
print v(xbgr.mr_n72916384)
print v(xbgr.mr_n72916496)
print v(xbgr.mr_n72916816)
print v(xbgr.mr_n72916928)
print v(xbgr.mr_n72917248)
print v(xbgr.mr_n72917360)
print v(xbgr.mr_n72917680)
print v(xbgr.mr_n72917792)
print v(xbgr.mr_n72918112)
print v(xbgr.mr_n72918224)
print v(xbgr.mr_n72918544)
print v(xbgr.mr_n72918656)
print v(xbgr.mr_n72918976)
print v(xbgr.mr_n72919088)
print v(xbgr.mr_n72919408)
print v(xbgr.mr_n72919520)
print v(xbgr.mr_n72919840)
print v(xbgr.mr_n72919952)
print v(xbgr.mr_n72920272)
print v(xbgr.mr_n72920384)
print v(xbgr.mr_n72920704)
print v(xbgr.mr_n72920816)
print v(xbgr.mr_n72921136)
print v(xbgr.mr_n72921248)
print v(xbgr.mr_n72921568)
print v(xbgr.mr_n72921680)
print v(xbgr.mr_n72922000)
print v(xbgr.mr_n72922112)
print v(xbgr.mr_n72922432)
print v(xbgr.mr_n72922544)
print v(xbgr.mr_n72922864)
print v(xbgr.mr_n72922976)
print v(xbgr.mr_n72923296)
print v(xbgr.mr_n72923408)
print v(xbgr.mr_n72923728)
print v(xbgr.mr_n72923840)
print v(xbgr.mr_n72924160)
print v(xbgr.mr_n72924272)
print v(xbgr.mr_n72924592)
print v(xbgr.mr_n72924704)
print v(xbgr.mr_n72925024)
print v(xbgr.mr_n72925136)
print v(xbgr.mr_n72925456)
print v(xbgr.mr_n72925568)
print v(xbgr.mr_n72925888)
print v(xbgr.mr_n72926000)
print v(xbgr.mr_n72926320)
print v(xbgr.mr_n72926432)
print v(xbgr.mr_n72926752)
print v(xbgr.mr_n72926864)
print v(xbgr.mr_n72927184)
print v(xbgr.mr_n72927296)
print v(xbgr.mr_n72927616)
print v(xbgr.mr_n72927728)
print v(xbgr.mr_n72928048)
print v(xbgr.mr_n72928160)
print v(xbgr.mr_n72928480)
print v(xbgr.mr_n72928592)
print v(xbgr.mr_n72928912)
print v(xbgr.mr_n72929024)
print v(xbgr.mr_n72929344)
print v(xbgr.mr_n72929456)
print v(xbgr.mr_n72929776)
print v(xbgr.mr_n72929888)
print v(xbgr.mr_n72930208)
print v(xbgr.mr_n72930320)
print v(xbgr.mr_n72930640)
print v(xbgr.mr_n72930752)
print v(xbgr.mr_n72931072)
print v(xbgr.mr_n72931184)
print v(xbgr.mr_n72931504)
print v(xbgr.mr_n72931616)
print v(xbgr.mr_n72931936)
print v(xbgr.mr_n72932048)
print v(xbgr.mr_n72932368)
print v(xbgr.mr_n72932480)
print v(xbgr.mr_n72932800)
print v(xbgr.mr_n72932912)
print v(xbgr.mr_n72933232)
print v(xbgr.mr_n72933344)
print v(xbgr.mr_n72933664)
print v(xbgr.mr_n72933776)
print v(xbgr.mr_n72934096)
print v(xbgr.mr_n72934208)
print v(xbgr.mr_n72934528)
print v(xbgr.mr_n72934640)
print v(xbgr.mr_n72934960)
print v(xbgr.mr_n72935072)
print v(xbgr.mr_n72935392)
print v(xbgr.mr_n72935504)
print v(xbgr.mr_n72935824)
print v(xbgr.mr_n72935936)
print v(xbgr.mr_n72936256)
print v(xbgr.mr_n72936368)
print v(xbgr.mr_n72936688)
print v(xbgr.mr_n72936800)
print v(xbgr.mr_n72937120)
print v(xbgr.mr_n72937232)
print v(xbgr.mr_n72937552)
print v(xbgr.mr_n72937664)
print v(xbgr.mr_n72937984)
print v(xbgr.mr_n72938096)
print v(xbgr.mr_n72938416)
print v(xbgr.mr_n72938528)
print v(xbgr.mr_n72938848)
print v(xbgr.mr_n72938960)
print v(xbgr.mr_n72939280)
print v(xbgr.mr_n72939392)
print v(xbgr.mr_n72939712)
print v(xbgr.mr_n72939824)
print v(xbgr.mr_n72940144)
print v(xbgr.mr_n72940256)
print v(xbgr.mr_n72940576)
print v(xbgr.mr_n72940688)
print v(xbgr.mr_n72941008)
print v(xbgr.mr_n72941120)
print v(xbgr.mr_n72941440)
print v(xbgr.mr_n72941552)
print v(xbgr.mr_n72941872)
print v(xbgr.mr_n72941984)
print v(xbgr.mr_n72942304)
print v(xbgr.mr_n72942416)
print v(xbgr.mr_n72942736)
print v(xbgr.mr_n72942848)
print v(xbgr.mr_n72943168)
print v(xbgr.mr_n72943280)
print v(xbgr.mr_n72943600)
print v(xbgr.mr_n72943712)
print v(xbgr.mr_n72944032)
print v(xbgr.mr_n72944144)
print v(xbgr.mr_n72944464)
print v(xbgr.mr_n72944576)
print v(xbgr.mr_n72944896)
print v(xbgr.mr_n72945008)
print v(xbgr.mr_n72945328)
print v(xbgr.mr_n72945440)
print v(xbgr.mr_n72945760)
print v(xbgr.mr_n72945872)
print v(xbgr.mr_n72946192)
print v(xbgr.mr_n72946304)
print v(xbgr.mr_n72946624)
print v(xbgr.mr_n72946736)
print v(xbgr.mr_n72947056)
print v(xbgr.mr_n72947168)
print v(xbgr.mr_n72947488)
print v(xbgr.mr_n72947600)
print v(xbgr.mr_n72947920)
print v(xbgr.mr_n72948032)
print v(xbgr.mr_n72948352)
print v(xbgr.mr_n72948464)
print v(xbgr.mr_n72948784)
print v(xbgr.mr_n72948896)
print v(xbgr.mr_n72949216)
print v(xbgr.mr_n72949328)
print v(xbgr.mr_n72949648)
print v(xbgr.mr_n72949760)
print v(xbgr.mr_n72950080)
print v(xbgr.mr_n72950192)
print v(xbgr.mr_n72950512)
print v(xbgr.mr_n72950624)
print v(xbgr.mr_n72950944)
print v(xbgr.mr_n72951056)
print v(xbgr.mr_n72951376)
print v(xbgr.mr_n72951488)
print v(xbgr.mr_n72951808)
print v(xbgr.mr_n72951920)
print v(xbgr.mr_n72952240)
print v(xbgr.mr_n72952352)
print v(xbgr.mr_n72952672)
print v(xbgr.mr_n72952784)
print v(xbgr.mr_n72953104)
print v(xbgr.mr_n72953216)
print v(xbgr.mr_n72953536)
print v(xbgr.mr_n72953648)
print v(xbgr.mr_n72953968)
print v(xbgr.mr_n72954080)
print v(xbgr.mr_n72954400)
print v(xbgr.mr_n72954512)
print v(xbgr.mr_n72954832)
print v(xbgr.mr_n72954944)
print v(xbgr.mr_n72955264)
print v(xbgr.mr_n72955376)
print v(xbgr.mr_n72955696)
print v(xbgr.mr_n72955808)
print v(xbgr.mr_n72956128)
print v(xbgr.mr_n72956240)
print v(xbgr.mr_n72956560)
print v(xbgr.mr_n72956672)
print v(xbgr.mr_n72956992)
print v(xbgr.mr_n72957104)
print v(xbgr.mr_n72957424)
print v(xbgr.mr_n72957536)
print v(xbgr.mr_n72957856)
print v(xbgr.mr_n72957968)
print v(xbgr.mr_n72958288)
print v(xbgr.mr_n72958400)
print v(xbgr.mr_n72958720)
print v(xbgr.mr_n72958832)
print v(xbgr.mr_n72959152)
print v(xbgr.mr_n72959264)
print v(xbgr.mr_n72959584)
print v(xbgr.mr_n72959696)
print v(xbgr.mr_n72960016)
print v(xbgr.mr_n72960128)
print v(xbgr.mr_n72960448)
print v(xbgr.mr_n72960560)
print v(xbgr.mr_n72960880)
print v(xbgr.mr_n72960992)
print v(xbgr.mr_n72961312)
print v(xbgr.mr_n72961424)
print v(xbgr.mr_n72961744)
print v(xbgr.mr_n72961856)
print v(xbgr.mr_n72962176)
print v(xbgr.mr_n72962288)
print v(xbgr.mr_n72962608)
print v(xbgr.mr_n72962720)
print v(xbgr.mr_n72963040)
print v(xbgr.mr_n72963152)
print v(xbgr.mr_n72963472)
print v(xbgr.mr_n72963584)
print v(xbgr.mr_n72963904)
print v(xbgr.mr_n72964016)
print v(xbgr.mr_n72964336)
print v(xbgr.mr_n72964448)
print v(xbgr.mr_n72964768)
print v(xbgr.mr_n72964880)
print v(xbgr.mr_n72965200)
print v(xbgr.mr_n72965312)
print v(xbgr.mr_n72965632)
print v(xbgr.mr_n72965744)
print v(xbgr.mr_n72966064)
print v(xbgr.mr_n72966176)
print v(xbgr.mr_n72966496)
print v(xbgr.mr_n72966608)
print v(xbgr.mr_n72966928)
print v(xbgr.mr_n72967040)
print v(xbgr.mr_n72967360)
print v(xbgr.mr_n72967472)
print v(xbgr.mr_n72967792)
print v(xbgr.mr_n72967904)
print v(xbgr.mr_n72968224)
print v(xbgr.mr_n72968336)
print v(xbgr.mr_n72968656)
print v(xbgr.mr_n72968768)
print v(xbgr.mr_n72969088)
print v(xbgr.mr_n72969200)
print v(xbgr.mr_n72969520)
print v(xbgr.mr_n72969632)
print v(xbgr.mr_n72969952)
print v(xbgr.mr_n72970064)
print v(xbgr.mr_n72970384)
print v(xbgr.mr_n72970496)
print v(xbgr.mr_n72970816)
print v(xbgr.mr_n72970928)
print v(xbgr.mr_n72971248)
print v(xbgr.mr_n72971360)
print v(xbgr.mr_n72971680)
print v(xbgr.mr_n72971792)
print v(xbgr.mr_n72972112)
print v(xbgr.mr_n72972224)
print v(xbgr.mr_n72972544)
print v(xbgr.mr_n72972656)
print v(xbgr.mr_n72972976)
print v(xbgr.mr_n72973088)
print v(xbgr.mr_n72973408)
print v(xbgr.mr_n72973520)
print v(xbgr.mr_n72973840)
print v(xbgr.mr_n72973952)
print v(xbgr.mr_n72974272)
print v(xbgr.mr_n72974384)
print v(xbgr.mr_n72974704)
print v(xbgr.mr_n72974816)
print v(xbgr.mr_n72975136)
print v(xbgr.mr_n72975248)
print v(xbgr.mr_n72975568)
print v(xbgr.mr_n72975680)
print v(xbgr.mr_n72976000)
print v(xbgr.mr_n72976112)
print v(xbgr.mr_n72976432)
print v(xbgr.mr_n72976544)
print v(xbgr.mr_n72976864)
print v(xbgr.mr_n72976976)
print v(xbgr.mr_n72977296)
print v(xbgr.mr_n72977408)
print v(xbgr.mr_n72977728)
print v(xbgr.mr_n72977840)
print v(xbgr.mr_n72978160)
print v(xbgr.mr_n72978272)
print v(xbgr.mr_n72978592)
print v(xbgr.mr_n72978704)
print v(xbgr.mr_n72979024)
print v(xbgr.mr_n72979136)
print v(xbgr.mr_n72979456)
print v(xbgr.mr_n72979568)
print v(xbgr.mr_n72979888)
print v(xbgr.mr_n72980000)
print v(xbgr.mr_n72980320)
print v(xbgr.mr_n72980432)
print v(xbgr.mr_n72980752)
print v(xbgr.mr_n72980864)
print v(xbgr.mr_n72981184)
print v(xbgr.mr_n72981296)
print v(xbgr.mr_n72981616)
print v(xbgr.mr_n72981728)
print v(xbgr.mr_n72982048)
print v(xbgr.mr_n72982160)
print v(xbgr.mr_n72982480)
print v(xbgr.mr_n72982592)
print v(xbgr.mr_n72982912)
print v(xbgr.mr_n72983024)
print v(xbgr.mr_n72983344)
print v(xbgr.mr_n72983456)
print v(xbgr.mr_n72983776)
print v(xbgr.mr_n72983888)
print v(xbgr.mr_n72984208)
print v(xbgr.mr_n72984320)
print v(xbgr.mr_n72984640)
print v(xbgr.mr_n72984752)
print v(xbgr.mr_n72985072)
print v(xbgr.mr_n72985184)
print v(xbgr.mr_n72985504)
print v(xbgr.mr_n72985616)
print v(xbgr.mr_n72985936)
print v(xbgr.mr_n72986048)
print v(xbgr.mr_n72986368)
print v(xbgr.mr_n72986480)
print v(xbgr.mr_n72986800)
print v(xbgr.mr_n72986912)
print v(xbgr.mr_n72987232)
print v(xbgr.mr_n72987344)
print v(xbgr.mr_n72987664)
print v(xbgr.mr_n72987776)
print v(xbgr.mr_n72988096)
print v(xbgr.mr_n72988208)
print v(xbgr.mr_n72988528)
print v(xbgr.mr_n72988640)
print v(xbgr.mr_n72988960)
print v(xbgr.mr_n72989072)
print v(xbgr.mr_n72989392)
print v(xbgr.mr_n72989504)
print v(xbgr.mr_n72989824)
print v(xbgr.mr_n72989936)
print v(xbgr.mr_n72990256)
print v(xbgr.mr_n72990368)
print v(xbgr.mr_n72990688)
print v(xbgr.mr_n72990800)
print v(xbgr.mr_n72991664)
print v(xbgr.mr_n72992096)
print v(xbgr.mr_n72992528)
print v(xbgr.mr_n72992960)
print v(xbgr.mr_n72993392)
print v(xbgr.mr_n72993824)
print v(xbgr.mr_n72994256)
print v(xbgr.mr_n72994688)
print v(xbgr.mr_n72995120)
print v(xbgr.mr_n72995552)
print v(xbgr.mr_n72995984)
print v(xbgr.mr_n72996416)
print v(xbgr.mr_n72996848)
print v(xbgr.mr_n72997280)
print v(xbgr.mr_n72997712)
print v(xbgr.mr_n72998144)
print v(xbgr.mr_n72998576)
print v(xbgr.mr_n72999008)
print v(xbgr.mr_n72999440)
print v(xbgr.mr_n72999872)
print v(xbgr.mr_n73000304)
print v(xbgr.mr_n73000736)
print v(xbgr.mr_n73001168)
print v(xbgr.mr_n73001600)
print v(xbgr.mr_n73003760)
print v(xbgr.mr_n73004192)
print v(xbgr.mr_n73004624)
print v(xbgr.mr_n73005056)
print v(xbgr.mr_n73005488)
print v(xbgr.mr_n73005920)
print v(xbgr.mr_n73006352)
print v(xbgr.mr_n73006784)
print v(xbgr.mr_n73007216)
print v(xbgr.mr_n73007648)
print v(xbgr.mr_n73008080)
print v(xbgr.mr_n73008512)
print v(xbgr.mr_n73008944)
print v(xbgr.mr_n73009376)
print v(xbgr.mr_n73009808)
print v(xbgr.mr_n73010240)
print v(xbgr.mr_n73010672)
print v(xbgr.mr_n73011104)
print v(xbgr.mr_n73011536)
print v(xbgr.mr_n73011968)
print v(xbgr.mr_n73012400)
print v(xbgr.mr_n73012832)
print v(xbgr.mr_n73013264)
print v(xbgr.mr_n73013696)
print v(xbgr.mr_n73017584)
print v(xbgr.mr_n73018016)
print v(xbgr.mr_n73018448)
print v(xbgr.mr_n73018880)
print v(xbgr.mr_n73019312)
print v(xbgr.mr_n73019744)
print v(xbgr.mr_n73020176)
print v(xbgr.mr_n73020608)
print v(xbgr.mr_n73021040)
print v(xbgr.mr_n73021472)
print v(xbgr.mr_n73021904)
print v(xbgr.mr_n73022336)
print v(xbgr.mr_n73022768)
print v(xbgr.mr_n73023200)
print v(xbgr.mr_n73023632)
print v(xbgr.mr_n73024928)
print v(xbgr.mr_n73025360)
print v(xbgr.mr_n73025792)
print v(xbgr.mr_n73026224)
print v(xbgr.mr_n73026656)
print v(xbgr.mr_n73027088)
print v(xbgr.mr_n73027520)
print v(xbgr.mr_n73027952)
print v(xbgr.mr_n73028384)
print v(xbgr.mr_n73028816)
print v(xbgr.mr_n73030112)
print v(xbgr.mr_n73030544)
print v(xbgr.mr_n73030976)
print v(xbgr.mr_n73031408)
print v(xbgr.mr_n73031840)
print v(xbgr.mr_n73032272)
print v(xbgr.mr_n73032704)
print v(xbgr.mr_n73033136)
print v(xbgr.mr_n73033456)
print v(xbgr.mr_n73033568)
print v(xbgr.mr_n73033888)
print v(xbgr.mr_n73034000)
print v(xbgr.mr_n73034320)
print v(xbgr.mr_n73034432)
print v(xbgr.mr_n73034752)
print v(xbgr.mr_n73034864)
print v(xbgr.mr_n73035184)
print v(xbgr.mr_n73035296)
print v(xbgr.mr_n73035616)
print v(xbgr.mr_n73035728)
print v(xbgr.mr_n73036048)
print v(xbgr.mr_n73036160)
print v(xbgr.mr_n73036480)
print v(xbgr.mr_n73036592)
print v(xbgr.mr_n73036912)
print v(xbgr.mr_n73037024)
print v(xbgr.mr_n73037344)
print v(xbgr.mr_n73037456)
print v(xbgr.mr_n73037776)
print v(xbgr.mr_n73037888)
print v(xbgr.mr_n73038208)
print v(xbgr.mr_n73038320)
print v(xbgr.mr_n73038640)
print v(xbgr.mr_n73038752)
print v(xbgr.mr_n73039072)
print v(xbgr.mr_n73039184)
print v(xbgr.mr_n73039504)
print v(xbgr.mr_n73039616)
print v(xbgr.mr_n73039936)
print v(xbgr.mr_n73040048)
print v(xbgr.mr_n73040368)
print v(xbgr.mr_n73040480)
print v(xbgr.mr_n73040800)
print v(xbgr.mr_n73040912)
print v(xbgr.mr_n73041232)
print v(xbgr.mr_n73041344)
print v(xbgr.mr_n73041664)
print v(xbgr.mr_n73041776)
print v(xbgr.mr_n73042096)
print v(xbgr.mr_n73042208)
print v(xbgr.mr_n73042528)
print v(xbgr.mr_n73042640)
print v(xbgr.mr_n73042960)
print v(xbgr.mr_n73043072)
print v(xbgr.mr_n73043392)
print v(xbgr.mr_n73043504)
print v(xbgr.mr_n73043824)
print v(xbgr.mr_n73043936)
print v(xbgr.mr_n73044256)
print v(xbgr.mr_n73044368)
print v(xbgr.mr_n73044688)
print v(xbgr.mr_n73044800)
print v(xbgr.mr_n73045120)
print v(xbgr.mr_n73045232)
print v(xbgr.mr_n73045552)
print v(xbgr.mr_n73045664)
print v(xbgr.mr_n73045984)
print v(xbgr.mr_n73046096)
print v(xbgr.mr_n73046416)
print v(xbgr.mr_n73046528)
print v(xbgr.mr_n73046848)
print v(xbgr.mr_n73046960)
print v(xbgr.mr_n73047280)
print v(xbgr.mr_n73047392)
print v(xbgr.mr_n73047712)
print v(xbgr.mr_n73047824)
print v(xbgr.mr_n73048144)
print v(xbgr.mr_n73048256)
print v(xbgr.mr_n73048576)
print v(xbgr.mr_n73048688)
print v(xbgr.mr_n73049008)
print v(xbgr.mr_n73049120)
print v(xbgr.mr_n73049440)
print v(xbgr.mr_n73049552)
print v(xbgr.mr_n73049872)
print v(xbgr.mr_n73049984)
print v(xbgr.mr_n73050304)
print v(xbgr.mr_n73050416)
print v(xbgr.mr_n73050736)
print v(xbgr.mr_n73050848)
print v(xbgr.mr_n73051168)
print v(xbgr.mr_n73051280)
print v(xbgr.mr_n73051600)
print v(xbgr.mr_n73051712)
print v(xbgr.mr_n73052032)
print v(xbgr.mr_n73052144)
print v(xbgr.mr_n73052464)
print v(xbgr.mr_n73052576)
print v(xbgr.mr_n73052896)
print v(xbgr.mr_n73053008)
print v(xbgr.mr_n73053328)
print v(xbgr.mr_n73053440)
print v(xbgr.mr_n73053760)
print v(xbgr.mr_n73053872)
print v(xbgr.mr_n73054192)
print v(xbgr.mr_n73054304)
print v(xbgr.mr_n73054624)
print v(xbgr.mr_n73054736)
print v(xbgr.mr_n73055056)
print v(xbgr.mr_n73055168)
print v(xbgr.mr_n73055488)
print v(xbgr.mr_n73055600)
print v(xbgr.mr_n73055920)
print v(xbgr.mr_n73056032)
print v(xbgr.mr_n73056352)
print v(xbgr.mr_n73056464)
print v(xbgr.mr_n73056784)
print v(xbgr.mr_n73056896)
print v(xbgr.mr_n73057216)
print v(xbgr.mr_n73057328)
print v(xbgr.mr_n73057648)
print v(xbgr.mr_n73057760)
print v(xbgr.mr_n73058080)
print v(xbgr.mr_n73058192)
print v(xbgr.mr_n73058512)
print v(xbgr.mr_n73058624)
print v(xbgr.mr_n73058944)
print v(xbgr.mr_n73059056)
print v(xbgr.mr_n73059376)
print v(xbgr.mr_n73059488)
print v(xbgr.mr_n73059808)
print v(xbgr.mr_n73059920)
print v(xbgr.mr_n73060240)
print v(xbgr.mr_n73060352)
print v(xbgr.mr_n73060672)
print v(xbgr.mr_n73060784)
print v(xbgr.mr_n73061104)
print v(xbgr.mr_n73061216)
print v(xbgr.mr_n73061536)
print v(xbgr.mr_n73061648)
print v(xbgr.mr_n73061968)
print v(xbgr.mr_n73062080)
print v(xbgr.mr_n73062400)
print v(xbgr.mr_n73062512)
print v(xbgr.mr_n73062832)
print v(xbgr.mr_n73062944)
print v(xbgr.mr_n73063264)
print v(xbgr.mr_n73063376)
print v(xbgr.mr_n73063696)
print v(xbgr.mr_n73063808)
print v(xbgr.mr_n73064128)
print v(xbgr.mr_n73064240)
print v(xbgr.mr_n73064560)
print v(xbgr.mr_n73064672)
print v(xbgr.mr_n73064992)
print v(xbgr.mr_n73065104)
print v(xbgr.mr_n73065424)
print v(xbgr.mr_n73065536)
print v(xbgr.mr_n73065856)
print v(xbgr.mr_n73065968)
print v(xbgr.mr_n73066288)
print v(xbgr.mr_n73066400)
print v(xbgr.mr_n73066720)
print v(xbgr.mr_n73066832)
print v(xbgr.mr_n73067152)
print v(xbgr.mr_n73067264)
print v(xbgr.mr_n73067584)
print v(xbgr.mr_n73067696)
print v(xbgr.mr_n73068016)
print v(xbgr.mr_n73068128)
print v(xbgr.mr_n73068448)
print v(xbgr.mr_n73068560)
print v(xbgr.mr_n73068880)
print v(xbgr.mr_n73068992)
print v(xbgr.mr_n73069312)
print v(xbgr.mr_n73069424)
print v(xbgr.mr_n73069744)
print v(xbgr.mr_n73069856)
print v(xbgr.mr_n73070176)
print v(xbgr.mr_n73070288)
print v(xbgr.mr_n73070608)
print v(xbgr.mr_n73070720)
print v(xbgr.mr_n73071040)
print v(xbgr.mr_n73071152)
print v(xbgr.mr_n73071472)
print v(xbgr.mr_n73071584)
print v(xbgr.mr_n73071904)
print v(xbgr.mr_n73072016)
print v(xbgr.mr_n73072336)
print v(xbgr.mr_n73072448)
print v(xbgr.mr_n73072768)
print v(xbgr.mr_n73072880)
print v(xbgr.mr_n73073200)
print v(xbgr.mr_n73073312)
print v(xbgr.mr_n73073632)
print v(xbgr.mr_n73073744)
print v(xbgr.mr_n73074064)
print v(xbgr.mr_n73074176)
print v(xbgr.mr_n73074496)
print v(xbgr.mr_n73074608)
print v(xbgr.mr_n73074928)
print v(xbgr.mr_n73075040)
print v(xbgr.mr_n73075360)
print v(xbgr.mr_n73075472)
print v(xbgr.mr_n73075792)
print v(xbgr.mr_n73075904)
print v(xbgr.mr_n73076224)
print v(xbgr.mr_n73076336)
print v(xbgr.mr_n73076656)
print v(xbgr.mr_n73076768)
print v(xbgr.mr_n73077088)
print v(xbgr.mr_n73077200)
print v(xbgr.mr_n73077520)
print v(xbgr.mr_n73077632)
print v(xbgr.mr_n73077952)
print v(xbgr.mr_n73078064)
print v(xbgr.mr_n73078384)
print v(xbgr.mr_n73078496)
print v(xbgr.mr_n73078816)
print v(xbgr.mr_n73078928)
print v(xbgr.mr_n73079248)
print v(xbgr.mr_n73079360)
print v(xbgr.mr_n73079680)
print v(xbgr.mr_n73079792)
print v(xbgr.mr_n73080112)
print v(xbgr.mr_n73080544)
print v(xbgr.mr_n73080656)
print v(xbgr.mr_n73080976)
print v(xbgr.mr_n73081088)
print v(xbgr.mr_n73081408)
print v(xbgr.mr_n73081520)
print v(xbgr.mr_n73081840)
print v(xbgr.mr_n73081952)
print v(xbgr.mr_n73082272)
print v(xbgr.mr_n73082384)
print v(xbgr.mr_n73082704)
print v(xbgr.mr_n73082816)
print v(xbgr.mr_n73083136)
print v(xbgr.mr_n73083248)
print v(xbgr.mr_n73083568)
print v(xbgr.mr_n73083680)
print v(xbgr.mr_n73084000)
print v(xbgr.mr_n73084112)
print v(xbgr.mr_n73084432)
print v(xbgr.mr_n73084544)
print v(xbgr.mr_n73084864)
print v(xbgr.mr_n73084976)
print v(xbgr.mr_n73085296)
print v(xbgr.mr_n73085408)
print v(xbgr.mr_n73085728)
print v(xbgr.mr_n73085840)
print v(xbgr.mr_n73086160)
print v(xbgr.mr_n73086272)
print v(xbgr.mr_n73086592)
print v(xbgr.mr_n73086704)
print v(xbgr.mr_n73087024)
print v(xbgr.mr_n73087136)
print v(xbgr.mr_n73087456)
print v(xbgr.mr_n73087568)
print v(xbgr.mr_n73087888)
print v(xbgr.mr_n73088000)
print v(xbgr.mr_n73088320)
print v(xbgr.mr_n73088432)
print v(xbgr.mr_n73088752)
print v(xbgr.mr_n73088864)
print v(xbgr.mr_n73089184)
print v(xbgr.mr_n73089296)
print v(xbgr.mr_n73089616)
print v(xbgr.mr_n73089728)
print v(xbgr.mr_n73090048)
print v(xbgr.mr_n73090160)
print v(xbgr.mr_n73090480)
print v(xbgr.mr_n73090592)
print v(xbgr.mr_n73090912)
print v(xbgr.mr_n73091024)
print v(xbgr.mr_n73091344)
print v(xbgr.mr_n73091456)
print v(xbgr.mr_n73091776)
print v(xbgr.mr_n73091888)
print v(xbgr.mr_n73092208)
print v(xbgr.mr_n73092320)
print v(xbgr.mr_n73092640)
print v(xbgr.mr_n73092752)
print v(xbgr.mr_n73093072)
print v(xbgr.mr_n73093184)
print v(xbgr.mr_n73093504)
print v(xbgr.mr_n73093616)
print v(xbgr.mr_n73093936)
print v(xbgr.mr_n73094048)
print v(xbgr.mr_n73094368)
print v(xbgr.mr_n73094480)
print v(xbgr.mr_n73094800)
print v(xbgr.mr_n73094912)
print v(xbgr.mr_n73095232)
print v(xbgr.mr_n73095344)
print v(xbgr.mr_n73095664)
print v(xbgr.mr_n73096096)
print v(xbgr.mr_n73096208)
print v(xbgr.mr_n73096528)
print v(xbgr.mr_n73096640)
print v(xbgr.mr_n73096960)
print v(xbgr.mr_n73097072)
print v(xbgr.mr_n73097392)
print v(xbgr.mr_n73097824)
print v(xbgr.mr_n73097936)
print v(xbgr.mr_n73098256)
print v(xbgr.mr_n73098368)
print v(xbgr.mr_n73098688)
print v(xbgr.mr_n73098800)
print v(xbgr.mr_n73099120)
print v(xbgr.mr_n73099552)
print v(xbgr.mr_n73099664)
print v(xbgr.mr_n73099984)
print v(xbgr.mr_n73100096)
print v(xbgr.mr_n73100416)
print v(xbgr.mr_n73100528)
print v(xbgr.mr_n73100848)
print v(xbgr.mr_n73100960)
print v(xbgr.mr_n73101280)
print v(xbgr.mr_n73101392)
print v(xbgr.mr_n73101712)
print v(xbgr.mr_n73101824)
print v(xbgr.mr_n73102144)
print v(xbgr.mr_n73102256)
print v(xbgr.mr_n73102576)
print v(xbgr.mr_n73102688)
print v(xbgr.mr_n73103008)
print v(xbgr.mr_n73103120)
print v(xbgr.mr_n73103440)
print v(xbgr.mr_n73103552)
print v(xbgr.mr_n73103872)
print v(xbgr.mr_n73103984)
print v(xbgr.mr_n73104304)
print v(xbgr.mr_n73104416)
print v(xbgr.mr_n73104736)
print v(xbgr.mr_n73104848)
print v(xbgr.mr_n73105168)
print v(xbgr.mr_n73105280)
print v(xbgr.mr_n73105600)
print v(xbgr.mr_n73105712)
print v(xbgr.mr_n73106032)
print v(xbgr.mr_n73106144)
print v(xbgr.mr_n73106464)
print v(xbgr.mr_n73106896)
print v(xbgr.mr_n73107008)
print v(xbgr.mr_n73107328)
print v(xbgr.mr_n73107440)
print v(xbgr.mr_n73107760)
print v(xbgr.mr_n73107872)
print v(xbgr.mr_n73108192)
print v(xbgr.mr_n73108304)
print v(xbgr.mr_n73108624)
print v(xbgr.mr_n73108736)
print v(xbgr.mr_n73109056)
print v(xbgr.mr_n73109168)
print v(xbgr.mr_n73109488)
print v(xbgr.mr_n73109600)
print v(xbgr.mr_n73109920)
print v(xbgr.mr_n73110032)
print v(xbgr.mr_n73110352)
print v(xbgr.mr_n73110464)
print v(xbgr.mr_n73110784)
print v(xbgr.mr_n73110896)
print v(xbgr.mr_n73111216)
print v(xbgr.mr_n73111648)
print v(xbgr.mr_n73111760)
print v(xbgr.mr_n73112080)
print v(xbgr.mr_n73112512)
print v(xbgr.mr_n73112624)
print v(xbgr.mr_n73112944)
print v(xbgr.mr_n73113056)
print v(xbgr.mr_n73113376)
print v(xbgr.mr_n73113488)
print v(xbgr.mr_n73113808)
print v(xbgr.mr_n73113920)
print v(xbgr.mr_n73114240)
print v(xbgr.mr_n73114352)
print v(xbgr.mr_n73114672)
print v(xbgr.mr_n73115104)
print v(xbgr.mr_n73115216)
print v(xbgr.mr_n73115536)
print v(xbgr.mr_n73115648)
print v(xbgr.mr_n73115968)
print v(xbgr.mr_n73116080)
print v(xbgr.mr_n73120208)
print v(xbgr.mr_n73120320)
print v(xbgr.mr_n73120656)
print v(xbgr.mr_n73120768)
print v(xbgr.mr_n73121088)
print v(xbgr.mr_n73121200)
print v(xbgr.mr_n73121568)
print v(xbgr.mr_n73121680)
print v(xbgr.mr_n73122000)
print v(xbgr.mr_n73122112)
print v(xbgr.mr_n73122432)
print v(xbgr.mr_n73122784)
print v(xbgr.mr_n73122896)
print v(xbgr.mr_n73123216)
print v(xbgr.mr_n73123648)
print v(xbgr.mr_n73123760)
print v(xbgr.mr_n73124080)
print v(xbgr.mr_n73124192)
print v(xbgr.mr_n73124512)
print v(xbgr.mr_n73124624)
print v(xbgr.mr_n73124944)
print v(xbgr.mr_n73125056)
print v(xbgr.mr_n73125376)
print v(xbgr.mr_n73125488)
print v(xbgr.mr_n73125808)
print v(xbgr.mr_n73126240)
print v(xbgr.mr_n73126352)
print v(xbgr.mr_n73126672)
print v(xbgr.mr_n73127104)
print v(xbgr.mr_n73127216)
print v(xbgr.mr_n73127536)
print v(xbgr.mr_n73127648)
print v(xbgr.mr_n73127968)
print v(xbgr.mr_n73128080)
print v(xbgr.mr_n73128400)
print v(xbgr.mr_n73128512)
print v(xbgr.mr_n73128832)
print v(xbgr.mr_n73128944)
print v(xbgr.mr_n73129264)
print v(xbgr.mr_n73129376)
print v(xbgr.mr_n73129696)
print v(xbgr.mr_n73129808)
print v(xbgr.mr_n73130128)
print v(xbgr.mr_n73130560)
print v(xbgr.mr_n73130672)
print v(xbgr.mr_n73130992)
print v(xbgr.mr_n73131104)
print v(xbgr.mr_n73131424)
print v(xbgr.mr_n73131536)
print v(xbgr.mr_n73131856)
print v(xbgr.mr_n73131968)
print v(xbgr.mr_n73132288)
print v(xbgr.mr_n73132400)
print v(xbgr.mr_n73132720)
print v(xbgr.mr_n73132832)
print v(xbgr.mr_n73133152)
print v(xbgr.mr_n73133264)
print v(xbgr.mr_n73133584)
print v(xbgr.mr_n73134016)
print v(xbgr.mr_n73134128)
print v(xbgr.mr_n73134448)
print v(xbgr.mr_n73134880)
print v(xbgr.mr_n73134992)
print v(xbgr.mr_n73135312)
print v(xbgr.mr_n73135424)
print v(xbgr.mr_n73135744)
print v(xbgr.mr_n73135856)
print v(xbgr.mr_n73136176)
print v(xbgr.mr_n73136288)
print v(xbgr.mr_n73136608)
print v(xbgr.mr_n73136720)
print v(xbgr.mr_n73137040)
print v(xbgr.mr_n73137152)
print v(xbgr.mr_n73137472)
print v(xbgr.mr_n73137584)
print v(xbgr.mr_n73137904)
print v(xbgr.mr_n73138336)
print v(xbgr.mr_n73138448)
print v(xbgr.mr_n73138768)
print v(xbgr.mr_n73138880)
print v(xbgr.mr_n73139200)
print v(xbgr.mr_n73139312)
print v(xbgr.mr_n73139632)
print v(xbgr.mr_n73140064)
print v(xbgr.mr_n73140176)
print v(xbgr.mr_n73140496)
print v(xbgr.mr_n73140608)
print v(xbgr.mr_n73140928)
print v(xbgr.mr_n73141040)
print v(xbgr.mr_n73141360)
print v(xbgr.mr_n73141472)
print v(xbgr.mr_n73141792)
print v(xbgr.mr_n73141904)
print v(xbgr.mr_n73142224)
print v(xbgr.mr_n73142336)
print v(xbgr.mr_n73142656)
print v(xbgr.mr_n73142768)
print v(xbgr.mr_n73143088)
print v(xbgr.mr_n73143520)
print v(xbgr.mr_n73143632)
print v(xbgr.mr_n73143952)
print v(xbgr.mr_n73144064)
print v(xbgr.mr_n73144384)
print v(xbgr.mr_n73144496)
print v(xbgr.mr_n73144816)
print v(xbgr.mr_n73145248)
print v(xbgr.mr_n73145360)
print v(xbgr.mr_n73145680)
print v(xbgr.mr_n73145792)
print v(xbgr.mr_n73146112)
print v(xbgr.mr_n73146224)
print v(xbgr.mr_n73146544)
print v(xbgr.mr_n73146656)
print v(xbgr.mr_n73146976)
print v(xbgr.mr_n73147088)
print v(xbgr.mr_n73147408)
print v(xbgr.mr_n73147520)
print v(xbgr.mr_n73147840)
print v(xbgr.mr_n73147952)
print v(xbgr.mr_n73148272)
print v(xbgr.mr_n73148384)
print v(xbgr.mr_n73148704)
print v(xbgr.mr_n73148816)
print v(xbgr.mr_n73149136)
print v(xbgr.mr_n73149568)
print v(xbgr.mr_n73149680)
print v(xbgr.mr_n73150000)
print v(xbgr.mr_n73150112)
print v(xbgr.mr_n73150336)
print v(xbgr.mr_n73150704)
print v(xbgr.mr_n73150816)
print v(xbgr.mr_n73151072)
print v(xbgr.mr_n73151184)
print v(xbgr.mr_n73151440)
print v(xbgr.mr_n73151552)
print v(xbgr.mr_n73151808)
print v(xbgr.mr_n73151920)
print v(xbgr.mr_n73152176)
print v(xbgr.mr_n73152288)
print v(xbgr.mr_n73152544)
print v(xbgr.mr_n73152912)
print v(xbgr.mr_n73153024)
print v(xbgr.mr_n73153280)
print v(xbgr.mr_n73153648)
print v(xbgr.mr_n73153760)
print v(xbgr.mr_n73154016)
print v(xbgr.mr_n73154384)
print v(xbgr.mr_n73154496)
print v(xbgr.mr_n73154752)
print v(xbgr.mr_n73154864)
print v(xbgr.mr_n73155120)
print v(xbgr.mr_n73155232)
print v(xbgr.mr_n73155488)
print v(xbgr.mr_n73155856)
print v(xbgr.mr_n73155968)
print v(xbgr.mr_n73156224)
print v(xbgr.mr_n73156592)
print v(xbgr.mr_n73156704)
print v(xbgr.mr_n73156960)
print v(xbgr.mr_n73157328)
print v(xbgr.mr_n73157440)
print v(xbgr.mr_n73157696)
print v(xbgr.mr_n73157808)
print v(xbgr.mr_n73158064)
print v(xbgr.mr_n73158176)
print v(xbgr.mr_n73158432)
print v(xbgr.mr_n73158544)
print v(xbgr.mr_n73158800)
print v(xbgr.mr_n73158912)
print v(xbgr.mr_n73159168)
print v(xbgr.mr_n73159536)
print v(xbgr.mr_n73159648)
print v(xbgr.mr_n73159904)
print v(xbgr.mr_n73160016)
print v(xbgr.mr_n73160272)
print v(xbgr.mr_n73160384)
print v(xbgr.mr_n73160640)
print v(xbgr.mr_n73160752)
print v(xbgr.mr_n73161008)
print v(xbgr.mr_n73161120)
print v(xbgr.mr_n73161376)
print v(xbgr.mr_n73161744)
print v(xbgr.mr_n73161856)
print v(xbgr.mr_n73162112)
print v(xbgr.mr_n73162480)
print v(xbgr.mr_n73162592)
print v(xbgr.mr_n73162848)
print v(xbgr.mr_n73162960)
print v(xbgr.mr_n73163216)
print v(xbgr.mr_n73163328)
print v(xbgr.mr_n73163616)
print v(xbgr.mr_n73164048)
print v(xbgr.mr_n73164160)
print v(xbgr.mr_n73164480)
print v(xbgr.mr_n73164912)
print v(xbgr.mr_n73165024)
print v(xbgr.mr_n73165344)
print v(xbgr.mr_n73165456)
print v(xbgr.mr_n73165776)
print v(xbgr.mr_n73165888)
print v(xbgr.mr_n73166208)
print v(xbgr.mr_n73166320)
print v(xbgr.mr_n73166640)
print v(xbgr.mr_n73166752)
print v(xbgr.mr_n73167072)
print v(xbgr.mr_n73167184)
print v(xbgr.mr_n73167504)
print v(xbgr.mr_n73167616)
print v(xbgr.mr_n73167936)
print v(xbgr.mr_n73168368)
print v(xbgr.mr_n73168480)
print v(xbgr.mr_n73168800)
print v(xbgr.mr_n73168912)
print v(xbgr.mr_n73169232)
print v(xbgr.mr_n73169344)
print v(xbgr.mr_n73169664)
print v(xbgr.mr_n73169776)
print v(xbgr.mr_n73170096)
print v(xbgr.mr_n73170208)
print v(xbgr.mr_n73170528)
print v(xbgr.mr_n73170960)
print v(xbgr.mr_n73171072)
print v(xbgr.mr_n73171392)
print v(xbgr.mr_n73171824)
print v(xbgr.mr_n73171936)
print v(xbgr.mr_n73172256)
print v(xbgr.mr_n73172368)
print v(xbgr.mr_n73172688)
print v(xbgr.mr_n73172800)
print v(xbgr.mr_n73173120)
print v(xbgr.mr_n73173232)
print v(xbgr.mr_n73173552)
print v(xbgr.mr_n73173664)
print v(xbgr.mr_n73173984)
print v(xbgr.mr_n73174096)
print v(xbgr.mr_n73174416)
print v(xbgr.mr_n73174528)
print v(xbgr.mr_n73174848)
print v(xbgr.mr_n73174960)
print v(xbgr.mr_n73175280)
print v(xbgr.mr_n73175824)
print v(xbgr.mr_n73176256)
print v(xbgr.mr_n73176688)
print v(xbgr.mr_n73177120)
print v(xbgr.mr_n73177552)
print v(xbgr.mr_n73177984)
print v(xbgr.mr_n73178416)
print v(xbgr.mr_n73178848)
print v(xbgr.mr_n73179280)
print v(xbgr.mr_n73179712)
print v(xbgr.mr_n73180032)
print v(xbgr.mr_n73180464)
print v(xbgr.mr_n73180896)
print v(xbgr.mr_n73181328)
print v(xbgr.mr_n73181760)
print v(xbgr.mr_n73182192)
print v(xbgr.mr_n73182624)
print v(xbgr.mr_n73183056)
print v(xbgr.mr_n73183488)
print v(xbgr.mr_n73183920)
print v(xbgr.mr_n73184352)
print v(xbgr.mr_n73184784)
print v(xbgr.mr_n73185216)
print v(xbgr.mr_n73185648)
print v(xbgr.mr_n73186080)
print v(xbgr.mr_n73186512)
print v(xbgr.mr_n73186944)
print v(xbgr.mr_n73187376)
print v(xbgr.mr_n73187808)
print v(xbgr.mr_n73188240)
print v(xbgr.mr_n73188672)
print v(xbgr.mr_n73189104)
print v(xbgr.mr_n73189536)
print v(xbgr.mr_n73189968)
print v(xbgr.mr_n73190400)
print v(xbgr.mr_n73190832)
print v(xbgr.mr_n73191264)
print v(xbgr.mr_n73191696)
print v(xbgr.mr_n73192128)
print v(xbgr.mr_n73192560)
print v(xbgr.mr_n73192992)
print v(xbgr.mr_n73193424)
print v(xbgr.mr_n73193856)
print v(xbgr.mr_n73194288)
print v(xbgr.mr_n73194720)
print v(xbgr.mr_n73195152)
print v(xbgr.mr_n73195584)
print v(xbgr.mr_n73196016)
print v(xbgr.mr_n73196448)
print v(xbgr.mr_n73196880)
print v(xbgr.mr_n73197312)
print v(xbgr.mr_n73197744)
print v(xbgr.mr_n73198176)
print v(xbgr.mr_n73198608)
print v(xbgr.mr_n73199040)
print v(xbgr.mr_n73199472)
print v(xbgr.mr_n73199904)
print v(xbgr.mr_n73200336)
print v(xbgr.mr_n73201632)
print v(xbgr.mr_n73202064)
print v(xbgr.mr_n73202496)
print v(xbgr.mr_n73202928)
print v(xbgr.mr_n73203360)
print v(xbgr.mr_n73203792)
print v(xbgr.mr_n73204224)
print v(xbgr.mr_n73204656)
print v(xbgr.mr_n73205088)
print v(xbgr.mr_n73205520)
print v(xbgr.mr_n73205952)
print v(xbgr.mr_n73206384)
print v(xbgr.mr_n73208544)
print v(xbgr.mr_n73208976)
print v(xbgr.mr_n73209408)
print v(xbgr.mr_n73209840)
print v(xbgr.mr_n73210272)
print v(xbgr.mr_n73210704)
print v(xbgr.mr_n73211136)
print v(xbgr.mr_n73211568)
print v(xbgr.mr_n73212000)
print v(xbgr.mr_n73212432)
print v(xbgr.mr_n73213728)
print v(xbgr.mr_n73214160)
print v(xbgr.mr_n73214592)
print v(xbgr.mr_n73215024)
print v(xbgr.mr_n73215456)
print v(xbgr.mr_n73215888)
print v(xbgr.mr_n73216320)
print v(xbgr.mr_n73216752)
print v(xbgr.mr_n73217184)
print v(xbgr.mr_n73217616)
print v(xbgr.mr_n73218048)
print v(xbgr.mr_n73218480)
print v(xbgr.mr_n73219776)
print v(xbgr.mr_n73220208)
print v(xbgr.mr_n73221504)
print v(xbgr.mr_n73221936)
print v(xbgr.mr_n73222368)
print v(xbgr.mr_n73222800)
print v(xbgr.mr_n73223232)
print v(xbgr.mr_n73223664)
print v(xbgr.mr_n73224096)
print v(xbgr.mr_n73224528)
print v(xbgr.mr_n73225824)
print v(xbgr.mr_n73226256)
print v(xbgr.mr_n73226576)
print v(xbgr.mr_n73226688)
print v(xbgr.mr_n73227008)
print v(xbgr.mr_n73227120)
print v(xbgr.mr_n73227440)
print v(xbgr.mr_n73227552)
print v(xbgr.mr_n73227872)
print v(xbgr.mr_n73227984)
print v(xbgr.mr_n73228304)
print v(xbgr.mr_n73228416)
print v(xbgr.mr_n73228736)
print v(xbgr.mr_n73228848)
print v(xbgr.mr_n73229168)
print v(xbgr.mr_n73229280)
print v(xbgr.mr_n73229600)
print v(xbgr.mr_n73229712)
print v(xbgr.mr_n73230144)
print v(xbgr.mr_n73230576)
print v(xbgr.mr_n73231008)
print v(xbgr.mr_n73231440)
print v(xbgr.mr_n73231872)
print v(xbgr.mr_n73232304)
print v(xbgr.mr_n73232736)
print v(xbgr.mr_n73233168)
print v(xbgr.mr_n73233600)
print v(xbgr.mr_n73234032)
print v(xbgr.mr_n73234464)
print v(xbgr.mr_n73234896)
print v(xbgr.mr_n73235328)
print v(xbgr.mr_n73235760)
print v(xbgr.mr_n73236192)
print v(xbgr.mr_n73236624)
print v(xbgr.mr_n73237056)
print v(xbgr.mr_n73237488)
print v(xbgr.mr_n73237920)
print v(xbgr.mr_n73238352)
print v(xbgr.mr_n73238784)
print v(xbgr.mr_n73239216)
print v(xbgr.mr_n73239648)
print v(xbgr.mr_n73240080)
print v(xbgr.mr_n73240512)
print v(xbgr.mr_n73240944)
print v(xbgr.mr_n73241584)
print v(xbgr.mr_n73242016)
print v(xbgr.mr_n73242448)
print v(xbgr.mr_n73242880)
print v(xbgr.mr_n73243312)
print v(xbgr.mr_n73243744)
print v(xbgr.mr_n73244176)
print v(xbgr.mr_n73244608)
print v(xbgr.mr_n73245040)
print v(xbgr.mr_n73245472)
print v(xbgr.mr_n73245904)
print v(xbgr.mr_n73246336)
print v(xbgr.mr_n73246768)
print v(xbgr.mr_n73247200)
print v(xbgr.mr_n73247632)
print v(xbgr.mr_n73248064)
print v(xbgr.mr_n73248496)
print v(xbgr.mr_n73248928)
print v(xbgr.mr_n73249360)
print v(xbgr.mr_n73249792)
print v(xbgr.mr_n73250224)
print v(xbgr.mr_n73250656)
print v(xbgr.mr_n73251088)
print v(xbgr.mr_n73251520)
print v(xbgr.mr_n73251952)
print v(xbgr.mr_n73252384)
print v(xbgr.mr_n73252816)
print v(xbgr.mr_n73253248)
print v(xbgr.mr_n73253680)
print v(xbgr.mr_n73254112)
print v(xbgr.mr_n73254544)
print v(xbgr.mr_n73254976)
print v(xbgr.mr_n73255408)
print v(xbgr.mr_n73255840)
print v(xbgr.mr_n73256272)
print v(xbgr.mr_n73256704)
print v(xbgr.mr_n73257136)
print v(xbgr.mr_n73257568)
print v(xbgr.mr_n73258000)
print v(xbgr.mr_n73258432)
print v(xbgr.mr_n73258864)
print v(xbgr.mr_n73259296)
print v(xbgr.mr_n73259728)
print v(xbgr.mr_n73260160)
print v(xbgr.mr_n73260592)
print v(xbgr.mr_n73261024)
print v(xbgr.mr_n73261456)
print v(xbgr.mr_n73261888)
print v(xbgr.mr_n73262320)
print v(xbgr.mr_n73262752)
print v(xbgr.mr_n73263184)
print v(xbgr.mr_n73263616)
print v(xbgr.mr_n73264048)
print v(xbgr.mr_n73264480)
print v(xbgr.mr_n73264912)
print v(xbgr.mr_n73265344)
print v(xbgr.mr_n73265776)
print v(xbgr.mr_n73266208)
print v(xbgr.mr_n73266640)
print v(xbgr.mr_n73267072)
print v(xbgr.mr_n73267504)
print v(xbgr.mr_n73267936)
print v(xbgr.mr_n73268368)
print v(xbgr.mr_n73268800)
print v(xbgr.mr_n73269232)
print v(xbgr.mr_n73269664)
print v(xbgr.mr_n73270096)
print v(xbgr.mr_n73270528)
print v(xbgr.mr_n73270960)
print v(xbgr.mr_n73271392)
print v(xbgr.mr_n73271824)
print v(xbgr.mr_n73272256)
print v(xbgr.mr_n73272688)
print v(xbgr.mr_n73273120)
print v(xbgr.mr_n73273552)
print v(xbgr.mr_n73273984)
print v(xbgr.mr_n73274416)
print v(xbgr.mr_n73274848)
print v(xbgr.mr_n73275280)
print v(xbgr.mr_n73275712)
print v(xbgr.mr_n73276144)
print v(xbgr.mr_n73276576)
print v(xbgr.mr_n73277008)
print v(xbgr.mr_n73277440)
print v(xbgr.mr_n73277872)
print v(xbgr.mr_n73278192)
print v(xbgr.mr_n73278304)
print v(xbgr.mr_n73278624)
print v(xbgr.mr_n73278736)
print v(xbgr.mr_n73279056)
print v(xbgr.mr_n73279168)
print v(xbgr.mr_n73279488)
print v(xbgr.mr_n73279600)
print v(xbgr.mr_n73280032)
print v(xbgr.mr_n73280464)
print v(xbgr.mr_n73280896)
print v(xbgr.mr_n73281328)
print v(xbgr.mr_n73281760)
print v(xbgr.mr_n73282192)
print v(xbgr.mr_n73282624)
print v(xbgr.mr_n73283056)
print v(xbgr.mr_n73283488)
print v(xbgr.mr_n73283920)
print v(xbgr.mr_n73284352)
print v(xbgr.mr_n73284784)
print v(xbgr.mr_n73285216)
print v(xbgr.mr_n73285648)
print v(xbgr.mr_n73286080)
print v(xbgr.mr_n73286512)
print v(xbgr.mr_n73286944)
print v(xbgr.mr_n73287376)
print v(xbgr.mr_n73287808)
print v(xbgr.mr_n73288240)
print v(xbgr.mr_n73288672)
print v(xbgr.mr_n73289104)
print v(xbgr.mr_n73289536)
print v(xbgr.mr_n73289968)
print v(xbgr.mr_n73290400)
print v(xbgr.mr_n73290832)
print v(xbgr.mr_n73291264)
print v(xbgr.mr_n73291696)
print v(xbgr.mr_n73292128)
print v(xbgr.mr_n73292560)
print v(xbgr.mr_n73292992)
print v(xbgr.mr_n73293424)
print v(xbgr.mr_n73293856)
print v(xbgr.mr_n73294288)
print v(xbgr.mr_n73294720)
print v(xbgr.mr_n73295152)
print v(xbgr.mr_n73295584)
print v(xbgr.mr_n73296016)
print v(xbgr.mr_n73296448)
print v(xbgr.mr_n73296880)
print v(xbgr.mr_n73297312)
print v(xbgr.mr_n73297744)
print v(xbgr.mr_n73298176)
print v(xbgr.mr_n73298608)
print v(xbgr.mr_n73299040)
print v(xbgr.mr_n73299472)
print v(xbgr.mr_n73299904)
print v(xbgr.mr_n73300336)
print v(xbgr.mr_n73300768)
print v(xbgr.mr_n73301200)
print v(xbgr.mr_n73301632)
print v(xbgr.mr_n73302064)
print v(xbgr.mr_n73302496)
print v(xbgr.mr_n73302928)
print v(xbgr.mr_n73303360)
print v(xbgr.mr_n73303792)
print v(xbgr.mr_n73304224)
print v(xbgr.mr_n73304656)
print v(xbgr.mr_n73305088)
print v(xbgr.mr_n73305520)
print v(xbgr.mr_n73305952)
print v(xbgr.mr_n73306384)
print v(xbgr.mr_n73306816)
print v(xbgr.mr_n73307248)
print v(xbgr.mr_n73308544)
print v(xbgr.mr_n73308976)
print v(xbgr.mr_n73310272)
print v(xbgr.mr_n73310704)
print v(xbgr.mr_n73312000)
print v(xbgr.mr_n73312432)
print v(xbgr.mr_n73312864)
print v(xbgr.mr_n73313296)
print v(xbgr.mr_n73313728)
print v(xbgr.mr_n73314160)
print v(xbgr.mr_n73314592)
print v(xbgr.mr_n73315024)
print v(xbgr.mr_n73315456)
print v(xbgr.mr_n73315888)
print v(xbgr.mr_n73316320)
print v(xbgr.mr_n73316752)
print v(xbgr.mr_n73317184)
print v(xbgr.mr_n73317616)
print v(xbgr.mr_n73318048)
print v(xbgr.mr_n73318480)
print v(xbgr.mr_n73319776)
print v(xbgr.mr_n73320208)
print v(xbgr.mr_n73320640)
print v(xbgr.mr_n73321072)
print v(xbgr.mr_n73321504)
print v(xbgr.mr_n73321936)
print v(xbgr.mr_n73323232)
print v(xbgr.mr_n73323664)
print v(xbgr.mr_n73324096)
print v(xbgr.mr_n73324528)
print v(xbgr.mr_n73324960)
print v(xbgr.mr_n73325392)
print v(xbgr.mr_n73325824)
print v(xbgr.mr_n73326256)
print v(xbgr.mr_n73326688)
print v(xbgr.mr_n73327120)
print v(xbgr.mr_n73327552)
print v(xbgr.mr_n73327984)
print v(xbgr.mr_n73328416)
print v(xbgr.mr_n73328848)
print v(xbgr.mr_n73329280)
print v(xbgr.mr_n73329712)
print v(xbgr.mr_n73330144)
print v(xbgr.mr_n73330576)
print v(xbgr.mr_n73331008)
print v(xbgr.mr_n73331440)
print v(xbgr.mr_n73331872)
print v(xbgr.mr_n73332304)
print v(xbgr.mr_n73332736)
print v(xbgr.mr_n73333168)
print v(xbgr.mr_n73333600)
print v(xbgr.mr_n73334032)
print v(xbgr.mr_n73334464)
print v(xbgr.mr_n73334896)
print v(xbgr.mr_n73335328)
print v(xbgr.mr_n73335760)
print v(xbgr.mr_n73336192)
print v(xbgr.mr_n73336624)
print v(xbgr.mr_n73337056)
print v(xbgr.mr_n73337488)
print v(xbgr.mr_n73337920)
print v(xbgr.mr_n73338352)
print v(xbgr.mr_n73338784)
print v(xbgr.mr_n73339216)
print v(xbgr.mr_n73339648)
print v(xbgr.mr_n73340080)
print v(xbgr.mr_n73340512)
print v(xbgr.mr_n73340944)
print v(xbgr.mr_n73341376)
print v(xbgr.mr_n73341808)
print v(xbgr.mr_n73342240)
print v(xbgr.mr_n73342672)
print v(xbgr.mr_n73343104)
print v(xbgr.mr_n73343536)
print v(xbgr.mr_n73343968)
print v(xbgr.mr_n73344400)
print v(xbgr.mr_n73344832)
print v(xbgr.mr_n73345264)
print v(xbgr.mr_n73345696)
print v(xbgr.mr_n73346128)
print v(xbgr.mr_n73346560)
print v(xbgr.mr_n73346992)
print v(xbgr.mr_n73347424)
print v(xbgr.mr_n73347744)
print v(xbgr.mr_n73347856)
print v(xbgr.mr_n73348176)
print v(xbgr.mr_n73348288)
print v(xbgr.mr_n73348608)
print v(xbgr.mr_n73348720)
print v(xbgr.mr_n73349040)
print v(xbgr.mr_n73349152)
print v(xbgr.mr_n73349472)
print v(xbgr.mr_n73349584)
print v(xbgr.mr_n73349904)
print v(xbgr.mr_n73350016)
print v(xbgr.mr_n73350336)
print v(xbgr.mr_n73350448)
print v(xbgr.mr_n73350768)
print v(xbgr.mr_n73350880)
print v(xbgr.mr_n73351200)
print v(xbgr.mr_n73351312)
print v(xbgr.mr_n73351632)
print v(xbgr.mr_n73351744)
print v(xbgr.mr_n73352064)
print v(xbgr.mr_n73352176)
print v(xbgr.mr_n73352496)
print v(xbgr.mr_n73352608)
print v(xbgr.mr_n73352928)
print v(xbgr.mr_n73353040)
print v(xbgr.mr_n73353360)
print v(xbgr.mr_n73353472)
print v(xbgr.mr_n73353792)
print v(xbgr.mr_n73353904)
print v(xbgr.mr_n73354224)
print v(xbgr.mr_n73354336)
print v(xbgr.mr_n73354656)
print v(xbgr.mr_n73354768)
print v(xbgr.mr_n73355088)
print v(xbgr.mr_n73355200)
print v(xbgr.mr_n73355520)
print v(xbgr.mr_n73355632)
print v(xbgr.mr_n73355952)
print v(xbgr.mr_n73356064)
print v(xbgr.mr_n73356384)
print v(xbgr.mr_n73356496)
print v(xbgr.mr_n73356816)
print v(xbgr.mr_n73356928)
print v(xbgr.mr_n73357248)
print v(xbgr.mr_n73357360)
print v(xbgr.mr_n73357680)
print v(xbgr.mr_n73357792)
print v(xbgr.mr_n73358112)
print v(xbgr.mr_n73358224)
print v(xbgr.mr_n73358544)
print v(xbgr.mr_n73358656)
print v(xbgr.mr_n73358976)
print v(xbgr.mr_n73359088)
print v(xbgr.mr_n73359408)
print v(xbgr.mr_n73359520)
print v(xbgr.mr_n73359840)
print v(xbgr.mr_n73359952)
print v(xbgr.mr_n73360272)
print v(xbgr.mr_n73360384)
print v(xbgr.mr_n73360704)
print v(xbgr.mr_n73360816)
print v(xbgr.mr_n73361136)
print v(xbgr.mr_n73361248)
print v(xbgr.mr_n73361568)
print v(xbgr.mr_n73361680)
print v(xbgr.mr_n73362000)
print v(xbgr.mr_n73362112)
print v(xbgr.mr_n73362432)
print v(xbgr.mr_n73362544)
print v(xbgr.mr_n73362864)
print v(xbgr.mr_n73362976)
print v(xbgr.mr_n73363296)
print v(xbgr.mr_n73363408)
print v(xbgr.mr_n73363728)
print v(xbgr.mr_n73363840)
print v(xbgr.mr_n73364256)
print v(xbgr.mr_n73364688)
print v(xbgr.mr_n73365120)
print v(xbgr.mr_n73365552)
print v(xbgr.mr_n73365984)
print v(xbgr.mr_n73366416)
print v(xbgr.mr_n73366848)
print v(xbgr.mr_n73367280)
print v(xbgr.mr_n73367712)
print v(xbgr.mr_n73368144)
print v(xbgr.mr_n73368576)
print v(xbgr.mr_n73369008)
print v(xbgr.mr_n73369328)
print v(xbgr.mr_n73369440)
print v(xbgr.mr_n73369760)
print v(xbgr.mr_n73369872)
print v(xbgr.mr_n73370304)
print v(xbgr.mr_n73370736)
print v(xbgr.mr_n73371168)
print v(xbgr.mr_n73371600)
print v(xbgr.mr_n73372032)
print v(xbgr.mr_n73372464)
print v(xbgr.mr_n73372896)
print v(xbgr.mr_n73373328)
print v(xbgr.mr_n73373760)
print v(xbgr.mr_n73374192)
print v(xbgr.mr_n73374624)
print v(xbgr.mr_n73375056)
print v(xbgr.mr_n73375488)
print v(xbgr.mr_n73375920)
print v(xbgr.mr_n73376352)
print v(xbgr.mr_n73376784)
print v(xbgr.mr_n73377216)
print v(xbgr.mr_n73377648)
print v(xbgr.mr_n73378080)
print v(xbgr.mr_n73378512)
print v(xbgr.mr_n73378944)
print v(xbgr.mr_n73379376)
print v(xbgr.mr_n73379808)
print v(xbgr.mr_n73380240)
print v(xbgr.mr_n73380672)
print v(xbgr.mr_n73381104)
print v(xbgr.mr_n73381536)
print v(xbgr.mr_n73381968)
print v(xbgr.mr_n73382400)
print v(xbgr.mr_n73382832)
print v(xbgr.mr_n73383264)
print v(xbgr.mr_n73383696)
print v(xbgr.mr_n73384128)
print v(xbgr.mr_n73384560)
print v(xbgr.mr_n73384992)
print v(xbgr.mr_n73385424)
print v(xbgr.mr_n73385856)
print v(xbgr.mr_n73386288)
print v(xbgr.mr_n73386720)
print v(xbgr.mr_n73387152)
print v(xbgr.mr_n73387472)
print v(xbgr.mr_n73387584)
print v(xbgr.mr_n73387904)
print v(xbgr.mr_n73388016)
print v(xbgr.mr_n73388448)
print v(xbgr.mr_n73388768)
print v(xbgr.mr_n73388880)
print v(xbgr.mr_n73389312)
print v(xbgr.mr_n73389744)
print v(xbgr.mr_n73390176)
print v(xbgr.mr_n73390608)
print v(xbgr.mr_n73391040)
print v(xbgr.mr_n73391472)
print v(xbgr.mr_n73391904)
print v(xbgr.mr_n73392336)
print v(xbgr.mr_n73392768)
print v(xbgr.mr_n73393200)
print v(xbgr.mr_n73393632)
print v(xbgr.mr_n73394064)
print v(xbgr.mr_n73394496)
print v(xbgr.mr_n73394928)
print v(xbgr.mr_n73395360)
print v(xbgr.mr_n73395792)
print v(xbgr.mr_n73396224)
print v(xbgr.mr_n73396656)
print v(xbgr.mr_n73397088)
print v(xbgr.mr_n73397520)
print v(xbgr.mr_n73397952)
print v(xbgr.mr_n73398384)
print v(xbgr.mr_n73398816)
print v(xbgr.mr_n73399248)
print v(xbgr.mr_n73399680)
print v(xbgr.mr_n73400112)
print v(xbgr.mr_n73400544)
print v(xbgr.mr_n73400976)
print v(xbgr.mr_n73401408)
print v(xbgr.mr_n73401840)
print v(xbgr.mr_n73402272)
print v(xbgr.mr_n73402704)
print v(xbgr.mr_n73403136)
print v(xbgr.mr_n73403568)
print v(xbgr.mr_n73404000)
print v(xbgr.mr_n73404432)
print v(xbgr.mr_n73404864)
print v(xbgr.mr_n73405296)
print v(xbgr.mr_n73405728)
print v(xbgr.mr_n73406160)
print v(xbgr.mr_n73406592)
print v(xbgr.mr_n73407024)
print v(xbgr.mr_n73407456)
print v(xbgr.mr_n73407888)
print v(xbgr.mr_n73408320)
print v(xbgr.mr_n73408752)
print v(xbgr.mr_n73409184)
print v(xbgr.mr_n73409504)
print v(xbgr.mr_n73409616)
print v(xbgr.mr_n73410048)
print v(xbgr.mr_n73410480)
print v(xbgr.mr_n73410800)
print v(xbgr.mr_n73410912)
print v(xbgr.mr_n73411232)
print v(xbgr.mr_n73411344)
print v(xbgr.mr_n73411664)
print v(xbgr.mr_n73411776)
print v(xbgr.mr_n73412096)
print v(xbgr.mr_n73412208)
print v(xbgr.mr_n73412528)
print v(xbgr.mr_n73412640)
print v(xbgr.mr_n73412960)
print v(xbgr.mr_n73413072)
print v(xbgr.mr_n73413504)
print v(xbgr.mr_n73413824)
print v(xbgr.mr_n73413936)
print v(xbgr.mr_n73414256)
print v(xbgr.mr_n73414368)
print v(xbgr.mr_n73414688)
print v(xbgr.mr_n73414800)
print v(xbgr.mr_n73415120)
print v(xbgr.mr_n73415232)
print v(xbgr.mr_n73415552)
print v(xbgr.mr_n73415664)
print v(xbgr.mr_n73415984)
print v(xbgr.mr_n73416096)
print v(xbgr.mr_n73416528)
print v(xbgr.mr_n73416848)
print v(xbgr.mr_n73416960)
print v(xbgr.mr_n73417280)
print v(xbgr.mr_n73417392)
print v(xbgr.mr_n73417712)
print v(xbgr.mr_n73417824)
print v(xbgr.mr_n73418144)
print v(xbgr.mr_n73418256)
print v(xbgr.mr_n73418576)
print v(xbgr.mr_n73418688)
print v(xbgr.mr_n73419008)
print v(xbgr.mr_n73419120)
print v(xbgr.mr_n73419552)
print v(xbgr.mr_n73419872)
print v(xbgr.mr_n73419984)
print v(xbgr.mr_n73420304)
print v(xbgr.mr_n73420416)
print v(xbgr.mr_n73420736)
print v(xbgr.mr_n73420848)
print v(xbgr.mr_n73421280)
print v(xbgr.mr_n73421600)
print v(xbgr.mr_n73421712)
print v(xbgr.mr_n73422144)
print v(xbgr.mr_n73422576)
print v(xbgr.mr_n73423008)
print v(xbgr.mr_n73423440)
print v(xbgr.mr_n73424736)
print v(xbgr.mr_n73425168)
print v(xbgr.mr_n73426464)
print v(xbgr.mr_n73426896)
print v(xbgr.mr_n73427216)
print v(xbgr.mr_n73427328)
print v(xbgr.mr_n73427648)
print v(xbgr.mr_n73427760)
print v(xbgr.mr_n73428080)
print v(xbgr.mr_n73428192)
print v(xbgr.mr_n73428512)
print v(xbgr.mr_n73429056)
print v(xbgr.mr_n73429808)
print v(xbgr.mr_n73429920)
print v(xbgr.mr_n73430240)
print v(xbgr.mr_n73432512)
print v(xbgr.mr_n73433376)
print v(xbgr.mr_n73434240)
print v(xbgr.mr_n73434672)
print v(xbgr.mr_n73435104)
print v(xbgr.mr_n73435536)
print v(xbgr.mr_n73437584)
print v(xbgr.mr_n73437696)
print v(xbgr.mr_n73438128)
print v(xbgr.mr_n73438448)
print v(xbgr.mr_n73438560)
print v(xbgr.mr_n73438880)
print v(xbgr.mr_n73438992)
print v(xbgr.mr_n73439424)
print v(xbgr.mr_n73439744)
print v(xbgr.mr_n73439856)
print v(xbgr.mr_n73440176)
print v(xbgr.mr_n73440288)
print v(xbgr.mr_n73440608)
print v(xbgr.mr_n73440720)
print v(xbgr.mr_n73441152)
print v(xbgr.mr_n73441472)
print v(xbgr.mr_n73441584)
print v(xbgr.mr_n73441904)
print v(xbgr.mr_n73442016)
print v(xbgr.mr_n73442336)
print v(xbgr.mr_n73442448)
print v(xbgr.mr_n73442880)
print v(xbgr.mr_n73443200)
print v(xbgr.mr_n73443312)
print v(xbgr.mr_n73443632)
print v(xbgr.mr_n73443744)
print v(xbgr.mr_n73444064)
print v(xbgr.mr_n73444176)
print v(xbgr.mr_n73444496)
print v(xbgr.mr_n73444608)
print v(xbgr.mr_n73444928)
print v(xbgr.mr_n73445040)
print v(xbgr.mr_n73445472)
print v(xbgr.mr_n73445792)
print v(xbgr.mr_n73445904)
print v(xbgr.mr_n73446224)
print v(xbgr.mr_n73446336)
print v(xbgr.mr_n73446656)
print v(xbgr.mr_n73446768)
print v(xbgr.mr_n73447088)
print v(xbgr.mr_n73447200)
print v(xbgr.mr_n73447632)
print v(xbgr.mr_n73447952)
print v(xbgr.mr_n73448064)
print v(xbgr.mr_n73448384)
print v(xbgr.mr_n73448496)
print v(xbgr.mr_n73448928)
print v(xbgr.mr_n73449248)
print v(xbgr.mr_n73449360)
print v(xbgr.mr_n73449680)
print v(xbgr.mr_n73449792)
print v(xbgr.mr_n73450112)
print v(xbgr.mr_n73450224)
print v(xbgr.mr_n73450656)
print v(xbgr.mr_n73450976)
print v(xbgr.mr_n73451088)
print v(xbgr.mr_n73451408)
print v(xbgr.mr_n73451520)
print v(xbgr.mr_n73451840)
print v(xbgr.mr_n73451952)
print v(xbgr.mr_n73452384)
print v(xbgr.mr_n73452704)
print v(xbgr.mr_n73452816)
print v(xbgr.mr_n73453136)
print v(xbgr.mr_n73453248)
print v(xbgr.mr_n73453568)
print v(xbgr.mr_n73453680)
print v(xbgr.mr_n73454000)
print v(xbgr.mr_n73454112)
print v(xbgr.mr_n73454432)
print v(xbgr.mr_n73454544)
print v(xbgr.mr_n73454864)
print v(xbgr.mr_n73454976)
print v(xbgr.mr_n73455296)
print v(xbgr.mr_n73455408)
print v(xbgr.mr_n73455728)
print v(xbgr.mr_n73455840)
print v(xbgr.mr_n73456160)
print v(xbgr.mr_n73456272)
print v(xbgr.mr_n73456592)
print v(xbgr.mr_n73456704)
print v(xbgr.mr_n73457024)
print v(xbgr.mr_n73457136)
print v(xbgr.mr_n73457456)
print v(xbgr.mr_n73457568)
print v(xbgr.mr_n73457888)
print v(xbgr.mr_n73458000)
print v(xbgr.mr_n73458432)
print v(xbgr.mr_n73458752)
print v(xbgr.mr_n73458864)
print v(xbgr.mr_n73459184)
print v(xbgr.mr_n73459296)
print v(xbgr.mr_n73459616)
print v(xbgr.mr_n73459728)
print v(xbgr.mr_n73460048)
print v(xbgr.mr_n73460160)
print v(xbgr.mr_n73460480)
print v(xbgr.mr_n73460592)
print v(xbgr.mr_n73460912)
print v(xbgr.mr_n73461024)
print v(xbgr.mr_n73461344)
print v(xbgr.mr_n73461456)
print v(xbgr.mr_n73461776)
print v(xbgr.mr_n73461888)
print v(xbgr.mr_n73462208)
print v(xbgr.mr_n73462320)
print v(xbgr.mr_n73462640)
print v(xbgr.mr_n73462752)
print v(xbgr.mr_n73463184)
print v(xbgr.mr_n73463504)
print v(xbgr.mr_n73463616)
print v(xbgr.mr_n73463936)
print v(xbgr.mr_n73464048)
print v(xbgr.mr_n73464368)
print v(xbgr.mr_n73464480)
print v(xbgr.mr_n73464800)
print v(xbgr.mr_n73464912)
print v(xbgr.mr_n73465232)
print v(xbgr.mr_n73465344)
print v(xbgr.mr_n73465664)
print v(xbgr.mr_n73465776)
print v(xbgr.mr_n73466096)
print v(xbgr.mr_n73466208)
print v(xbgr.mr_n73466528)
print v(xbgr.mr_n73466640)
print v(xbgr.mr_n73466960)
print v(xbgr.mr_n73467072)
print v(xbgr.mr_n73467392)
print v(xbgr.mr_n73467504)
print v(xbgr.mr_n73467824)
print v(xbgr.mr_n73467936)
print v(xbgr.mr_n73468256)
print v(xbgr.mr_n73468368)
print v(xbgr.mr_n73468688)
print v(xbgr.mr_n73468800)
print v(xbgr.mr_n73469120)
print v(xbgr.mr_n73469232)
print v(xbgr.mr_n73469552)
print v(xbgr.mr_n73469664)
print v(xbgr.mr_n73469984)
print v(xbgr.mr_n73470096)
print v(xbgr.mr_n73470528)
print v(xbgr.mr_n73470848)
print v(xbgr.mr_n73470960)
print v(xbgr.mr_n73471280)
print v(xbgr.mr_n73471392)
print v(xbgr.mr_n73471712)
print v(xbgr.mr_n73471824)
print v(xbgr.mr_n73472144)
print v(xbgr.mr_n73472256)
print v(xbgr.mr_n73472576)
print v(xbgr.mr_n73472688)
print v(xbgr.mr_n73473008)
print v(xbgr.mr_n73473120)
print v(xbgr.mr_n73473440)
print v(xbgr.mr_n73473552)
print v(xbgr.mr_n73473872)
print v(xbgr.mr_n73473984)
print v(xbgr.mr_n73474304)
print v(xbgr.mr_n73474416)
print v(xbgr.mr_n73474736)
print v(xbgr.mr_n73474848)
print v(xbgr.mr_n73475168)
print v(xbgr.mr_n73475280)
print v(xbgr.mr_n73475600)
print v(xbgr.mr_n73475712)
print v(xbgr.mr_n73476144)
print v(xbgr.mr_n73476464)
print v(xbgr.mr_n73476576)
print v(xbgr.mr_n73476896)
print v(xbgr.mr_n73477008)
print v(xbgr.mr_n73477328)
print v(xbgr.mr_n73477440)
print v(xbgr.mr_n73477760)
print v(xbgr.mr_n73477872)
print v(xbgr.mr_n73478192)
print v(xbgr.mr_n73478304)
print v(xbgr.mr_n73478624)
print v(xbgr.mr_n73478736)
print v(xbgr.mr_n73479056)
print v(xbgr.mr_n73479168)
print v(xbgr.mr_n73479488)
print v(xbgr.mr_n73479600)
print v(xbgr.mr_n73479920)
print v(xbgr.mr_n73480032)
print v(xbgr.mr_n73480352)
print v(xbgr.mr_n73480464)
print v(xbgr.mr_n73480784)
print v(xbgr.mr_n73480896)
print v(xbgr.mr_n73481216)
print v(xbgr.mr_n73481328)
print v(xbgr.mr_n73481648)
print v(xbgr.mr_n73481760)
print v(xbgr.mr_n73482080)
print v(xbgr.mr_n73482192)
print v(xbgr.mr_n73482512)
print v(xbgr.mr_n73482624)
print v(xbgr.mr_n73482944)
print v(xbgr.mr_n73483056)
print v(xbgr.mr_n73483376)
print v(xbgr.mr_n73483488)
print v(xbgr.mr_n73483808)
print v(xbgr.mr_n73483920)
print v(xbgr.mr_n73484240)
print v(xbgr.mr_n73484352)
print v(xbgr.mr_n73484672)
print v(xbgr.mr_n73484784)
print v(xbgr.mr_n73485216)
print v(xbgr.mr_n73485536)
print v(xbgr.mr_n73485648)
print v(xbgr.mr_n73485968)
print v(xbgr.mr_n73486080)
print v(xbgr.mr_n73486400)
print v(xbgr.mr_n73486512)
print v(xbgr.mr_n73486832)
print v(xbgr.mr_n73486944)
print v(xbgr.mr_n73487264)
print v(xbgr.mr_n73487376)
print v(xbgr.mr_n73487696)
print v(xbgr.mr_n73487808)
print v(xbgr.mr_n73488128)
print v(xbgr.mr_n73488240)
print v(xbgr.mr_n73488560)
print v(xbgr.mr_n73488672)
print v(xbgr.mr_n73488992)
print v(xbgr.mr_n73489104)
print v(xbgr.mr_n73489424)
print v(xbgr.mr_n73489536)
print v(xbgr.mr_n73489856)
print v(xbgr.mr_n73489968)
print v(xbgr.mr_n73490288)
print v(xbgr.mr_n73490400)
print v(xbgr.mr_n73490720)
print v(xbgr.mr_n73490832)
print v(xbgr.mr_n73491152)
print v(xbgr.mr_n73491264)
print v(xbgr.mr_n73491584)
print v(xbgr.mr_n73491696)
print v(xbgr.mr_n73492016)
print v(xbgr.mr_n73492128)
print v(xbgr.mr_n73492448)
print v(xbgr.mr_n73492560)
print v(xbgr.mr_n73492880)
print v(xbgr.mr_n73492992)
print v(xbgr.mr_n73493312)
print v(xbgr.mr_n73493424)
print v(xbgr.mr_n73493744)
print v(xbgr.mr_n73493856)
print v(xbgr.mr_n73494176)
print v(xbgr.mr_n73494288)
print v(xbgr.mr_n73494608)
print v(xbgr.mr_n73494720)
print v(xbgr.mr_n73495152)
print v(xbgr.mr_n73495472)
print v(xbgr.mr_n73495584)
print v(xbgr.mr_n73495904)
print v(xbgr.mr_n73496016)
print v(xbgr.mr_n73496336)
print v(xbgr.mr_n73496448)
print v(xbgr.mr_n73496768)
print v(xbgr.mr_n73496880)
print v(xbgr.mr_n73497200)
print v(xbgr.mr_n73497312)
print v(xbgr.mr_n73497632)
print v(xbgr.mr_n73497744)
print v(xbgr.mr_n73498064)
print v(xbgr.mr_n73498176)
print v(xbgr.mr_n73498496)
print v(xbgr.mr_n73498608)
print v(xbgr.mr_n73498928)
print v(xbgr.mr_n73499040)
print v(xbgr.mr_n73499360)
print v(xbgr.mr_n73499472)
print v(xbgr.mr_n73499792)
print v(xbgr.mr_n73499904)
print v(xbgr.mr_n73500224)
print v(xbgr.mr_n73500336)
print v(xbgr.mr_n73500768)
print v(xbgr.mr_n73501200)
print v(xbgr.mr_n73501632)
print v(xbgr.mr_n73502064)
print v(xbgr.mr_n73502496)
print v(xbgr.mr_n73502928)
print v(xbgr.mr_n73503360)
print v(xbgr.mr_n73503792)
print v(xbgr.mr_n73504224)
print v(xbgr.mr_n73504656)
print v(xbgr.mr_n73505088)
print v(xbgr.mr_n73505520)
print v(xbgr.mr_n73505952)
print v(xbgr.mr_n73506384)
print v(xbgr.mr_n73506816)
print v(xbgr.mr_n73507248)
print v(xbgr.mr_n73507680)
print v(xbgr.mr_n73508112)
print v(xbgr.mr_n73508544)
print v(xbgr.mr_n73508976)
print v(xbgr.mr_n73509408)
print v(xbgr.mr_n73509840)
print v(xbgr.mr_n73510272)
print v(xbgr.mr_n73510704)
print v(xbgr.mr_n73511136)
print v(xbgr.mr_n73511568)
print v(xbgr.mr_n73512000)
print v(xbgr.mr_n73512432)
print v(xbgr.mr_n73512864)
print v(xbgr.mr_n73513296)
print v(xbgr.mr_n73513728)
print v(xbgr.mr_n73514160)
print v(xbgr.mr_n73514592)
print v(xbgr.mr_n73515024)
print v(xbgr.mr_n73515456)
print v(xbgr.mr_n73515888)
print v(xbgr.mr_n73516320)
print v(xbgr.mr_n73516752)
print v(xbgr.mr_n73517184)
print v(xbgr.mr_n73517616)
print v(xbgr.mr_n73518048)
print v(xbgr.mr_n73518480)
print v(xbgr.mr_n73518912)
print v(xbgr.mr_n73519344)
print v(xbgr.mr_n73519776)
print v(xbgr.mr_n73520208)
print v(xbgr.mr_n73520640)
print v(xbgr.mr_n73521072)
print v(xbgr.mr_n73521504)
print v(xbgr.mr_n73521936)
print v(xbgr.mr_n73522368)
print v(xbgr.mr_n73522800)
print v(xbgr.mr_n73523232)
print v(xbgr.mr_n73523664)
print v(xbgr.mr_n73524096)
print v(xbgr.mr_n73524528)
print v(xbgr.mr_n73524960)
print v(xbgr.mr_n73525392)
print v(xbgr.mr_n73525824)
print v(xbgr.mr_n73526256)
print v(xbgr.mr_n73526688)
print v(xbgr.mr_n73527120)
print v(xbgr.mr_n73527552)
print v(xbgr.mr_n73527984)
print v(xbgr.mr_n73528416)
print v(xbgr.mr_n73528848)
print v(xbgr.mr_n73529280)
print v(xbgr.mr_n73529712)
print v(xbgr.mr_n73530144)
print v(xbgr.mr_n73530576)
print v(xbgr.mr_n73531008)
print v(xbgr.mr_n73531440)
print v(xbgr.mr_n73531872)
print v(xbgr.mr_n73532304)
print v(xbgr.mr_n73532736)
print v(xbgr.mr_n73533168)
print v(xbgr.mr_n73533600)
print v(xbgr.mr_n73534032)
print v(xbgr.mr_n73534464)
print v(xbgr.mr_n73534896)
print v(xbgr.mr_n73535328)
print v(xbgr.mr_n73535760)
print v(xbgr.mr_n73536192)
print v(xbgr.mr_n73536624)
print v(xbgr.mr_n73537056)
print v(xbgr.mr_n73537488)
print v(xbgr.mr_n73537920)
print v(xbgr.mr_n73538352)
print v(xbgr.mr_n73538784)
print v(xbgr.mr_n73539216)
print v(xbgr.mr_n73539648)
print v(xbgr.mr_n73540080)
print v(xbgr.mr_n73540512)
print v(xbgr.mr_n73540944)
print v(xbgr.mr_n73541376)
print v(xbgr.mr_n73541808)
print v(xbgr.mr_n73542240)
print v(xbgr.mr_n73542672)
print v(xbgr.mr_n73543104)
print v(xbgr.mr_n73543536)
print v(xbgr.mr_n73543968)
print v(xbgr.mr_n73544400)
print v(xbgr.mr_n73544832)
print v(xbgr.mr_n73545264)
print v(xbgr.mr_n73545696)
print v(xbgr.mr_n73546128)
print v(xbgr.mr_n73546560)
print v(xbgr.mr_n73546992)
print v(xbgr.mr_n73547424)
print v(xbgr.mr_n73547856)
print v(xbgr.mr_n73548176)
print v(xbgr.mr_n73548288)
print v(xbgr.mr_n73548608)
print v(xbgr.mr_n73548720)
print v(xbgr.mr_n73549040)
print v(xbgr.mr_n73549152)
print v(xbgr.mr_n73549472)
print v(xbgr.mr_n73549584)
print v(xbgr.mr_n73549904)
print v(xbgr.mr_n73550016)
print v(xbgr.mr_n73550336)
print v(xbgr.mr_n73550448)
print v(xbgr.mr_n73550768)
print v(xbgr.mr_n73550880)
print v(xbgr.mr_n73551200)
print v(xbgr.mr_n73551312)
print v(xbgr.mr_n73551632)
print v(xbgr.mr_n73551744)
print v(xbgr.mr_n73552064)
print v(xbgr.mr_n73552176)
print v(xbgr.mr_n73552496)
print v(xbgr.mr_n73552608)
print v(xbgr.mr_n73552928)
print v(xbgr.mr_n73553040)
print v(xbgr.mr_n73553360)
print v(xbgr.mr_n73553472)
print v(xbgr.mr_n73553792)
print v(xbgr.mr_n73553904)
print v(xbgr.mr_n73554224)
print v(xbgr.mr_n73554336)
print v(xbgr.mr_n73554656)
print v(xbgr.mr_n73554768)
print v(xbgr.mr_n73555088)
print v(xbgr.mr_n73555200)
print v(xbgr.mr_n73555520)
print v(xbgr.mr_n73555632)
print v(xbgr.mr_n73555952)
print v(xbgr.mr_n73556064)
print v(xbgr.mr_n73556384)
print v(xbgr.mr_n73556496)
print v(xbgr.mr_n73556816)
print v(xbgr.mr_n73556928)
print v(xbgr.mr_n73557248)
print v(xbgr.mr_n73557360)
print v(xbgr.mr_n73557680)
print v(xbgr.mr_n73557792)
print v(xbgr.mr_n73558112)
print v(xbgr.mr_n73558224)
print v(xbgr.mr_n73558544)
print v(xbgr.mr_n73558656)
print v(xbgr.mr_n73558976)
print v(xbgr.mr_n73559088)
print v(xbgr.mr_n73559408)
print v(xbgr.mr_n73559520)
print v(xbgr.mr_n73559840)
print v(xbgr.mr_n73559952)
print v(xbgr.mr_n73560272)
print v(xbgr.mr_n73560384)
print v(xbgr.mr_n73560704)
print v(xbgr.mr_n73560816)
print v(xbgr.mr_n73561136)
print v(xbgr.mr_n73561248)
print v(xbgr.mr_n73561568)
print v(xbgr.mr_n73561680)
print v(xbgr.mr_n73562000)
print v(xbgr.mr_n73562112)
print v(xbgr.mr_n73562432)
print v(xbgr.mr_n73562544)
print v(xbgr.mr_n73562864)
print v(xbgr.mr_n73562976)
print v(xbgr.mr_n73563296)
print v(xbgr.mr_n73563408)
print v(xbgr.mr_n73563728)
print v(xbgr.mr_n73563840)
print v(xbgr.mr_n73564160)
print v(xbgr.mr_n73564272)
print v(xbgr.mr_n73564592)
print v(xbgr.mr_n73564704)
print v(xbgr.mr_n73565024)
print v(xbgr.mr_n73565136)
print v(xbgr.mr_n73565456)
print v(xbgr.mr_n73565568)
print v(xbgr.mr_n73565888)
print v(xbgr.mr_n73566000)
print v(xbgr.mr_n73566320)
print v(xbgr.mr_n73566432)
print v(xbgr.mr_n73566752)
print v(xbgr.mr_n73566864)
print v(xbgr.mr_n73567184)
print v(xbgr.mr_n73567296)
print v(xbgr.mr_n73567616)
print v(xbgr.mr_n73567728)
print v(xbgr.mr_n73568048)
print v(xbgr.mr_n73568160)
print v(xbgr.mr_n73568480)
print v(xbgr.mr_n73568592)
print v(xbgr.mr_n73568912)
print v(xbgr.mr_n73569024)
print v(xbgr.mr_n73569344)
print v(xbgr.mr_n73569456)
print v(xbgr.mr_n73569888)
print v(xbgr.mr_n73570208)
print v(xbgr.mr_n73570320)
print v(xbgr.mr_n73570640)
print v(xbgr.mr_n73570752)
print v(xbgr.mr_n73571072)
print v(xbgr.mr_n73571184)
print v(xbgr.mr_n73571504)
print v(xbgr.mr_n73571616)
print v(xbgr.mr_n73571936)
print v(xbgr.mr_n73572048)
print v(xbgr.mr_n73572368)
print v(xbgr.mr_n73572480)
print v(xbgr.mr_n73572800)
print v(xbgr.mr_n73572912)
print v(xbgr.mr_n73573232)
print v(xbgr.mr_n73573344)
print v(xbgr.mr_n73573664)
print v(xbgr.mr_n73573776)
print v(xbgr.mr_n73574096)
print v(xbgr.mr_n73574208)
print v(xbgr.mr_n73574528)
print v(xbgr.mr_n73574640)
print v(xbgr.mr_n73574960)
print v(xbgr.mr_n73575072)
print v(xbgr.mr_n73575392)
print v(xbgr.mr_n73575504)
print v(xbgr.mr_n73575824)
print v(xbgr.mr_n73575936)
print v(xbgr.mr_n73576256)
print v(xbgr.mr_n73576368)
print v(xbgr.mr_n73576688)
print v(xbgr.mr_n73576800)
print v(xbgr.mr_n73577248)
print v(xbgr.mr_n73577360)
print v(xbgr.mr_n73577680)
print v(xbgr.mr_n73577792)
print v(xbgr.mr_n73578112)
print v(xbgr.mr_n73578224)
print v(xbgr.mr_n73578544)
print v(xbgr.mr_n73578656)
print v(xbgr.mr_n73578976)
print v(xbgr.mr_n73579088)
print v(xbgr.mr_n73579408)
print v(xbgr.mr_n73579520)
print v(xbgr.mr_n73579840)
print v(xbgr.mr_n73579952)
print v(xbgr.mr_n73580272)
print v(xbgr.mr_n73580384)
print v(xbgr.mr_n73580704)
print v(xbgr.mr_n73580816)
print v(xbgr.mr_n73581136)
print v(xbgr.mr_n73581248)
print v(xbgr.mr_n73581568)
print v(xbgr.mr_n73581680)
print v(xbgr.mr_n73582112)
print v(xbgr.mr_n73582432)
print v(xbgr.mr_n73582544)
print v(xbgr.mr_n73582864)
print v(xbgr.mr_n73582976)
print v(xbgr.mr_n73583296)
print v(xbgr.mr_n73583408)
print v(xbgr.mr_n73583728)
print v(xbgr.mr_n73583840)
print v(xbgr.mr_n73584272)
print v(xbgr.mr_n73584704)
print v(xbgr.mr_n73585024)
print v(xbgr.mr_n73585136)
print v(xbgr.mr_n73585456)
print v(xbgr.mr_n73585568)
print v(xbgr.mr_n73585888)
print v(xbgr.mr_n73586000)
print v(xbgr.mr_n73586320)
print v(xbgr.mr_n73586432)
print v(xbgr.mr_n73586752)
print v(xbgr.mr_n73586864)
print v(xbgr.mr_n73587184)
print v(xbgr.mr_n73587296)
print v(xbgr.mr_n73587728)
print v(xbgr.mr_n73588048)
print v(xbgr.mr_n73588160)
print v(xbgr.mr_n73588480)
print v(xbgr.mr_n73588592)
print v(xbgr.mr_n73588912)
print v(xbgr.mr_n73589024)
print v(xbgr.mr_n73589344)
print v(xbgr.mr_n73589456)
print v(xbgr.mr_n73589776)
print v(xbgr.mr_n73589888)
print v(xbgr.mr_n73590208)
print v(xbgr.mr_n73590320)
print v(xbgr.mr_n73590640)
print v(xbgr.mr_n73590752)
print v(xbgr.mr_n73591072)
print v(xbgr.mr_n73591184)
print v(xbgr.mr_n73591504)
print v(xbgr.mr_n73591616)
print v(xbgr.mr_n73591936)
print v(xbgr.mr_n73592048)
print v(xbgr.mr_n73592368)
print v(xbgr.mr_n73592480)
print v(xbgr.mr_n73592800)
print v(xbgr.mr_n73592912)
print v(xbgr.mr_n73593344)
print v(xbgr.mr_n73593776)
print v(xbgr.mr_n73594208)
print v(xbgr.mr_n73594640)
print v(xbgr.mr_n73595136)
print v(xbgr.mr_n73595248)
print v(xbgr.mr_n73595584)
print v(xbgr.mr_n73595696)
print v(xbgr.mr_n73596016)
print v(xbgr.mr_n73596128)
print v(xbgr.mr_n73596496)
print v(xbgr.mr_n73596608)
print v(xbgr.mr_n73596928)
print v(xbgr.mr_n73597040)
print v(xbgr.mr_n73597360)
print v(xbgr.mr_n73597472)
print v(xbgr.mr_n73597712)
print v(xbgr.mr_n73597824)
print v(xbgr.mr_n73598144)
print v(xbgr.mr_n73598256)
print v(xbgr.mr_n73598576)
print v(xbgr.mr_n73598688)
print v(xbgr.mr_n73599008)
print v(xbgr.mr_n73599120)
print v(xbgr.mr_n73599440)
print v(xbgr.mr_n73599552)
print v(xbgr.mr_n73599872)
print v(xbgr.mr_n73599984)
print v(xbgr.mr_n73600304)
print v(xbgr.mr_n73600416)
print v(xbgr.mr_n73600736)
print v(xbgr.mr_n73600848)
print v(xbgr.mr_n73601168)
print v(xbgr.mr_n73601280)
print v(xbgr.mr_n73601600)
print v(xbgr.mr_n73601712)
print v(xbgr.mr_n73602032)
print v(xbgr.mr_n73602144)
print v(xbgr.mr_n73602464)
print v(xbgr.mr_n73602576)
print v(xbgr.mr_n73602896)
print v(xbgr.mr_n73603008)
print v(xbgr.mr_n73603328)
print v(xbgr.mr_n73603440)
print v(xbgr.mr_n73603760)
print v(xbgr.mr_n73603872)
print v(xbgr.mr_n73604192)
print v(xbgr.mr_n73604304)
print v(xbgr.mr_n73604624)
print v(xbgr.mr_n73604736)
print v(xbgr.mr_n73605056)
print v(xbgr.mr_n73605168)
print v(xbgr.mr_n73605488)
print v(xbgr.mr_n73605600)
print v(xbgr.mr_n73605920)
print v(xbgr.mr_n73606032)
print v(xbgr.mr_n73606352)
print v(xbgr.mr_n73606464)
print v(xbgr.mr_n73606784)
print v(xbgr.mr_n73606896)
print v(xbgr.mr_n73607216)
print v(xbgr.mr_n73607328)
print v(xbgr.mr_n73607648)
print v(xbgr.mr_n73607760)
print v(xbgr.mr_n73608080)
print v(xbgr.mr_n73608192)
print v(xbgr.mr_n73608624)
print v(xbgr.mr_n73608944)
print v(xbgr.mr_n73609936)
print v(xbgr.mr_n73610048)
print v(xbgr.mr_n73610368)
print v(xbgr.mr_n73610480)
print v(xbgr.mr_n73610800)
print v(xbgr.mr_n73610912)
print v(xbgr.mr_n73611344)
print v(xbgr.mr_n73611664)
print v(xbgr.mr_n73611776)
print v(xbgr.mr_n73612096)
print v(xbgr.mr_n73612208)
print v(xbgr.mr_n73612528)
print v(xbgr.mr_n73612640)
print v(xbgr.mr_n73612960)
print v(xbgr.mr_n73613072)
print v(xbgr.mr_n73613392)
print v(xbgr.mr_n73613504)
print v(xbgr.mr_n73613936)
print v(xbgr.mr_n73614368)
print v(xbgr.mr_n73614800)
print v(xbgr.mr_n73615232)
print v(xbgr.mr_n73615552)
print v(xbgr.mr_n73615664)
print v(xbgr.mr_n73615984)
print v(xbgr.mr_n73616096)
print v(xbgr.mr_n73616416)
print v(xbgr.mr_n73616528)
print v(xbgr.mr_n73616960)
print v(xbgr.mr_n73617392)
print v(xbgr.mr_n73617712)
print v(xbgr.mr_n73617824)
print v(xbgr.mr_n73618144)
print v(xbgr.mr_n73618256)
print v(xbgr.mr_n73618576)
print v(xbgr.mr_n73618688)
print v(xbgr.mr_n73619008)
print v(xbgr.mr_n73619120)
print v(xbgr.mr_n73619552)
print v(xbgr.mr_n73619984)
print v(xbgr.mr_n73620416)
print v(xbgr.mr_n73620848)
print v(xbgr.mr_n73621280)
print v(xbgr.mr_n73621600)
print v(xbgr.mr_n73621712)
print v(xbgr.mr_n73622032)
print v(xbgr.mr_n73622144)
print v(xbgr.mr_n73622464)
print v(xbgr.mr_n73622576)
print v(xbgr.mr_n73622896)
print v(xbgr.mr_n73623008)
print v(xbgr.mr_n73623328)
print v(xbgr.mr_n73623440)
print v(xbgr.mr_n73623760)
print v(xbgr.mr_n73623872)
print v(xbgr.mr_n73624192)
print v(xbgr.mr_n73624304)
print v(xbgr.mr_n73624624)
print v(xbgr.mr_n73624736)
print v(xbgr.mr_n73625056)
print v(xbgr.mr_n73625168)
print v(xbgr.mr_n73625488)
print v(xbgr.mr_n73625600)
print v(xbgr.mr_n73625920)
print v(xbgr.mr_n73626032)
print v(xbgr.mr_n73626352)
print v(xbgr.mr_n73626464)
print v(xbgr.mr_n73626896)
print v(xbgr.mr_n73627216)
print v(xbgr.mr_n73627328)
print v(xbgr.mr_n73627648)
print v(xbgr.mr_n73627760)
print v(xbgr.mr_n73628080)
print v(xbgr.mr_n73628192)
print v(xbgr.mr_n73628512)
print v(xbgr.mr_n73628624)
print v(xbgr.mr_n73628944)
print v(xbgr.mr_n73629056)
print v(xbgr.mr_n73629488)
print v(xbgr.mr_n73629920)
print v(xbgr.mr_n73630352)
print v(xbgr.mr_n73630784)
print v(xbgr.mr_n73631104)
print v(xbgr.mr_n73631216)
print v(xbgr.mr_n73631536)
print v(xbgr.mr_n73631648)
print v(xbgr.mr_n73631968)
print v(xbgr.mr_n73632080)
print v(xbgr.mr_n73632400)
print v(xbgr.mr_n73632512)
print v(xbgr.mr_n73632832)
print v(xbgr.mr_n73632944)
print v(xbgr.mr_n73633264)
print v(xbgr.mr_n73633376)
print v(xbgr.mr_n73633696)
print v(xbgr.mr_n73633808)
print v(xbgr.mr_n73634128)
print v(xbgr.mr_n73634240)
print v(xbgr.mr_n73634560)
print v(xbgr.mr_n73634672)
print v(xbgr.mr_n73634992)
print v(xbgr.mr_n73635104)
print v(xbgr.mr_n73635424)
print v(xbgr.mr_n73635536)
print v(xbgr.mr_n73635856)
print v(xbgr.mr_n73635968)
print v(xbgr.mr_n73636288)
print v(xbgr.mr_n73636400)
print v(xbgr.mr_n73636720)
print v(xbgr.mr_n73636832)
print v(xbgr.mr_n73637152)
print v(xbgr.mr_n73637264)
print v(xbgr.mr_n73637584)
print v(xbgr.mr_n73637696)
print v(xbgr.mr_n73638016)
print v(xbgr.mr_n73638128)
print v(xbgr.mr_n73638448)
print v(xbgr.mr_n73638560)
print v(xbgr.mr_n73638880)
print v(xbgr.mr_n73638992)
print v(xbgr.mr_n73639312)
print v(xbgr.mr_n73639424)
print v(xbgr.mr_n73639744)
print v(xbgr.mr_n73639856)
print v(xbgr.mr_n73640176)
print v(xbgr.mr_n73640288)
print v(xbgr.mr_n73640608)
print v(xbgr.mr_n73640720)
print v(xbgr.mr_n73641040)
print v(xbgr.mr_n73641152)
print v(xbgr.mr_n73641472)
print v(xbgr.mr_n73641584)
print v(xbgr.mr_n73641904)
print v(xbgr.mr_n73642016)
print v(xbgr.mr_n73642336)
print v(xbgr.mr_n73642448)
print v(xbgr.mr_n73642768)
print v(xbgr.mr_n73642880)
print v(xbgr.mr_n73643200)
print v(xbgr.mr_n73643312)
print v(xbgr.mr_n73643632)
print v(xbgr.mr_n73643744)
print v(xbgr.mr_n73644064)
print v(xbgr.mr_n73644176)
print v(xbgr.mr_n73644496)
print v(xbgr.mr_n73644608)
print v(xbgr.mr_n73644928)
print v(xbgr.mr_n73645040)
print v(xbgr.mr_n73645360)
print v(xbgr.mr_n73645472)
print v(xbgr.mr_n73645792)
print v(xbgr.mr_n73645904)
print v(xbgr.mr_n73646224)
print v(xbgr.mr_n73646336)
print v(xbgr.mr_n73646656)
print v(xbgr.mr_n73646768)
print v(xbgr.mr_n73647088)
print v(xbgr.mr_n73647200)
print v(xbgr.mr_n73647520)
print v(xbgr.mr_n73647632)
print v(xbgr.mr_n73647952)
print v(xbgr.mr_n73648064)
print v(xbgr.mr_n73648384)
print v(xbgr.mr_n73648496)
print v(xbgr.mr_n73648816)
print v(xbgr.mr_n73648928)
print v(xbgr.mr_n73649248)
print v(xbgr.mr_n73649360)
print v(xbgr.mr_n73649680)
print v(xbgr.mr_n73649792)
print v(xbgr.mr_n73650224)
print v(xbgr.mr_n73650656)
print v(xbgr.mr_n73650976)
print v(xbgr.mr_n73651088)
print v(xbgr.mr_n73651408)
print v(xbgr.mr_n73651520)
print v(xbgr.mr_n73651840)
print v(xbgr.mr_n73651952)
print v(xbgr.mr_n73652272)
print v(xbgr.mr_n73652384)
print v(xbgr.mr_n73652816)
print v(xbgr.mr_n73653248)
print v(xbgr.mr_n73653568)
print v(xbgr.mr_n73653680)
print v(xbgr.mr_n73654000)
print v(xbgr.mr_n73654112)
print v(xbgr.mr_n73654432)
print v(xbgr.mr_n73654544)
print v(xbgr.mr_n73654976)
print v(xbgr.mr_n73655408)
print v(xbgr.mr_n73655840)
print v(xbgr.mr_n73656272)
print v(xbgr.mr_n73656704)
print v(xbgr.mr_n73657136)
print v(xbgr.mr_n73657568)
print v(xbgr.mr_n73658000)
print v(xbgr.mr_n73658432)
print v(xbgr.mr_n73658864)
print v(xbgr.mr_n73659296)
print v(xbgr.mr_n73659728)
print v(xbgr.mr_n73660160)
print v(xbgr.mr_n73660480)
print v(xbgr.mr_n73660912)
print v(xbgr.mr_n73661344)
print v(xbgr.mr_n73661776)
print v(xbgr.mr_n73662208)
print v(xbgr.mr_n73662640)
print v(xbgr.mr_n73663072)
print v(xbgr.mr_n73663504)
print v(xbgr.mr_n73663936)
print v(xbgr.mr_n73664048)
print v(xbgr.mr_n73664368)
print v(xbgr.mr_n73664480)
print v(xbgr.mr_n73664800)
print v(xbgr.mr_n73664912)
print v(xbgr.mr_n73665232)
print v(xbgr.mr_n73665344)
print v(xbgr.mr_n73665664)
print v(xbgr.mr_n73665776)
print v(xbgr.mr_n73666096)
print v(xbgr.mr_n73666208)
print v(xbgr.mr_n73666528)
print v(xbgr.mr_n73666640)
print v(xbgr.mr_n73666960)
print v(xbgr.mr_n73667072)
print v(xbgr.mr_n73667392)
print v(xbgr.mr_n73667824)
print v(xbgr.mr_n73668256)
print v(xbgr.mr_n73668688)
print v(xbgr.mr_n73669120)
print v(xbgr.mr_n73669552)
print v(xbgr.mr_n73669984)
print v(xbgr.mr_n73670416)
print v(xbgr.mr_n73670848)
print v(xbgr.mr_n73671280)
print v(xbgr.mr_n73671824)
print v(xbgr.mr_n73672256)
print v(xbgr.mr_n73672688)
print v(xbgr.mr_n73673120)
print v(xbgr.mr_n73673552)
print v(xbgr.mr_n73673984)
print v(xbgr.mr_n73674416)
print v(xbgr.mr_n73674848)
print v(xbgr.mr_n73675280)
print v(xbgr.mr_n73675712)
print v(xbgr.mr_n73676144)
print v(xbgr.mr_n73676576)
print v(xbgr.mr_n73677008)
print v(xbgr.mr_n73677440)
print v(xbgr.mr_n73677872)
print v(xbgr.mr_n73678304)
print v(xbgr.mr_n73678736)
print v(xbgr.mr_n73679168)
print v(xbgr.mr_n73679600)
print v(xbgr.mr_n73680032)
print v(xbgr.mr_n73680464)
print v(xbgr.mr_n73680896)
print v(xbgr.mr_n73681328)
print v(xbgr.mr_n73681760)
print v(xbgr.mr_n73682192)
print v(xbgr.mr_n73682624)
print v(xbgr.mr_n73683056)
print v(xbgr.mr_n73683488)
print v(xbgr.mr_n73683920)
print v(xbgr.mr_n73684352)
print v(xbgr.mr_n73684784)
print v(xbgr.mr_n73685216)
print v(xbgr.mr_n73685648)
print v(xbgr.mr_n73686080)
print v(xbgr.mr_n73686512)
print v(xbgr.mr_n73686944)
print v(xbgr.mr_n73687376)
print v(xbgr.mr_n73687808)
print v(xbgr.mr_n73688240)
print v(xbgr.mr_n73688672)
print v(xbgr.mr_n73689104)
print v(xbgr.mr_n73689536)
print v(xbgr.mr_n73689968)
print v(xbgr.mr_n73690400)
print v(xbgr.mr_n73690832)
print v(xbgr.mr_n73691264)
print v(xbgr.mr_n73691696)
print v(xbgr.mr_n73692128)
print v(xbgr.mr_n73692560)
print v(xbgr.mr_n73692992)
print v(xbgr.mr_n73693424)
print v(xbgr.mr_n73693856)
print v(xbgr.mr_n73694288)
print v(xbgr.mr_n73694720)
print v(xbgr.mr_n73695152)
print v(xbgr.mr_n73695584)
print v(xbgr.mr_n73696016)
print v(xbgr.mr_n73696448)
print v(xbgr.mr_n73696880)
print v(xbgr.mr_n73697312)
print v(xbgr.mr_n73697744)
print v(xbgr.mr_n73698176)
print v(xbgr.mr_n73698608)
print v(xbgr.mr_n73699040)
print v(xbgr.mr_n73699360)
print v(xbgr.mr_n73699792)
print v(xbgr.mr_n73700224)
print v(xbgr.mr_n73700656)
print v(xbgr.mr_n73701088)
print v(xbgr.mr_n73701520)
print v(xbgr.mr_n73702064)
print v(xbgr.mr_n73702496)
print v(xbgr.mr_n73702928)
print v(xbgr.mr_n73703360)
print v(xbgr.mr_n73703792)
print v(xbgr.mr_n73704224)
print v(xbgr.mr_n73704656)
print v(xbgr.mr_n73705088)
print v(xbgr.mr_n73705520)
print v(xbgr.mr_n73705952)
print v(xbgr.mr_n73706384)
print v(xbgr.mr_n73706816)
print v(xbgr.mr_n73707248)
print v(xbgr.mr_n73707680)
print v(xbgr.mr_n73708112)
print v(xbgr.mr_n73708544)
print v(xbgr.mr_n73708976)
print v(xbgr.mr_n73709408)
print v(xbgr.mr_n73709840)
print v(xbgr.mr_n73710272)
print v(xbgr.mr_n73710704)
print v(xbgr.mr_n73711136)
print v(xbgr.mr_n73711568)
print v(xbgr.mr_n73712000)
print v(xbgr.mr_n73712432)
print v(xbgr.mr_n73712864)
print v(xbgr.mr_n73713184)
print v(xbgr.mr_n73713296)
print v(xbgr.mr_n73713616)
print v(xbgr.mr_n73713728)
print v(xbgr.mr_n73714048)
print v(xbgr.mr_n73714160)
print v(xbgr.mr_n73714480)
print v(xbgr.mr_n73714592)
print v(xbgr.mr_n73714912)
print v(xbgr.mr_n73715024)
print v(xbgr.mr_n73715344)
print v(xbgr.mr_n73715456)
print v(xbgr.mr_n73715776)
print v(xbgr.mr_n73715888)
print v(xbgr.mr_n73716208)
print v(xbgr.mr_n73716320)
print v(xbgr.mr_n73716640)
print v(xbgr.mr_n73716752)
print v(xbgr.mr_n73717072)
print v(xbgr.mr_n73717184)
print v(xbgr.mr_n73717504)
print v(xbgr.mr_n73717616)
print v(xbgr.mr_n73717936)
print v(xbgr.mr_n73718048)
print v(xbgr.mr_n73718368)
print v(xbgr.mr_n73718480)
print v(xbgr.mr_n73718800)
print v(xbgr.mr_n73718912)
print v(xbgr.mr_n73719232)
print v(xbgr.mr_n73719344)
print v(xbgr.mr_n73719664)
print v(xbgr.mr_n73720096)
print v(xbgr.mr_n73720208)
print v(xbgr.mr_n73720528)
print v(xbgr.mr_n73720960)
print v(xbgr.mr_n73721072)
print v(xbgr.mr_n73721392)
print v(xbgr.mr_n73721504)
print v(xbgr.mr_n73721824)
print v(xbgr.mr_n73721936)
print v(xbgr.mr_n73722256)
print v(xbgr.mr_n73722368)
print v(xbgr.mr_n73722688)
print v(xbgr.mr_n73722800)
print v(xbgr.mr_n73723120)
print v(xbgr.mr_n73723232)
print v(xbgr.mr_n73723552)
print v(xbgr.mr_n73723664)
print v(xbgr.mr_n73723984)
print v(xbgr.mr_n73724416)
print v(xbgr.mr_n73724528)
print v(xbgr.mr_n73724848)
print v(xbgr.mr_n73724960)
print v(xbgr.mr_n73725280)
print v(xbgr.mr_n73725392)
print v(xbgr.mr_n73725712)
print v(xbgr.mr_n73725824)
print v(xbgr.mr_n73726144)
print v(xbgr.mr_n73726256)
print v(xbgr.mr_n73726576)
print v(xbgr.mr_n73726688)
print v(xbgr.mr_n73727008)
print v(xbgr.mr_n73727120)
print v(xbgr.mr_n73727440)
print v(xbgr.mr_n73727552)
print v(xbgr.mr_n73727872)
print v(xbgr.mr_n73727984)
print v(xbgr.mr_n73728304)
print v(xbgr.mr_n73728416)
print v(xbgr.mr_n73728736)
print v(xbgr.mr_n73728848)
print v(xbgr.mr_n73729168)
print v(xbgr.mr_n73729600)
print v(xbgr.mr_n73729712)
print v(xbgr.mr_n73730032)
print v(xbgr.mr_n73730144)
print v(xbgr.mr_n73730464)
print v(xbgr.mr_n73730576)
print v(xbgr.mr_n73730896)
print v(xbgr.mr_n73731008)
print v(xbgr.mr_n73731328)
print v(xbgr.mr_n73731440)
print v(xbgr.mr_n73731760)
print v(xbgr.mr_n73731872)
print v(xbgr.mr_n73732192)
print v(xbgr.mr_n73732304)
print v(xbgr.mr_n73732624)
print v(xbgr.mr_n73732736)
print v(xbgr.mr_n73733056)
print v(xbgr.mr_n73733168)
print v(xbgr.mr_n73733488)
print v(xbgr.mr_n73733600)
print v(xbgr.mr_n73733920)
print v(xbgr.mr_n73734032)
print v(xbgr.mr_n73734352)
print v(xbgr.mr_n73734464)
print v(xbgr.mr_n73734784)
print v(xbgr.mr_n73734896)
print v(xbgr.mr_n73735216)
print v(xbgr.mr_n73735648)
print v(xbgr.mr_n73735760)
print v(xbgr.mr_n73736080)
print v(xbgr.mr_n73736192)
print v(xbgr.mr_n73736512)
print v(xbgr.mr_n73736624)
print v(xbgr.mr_n73736944)
print v(xbgr.mr_n73737056)
print v(xbgr.mr_n73737376)
print v(xbgr.mr_n73737488)
print v(xbgr.mr_n73737808)
print v(xbgr.mr_n73737920)
print v(xbgr.mr_n73738240)
print v(xbgr.mr_n73738352)
print v(xbgr.mr_n73738672)
print v(xbgr.mr_n73739104)
print v(xbgr.mr_n73739216)
print v(xbgr.mr_n73739536)
print v(xbgr.mr_n73739968)
print v(xbgr.mr_n73740080)
print v(xbgr.mr_n73740400)
print v(xbgr.mr_n73740512)
print v(xbgr.mr_n73740832)
print v(xbgr.mr_n73740944)
print v(xbgr.mr_n73741264)
print v(xbgr.mr_n73741376)
print v(xbgr.mr_n73741696)
print v(xbgr.mr_n73741808)
print v(xbgr.mr_n73742128)
print v(xbgr.mr_n73742240)
print v(xbgr.mr_n73742560)
print v(xbgr.mr_n73742672)
print v(xbgr.mr_n73742992)
print v(xbgr.mr_n73743104)
print v(xbgr.mr_n73743424)
print v(xbgr.mr_n73743536)
print v(xbgr.mr_n73743856)
print v(xbgr.mr_n73743968)
print v(xbgr.mr_n73744288)
print v(xbgr.mr_n73744400)
print v(xbgr.mr_n73744720)
print v(xbgr.mr_n73744832)
print v(xbgr.mr_n73745264)
print v(xbgr.mr_n73745696)
print v(xbgr.mr_n73746128)
print v(xbgr.mr_n73746560)
print v(xbgr.mr_n73746992)
print v(xbgr.mr_n73747424)
print v(xbgr.mr_n73747856)
print v(xbgr.mr_n73748288)
print v(xbgr.mr_n73748720)
print v(xbgr.mr_n73749152)
print v(xbgr.mr_n73749584)
print v(xbgr.mr_n73750016)
print v(xbgr.mr_n73750448)
print v(xbgr.mr_n73750880)
print v(xbgr.mr_n73751312)
print v(xbgr.mr_n73751744)
print v(xbgr.mr_n73752176)
print v(xbgr.mr_n73752608)
print v(xbgr.mr_n73753040)
print v(xbgr.mr_n73753472)
print v(xbgr.mr_n73753904)
print v(xbgr.mr_n73754336)
print v(xbgr.mr_n73754768)
print v(xbgr.mr_n73755200)
print v(xbgr.mr_n73755632)
print v(xbgr.mr_n73756064)
print v(xbgr.mr_n73756496)
print v(xbgr.mr_n73756928)
print v(xbgr.mr_n73757360)
print v(xbgr.mr_n73757792)
print v(xbgr.mr_n73758224)
print v(xbgr.mr_n73758656)
print v(xbgr.mr_n73759088)
print v(xbgr.mr_n73759520)
print v(xbgr.mr_n73759952)
print v(xbgr.mr_n73760384)
print v(xbgr.mr_n73760816)
print v(xbgr.mr_n73761248)
print v(xbgr.mr_n73761680)
print v(xbgr.mr_n73762112)
print v(xbgr.mr_n73762544)
print v(xbgr.mr_n73762976)
print v(xbgr.mr_n73763408)
print v(xbgr.mr_n73763840)
print v(xbgr.mr_n73764272)
print v(xbgr.mr_n73764704)
print v(xbgr.mr_n73765136)
print v(xbgr.mr_n73765568)
print v(xbgr.mr_n73766000)
print v(xbgr.mr_n73766432)
print v(xbgr.mr_n73766864)
print v(xbgr.mr_n73767296)
print v(xbgr.mr_n73767728)
print v(xbgr.mr_n73768160)
print v(xbgr.mr_n73768592)
print v(xbgr.mr_n73769024)
print v(xbgr.mr_n73769456)
print v(xbgr.mr_n73769888)
print v(xbgr.mr_n73770320)
print v(xbgr.mr_n73770752)
print v(xbgr.mr_n73771184)
print v(xbgr.mr_n73771616)
print v(xbgr.mr_n73772048)
print v(xbgr.mr_n73772480)
print v(xbgr.mr_n73772912)
print v(xbgr.mr_n73773344)
print v(xbgr.mr_n73773776)
print v(xbgr.mr_n73774208)
print v(xbgr.mr_n73774640)
print v(xbgr.mr_n73775072)
print v(xbgr.mr_n73775504)
print v(xbgr.mr_n73775936)
print v(xbgr.mr_n73776368)
print v(xbgr.mr_n73776800)
print v(xbgr.mr_n73777232)
print v(xbgr.mr_n73777664)
print v(xbgr.mr_n73778096)
print v(xbgr.mr_n73778528)
print v(xbgr.mr_n73778848)
print v(xbgr.mr_n73778960)
print v(xbgr.mr_n73779280)
print v(xbgr.mr_n73779392)
print v(xbgr.mr_n73779824)
print v(xbgr.mr_n73780256)
print v(xbgr.mr_n73780576)
print v(xbgr.mr_n73780688)
print v(xbgr.mr_n73781008)
print v(xbgr.mr_n73781552)
print v(xbgr.mr_n73781984)
print v(xbgr.mr_n73782304)
print v(xbgr.mr_n73782416)
print v(xbgr.mr_n73782736)
print v(xbgr.mr_n73782848)
print v(xbgr.mr_n73783168)
print v(xbgr.mr_n73783280)
print v(xbgr.mr_n73783600)
print v(xbgr.mr_n73783712)
print v(xbgr.mr_n73784032)
print v(xbgr.mr_n73784144)
print v(xbgr.mr_n73784464)
print v(xbgr.mr_n73784576)
print v(xbgr.mr_n73784896)
print v(xbgr.mr_n73785008)
print v(xbgr.mr_n73785328)
print v(xbgr.mr_n73785440)
print v(xbgr.mr_n73785760)
print v(xbgr.mr_n73785872)
print v(xbgr.mr_n73786192)
print v(xbgr.mr_n73786304)
print v(xbgr.mr_n73786624)
print v(xbgr.mr_n73786736)
print v(xbgr.mr_n73787056)
print v(xbgr.mr_n73787168)
print v(xbgr.mr_n73787600)
print v(xbgr.mr_n73788032)
print v(xbgr.mr_n73788352)
print v(xbgr.mr_n73788464)
print v(xbgr.mr_n73788784)
print v(xbgr.mr_n73788896)
print v(xbgr.mr_n73789328)
print v(xbgr.mr_n73789760)
print v(xbgr.mr_n73790192)
print v(xbgr.mr_n73790624)
print v(xbgr.mr_n73791056)
print v(xbgr.mr_n73791488)
print v(xbgr.mr_n73791920)
print v(xbgr.mr_n73792352)
print v(xbgr.mr_n73792784)
print v(xbgr.mr_n73793216)
print v(xbgr.mr_n73793648)
print v(xbgr.mr_n73794080)
print v(xbgr.mr_n73794512)
print v(xbgr.mr_n73794944)
print v(xbgr.mr_n73795376)
print v(xbgr.mr_n73795808)
print v(xbgr.mr_n73796240)
print v(xbgr.mr_n73796672)
print v(xbgr.mr_n73797104)
print v(xbgr.mr_n73797536)
print v(xbgr.mr_n73797968)
print v(xbgr.mr_n73798400)
print v(xbgr.mr_n73798832)
print v(xbgr.mr_n73799264)
print v(xbgr.mr_n73799696)
print v(xbgr.mr_n73800128)
print v(xbgr.mr_n73800560)
print v(xbgr.mr_n73800992)
print v(xbgr.mr_n73801424)
print v(xbgr.mr_n73801856)
print v(xbgr.mr_n73802288)
print v(xbgr.mr_n73802720)
print v(xbgr.mr_n73803152)
print v(xbgr.mr_n73803584)
print v(xbgr.mr_n73804016)
print v(xbgr.mr_n73804448)
print v(xbgr.mr_n73804880)
print v(xbgr.mr_n73805312)
print v(xbgr.mr_n73805744)
print v(xbgr.mr_n73806176)
print v(xbgr.mr_n73806608)
print v(xbgr.mr_n73807040)
print v(xbgr.mr_n73807472)
print v(xbgr.mr_n73807904)
print v(xbgr.mr_n73808336)
print v(xbgr.mr_n73808768)
print v(xbgr.mr_n73809200)
print v(xbgr.mr_n73809632)
print v(xbgr.mr_n73810064)
print v(xbgr.mr_n73810496)
print v(xbgr.mr_n73810928)
print v(xbgr.mr_n73811360)
print v(xbgr.mr_n73811792)
print v(xbgr.mr_n73812224)
print v(xbgr.mr_n73812656)
print v(xbgr.mr_n73813088)
print v(xbgr.mr_n73813520)
print v(xbgr.mr_n73813952)
print v(xbgr.mr_n73814384)
print v(xbgr.mr_n73814816)
print v(xbgr.mr_n73815248)
print v(xbgr.mr_n73815680)
print v(xbgr.mr_n73816112)
print v(xbgr.mr_n73816544)
print v(xbgr.mr_n73816976)
print v(xbgr.mr_n73817408)
print v(xbgr.mr_n73817840)
print v(xbgr.mr_n73818272)
print v(xbgr.mr_n73818704)
print v(xbgr.mr_n73819136)
print v(xbgr.mr_n73819568)
print v(xbgr.mr_n73820000)
print v(xbgr.mr_n73820432)
print v(xbgr.mr_n73820864)
print v(xbgr.mr_n73821296)
print v(xbgr.mr_n73821728)
print v(xbgr.mr_n73822160)
print v(xbgr.mr_n73822592)
print v(xbgr.mr_n73823024)
print v(xbgr.mr_n73823456)
print v(xbgr.mr_n73823888)
print v(xbgr.mr_n73824320)
print v(xbgr.mr_n73824752)
print v(xbgr.mr_n73825184)
print v(xbgr.mr_n73825616)
print v(xbgr.mr_n73826048)
print v(xbgr.mr_n73826480)
print v(xbgr.mr_n73826912)
print v(xbgr.mr_n73827344)
print v(xbgr.mr_n73827776)
print v(xbgr.mr_n73828208)
print v(xbgr.mr_n73828640)
print v(xbgr.mr_n73829072)
print v(xbgr.mr_n73829504)
print v(xbgr.mr_n73829936)
print v(xbgr.mr_n73830368)
print v(xbgr.mr_n73830800)
print v(xbgr.mr_n73831232)
print v(xbgr.mr_n73831664)
print v(xbgr.mr_n73832096)
print v(xbgr.mr_n73832528)
print v(xbgr.mr_n73832960)
print v(xbgr.mr_n73833392)
print v(xbgr.mr_n73833824)
print v(xbgr.mr_n73834256)
print v(xbgr.mr_n73834688)
print v(xbgr.mr_n73835120)
print v(xbgr.mr_n73835552)
print v(xbgr.mr_n73835984)
print v(xbgr.mr_n73836416)
print v(xbgr.mr_n73836848)
print v(xbgr.mr_n73837280)
print v(xbgr.mr_n73837712)
print v(xbgr.mr_n73838144)
print v(xbgr.mr_n73838576)
print v(xbgr.mr_n73839008)
print v(xbgr.mr_n73839440)
print v(xbgr.mr_n73839872)
print v(xbgr.mr_n73840304)
print v(xbgr.mr_n73840736)
print v(xbgr.mr_n73841168)
print v(xbgr.mr_n73841600)
print v(xbgr.mr_n73842032)
print v(xbgr.mr_n73842464)
print v(xbgr.mr_n73842896)
print v(xbgr.mr_n73843328)
print v(xbgr.mr_n73843760)
print v(xbgr.mr_n73844192)
print v(xbgr.mr_n73844624)
print v(xbgr.mr_n73845056)
print v(xbgr.mr_n73845488)
print v(xbgr.mr_n73845920)
print v(xbgr.mr_n73846352)
print v(xbgr.mr_n73846784)
print v(xbgr.mr_n73847216)
print v(xbgr.mr_n73847648)
print v(xbgr.mr_n73847968)
print v(xbgr.mr_n73848080)
print v(xbgr.mr_n73848400)
print v(xbgr.mr_n73848512)
print v(xbgr.mr_n73848832)
print v(xbgr.mr_n73848944)
print v(xbgr.mr_n73849264)
print v(xbgr.mr_n73849376)
print v(xbgr.mr_n73849696)
print v(xbgr.mr_n73849808)
print v(xbgr.mr_n73850128)
print v(xbgr.mr_n73850240)
print v(xbgr.mr_n73850560)
print v(xbgr.mr_n73850672)
print v(xbgr.mr_n73850992)
print v(xbgr.mr_n73851104)
print v(xbgr.mr_n73851424)
print v(xbgr.mr_n73851536)
print v(xbgr.mr_n73851856)
print v(xbgr.mr_n73851968)
print v(xbgr.mr_n73852288)
print v(xbgr.mr_n73852400)
print v(xbgr.mr_n73852720)
print v(xbgr.mr_n73852832)
print v(xbgr.mr_n73853152)
print v(xbgr.mr_n73853264)
print v(xbgr.mr_n73853584)
print v(xbgr.mr_n73853696)
print v(xbgr.mr_n73854016)
print v(xbgr.mr_n73854128)
print v(xbgr.mr_n73854448)
print v(xbgr.mr_n73854560)
print v(xbgr.mr_n73854880)
print v(xbgr.mr_n73854992)
print v(xbgr.mr_n73855312)
print v(xbgr.mr_n73855424)
print v(xbgr.mr_n73855744)
print v(xbgr.mr_n73855856)
print v(xbgr.mr_n73856176)
print v(xbgr.mr_n73856288)
print v(xbgr.mr_n73856608)
print v(xbgr.mr_n73856720)
print v(xbgr.mr_n73857040)
print v(xbgr.mr_n73857152)
print v(xbgr.mr_n73857472)
print v(xbgr.mr_n73857584)
print v(xbgr.mr_n73857904)
print v(xbgr.mr_n73858016)
print v(xbgr.mr_n73858336)
print v(xbgr.mr_n73858448)
print v(xbgr.mr_n73858768)
print v(xbgr.mr_n73858880)
print v(xbgr.mr_n73859200)
print v(xbgr.mr_n73859312)
print v(xbgr.mr_n73859632)
print v(xbgr.mr_n73859744)
print v(xbgr.mr_n73860064)
print v(xbgr.mr_n73860176)
print v(xbgr.mr_n73860496)
print v(xbgr.mr_n73860608)
print v(xbgr.mr_n73861040)
print v(xbgr.mr_n73861472)
print v(xbgr.mr_n73861904)
print v(xbgr.mr_n73862336)
print v(xbgr.mr_n73862656)
print v(xbgr.mr_n73862768)
print v(xbgr.mr_n73863088)
print v(xbgr.mr_n73863200)
print v(xbgr.mr_n73863520)
print v(xbgr.mr_n73863632)
print v(xbgr.mr_n73863952)
print v(xbgr.mr_n73864064)
print v(xbgr.mr_n73864384)
print v(xbgr.mr_n73864496)
print v(xbgr.mr_n73864816)
print v(xbgr.mr_n73864928)
print v(xbgr.mr_n73865360)
print v(xbgr.mr_n73865792)
print v(xbgr.mr_n73866224)
print v(xbgr.mr_n73866544)
print v(xbgr.mr_n73866656)
print v(xbgr.mr_n73866976)
print v(xbgr.mr_n73867088)
print v(xbgr.mr_n73867408)
print v(xbgr.mr_n73867520)
print v(xbgr.mr_n73867840)
print v(xbgr.mr_n73867952)
print v(xbgr.mr_n73868272)
print v(xbgr.mr_n73868384)
print v(xbgr.mr_n73868704)
print v(xbgr.mr_n73868816)
print v(xbgr.mr_n73869136)
print v(xbgr.mr_n73869248)
print v(xbgr.mr_n73869568)
print v(xbgr.mr_n73869680)
print v(xbgr.mr_n73870000)
print v(xbgr.mr_n73870112)
print v(xbgr.mr_n73870432)
print v(xbgr.mr_n73870544)
print v(xbgr.mr_n73870976)
print v(xbgr.mr_n73871408)
print v(xbgr.mr_n73871840)
print v(xbgr.mr_n73872272)
print v(xbgr.mr_n73872704)
print v(xbgr.mr_n73873136)
print v(xbgr.mr_n73873568)
print v(xbgr.mr_n73874000)
print v(xbgr.mr_n73874432)
print v(xbgr.mr_n73874864)
print v(xbgr.mr_n73875296)
print v(xbgr.mr_n73875728)
print v(xbgr.mr_n73876160)
print v(xbgr.mr_n73876480)
print v(xbgr.mr_n73876592)
print v(xbgr.mr_n73876912)
print v(xbgr.mr_n73877024)
print v(xbgr.mr_n73877344)
print v(xbgr.mr_n73877456)
print v(xbgr.mr_n73877776)
print v(xbgr.mr_n73877888)
print v(xbgr.mr_n73878208)
print v(xbgr.mr_n73878320)
print v(xbgr.mr_n73878752)
print v(xbgr.mr_n73879184)
print v(xbgr.mr_n73879616)
print v(xbgr.mr_n73880048)
print v(xbgr.mr_n73880480)
print v(xbgr.mr_n73880912)
print v(xbgr.mr_n73881232)
print v(xbgr.mr_n73881344)
print v(xbgr.mr_n73881664)
print v(xbgr.mr_n73881776)
print v(xbgr.mr_n73882208)
print v(xbgr.mr_n73882640)
print v(xbgr.mr_n73882960)
print v(xbgr.mr_n73883072)
print v(xbgr.mr_n73883392)
print v(xbgr.mr_n73883504)
print v(xbgr.mr_n73883824)
print v(xbgr.mr_n73883936)
print v(xbgr.mr_n73884256)
print v(xbgr.mr_n73884368)
print v(xbgr.mr_n73884688)
print v(xbgr.mr_n73884800)
print v(xbgr.mr_n73885120)
print v(xbgr.mr_n73885232)
print v(xbgr.mr_n73885552)
print v(xbgr.mr_n73885664)
print v(xbgr.mr_n73885984)
print v(xbgr.mr_n73886096)
print v(xbgr.mr_n73886416)
print v(xbgr.mr_n73886528)
print v(xbgr.mr_n73886848)
print v(xbgr.mr_n73886960)
print v(xbgr.mr_n73887280)
print v(xbgr.mr_n73887392)
print v(xbgr.mr_n73887712)
print v(xbgr.mr_n73887824)
print v(xbgr.mr_n73888144)
print v(xbgr.mr_n73888256)
print v(xbgr.mr_n73888576)
print v(xbgr.mr_n73888688)
print v(xbgr.mr_n73889120)
print v(xbgr.mr_n73889552)
print v(xbgr.mr_n73889872)
print v(xbgr.mr_n73889984)
print v(xbgr.mr_n73890304)
print v(xbgr.mr_n73890416)
print v(xbgr.mr_n73890736)
print v(xbgr.mr_n73890848)
print v(xbgr.mr_n73891168)
print v(xbgr.mr_n73891280)
print v(xbgr.mr_n73891600)
print v(xbgr.mr_n73891712)
print v(xbgr.mr_n73892032)
print v(xbgr.mr_n73892144)
print v(xbgr.mr_n73892576)
print v(xbgr.mr_n73893008)
print v(xbgr.mr_n73893328)
print v(xbgr.mr_n73893440)
print v(xbgr.mr_n73893760)
print v(xbgr.mr_n73893872)
print v(xbgr.mr_n73894192)
print v(xbgr.mr_n73894304)
print v(xbgr.mr_n73894624)
print v(xbgr.mr_n73894736)
print v(xbgr.mr_n73895056)
print v(xbgr.mr_n73895168)
print v(xbgr.mr_n73895488)
print v(xbgr.mr_n73895600)
print v(xbgr.mr_n73895920)
print v(xbgr.mr_n73896032)
print v(xbgr.mr_n73896352)
print v(xbgr.mr_n73896464)
print v(xbgr.mr_n73896784)
print v(xbgr.mr_n73896896)
print v(xbgr.mr_n73897216)
print v(xbgr.mr_n73897328)
print v(xbgr.mr_n73897648)
print v(xbgr.mr_n73897760)
print v(xbgr.mr_n73898080)
print v(xbgr.mr_n73898192)
print v(xbgr.mr_n73898512)
print v(xbgr.mr_n73898624)
print v(xbgr.mr_n73898944)
print v(xbgr.mr_n73899056)
print v(xbgr.mr_n73899376)
print v(xbgr.mr_n73899488)
print v(xbgr.mr_n73899808)
print v(xbgr.mr_n73899920)
print v(xbgr.mr_n73900240)
print v(xbgr.mr_n73900352)
print v(xbgr.mr_n73900672)
print v(xbgr.mr_n73900784)
print v(xbgr.mr_n73901104)
print v(xbgr.mr_n73901216)
print v(xbgr.mr_n73901536)
print v(xbgr.mr_n73901648)
print v(xbgr.mr_n73901968)
print v(xbgr.mr_n73902080)
print v(xbgr.mr_n73902400)
print v(xbgr.mr_n73902512)
print v(xbgr.mr_n73902832)
print v(xbgr.mr_n73902944)
print v(xbgr.mr_n73903264)
print v(xbgr.mr_n73903376)
print v(xbgr.mr_n73903696)
print v(xbgr.mr_n73903808)
print v(xbgr.mr_n73904128)
print v(xbgr.mr_n73904240)
print v(xbgr.mr_n73904560)
print v(xbgr.mr_n73904672)
print v(xbgr.mr_n73904992)
print v(xbgr.mr_n73905104)
print v(xbgr.mr_n73905424)
print v(xbgr.mr_n73905536)
print v(xbgr.mr_n73905856)
print v(xbgr.mr_n73905968)
print v(xbgr.mr_n73906288)
print v(xbgr.mr_n73906400)
print v(xbgr.mr_n73906720)
print v(xbgr.mr_n73906832)
print v(xbgr.mr_n73907152)
print v(xbgr.mr_n73907264)
print v(xbgr.mr_n73907584)
print v(xbgr.mr_n73907696)
print v(xbgr.mr_n73908016)
print v(xbgr.mr_n73908128)
print v(xbgr.mr_n73908448)
print v(xbgr.mr_n73908560)
print v(xbgr.mr_n73908880)
print v(xbgr.mr_n73908992)
print v(xbgr.mr_n73909312)
print v(xbgr.mr_n73909424)
print v(xbgr.mr_n73909744)
print v(xbgr.mr_n73909856)
print v(xbgr.mr_n73910176)
print v(xbgr.mr_n73910288)
print v(xbgr.mr_n73910608)
print v(xbgr.mr_n73910720)
print v(xbgr.mr_n73911040)
print v(xbgr.mr_n73911152)
print v(xbgr.mr_n73911472)
print v(xbgr.mr_n73911584)
print v(xbgr.mr_n73911904)
print v(xbgr.mr_n73912016)
print v(xbgr.mr_n73912336)
print v(xbgr.mr_n73912448)
print v(xbgr.mr_n73912768)
print v(xbgr.mr_n73912880)
print v(xbgr.mr_n73913200)
print v(xbgr.mr_n73913312)
print v(xbgr.mr_n73913632)
print v(xbgr.mr_n73913744)
print v(xbgr.mr_n73914064)
print v(xbgr.mr_n73914176)
print v(xbgr.mr_n73914496)
print v(xbgr.mr_n73914608)
print v(xbgr.mr_n73914928)
print v(xbgr.mr_n73915040)
print v(xbgr.mr_n73915360)
print v(xbgr.mr_n73915472)
print v(xbgr.mr_n73915792)
print v(xbgr.mr_n73915904)
print v(xbgr.mr_n73916224)
print v(xbgr.mr_n73916336)
print v(xbgr.mr_n73916656)
print v(xbgr.mr_n73916768)
print v(xbgr.mr_n73917088)
print v(xbgr.mr_n73917200)
print v(xbgr.mr_n73917520)
print v(xbgr.mr_n73917632)
print v(xbgr.mr_n73917952)
print v(xbgr.mr_n73918064)
print v(xbgr.mr_n73918384)
print v(xbgr.mr_n73918496)
print v(xbgr.mr_n73918816)
print v(xbgr.mr_n73918928)
print v(xbgr.mr_n73919248)
print v(xbgr.mr_n73919360)
print v(xbgr.mr_n73919680)
print v(xbgr.mr_n73919792)
print v(xbgr.mr_n73920112)
print v(xbgr.mr_n73920224)
print v(xbgr.mr_n73920544)
print v(xbgr.mr_n73920656)
print v(xbgr.mr_n73920976)
print v(xbgr.mr_n73921088)
print v(xbgr.mr_n73921408)
print v(xbgr.mr_n73921520)
print v(xbgr.mr_n73921840)
print v(xbgr.mr_n73921952)
print v(xbgr.mr_n73922272)
print v(xbgr.mr_n73922384)
print v(xbgr.mr_n73922704)
print v(xbgr.mr_n73922816)
print v(xbgr.mr_n73923136)
print v(xbgr.mr_n73923248)
print v(xbgr.mr_n73923568)
print v(xbgr.mr_n73923680)
print v(xbgr.mr_n73924000)
print v(xbgr.mr_n73924112)
print v(xbgr.mr_n73924432)
print v(xbgr.mr_n73924544)
print v(xbgr.mr_n73924864)
print v(xbgr.mr_n73924976)
print v(xbgr.mr_n73925296)
print v(xbgr.mr_n73925408)
print v(xbgr.mr_n73925728)
print v(xbgr.mr_n73925840)
print v(xbgr.mr_n73926160)
print v(xbgr.mr_n73926272)
print v(xbgr.mr_n73926592)
print v(xbgr.mr_n73926704)
print v(xbgr.mr_n73927024)
print v(xbgr.mr_n73927136)
print v(xbgr.mr_n73927456)
print v(xbgr.mr_n73927568)
print v(xbgr.mr_n73927888)
print v(xbgr.mr_n73928000)
print v(xbgr.mr_n73928320)
print v(xbgr.mr_n73928432)
print v(xbgr.mr_n73928752)
print v(xbgr.mr_n73928864)
print v(xbgr.mr_n73929184)
print v(xbgr.mr_n73929296)
print v(xbgr.mr_n73929616)
print v(xbgr.mr_n73929728)
print v(xbgr.mr_n73930048)
print v(xbgr.mr_n73930160)
print v(xbgr.mr_n73930480)
print v(xbgr.mr_n73930592)
print v(xbgr.mr_n73930912)
print v(xbgr.mr_n73931024)
print v(xbgr.mr_n73931344)
print v(xbgr.mr_n73931456)
print v(xbgr.mr_n73931776)
print v(xbgr.mr_n73931888)
print v(xbgr.mr_n73932208)
print v(xbgr.mr_n73932320)
print v(xbgr.mr_n73932640)
print v(xbgr.mr_n73932752)
print v(xbgr.mr_n73933072)
print v(xbgr.mr_n73933184)
print v(xbgr.mr_n73933504)
print v(xbgr.mr_n73933616)
print v(xbgr.mr_n73933936)
print v(xbgr.mr_n73934048)
print v(xbgr.mr_n73934368)
print v(xbgr.mr_n73934480)
print v(xbgr.mr_n73934800)
print v(xbgr.mr_n73934912)
print v(xbgr.mr_n73935232)
print v(xbgr.mr_n73935344)
print v(xbgr.mr_n73935664)
print v(xbgr.mr_n73935776)
print v(xbgr.mr_n73936096)
print v(xbgr.mr_n73936208)
print v(xbgr.mr_n73936528)
print v(xbgr.mr_n73936640)
print v(xbgr.mr_n73936960)
print v(xbgr.mr_n73937072)
print v(xbgr.mr_n73937392)
print v(xbgr.mr_n73937504)
print v(xbgr.mr_n73937824)
print v(xbgr.mr_n73937936)
print v(xbgr.mr_n73938256)
print v(xbgr.mr_n73938368)
print v(xbgr.mr_n73938688)
print v(xbgr.mr_n73938800)
print v(xbgr.mr_n73939120)
print v(xbgr.mr_n73939232)
print v(xbgr.mr_n73939552)
print v(xbgr.mr_n73939664)
print v(xbgr.mr_n73939984)
print v(xbgr.mr_n73940096)
print v(xbgr.mr_n73940416)
print v(xbgr.mr_n73940528)
print v(xbgr.mr_n73940848)
print v(xbgr.mr_n73940960)
print v(xbgr.mr_n73941280)
print v(xbgr.mr_n73941392)
print v(xbgr.mr_n73941712)
print v(xbgr.mr_n73941824)
print v(xbgr.mr_n73942144)
print v(xbgr.mr_n73942256)
print v(xbgr.mr_n73942576)
print v(xbgr.mr_n73942688)
print v(xbgr.mr_n73943008)
print v(xbgr.mr_n73943120)
print v(xbgr.mr_n73943440)
print v(xbgr.mr_n73943552)
print v(xbgr.mr_n73943984)
print v(xbgr.mr_n73944416)
print v(xbgr.mr_n73944848)
print v(xbgr.mr_n73945280)
print v(xbgr.mr_n73945712)
print v(xbgr.mr_n73946144)
print v(xbgr.mr_n73946576)
print v(xbgr.mr_n73947008)
print v(xbgr.mr_n73947440)
print v(xbgr.mr_n73947872)
print v(xbgr.mr_n73948304)
print v(xbgr.mr_n73948736)
print v(xbgr.mr_n73949168)
print v(xbgr.mr_n73949600)
print v(xbgr.mr_n73950032)
print v(xbgr.mr_n73950464)
print v(xbgr.mr_n73950896)
print v(xbgr.mr_n73951328)
print v(xbgr.mr_n73951760)
print v(xbgr.mr_n73952192)
print v(xbgr.mr_n73952624)
print v(xbgr.mr_n73953056)
print v(xbgr.mr_n73953488)
print v(xbgr.mr_n73953920)
print v(xbgr.mr_n73954352)
print v(xbgr.mr_n73954784)
print v(xbgr.mr_n73955216)
print v(xbgr.mr_n73955648)
print v(xbgr.mr_n73956080)
print v(xbgr.mr_n73956512)
print v(xbgr.mr_n73956944)
print v(xbgr.mr_n73957376)
print v(xbgr.mr_n73957808)
print v(xbgr.mr_n73958240)
print v(xbgr.mr_n73958560)
print v(xbgr.mr_n73958672)
print v(xbgr.mr_n73958992)
print v(xbgr.mr_n73959104)
print v(xbgr.mr_n73959536)
print v(xbgr.mr_n73959856)
print v(xbgr.mr_n73959968)
print v(xbgr.mr_n73960288)
print v(xbgr.mr_n73960400)
print v(xbgr.mr_n73960720)
print v(xbgr.mr_n73960832)
print v(xbgr.mr_n73961152)
print v(xbgr.mr_n73961264)
print v(xbgr.mr_n73961584)
print v(xbgr.mr_n73961696)
print v(xbgr.mr_n73962016)
print v(xbgr.mr_n73962128)
print v(xbgr.mr_n73962448)
print v(xbgr.mr_n73962560)
print v(xbgr.mr_n73962880)
print v(xbgr.mr_n73962992)
print v(xbgr.mr_n73963424)
print v(xbgr.mr_n73963856)
print v(xbgr.mr_n73964288)
print v(xbgr.mr_n73964720)
print v(xbgr.mr_n73965152)
print v(xbgr.mr_n73965584)
print v(xbgr.mr_n73966016)
print v(xbgr.mr_n73966448)
print v(xbgr.mr_n73966880)
print v(xbgr.mr_n73967200)
print v(xbgr.mr_n73967312)
print v(xbgr.mr_n73967632)
print v(xbgr.mr_n73967744)
print v(xbgr.mr_n73968064)
print v(xbgr.mr_n73968176)
print v(xbgr.mr_n73968496)
print v(xbgr.mr_n73968608)
print v(xbgr.mr_n73969040)
print v(xbgr.mr_n73969472)
print v(xbgr.mr_n73969904)
print v(xbgr.mr_n73970336)
print v(xbgr.mr_n73970768)
print v(xbgr.mr_n73971200)
print v(xbgr.mr_n73971632)
print v(xbgr.mr_n73972064)
print v(xbgr.mr_n73972496)
print v(xbgr.mr_n73972928)
print v(xbgr.mr_n73973360)
print v(xbgr.mr_n73973792)
print v(xbgr.mr_n73974224)
print v(xbgr.mr_n73974656)
print v(xbgr.mr_n73975088)
print v(xbgr.mr_n73975520)
print v(xbgr.mr_n73975952)
print v(xbgr.mr_n73976384)
print v(xbgr.mr_n73976816)
print v(xbgr.mr_n73977248)
print v(xbgr.mr_n73977680)
print v(xbgr.mr_n73978112)
print v(xbgr.mr_n73978544)
print v(xbgr.mr_n73978976)
print v(xbgr.mr_n73979408)
print v(xbgr.mr_n73979840)
print v(xbgr.mr_n73980272)
print v(xbgr.mr_n73980704)
print v(xbgr.mr_n73981136)
print v(xbgr.mr_n73981456)
print v(xbgr.mr_n73981568)
print v(xbgr.mr_n73981888)
print v(xbgr.mr_n73982000)
print v(xbgr.mr_n73982320)
print v(xbgr.mr_n73982432)
print v(xbgr.mr_n73982752)
print v(xbgr.mr_n73982864)
print v(xbgr.mr_n73983184)
print v(xbgr.mr_n73983296)
print v(xbgr.mr_n73983616)
print v(xbgr.mr_n73983728)
print v(xbgr.mr_n74246208)
print v(xbgr.mr_n74246992)
print v(xbgr.mr_n74247856)
print v(xbgr.mr_n74247968)
print v(xbgr.mr_n74248288)
print v(xbgr.mr_n74248720)
print v(xbgr.mr_n74249152)
print v(xbgr.mr_n74249584)
print v(xbgr.mr_n74249696)
print v(xbgr.mr_n74250016)
print v(xbgr.mr_n74250448)
print v(xbgr.mr_n74250880)
print v(xbgr.mr_n74251312)
print v(xbgr.mr_n74251424)
print v(xbgr.mr_n74251744)
print v(xbgr.mr_n74251856)
print v(xbgr.mr_n74252176)
print v(xbgr.mr_n74252288)
print v(xbgr.mr_n74252720)
print v(xbgr.mr_n74253152)
print v(xbgr.mr_n74253584)
print v(xbgr.mr_n74253904)
print v(xbgr.mr_n74254768)
print v(xbgr.mr_n74254880)
print v(xbgr.mr_n74255200)
print v(xbgr.mr_n74255312)
print v(xbgr.mr_n74255632)
print v(xbgr.mr_n74256608)
print v(xbgr.mr_n74257040)
print v(xbgr.mr_n74257360)
print v(xbgr.mr_n74258224)
print v(xbgr.mr_n74258336)
print v(xbgr.mr_n74258656)
print v(xbgr.mr_n74258768)
print v(xbgr.mr_n74259088)
print v(xbgr.mr_n74259200)
print v(xbgr.mr_n74261696)
print v(xbgr.mr_n74262128)
print v(xbgr.mr_n74262448)
print v(xbgr.mr_n74263424)
print v(xbgr.mr_n74263744)
print v(xbgr.mr_n74264720)
print v(xbgr.mr_n74265040)
print v(xbgr.mr_n74266016)
print v(xbgr.mr_n74266336)
print v(xbgr.mr_n74266448)
print v(xbgr.mr_n74266880)
print v(xbgr.mr_n74267312)
print v(xbgr.mr_n74267632)
print v(xbgr.mr_n74268608)
print v(xbgr.mr_n74268928)
print v(xbgr.mr_n74269904)
print v(xbgr.mr_n74270224)
print v(xbgr.mr_n74271200)
print v(xbgr.mr_n74271520)
print v(xbgr.mr_n74271632)
print v(xbgr.mr_n74272384)
print v(xbgr.mr_n74272496)
print v(xbgr.mr_n74273248)
print v(xbgr.mr_n74273360)
print v(xbgr.mr_n74274112)
print v(xbgr.mr_n74274224)
print v(xbgr.mr_n74274976)
print v(xbgr.mr_n74275088)
print v(xbgr.mr_n74275840)
print v(xbgr.mr_n74275952)
print v(xbgr.mr_n74276704)
print v(xbgr.mr_n74276816)
print v(xbgr.mr_n74277568)
print v(xbgr.mr_n74277680)
print v(xbgr.mr_n74278544)
print v(xbgr.mr_n74278976)
print v(xbgr.mr_n74279408)
print v(xbgr.mr_n74279840)
print v(xbgr.mr_n74280272)
print v(xbgr.mr_n74280704)
print v(xbgr.mr_n74281136)
print v(xbgr.mr_n74281568)
print v(xbgr.mr_n74282000)
print v(xbgr.mr_n74282432)
print v(xbgr.mr_n74282864)
print v(xbgr.mr_n74283296)
print v(xbgr.mr_n74283728)
print v(xbgr.mr_n74284160)
print v(xbgr.mr_n74284592)
print v(xbgr.mr_n74285024)
print v(xbgr.mr_n74285456)
print v(xbgr.mr_n74285888)
print v(xbgr.mr_n74286320)
print v(xbgr.mr_n74286752)
print v(xbgr.mr_n74287184)
print v(xbgr.mr_n74287616)
print v(xbgr.mr_n74288048)
print v(xbgr.mr_n74288480)
print v(xbgr.mr_n74348096)
print v(xbgr.mr_n74348288)
print v(xbgr.mr_n74348736)
print v(xbgr.mr_n74349248)
print v(xbgr.mr_n74351488)
print v(xbgr.mr_n74352112)
print v(xbgr.mr_n74354272)
print v(xbgr.mr_n74355424)
print v(xbgr.mr_n74355872)
print v(xbgr.mr_n74356176)
print v(xbgr.mr_n74357792)
print v(xbgr.mr_n74359408)
print v(xbgr.mr_n74360416)
print v(xbgr.mr_n74361552)
print v(xbgr.mr_n74364240)
print v(xbgr.mr_n74367904)
print v(xbgr.mr_n74368048)
print v(xbgr.mr_n74368416)
print v(xbgr.mr_n74368528)
print v(xbgr.mr_n74368704)
print v(xbgr.mr_n74371088)
print v(xbgr.mr_n74371328)
print v(xbgr.mr_n74371536)
print v(xbgr.mr_n74372192)
print v(xbgr.mr_n74372304)
print v(xbgr.mr_n74373904)
print v(xbgr.mr_n74374112)
print v(xbgr.mr_n74375904)
print v(xbgr.mr_n74377248)
print v(xbgr.mr_n74378672)
print v(xbgr.mr_n74380272)
print v(xbgr.mr_n74381280)
print v(xbgr.mr_n74381728)
print v(xbgr.mr_n74385312)
print v(xbgr.mr_n74385760)
print v(xbgr.mr_n74386720)
print v(xbgr.mr_n74387344)
print v(xbgr.mr_n74388448)
print v(xbgr.mr_n74390032)
print v(xbgr.mr_n74390240)
print v(xbgr.mr_n74488720)
print v(xbgr.mr_n74490176)
print v(xbgr.mr_n74491152)
print v(xbgr.mr_n74500928)
print v(xbgr.mr_n74506816)
print v(xbgr.mr_n74508112)
print v(xbgr.mr_n74510864)
print v(xbgr.mr_n74511808)
print v(xbgr.mr_n74514256)
print v(xbgr.mr_n74515456)
print v(xbgr.mr_n74516176)
print v(xbgr.mr_n74517904)
print v(xbgr.mr_n74522960)
print v(xbgr.mr_n74523136)
print v(xbgr.mr_n74525760)
print v(xbgr.mr_n74526528)
print v(xbgr.mr_n74537216)
print v(xbgr.mr_n74606176)
print v(xbgr.mr_n74606416)
print v(xbgr.mr_n74607136)
print v(xbgr.mr_n74607312)
print v(xbgr.mr_n74607520)
print v(xbgr.mr_n74607760)
print v(xbgr.mr_n74607968)
print v(xbgr.mr_n74608864)
print v(xbgr.mr_n74609824)
print v(xbgr.mr_n74610240)
print v(xbgr.mr_n74616720)
print v(xbgr.mr_n74617376)
print v(xbgr.mr_n74618064)
print v(xbgr.mr_n74618272)
print v(xbgr.mr_n74619168)
print v(xbgr.mr_n74621648)
print v(xbgr.mr_n74621920)
print v(xbgr.mr_n74622096)
print v(xbgr.mr_n74622304)
print v(xbgr.mr_n74622544)
print v(xbgr.mr_n74622752)
print v(xbgr.mr_n74623536)
print v(xbgr.mr_n74623888)
print v(xbgr.mr_n74624992)
print v(xbgr.mr_n74625680)
print v(xbgr.mr_n74626016)
print v(xbgr.mr_n74626128)
print v(xbgr.mr_n74627744)
print v(xbgr.mr_n74628576)
print v(xbgr.mr_n74629360)
print v(xbgr.mr_n74629664)
print v(xbgr.mr_n74630608)
print v(xbgr.mr_n74632672)
print v(xbgr.mr_n74633056)
print v(xbgr.mr_n74633504)
print v(xbgr.mr_n74633968)
print v(xbgr.mr_n74649840)
print v(xbgr.mr_n74651584)
print v(xbgr.mr_n74651696)
print v(xbgr.mr_n74655248)
print v(xbgr.mr_n74662688)
print v(xbgr.mr_n74663456)
print v(xbgr.mr_n74664336)
print v(xbgr.mr_n74664816)
print v(xbgr.mr_n74664928)
print v(xbgr.mr_n74688096)
print v(xbgr.mr_n74704432)
print v(xbgr.mr_n74707696)
print v(xbgr.mr_n74707872)
print v(xbgr.mr_n74709872)
print v(xbgr.mr_n74710688)
print v(xbgr.mr_n74712016)
print v(xbgr.mr_n74713152)
print v(xbgr.mr_n74713600)
print v(xbgr.mr_n74722944)
print v(xbgr.mr_n74724336)
print v(xbgr.mr_n74728832)
print v(xbgr.mr_n74729008)
print v(xbgr.mr_n74729120)
print v(xbgr.mr_n74730224)
print v(xbgr.mr_n74730496)
print v(xbgr.mr_n74730992)
print v(xbgr.mr_n74731328)
print v(xbgr.mr_n74731856)
print v(xbgr.mr_n74732000)
print v(xbgr.mr_n74738624)
print v(xbgr.mr_n74739520)
print v(xbgr.mr_n74770880)
print v(xbgr.mr_n74771824)
print v(xbgr.mr_n74789568)
print v(xbgr.mr_n74791296)
print v(xbgr.mr_n74792048)
print v(xbgr.mr_n74793808)
print v(xbgr.mr_n74799120)
print v(xbgr.mr_n74871680)
print v(xbgr.mr_n74871872)
print v(xbgr.mr_n75062896)
print v(xbgr.mr_n75063088)
print v(xbgr.mr_n75063504)
print v(xbgr.mr_n75064736)
print v(xbgr.mr_n75065264)
print v(xbgr.mr_n75067264)
print v(xbgr.mr_n75121920)
print v(xbgr.mr_n75128960)
print v(xbgr.mr_n75130496)
print v(xbgr.mr_n75133232)
print v(xbgr.mr_n75133568)
print v(xbgr.mr_n75134000)
print v(xbgr.mr_n75135664)
print v(xbgr.mr_n75164928)
print v(xbgr.mr_n75172160)
print v(xbgr.mr_n75173936)
print v(xbgr.mr_n75175488)
print v(xbgr.mr_n75178224)
print v(xbgr.mr_n75178992)
print v(xbgr.mr_n75182832)
print v(xbgr.mr_n75184128)
print v(xbgr.mr_n75185424)
print v(xbgr.mr_n75185648)
print v(xbgr.mr_n75187056)
print v(xbgr.mr_n75187200)
print v(xbgr.mr_n75196176)
print v(xbgr.mr_n75197328)
print v(xbgr.mr_n75198528)
print v(xbgr.mr_n75200080)
print v(xbgr.mr_n75200672)
print v(xbgr.mr_n75201552)
print v(xbgr.mr_n75202080)
print v(xbgr.mr_n75202880)
print v(xbgr.mr_n75204288)
print v(xbgr.mr_n75204832)
print v(xbgr.mr_n75205504)
print v(xbgr.mr_n75205744)
print v(xbgr.mr_n75211872)
print v(xbgr.mr_n75211984)
print v(xbgr.mr_n75212096)
print v(xbgr.mr_n75212208)
print v(xbgr.mr_n75212512)
print v(xbgr.mr_n75212784)
print v(xbgr.mr_n75213056)
print v(xbgr.mr_n75215168)
print v(xbgr.mr_n75215632)
print v(xbgr.mr_n75215984)
print v(xbgr.mr_n75216096)
print v(xbgr.mr_n75216560)
print v(xbgr.mr_n75217024)
print v(xbgr.mr_n75217488)
print v(xbgr.mr_n75217952)
print v(xbgr.mr_n75218416)
print v(xbgr.mr_n75218880)
print v(xbgr.mr_n75219344)
print v(xbgr.mr_n75219808)
print v(xbgr.mr_n75226224)
print v(xbgr.mr_n75226720)
print v(xbgr.mr_n75227072)
print v(xbgr.mr_n75230016)
print v(xbgr.mr_n75230720)
print v(xbgr.mr_n75231088)
print v(xbgr.mr_n75232304)
print v(xbgr.mr_n75235584)
print v(xbgr.mr_n75236192)
print v(xbgr.mr_n75236368)
print v(xbgr.mr_n75237952)
print v(xbgr.mr_n75239344)
print v(xbgr.mr_n75241024)
print v(xbgr.mr_n75241584)
print v(xbgr.mr_n75242288)
print v(xbgr.mr_n75244400)
print v(xbgr.mr_n75245312)
print v(xbgr.mr_n75245808)
print v(xbgr.mr_n75246608)
print v(xbgr.mr_n75247552)
print v(xbgr.mr_n75248624)
print v(xbgr.mr_n75250032)
print v(xbgr.mr_n75252352)
print v(xbgr.mr_n75252736)
print v(xbgr.mr_n75253120)
print v(xbgr.mr_n75253760)
print v(xbgr.mr_n75254016)
print v(xbgr.mr_n75254256)
print v(xbgr.mr_n75255936)
print v(xbgr.mr_n75257984)
print v(xbgr.mr_n75258288)
print v(xbgr.mr_n75262208)
print v(xbgr.mr_n75264112)
print v(xbgr.mr_n75266432)
print v(xbgr.mr_n75266928)
print v(xbgr.mr_n75268432)
print v(xbgr.mr_n75269840)
print v(xbgr.mr_n75269952)
print v(xbgr.mr_n75270480)
print v(xbgr.mr_n75271152)
print v(xbgr.mr_n75272560)
print v(xbgr.mr_n75273968)
print v(xbgr.mr_n75274880)
print v(xbgr.mr_n75275376)
print v(xbgr.mr_n75278464)
print v(xbgr.mr_n75279104)
print v(xbgr.mr_n75280304)
print v(xbgr.mr_n75280576)
print v(xbgr.mr_n75282624)
print v(xbgr.mr_n75283920)
print v(xbgr.mr_n75285936)
print v(xbgr.mr_n75287344)
print v(xbgr.mr_n75292272)
print v(xbgr.mr_n75293072)
print v(xbgr.mr_n75293680)
print v(xbgr.mr_n75296064)
print v(xbgr.mr_n75300080)
print v(xbgr.mr_n75301952)
print v(xbgr.mr_n75302416)
print v(xbgr.mr_n75302880)
print v(xbgr.mr_n75303344)
print v(xbgr.mr_n75303808)
print v(xbgr.mr_n75304272)
print v(xbgr.mr_n75304736)
print v(xbgr.mr_n75305200)
print v(xbgr.mr_n75305664)
print v(xbgr.mr_n75306128)
print v(xbgr.mr_n75306592)
print v(xbgr.mr_n75309216)
print v(xbgr.mr_n75310432)
print v(xbgr.mr_n75312624)
print v(xbgr.mr_n75313232)
print v(xbgr.mr_n75315904)
print v(xbgr.mr_n75317184)
print v(xbgr.mr_n75317424)
print v(xbgr.mr_n75318944)
print v(xbgr.mr_n75321376)
print v(xbgr.mr_n75322352)
print v(xbgr.mr_n75322960)
print v(xbgr.mr_n75327520)
print v(xbgr.mr_n75329952)
print v(xbgr.mr_n75332080)
print v(xbgr.mr_n75334272)
print v(xbgr.mr_n75334512)
print v(xbgr.mr_n75338640)
print v(xbgr.mr_n75339056)
print v(xbgr.mr_n75339824)
print v(xbgr.mr_n75340832)
print v(xbgr.mr_n75342528)
print v(xbgr.mr_n75344544)
print v(xbgr.mr_n75345136)
print v(xbgr.mr_n75350848)
print v(xbgr.mr_n75351040)
print v(xbgr.mr_n75353152)
print v(xbgr.mr_n75353616)
print v(xbgr.mr_n75354080)
print v(xbgr.mr_n75354544)
print v(xbgr.mr_n75355008)
print v(xbgr.mr_n75355472)
print v(xbgr.mr_n75355936)
print v(xbgr.mr_n75356400)
print v(xbgr.mr_n75356864)
print v(xbgr.mr_n75357328)
print v(xbgr.mr_n75357792)
print v(xbgr.mr_n75358256)
print v(xbgr.mr_n75358720)
print v(xbgr.mr_n75359184)
print v(xbgr.mr_n75359648)
print v(xbgr.mr_n75360112)
print v(xbgr.mr_n75360576)
print v(xbgr.mr_n75361040)
print v(xbgr.mr_n75361504)
print v(xbgr.mr_n75361968)
print v(xbgr.mr_n75362432)
print v(xbgr.mr_n75362896)
print v(xbgr.mr_n75363360)
print v(xbgr.mr_n75363824)
print v(xbgr.mr_n75364288)
print v(xbgr.mr_n75364752)
print v(xbgr.mr_n75365216)
print v(xbgr.mr_n75365680)
print v(xbgr.mr_n75366144)
print v(xbgr.mr_n75366608)
print v(xbgr.mr_n75367072)
print v(xbgr.mr_n75367536)
print v(xbgr.mr_n75368000)
print v(xbgr.mr_n75368464)
print v(xbgr.mr_n75368928)
print v(xbgr.mr_n75369392)
print v(xbgr.mr_n75369856)
print v(xbgr.mr_n75370320)
print v(xbgr.mr_n75370784)
print v(xbgr.mr_n75371248)
print v(xbgr.mr_n75371712)
print v(xbgr.mr_n75372160)
print v(xbgr.mr_n75372624)
print v(xbgr.mr_n75373024)
print v(xbgr.mr_n75373424)
print v(xbgr.mr_n75373888)
print v(xbgr.mr_n75374352)
print v(xbgr.mr_n75374816)
print v(xbgr.mr_n75375280)
print v(xbgr.mr_n75375744)
print v(xbgr.mr_n75376208)
print v(xbgr.mr_n75376672)
print v(xbgr.mr_n75377136)
print v(xbgr.mr_n75377600)
print v(xbgr.mr_n75378064)
print v(xbgr.mr_n75378528)
print v(xbgr.mr_n75378992)
print v(xbgr.mr_n75379456)
print v(xbgr.mr_n75379920)
print v(xbgr.mr_n75380384)
print v(xbgr.mr_n75380848)
print v(xbgr.mr_n75381312)
print v(xbgr.mr_n75381776)
print v(xbgr.mr_n75382240)
print v(xbgr.mr_n75382704)
print v(xbgr.mr_n75383168)
print v(xbgr.mr_n75383632)
print v(xbgr.mr_n75384096)
print v(xbgr.mr_n75384560)
print v(xbgr.mr_n75385024)
print v(xbgr.mr_n75385488)
print v(xbgr.mr_n75385952)
print v(xbgr.mr_n75386416)
print v(xbgr.mr_n75386880)
print v(xbgr.mr_n75387344)
print v(xbgr.mr_n75387808)
print v(xbgr.mr_n75388272)
print v(xbgr.mr_n75388736)
print v(xbgr.mr_n75389200)
print v(xbgr.mr_n75389664)
print v(xbgr.mr_n75390128)
print v(xbgr.mr_n75390592)
print v(xbgr.mr_n75391056)
print v(xbgr.mr_n75391520)
print v(xbgr.mr_n75391984)
print v(xbgr.mr_n75392448)
print v(xbgr.mr_n75392912)
print v(xbgr.mr_n75393376)
print v(xbgr.mr_n75393840)
print v(xbgr.mr_n75394304)
print v(xbgr.mr_n75394768)
print v(xbgr.mr_n75395232)
print v(xbgr.mr_n75395696)
print v(xbgr.mr_n75396160)
print v(xbgr.mr_n75396624)
print v(xbgr.mr_n75397088)
print v(xbgr.mr_n75397552)
print v(xbgr.mr_n75398016)
print v(xbgr.mr_n75398288)
print v(xbgr.mr_n75398480)
print v(xbgr.mr_n75398944)
print v(xbgr.mr_n75399408)
print v(xbgr.mr_n75399872)
print v(xbgr.mr_n75400336)
print v(xbgr.mr_n75400800)
print v(xbgr.mr_n75401264)
print v(xbgr.mr_n75401728)
print v(xbgr.mr_n75402192)
print v(xbgr.mr_n75402656)
print v(xbgr.mr_n75403120)
print v(xbgr.mr_n75403584)
print v(xbgr.mr_n75404048)
print v(xbgr.mr_n75404512)
print v(xbgr.mr_n75404976)
print v(xbgr.mr_n75405440)
print v(xbgr.mr_n75405904)
print v(xbgr.mr_n75406368)
print v(xbgr.mr_n75406832)
print v(xbgr.mr_n75407296)
print v(xbgr.mr_n75407760)
print v(xbgr.mr_n75408224)
print v(xbgr.mr_n75408336)
print v(xbgr.mr_n75408960)
print v(xbgr.mr_n75409072)
print v(xbgr.mr_n75409696)
print v(xbgr.mr_n75409920)
print v(xbgr.mr_n75410432)
print v(xbgr.mr_n75410544)
print v(xbgr.mr_n75411168)
print v(xbgr.mr_n75411280)
print v(xbgr.mr_n75411392)
print v(xbgr.mr_n75411904)
print v(xbgr.mr_n75412016)
print v(xbgr.mr_n75412128)
print v(xbgr.mr_n75412640)
print v(xbgr.mr_n75412752)
print v(xbgr.mr_n75412864)
print v(xbgr.mr_n75413376)
print v(xbgr.mr_n75413648)
print v(xbgr.mr_n75413920)
print v(xbgr.mr_n75414192)
print v(xbgr.mr_n75414304)
print v(xbgr.mr_n75414416)
print v(xbgr.mr_n75414928)
print v(xbgr.mr_n75415200)
print v(xbgr.mr_n75415472)
print v(xbgr.mr_n75415744)
print v(xbgr.mr_n75416016)
print v(xbgr.mr_n75416560)
print v(xbgr.mr_n75416832)
print v(xbgr.mr_n75417104)
print v(xbgr.mr_n75417376)
print v(xbgr.mr_n75417648)
print v(xbgr.mr_n75417920)
print v(xbgr.mr_n75418192)
print v(xbgr.mr_n75418464)
print v(xbgr.mr_n75418736)
print v(xbgr.mr_n75419008)
print v(xbgr.mr_n75419280)
print v(xbgr.mr_n75419552)
print v(xbgr.mr_n75419824)
print v(xbgr.mr_n75420096)
print v(xbgr.mr_n75420368)
print v(xbgr.mr_n75420640)
print v(xbgr.mr_n75420912)
print v(xbgr.mr_n75421184)
print v(xbgr.mr_n75421456)
print v(xbgr.mr_n75421728)
print v(xbgr.mr_n75422192)
print v(xbgr.mr_n75422656)
print v(xbgr.mr_n75423120)
print v(xbgr.mr_n75423584)
print v(xbgr.mr_n75424048)
print v(xbgr.mr_n75424512)
print v(xbgr.mr_n75424976)
print v(xbgr.mr_n75425440)
print v(xbgr.mr_n75425904)
print v(xbgr.mr_n75426368)
print v(xbgr.mr_n75426832)
print v(xbgr.mr_n75429408)
print v(xbgr.mr_n75429744)
print v(xbgr.mr_n75432416)
print v(xbgr.mr_n75436144)
print v(xbgr.mr_n75440368)
print v(xbgr.mr_n75444016)
print v(xbgr.mr_n75444544)
print v(xbgr.mr_n75444944)
print v(xbgr.mr_n75445408)
print v(xbgr.mr_n75446000)
print v(xbgr.mr_n75446592)
print v(xbgr.mr_n75447184)
print v(xbgr.mr_n75448432)
print v(xbgr.mr_n75448960)
print v(xbgr.mr_n75449552)
print v(xbgr.mr_n75450144)
print v(xbgr.mr_n75450736)
print v(xbgr.mr_n75451328)
print v(xbgr.mr_n75451920)
print v(xbgr.mr_n75452512)
print v(xbgr.mr_n75453104)
print v(xbgr.mr_n75453696)
print v(xbgr.mr_n75454288)
print v(xbgr.mr_n75454880)
print v(xbgr.mr_n75455472)
print v(xbgr.mr_n75456064)
print v(xbgr.mr_n75456656)
print v(xbgr.mr_n75457840)
print v(xbgr.mr_n75458352)
print v(xbgr.mr_n75459024)
print v(xbgr.mr_n75459616)
print v(xbgr.mr_n75460208)
print v(xbgr.mr_n75460608)
print v(xbgr.mr_n75461344)
print v(xbgr.mr_n75477456)
print v(xbgr.mr_n75478064)
print v(xbgr.mr_n75481776)
print v(xbgr.mr_n75482784)
print v(xbgr.mr_n75486816)
print v(xbgr.mr_n75490960)
print v(xbgr.mr_n75493280)
print v(xbgr.mr_n75494464)
print v(xbgr.mr_n75498176)
print v(xbgr.mr_n75504064)
print v(xbgr.mr_n75505568)
print v(xbgr.mr_n75505824)
print v(xbgr.mr_n75508688)
print v(xbgr.mr_n75509296)
print v(xbgr.mr_n75509408)
print v(xbgr.mr_n75510016)
print v(xbgr.mr_n75510128)
print v(xbgr.mr_n75510736)
print v(xbgr.mr_n75510848)
print v(xbgr.mr_n75511456)
print v(xbgr.mr_n75512176)
print v(xbgr.mr_n75512288)
print v(xbgr.mr_n75512896)
print v(xbgr.mr_n75513616)
print v(xbgr.mr_n75519424)
print v(xbgr.mr_n75520032)
print v(xbgr.mr_n75520400)
print v(xbgr.mr_n75520640)
print v(xbgr.mr_n75521248)
print v(xbgr.mr_n75521856)
print v(xbgr.mr_n75527024)
print v(xbgr.mr_n75528128)
print v(xbgr.mr_n75528848)
print v(xbgr.mr_n75529456)
print v(xbgr.mr_n75532928)
print v(xbgr.mr_n75534992)
print v(xbgr.mr_n75535296)
print v(xbgr.mr_n75538576)
print v(xbgr.mr_n75541616)
print v(xbgr.mr_n75543024)
print v(xbgr.mr_n75543200)
print v(xbgr.mr_n75543504)
print v(xbgr.mr_n75544960)
print v(xbgr.mr_n75545264)
print v(xbgr.mr_n75546544)
print v(xbgr.mr_n75548064)
print v(xbgr.mr_n75548976)
print v(xbgr.mr_n75549984)
print v(xbgr.mr_n75550992)
print v(xbgr.mr_n75551936)
print v(xbgr.mr_n75552560)
print v(xbgr.mr_n75556592)
print v(xbgr.mr_n75557344)
print v(xbgr.mr_n75558880)
print v(xbgr.mr_n75559584)
print v(xbgr.mr_n75559984)
print v(xbgr.mr_n75560128)
print v(xbgr.mr_n75560240)
print v(xbgr.mr_n75561136)
print v(xbgr.mr_n75565312)
print v(xbgr.mr_n75565488)
print v(xbgr.mr_n75565664)
print v(xbgr.mr_n75566608)
print v(xbgr.mr_n75567728)
print v(xbgr.mr_n75568400)
print v(xbgr.mr_n75568992)
print v(xbgr.mr_n75569584)
print v(xbgr.mr_n75570176)
print v(xbgr.mr_n75570768)
print v(xbgr.mr_n75571296)
print v(xbgr.mr_n75571872)
print v(xbgr.mr_n75572480)
print v(xbgr.mr_n75573136)
print v(xbgr.mr_n75573728)
print v(xbgr.mr_n75574320)
print v(xbgr.mr_n75574912)
print v(xbgr.mr_n75575504)
print v(xbgr.mr_n75576096)
print v(xbgr.mr_n75576688)
print v(xbgr.mr_n75577280)
print v(xbgr.mr_n75578464)
print v(xbgr.mr_n75579056)
print v(xbgr.mr_n75579568)
print v(xbgr.mr_n75580240)
print v(xbgr.mr_n75580752)
print v(xbgr.mr_n75581424)
print v(xbgr.mr_n75582016)
print v(xbgr.mr_n75582608)
print v(xbgr.mr_n75583200)
print v(xbgr.mr_n75583792)
print v(xbgr.mr_n75584384)
print v(xbgr.mr_n75584976)
print v(xbgr.mr_n75585488)
print v(xbgr.mr_n75586080)
print v(xbgr.mr_n75586752)
print v(xbgr.mr_n75587264)
print v(xbgr.mr_n75587936)
print v(xbgr.mr_n75588528)
print v(xbgr.mr_n75589056)
print v(xbgr.mr_n75589712)
print v(xbgr.mr_n75590304)
print v(xbgr.mr_n75590896)
print v(xbgr.mr_n75591408)
print v(xbgr.mr_n75592080)
print v(xbgr.mr_n75592672)
print v(xbgr.mr_n75593264)
print v(xbgr.mr_n75593856)
print v(xbgr.mr_n75594448)
print v(xbgr.mr_n75594784)
print v(xbgr.mr_n75595040)
print v(xbgr.mr_n75595632)
print v(xbgr.mr_n75595744)
print v(xbgr.mr_n75596160)
print v(xbgr.mr_n75596800)
print v(xbgr.mr_n75597488)
print v(xbgr.mr_n75598592)
print v(xbgr.mr_n75599104)
print v(xbgr.mr_n75599504)
print v(xbgr.mr_n75599696)
print v(xbgr.mr_n75600288)
print v(xbgr.mr_n75600960)
print v(xbgr.mr_n75601552)
print v(xbgr.mr_n75602112)
print v(xbgr.mr_n75602624)
print v(xbgr.mr_n75603296)
print v(xbgr.mr_n75603888)
print v(xbgr.mr_n75604480)
print v(xbgr.mr_n75605072)
print v(xbgr.mr_n75605664)
print v(xbgr.mr_n75606256)
print v(xbgr.mr_n75606848)
print v(xbgr.mr_n75607440)
print v(xbgr.mr_n75608032)
print v(xbgr.mr_n75608544)
print v(xbgr.mr_n75609216)
print v(xbgr.mr_n75609808)
print v(xbgr.mr_n75610400)
print v(xbgr.mr_n75610992)
print v(xbgr.mr_n75611584)
print v(xbgr.mr_n75612176)
print v(xbgr.mr_n75612768)
print v(xbgr.mr_n75613360)
print v(xbgr.mr_n75613952)
print v(xbgr.mr_n75614544)
print v(xbgr.mr_n75614880)
print v(xbgr.mr_n75615136)
print v(xbgr.mr_n75615728)
print v(xbgr.mr_n75616320)
print v(xbgr.mr_n75616832)
print v(xbgr.mr_n75617424)
print v(xbgr.mr_n75618096)
print v(xbgr.mr_n75618688)
print v(xbgr.mr_n75619280)
print v(xbgr.mr_n75619872)
print v(xbgr.mr_n75620464)
print v(xbgr.mr_n75620976)
print v(xbgr.mr_n75621568)
print v(xbgr.mr_n75622240)
print v(xbgr.mr_n75622496)
print v(xbgr.mr_n75622752)
print v(xbgr.mr_n75623344)
print v(xbgr.mr_n75624016)
print v(xbgr.mr_n75625120)
print v(xbgr.mr_n75625536)
print v(xbgr.mr_n75625792)
print v(xbgr.mr_n75626304)
print v(xbgr.mr_n75626976)
print v(xbgr.mr_n75627568)
print v(xbgr.mr_n75628160)
print v(xbgr.mr_n75628752)
print v(xbgr.mr_n75629344)
print v(xbgr.mr_n75629936)
print v(xbgr.mr_n75630528)
print v(xbgr.mr_n75631120)
print v(xbgr.mr_n75631712)
print v(xbgr.mr_n75632224)
print v(xbgr.mr_n75632816)
print v(xbgr.mr_n75633488)
print v(xbgr.mr_n75634080)
print v(xbgr.mr_n75634672)
print v(xbgr.mr_n75635264)
print v(xbgr.mr_n75635856)
print v(xbgr.mr_n75636368)
print v(xbgr.mr_n75636864)
print v(xbgr.mr_n75637040)
print v(xbgr.mr_n75637632)
print v(xbgr.mr_n75638224)
print v(xbgr.mr_n75638816)
print v(xbgr.mr_n75639408)
print v(xbgr.mr_n75640000)
print v(xbgr.mr_n75640512)
print v(xbgr.mr_n75641104)
print v(xbgr.mr_n75641696)
print v(xbgr.mr_n75642368)
print v(xbgr.mr_n75642960)
print v(xbgr.mr_n75643552)
print v(xbgr.mr_n75644144)
print v(xbgr.mr_n75644736)
print v(xbgr.mr_n75645328)
print v(xbgr.mr_n75645664)
print v(xbgr.mr_n75646160)
print v(xbgr.mr_n75646880)
print v(xbgr.mr_n75647680)
print v(xbgr.mr_n75648480)
print v(xbgr.mr_n75648880)
print v(xbgr.mr_n75649280)
print v(xbgr.mr_n75649680)
print v(xbgr.mr_n75650080)
print v(xbgr.mr_n75651200)
print v(xbgr.mr_n75651760)
print v(xbgr.mr_n75654784)
print v(xbgr.mr_n75655104)
print v(xbgr.mr_n75659440)
print v(xbgr.mr_n75659824)
print v(xbgr.mr_n75662608)
print v(xbgr.mr_n75662864)
print v(xbgr.mr_n75667056)
print v(xbgr.mr_n75668528)
print v(xbgr.mr_n75672064)
print v(xbgr.mr_n75675312)
print v(xbgr.mr_n75678832)
print v(xbgr.mr_n75680736)
print v(xbgr.mr_n75681328)
print v(xbgr.mr_n75681920)
print v(xbgr.mr_n75682512)
print v(xbgr.mr_n75683104)
print v(xbgr.mr_n75683696)
print v(xbgr.mr_n75684288)
print v(xbgr.mr_n75684880)
print v(xbgr.mr_n75685472)
print v(xbgr.mr_n75686064)
print v(xbgr.mr_n75686656)
print v(xbgr.mr_n75689184)
print v(xbgr.mr_n75693008)
print v(xbgr.mr_n75698704)
print v(xbgr.mr_n75699344)
print v(xbgr.mr_n75706704)
print v(xbgr.mr_n75708944)
print v(xbgr.mr_n75710432)
print v(xbgr.mr_n75713424)
print v(xbgr.mr_n75720688)
print v(xbgr.mr_n75720944)
print v(xbgr.mr_n75722928)
print v(xbgr.mr_n75723072)
print v(xbgr.mr_n75723280)
print v(xbgr.mr_n75723712)
print v(xbgr.mr_n75724160)
print v(xbgr.mr_n75725280)
print v(xbgr.mr_n75725872)
print v(xbgr.mr_n75726464)
print v(xbgr.mr_n75727056)
print v(xbgr.mr_n75727648)
print v(xbgr.mr_n75728240)
print v(xbgr.mr_n75729424)
print v(xbgr.mr_n75730016)
print v(xbgr.mr_n75730608)
print v(xbgr.mr_n75730992)
print v(xbgr.mr_n75731104)
print v(xbgr.mr_n75731488)
print v(xbgr.mr_n75732560)
print v(xbgr.mr_n75733152)
print v(xbgr.mr_n75733744)
print v(xbgr.mr_n75734336)
print v(xbgr.mr_n75734928)
print v(xbgr.mr_n75735520)
print v(xbgr.mr_n75736112)
print v(xbgr.mr_n75736704)
print v(xbgr.mr_n75737296)
print v(xbgr.mr_n75737888)
print v(xbgr.mr_n75738480)
print v(xbgr.mr_n75739072)
print v(xbgr.mr_n75739664)
print v(xbgr.mr_n75740256)
print v(xbgr.mr_n75740848)
print v(xbgr.mr_n75741440)
print v(xbgr.mr_n75742624)
print v(xbgr.mr_n75743216)
print v(xbgr.mr_n75743808)
print v(xbgr.mr_n75744400)
print v(xbgr.mr_n75744992)
print v(xbgr.mr_n75745584)
print v(xbgr.mr_n75746112)
print v(xbgr.mr_n75746768)
print v(xbgr.mr_n75747360)
print v(xbgr.mr_n75747952)
print v(xbgr.mr_n75748544)
print v(xbgr.mr_n75749728)
print v(xbgr.mr_n75750320)
print v(xbgr.mr_n75750912)
print v(xbgr.mr_n75751504)
print v(xbgr.mr_n75752096)
print v(xbgr.mr_n75752688)
print v(xbgr.mr_n75753280)
print v(xbgr.mr_n75753872)
print v(xbgr.mr_n75754464)
print v(xbgr.mr_n75755056)
print v(xbgr.mr_n75756240)
print v(xbgr.mr_n75756832)
print v(xbgr.mr_n75757424)
print v(xbgr.mr_n75758016)
print v(xbgr.mr_n75758608)
print v(xbgr.mr_n75759200)
print v(xbgr.mr_n75759792)
print v(xbgr.mr_n75760384)
print v(xbgr.mr_n75760976)
print v(xbgr.mr_n75761568)
print v(xbgr.mr_n75762160)
print v(xbgr.mr_n75762752)
print v(xbgr.mr_n75763344)
print v(xbgr.mr_n75763936)
print v(xbgr.mr_n75764528)
print v(xbgr.mr_n75765120)
print v(xbgr.mr_n75765712)
print v(xbgr.mr_n75766304)
print v(xbgr.mr_n75766896)
print v(xbgr.mr_n75767488)
print v(xbgr.mr_n75768080)
print v(xbgr.mr_n75768672)
print v(xbgr.mr_n75769264)
print v(xbgr.mr_n75769856)
print v(xbgr.mr_n75770448)
print v(xbgr.mr_n75771040)
print v(xbgr.mr_n75771632)
print v(xbgr.mr_n75772224)
print v(xbgr.mr_n75772816)
print v(xbgr.mr_n75773408)
print v(xbgr.mr_n75774000)
print v(xbgr.mr_n75774592)
print v(xbgr.mr_n75775184)
print v(xbgr.mr_n75775712)
print v(xbgr.mr_n75776368)
print v(xbgr.mr_n75776960)
print v(xbgr.mr_n75777552)
print v(xbgr.mr_n75778144)
print v(xbgr.mr_n75778736)
print v(xbgr.mr_n75779328)
print v(xbgr.mr_n75779920)
print v(xbgr.mr_n75780256)
print v(xbgr.mr_n75780512)
print v(xbgr.mr_n75781104)
print v(xbgr.mr_n75781696)
print v(xbgr.mr_n75782288)
print v(xbgr.mr_n75782880)
print v(xbgr.mr_n75783472)
print v(xbgr.mr_n75784064)
print v(xbgr.mr_n75784656)
print v(xbgr.mr_n75785248)
print v(xbgr.mr_n75785584)
print v(xbgr.mr_n75785840)
print v(xbgr.mr_n75786432)
print v(xbgr.mr_n75787024)
print v(xbgr.mr_n75787616)
print v(xbgr.mr_n75788208)
print v(xbgr.mr_n75788800)
print v(xbgr.mr_n75789392)
print v(xbgr.mr_n75789984)
print v(xbgr.mr_n75790576)
print v(xbgr.mr_n75791168)
print v(xbgr.mr_n75792352)
print v(xbgr.mr_n75792944)
print v(xbgr.mr_n75793472)
print v(xbgr.mr_n75794128)
print v(xbgr.mr_n75794656)
print v(xbgr.mr_n75795120)
print v(xbgr.mr_n75795584)
print v(xbgr.mr_n75795696)
print v(xbgr.mr_n75796048)
print v(xbgr.mr_n75796512)
print v(xbgr.mr_n75796624)
print v(xbgr.mr_n75796976)
print v(xbgr.mr_n75797088)
print v(xbgr.mr_n75798480)
print v(xbgr.mr_n75798736)
print v(xbgr.mr_n75799072)
print v(xbgr.mr_n75799712)
print v(xbgr.mr_n75800112)
print v(xbgr.mr_n75800512)
print v(xbgr.mr_n75800912)
print v(xbgr.mr_n75801312)
print v(xbgr.mr_n75801712)
print v(xbgr.mr_n75802112)
print v(xbgr.mr_n75802512)
print v(xbgr.mr_n75802912)
print v(xbgr.mr_n75803312)
print v(xbgr.mr_n75803712)
print v(xbgr.mr_n75804112)
print v(xbgr.mr_n75804512)
print v(xbgr.mr_n75804912)
print v(xbgr.mr_n75805312)
print v(xbgr.mr_n75805712)
print v(xbgr.mr_n75806112)
print v(xbgr.mr_n75806512)
print v(xbgr.mr_n75806912)
print v(xbgr.mr_n75807312)
print v(xbgr.mr_n75807712)
print v(xbgr.mr_n75808112)
print v(xbgr.mr_n75808512)
print v(xbgr.mr_n75808912)
print v(xbgr.mr_n75809312)
print v(xbgr.mr_n75809712)
print v(xbgr.mr_n75810112)
print v(xbgr.mr_n75810512)
print v(xbgr.mr_n75810912)
print v(xbgr.mr_n75811312)
print v(xbgr.mr_n75811712)
print v(xbgr.mr_n75812112)
print v(xbgr.mr_n75812512)
print v(xbgr.mr_n75812912)
print v(xbgr.mr_n75813312)
print v(xbgr.mr_n75813712)
print v(xbgr.mr_n75814176)
print v(xbgr.mr_n75814768)
print v(xbgr.mr_n75815360)
print v(xbgr.mr_n75815952)
print v(xbgr.mr_n75816544)
print v(xbgr.mr_n75817136)
print v(xbgr.mr_n75817728)
print v(xbgr.mr_n75818320)
print v(xbgr.mr_n75818848)
print v(xbgr.mr_n75819504)
print v(xbgr.mr_n75820096)
print v(xbgr.mr_n75824272)
print v(xbgr.mr_n75830288)
print v(xbgr.mr_n75830608)
print v(xbgr.mr_n75835472)
print v(xbgr.mr_n75837152)
print v(xbgr.mr_n75837664)
print v(xbgr.mr_n75838336)
print v(xbgr.mr_n75838928)
print v(xbgr.mr_n75839440)
print v(xbgr.mr_n75840112)
print v(xbgr.mr_n75840704)
print v(xbgr.mr_n75841120)
print v(xbgr.mr_n75841296)
print v(xbgr.mr_n75841888)
print v(xbgr.mr_n75842544)
print v(xbgr.mr_n75843072)
print v(xbgr.mr_n75843664)
print v(xbgr.mr_n75844256)
print v(xbgr.mr_n75844848)
print v(xbgr.mr_n75845440)
print v(xbgr.mr_n75846032)
print v(xbgr.mr_n75846544)
print v(xbgr.mr_n75847216)
print v(xbgr.mr_n75847808)
print v(xbgr.mr_n75848400)
print v(xbgr.mr_n75848992)
print v(xbgr.mr_n75849584)
print v(xbgr.mr_n75850176)
print v(xbgr.mr_n75850704)
print v(xbgr.mr_n75851280)
print v(xbgr.mr_n75851888)
print v(xbgr.mr_n75852480)
print v(xbgr.mr_n75853136)
print v(xbgr.mr_n75853728)
print v(xbgr.mr_n75854240)
print v(xbgr.mr_n75854912)
print v(xbgr.mr_n75855504)
print v(xbgr.mr_n75856688)
print v(xbgr.mr_n75857200)
print v(xbgr.mr_n75857808)
print v(xbgr.mr_n75858464)
print v(xbgr.mr_n75859120)
print v(xbgr.mr_n75859648)
print v(xbgr.mr_n75860240)
print v(xbgr.mr_n75860832)
print v(xbgr.mr_n75861344)
print v(xbgr.mr_n75862016)
print v(xbgr.mr_n75862608)
print v(xbgr.mr_n75862864)
print v(xbgr.mr_n75863120)
print v(xbgr.mr_n75863792)
print v(xbgr.mr_n75864384)
print v(xbgr.mr_n75864848)
print v(xbgr.mr_n75865552)
print v(xbgr.mr_n75871344)
print v(xbgr.mr_n75874032)
print v(xbgr.mr_n75877680)
print v(xbgr.mr_n75879136)
print v(xbgr.mr_n75888304)
print v(xbgr.mr_n75892368)
print v(xbgr.mr_n75906672)
print v(xbgr.mr_n75906816)
print v(xbgr.mr_n75907568)
print v(xbgr.mr_n75907728)
print v(xbgr.mr_n75910144)
print v(xbgr.mr_n75910256)
print v(xbgr.mr_n75910864)
print v(xbgr.mr_n75911584)
print v(xbgr.mr_n75911696)
print v(xbgr.mr_n75912304)
print v(xbgr.mr_n75913024)
print v(xbgr.mr_n75913136)
print v(xbgr.mr_n75913744)
print v(xbgr.mr_n75914496)
print v(xbgr.mr_n75915008)
print v(xbgr.mr_n75916976)
print v(xbgr.mr_n75919728)
print v(xbgr.mr_n75922288)
print v(xbgr.mr_n75923264)
print v(xbgr.mr_n75934448)
print v(xbgr.mr_n75946736)
print v(xbgr.mr_n75948112)
print v(xbgr.mr_n75948384)
print v(xbgr.mr_n75949488)
print v(xbgr.mr_n75949856)
print v(xbgr.mr_n75952032)
print v(xbgr.mr_n75953072)
print v(xbgr.mr_n75953456)
print v(xbgr.mr_n75953664)
print v(xbgr.mr_n75954112)
print v(xbgr.mr_n75954480)
print v(xbgr.mr_n75956096)
print v(xbgr.mr_n75956208)
print v(xbgr.mr_n75957392)
print v(xbgr.mr_n75958416)
print v(xbgr.mr_n75959344)
print v(xbgr.mr_n75959808)
print v(xbgr.mr_n75960336)
print v(xbgr.mr_n75961520)
print v(xbgr.mr_n75962112)
print v(xbgr.mr_n75962704)
print v(xbgr.mr_n75963072)
print v(xbgr.mr_n75963296)
print v(xbgr.mr_n75963888)
print v(xbgr.mr_n75964480)
print v(xbgr.mr_n75965072)
print v(xbgr.mr_n75965664)
print v(xbgr.mr_n75966176)
print v(xbgr.mr_n75966848)
print v(xbgr.mr_n75967440)
print v(xbgr.mr_n75968032)
print v(xbgr.mr_n75968624)
print v(xbgr.mr_n75969216)
print v(xbgr.mr_n75969808)
print v(xbgr.mr_n75970400)
print v(xbgr.mr_n75970992)
print v(xbgr.mr_n75972176)
print v(xbgr.mr_n75972768)
print v(xbgr.mr_n75973360)
print v(xbgr.mr_n75973952)
print v(xbgr.mr_n75974544)
print v(xbgr.mr_n75975136)
print v(xbgr.mr_n75975728)
print v(xbgr.mr_n75976320)
print v(xbgr.mr_n75976912)
print v(xbgr.mr_n75977504)
print v(xbgr.mr_n75978096)
print v(xbgr.mr_n75979280)
print v(xbgr.mr_n75979872)
print v(xbgr.mr_n75980464)
print v(xbgr.mr_n75981056)
print v(xbgr.mr_n75981648)
print v(xbgr.mr_n75982240)
print v(xbgr.mr_n75982832)
print v(xbgr.mr_n75983344)
print v(xbgr.mr_n75984000)
print v(xbgr.mr_n75984592)
print v(xbgr.mr_n75985184)
print v(xbgr.mr_n75985776)
print v(xbgr.mr_n75986368)
print v(xbgr.mr_n75986880)
print v(xbgr.mr_n75987552)
print v(xbgr.mr_n75988144)
print v(xbgr.mr_n75988736)
print v(xbgr.mr_n75989328)
print v(xbgr.mr_n75989920)
print v(xbgr.mr_n75990512)
print v(xbgr.mr_n75991104)
print v(xbgr.mr_n75991696)
print v(xbgr.mr_n75992288)
print v(xbgr.mr_n75993472)
print v(xbgr.mr_n75994064)
print v(xbgr.mr_n75994656)
print v(xbgr.mr_n75995248)
print v(xbgr.mr_n75995760)
print v(xbgr.mr_n75996432)
print v(xbgr.mr_n75997024)
print v(xbgr.mr_n75997616)
print v(xbgr.mr_n75998208)
print v(xbgr.mr_n75998800)
print v(xbgr.mr_n75999392)
print v(xbgr.mr_n75999984)
print v(xbgr.mr_n76000320)
print v(xbgr.mr_n76000576)
print v(xbgr.mr_n76001248)
print v(xbgr.mr_n76001360)
print v(xbgr.mr_n76002384)
print v(xbgr.mr_n76002928)
print v(xbgr.mr_n76003392)
print v(xbgr.mr_n76003856)
print v(xbgr.mr_n76004320)
print v(xbgr.mr_n76004592)
print v(xbgr.mr_n76004784)
print v(xbgr.mr_n76005824)
print v(xbgr.mr_n76006800)
print v(xbgr.mr_n76007328)
print v(xbgr.mr_n76007920)
print v(xbgr.mr_n76008448)
print v(xbgr.mr_n76012016)
print v(xbgr.mr_n76012752)
print v(xbgr.mr_n76013632)
print v(xbgr.mr_n76013744)
print v(xbgr.mr_n76013856)
print v(xbgr.mr_n76013968)
print v(xbgr.mr_n76014080)
print v(xbgr.mr_n76014192)
print v(xbgr.mr_n76014304)
print v(xbgr.mr_n76014496)
print v(xbgr.mr_n76014768)
print v(xbgr.mr_n76015040)
print v(xbgr.mr_n76015312)
print v(xbgr.mr_n76015584)
print v(xbgr.mr_n76015856)
print v(xbgr.mr_n76016128)
print v(xbgr.mr_n76016400)
print v(xbgr.mr_n76016672)
print v(xbgr.mr_n76016976)
print v(xbgr.mr_n76017376)
print v(xbgr.mr_n76017776)
print v(xbgr.mr_n76018176)
print v(xbgr.mr_n76018576)
print v(xbgr.mr_n76018976)
print v(xbgr.mr_n76019376)
print v(xbgr.mr_n76019776)
print v(xbgr.mr_n76020176)
print v(xbgr.mr_n76020576)
print v(xbgr.mr_n76020976)
print v(xbgr.mr_n76021376)
print v(xbgr.mr_n76021776)
print v(xbgr.mr_n76022176)
print v(xbgr.mr_n76022576)
print v(xbgr.mr_n76022896)
print v(xbgr.mr_n76023376)
print v(xbgr.mr_n76023776)
print v(xbgr.mr_n76024176)
print v(xbgr.mr_n76024576)
print v(xbgr.mr_n76024976)
print v(xbgr.mr_n76025376)
print v(xbgr.mr_n76025776)
print v(xbgr.mr_n76026176)
print v(xbgr.mr_n76026576)
print v(xbgr.mr_n76026976)
print v(xbgr.mr_n76027376)
print v(xbgr.mr_n76027776)
print v(xbgr.mr_n76028176)
print v(xbgr.mr_n76028432)
print v(xbgr.mr_n76028624)
print v(xbgr.mr_n76028896)
print v(xbgr.mr_n76029168)
print v(xbgr.mr_n76029440)
print v(xbgr.mr_n76029712)
print v(xbgr.mr_n76029984)
print v(xbgr.mr_n76030256)
print v(xbgr.mr_n76030528)
print v(xbgr.mr_n76030800)
print v(xbgr.mr_n76031072)
print v(xbgr.mr_n76031344)
print v(xbgr.mr_n76031616)
print v(xbgr.mr_n76031888)
print v(xbgr.mr_n76032160)
print v(xbgr.mr_n76032432)
print v(xbgr.mr_n76032704)
print v(xbgr.mr_n76032976)
print v(xbgr.mr_n76033424)
print v(xbgr.mr_n76033616)
print v(xbgr.mr_n76033808)
print v(xbgr.mr_n76034000)
print v(xbgr.mr_n76034944)
print v(xbgr.mr_n76038704)
print v(xbgr.mr_n76038816)
print v(xbgr.mr_n76039008)
print v(xbgr.mr_n76039760)
print v(xbgr.mr_n76040672)
print v(xbgr.mr_n76041424)
print v(xbgr.mr_n76043696)
print v(xbgr.mr_n76043808)
print v(xbgr.mr_n76044000)
print v(xbgr.mr_n76044752)
print v(xbgr.mr_n76045664)
print v(xbgr.mr_n76046416)
print v(xbgr.mr_n76048688)
print v(xbgr.mr_n76048800)
print v(xbgr.mr_n76048992)
print v(xbgr.mr_n76049744)
print v(xbgr.mr_n76050656)
print v(xbgr.mr_n76051408)
print v(xbgr.mr_n76053680)
print v(xbgr.mr_n76053792)
print v(xbgr.mr_n76053984)
print v(xbgr.mr_n76054736)
print v(xbgr.mr_n76055648)
print v(xbgr.mr_n76056400)
print v(xbgr.mr_n76058672)
print v(xbgr.mr_n76058784)
print v(xbgr.mr_n76058976)
print v(xbgr.mr_n76059728)
print v(xbgr.mr_n76060640)
print v(xbgr.mr_n76061392)
print v(xbgr.mr_n76063664)
print v(xbgr.mr_n76063776)
print v(xbgr.mr_n76063968)
print v(xbgr.mr_n76064720)
print v(xbgr.mr_n76068240)
print v(xbgr.mr_n76068752)
print v(xbgr.mr_n76069184)
print v(xbgr.mr_n76069360)
print v(xbgr.mr_n76069696)
print v(xbgr.mr_n76070208)
print v(xbgr.mr_n76070640)
print v(xbgr.mr_n76070816)
print v(xbgr.mr_n76071072)
print v(xbgr.mr_n76071856)
print v(xbgr.mr_n76072032)
print v(xbgr.mr_n76072208)
print v(xbgr.mr_n76072720)
print v(xbgr.mr_n76072832)
print v(xbgr.mr_n76073392)
print v(xbgr.mr_n76073568)
print v(xbgr.mr_n76073904)
print v(xbgr.mr_n76074768)
print v(xbgr.mr_n76074944)
print v(xbgr.mr_n76075120)
print v(xbgr.mr_n76075632)
print v(xbgr.mr_n76075744)
print v(xbgr.mr_n76076304)
print v(xbgr.mr_n76076480)
print v(xbgr.mr_n76076976)
print v(xbgr.mr_n76077488)
print v(xbgr.mr_n76077920)
print v(xbgr.mr_n76078096)
print v(xbgr.mr_n76078432)
print v(xbgr.mr_n76079136)
print v(xbgr.mr_n76079312)
print v(xbgr.mr_n76079488)
print v(xbgr.mr_n76080000)
print v(xbgr.mr_n76080112)
print v(xbgr.mr_n76080672)
print v(xbgr.mr_n76080848)
print v(xbgr.mr_n76081344)
print v(xbgr.mr_n76081856)
print v(xbgr.mr_n76082288)
print v(xbgr.mr_n76082464)
print v(xbgr.mr_n76082800)
print v(xbgr.mr_n76083312)
print v(xbgr.mr_n76083744)
print v(xbgr.mr_n76083920)
print v(xbgr.mr_n76084256)
print v(xbgr.mr_n76084960)
print v(xbgr.mr_n76085136)
print v(xbgr.mr_n76085312)
print v(xbgr.mr_n76085824)
print v(xbgr.mr_n76086256)
print v(xbgr.mr_n76086432)
print v(xbgr.mr_n76086688)
print v(xbgr.mr_n76087280)
print v(xbgr.mr_n76087712)
print v(xbgr.mr_n76087888)
print v(xbgr.mr_n76088224)
print v(xbgr.mr_n76088848)
print v(xbgr.mr_n76089408)
print v(xbgr.mr_n76089584)
print v(xbgr.mr_n76090080)
print v(xbgr.mr_n76090784)
print v(xbgr.mr_n76090960)
print v(xbgr.mr_n76091136)
print v(xbgr.mr_n76091648)
print v(xbgr.mr_n76091760)
print v(xbgr.mr_n76091872)
print v(xbgr.mr_n76091984)
print v(xbgr.mr_n76092096)
print v(xbgr.mr_n76092368)
print v(xbgr.mr_n76092720)
print v(xbgr.mr_n76092832)
print v(xbgr.mr_n76093104)
print v(xbgr.mr_n76093456)
print v(xbgr.mr_n76093696)
print v(xbgr.mr_n76094032)
print v(xbgr.mr_n76094384)
print v(xbgr.mr_n76094496)
print v(xbgr.mr_n76094688)
print v(xbgr.mr_n76094960)
print v(xbgr.mr_n76095232)
print v(xbgr.mr_n76095504)
print v(xbgr.mr_n76095776)
print v(xbgr.mr_n76096048)
print v(xbgr.mr_n76096672)
print v(xbgr.mr_n76096864)
print v(xbgr.mr_n76097056)
print v(xbgr.mr_n76097248)
print v(xbgr.mr_n76098000)
print v(xbgr.mr_n76116144)
print v(xbgr.mr_n76116320)
print v(xbgr.mr_n76117024)
print v(xbgr.mr_n76117200)
print v(xbgr.mr_n76117376)
print v(xbgr.mr_n76118080)
print v(xbgr.mr_n76118256)
print v(xbgr.mr_n76118432)
print v(xbgr.mr_n76119136)
print v(xbgr.mr_n76119312)
print v(xbgr.mr_n76119488)
print v(xbgr.mr_n76120192)
print v(xbgr.mr_n76120368)
print v(xbgr.mr_n76120544)
print v(xbgr.mr_n76121248)
print v(xbgr.mr_n76121424)
print v(xbgr.mr_n76121600)
print v(xbgr.mr_n76122176)
print v(xbgr.mr_n76122368)
print v(xbgr.mr_n76122640)
print v(xbgr.mr_n76122912)
print v(xbgr.mr_n76123184)
print v(xbgr.mr_n76123456)
print v(xbgr.mr_n76123728)
print v(xbgr.mr_n76124000)
print v(xbgr.mr_n76124272)
print v(xbgr.mr_n76124544)
print v(xbgr.mr_n76128080)
print v(xbgr.mr_n76128416)
print v(xbgr.mr_n76128752)
print v(xbgr.mr_n76129088)
print v(xbgr.mr_n76129744)
print v(xbgr.mr_n76130384)
print v(xbgr.mr_n76130784)
print v(xbgr.mr_n76131184)
print v(xbgr.mr_n76131584)
print v(xbgr.mr_n76131984)
print v(xbgr.mr_n76132384)
print v(xbgr.mr_n76132784)
print v(xbgr.mr_n76133248)
print v(xbgr.mr_n76133424)
print v(xbgr.mr_n76134048)
print v(xbgr.mr_n76134224)
print v(xbgr.mr_n76134496)
print v(xbgr.mr_n76134848)
print v(xbgr.mr_n76135024)
print v(xbgr.mr_n76135648)
print v(xbgr.mr_n76135824)
print v(xbgr.mr_n76136720)
print v(xbgr.mr_n76136944)
print v(xbgr.mr_n76137184)
print v(xbgr.mr_n76137456)
print v(xbgr.mr_n76137568)
print v(xbgr.mr_n76137680)
print v(xbgr.mr_n76137792)
print v(xbgr.mr_n76138624)
print v(xbgr.mr_n76139504)
print v(xbgr.mr_n76142544)
print v(xbgr.mr_n76143056)
print v(xbgr.mr_n76144352)
print v(xbgr.mr_n76144864)
print v(xbgr.mr_n76146160)
print v(xbgr.mr_n76146672)
print v(xbgr.mr_n76147968)
print v(xbgr.mr_n76148480)
print v(xbgr.mr_n76149776)
print v(xbgr.mr_n76150288)
print v(xbgr.mr_n76151584)
print v(xbgr.mr_n76152096)
print v(xbgr.mr_n76153392)
print v(xbgr.mr_n76153904)
print v(xbgr.mr_n76155200)
print v(xbgr.mr_n76155712)
print v(xbgr.mr_n76157008)
print v(xbgr.mr_n76157520)
print v(xbgr.mr_n76158816)
print v(xbgr.mr_n76159328)
print v(xbgr.mr_n76160624)
print v(xbgr.mr_n76161136)
print v(xbgr.mr_n76162352)
print v(xbgr.mr_n76162944)
print v(xbgr.mr_n76163056)
print v(xbgr.mr_n76163168)
print v(xbgr.mr_n76163280)
print v(xbgr.mr_n76163552)
print v(xbgr.mr_n76163664)
print v(xbgr.mr_n76164016)
print v(xbgr.mr_n76164128)
print v(xbgr.mr_n76164400)
print v(xbgr.mr_n76164752)
print v(xbgr.mr_n76164864)
print v(xbgr.mr_n76165232)
print v(xbgr.mr_n76165856)
print v(xbgr.mr_n76166400)
print v(xbgr.mr_n76166832)
print v(xbgr.mr_n76167248)
print v(xbgr.mr_n76167936)
print v(xbgr.mr_n76168400)
print v(xbgr.mr_n76168816)
print v(xbgr.mr_n76169504)
print v(xbgr.mr_n76170032)
print v(xbgr.mr_n76170384)
print v(xbgr.mr_n76171072)
print v(xbgr.mr_n76171536)
print v(xbgr.mr_n76171952)
print v(xbgr.mr_n76172640)
print v(xbgr.mr_n76173104)
print v(xbgr.mr_n76173520)
print v(xbgr.mr_n76174208)
print v(xbgr.mr_n76174736)
print v(xbgr.mr_n76175088)
print v(xbgr.mr_n76175776)
print v(xbgr.mr_n76176240)
print v(xbgr.mr_n76176656)
print v(xbgr.mr_n76177344)
print v(xbgr.mr_n76177808)
print v(xbgr.mr_n76178224)
print v(xbgr.mr_n76178912)
print v(xbgr.mr_n76179376)
print v(xbgr.mr_n76179792)
print v(xbgr.mr_n76180480)
print v(xbgr.mr_n76180944)
print v(xbgr.mr_n76181360)
print v(xbgr.mr_n76182048)
print v(xbgr.mr_n76182576)
print v(xbgr.mr_n76182928)
print v(xbgr.mr_n76183616)
print v(xbgr.mr_n76184000)
print v(xbgr.mr_n76184496)
print v(xbgr.mr_n76185184)
print v(xbgr.mr_n76185712)
print v(xbgr.mr_n76186064)
print v(xbgr.mr_n76186576)
print v(xbgr.mr_n76188032)
print v(xbgr.mr_n76190528)
print v(xbgr.mr_n76193152)
print v(xbgr.mr_n76196736)
print v(xbgr.mr_n76196880)
print v(xbgr.mr_n76197184)
print v(xbgr.mr_n76197456)
print v(xbgr.mr_n76198656)
print v(xbgr.mr_n76200320)
print v(xbgr.mr_n76200832)
print v(xbgr.mr_n76202112)
print v(xbgr.mr_n76204736)
print v(xbgr.mr_n76208192)
print v(xbgr.mr_n76209120)
print v(xbgr.mr_n76209584)
print v(xbgr.mr_n76210048)
print v(xbgr.mr_n76210512)
print v(xbgr.mr_n76210976)
print v(xbgr.mr_n76211440)
print v(xbgr.mr_n76211904)
print v(xbgr.mr_n76212368)
print v(xbgr.mr_n76212832)
print v(xbgr.mr_n76213296)
print v(xbgr.mr_n76213760)
print v(xbgr.mr_n76214224)
print v(xbgr.mr_n76214688)
print v(xbgr.mr_n76215152)
print v(xbgr.mr_n76215616)
print v(xbgr.mr_n76216080)
print v(xbgr.mr_n76216192)
print v(xbgr.mr_n76216448)
print v(xbgr.mr_n76216704)
print v(xbgr.mr_n76217024)
print v(xbgr.mr_n76219936)
print v(xbgr.mr_n76220480)
print v(xbgr.mr_n76220816)
print v(xbgr.mr_n76221152)
print v(xbgr.mr_n76222256)
print v(xbgr.mr_n76222368)
print v(xbgr.mr_n76222880)
print v(xbgr.mr_n76223472)
print v(xbgr.mr_n76224192)
print v(xbgr.mr_n76225072)
print v(xbgr.mr_n76225328)
print v(xbgr.mr_n76230064)
print v(xbgr.mr_n76236464)
print v(xbgr.mr_n76238096)
print v(xbgr.mr_n76238208)
print v(xbgr.mr_n76239888)
print v(xbgr.mr_n76240560)
print v(xbgr.mr_n76241616)
print v(xbgr.mr_n76241808)
print v(xbgr.mr_n76243328)
print v(xbgr.mr_n76243936)
print v(xbgr.mr_n76244784)
print v(xbgr.mr_n76244976)
print v(xbgr.mr_n76245760)
print v(xbgr.mr_n76246496)
print v(xbgr.mr_n76247184)
print v(xbgr.mr_n76248304)
print v(xbgr.mr_n76262816)
print v(xbgr.mr_n76267680)
print v(xbgr.mr_n76268464)
print v(xbgr.mr_n76268640)
print v(xbgr.mr_n76269200)
print v(xbgr.mr_n76269728)
print v(xbgr.mr_n76269904)
print v(xbgr.mr_n76270160)
print v(xbgr.mr_n76270864)
print v(xbgr.mr_n76271040)
print v(xbgr.mr_n76278640)
print v(xbgr.mr_n76279104)
print v(xbgr.mr_n76279568)
print v(xbgr.mr_n76280032)
print v(xbgr.mr_n76280496)
print v(xbgr.mr_n76280960)
print v(xbgr.mr_n76281424)
print v(xbgr.mr_n76281888)
print v(xbgr.mr_n76282352)
print v(xbgr.mr_n76282816)
print v(xbgr.mr_n76283280)
print v(xbgr.mr_n76283744)
print v(xbgr.mr_n76284208)
print v(xbgr.mr_n76284672)
print v(xbgr.mr_n76285136)
print v(xbgr.mr_n76285600)
print v(xbgr.mr_n76286064)
print v(xbgr.mr_n76293216)
print v(xbgr.mr_n76302848)
print v(xbgr.mr_n76305760)
print v(xbgr.mr_n76314432)
print v(xbgr.mr_n76314784)
print v(xbgr.mr_n76315680)
print v(xbgr.mr_n76320800)
print v(xbgr.mr_n76321552)
print v(xbgr.mr_n76321744)
print v(xbgr.mr_n76322000)
print v(xbgr.mr_n76322256)
print v(xbgr.mr_n76324224)
print v(xbgr.mr_n76325520)
print v(xbgr.mr_n76328160)
print v(xbgr.mr_n76329488)
print v(xbgr.mr_n76331536)
print v(xbgr.mr_n76334304)
print v(xbgr.mr_n76335632)
print v(xbgr.mr_n76337680)
print v(xbgr.mr_n76340448)
print v(xbgr.mr_n76341776)
print v(xbgr.mr_n76343824)
print v(xbgr.mr_n76346592)
print v(xbgr.mr_n76347920)
print v(xbgr.mr_n76349968)
print v(xbgr.mr_n76352736)
print v(xbgr.mr_n76354064)
print v(xbgr.mr_n76356112)
print v(xbgr.mr_n76358880)
print v(xbgr.mr_n76360208)
print v(xbgr.mr_n76364320)
print v(xbgr.mr_n76367520)
print v(xbgr.mr_n76367920)
print v(xbgr.mr_n76368320)
print v(xbgr.mr_n76368720)
print v(xbgr.mr_n76369120)
print v(xbgr.mr_n76369520)
print v(xbgr.mr_n76369920)
print v(xbgr.mr_n76370320)
print v(xbgr.mr_n76370720)
print v(xbgr.mr_n76371120)
print v(xbgr.mr_n76371520)
print v(xbgr.mr_n76371920)
print v(xbgr.mr_n76372320)
print v(xbgr.mr_n76372720)
print v(xbgr.mr_n76373120)
print v(xbgr.mr_n76373520)
print v(xbgr.mr_n76373792)
print v(xbgr.mr_n76373904)
print v(xbgr.mr_n76374016)
print v(xbgr.mr_n76374128)
print v(xbgr.mr_n76374240)
print v(xbgr.mr_n76374432)
print v(xbgr.mr_n76374704)
print v(xbgr.mr_n76374976)
print v(xbgr.mr_n76375248)
print v(xbgr.mr_n76375520)
print v(xbgr.mr_n76375792)
print v(xbgr.mr_n76376064)
print v(xbgr.mr_n76376336)
print v(xbgr.mr_n76376672)
print v(xbgr.mr_n76377072)
print v(xbgr.mr_n76380096)
print v(xbgr.mr_n76380208)
print v(xbgr.mr_n76389568)
print v(xbgr.mr_n76391296)
print v(xbgr.mr_n76391840)
print v(xbgr.mr_n76392016)
print v(xbgr.mr_n76392864)
print v(xbgr.mr_n76393344)
print v(xbgr.mr_n76393840)
print v(xbgr.mr_n76394384)
print v(xbgr.mr_n76394560)
print v(xbgr.mr_n76395408)
print v(xbgr.mr_n76395888)
print v(xbgr.mr_n76396384)
print v(xbgr.mr_n76396928)
print v(xbgr.mr_n76397104)
print v(xbgr.mr_n76397888)
print v(xbgr.mr_n76398432)
print v(xbgr.mr_n76398928)
print v(xbgr.mr_n76399472)
print v(xbgr.mr_n76399648)
print v(xbgr.mr_n76400352)
print v(xbgr.mr_n76400976)
print v(xbgr.mr_n76401472)
print v(xbgr.mr_n76402016)
print v(xbgr.mr_n76402192)
print v(xbgr.mr_n76403040)
print v(xbgr.mr_n76403520)
print v(xbgr.mr_n76403952)
print v(xbgr.mr_n76404560)
print v(xbgr.mr_n76404736)
print v(xbgr.mr_n76405584)
print v(xbgr.mr_n76406064)
print v(xbgr.mr_n76406560)
print v(xbgr.mr_n76406752)
print v(xbgr.mr_n76406864)
print v(xbgr.mr_n76406976)
print v(xbgr.mr_n76407680)
print v(xbgr.mr_n76408256)
print v(xbgr.mr_n76408528)
print v(xbgr.mr_n76408800)
print v(xbgr.mr_n76409264)
print v(xbgr.mr_n76409728)
print v(xbgr.mr_n76410192)
print v(xbgr.mr_n76410656)
print v(xbgr.mr_n76417552)
print v(xbgr.mr_n76422784)
print v(xbgr.mr_n76422976)
print v(xbgr.mr_n76423232)
print v(xbgr.mr_n76423488)
print v(xbgr.mr_n76425456)
print v(xbgr.mr_n76448768)
print v(xbgr.mr_n76449264)
print v(xbgr.mr_n76449568)
print v(xbgr.mr_n76450064)
print v(xbgr.mr_n76450368)
print v(xbgr.mr_n76450928)
print v(xbgr.mr_n76451232)
print v(xbgr.mr_n76452112)
print v(xbgr.mr_n76452416)
print v(xbgr.mr_n76453296)
print v(xbgr.mr_n76453600)
print v(xbgr.mr_n76454480)
print v(xbgr.mr_n76454784)
print v(xbgr.mr_n76455664)
print v(xbgr.mr_n76455968)
print v(xbgr.mr_n76456848)
print v(xbgr.mr_n76457152)
print v(xbgr.mr_n76458032)
print v(xbgr.mr_n76458336)
print v(xbgr.mr_n76459216)
print v(xbgr.mr_n76459520)
print v(xbgr.mr_n76460400)
print v(xbgr.mr_n76460704)
print v(xbgr.mr_n76461584)
print v(xbgr.mr_n76461888)
print v(xbgr.mr_n76462768)
print v(xbgr.mr_n76463072)
print v(xbgr.mr_n76463952)
print v(xbgr.mr_n76464256)
print v(xbgr.mr_n76465136)
print v(xbgr.mr_n76465328)
print v(xbgr.mr_n76465600)
print v(xbgr.mr_n76466064)
print v(xbgr.mr_n76467856)
print v(xbgr.mr_n76478880)
print v(xbgr.mr_n76480128)
print v(xbgr.mr_n76480464)
print v(xbgr.mr_n76480800)
print v(xbgr.mr_n76481136)
print v(xbgr.mr_n76483168)
print v(xbgr.mr_n76483936)
print v(xbgr.mr_n76484336)
print v(xbgr.mr_n76484736)
print v(xbgr.mr_n76485136)
print v(xbgr.mr_n76485536)
print v(xbgr.mr_n76485936)
print v(xbgr.mr_n76486336)
print v(xbgr.mr_n76486736)
print v(xbgr.mr_n76487136)
print v(xbgr.mr_n76487536)
print v(xbgr.mr_n76487936)
print v(xbgr.mr_n76488336)
print v(xbgr.mr_n76488736)
print v(xbgr.mr_n76489136)
print v(xbgr.mr_n76489536)
print v(xbgr.mr_n76489936)
print v(xbgr.mr_n76492400)
print v(xbgr.mr_n76501984)
print v(xbgr.mr_n76510912)
print v(xbgr.mr_n76513456)
print v(xbgr.mr_n76519136)
print v(xbgr.mr_n76520352)
print v(xbgr.mr_n76520656)
print v(xbgr.mr_n76520960)
print v(xbgr.mr_n76521264)
print v(xbgr.mr_n76521648)
print v(xbgr.mr_n76522112)
print v(xbgr.mr_n76522576)
print v(xbgr.mr_n76523040)
print v(xbgr.mr_n76523504)
print v(xbgr.mr_n76523968)
print v(xbgr.mr_n76524432)
print v(xbgr.mr_n76524896)
print v(xbgr.mr_n76525360)
print v(xbgr.mr_n76525920)
print v(xbgr.mr_n76526592)
print v(xbgr.mr_n76527136)
print v(xbgr.mr_n76527312)
print v(xbgr.mr_n76528192)
print v(xbgr.mr_n76528368)
print v(xbgr.mr_n76529536)
print v(xbgr.mr_n76530240)
print v(xbgr.mr_n76530752)
print v(xbgr.mr_n76531232)
print v(xbgr.mr_n76532064)
print v(xbgr.mr_n76534416)
print v(xbgr.mr_n76538080)
print v(xbgr.mr_n76538416)
print v(xbgr.mr_n76538752)
print v(xbgr.mr_n76539088)
print v(xbgr.mr_n76539280)
print v(xbgr.mr_n76541408)
print v(xbgr.mr_n76543888)
print v(xbgr.mr_n76544224)
print v(xbgr.mr_n76545648)
print v(xbgr.mr_n76546352)
print v(xbgr.mr_n76546464)
print v(xbgr.mr_n76548736)
print v(xbgr.mr_n76548848)
print v(xbgr.mr_n76548960)
print v(xbgr.mr_n76549232)
print v(xbgr.mr_n76551344)
print v(xbgr.mr_n76551984)
print v(xbgr.mr_n76552096)
print v(xbgr.mr_n76553792)
print v(xbgr.mr_n76553904)
print v(xbgr.mr_n76554016)
print v(xbgr.mr_n76554288)
print v(xbgr.mr_n76556256)
print v(xbgr.mr_n76557040)
print v(xbgr.mr_n76557152)
print v(xbgr.mr_n76558416)
print v(xbgr.mr_n76559120)
print v(xbgr.mr_n76559760)
print v(xbgr.mr_n76559872)
print v(xbgr.mr_n76561216)
print v(xbgr.mr_n76562096)
print v(xbgr.mr_n76562208)
print v(xbgr.mr_n76563904)
print v(xbgr.mr_n76564016)
print v(xbgr.mr_n76564128)
print v(xbgr.mr_n76564400)
print v(xbgr.mr_n76566560)
print v(xbgr.mr_n76566672)
print v(xbgr.mr_n76566864)
print v(xbgr.mr_n76568336)
print v(xbgr.mr_n76569088)
print v(xbgr.mr_n76569872)
print v(xbgr.mr_n76569984)
print v(xbgr.mr_n76571488)
print v(xbgr.mr_n76572208)
print v(xbgr.mr_n76572320)
print v(xbgr.mr_n76574016)
print v(xbgr.mr_n76574128)
print v(xbgr.mr_n76574240)
print v(xbgr.mr_n76574512)
print v(xbgr.mr_n76576672)
print v(xbgr.mr_n76576784)
print v(xbgr.mr_n76576976)
print v(xbgr.mr_n76579008)
print v(xbgr.mr_n76579120)
print v(xbgr.mr_n76579232)
print v(xbgr.mr_n76579504)
print v(xbgr.mr_n76581728)
print v(xbgr.mr_n76581840)
print v(xbgr.mr_n76582032)
print v(xbgr.mr_n76582544)
print v(xbgr.mr_n76582880)
print v(xbgr.mr_n76583232)
print v(xbgr.mr_n76583856)
print v(xbgr.mr_n76584384)
print v(xbgr.mr_n76584736)
print v(xbgr.mr_n76585424)
print v(xbgr.mr_n76585888)
print v(xbgr.mr_n76586304)
print v(xbgr.mr_n76586992)
print v(xbgr.mr_n76587456)
print v(xbgr.mr_n76587872)
print v(xbgr.mr_n76588560)
print v(xbgr.mr_n76589024)
print v(xbgr.mr_n76589440)
print v(xbgr.mr_n76590128)
print v(xbgr.mr_n76590592)
print v(xbgr.mr_n76591008)
print v(xbgr.mr_n76591696)
print v(xbgr.mr_n76592160)
print v(xbgr.mr_n76592576)
print v(xbgr.mr_n76593264)
print v(xbgr.mr_n76593728)
print v(xbgr.mr_n76594144)
print v(xbgr.mr_n76594832)
print v(xbgr.mr_n76595360)
print v(xbgr.mr_n76595712)
print v(xbgr.mr_n76596400)
print v(xbgr.mr_n76596864)
print v(xbgr.mr_n76597280)
print v(xbgr.mr_n76597968)
print v(xbgr.mr_n76598496)
print v(xbgr.mr_n76598848)
print v(xbgr.mr_n76599536)
print v(xbgr.mr_n76600000)
print v(xbgr.mr_n76605280)
print v(xbgr.mr_n76605584)
print v(xbgr.mr_n76605968)
print v(xbgr.mr_n76610208)
print v(xbgr.mr_n76611456)
print v(xbgr.mr_n76620896)
print v(xbgr.mr_n76621360)
print v(xbgr.mr_n76621824)
print v(xbgr.mr_n76622288)
print v(xbgr.mr_n76622752)
print v(xbgr.mr_n76623216)
print v(xbgr.mr_n76623680)
print v(xbgr.mr_n76624144)
print v(xbgr.mr_n76624608)
print v(xbgr.mr_n76625072)
print v(xbgr.mr_n76625536)
print v(xbgr.mr_n76626000)
print v(xbgr.mr_n76626464)
print v(xbgr.mr_n76626928)
print v(xbgr.mr_n76627392)
print v(xbgr.mr_n76627856)
print v(xbgr.mr_n76628320)
print v(xbgr.mr_n76628784)
print v(xbgr.mr_n76629248)
print v(xbgr.mr_n76629712)
print v(xbgr.mr_n76631744)
print v(xbgr.mr_n76640384)
print v(xbgr.mr_n76652784)
print v(xbgr.mr_n76652976)
print v(xbgr.mr_n76653488)
print v(xbgr.mr_n76655456)
print v(xbgr.mr_n76677328)
print v(xbgr.mr_n76678032)
print v(xbgr.mr_n76678144)
print v(xbgr.mr_n76678656)
print v(xbgr.mr_n76678768)
print v(xbgr.mr_n76678880)
print v(xbgr.mr_n76679392)
print v(xbgr.mr_n76679504)
print v(xbgr.mr_n76679856)
print v(xbgr.mr_n76679968)
print v(xbgr.mr_n76680320)
print v(xbgr.mr_n76680432)
print v(xbgr.mr_n76680784)
print v(xbgr.mr_n76680896)
print v(xbgr.mr_n76681280)
print v(xbgr.mr_n76681456)
print v(xbgr.mr_n76681936)
print v(xbgr.mr_n76682112)
print v(xbgr.mr_n76682592)
print v(xbgr.mr_n76682768)
print v(xbgr.mr_n76683248)
print v(xbgr.mr_n76683424)
print v(xbgr.mr_n76683904)
print v(xbgr.mr_n76684080)
print v(xbgr.mr_n76684560)
print v(xbgr.mr_n76684736)
print v(xbgr.mr_n76688096)
print v(xbgr.mr_n76688432)
print v(xbgr.mr_n76689088)
print v(xbgr.mr_n76689920)
print v(xbgr.mr_n76690096)
print v(xbgr.mr_n76690272)
print v(xbgr.mr_n76690976)
print v(xbgr.mr_n76691152)
print v(xbgr.mr_n76691712)
print v(xbgr.mr_n76692176)
print v(xbgr.mr_n76692352)
print v(xbgr.mr_n76692528)
print v(xbgr.mr_n76693232)
print v(xbgr.mr_n76693408)
print v(xbgr.mr_n76694032)
print v(xbgr.mr_n76694208)
print v(xbgr.mr_n76694384)
print v(xbgr.mr_n76694896)
print v(xbgr.mr_n76695328)
print v(xbgr.mr_n76695504)
print v(xbgr.mr_n76695840)
print v(xbgr.mr_n76696544)
print v(xbgr.mr_n76696720)
print v(xbgr.mr_n76697344)
print v(xbgr.mr_n76697520)
print v(xbgr.mr_n76697696)
print v(xbgr.mr_n76698400)
print v(xbgr.mr_n76698576)
print v(xbgr.mr_n76699200)
print v(xbgr.mr_n76699376)
print v(xbgr.mr_n76699552)
print v(xbgr.mr_n76700192)
print v(xbgr.mr_n76700464)
print v(xbgr.mr_n76700896)
print v(xbgr.mr_n76701072)
print v(xbgr.mr_n76701408)
print v(xbgr.mr_n76702112)
print v(xbgr.mr_n76702288)
print v(xbgr.mr_n76702912)
print v(xbgr.mr_n76703088)
print v(xbgr.mr_n76703264)
print v(xbgr.mr_n76703904)
print v(xbgr.mr_n76704176)
print v(xbgr.mr_n76704288)
print v(xbgr.mr_n76704400)
print v(xbgr.mr_n76704512)
print v(xbgr.mr_n76704624)
print v(xbgr.mr_n76704896)
print v(xbgr.mr_n76705248)
print v(xbgr.mr_n76705360)
print v(xbgr.mr_n76705472)
print v(xbgr.mr_n76705904)
print v(xbgr.mr_n76706384)
print v(xbgr.mr_n76706560)
print v(xbgr.mr_n76706912)
print v(xbgr.mr_n76707280)
print v(xbgr.mr_n76707616)
print v(xbgr.mr_n76707968)
print v(xbgr.mr_n76708080)
print v(xbgr.mr_n76708576)
print v(xbgr.mr_n76709072)
print v(xbgr.mr_n76709552)
print v(xbgr.mr_n76709728)
print v(xbgr.mr_n76710080)
print v(xbgr.mr_n76710448)
print v(xbgr.mr_n76710784)
print v(xbgr.mr_n76711136)
print v(xbgr.mr_n76711248)
print v(xbgr.mr_n76711744)
print v(xbgr.mr_n76712240)
print v(xbgr.mr_n76712720)
print v(xbgr.mr_n76712896)
print v(xbgr.mr_n76713248)
print v(xbgr.mr_n76713616)
print v(xbgr.mr_n76713952)
print v(xbgr.mr_n76714304)
print v(xbgr.mr_n76726192)
print v(xbgr.mr_n76726576)
print v(xbgr.mr_n76727040)
print v(xbgr.mr_n76727504)
print v(xbgr.mr_n76727968)
print v(xbgr.mr_n76728432)
print v(xbgr.mr_n76728896)
print v(xbgr.mr_n76729360)
print v(xbgr.mr_n76729824)
print v(xbgr.mr_n76730288)
print v(xbgr.mr_n76730752)
print v(xbgr.mr_n76731216)
print v(xbgr.mr_n76731680)
print v(xbgr.mr_n76732144)
print v(xbgr.mr_n76732608)
print v(xbgr.mr_n76733072)
print v(xbgr.mr_n76733536)
print v(xbgr.mr_n76734000)
print v(xbgr.mr_n76734464)
print v(xbgr.mr_n76734928)
print v(xbgr.mr_n76735392)
print v(xbgr.mr_n76735856)
print v(xbgr.mr_n76736320)
print v(xbgr.mr_n76736784)
print v(xbgr.mr_n76737312)
print v(xbgr.mr_n76737904)
print v(xbgr.mr_n76740656)
print v(xbgr.mr_n76744800)
print v(xbgr.mr_n76753136)
print v(xbgr.mr_n76755808)
print v(xbgr.mr_n76759600)
print v(xbgr.mr_n76770432)
print v(xbgr.mr_n76770608)
print v(xbgr.mr_n76770944)
print v(xbgr.mr_n76773008)
print v(xbgr.mr_n76773120)
print v(xbgr.mr_n76773312)
print v(xbgr.mr_n76774064)
print v(xbgr.mr_n76776688)
print v(xbgr.mr_n76777440)
print v(xbgr.mr_n76787008)
print v(xbgr.mr_n76787264)
print v(xbgr.mr_n76787616)
print v(xbgr.mr_n76787840)
print v(xbgr.mr_n76790240)
print v(xbgr.mr_n76791328)
print v(xbgr.mr_n76793632)
print v(xbgr.mr_n76794320)
print v(xbgr.mr_n76794480)
print v(xbgr.mr_n76794912)
print v(xbgr.mr_n76795088)
print v(xbgr.mr_n76795424)
print v(xbgr.mr_n76796128)
print v(xbgr.mr_n76796304)
print v(xbgr.mr_n76796768)
print v(xbgr.mr_n76796928)
print v(xbgr.mr_n76797104)
print v(xbgr.mr_n76797296)
print v(xbgr.mr_n76797728)
print v(xbgr.mr_n76797904)
print v(xbgr.mr_n76798528)
print v(xbgr.mr_n76798704)
print v(xbgr.mr_n76799328)
print v(xbgr.mr_n76799504)
print v(xbgr.mr_n76800128)
print v(xbgr.mr_n76800304)
print v(xbgr.mr_n76800928)
print v(xbgr.mr_n76801104)
print v(xbgr.mr_n76801664)
print v(xbgr.mr_n76803088)
print v(xbgr.mr_n76803456)
print v(xbgr.mr_n76803600)
print v(xbgr.mr_n76803968)
print v(xbgr.mr_n76804176)
print v(xbgr.mr_n76805280)
print v(xbgr.mr_n76805456)
print v(xbgr.mr_n76805712)
print v(xbgr.mr_n76807184)
print v(xbgr.mr_n76809120)
print v(xbgr.mr_n76809824)
print v(xbgr.mr_n76810992)
print v(xbgr.mr_n76811232)
print v(xbgr.mr_n76811376)
print v(xbgr.mr_n76812016)
print v(xbgr.mr_n76812144)
print v(xbgr.mr_n76813360)
print v(xbgr.mr_n76813552)
print v(xbgr.mr_n76813984)
print v(xbgr.mr_n76814256)
print v(xbgr.mr_n76814496)
print v(xbgr.mr_n76815376)
print v(xbgr.mr_n76815792)
print v(xbgr.mr_n76815968)
print v(xbgr.mr_n76817312)
print v(xbgr.mr_n76817664)
print v(xbgr.mr_n76818096)
print v(xbgr.mr_n76818800)
print v(xbgr.mr_n76819728)
print v(xbgr.mr_n76819984)
print v(xbgr.mr_n76822208)
print v(xbgr.mr_n76822720)
print v(xbgr.mr_n76822880)
print v(xbgr.mr_n76823216)
print v(xbgr.mr_n76823552)
print v(xbgr.mr_n76824192)
print v(xbgr.mr_n76824304)
print v(xbgr.mr_n76824976)
print v(xbgr.mr_n76825328)
print v(xbgr.mr_n76825952)
print v(xbgr.mr_n76827312)
print v(xbgr.mr_n76828576)
print v(xbgr.mr_n76828880)
print v(xbgr.mr_n76828992)
print v(xbgr.mr_n76829920)
print v(xbgr.mr_n76830736)
print v(xbgr.mr_n76831408)
print v(xbgr.mr_n76831872)
print v(xbgr.mr_n76832960)
print v(xbgr.mr_n76833728)
print v(xbgr.mr_n76833904)
print v(xbgr.mr_n76834016)
print v(xbgr.mr_n76834880)
print v(xbgr.mr_n76835408)
print v(xbgr.mr_n76835792)
print v(xbgr.mr_n76837328)
print v(xbgr.mr_n76838816)
print v(xbgr.mr_n76839776)
print v(xbgr.mr_n76839888)
print v(xbgr.mr_n76840432)
print v(xbgr.mr_n76841328)
print v(xbgr.mr_n76843024)
print v(xbgr.mr_n76843344)
print v(xbgr.mr_n76843728)
print v(xbgr.mr_n76844000)
print v(xbgr.mr_n76844272)
print v(xbgr.mr_n76844448)
print v(xbgr.mr_n76845408)
print v(xbgr.mr_n76845520)
print v(xbgr.mr_n76846336)
print v(xbgr.mr_n76847536)
print v(xbgr.mr_n76847872)
print v(xbgr.mr_n76848496)
print v(xbgr.mr_n76848832)
print v(xbgr.mr_n76849168)
print v(xbgr.mr_n76849360)
print v(xbgr.mr_n76851200)
print v(xbgr.mr_n76852032)
print v(xbgr.mr_n76852144)
print v(xbgr.mr_n76853184)
print v(xbgr.mr_n76853648)
print v(xbgr.mr_n76854128)
print v(xbgr.mr_n76854272)
print v(xbgr.mr_n76855120)
print v(xbgr.mr_n76855264)
print v(xbgr.mr_n76855648)
print v(xbgr.mr_n76856032)
print v(xbgr.mr_n76856896)
print v(xbgr.mr_n76857088)
print v(xbgr.mr_n76857712)
print v(xbgr.mr_n76857904)
print v(xbgr.mr_n76858096)
print v(xbgr.mr_n76858992)
print v(xbgr.mr_n76859584)
print v(xbgr.mr_n76859968)
print v(xbgr.mr_n76860240)
print v(xbgr.mr_n76860512)
print v(xbgr.mr_n76860784)
print v(xbgr.mr_n76861056)
print v(xbgr.mr_n76861328)
print v(xbgr.mr_n76861600)
print v(xbgr.mr_n76861872)
print v(xbgr.mr_n76862144)
print v(xbgr.mr_n76862416)
print v(xbgr.mr_n76862688)
print v(xbgr.mr_n76862960)
print v(xbgr.mr_n76863232)
print v(xbgr.mr_n76863504)
print v(xbgr.mr_n76863840)
print v(xbgr.mr_n76864304)
print v(xbgr.mr_n76864768)
print v(xbgr.mr_n76869488)
print v(xbgr.mr_n76881360)
print v(xbgr.mr_n76882448)
print v(xbgr.mr_n76887248)
print v(xbgr.mr_n76902736)
print v(xbgr.mr_n76903024)
print v(xbgr.mr_n76910096)
print v(xbgr.mr_n76910432)
print v(xbgr.mr_n76910768)
print v(xbgr.mr_n76911104)
print v(xbgr.mr_n76911440)
print v(xbgr.mr_n76911696)
print v(xbgr.mr_n76911808)
print v(xbgr.mr_n76911920)
print v(xbgr.mr_n76912032)
print v(xbgr.mr_n76912144)
print v(xbgr.mr_n76912256)
print v(xbgr.mr_n76912368)
print v(xbgr.mr_n76912480)
print v(xbgr.mr_n76912752)
print v(xbgr.mr_n76913104)
print v(xbgr.mr_n76913216)
print v(xbgr.mr_n76913568)
print v(xbgr.mr_n76913888)
print v(xbgr.mr_n76914160)
print v(xbgr.mr_n76914560)
print v(xbgr.mr_n76914752)
print v(xbgr.mr_n76915344)
print v(xbgr.mr_n76915456)
print v(xbgr.mr_n76916960)
print v(xbgr.mr_n76917904)
print v(xbgr.mr_n76918016)
print v(xbgr.mr_n76918128)
print v(xbgr.mr_n76918960)
print v(xbgr.mr_n76919888)
print v(xbgr.mr_n76920272)
print v(xbgr.mr_n76920384)
print v(xbgr.mr_n76920816)
print v(xbgr.mr_n76921008)
print v(xbgr.mr_n76921648)
print v(xbgr.mr_n76923616)
print v(xbgr.mr_n76924208)
print v(xbgr.mr_n76924320)
print v(xbgr.mr_n76924928)
print v(xbgr.mr_n76925120)
print v(xbgr.mr_n76925312)
print v(xbgr.mr_n76925504)
print v(xbgr.mr_n76926400)
print v(xbgr.mr_n76926736)
print v(xbgr.mr_n76927632)
print v(xbgr.mr_n76928464)
print v(xbgr.mr_n76928784)
print v(xbgr.mr_n76929136)
print v(xbgr.mr_n76929568)
print v(xbgr.mr_n76929872)
print v(xbgr.mr_n76930496)
print v(xbgr.mr_n76930848)
print v(xbgr.mr_n76931216)
print v(xbgr.mr_n76931632)
print v(xbgr.mr_n76932064)
print v(xbgr.mr_n76932528)
print v(xbgr.mr_n76932880)
print v(xbgr.mr_n76933312)
print v(xbgr.mr_n76933616)
print v(xbgr.mr_n76934240)
print v(xbgr.mr_n76934592)
print v(xbgr.mr_n76935024)
print v(xbgr.mr_n76935376)
print v(xbgr.mr_n76935808)
print v(xbgr.mr_n76936272)
print v(xbgr.mr_n76936624)
print v(xbgr.mr_n76937056)
print v(xbgr.mr_n76937360)
print v(xbgr.mr_n76937984)
print v(xbgr.mr_n76938336)
print v(xbgr.mr_n76938768)
print v(xbgr.mr_n76939120)
print v(xbgr.mr_n76939552)
print v(xbgr.mr_n76939952)
print v(xbgr.mr_n76940368)
print v(xbgr.mr_n76940800)
print v(xbgr.mr_n76941104)
print v(xbgr.mr_n76941728)
print v(xbgr.mr_n76942080)
print v(xbgr.mr_n76942192)
print v(xbgr.mr_n76942384)
print v(xbgr.mr_n76942656)
print v(xbgr.mr_n76942928)
print v(xbgr.mr_n76943200)
print v(xbgr.mr_n76943472)
print v(xbgr.mr_n76943744)
print v(xbgr.mr_n76944016)
print v(xbgr.mr_n76944288)
print v(xbgr.mr_n76944560)
print v(xbgr.mr_n76944832)
print v(xbgr.mr_n76945104)
print v(xbgr.mr_n76945376)
print v(xbgr.mr_n76945648)
print v(xbgr.mr_n76945920)
print v(xbgr.mr_n76946192)
print v(xbgr.mr_n76946656)
print v(xbgr.mr_n76949184)
print v(xbgr.mr_n76967168)
print v(xbgr.mr_n76967424)
print v(xbgr.mr_n76968176)
print v(xbgr.mr_n76968368)
print v(xbgr.mr_n76968560)
print v(xbgr.mr_n76968816)
print v(xbgr.mr_n76969072)
print v(xbgr.mr_n76971040)
print v(xbgr.mr_n76972128)
print v(xbgr.mr_n76973616)
print v(xbgr.mr_n76977744)
print v(xbgr.mr_n76978224)
print v(xbgr.mr_n76978880)
print v(xbgr.mr_n76979520)
print v(xbgr.mr_n76981888)
print v(xbgr.mr_n76982544)
print v(xbgr.mr_n76983056)
print v(xbgr.mr_n76984352)
print v(xbgr.mr_n76984864)
print v(xbgr.mr_n76986080)
print v(xbgr.mr_n76986672)
print v(xbgr.mr_n76987968)
print v(xbgr.mr_n76988480)
print v(xbgr.mr_n76989776)
print v(xbgr.mr_n76990288)
print v(xbgr.mr_n76991584)
print v(xbgr.mr_n76992096)
print v(xbgr.mr_n76993392)
print v(xbgr.mr_n76993904)
print v(xbgr.mr_n76995200)
print v(xbgr.mr_n76995712)
print v(xbgr.mr_n76996928)
print v(xbgr.mr_n76997520)
print v(xbgr.mr_n76997632)
print v(xbgr.mr_n76997744)
print v(xbgr.mr_n76997856)
print v(xbgr.mr_n76997968)
print v(xbgr.mr_n76998160)
print v(xbgr.mr_n76998592)
print v(xbgr.mr_n76998704)
print v(xbgr.mr_n76998976)
print v(xbgr.mr_n76999328)
print v(xbgr.mr_n76999568)
print v(xbgr.mr_n76999968)
print v(xbgr.mr_n77000320)
print v(xbgr.mr_n77000752)
print v(xbgr.mr_n77001440)
print v(xbgr.mr_n77002064)
print v(xbgr.mr_n77002608)
print v(xbgr.mr_n77003040)
print v(xbgr.mr_n77003456)
print v(xbgr.mr_n77003712)
print v(xbgr.mr_n77004144)
print v(xbgr.mr_n77004608)
print v(xbgr.mr_n77005024)
print v(xbgr.mr_n77005456)
print v(xbgr.mr_n77006144)
print v(xbgr.mr_n77006832)
print v(xbgr.mr_n77007312)
print v(xbgr.mr_n77007808)
print v(xbgr.mr_n77008160)
print v(xbgr.mr_n77008848)
print v(xbgr.mr_n77009376)
print v(xbgr.mr_n77009728)
print v(xbgr.mr_n77010848)
print v(xbgr.mr_n77011536)
print v(xbgr.mr_n77012016)
print v(xbgr.mr_n77012640)
print v(xbgr.mr_n77012832)
print v(xbgr.mr_n77013520)
print v(xbgr.mr_n77014048)
print v(xbgr.mr_n77014400)
print v(xbgr.mr_n77014832)
print v(xbgr.mr_n77015520)
print v(xbgr.mr_n77016144)
print v(xbgr.mr_n77016688)
print v(xbgr.mr_n77017120)
print v(xbgr.mr_n77017536)
print v(xbgr.mr_n77018224)
print v(xbgr.mr_n77018752)
print v(xbgr.mr_n77019104)
print v(xbgr.mr_n77019536)
print v(xbgr.mr_n77020224)
print v(xbgr.mr_n77020848)
print v(xbgr.mr_n77021392)
print v(xbgr.mr_n77021824)
print v(xbgr.mr_n77022240)
print v(xbgr.mr_n77022928)
print v(xbgr.mr_n77023392)
print v(xbgr.mr_n77023808)
print v(xbgr.mr_n77024240)
print v(xbgr.mr_n77024432)
print v(xbgr.mr_n77024704)
print v(xbgr.mr_n77024976)
print v(xbgr.mr_n77025248)
print v(xbgr.mr_n77025520)
print v(xbgr.mr_n77025792)
print v(xbgr.mr_n77026064)
print v(xbgr.mr_n77026336)
print v(xbgr.mr_n77026608)
print v(xbgr.mr_n77026880)
print v(xbgr.mr_n77027152)
print v(xbgr.mr_n77027424)
print v(xbgr.mr_n77027696)
print v(xbgr.mr_n77030304)
print v(xbgr.mr_n77032512)
print v(xbgr.mr_n77033056)
print v(xbgr.mr_n77034208)
print v(xbgr.mr_n77034352)
print v(xbgr.mr_n77037536)
print v(xbgr.mr_n77045728)
print v(xbgr.mr_n77046048)
print v(xbgr.mr_n77049312)
print v(xbgr.mr_n77051808)
print v(xbgr.mr_n77052416)
print v(xbgr.mr_n77052880)
print v(xbgr.mr_n77053344)
print v(xbgr.mr_n77053808)
print v(xbgr.mr_n77054272)
print v(xbgr.mr_n77060464)
print v(xbgr.mr_n77064960)
print v(xbgr.mr_n77068336)
print v(xbgr.mr_n77082912)
print v(xbgr.mr_n77083168)
print v(xbgr.mr_n77083424)
print v(xbgr.mr_n77083680)
print v(xbgr.mr_n77085648)
print v(xbgr.mr_n77085760)
print v(xbgr.mr_n77086416)
print v(xbgr.mr_n77091248)
print v(xbgr.mr_n77096432)
print v(xbgr.mr_n77097712)
print v(xbgr.mr_n77098352)
print v(xbgr.mr_n77099648)
print v(xbgr.mr_n77100160)
print v(xbgr.mr_n77101456)
print v(xbgr.mr_n77101968)
print v(xbgr.mr_n77103264)
print v(xbgr.mr_n77103776)
print v(xbgr.mr_n77104672)
print v(xbgr.mr_n77105248)
print v(xbgr.mr_n77105840)
print v(xbgr.mr_n77106736)
print v(xbgr.mr_n77107152)
print v(xbgr.mr_n77107904)
print v(xbgr.mr_n77108800)
print v(xbgr.mr_n77109456)
print v(xbgr.mr_n77109968)
print v(xbgr.mr_n77110864)
print v(xbgr.mr_n77111280)
print v(xbgr.mr_n77112032)
print v(xbgr.mr_n77112928)
print v(xbgr.mr_n77113504)
print v(xbgr.mr_n77114096)
print v(xbgr.mr_n77114992)
print v(xbgr.mr_n77115648)
print v(xbgr.mr_n77116160)
print v(xbgr.mr_n77117056)
print v(xbgr.mr_n77117712)
print v(xbgr.mr_n77118224)
print v(xbgr.mr_n77119120)
print v(xbgr.mr_n77119616)
print v(xbgr.mr_n77120288)
print v(xbgr.mr_n77121184)
print v(xbgr.mr_n77121840)
print v(xbgr.mr_n77122352)
print v(xbgr.mr_n77123248)
print v(xbgr.mr_n77123904)
print v(xbgr.mr_n77124416)
print v(xbgr.mr_n77125312)
print v(xbgr.mr_n77125968)
print v(xbgr.mr_n77126480)
print v(xbgr.mr_n77127376)
print v(xbgr.mr_n77127952)
print v(xbgr.mr_n77128544)
print v(xbgr.mr_n77129840)
print v(xbgr.mr_n77130352)
print v(xbgr.mr_n77130464)
print v(xbgr.mr_n77130576)
print v(xbgr.mr_n77130688)
print v(xbgr.mr_n77130960)
print v(xbgr.mr_n77131072)
print v(xbgr.mr_n77131424)
print v(xbgr.mr_n77131536)
print v(xbgr.mr_n77131648)
print v(xbgr.mr_n77132080)
print v(xbgr.mr_n77132560)
print v(xbgr.mr_n77132736)
print v(xbgr.mr_n77133088)
print v(xbgr.mr_n77133456)
print v(xbgr.mr_n77133792)
print v(xbgr.mr_n77134144)
print v(xbgr.mr_n77134256)
print v(xbgr.mr_n77134752)
print v(xbgr.mr_n77135248)
print v(xbgr.mr_n77135728)
print v(xbgr.mr_n77135904)
print v(xbgr.mr_n77136256)
print v(xbgr.mr_n77136624)
print v(xbgr.mr_n77136960)
print v(xbgr.mr_n77137312)
print v(xbgr.mr_n77137424)
print v(xbgr.mr_n77137920)
print v(xbgr.mr_n77138416)
print v(xbgr.mr_n77138896)
print v(xbgr.mr_n77139072)
print v(xbgr.mr_n77139424)
print v(xbgr.mr_n77139856)
print v(xbgr.mr_n77140320)
print v(xbgr.mr_n77140736)
print v(xbgr.mr_n77141168)
print v(xbgr.mr_n77141856)
print v(xbgr.mr_n77142480)
print v(xbgr.mr_n77143024)
print v(xbgr.mr_n77143456)
print v(xbgr.mr_n77143872)
print v(xbgr.mr_n77144560)
print v(xbgr.mr_n77145088)
print v(xbgr.mr_n77145440)
print v(xbgr.mr_n77145872)
print v(xbgr.mr_n77146560)
print v(xbgr.mr_n77147184)
print v(xbgr.mr_n77147600)
print v(xbgr.mr_n77147712)
print v(xbgr.mr_n77147904)
print v(xbgr.mr_n77148176)
print v(xbgr.mr_n77148448)
print v(xbgr.mr_n77148720)
print v(xbgr.mr_n77148992)
print v(xbgr.mr_n77149264)
print v(xbgr.mr_n77149536)
print v(xbgr.mr_n77149808)
print v(xbgr.mr_n77150080)
print v(xbgr.mr_n77150352)
print v(xbgr.mr_n77150624)
print v(xbgr.mr_n77150896)
print v(xbgr.mr_n77151168)
print v(xbgr.mr_n77151440)
print v(xbgr.mr_n77151712)
print v(xbgr.mr_n77151984)
print v(xbgr.mr_n77153632)
print v(xbgr.mr_n77163488)
print v(xbgr.mr_n77167136)
print v(xbgr.mr_n77169328)
print v(xbgr.mr_n77169856)
print v(xbgr.mr_n77170320)
print v(xbgr.mr_n77170784)
print v(xbgr.mr_n77171248)
print v(xbgr.mr_n77171712)
print v(xbgr.mr_n77172176)
print v(xbgr.mr_n77172640)
print v(xbgr.mr_n77173168)
print v(xbgr.mr_n77173760)
print v(xbgr.mr_n77174352)
print v(xbgr.mr_n77174944)
print v(xbgr.mr_n77175536)
print v(xbgr.mr_n77176128)
print v(xbgr.mr_n77176720)
print v(xbgr.mr_n77177312)
print v(xbgr.mr_n77177904)
print v(xbgr.mr_n77178496)
print v(xbgr.mr_n77180608)
print v(xbgr.mr_n77190144)
print v(xbgr.mr_n77201328)
print v(xbgr.mr_n77201472)
print v(xbgr.mr_n77204976)
print v(xbgr.mr_n77207456)
print v(xbgr.mr_n77207648)
print v(xbgr.mr_n77207904)
print v(xbgr.mr_n77208160)
print v(xbgr.mr_n77210320)
print v(xbgr.mr_n77217552)
print v(xbgr.mr_n77217776)
print v(xbgr.mr_n77218208)
print v(xbgr.mr_n77218960)
print v(xbgr.mr_n77220880)
print v(xbgr.mr_n77221392)
print v(xbgr.mr_n77223456)
print v(xbgr.mr_n77223968)
print v(xbgr.mr_n77225184)
print v(xbgr.mr_n77225776)
print v(xbgr.mr_n77227072)
print v(xbgr.mr_n77227584)
print v(xbgr.mr_n77228880)
print v(xbgr.mr_n77229392)
print v(xbgr.mr_n77230608)
print v(xbgr.mr_n77231200)
print v(xbgr.mr_n77232496)
print v(xbgr.mr_n77233008)
print v(xbgr.mr_n77234304)
print v(xbgr.mr_n77234816)
print v(xbgr.mr_n77236032)
print v(xbgr.mr_n77236624)
print v(xbgr.mr_n77237840)
print v(xbgr.mr_n77238432)
print v(xbgr.mr_n77239648)
print v(xbgr.mr_n77240240)
print v(xbgr.mr_n77241536)
print v(xbgr.mr_n77242048)
print v(xbgr.mr_n77243344)
print v(xbgr.mr_n77243856)
print v(xbgr.mr_n77245072)
print v(xbgr.mr_n77245664)
print v(xbgr.mr_n77246880)
print v(xbgr.mr_n77247472)
print v(xbgr.mr_n77247584)
print v(xbgr.mr_n77247696)
print v(xbgr.mr_n77247808)
print v(xbgr.mr_n77248080)
print v(xbgr.mr_n77248192)
print v(xbgr.mr_n77248544)
print v(xbgr.mr_n77248656)
print v(xbgr.mr_n77248928)
print v(xbgr.mr_n77249280)
print v(xbgr.mr_n77249392)
print v(xbgr.mr_n77249760)
print v(xbgr.mr_n77250256)
print v(xbgr.mr_n77250736)
print v(xbgr.mr_n77250912)
print v(xbgr.mr_n77251328)
print v(xbgr.mr_n77252016)
print v(xbgr.mr_n77252544)
print v(xbgr.mr_n77252896)
print v(xbgr.mr_n77253328)
print v(xbgr.mr_n77253440)
print v(xbgr.mr_n77254016)
print v(xbgr.mr_n77254640)
print v(xbgr.mr_n77255184)
print v(xbgr.mr_n77255680)
print v(xbgr.mr_n77256032)
print v(xbgr.mr_n77256720)
print v(xbgr.mr_n77257184)
print v(xbgr.mr_n77257600)
print v(xbgr.mr_n77258032)
print v(xbgr.mr_n77258720)
print v(xbgr.mr_n77259408)
print v(xbgr.mr_n77259888)
print v(xbgr.mr_n77260384)
print v(xbgr.mr_n77260736)
print v(xbgr.mr_n77261424)
print v(xbgr.mr_n77261952)
print v(xbgr.mr_n77262304)
print v(xbgr.mr_n77262736)
print v(xbgr.mr_n77263424)
print v(xbgr.mr_n77264048)
print v(xbgr.mr_n77264592)
print v(xbgr.mr_n77265088)
print v(xbgr.mr_n77265440)
print v(xbgr.mr_n77266128)
print v(xbgr.mr_n77266656)
print v(xbgr.mr_n77267008)
print v(xbgr.mr_n77267440)
print v(xbgr.mr_n77268128)
print v(xbgr.mr_n77268816)
print v(xbgr.mr_n77269296)
print v(xbgr.mr_n77269792)
print v(xbgr.mr_n77270144)
print v(xbgr.mr_n77270832)
print v(xbgr.mr_n77271296)
print v(xbgr.mr_n77271712)
print v(xbgr.mr_n77272144)
print v(xbgr.mr_n77272832)
print v(xbgr.mr_n77273520)
print v(xbgr.mr_n77273872)
print v(xbgr.mr_n77273984)
print v(xbgr.mr_n77274176)
print v(xbgr.mr_n77274448)
print v(xbgr.mr_n77274720)
print v(xbgr.mr_n77274992)
print v(xbgr.mr_n77275264)
print v(xbgr.mr_n77275536)
print v(xbgr.mr_n77275808)
print v(xbgr.mr_n77276080)
print v(xbgr.mr_n77276352)
print v(xbgr.mr_n77276624)
print v(xbgr.mr_n77276896)
print v(xbgr.mr_n77277168)
print v(xbgr.mr_n77277440)
print v(xbgr.mr_n77277712)
print v(xbgr.mr_n77277984)
print v(xbgr.mr_n77278256)
print v(xbgr.mr_n77287536)
print v(xbgr.mr_n77288352)
print v(xbgr.mr_n77293408)
print v(xbgr.mr_n77302016)
print v(xbgr.mr_n77302480)
print v(xbgr.mr_n77302944)
print v(xbgr.mr_n77303408)
print v(xbgr.mr_n77303872)
print v(xbgr.mr_n77304336)
print v(xbgr.mr_n77304800)
print v(xbgr.mr_n77305328)
print v(xbgr.mr_n77305920)
print v(xbgr.mr_n77306512)
print v(xbgr.mr_n77307104)
print v(xbgr.mr_n77307696)
print v(xbgr.mr_n77308288)
print v(xbgr.mr_n77308880)
print v(xbgr.mr_n77309472)
print v(xbgr.mr_n77310064)
print v(xbgr.mr_n77310656)
print v(xbgr.mr_n77316160)
print v(xbgr.mr_n77317248)
print v(xbgr.mr_n77328496)
print v(xbgr.mr_n77328672)
print v(xbgr.mr_n77329008)
print v(xbgr.mr_n77330784)
print v(xbgr.mr_n77331376)
print v(xbgr.mr_n77331968)
print v(xbgr.mr_n77332560)
print v(xbgr.mr_n77333152)
print v(xbgr.mr_n77333744)
print v(xbgr.mr_n77334336)
print v(xbgr.mr_n77334928)
print v(xbgr.mr_n77335520)
print v(xbgr.mr_n77336112)
print v(xbgr.mr_n77336704)
print v(xbgr.mr_n77337296)
print v(xbgr.mr_n77337888)
print v(xbgr.mr_n77338480)
print v(xbgr.mr_n77339072)
print v(xbgr.mr_n77339664)
print v(xbgr.mr_n77340256)
print v(xbgr.mr_n77340848)
print v(xbgr.mr_n77341440)
print v(xbgr.mr_n77348688)
print v(xbgr.mr_n77349936)
print v(xbgr.mr_n77350352)
print v(xbgr.mr_n77350896)
print v(xbgr.mr_n77351328)
print v(xbgr.mr_n77351824)
print v(xbgr.mr_n77352560)
print v(xbgr.mr_n77353008)
print v(xbgr.mr_n77353312)
print v(xbgr.mr_n77353424)
print v(xbgr.mr_n77354128)
print v(xbgr.mr_n77356912)
print v(xbgr.mr_n77357648)
print v(xbgr.mr_n77358000)
print v(xbgr.mr_n77358112)
print v(xbgr.mr_n77358816)
print v(xbgr.mr_n77361056)
print v(xbgr.mr_n77361408)
print v(xbgr.mr_n77361520)
print v(xbgr.mr_n77362224)
print v(xbgr.mr_n77364400)
print v(xbgr.mr_n77364816)
print v(xbgr.mr_n77364928)
print v(xbgr.mr_n77365632)
print v(xbgr.mr_n77367808)
print v(xbgr.mr_n77368224)
print v(xbgr.mr_n77368336)
print v(xbgr.mr_n77369040)
print v(xbgr.mr_n77371280)
print v(xbgr.mr_n77371632)
print v(xbgr.mr_n77371744)
print v(xbgr.mr_n77372448)
print v(xbgr.mr_n77374624)
print v(xbgr.mr_n77375040)
print v(xbgr.mr_n77375152)
print v(xbgr.mr_n77375856)
print v(xbgr.mr_n77376608)
print v(xbgr.mr_n77378096)
print v(xbgr.mr_n77378448)
print v(xbgr.mr_n77378560)
print v(xbgr.mr_n77379264)
print v(xbgr.mr_n77393216)
print v(xbgr.mr_n77393392)
print v(xbgr.mr_n77394016)
print v(xbgr.mr_n77394192)
print v(xbgr.mr_n77394816)
print v(xbgr.mr_n77394992)
print v(xbgr.mr_n77395616)
print v(xbgr.mr_n77395792)
print v(xbgr.mr_n77396416)
print v(xbgr.mr_n77396592)
print v(xbgr.mr_n77397216)
print v(xbgr.mr_n77397392)
print v(xbgr.mr_n77398016)
print v(xbgr.mr_n77398192)
print v(xbgr.mr_n77398816)
print v(xbgr.mr_n77398992)
print v(xbgr.mr_n77399616)
print v(xbgr.mr_n77399792)
print v(xbgr.mr_n77400416)
print v(xbgr.mr_n77400592)
print v(xbgr.mr_n77401216)
print v(xbgr.mr_n77401392)
print v(xbgr.mr_n77402016)
print v(xbgr.mr_n77402192)
print v(xbgr.mr_n77402816)
print v(xbgr.mr_n77402992)
print v(xbgr.mr_n77403616)
print v(xbgr.mr_n77403792)
print v(xbgr.mr_n77404416)
print v(xbgr.mr_n77404592)
print v(xbgr.mr_n77405216)
print v(xbgr.mr_n77405392)
print v(xbgr.mr_n77405824)
print v(xbgr.mr_n77405936)
print v(xbgr.mr_n77406048)
print v(xbgr.mr_n77406160)
print v(xbgr.mr_n77406352)
print v(xbgr.mr_n77406624)
print v(xbgr.mr_n77406896)
print v(xbgr.mr_n77407168)
print v(xbgr.mr_n77407440)
print v(xbgr.mr_n77407712)
print v(xbgr.mr_n77407984)
print v(xbgr.mr_n77408256)
print v(xbgr.mr_n77408528)
print v(xbgr.mr_n77408800)
print v(xbgr.mr_n77409072)
print v(xbgr.mr_n77409344)
print v(xbgr.mr_n77409616)
print v(xbgr.mr_n77424832)
print v(xbgr.mr_n77425680)
print v(xbgr.mr_n77427456)
print v(xbgr.mr_n77431760)
print v(xbgr.mr_n77441664)
print v(xbgr.mr_n77447104)
print v(xbgr.mr_n77447280)
print v(xbgr.mr_n77447616)
print v(xbgr.mr_n77449456)
print v(xbgr.mr_n77449632)
print v(xbgr.mr_n77450576)
print v(xbgr.mr_n77451232)
print v(xbgr.mr_n77451408)
print v(xbgr.mr_n77452352)
print v(xbgr.mr_n77453008)
print v(xbgr.mr_n77453184)
print v(xbgr.mr_n77454128)
print v(xbgr.mr_n77454784)
print v(xbgr.mr_n77454960)
print v(xbgr.mr_n77455904)
print v(xbgr.mr_n77456560)
print v(xbgr.mr_n77456736)
print v(xbgr.mr_n77457680)
print v(xbgr.mr_n77458336)
print v(xbgr.mr_n77458512)
print v(xbgr.mr_n77459456)
print v(xbgr.mr_n77460112)
print v(xbgr.mr_n77460288)
print v(xbgr.mr_n77461232)
print v(xbgr.mr_n77461888)
print v(xbgr.mr_n77462064)
print v(xbgr.mr_n77463008)
print v(xbgr.mr_n77463664)
print v(xbgr.mr_n77463840)
print v(xbgr.mr_n77464784)
print v(xbgr.mr_n77465440)
print v(xbgr.mr_n77465616)
print v(xbgr.mr_n77466656)
print v(xbgr.mr_n77466928)
print v(xbgr.mr_n77467200)
print v(xbgr.mr_n77467536)
print v(xbgr.mr_n77468000)
print v(xbgr.mr_n77468352)
print v(xbgr.mr_n77468544)
print v(xbgr.mr_n77468736)
print v(xbgr.mr_n77468928)
print v(xbgr.mr_n77469680)
print v(xbgr.mr_n77473328)
print v(xbgr.mr_n77473680)
print v(xbgr.mr_n77473792)
print v(xbgr.mr_n77474496)
print v(xbgr.mr_n77476672)
print v(xbgr.mr_n77477088)
print v(xbgr.mr_n77477200)
print v(xbgr.mr_n77477904)
print v(xbgr.mr_n77480080)
print v(xbgr.mr_n77480496)
print v(xbgr.mr_n77480608)
print v(xbgr.mr_n77481312)
print v(xbgr.mr_n77482384)
print v(xbgr.mr_n77483488)
print v(xbgr.mr_n77483904)
print v(xbgr.mr_n77484016)
print v(xbgr.mr_n77484720)
print v(xbgr.mr_n77485408)
print v(xbgr.mr_n77486896)
print v(xbgr.mr_n77487312)
print v(xbgr.mr_n77487424)
print v(xbgr.mr_n77488064)
print v(xbgr.mr_n77488176)
print v(xbgr.mr_n77488784)
print v(xbgr.mr_n77489136)
print v(xbgr.mr_n77489888)
print v(xbgr.mr_n77490240)
print v(xbgr.mr_n77490352)
print v(xbgr.mr_n77491056)
print v(xbgr.mr_n77494512)
print v(xbgr.mr_n77494864)
print v(xbgr.mr_n77494976)
print v(xbgr.mr_n77495680)
print v(xbgr.mr_n77496752)
print v(xbgr.mr_n77497920)
print v(xbgr.mr_n77498272)
print v(xbgr.mr_n77498384)
print v(xbgr.mr_n77499088)
print v(xbgr.mr_n77501264)
print v(xbgr.mr_n77501680)
print v(xbgr.mr_n77501792)
print v(xbgr.mr_n77502496)
print v(xbgr.mr_n77514928)
print v(xbgr.mr_n77515104)
print v(xbgr.mr_n77515728)
print v(xbgr.mr_n77515904)
print v(xbgr.mr_n77516528)
print v(xbgr.mr_n77516704)
print v(xbgr.mr_n77517328)
print v(xbgr.mr_n77517504)
print v(xbgr.mr_n77518128)
print v(xbgr.mr_n77518304)
print v(xbgr.mr_n77518928)
print v(xbgr.mr_n77519104)
print v(xbgr.mr_n77519728)
print v(xbgr.mr_n77519904)
print v(xbgr.mr_n77520528)
print v(xbgr.mr_n77520704)
print v(xbgr.mr_n77521328)
print v(xbgr.mr_n77521504)
print v(xbgr.mr_n77522128)
print v(xbgr.mr_n77522304)
print v(xbgr.mr_n77522928)
print v(xbgr.mr_n77523104)
print v(xbgr.mr_n77523728)
print v(xbgr.mr_n77523904)
print v(xbgr.mr_n77524528)
print v(xbgr.mr_n77524704)
print v(xbgr.mr_n77525328)
print v(xbgr.mr_n77525504)
print v(xbgr.mr_n77526128)
print v(xbgr.mr_n77526304)
print v(xbgr.mr_n77526928)
print v(xbgr.mr_n77527104)
print v(xbgr.mr_n77530416)
print v(xbgr.mr_n77531584)
print v(xbgr.mr_n77536192)
print v(xbgr.mr_n77538736)
print v(xbgr.mr_n77539040)
print v(xbgr.mr_n77539344)
print v(xbgr.mr_n77539648)
print v(xbgr.mr_n77540032)
print v(xbgr.mr_n77540496)
print v(xbgr.mr_n77540960)
print v(xbgr.mr_n77541424)
print v(xbgr.mr_n77541888)
print v(xbgr.mr_n77542352)
print v(xbgr.mr_n77542816)
print v(xbgr.mr_n77543280)
print v(xbgr.mr_n77543744)
print v(xbgr.mr_n77544208)
print v(xbgr.mr_n77544672)
print v(xbgr.mr_n77545136)
print v(xbgr.mr_n77545600)
print v(xbgr.mr_n77546064)
print v(xbgr.mr_n77546528)
print v(xbgr.mr_n77546992)
print v(xbgr.mr_n77547456)
print v(xbgr.mr_n77547920)
print v(xbgr.mr_n77548384)
print v(xbgr.mr_n77548848)
print v(xbgr.mr_n77549312)
print v(xbgr.mr_n77549776)
print v(xbgr.mr_n77550240)
print v(xbgr.mr_n77550704)
print v(xbgr.mr_n77551168)
print v(xbgr.mr_n77551632)
print v(xbgr.mr_n77565184)
print v(xbgr.mr_n77575616)
print v(xbgr.mr_n77576224)
print v(xbgr.mr_n77576688)
print v(xbgr.mr_n77577152)
print v(xbgr.mr_n77577680)
print v(xbgr.mr_n77578272)
print v(xbgr.mr_n77578864)
print v(xbgr.mr_n77579456)
print v(xbgr.mr_n77580048)
print v(xbgr.mr_n77580640)
print v(xbgr.mr_n77581232)
print v(xbgr.mr_n77581824)
print v(xbgr.mr_n77582416)
print v(xbgr.mr_n77583008)
print v(xbgr.mr_n77583600)
print v(xbgr.mr_n77584192)
print v(xbgr.mr_n77584784)
print v(xbgr.mr_n77585376)
print v(xbgr.mr_n77586528)
print v(xbgr.mr_n77588304)
print v(xbgr.mr_n77594144)
print v(xbgr.mr_n77595664)
print v(xbgr.mr_n77602400)
print v(xbgr.mr_n77607184)
print v(xbgr.mr_n77608288)
print v(xbgr.mr_n77608480)
print v(xbgr.mr_n77608736)
print v(xbgr.mr_n77608992)
print v(xbgr.mr_n77611152)
print v(xbgr.mr_n77632576)
print v(xbgr.mr_n77633376)
print v(xbgr.mr_n77639488)
print v(xbgr.mr_n77641648)
print v(xbgr.mr_n77643104)
print v(xbgr.mr_n77644608)
print v(xbgr.mr_n77650880)
print v(xbgr.mr_n77651216)
print v(xbgr.mr_n77651456)
print v(xbgr.mr_n77664848)
print v(xbgr.mr_n77667440)
print v(xbgr.mr_n77670880)
print v(xbgr.mr_n77672208)
print v(xbgr.mr_n77674064)
print v(xbgr.mr_n77675392)
print v(xbgr.mr_n77677008)
print v(xbgr.mr_n77677600)
print v(xbgr.mr_n77678192)
print v(xbgr.mr_n77678784)
print v(xbgr.mr_n77679376)
print v(xbgr.mr_n77679968)
print v(xbgr.mr_n77680560)
print v(xbgr.mr_n77681152)
print v(xbgr.mr_n77681744)
print v(xbgr.mr_n77682336)
print v(xbgr.mr_n77682928)
print v(xbgr.mr_n77683520)
print v(xbgr.mr_n77684048)
print v(xbgr.mr_n77684672)
print v(xbgr.mr_n77685008)
print v(xbgr.mr_n77685152)
print v(xbgr.mr_n77685584)
print v(xbgr.mr_n77686800)
print v(xbgr.mr_n77687264)
print v(xbgr.mr_n77687712)
print v(xbgr.mr_n77690992)
print v(xbgr.mr_n77691168)
print v(xbgr.mr_n77691344)
print v(xbgr.mr_n77693136)
print v(xbgr.mr_n77693664)
print v(xbgr.mr_n77697600)
print v(xbgr.mr_n77697936)
print v(xbgr.mr_n77698272)
print v(xbgr.mr_n77699312)
print v(xbgr.mr_n77699712)
print v(xbgr.mr_n77700752)
print v(xbgr.mr_n77700928)
print v(xbgr.mr_n77701440)
print v(xbgr.mr_n77701936)
print v(xbgr.mr_n77702112)
print v(xbgr.mr_n77702528)
print v(xbgr.mr_n77703040)
print v(xbgr.mr_n77703536)
print v(xbgr.mr_n77703872)
print v(xbgr.mr_n77704384)
print v(xbgr.mr_n77704496)
print v(xbgr.mr_n77704608)
print v(xbgr.mr_n77705600)
print v(xbgr.mr_n77706016)
print v(xbgr.mr_n77706528)
print v(xbgr.mr_n77707024)
print v(xbgr.mr_n77707200)
print v(xbgr.mr_n77707536)
print v(xbgr.mr_n77708128)
print v(xbgr.mr_n77708688)
print v(xbgr.mr_n77708864)
print v(xbgr.mr_n77709360)
print v(xbgr.mr_n77710128)
print v(xbgr.mr_n77710304)
print v(xbgr.mr_n77710480)
print v(xbgr.mr_n77711072)
print v(xbgr.mr_n77711184)
print v(xbgr.mr_n77711296)
print v(xbgr.mr_n77711408)
print v(xbgr.mr_n77712896)
print v(xbgr.mr_n77713072)
print v(xbgr.mr_n77713648)
print v(xbgr.mr_n77714352)
print v(xbgr.mr_n77714528)
print v(xbgr.mr_n77714960)
print v(xbgr.mr_n77715072)
print v(xbgr.mr_n77715904)
print v(xbgr.mr_n77716080)
print v(xbgr.mr_n77716336)
print v(xbgr.mr_n77716912)
print v(xbgr.mr_n77717696)
print v(xbgr.mr_n77717872)
print v(xbgr.mr_n77718304)
print v(xbgr.mr_n77718864)
print v(xbgr.mr_n77719040)
print v(xbgr.mr_n77719536)
print v(xbgr.mr_n77720048)
print v(xbgr.mr_n77720160)
print v(xbgr.mr_n77720864)
print v(xbgr.mr_n77721200)
print v(xbgr.mr_n77721792)
print v(xbgr.mr_n77722288)
print v(xbgr.mr_n77722464)
print v(xbgr.mr_n77722880)
print v(xbgr.mr_n77723392)
print v(xbgr.mr_n77723888)
print v(xbgr.mr_n77724224)
print v(xbgr.mr_n77724736)
print v(xbgr.mr_n77724848)
print v(xbgr.mr_n77724960)
print v(xbgr.mr_n77726080)
print v(xbgr.mr_n77726256)
print v(xbgr.mr_n77726512)
print v(xbgr.mr_n77727088)
print v(xbgr.mr_n77727680)
print v(xbgr.mr_n77727792)
print v(xbgr.mr_n77727984)
print v(xbgr.mr_n77728336)
print v(xbgr.mr_n77728448)
print v(xbgr.mr_n77728960)
print v(xbgr.mr_n77729072)
print v(xbgr.mr_n77729184)
print v(xbgr.mr_n77729536)
print v(xbgr.mr_n77729872)
print v(xbgr.mr_n77730816)
print v(xbgr.mr_n77731232)
print v(xbgr.mr_n77731344)
print v(xbgr.mr_n77731904)
print v(xbgr.mr_n77732160)
print v(xbgr.mr_n77732976)
print v(xbgr.mr_n77733408)
print v(xbgr.mr_n77733584)
print v(xbgr.mr_n77734512)
print v(xbgr.mr_n77734688)
print v(xbgr.mr_n77735264)
print v(xbgr.mr_n77735376)
print v(xbgr.mr_n77735488)
print v(xbgr.mr_n77736256)
print v(xbgr.mr_n77736592)
print v(xbgr.mr_n77737536)
print v(xbgr.mr_n77737952)
print v(xbgr.mr_n77738064)
print v(xbgr.mr_n77738624)
print v(xbgr.mr_n77738880)
print v(xbgr.mr_n77739824)
print v(xbgr.mr_n77740240)
print v(xbgr.mr_n77740352)
print v(xbgr.mr_n77740464)
print v(xbgr.mr_n77741232)
print v(xbgr.mr_n77741568)
print v(xbgr.mr_n77742576)
print v(xbgr.mr_n77742752)
print v(xbgr.mr_n77743328)
print v(xbgr.mr_n77743760)
print v(xbgr.mr_n77743936)
print v(xbgr.mr_n77744672)
print v(xbgr.mr_n77744784)
print v(xbgr.mr_n77745344)
print v(xbgr.mr_n77745600)
print v(xbgr.mr_n77746544)
print v(xbgr.mr_n77746960)
print v(xbgr.mr_n77747072)
print v(xbgr.mr_n77747184)
print v(xbgr.mr_n77747952)
print v(xbgr.mr_n77748288)
print v(xbgr.mr_n77749104)
print v(xbgr.mr_n77749216)
print v(xbgr.mr_n77749776)
print v(xbgr.mr_n77750032)
print v(xbgr.mr_n77750976)
print v(xbgr.mr_n77751392)
print v(xbgr.mr_n77751504)
print v(xbgr.mr_n77752064)
print v(xbgr.mr_n77752320)
print v(xbgr.mr_n77753136)
print v(xbgr.mr_n77753568)
print v(xbgr.mr_n77753744)
print v(xbgr.mr_n77759008)
print v(xbgr.mr_n77759552)
print v(xbgr.mr_n77760016)
print v(xbgr.mr_n77760480)
print v(xbgr.mr_n77760944)
print v(xbgr.mr_n77761408)
print v(xbgr.mr_n77761872)
print v(xbgr.mr_n77762336)
print v(xbgr.mr_n77762800)
print v(xbgr.mr_n77763264)
print v(xbgr.mr_n77763728)
print v(xbgr.mr_n77764192)
print v(xbgr.mr_n77764656)
print v(xbgr.mr_n77765120)
print v(xbgr.mr_n77765584)
print v(xbgr.mr_n77766048)
print v(xbgr.mr_n77766512)
print v(xbgr.mr_n77766960)
print v(xbgr.mr_n77767424)
print v(xbgr.mr_n77767888)
print v(xbgr.mr_n77768352)
print v(xbgr.mr_n77768816)
print v(xbgr.mr_n77769280)
print v(xbgr.mr_n77769744)
print v(xbgr.mr_n77770208)
print v(xbgr.mr_n77771744)
print v(xbgr.mr_n77774864)
print v(xbgr.mr_n77775184)
print v(xbgr.mr_n77777744)
print v(xbgr.mr_n77779760)
print v(xbgr.mr_n77781264)
print v(xbgr.mr_n77786544)
print v(xbgr.mr_n77788464)
print v(xbgr.mr_n77789616)
print v(xbgr.mr_n77793472)
print v(xbgr.mr_n77799760)
print v(xbgr.mr_n77800400)
print v(xbgr.mr_n77803920)
print v(xbgr.mr_n77806320)
print v(xbgr.mr_n77808592)
print v(xbgr.mr_n77809232)
print v(xbgr.mr_n77809344)
print v(xbgr.mr_n77810288)
print v(xbgr.mr_n77813456)
print v(xbgr.mr_n77813712)
print v(xbgr.mr_n77814048)
print v(xbgr.mr_n77814384)
print v(xbgr.mr_n77816272)
print v(xbgr.mr_n77817056)
print v(xbgr.mr_n77817168)
print v(xbgr.mr_n77819024)
print v(xbgr.mr_n77819136)
print v(xbgr.mr_n77820832)
print v(xbgr.mr_n77820944)
print v(xbgr.mr_n77822640)
print v(xbgr.mr_n77822752)
print v(xbgr.mr_n77824448)
print v(xbgr.mr_n77824560)
print v(xbgr.mr_n77826256)
print v(xbgr.mr_n77826368)
print v(xbgr.mr_n77828064)
print v(xbgr.mr_n77828176)
print v(xbgr.mr_n77829872)
print v(xbgr.mr_n77829984)
print v(xbgr.mr_n77831680)
print v(xbgr.mr_n77831792)
print v(xbgr.mr_n77833488)
print v(xbgr.mr_n77833600)
print v(xbgr.mr_n77835296)
print v(xbgr.mr_n77835408)
print v(xbgr.mr_n77837104)
print v(xbgr.mr_n77837216)
print v(xbgr.mr_n77838912)
print v(xbgr.mr_n77839024)
print v(xbgr.mr_n77840720)
print v(xbgr.mr_n77840832)
print v(xbgr.mr_n77842528)
print v(xbgr.mr_n77842640)
print v(xbgr.mr_n77844336)
print v(xbgr.mr_n77844448)
print v(xbgr.mr_n77846144)
print v(xbgr.mr_n77846256)
print v(xbgr.mr_n77857120)
print v(xbgr.mr_n77863904)
print v(xbgr.mr_n77864864)
print v(xbgr.mr_n77865952)
print v(xbgr.mr_n77871840)
print v(xbgr.mr_n77872256)
print v(xbgr.mr_n77872720)
print v(xbgr.mr_n77872832)
print v(xbgr.mr_n77873648)
print v(xbgr.mr_n77874112)
print v(xbgr.mr_n77874224)
print v(xbgr.mr_n77875040)
print v(xbgr.mr_n77875568)
print v(xbgr.mr_n77875744)
print v(xbgr.mr_n77876688)
print v(xbgr.mr_n77877344)
print v(xbgr.mr_n77877520)
print v(xbgr.mr_n77878464)
print v(xbgr.mr_n77879120)
print v(xbgr.mr_n77879296)
print v(xbgr.mr_n77880240)
print v(xbgr.mr_n77880896)
print v(xbgr.mr_n77881072)
print v(xbgr.mr_n77882016)
print v(xbgr.mr_n77882672)
print v(xbgr.mr_n77882848)
print v(xbgr.mr_n77883792)
print v(xbgr.mr_n77884448)
print v(xbgr.mr_n77884624)
print v(xbgr.mr_n77885568)
print v(xbgr.mr_n77886224)
print v(xbgr.mr_n77886400)
print v(xbgr.mr_n77887344)
print v(xbgr.mr_n77887936)
print v(xbgr.mr_n77888528)
print v(xbgr.mr_n77889120)
print v(xbgr.mr_n77889712)
print v(xbgr.mr_n77890304)
print v(xbgr.mr_n77890896)
print v(xbgr.mr_n77891488)
print v(xbgr.mr_n77892080)
print v(xbgr.mr_n77892672)
print v(xbgr.mr_n77893264)
print v(xbgr.mr_n77893600)
print v(xbgr.mr_n77893712)
print v(xbgr.mr_n77893824)
print v(xbgr.mr_n77893936)
print v(xbgr.mr_n77895152)
print v(xbgr.mr_n77896064)
print v(xbgr.mr_n77896944)
print v(xbgr.mr_n77897536)
print v(xbgr.mr_n77898128)
print v(xbgr.mr_n77898720)
print v(xbgr.mr_n77899312)
print v(xbgr.mr_n77899904)
print v(xbgr.mr_n77900496)
print v(xbgr.mr_n77901088)
print v(xbgr.mr_n77901680)
print v(xbgr.mr_n77902272)
print v(xbgr.mr_n77902864)
print v(xbgr.mr_n77903456)
print v(xbgr.mr_n77904048)
print v(xbgr.mr_n77904640)
print v(xbgr.mr_n77905232)
print v(xbgr.mr_n77905824)
print v(xbgr.mr_n77906416)
print v(xbgr.mr_n77908112)
print v(xbgr.mr_n77912352)
print v(xbgr.mr_n77916304)
print v(xbgr.mr_n77919248)
print v(xbgr.mr_n77923104)
print v(xbgr.mr_n77923440)
print v(xbgr.mr_n77924096)
print v(xbgr.mr_n77924608)
print v(xbgr.mr_n77924720)
print v(xbgr.mr_n77926416)
print v(xbgr.mr_n77926528)
print v(xbgr.mr_n77928224)
print v(xbgr.mr_n77928336)
print v(xbgr.mr_n77930032)
print v(xbgr.mr_n77930144)
print v(xbgr.mr_n77931840)
print v(xbgr.mr_n77931952)
print v(xbgr.mr_n77933648)
print v(xbgr.mr_n77933760)
print v(xbgr.mr_n77935456)
print v(xbgr.mr_n77935568)
print v(xbgr.mr_n77937264)
print v(xbgr.mr_n77937376)
print v(xbgr.mr_n77939072)
print v(xbgr.mr_n77939184)
print v(xbgr.mr_n77940880)
print v(xbgr.mr_n77940992)
print v(xbgr.mr_n77942688)
print v(xbgr.mr_n77942800)
print v(xbgr.mr_n77942912)
print v(xbgr.mr_n77944752)
print v(xbgr.mr_n77944864)
print v(xbgr.mr_n77944976)
print v(xbgr.mr_n77946816)
print v(xbgr.mr_n77946928)
print v(xbgr.mr_n77947040)
print v(xbgr.mr_n77948880)
print v(xbgr.mr_n77948992)
print v(xbgr.mr_n77949104)
print v(xbgr.mr_n77950944)
print v(xbgr.mr_n77951056)
print v(xbgr.mr_n77951168)
print v(xbgr.mr_n77953008)
print v(xbgr.mr_n77953120)
print v(xbgr.mr_n77953232)
print v(xbgr.mr_n77955072)
print v(xbgr.mr_n77955184)
print v(xbgr.mr_n77955296)
print v(xbgr.mr_n77956208)
print v(xbgr.mr_n77956560)
print v(xbgr.mr_n77957072)
print v(xbgr.mr_n77957616)
print v(xbgr.mr_n77958160)
print v(xbgr.mr_n77958704)
print v(xbgr.mr_n77959248)
print v(xbgr.mr_n77959792)
print v(xbgr.mr_n77960336)
print v(xbgr.mr_n77960880)
print v(xbgr.mr_n77961424)
print v(xbgr.mr_n77961968)
print v(xbgr.mr_n77962512)
print v(xbgr.mr_n77963056)
print v(xbgr.mr_n77963600)
print v(xbgr.mr_n77964144)
print v(xbgr.mr_n77964688)
print v(xbgr.mr_n77965232)
print v(xbgr.mr_n77965776)
print v(xbgr.mr_n77966320)
print v(xbgr.mr_n77966864)
print v(xbgr.mr_n77967408)
print v(xbgr.mr_n77967952)
print v(xbgr.mr_n77968496)
print v(xbgr.mr_n77969040)
print v(xbgr.mr_n77969584)
print v(xbgr.mr_n77970128)
print v(xbgr.mr_n77970672)
print v(xbgr.mr_n77971264)
print v(xbgr.mr_n77971568)
print v(xbgr.mr_n77971952)
print v(xbgr.mr_n77972416)
print v(xbgr.mr_n77972880)
print v(xbgr.mr_n77973344)
print v(xbgr.mr_n77973808)
print v(xbgr.mr_n77974272)
print v(xbgr.mr_n77974736)
print v(xbgr.mr_n77975200)
print v(xbgr.mr_n77975664)
print v(xbgr.mr_n77976128)
print v(xbgr.mr_n77976592)
print v(xbgr.mr_n77977056)
print v(xbgr.mr_n77977520)
print v(xbgr.mr_n77977984)
print v(xbgr.mr_n77978448)
print v(xbgr.mr_n77978912)
print v(xbgr.mr_n77979376)
print v(xbgr.mr_n77979840)
print v(xbgr.mr_n77980304)
print v(xbgr.mr_n77980768)
print v(xbgr.mr_n77981232)
print v(xbgr.mr_n77981728)
print v(xbgr.mr_n77982320)
print v(xbgr.mr_n77982912)
print v(xbgr.mr_n77983504)
print v(xbgr.mr_n77984096)
print v(xbgr.mr_n77984688)
print v(xbgr.mr_n77985280)
print v(xbgr.mr_n77985904)
print v(xbgr.mr_n77988768)
print v(xbgr.mr_n77989056)
print v(xbgr.mr_n77997168)
print v(xbgr.mr_n78000256)
print v(xbgr.mr_n78000704)
print v(xbgr.mr_n78005824)
print v(xbgr.mr_n78013552)
print v(xbgr.mr_n78022768)
print v(xbgr.mr_n78031344)
print v(xbgr.mr_n78035136)
print v(xbgr.mr_n78035776)
print v(xbgr.mr_n78036544)
print v(xbgr.mr_n78037104)
print v(xbgr.mr_n78038112)
print v(xbgr.mr_n78042208)
print v(xbgr.mr_n78042656)
print v(xbgr.mr_n78044176)
print v(xbgr.mr_n78044512)
print v(xbgr.mr_n78045072)
print v(xbgr.mr_n78047872)
print v(xbgr.mr_n78049952)
print v(xbgr.mr_n78050560)
print v(xbgr.mr_n78050832)
print v(xbgr.mr_n78051696)
print v(xbgr.mr_n78055008)
print v(xbgr.mr_n78060224)
print v(xbgr.mr_n78063040)
print v(xbgr.mr_n78063360)
print v(xbgr.mr_n78064576)
print v(xbgr.mr_n78067712)
print v(xbgr.mr_n78070576)
print v(xbgr.mr_n78073232)
print v(xbgr.mr_n78074576)
print v(xbgr.mr_n78074752)
print v(xbgr.mr_n78075616)
print v(xbgr.mr_n78076064)
print v(xbgr.mr_n78078480)
print v(xbgr.mr_n78078928)
print v(xbgr.mr_n78079280)
print v(xbgr.mr_n78079536)
print v(xbgr.mr_n78079792)
print v(xbgr.mr_n78081680)
print v(xbgr.mr_n78082272)
print v(xbgr.mr_n78082608)
print v(xbgr.mr_n78082784)
print v(xbgr.mr_n78082896)
print v(xbgr.mr_n78083744)
print v(xbgr.mr_n78085456)
print v(xbgr.mr_n78086288)
print v(xbgr.mr_n78089888)
print v(xbgr.mr_n78091104)
print v(xbgr.mr_n78093504)
print v(xbgr.mr_n78093840)
print v(xbgr.mr_n78094176)
print v(xbgr.mr_n78094512)
print v(xbgr.mr_n78094928)
print v(xbgr.mr_n78095168)
print v(xbgr.mr_n78095552)
print v(xbgr.mr_n78096064)
print v(xbgr.mr_n78096176)
print v(xbgr.mr_n78096288)
print v(xbgr.mr_n78098128)
print v(xbgr.mr_n78098240)
print v(xbgr.mr_n78098352)
print v(xbgr.mr_n78100192)
print v(xbgr.mr_n78100304)
print v(xbgr.mr_n78100416)
print v(xbgr.mr_n78102256)
print v(xbgr.mr_n78102368)
print v(xbgr.mr_n78102480)
print v(xbgr.mr_n78104320)
print v(xbgr.mr_n78104432)
print v(xbgr.mr_n78104544)
print v(xbgr.mr_n78106384)
print v(xbgr.mr_n78106496)
print v(xbgr.mr_n78106608)
print v(xbgr.mr_n78108448)
print v(xbgr.mr_n78108560)
print v(xbgr.mr_n78108672)
print v(xbgr.mr_n78110512)
print v(xbgr.mr_n78110624)
print v(xbgr.mr_n78110736)
print v(xbgr.mr_n78112576)
print v(xbgr.mr_n78112688)
print v(xbgr.mr_n78112800)
print v(xbgr.mr_n78114640)
print v(xbgr.mr_n78114752)
print v(xbgr.mr_n78114864)
print v(xbgr.mr_n78116704)
print v(xbgr.mr_n78116816)
print v(xbgr.mr_n78116928)
print v(xbgr.mr_n78118768)
print v(xbgr.mr_n78118880)
print v(xbgr.mr_n78118992)
print v(xbgr.mr_n78120832)
print v(xbgr.mr_n78120944)
print v(xbgr.mr_n78121056)
print v(xbgr.mr_n78123600)
print v(xbgr.mr_n78123712)
print v(xbgr.mr_n78124080)
print v(xbgr.mr_n78127584)
print v(xbgr.mr_n78127696)
print v(xbgr.mr_n78128064)
print v(xbgr.mr_n78128240)
print v(xbgr.mr_n78131568)
print v(xbgr.mr_n78131680)
print v(xbgr.mr_n78132048)
print v(xbgr.mr_n78135552)
print v(xbgr.mr_n78135664)
print v(xbgr.mr_n78136032)
print v(xbgr.mr_n78138624)
print v(xbgr.mr_n78138736)
print v(xbgr.mr_n78139168)
print v(xbgr.mr_n78140240)
print v(xbgr.mr_n78140960)
print v(xbgr.mr_n78141136)
print v(xbgr.mr_n78142704)
print v(xbgr.mr_n78143520)
print v(xbgr.mr_n78143696)
print v(xbgr.mr_n78145264)
print v(xbgr.mr_n78145648)
print v(xbgr.mr_n78146080)
print v(xbgr.mr_n78146256)
print v(xbgr.mr_n78147824)
print v(xbgr.mr_n78148640)
print v(xbgr.mr_n78148816)
print v(xbgr.mr_n78150384)
print v(xbgr.mr_n78151200)
print v(xbgr.mr_n78151376)
print v(xbgr.mr_n78151936)
print v(xbgr.mr_n78152944)
print v(xbgr.mr_n78153760)
print v(xbgr.mr_n78153936)
print v(xbgr.mr_n78155504)
print v(xbgr.mr_n78156320)
print v(xbgr.mr_n78156496)
print v(xbgr.mr_n78158064)
print v(xbgr.mr_n78158880)
print v(xbgr.mr_n78159056)
print v(xbgr.mr_n78160624)
print v(xbgr.mr_n78161440)
print v(xbgr.mr_n78161616)
print v(xbgr.mr_n78163184)
print v(xbgr.mr_n78164320)
print v(xbgr.mr_n78164512)
print v(xbgr.mr_n78166240)
print v(xbgr.mr_n78166864)
print v(xbgr.mr_n78166976)
print v(xbgr.mr_n78167088)
print v(xbgr.mr_n78169088)
print v(xbgr.mr_n78170608)
print v(xbgr.mr_n78170784)
print v(xbgr.mr_n78171424)
print v(xbgr.mr_n78172352)
print v(xbgr.mr_n78173168)
print v(xbgr.mr_n78173344)
print v(xbgr.mr_n78173456)
print v(xbgr.mr_n78174912)
print v(xbgr.mr_n78175728)
print v(xbgr.mr_n78175904)
print v(xbgr.mr_n78177472)
print v(xbgr.mr_n78178288)
print v(xbgr.mr_n78178464)
print v(xbgr.mr_n78180032)
print v(xbgr.mr_n78180848)
print v(xbgr.mr_n78181024)
print v(xbgr.mr_n78182592)
print v(xbgr.mr_n78183408)
print v(xbgr.mr_n78183584)
print v(xbgr.mr_n78185152)
print v(xbgr.mr_n78185968)
print v(xbgr.mr_n78186144)
print v(xbgr.mr_n78187712)
print v(xbgr.mr_n78188528)
print v(xbgr.mr_n78188704)
print v(xbgr.mr_n78190272)
print v(xbgr.mr_n78191088)
print v(xbgr.mr_n78191264)
print v(xbgr.mr_n78192832)
print v(xbgr.mr_n78193648)
print v(xbgr.mr_n78193824)
print v(xbgr.mr_n78195392)
print v(xbgr.mr_n78196208)
print v(xbgr.mr_n78196384)
print v(xbgr.mr_n78197952)
print v(xbgr.mr_n78198768)
print v(xbgr.mr_n78198944)
print v(xbgr.mr_n78200512)
print v(xbgr.mr_n78201328)
print v(xbgr.mr_n78201504)
print v(xbgr.mr_n78203072)
print v(xbgr.mr_n78203888)
print v(xbgr.mr_n78204064)
print v(xbgr.mr_n78204304)
print v(xbgr.mr_n78205632)
print v(xbgr.mr_n78281312)
print v(xbgr.mr_n78281872)
print v(xbgr.mr_n78282176)
print v(xbgr.mr_n78282768)
print v(xbgr.mr_n78285760)
print v(xbgr.mr_n78288640)
print v(xbgr.mr_n78296000)
print v(xbgr.mr_n78296512)
print v(xbgr.mr_n78297472)
print v(xbgr.mr_n78301056)
print v(xbgr.mr_n78304000)
print v(xbgr.mr_n78309888)
print v(xbgr.mr_n78311056)
print v(xbgr.mr_n78318080)
print v(xbgr.mr_n78318880)
print v(xbgr.mr_n78319584)
print v(xbgr.mr_n78320160)
print v(xbgr.mr_n78320544)
print v(xbgr.mr_n78320896)
print v(xbgr.mr_n78322256)
print v(xbgr.mr_n78323344)
print v(xbgr.mr_n78323680)
print v(xbgr.mr_n78323856)
print v(xbgr.mr_n78324080)
print v(xbgr.mr_n78324384)
print v(xbgr.mr_n78325456)
print v(xbgr.mr_n78326784)
print v(xbgr.mr_n78327056)
print v(xbgr.mr_n78327856)
print v(xbgr.mr_n78426816)
print v(xbgr.mr_n78426928)
print v(xbgr.mr_n78427760)
print v(xbgr.mr_n78427872)
print v(xbgr.mr_n78428704)
print v(xbgr.mr_n78428816)
print v(xbgr.mr_n78429648)
print v(xbgr.mr_n78429760)
print v(xbgr.mr_n78430592)
print v(xbgr.mr_n78430704)
print v(xbgr.mr_n78431536)
print v(xbgr.mr_n78431648)
print v(xbgr.mr_n78432480)
print v(xbgr.mr_n78432592)
print v(xbgr.mr_n78433424)
print v(xbgr.mr_n78433536)
print v(xbgr.mr_n78434368)
print v(xbgr.mr_n78436560)
print v(xbgr.mr_n78436832)
print v(xbgr.mr_n78437024)
print v(xbgr.mr_n78437536)
print v(xbgr.mr_n78439712)
print v(xbgr.mr_n78439904)
print v(xbgr.mr_n78442160)
print v(xbgr.mr_n78445152)
print v(xbgr.mr_n78449472)
print v(xbgr.mr_n78449664)
print v(xbgr.mr_n78452208)
print v(xbgr.mr_n78453824)
print v(xbgr.mr_n78455504)
print v(xbgr.mr_n78457760)
print v(xbgr.mr_n78460016)
print v(xbgr.mr_n78462272)
print v(xbgr.mr_n78464528)
print v(xbgr.mr_n78466784)
print v(xbgr.mr_n78469040)
print v(xbgr.mr_n78471296)
print v(xbgr.mr_n78492496)
print v(xbgr.mr_n78496448)
print v(xbgr.mr_n78497584)
print v(xbgr.mr_n78497696)
print v(xbgr.mr_n78498320)
print v(xbgr.mr_n78499856)
print v(xbgr.mr_n78500720)
print v(xbgr.mr_n78501680)
print v(xbgr.mr_n78501792)
print v(xbgr.mr_n78502736)
print v(xbgr.mr_n78503856)
print v(xbgr.mr_n78503968)
print v(xbgr.mr_n78504592)
print v(xbgr.mr_n78506128)
print v(xbgr.mr_n78506992)
print v(xbgr.mr_n78507952)
print v(xbgr.mr_n78508064)
print v(xbgr.mr_n78509008)
print v(xbgr.mr_n78510128)
print v(xbgr.mr_n78510240)
print v(xbgr.mr_n78510864)
print v(xbgr.mr_n78512400)
print v(xbgr.mr_n78513264)
print v(xbgr.mr_n78514224)
print v(xbgr.mr_n78514336)
print v(xbgr.mr_n78515280)
print v(xbgr.mr_n78516400)
print v(xbgr.mr_n78516512)
print v(xbgr.mr_n78517136)
print v(xbgr.mr_n78518672)
print v(xbgr.mr_n78519536)
print v(xbgr.mr_n78520496)
print v(xbgr.mr_n78520608)
print v(xbgr.mr_n78521552)
print v(xbgr.mr_n78522672)
print v(xbgr.mr_n78522784)
print v(xbgr.mr_n78523408)
print v(xbgr.mr_n78524944)
print v(xbgr.mr_n78525808)
print v(xbgr.mr_n78526768)
print v(xbgr.mr_n78526880)
print v(xbgr.mr_n78527824)
print v(xbgr.mr_n78528272)
print v(xbgr.mr_n78528944)
print v(xbgr.mr_n78529056)
print v(xbgr.mr_n78529680)
print v(xbgr.mr_n78531856)
print v(xbgr.mr_n78532032)
print v(xbgr.mr_n78533920)
print v(xbgr.mr_n78534608)
print v(xbgr.mr_n78535296)
print v(xbgr.mr_n78536048)
print v(xbgr.mr_n78536992)
print v(xbgr.mr_n78537936)
print v(xbgr.mr_n78538880)
print v(xbgr.mr_n78539824)
print v(xbgr.mr_n78540768)
print v(xbgr.mr_n78541712)
print v(xbgr.mr_n78542656)
print v(xbgr.mr_n78543600)
print v(xbgr.mr_n78544544)
print v(xbgr.mr_n78545488)
print v(xbgr.mr_n78546432)
print v(xbgr.mr_n78547376)
print v(xbgr.mr_n78548320)
print v(xbgr.mr_n78549264)
print v(xbgr.mr_n78550208)
print v(xbgr.mr_n78551152)
print v(xbgr.mr_n78552096)
print v(xbgr.mr_n78553040)
print v(xbgr.mr_n78553984)
print v(xbgr.mr_n78554928)
print v(xbgr.mr_n78555872)
print v(xbgr.mr_n78556816)
print v(xbgr.mr_n78557760)
print v(xbgr.mr_n78558704)
print v(xbgr.mr_n78559648)
print v(xbgr.mr_n78560592)
print v(xbgr.mr_n78561536)
print v(xbgr.mr_n78562480)
print v(xbgr.mr_n78563424)
print v(xbgr.mr_n78563536)
print v(xbgr.mr_n78564368)
print v(xbgr.mr_n78565312)
print v(xbgr.mr_n78566256)
print v(xbgr.mr_n78569728)
print v(xbgr.mr_n78569952)
print v(xbgr.mr_n78570720)
print v(xbgr.mr_n78572624)
print v(xbgr.mr_n78572736)
print v(xbgr.mr_n78575616)
print v(xbgr.mr_n78575728)
print v(xbgr.mr_n78576880)
print v(xbgr.mr_n78576992)
print v(xbgr.mr_n78578144)
print v(xbgr.mr_n78578256)
print v(xbgr.mr_n78579408)
print v(xbgr.mr_n78579520)
print v(xbgr.mr_n78580672)
print v(xbgr.mr_n78580784)
print v(xbgr.mr_n78581936)
print v(xbgr.mr_n78582048)
print v(xbgr.mr_n78583200)
print v(xbgr.mr_n78583312)
print v(xbgr.mr_n78584464)
print v(xbgr.mr_n78584576)
print v(xbgr.mr_n78585728)
print v(xbgr.mr_n78585840)
print v(xbgr.mr_n78586992)
print v(xbgr.mr_n78587104)
print v(xbgr.mr_n78589104)
print v(xbgr.mr_n78595616)
print v(xbgr.mr_n78602576)
print v(xbgr.mr_n78602928)
print v(xbgr.mr_n78603888)
print v(xbgr.mr_n78604144)
print v(xbgr.mr_n78604400)
print v(xbgr.mr_n78604656)
print v(xbgr.mr_n78607248)
print v(xbgr.mr_n78607360)
print v(xbgr.mr_n78608144)
print v(xbgr.mr_n78608816)
print v(xbgr.mr_n78609616)
print v(xbgr.mr_n78610448)
print v(xbgr.mr_n78611312)
print v(xbgr.mr_n78615600)
print v(xbgr.mr_n78616848)
print v(xbgr.mr_n78616960)
print v(xbgr.mr_n78618960)
print v(xbgr.mr_n78620704)
print v(xbgr.mr_n78620976)
print v(xbgr.mr_n78621168)
print v(xbgr.mr_n78624400)
print v(xbgr.mr_n78624592)
print v(xbgr.mr_n78628736)
print v(xbgr.mr_n78629008)
print v(xbgr.mr_n78629200)
print v(xbgr.mr_n78632432)
print v(xbgr.mr_n78632624)
print v(xbgr.mr_n78636768)
print v(xbgr.mr_n78637040)
print v(xbgr.mr_n78637232)
print v(xbgr.mr_n78638912)
print v(xbgr.mr_n78640464)
print v(xbgr.mr_n78640656)
print v(xbgr.mr_n78644800)
print v(xbgr.mr_n78645072)
print v(xbgr.mr_n78645264)
print v(xbgr.mr_n78648992)
print v(xbgr.mr_n78650240)
print v(xbgr.mr_n78650352)
print v(xbgr.mr_n78653392)
print v(xbgr.mr_n78653584)
print v(xbgr.mr_n78653776)
print v(xbgr.mr_n78655024)
print v(xbgr.mr_n78655136)
print v(xbgr.mr_n78656752)
print v(xbgr.mr_n78659552)
print v(xbgr.mr_n78660800)
print v(xbgr.mr_n78660912)
print v(xbgr.mr_n78663808)
print v(xbgr.mr_n78668816)
print v(xbgr.mr_n78672848)
print v(xbgr.mr_n78673680)
print v(xbgr.mr_n78673792)
print v(xbgr.mr_n78674624)
print v(xbgr.mr_n78674736)
print v(xbgr.mr_n78675568)
print v(xbgr.mr_n78675680)
print v(xbgr.mr_n78676768)
print v(xbgr.mr_n78676880)
print v(xbgr.mr_n78678032)
print v(xbgr.mr_n78678144)
print v(xbgr.mr_n78679296)
print v(xbgr.mr_n78679408)
print v(xbgr.mr_n78680560)
print v(xbgr.mr_n78680672)
print v(xbgr.mr_n78681824)
print v(xbgr.mr_n78681936)
print v(xbgr.mr_n78683088)
print v(xbgr.mr_n78683200)
print v(xbgr.mr_n78684352)
print v(xbgr.mr_n78684464)
print v(xbgr.mr_n78685616)
print v(xbgr.mr_n78685728)
print v(xbgr.mr_n78686880)
print v(xbgr.mr_n78686992)
print v(xbgr.mr_n78688144)
print v(xbgr.mr_n78688256)
print v(xbgr.mr_n78689408)
print v(xbgr.mr_n78689520)
print v(xbgr.mr_n78690672)
print v(xbgr.mr_n78690784)
print v(xbgr.mr_n78698192)
print v(xbgr.mr_n78698880)
print v(xbgr.mr_n78699568)
print v(xbgr.mr_n78700288)
print v(xbgr.mr_n78701904)
print v(xbgr.mr_n78703184)
print v(xbgr.mr_n78703296)
print v(xbgr.mr_n78703792)
print v(xbgr.mr_n78704240)
print v(xbgr.mr_n78705456)
print v(xbgr.mr_n78708208)
print v(xbgr.mr_n78708752)
print v(xbgr.mr_n78710160)
print v(xbgr.mr_n78710704)
print v(xbgr.mr_n78712048)
print v(xbgr.mr_n78712592)
print v(xbgr.mr_n78713936)
print v(xbgr.mr_n78714480)
print v(xbgr.mr_n78715824)
print v(xbgr.mr_n78716368)
print v(xbgr.mr_n78717712)
print v(xbgr.mr_n78718256)
print v(xbgr.mr_n78719600)
print v(xbgr.mr_n78720144)
print v(xbgr.mr_n78721488)
print v(xbgr.mr_n78722032)
print v(xbgr.mr_n78723104)
print v(xbgr.mr_n78723376)
print v(xbgr.mr_n78723920)
print v(xbgr.mr_n78725264)
print v(xbgr.mr_n78725808)
print v(xbgr.mr_n78727152)
print v(xbgr.mr_n78728016)
print v(xbgr.mr_n78728976)
print v(xbgr.mr_n78729088)
print v(xbgr.mr_n78730032)
print v(xbgr.mr_n78731184)
print v(xbgr.mr_n78731296)
print v(xbgr.mr_n78732240)
print v(xbgr.mr_n78733392)
print v(xbgr.mr_n78733504)
print v(xbgr.mr_n78736640)
print v(xbgr.mr_n78738800)
print v(xbgr.mr_n78746864)
print v(xbgr.mr_n78749136)
print v(xbgr.mr_n78749824)
print v(xbgr.mr_n78750512)
print v(xbgr.mr_n78751232)
print v(xbgr.mr_n78752176)
print v(xbgr.mr_n78752368)
print v(xbgr.mr_n78752560)
print v(xbgr.mr_n78752752)
print v(xbgr.mr_n78752944)
print v(xbgr.mr_n78753136)
print v(xbgr.mr_n78755280)
print v(xbgr.mr_n78755392)
print v(xbgr.mr_n78757408)
print v(xbgr.mr_n78759424)
print v(xbgr.mr_n78759536)
print v(xbgr.mr_n78765184)
print v(xbgr.mr_n78766128)
print v(xbgr.mr_n78772640)
print v(xbgr.mr_n78781152)
print v(xbgr.mr_n78782096)
print v(xbgr.mr_n78783040)
print v(xbgr.mr_n78783984)
print v(xbgr.mr_n78784928)
print v(xbgr.mr_n78785872)
print v(xbgr.mr_n78786816)
print v(xbgr.mr_n78787760)
print v(xbgr.mr_n78793248)
print v(xbgr.mr_n78793776)
print v(xbgr.mr_n78794336)
print v(xbgr.mr_n78794848)
print v(xbgr.mr_n78796400)
print v(xbgr.mr_n78796928)
print v(xbgr.mr_n78797488)
print v(xbgr.mr_n78798000)
print v(xbgr.mr_n78799616)
print v(xbgr.mr_n78799808)
print v(xbgr.mr_n78800640)
print v(xbgr.mr_n78801152)
print v(xbgr.mr_n78802656)
print v(xbgr.mr_n78802912)
print v(xbgr.mr_n78803104)
print v(xbgr.mr_n78803792)
print v(xbgr.mr_n78804304)
print v(xbgr.mr_n78805920)
print v(xbgr.mr_n78806112)
print v(xbgr.mr_n78806944)
print v(xbgr.mr_n78807456)
print v(xbgr.mr_n78809216)
print v(xbgr.mr_n78809408)
print v(xbgr.mr_n78810096)
print v(xbgr.mr_n78810608)
print v(xbgr.mr_n78811712)
print v(xbgr.mr_n78812368)
print v(xbgr.mr_n78812560)
print v(xbgr.mr_n78813248)
print v(xbgr.mr_n78813760)
print v(xbgr.mr_n78815520)
print v(xbgr.mr_n78815712)
print v(xbgr.mr_n78816400)
print v(xbgr.mr_n78816832)
print v(xbgr.mr_n78817664)
print v(xbgr.mr_n78818368)
print v(xbgr.mr_n78818928)
print v(xbgr.mr_n78819504)
print v(xbgr.mr_n78820192)
print v(xbgr.mr_n78820624)
print v(xbgr.mr_n78821456)
print v(xbgr.mr_n78821888)
print v(xbgr.mr_n78822720)
print v(xbgr.mr_n78823152)
print v(xbgr.mr_n78823984)
print v(xbgr.mr_n78824560)
print v(xbgr.mr_n78825248)
print v(xbgr.mr_n78827680)
print v(xbgr.mr_n78828368)
print v(xbgr.mr_n78829056)
print v(xbgr.mr_n78831568)
print v(xbgr.mr_n78831760)
print v(xbgr.mr_n78832592)
print v(xbgr.mr_n78832784)
print v(xbgr.mr_n78833360)
print v(xbgr.mr_n78833472)
print v(xbgr.mr_n78835232)
print v(xbgr.mr_n78836064)
print v(xbgr.mr_n78836336)
print v(xbgr.mr_n78836448)
print v(xbgr.mr_n78837088)
print v(xbgr.mr_n78837200)
print v(xbgr.mr_n78837312)
print v(xbgr.mr_n78837504)
print v(xbgr.mr_n78837696)
print v(xbgr.mr_n78837888)
print v(xbgr.mr_n78840432)
print v(xbgr.mr_n78840624)
print v(xbgr.mr_n78841136)
print v(xbgr.mr_n78845088)
print v(xbgr.mr_n78845280)
print v(xbgr.mr_n78845472)
print v(xbgr.mr_n78847600)
print v(xbgr.mr_n78847872)
print v(xbgr.mr_n78848064)
print v(xbgr.mr_n78848576)
print v(xbgr.mr_n78850512)
print v(xbgr.mr_n78851024)
print v(xbgr.mr_n78852160)
print v(xbgr.mr_n78854096)
print v(xbgr.mr_n78854288)
print v(xbgr.mr_n78854800)
print v(xbgr.mr_n78856416)
print v(xbgr.mr_n78856608)
print v(xbgr.mr_n78858736)
print v(xbgr.mr_n78859008)
print v(xbgr.mr_n78859200)
print v(xbgr.mr_n78859712)
print v(xbgr.mr_n78861648)
print v(xbgr.mr_n78862160)
print v(xbgr.mr_n78864896)
print v(xbgr.mr_n78865168)
print v(xbgr.mr_n78865360)
print v(xbgr.mr_n78865872)
print v(xbgr.mr_n78867488)
print v(xbgr.mr_n78867680)
print v(xbgr.mr_n78869872)
print v(xbgr.mr_n78870144)
print v(xbgr.mr_n78870336)
print v(xbgr.mr_n78870848)
print v(xbgr.mr_n78872784)
print v(xbgr.mr_n78873296)
print v(xbgr.mr_n78876032)
print v(xbgr.mr_n78876304)
print v(xbgr.mr_n78876496)
print v(xbgr.mr_n78877008)
print v(xbgr.mr_n78878624)
print v(xbgr.mr_n78878816)
print v(xbgr.mr_n78881008)
print v(xbgr.mr_n78881280)
print v(xbgr.mr_n78881472)
print v(xbgr.mr_n78881984)
print v(xbgr.mr_n78883920)
print v(xbgr.mr_n78884432)
print v(xbgr.mr_n78885728)
print v(xbgr.mr_n78885920)
print v(xbgr.mr_n78886112)
print v(xbgr.mr_n78888464)
print v(xbgr.mr_n78891792)
print v(xbgr.mr_n78893008)
print v(xbgr.mr_n78893120)
print v(xbgr.mr_n78894272)
print v(xbgr.mr_n78894384)
print v(xbgr.mr_n78895536)
print v(xbgr.mr_n78895648)
print v(xbgr.mr_n78896800)
print v(xbgr.mr_n78896912)
print v(xbgr.mr_n78898064)
print v(xbgr.mr_n78898176)
print v(xbgr.mr_n78899328)
print v(xbgr.mr_n78899440)
print v(xbgr.mr_n78900592)
print v(xbgr.mr_n78900704)
print v(xbgr.mr_n78901856)
print v(xbgr.mr_n78901968)
print v(xbgr.mr_n78903120)
print v(xbgr.mr_n78903232)
print v(xbgr.mr_n78904384)
print v(xbgr.mr_n78904496)
print v(xbgr.mr_n78905648)
print v(xbgr.mr_n78905760)
print v(xbgr.mr_n78906912)
print v(xbgr.mr_n78907024)
print v(xbgr.mr_n78908176)
print v(xbgr.mr_n78908288)
print v(xbgr.mr_n78909440)
print v(xbgr.mr_n78909552)
print v(xbgr.mr_n78910704)
print v(xbgr.mr_n78910816)
print v(xbgr.mr_n78918576)
print v(xbgr.mr_n78918912)
print v(xbgr.mr_n78926560)
print v(xbgr.mr_n78927856)
print v(xbgr.mr_n78929968)
print v(xbgr.mr_n78935232)
print v(xbgr.mr_n78944496)
print v(xbgr.mr_n78945184)
print v(xbgr.mr_n78945936)
print v(xbgr.mr_n78946880)
print v(xbgr.mr_n78949008)
print v(xbgr.mr_n78950384)
print v(xbgr.mr_n78953232)
print v(xbgr.mr_n78953424)
print v(xbgr.mr_n78954256)
print v(xbgr.mr_n78954368)
print v(xbgr.mr_n78954480)
print v(xbgr.mr_n78954592)
print v(xbgr.mr_n78954704)
print v(xbgr.mr_n78956448)
print v(xbgr.mr_n78956720)
print v(xbgr.mr_n78956912)
print v(xbgr.mr_n78957424)
print v(xbgr.mr_n78959360)
print v(xbgr.mr_n78961104)
print v(xbgr.mr_n78961376)
print v(xbgr.mr_n78961568)
print v(xbgr.mr_n78962080)
print v(xbgr.mr_n78964016)
print v(xbgr.mr_n78965760)
print v(xbgr.mr_n78966032)
print v(xbgr.mr_n78966224)
print v(xbgr.mr_n78966736)
print v(xbgr.mr_n78967968)
print v(xbgr.mr_n78968480)
print v(xbgr.mr_n78971920)
print v(xbgr.mr_n78972384)
print v(xbgr.mr_n78972896)
print v(xbgr.mr_n78975168)
print v(xbgr.mr_n78975280)
print v(xbgr.mr_n78975424)
print v(xbgr.mr_n78977888)
print v(xbgr.mr_n78978720)
print v(xbgr.mr_n78979184)
print v(xbgr.mr_n78979296)
print v(xbgr.mr_n78979408)
print v(xbgr.mr_n78979520)
print v(xbgr.mr_n78981264)
print v(xbgr.mr_n78981536)
print v(xbgr.mr_n78981728)
print v(xbgr.mr_n78982240)
print v(xbgr.mr_n78985472)
print v(xbgr.mr_n78985584)
print v(xbgr.mr_n78987328)
print v(xbgr.mr_n78987600)
print v(xbgr.mr_n78987792)
print v(xbgr.mr_n78988304)
print v(xbgr.mr_n78989536)
print v(xbgr.mr_n78990048)
print v(xbgr.mr_n78993488)
print v(xbgr.mr_n78993680)
print v(xbgr.mr_n78993872)
print v(xbgr.mr_n78994464)
print v(xbgr.mr_n78996608)
print v(xbgr.mr_n78996720)
print v(xbgr.mr_n78998464)
print v(xbgr.mr_n78998736)
print v(xbgr.mr_n78998928)
print v(xbgr.mr_n78999440)
print v(xbgr.mr_n79000592)
print v(xbgr.mr_n79001184)
print v(xbgr.mr_n79003088)
print v(xbgr.mr_n79004624)
print v(xbgr.mr_n79004896)
print v(xbgr.mr_n79005088)
print v(xbgr.mr_n79005600)
print v(xbgr.mr_n79007744)
print v(xbgr.mr_n79007936)
print v(xbgr.mr_n79008128)
print v(xbgr.mr_n79009936)
print v(xbgr.mr_n79010128)
print v(xbgr.mr_n79010640)
print v(xbgr.mr_n79011808)
print v(xbgr.mr_n79012320)
print v(xbgr.mr_n79015760)
print v(xbgr.mr_n79015952)
print v(xbgr.mr_n79016144)
print v(xbgr.mr_n79016736)
print v(xbgr.mr_n79018800)
print v(xbgr.mr_n79018912)
print v(xbgr.mr_n79019424)
print v(xbgr.mr_n79019536)
print v(xbgr.mr_n79020048)
print v(xbgr.mr_n79020160)
print v(xbgr.mr_n79020928)
print v(xbgr.mr_n79021040)
print v(xbgr.mr_n79021872)
print v(xbgr.mr_n79021984)
print v(xbgr.mr_n79022816)
print v(xbgr.mr_n79022928)
print v(xbgr.mr_n79023760)
print v(xbgr.mr_n79023872)
print v(xbgr.mr_n79024704)
print v(xbgr.mr_n79024816)
print v(xbgr.mr_n79025712)
print v(xbgr.mr_n79025824)
print v(xbgr.mr_n79026976)
print v(xbgr.mr_n79027088)
print v(xbgr.mr_n79028240)
print v(xbgr.mr_n79028352)
print v(xbgr.mr_n79029504)
print v(xbgr.mr_n79029616)
print v(xbgr.mr_n79030768)
print v(xbgr.mr_n79030880)
print v(xbgr.mr_n79032032)
print v(xbgr.mr_n79032144)
print v(xbgr.mr_n79033296)
print v(xbgr.mr_n79033408)
print v(xbgr.mr_n79045184)
print v(xbgr.mr_n79045296)
print v(xbgr.mr_n79046448)
print v(xbgr.mr_n79046560)
print v(xbgr.mr_n79047712)
print v(xbgr.mr_n79047824)
print v(xbgr.mr_n79048976)
print v(xbgr.mr_n79049088)
print v(xbgr.mr_n79050240)
print v(xbgr.mr_n79050352)
print v(xbgr.mr_n79051504)
print v(xbgr.mr_n79051616)
print v(xbgr.mr_n79052768)
print v(xbgr.mr_n79052880)
print v(xbgr.mr_n79054032)
print v(xbgr.mr_n79054144)
print v(xbgr.mr_n79055296)
print v(xbgr.mr_n79055408)
print v(xbgr.mr_n79056560)
print v(xbgr.mr_n79056672)
print v(xbgr.mr_n79057824)
print v(xbgr.mr_n79057936)
print v(xbgr.mr_n79059088)
print v(xbgr.mr_n79059200)
print v(xbgr.mr_n79060352)
print v(xbgr.mr_n79060464)
print v(xbgr.mr_n79061616)
print v(xbgr.mr_n79061728)
print v(xbgr.mr_n79062880)
print v(xbgr.mr_n79062992)
print v(xbgr.mr_n79064144)
print v(xbgr.mr_n79064256)
print v(xbgr.mr_n79065408)
print v(xbgr.mr_n79065520)
print v(xbgr.mr_n79068864)
print v(xbgr.mr_n79075680)
print v(xbgr.mr_n79079712)
print v(xbgr.mr_n79087744)
print v(xbgr.mr_n79088336)
print v(xbgr.mr_n79088864)
print v(xbgr.mr_n79089152)
print v(xbgr.mr_n79090800)
print v(xbgr.mr_n79091616)
print v(xbgr.mr_n79093728)
print v(xbgr.mr_n79094496)
print v(xbgr.mr_n79094784)
print v(xbgr.mr_n79095376)
print v(xbgr.mr_n79095728)
print v(xbgr.mr_n79095936)
print v(xbgr.mr_n79096256)
print v(xbgr.mr_n79097840)
print v(xbgr.mr_n79100832)
print v(xbgr.mr_n79101008)
print v(xbgr.mr_n79102000)
print v(xbgr.mr_n79103472)
print v(xbgr.mr_n79104112)
print v(xbgr.mr_n79104880)
print v(xbgr.mr_n79105168)
print v(xbgr.mr_n79105872)
print v(xbgr.mr_n79106048)
print v(xbgr.mr_n79109136)
print v(xbgr.mr_n79110192)
print v(xbgr.mr_n79110304)
print v(xbgr.mr_n79111568)
print v(xbgr.mr_n79113696)
print v(xbgr.mr_n79116832)
print v(xbgr.mr_n79119616)
print v(xbgr.mr_n79120144)
print v(xbgr.mr_n79120704)
print v(xbgr.mr_n79120816)
print v(xbgr.mr_n79120928)
print v(xbgr.mr_n79121040)
print v(xbgr.mr_n79121152)
print v(xbgr.mr_n79122896)
print v(xbgr.mr_n79123168)
print v(xbgr.mr_n79123360)
print v(xbgr.mr_n79123872)
print v(xbgr.mr_n79125808)
print v(xbgr.mr_n79127552)
print v(xbgr.mr_n79127824)
print v(xbgr.mr_n79128016)
print v(xbgr.mr_n79128528)
print v(xbgr.mr_n79130464)
print v(xbgr.mr_n79132208)
print v(xbgr.mr_n79132480)
print v(xbgr.mr_n79132672)
print v(xbgr.mr_n79133184)
print v(xbgr.mr_n79135120)
print v(xbgr.mr_n79136864)
print v(xbgr.mr_n79137136)
print v(xbgr.mr_n79137328)
print v(xbgr.mr_n79137840)
print v(xbgr.mr_n79139776)
print v(xbgr.mr_n79141520)
print v(xbgr.mr_n79141792)
print v(xbgr.mr_n79141984)
print v(xbgr.mr_n79142496)
print v(xbgr.mr_n79144432)
print v(xbgr.mr_n79146176)
print v(xbgr.mr_n79146448)
print v(xbgr.mr_n79146640)
print v(xbgr.mr_n79147152)
print v(xbgr.mr_n79149168)
print v(xbgr.mr_n79149360)
print v(xbgr.mr_n79151168)
print v(xbgr.mr_n79151360)
print v(xbgr.mr_n79151872)
print v(xbgr.mr_n79153744)
print v(xbgr.mr_n79155488)
print v(xbgr.mr_n79155760)
print v(xbgr.mr_n79155952)
print v(xbgr.mr_n79156464)
print v(xbgr.mr_n79158400)
print v(xbgr.mr_n79160144)
print v(xbgr.mr_n79160416)
print v(xbgr.mr_n79160608)
print v(xbgr.mr_n79161120)
print v(xbgr.mr_n79163056)
print v(xbgr.mr_n79164800)
print v(xbgr.mr_n79164992)
print v(xbgr.mr_n79165184)
print v(xbgr.mr_n79165776)
print v(xbgr.mr_n79167712)
print v(xbgr.mr_n79167904)
print v(xbgr.mr_n79169456)
print v(xbgr.mr_n79169728)
print v(xbgr.mr_n79169920)
print v(xbgr.mr_n79170432)
print v(xbgr.mr_n79172448)
print v(xbgr.mr_n79172640)
print v(xbgr.mr_n79174448)
print v(xbgr.mr_n79174640)
print v(xbgr.mr_n79175152)
print v(xbgr.mr_n79177024)
print v(xbgr.mr_n79178768)
print v(xbgr.mr_n79179040)
print v(xbgr.mr_n79179232)
print v(xbgr.mr_n79179744)
print v(xbgr.mr_n79181680)
print v(xbgr.mr_n79183424)
print v(xbgr.mr_n79183696)
print v(xbgr.mr_n79183888)
print v(xbgr.mr_n79184400)
print v(xbgr.mr_n79186336)
print v(xbgr.mr_n79188080)
print v(xbgr.mr_n79188352)
print v(xbgr.mr_n79188544)
print v(xbgr.mr_n79189056)
print v(xbgr.mr_n79190992)
print v(xbgr.mr_n79192736)
print v(xbgr.mr_n79193008)
print v(xbgr.mr_n79193200)
print v(xbgr.mr_n79193712)
print v(xbgr.mr_n79195648)
print v(xbgr.mr_n79197392)
print v(xbgr.mr_n79197664)
print v(xbgr.mr_n79197856)
print v(xbgr.mr_n79198368)
print v(xbgr.mr_n79201200)
print v(xbgr.mr_n79201984)
print v(xbgr.mr_n79203632)
print v(xbgr.mr_n79203968)
print v(xbgr.mr_n79205120)
print v(xbgr.mr_n79206176)
print v(xbgr.mr_n79207840)
print v(xbgr.mr_n79208272)
print v(xbgr.mr_n79208704)
print v(xbgr.mr_n79210128)
print v(xbgr.mr_n79210704)
print v(xbgr.mr_n79210816)
print v(xbgr.mr_n79211760)
print v(xbgr.mr_n79212592)
print v(xbgr.mr_n79212704)
print v(xbgr.mr_n79213648)
print v(xbgr.mr_n79214800)
print v(xbgr.mr_n79214912)
print v(xbgr.mr_n79215856)
print v(xbgr.mr_n79217008)
print v(xbgr.mr_n79217120)
print v(xbgr.mr_n79218064)
print v(xbgr.mr_n79219216)
print v(xbgr.mr_n79219328)
print v(xbgr.mr_n79220272)
print v(xbgr.mr_n79221424)
print v(xbgr.mr_n79221536)
print v(xbgr.mr_n79222480)
print v(xbgr.mr_n79223632)
print v(xbgr.mr_n79223744)
print v(xbgr.mr_n79224688)
print v(xbgr.mr_n79225840)
print v(xbgr.mr_n79225952)
print v(xbgr.mr_n79226896)
print v(xbgr.mr_n79228048)
print v(xbgr.mr_n79228160)
print v(xbgr.mr_n79229104)
print v(xbgr.mr_n79230256)
print v(xbgr.mr_n79230368)
print v(xbgr.mr_n79231312)
print v(xbgr.mr_n79232464)
print v(xbgr.mr_n79232576)
print v(xbgr.mr_n79233520)
print v(xbgr.mr_n79234672)
print v(xbgr.mr_n79234784)
print v(xbgr.mr_n79235728)
print v(xbgr.mr_n79236880)
print v(xbgr.mr_n79236992)
print v(xbgr.mr_n79237936)
print v(xbgr.mr_n79239088)
print v(xbgr.mr_n79239200)
print v(xbgr.mr_n79239840)
print v(xbgr.mr_n79240144)
print v(xbgr.mr_n79241296)
print v(xbgr.mr_n79241408)
print v(xbgr.mr_n79242560)
print v(xbgr.mr_n79242672)
print v(xbgr.mr_n79243824)
print v(xbgr.mr_n79243936)
print v(xbgr.mr_n79245264)
print v(xbgr.mr_n79247456)
print v(xbgr.mr_n79247568)
print v(xbgr.mr_n79248528)
print v(xbgr.mr_n79248640)
print v(xbgr.mr_n79251264)
print v(xbgr.mr_n79251376)
print v(xbgr.mr_n79252528)
print v(xbgr.mr_n79252640)
print v(xbgr.mr_n79253792)
print v(xbgr.mr_n79253904)
print v(xbgr.mr_n79255056)
print v(xbgr.mr_n79255168)
print v(xbgr.mr_n79256320)
print v(xbgr.mr_n79256432)
print v(xbgr.mr_n79257584)
print v(xbgr.mr_n79257696)
print v(xbgr.mr_n79258848)
print v(xbgr.mr_n79258960)
print v(xbgr.mr_n79260112)
print v(xbgr.mr_n79260224)
print v(xbgr.mr_n79261440)
print v(xbgr.mr_n79280368)
print v(xbgr.mr_n79285296)
print v(xbgr.mr_n79289584)
print v(xbgr.mr_n79289776)
print v(xbgr.mr_n79289968)
print v(xbgr.mr_n79290160)
print v(xbgr.mr_n79292480)
print v(xbgr.mr_n79292752)
print v(xbgr.mr_n79292944)
print v(xbgr.mr_n79293456)
print v(xbgr.mr_n79296768)
print v(xbgr.mr_n79299136)
print v(xbgr.mr_n79299408)
print v(xbgr.mr_n79299600)
print v(xbgr.mr_n79300112)
print v(xbgr.mr_n79302256)
print v(xbgr.mr_n79302368)
print v(xbgr.mr_n79302560)
print v(xbgr.mr_n79304112)
print v(xbgr.mr_n79304384)
print v(xbgr.mr_n79304576)
print v(xbgr.mr_n79305088)
print v(xbgr.mr_n79306320)
print v(xbgr.mr_n79306832)
print v(xbgr.mr_n79308896)
print v(xbgr.mr_n79310272)
print v(xbgr.mr_n79310544)
print v(xbgr.mr_n79310736)
print v(xbgr.mr_n79311248)
print v(xbgr.mr_n79313392)
print v(xbgr.mr_n79313504)
print v(xbgr.mr_n79315248)
print v(xbgr.mr_n79315520)
print v(xbgr.mr_n79315712)
print v(xbgr.mr_n79316224)
print v(xbgr.mr_n79317376)
print v(xbgr.mr_n79317968)
print v(xbgr.mr_n79320064)
print v(xbgr.mr_n79321408)
print v(xbgr.mr_n79321680)
print v(xbgr.mr_n79321872)
print v(xbgr.mr_n79322384)
print v(xbgr.mr_n79324528)
print v(xbgr.mr_n79324640)
print v(xbgr.mr_n79326384)
print v(xbgr.mr_n79326576)
print v(xbgr.mr_n79326768)
print v(xbgr.mr_n79327360)
print v(xbgr.mr_n79328592)
print v(xbgr.mr_n79329104)
print v(xbgr.mr_n79332544)
print v(xbgr.mr_n79332816)
print v(xbgr.mr_n79333008)
print v(xbgr.mr_n79333520)
print v(xbgr.mr_n79335664)
print v(xbgr.mr_n79335776)
print v(xbgr.mr_n79337520)
print v(xbgr.mr_n79337792)
print v(xbgr.mr_n79337984)
print v(xbgr.mr_n79338496)
print v(xbgr.mr_n79339728)
print v(xbgr.mr_n79340240)
print v(xbgr.mr_n79343680)
print v(xbgr.mr_n79343952)
print v(xbgr.mr_n79344144)
print v(xbgr.mr_n79344656)
print v(xbgr.mr_n79346800)
print v(xbgr.mr_n79346912)
print v(xbgr.mr_n79348656)
print v(xbgr.mr_n79348928)
print v(xbgr.mr_n79349120)
print v(xbgr.mr_n79349632)
print v(xbgr.mr_n79350864)
print v(xbgr.mr_n79351376)
print v(xbgr.mr_n79353504)
print v(xbgr.mr_n79353696)
print v(xbgr.mr_n79353888)
print v(xbgr.mr_n79356112)
print v(xbgr.mr_n79357248)
print v(xbgr.mr_n79360992)
print v(xbgr.mr_n79361104)
print v(xbgr.mr_n79361936)
print v(xbgr.mr_n79362048)
print v(xbgr.mr_n79362880)
print v(xbgr.mr_n79362992)
print v(xbgr.mr_n79364080)
print v(xbgr.mr_n79364192)
print v(xbgr.mr_n79365344)
print v(xbgr.mr_n79365456)
print v(xbgr.mr_n79366608)
print v(xbgr.mr_n79366720)
print v(xbgr.mr_n79367872)
print v(xbgr.mr_n79367984)
print v(xbgr.mr_n79369136)
print v(xbgr.mr_n79369248)
print v(xbgr.mr_n79370400)
print v(xbgr.mr_n79370512)
print v(xbgr.mr_n79371664)
print v(xbgr.mr_n79371776)
print v(xbgr.mr_n79372928)
print v(xbgr.mr_n79373040)
print v(xbgr.mr_n79374128)
print v(xbgr.mr_n79374240)
print v(xbgr.mr_n79375456)
print v(xbgr.mr_n79375568)
print v(xbgr.mr_n79376720)
print v(xbgr.mr_n79376832)
print v(xbgr.mr_n79377984)
print v(xbgr.mr_n79378096)
print v(xbgr.mr_n79383968)
print v(xbgr.mr_n79385760)
print v(xbgr.mr_n79388576)
print v(xbgr.mr_n79389264)
print v(xbgr.mr_n79389952)
print v(xbgr.mr_n79390640)
print v(xbgr.mr_n79391328)
print v(xbgr.mr_n79392432)
print v(xbgr.mr_n79394080)
print v(xbgr.mr_n79395024)
print v(xbgr.mr_n79395968)
print v(xbgr.mr_n79396912)
print v(xbgr.mr_n79397856)
print v(xbgr.mr_n79400272)
print v(xbgr.mr_n79400608)
print v(xbgr.mr_n79401792)
print v(xbgr.mr_n79402816)
print v(xbgr.mr_n79404384)
print v(xbgr.mr_n79405952)
print v(xbgr.mr_n79407520)
print v(xbgr.mr_n79409088)
print v(xbgr.mr_n79410656)
print v(xbgr.mr_n79412224)
print v(xbgr.mr_n79413728)
print v(xbgr.mr_n79418272)
print v(xbgr.mr_n79418960)
print v(xbgr.mr_n79419648)
print v(xbgr.mr_n79420400)
print v(xbgr.mr_n79422016)
print v(xbgr.mr_n79423296)
print v(xbgr.mr_n79423408)
print v(xbgr.mr_n79424352)
print v(xbgr.mr_n79425504)
print v(xbgr.mr_n79425616)
print v(xbgr.mr_n79426560)
print v(xbgr.mr_n79427712)
print v(xbgr.mr_n79427824)
print v(xbgr.mr_n79428768)
print v(xbgr.mr_n79429920)
print v(xbgr.mr_n79430032)
print v(xbgr.mr_n79430976)
print v(xbgr.mr_n79432128)
print v(xbgr.mr_n79432240)
print v(xbgr.mr_n79433184)
print v(xbgr.mr_n79434336)
print v(xbgr.mr_n79434448)
print v(xbgr.mr_n79435392)
print v(xbgr.mr_n79436544)
print v(xbgr.mr_n79436656)
print v(xbgr.mr_n79437600)
print v(xbgr.mr_n79438752)
print v(xbgr.mr_n79438864)
print v(xbgr.mr_n79439808)
print v(xbgr.mr_n79440960)
print v(xbgr.mr_n79441072)
print v(xbgr.mr_n79442016)
print v(xbgr.mr_n79443168)
print v(xbgr.mr_n79443280)
print v(xbgr.mr_n79444224)
print v(xbgr.mr_n79445376)
print v(xbgr.mr_n79445488)
print v(xbgr.mr_n79446432)
print v(xbgr.mr_n79447584)
print v(xbgr.mr_n79447696)
print v(xbgr.mr_n79448640)
print v(xbgr.mr_n79449792)
print v(xbgr.mr_n79449904)
print v(xbgr.mr_n79450848)
print v(xbgr.mr_n79452000)
print v(xbgr.mr_n79452112)
print v(xbgr.mr_n79453056)
print v(xbgr.mr_n79454208)
print v(xbgr.mr_n79454320)
print v(xbgr.mr_n79455264)
print v(xbgr.mr_n79456416)
print v(xbgr.mr_n79456528)
print v(xbgr.mr_n79457472)
print v(xbgr.mr_n79458624)
print v(xbgr.mr_n79458736)
print v(xbgr.mr_n79459616)
print v(xbgr.mr_n79460304)
print v(xbgr.mr_n79460992)
print v(xbgr.mr_n79461712)
print v(xbgr.mr_n79462656)
print v(xbgr.mr_n79463600)
print v(xbgr.mr_n79464544)
print v(xbgr.mr_n79465488)
print v(xbgr.mr_n79466432)
print v(xbgr.mr_n79467376)
print v(xbgr.mr_n79468320)
print v(xbgr.mr_n79475616)
print v(xbgr.mr_n79491440)
print v(xbgr.mr_n79492512)
print v(xbgr.mr_n79492704)
print v(xbgr.mr_n79492896)
print v(xbgr.mr_n79493088)
print v(xbgr.mr_n79495408)
print v(xbgr.mr_n79495680)
print v(xbgr.mr_n79495872)
print v(xbgr.mr_n79496384)
print v(xbgr.mr_n79501104)
print v(xbgr.mr_n79501376)
print v(xbgr.mr_n79501568)
print v(xbgr.mr_n79502080)
print v(xbgr.mr_n79504224)
print v(xbgr.mr_n79504336)
print v(xbgr.mr_n79506080)
print v(xbgr.mr_n79506352)
print v(xbgr.mr_n79506544)
print v(xbgr.mr_n79507056)
print v(xbgr.mr_n79508288)
print v(xbgr.mr_n79508800)
print v(xbgr.mr_n79512240)
print v(xbgr.mr_n79512512)
print v(xbgr.mr_n79512704)
print v(xbgr.mr_n79513216)
print v(xbgr.mr_n79515360)
print v(xbgr.mr_n79515472)
print v(xbgr.mr_n79516848)
print v(xbgr.mr_n79519376)
print v(xbgr.mr_n79519568)
print v(xbgr.mr_n79521312)
print v(xbgr.mr_n79521584)
print v(xbgr.mr_n79521776)
print v(xbgr.mr_n79522288)
print v(xbgr.mr_n79525648)
print v(xbgr.mr_n79525840)
print v(xbgr.mr_n79526032)
print v(xbgr.mr_n79527840)
print v(xbgr.mr_n79528032)
print v(xbgr.mr_n79528544)
print v(xbgr.mr_n79529776)
print v(xbgr.mr_n79530288)
print v(xbgr.mr_n79533664)
print v(xbgr.mr_n79533936)
print v(xbgr.mr_n79534128)
print v(xbgr.mr_n79534640)
print v(xbgr.mr_n79536784)
print v(xbgr.mr_n79536896)
print v(xbgr.mr_n79538640)
print v(xbgr.mr_n79538912)
print v(xbgr.mr_n79539104)
print v(xbgr.mr_n79539616)
print v(xbgr.mr_n79540848)
print v(xbgr.mr_n79541360)
print v(xbgr.mr_n79544800)
print v(xbgr.mr_n79545072)
print v(xbgr.mr_n79545264)
print v(xbgr.mr_n79545776)
print v(xbgr.mr_n79548080)
print v(xbgr.mr_n79548272)
print v(xbgr.mr_n79548464)
print v(xbgr.mr_n79548656)
print v(xbgr.mr_n79548848)
print v(xbgr.mr_n79551072)
print v(xbgr.mr_n79551984)
print v(xbgr.mr_n79552496)
print v(xbgr.mr_n79555936)
print v(xbgr.mr_n79556208)
print v(xbgr.mr_n79556400)
print v(xbgr.mr_n79556912)
print v(xbgr.mr_n79561856)
print v(xbgr.mr_n79561968)
print v(xbgr.mr_n79562800)
print v(xbgr.mr_n79562912)
print v(xbgr.mr_n79563744)
print v(xbgr.mr_n79563856)
print v(xbgr.mr_n79564944)
print v(xbgr.mr_n79565056)
print v(xbgr.mr_n79566208)
print v(xbgr.mr_n79566320)
print v(xbgr.mr_n79567472)
print v(xbgr.mr_n79567584)
print v(xbgr.mr_n79568736)
print v(xbgr.mr_n79568848)
print v(xbgr.mr_n79570000)
print v(xbgr.mr_n79570112)
print v(xbgr.mr_n79571264)
print v(xbgr.mr_n79571376)
print v(xbgr.mr_n79572528)
print v(xbgr.mr_n79572640)
print v(xbgr.mr_n79573792)
print v(xbgr.mr_n79573904)
print v(xbgr.mr_n79575056)
print v(xbgr.mr_n79575168)
print v(xbgr.mr_n79576320)
print v(xbgr.mr_n79576432)
print v(xbgr.mr_n79577584)
print v(xbgr.mr_n79577696)
print v(xbgr.mr_n79578848)
print v(xbgr.mr_n79578960)
print v(xbgr.mr_n79580496)
print v(xbgr.mr_n79580608)
print v(xbgr.mr_n79581760)
print v(xbgr.mr_n79581872)
print v(xbgr.mr_n79583024)
print v(xbgr.mr_n79583136)
print v(xbgr.mr_n79584288)
print v(xbgr.mr_n79584400)
print v(xbgr.mr_n79585552)
print v(xbgr.mr_n79585664)
print v(xbgr.mr_n79586816)
print v(xbgr.mr_n79586928)
print v(xbgr.mr_n79588080)
print v(xbgr.mr_n79588192)
print v(xbgr.mr_n79589344)
print v(xbgr.mr_n79589456)
print v(xbgr.mr_n79590608)
print v(xbgr.mr_n79590720)
print v(xbgr.mr_n79591872)
print v(xbgr.mr_n79591984)
print v(xbgr.mr_n79593136)
print v(xbgr.mr_n79593248)
print v(xbgr.mr_n79594400)
print v(xbgr.mr_n79594512)
print v(xbgr.mr_n79595664)
print v(xbgr.mr_n79595776)
print v(xbgr.mr_n79596928)
print v(xbgr.mr_n79597040)
print v(xbgr.mr_n79598192)
print v(xbgr.mr_n79598304)
print v(xbgr.mr_n79599456)
print v(xbgr.mr_n79599568)
print v(xbgr.mr_n79600720)
print v(xbgr.mr_n79600832)
print v(xbgr.mr_n79602608)
print v(xbgr.mr_n79613504)
print v(xbgr.mr_n79615808)
print v(xbgr.mr_n79622080)
print v(xbgr.mr_n79634032)
print v(xbgr.mr_n79635920)
print v(xbgr.mr_n79637520)
print v(xbgr.mr_n79638208)
print v(xbgr.mr_n79638896)
print v(xbgr.mr_n79639616)
print v(xbgr.mr_n79640560)
print v(xbgr.mr_n79641504)
print v(xbgr.mr_n79642448)
print v(xbgr.mr_n79643392)
print v(xbgr.mr_n79644336)
print v(xbgr.mr_n79645280)
print v(xbgr.mr_n79646224)
print v(xbgr.mr_n79647168)
print v(xbgr.mr_n79648112)
print v(xbgr.mr_n79649056)
print v(xbgr.mr_n79650000)
print v(xbgr.mr_n79653744)
print v(xbgr.mr_n79654992)
print v(xbgr.mr_n79656352)
print v(xbgr.mr_n79656960)
print v(xbgr.mr_n79658816)
print v(xbgr.mr_n79667664)
print v(xbgr.mr_n79667776)
print v(xbgr.mr_n79668608)
print v(xbgr.mr_n79668720)
print v(xbgr.mr_n79668832)
print v(xbgr.mr_n79668944)
print v(xbgr.mr_n79669056)
print v(xbgr.mr_n79670800)
print v(xbgr.mr_n79671072)
print v(xbgr.mr_n79671264)
print v(xbgr.mr_n79671776)
print v(xbgr.mr_n79672240)
print v(xbgr.mr_n79674368)
print v(xbgr.mr_n79674640)
print v(xbgr.mr_n79674832)
print v(xbgr.mr_n79675344)
print v(xbgr.mr_n79676832)
print v(xbgr.mr_n79678832)
print v(xbgr.mr_n79679104)
print v(xbgr.mr_n79679296)
print v(xbgr.mr_n79679808)
print v(xbgr.mr_n79681360)
print v(xbgr.mr_n79683616)
print v(xbgr.mr_n79683888)
print v(xbgr.mr_n79684080)
print v(xbgr.mr_n79684592)
print v(xbgr.mr_n79688080)
print v(xbgr.mr_n79688352)
print v(xbgr.mr_n79688544)
print v(xbgr.mr_n79689056)
print v(xbgr.mr_n79690608)
print v(xbgr.mr_n79692864)
print v(xbgr.mr_n79693136)
print v(xbgr.mr_n79693328)
print v(xbgr.mr_n79693840)
print v(xbgr.mr_n79697328)
print v(xbgr.mr_n79697600)
print v(xbgr.mr_n79697792)
print v(xbgr.mr_n79698304)
print v(xbgr.mr_n79700160)
print v(xbgr.mr_n79700352)
print v(xbgr.mr_n79700608)
print v(xbgr.mr_n79700864)
print v(xbgr.mr_n79703408)
print v(xbgr.mr_n79706576)
print v(xbgr.mr_n79706848)
print v(xbgr.mr_n79707040)
print v(xbgr.mr_n79707552)
print v(xbgr.mr_n79709104)
print v(xbgr.mr_n79711360)
print v(xbgr.mr_n79711632)
print v(xbgr.mr_n79711824)
print v(xbgr.mr_n79712336)
print v(xbgr.mr_n79715824)
print v(xbgr.mr_n79716096)
print v(xbgr.mr_n79716288)
print v(xbgr.mr_n79716800)
print v(xbgr.mr_n79719664)
print v(xbgr.mr_n79719936)
print v(xbgr.mr_n79720128)
print v(xbgr.mr_n79720640)
print v(xbgr.mr_n79722176)
print v(xbgr.mr_n79723504)
print v(xbgr.mr_n79723776)
print v(xbgr.mr_n79723968)
print v(xbgr.mr_n79724480)
print v(xbgr.mr_n79727840)
print v(xbgr.mr_n79727952)
print v(xbgr.mr_n79729696)
print v(xbgr.mr_n79729968)
print v(xbgr.mr_n79730160)
print v(xbgr.mr_n79730672)
print v(xbgr.mr_n79732816)
print v(xbgr.mr_n79732928)
print v(xbgr.mr_n79734672)
print v(xbgr.mr_n79734944)
print v(xbgr.mr_n79735136)
print v(xbgr.mr_n79735648)
print v(xbgr.mr_n79737792)
print v(xbgr.mr_n79737904)
print v(xbgr.mr_n79739648)
print v(xbgr.mr_n79739920)
print v(xbgr.mr_n79740112)
print v(xbgr.mr_n79740624)
print v(xbgr.mr_n79742768)
print v(xbgr.mr_n79742880)
print v(xbgr.mr_n79744624)
print v(xbgr.mr_n79744896)
print v(xbgr.mr_n79745088)
print v(xbgr.mr_n79745600)
print v(xbgr.mr_n79750768)
print v(xbgr.mr_n79752960)
print v(xbgr.mr_n79754528)
print v(xbgr.mr_n79755472)
print v(xbgr.mr_n79757664)
print v(xbgr.mr_n79759232)
print v(xbgr.mr_n79760176)
print v(xbgr.mr_n79762368)
print v(xbgr.mr_n79763984)
print v(xbgr.mr_n79764560)
print v(xbgr.mr_n79764672)
print v(xbgr.mr_n79765504)
print v(xbgr.mr_n79765616)
print v(xbgr.mr_n79766448)
print v(xbgr.mr_n79766560)
print v(xbgr.mr_n79767392)
print v(xbgr.mr_n79767504)
print v(xbgr.mr_n79768336)
print v(xbgr.mr_n79768448)
print v(xbgr.mr_n79769280)
print v(xbgr.mr_n79769392)
print v(xbgr.mr_n79770224)
print v(xbgr.mr_n79770336)
print v(xbgr.mr_n79771168)
print v(xbgr.mr_n79771280)
print v(xbgr.mr_n79772112)
print v(xbgr.mr_n79772224)
print v(xbgr.mr_n79773184)
print v(xbgr.mr_n79773296)
print v(xbgr.mr_n79775072)
print v(xbgr.mr_n79795360)
print v(xbgr.mr_n79795472)
print v(xbgr.mr_n79797920)
print v(xbgr.mr_n79798608)
print v(xbgr.mr_n79799296)
print v(xbgr.mr_n79799984)
print v(xbgr.mr_n79800672)
print v(xbgr.mr_n79802352)
print v(xbgr.mr_n79803296)
print v(xbgr.mr_n79804240)
print v(xbgr.mr_n79805184)
print v(xbgr.mr_n79806128)
print v(xbgr.mr_n79807072)
print v(xbgr.mr_n79808016)
print v(xbgr.mr_n79808960)
print v(xbgr.mr_n79809904)
print v(xbgr.mr_n79810848)
print v(xbgr.mr_n79811792)
print v(xbgr.mr_n79812736)
print v(xbgr.mr_n79813680)
print v(xbgr.mr_n79814624)
print v(xbgr.mr_n79814816)
print v(xbgr.mr_n79815008)
print v(xbgr.mr_n79815200)
print v(xbgr.mr_n79815392)
print v(xbgr.mr_n79815584)
print v(xbgr.mr_n79817728)
print v(xbgr.mr_n79817840)
print v(xbgr.mr_n79821152)
print v(xbgr.mr_n79821264)
print v(xbgr.mr_n79826144)
print v(xbgr.mr_n79827984)
print v(xbgr.mr_n79829824)
print v(xbgr.mr_n79831664)
print v(xbgr.mr_n79840256)
print v(xbgr.mr_n79840368)
print v(xbgr.mr_n79848832)
print v(xbgr.mr_n79850400)
print v(xbgr.mr_n79851968)
print v(xbgr.mr_n79853536)
print v(xbgr.mr_n79855104)
print v(xbgr.mr_n79856672)
print v(xbgr.mr_n79858240)
print v(xbgr.mr_n79859808)
print v(xbgr.mr_n79861376)
print v(xbgr.mr_n79862944)
print v(xbgr.mr_n79864512)
print v(xbgr.mr_n79866080)
print v(xbgr.mr_n79867648)
print v(xbgr.mr_n79869216)
print v(xbgr.mr_n79870784)
print v(xbgr.mr_n79872352)
print v(xbgr.mr_n79875600)
print v(xbgr.mr_n79875936)
print v(xbgr.mr_n79876048)
print v(xbgr.mr_n79876880)
print v(xbgr.mr_n79876992)
print v(xbgr.mr_n79877824)
print v(xbgr.mr_n79877936)
print v(xbgr.mr_n79878768)
print v(xbgr.mr_n79878880)
print v(xbgr.mr_n79882368)
print v(xbgr.mr_n79882880)
print v(xbgr.mr_n79882992)
print v(xbgr.mr_n79883104)
print v(xbgr.mr_n79883216)
print v(xbgr.mr_n79883328)
print v(xbgr.mr_n79884752)
print v(xbgr.mr_n79884944)
print v(xbgr.mr_n79885136)
print v(xbgr.mr_n79885728)
print v(xbgr.mr_n79887872)
print v(xbgr.mr_n79887984)
print v(xbgr.mr_n79889728)
print v(xbgr.mr_n79890000)
print v(xbgr.mr_n79890192)
print v(xbgr.mr_n79890704)
print v(xbgr.mr_n79892848)
print v(xbgr.mr_n79892960)
print v(xbgr.mr_n79894704)
print v(xbgr.mr_n79894976)
print v(xbgr.mr_n79895168)
print v(xbgr.mr_n79895680)
print v(xbgr.mr_n79897824)
print v(xbgr.mr_n79897936)
print v(xbgr.mr_n79899680)
print v(xbgr.mr_n79899952)
print v(xbgr.mr_n79900144)
print v(xbgr.mr_n79900656)
print v(xbgr.mr_n79902800)
print v(xbgr.mr_n79902912)
print v(xbgr.mr_n79904656)
print v(xbgr.mr_n79904928)
print v(xbgr.mr_n79905120)
print v(xbgr.mr_n79905632)
print v(xbgr.mr_n79907776)
print v(xbgr.mr_n79907888)
print v(xbgr.mr_n79909632)
print v(xbgr.mr_n79909904)
print v(xbgr.mr_n79910096)
print v(xbgr.mr_n79910608)
print v(xbgr.mr_n79912912)
print v(xbgr.mr_n79913104)
print v(xbgr.mr_n79913296)
print v(xbgr.mr_n79913488)
print v(xbgr.mr_n79913680)
print v(xbgr.mr_n79915904)
print v(xbgr.mr_n79917728)
print v(xbgr.mr_n79917840)
print v(xbgr.mr_n79919584)
print v(xbgr.mr_n79919856)
print v(xbgr.mr_n79920048)
print v(xbgr.mr_n79920560)
print v(xbgr.mr_n79921568)
print v(xbgr.mr_n79923456)
print v(xbgr.mr_n79926496)
print v(xbgr.mr_n79927184)
print v(xbgr.mr_n79927872)
print v(xbgr.mr_n79928560)
print v(xbgr.mr_n79929248)
print v(xbgr.mr_n79929936)
print v(xbgr.mr_n79930624)
print v(xbgr.mr_n79932432)
print v(xbgr.mr_n79933696)
print v(xbgr.mr_n79934640)
print v(xbgr.mr_n79935584)
print v(xbgr.mr_n79936528)
print v(xbgr.mr_n79937472)
print v(xbgr.mr_n79938416)
print v(xbgr.mr_n79939360)
print v(xbgr.mr_n79940304)
print v(xbgr.mr_n79941248)
print v(xbgr.mr_n79942192)
print v(xbgr.mr_n79943136)
print v(xbgr.mr_n79954624)
print v(xbgr.mr_n79955024)
print v(xbgr.mr_n79960080)
print v(xbgr.mr_n79961648)
print v(xbgr.mr_n79962688)
print v(xbgr.mr_n79962800)
print v(xbgr.mr_n79962912)
print v(xbgr.mr_n79964512)
print v(xbgr.mr_n79964624)
print v(xbgr.mr_n79968832)
print v(xbgr.mr_n79970048)
print v(xbgr.mr_n79970160)
print v(xbgr.mr_n79973904)
print v(xbgr.mr_n79975376)
print v(xbgr.mr_n79976944)
print v(xbgr.mr_n79978512)
print v(xbgr.mr_n79980080)
print v(xbgr.mr_n79984448)
print v(xbgr.mr_n79985056)
print v(xbgr.mr_n79986160)
print v(xbgr.mr_n79986432)
print v(xbgr.mr_n79988736)
print v(xbgr.mr_n79988928)
print v(xbgr.mr_n79989472)
print v(xbgr.mr_n79990304)
print v(xbgr.mr_n79990416)
print v(xbgr.mr_n79992576)
print v(xbgr.mr_n79994128)
print v(xbgr.mr_n79995248)
print v(xbgr.mr_n79995936)
print v(xbgr.mr_n79998832)
print v(xbgr.mr_n80000400)
print v(xbgr.mr_n80001344)
print v(xbgr.mr_n80008496)
print v(xbgr.mr_n80010112)
print v(xbgr.mr_n80010224)
print v(xbgr.mr_n80011376)
print v(xbgr.mr_n80011488)
print v(xbgr.mr_n80012640)
print v(xbgr.mr_n80012752)
print v(xbgr.mr_n80013904)
print v(xbgr.mr_n80014016)
print v(xbgr.mr_n80015104)
print v(xbgr.mr_n80015216)
print v(xbgr.mr_n80016432)
print v(xbgr.mr_n80016544)
print v(xbgr.mr_n80017696)
print v(xbgr.mr_n80017808)
print v(xbgr.mr_n80018896)
print v(xbgr.mr_n80019008)
print v(xbgr.mr_n80020224)
print v(xbgr.mr_n80020336)
print v(xbgr.mr_n80021488)
print v(xbgr.mr_n80021600)
print v(xbgr.mr_n80024656)
print v(xbgr.mr_n80027296)
print v(xbgr.mr_n80032224)
print v(xbgr.mr_n80039088)
print v(xbgr.mr_n80040128)
print v(xbgr.mr_n80040320)
print v(xbgr.mr_n80041104)
print v(xbgr.mr_n80041216)
print v(xbgr.mr_n80041408)
print v(xbgr.mr_n80041600)
print v(xbgr.mr_n80041792)
print v(xbgr.mr_n80044208)
print v(xbgr.mr_n80050048)
print v(xbgr.mr_n80050992)
print v(xbgr.mr_n80051936)
print v(xbgr.mr_n80052880)
print v(xbgr.mr_n80053824)
print v(xbgr.mr_n80054768)
print v(xbgr.mr_n80055712)
print v(xbgr.mr_n80056800)
print v(xbgr.mr_n80056912)
print v(xbgr.mr_n80057184)
print v(xbgr.mr_n80057456)
print v(xbgr.mr_n80058064)
print v(xbgr.mr_n80058944)
print v(xbgr.mr_n80061296)
print v(xbgr.mr_n80062240)
print v(xbgr.mr_n80063184)
print v(xbgr.mr_n80064128)
print v(xbgr.mr_n80065072)
print v(xbgr.mr_n80066016)
print v(xbgr.mr_n80066960)
print v(xbgr.mr_n80067904)
print v(xbgr.mr_n80068848)
print v(xbgr.mr_n80069792)
print v(xbgr.mr_n80070736)
print v(xbgr.mr_n80071680)
print v(xbgr.mr_n80072624)
print v(xbgr.mr_n80073568)
print v(xbgr.mr_n80074512)
print v(xbgr.mr_n80075456)
print v(xbgr.mr_n80079216)
print v(xbgr.mr_n80080160)
print v(xbgr.mr_n80081104)
print v(xbgr.mr_n80081296)
print v(xbgr.mr_n80081488)
print v(xbgr.mr_n80081680)
print v(xbgr.mr_n80081872)
print v(xbgr.mr_n80082064)
print v(xbgr.mr_n80084208)
print v(xbgr.mr_n80084320)
print v(xbgr.mr_n80087408)
print v(xbgr.mr_n80087520)
print v(xbgr.mr_n80093168)
print v(xbgr.mr_n80094112)
print v(xbgr.mr_n80095056)
print v(xbgr.mr_n80096000)
print v(xbgr.mr_n80096944)
print v(xbgr.mr_n80097888)
print v(xbgr.mr_n80098832)
print v(xbgr.mr_n80100720)
print v(xbgr.mr_n80101664)
print v(xbgr.mr_n80103792)
print v(xbgr.mr_n80104368)
print v(xbgr.mr_n80104480)
print v(xbgr.mr_n80105504)
print v(xbgr.mr_n80105696)
print v(xbgr.mr_n80105888)
print v(xbgr.mr_n80106080)
print v(xbgr.mr_n80106272)
print v(xbgr.mr_n80108528)
print v(xbgr.mr_n80108720)
print v(xbgr.mr_n80109232)
print v(xbgr.mr_n80109920)
print v(xbgr.mr_n80111776)
print v(xbgr.mr_n80114656)
print v(xbgr.mr_n80115488)
print v(xbgr.mr_n80115600)
print v(xbgr.mr_n80115712)
print v(xbgr.mr_n80115824)
print v(xbgr.mr_n80116016)
print v(xbgr.mr_n80116208)
print v(xbgr.mr_n80118016)
print v(xbgr.mr_n80118208)
print v(xbgr.mr_n80118720)
print v(xbgr.mr_n80120800)
print v(xbgr.mr_n80120912)
print v(xbgr.mr_n80122656)
print v(xbgr.mr_n80122928)
print v(xbgr.mr_n80123120)
print v(xbgr.mr_n80123632)
print v(xbgr.mr_n80125776)
print v(xbgr.mr_n80125888)
print v(xbgr.mr_n80127632)
print v(xbgr.mr_n80127824)
print v(xbgr.mr_n80128016)
print v(xbgr.mr_n80128608)
print v(xbgr.mr_n80130752)
print v(xbgr.mr_n80130864)
print v(xbgr.mr_n80131152)
print v(xbgr.mr_n80132608)
print v(xbgr.mr_n80132880)
print v(xbgr.mr_n80133072)
print v(xbgr.mr_n80133584)
print v(xbgr.mr_n80135728)
print v(xbgr.mr_n80135920)
print v(xbgr.mr_n80136112)
print v(xbgr.mr_n80137920)
print v(xbgr.mr_n80138112)
print v(xbgr.mr_n80138624)
print v(xbgr.mr_n80140704)
print v(xbgr.mr_n80142560)
print v(xbgr.mr_n80142832)
print v(xbgr.mr_n80143536)
print v(xbgr.mr_n80145680)
print v(xbgr.mr_n80145872)
print v(xbgr.mr_n80146064)
print v(xbgr.mr_n80147872)
print v(xbgr.mr_n80148064)
print v(xbgr.mr_n80148576)
print v(xbgr.mr_n80149648)
print v(xbgr.mr_n80150192)
print v(xbgr.mr_n80150736)
print v(xbgr.mr_n80151312)
print v(xbgr.mr_n80151776)
print v(xbgr.mr_n80157792)
print v(xbgr.mr_n80158464)
print v(xbgr.mr_n80158736)
print v(xbgr.mr_n80159696)
print v(xbgr.mr_n80159808)
print v(xbgr.mr_n80166208)
print v(xbgr.mr_n80166896)
print v(xbgr.mr_n80167584)
print v(xbgr.mr_n80168272)
print v(xbgr.mr_n80168960)
print v(xbgr.mr_n80169648)
print v(xbgr.mr_n80170336)
print v(xbgr.mr_n80171024)
print v(xbgr.mr_n80171712)
print v(xbgr.mr_n80172400)
print v(xbgr.mr_n80173088)
print v(xbgr.mr_n80173776)
print v(xbgr.mr_n80184576)
print v(xbgr.mr_n80186432)
print v(xbgr.mr_n80186544)
print v(xbgr.mr_n80189008)
print v(xbgr.mr_n80189120)
print v(xbgr.mr_n80190272)
print v(xbgr.mr_n80190384)
print v(xbgr.mr_n80191472)
print v(xbgr.mr_n80191584)
print v(xbgr.mr_n80191696)
print v(xbgr.mr_n80191808)
print v(xbgr.mr_n80192400)
print v(xbgr.mr_n80192512)
print v(xbgr.mr_n80193824)
print v(xbgr.mr_n80193936)
print v(xbgr.mr_n80195472)
print v(xbgr.mr_n80195584)
print v(xbgr.mr_n80197952)
print v(xbgr.mr_n80198064)
print v(xbgr.mr_n80199216)
print v(xbgr.mr_n80199328)
print v(xbgr.mr_n80200480)
print v(xbgr.mr_n80200592)
print v(xbgr.mr_n80201744)
print v(xbgr.mr_n80201856)
print v(xbgr.mr_n80203008)
print v(xbgr.mr_n80203120)
print v(xbgr.mr_n80204272)
print v(xbgr.mr_n80204384)
print v(xbgr.mr_n80205536)
print v(xbgr.mr_n80205648)
print v(xbgr.mr_n80206528)
print v(xbgr.mr_n80207056)
print v(xbgr.mr_n80209392)
print v(xbgr.mr_n80210512)
print v(xbgr.mr_n80211984)
print v(xbgr.mr_n80213552)
print v(xbgr.mr_n80215120)
print v(xbgr.mr_n80216688)
print v(xbgr.mr_n80218256)
print v(xbgr.mr_n80219824)
print v(xbgr.mr_n80221392)
print v(xbgr.mr_n80222960)
print v(xbgr.mr_n80224528)
print v(xbgr.mr_n80226096)
print v(xbgr.mr_n80228288)
print v(xbgr.mr_n80229856)
print v(xbgr.mr_n80231424)
print v(xbgr.mr_n80235072)
print v(xbgr.mr_n80243152)
print v(xbgr.mr_n80244224)
print v(xbgr.mr_n80244416)
print v(xbgr.mr_n80244608)
print v(xbgr.mr_n80244800)
print v(xbgr.mr_n80247120)
print v(xbgr.mr_n80247392)
print v(xbgr.mr_n80247584)
print v(xbgr.mr_n80248096)
print v(xbgr.mr_n80252816)
print v(xbgr.mr_n80253088)
print v(xbgr.mr_n80253280)
print v(xbgr.mr_n80253792)
print v(xbgr.mr_n80256528)
print v(xbgr.mr_n80256800)
print v(xbgr.mr_n80256992)
print v(xbgr.mr_n80257504)
print v(xbgr.mr_n80259648)
print v(xbgr.mr_n80259840)
print v(xbgr.mr_n80260032)
print v(xbgr.mr_n80261840)
print v(xbgr.mr_n80262032)
print v(xbgr.mr_n80262544)
print v(xbgr.mr_n80263712)
print v(xbgr.mr_n80264224)
print v(xbgr.mr_n80272016)
print v(xbgr.mr_n80272288)
print v(xbgr.mr_n80272480)
print v(xbgr.mr_n80272992)
print v(xbgr.mr_n80274352)
print v(xbgr.mr_n80274864)
print v(xbgr.mr_n80275296)
print v(xbgr.mr_n80276544)
print v(xbgr.mr_n80277056)
print v(xbgr.mr_n80279184)
print v(xbgr.mr_n80279696)
print v(xbgr.mr_n80280576)
print v(xbgr.mr_n80281696)
print v(xbgr.mr_n80282208)
print v(xbgr.mr_n80284272)
print v(xbgr.mr_n80284784)
print v(xbgr.mr_n80286848)
print v(xbgr.mr_n80287360)
print v(xbgr.mr_n80289424)
print v(xbgr.mr_n80289936)
print v(xbgr.mr_n80292000)
print v(xbgr.mr_n80292512)
print v(xbgr.mr_n80294576)
print v(xbgr.mr_n80295088)
print v(xbgr.mr_n80297152)
print v(xbgr.mr_n80297664)
print v(xbgr.mr_n80298560)
print v(xbgr.mr_n80299792)
print v(xbgr.mr_n80300304)
print v(xbgr.mr_n80300736)
print v(xbgr.mr_n80304176)
print v(xbgr.mr_n80308288)
print v(xbgr.mr_n80308400)
print v(xbgr.mr_n80309552)
print v(xbgr.mr_n80309664)
print v(xbgr.mr_n80310816)
print v(xbgr.mr_n80310928)
print v(xbgr.mr_n80312080)
print v(xbgr.mr_n80312192)
print v(xbgr.mr_n80313344)
print v(xbgr.mr_n80313456)
print v(xbgr.mr_n80314608)
print v(xbgr.mr_n80314720)
print v(xbgr.mr_n80315872)
print v(xbgr.mr_n80315984)
print v(xbgr.mr_n80317136)
print v(xbgr.mr_n80317248)
print v(xbgr.mr_n80318400)
print v(xbgr.mr_n80318512)
print v(xbgr.mr_n80319664)
print v(xbgr.mr_n80319776)
print v(xbgr.mr_n80320928)
print v(xbgr.mr_n80321040)
print v(xbgr.mr_n80322192)
print v(xbgr.mr_n80322304)
print v(xbgr.mr_n80323456)
print v(xbgr.mr_n80323568)
print v(xbgr.mr_n80324720)
print v(xbgr.mr_n80324832)
print v(xbgr.mr_n80325328)
print v(xbgr.mr_n80325584)
print v(xbgr.mr_n80327216)
print v(xbgr.mr_n80336384)
print v(xbgr.mr_n80337104)
print v(xbgr.mr_n80338576)
print v(xbgr.mr_n80340176)
print v(xbgr.mr_n80340864)
print v(xbgr.mr_n80341552)
print v(xbgr.mr_n80343456)
print v(xbgr.mr_n80344400)
print v(xbgr.mr_n80345344)
print v(xbgr.mr_n80346288)
print v(xbgr.mr_n80347232)
print v(xbgr.mr_n80348176)
print v(xbgr.mr_n80349120)
print v(xbgr.mr_n80350064)
print v(xbgr.mr_n80351008)
print v(xbgr.mr_n80351952)
print v(xbgr.mr_n80352896)
print v(xbgr.mr_n80353840)
print v(xbgr.mr_n80354784)
print v(xbgr.mr_n80355728)
print v(xbgr.mr_n80356672)
print v(xbgr.mr_n80357616)
print v(xbgr.mr_n80362608)
print v(xbgr.mr_n80363936)
print v(xbgr.mr_n80365504)
print v(xbgr.mr_n80367056)
print v(xbgr.mr_n80368848)
print v(xbgr.mr_n80370080)
print v(xbgr.mr_n80370192)
print v(xbgr.mr_n80371136)
print v(xbgr.mr_n80372288)
print v(xbgr.mr_n80372400)
print v(xbgr.mr_n80374176)
print v(xbgr.mr_n80374288)
print v(xbgr.mr_n80375232)
print v(xbgr.mr_n80376384)
print v(xbgr.mr_n80376496)
print v(xbgr.mr_n80378272)
print v(xbgr.mr_n80378384)
print v(xbgr.mr_n80379328)
print v(xbgr.mr_n80380480)
print v(xbgr.mr_n80380592)
print v(xbgr.mr_n80381760)
print v(xbgr.mr_n80382368)
print v(xbgr.mr_n80382480)
print v(xbgr.mr_n80383424)
print v(xbgr.mr_n80384576)
print v(xbgr.mr_n80384688)
print v(xbgr.mr_n80385936)
print v(xbgr.mr_n80386464)
print v(xbgr.mr_n80386576)
print v(xbgr.mr_n80387520)
print v(xbgr.mr_n80388672)
print v(xbgr.mr_n80388784)
print v(xbgr.mr_n80389952)
print v(xbgr.mr_n80390560)
print v(xbgr.mr_n80390672)
print v(xbgr.mr_n80391616)
print v(xbgr.mr_n80392768)
print v(xbgr.mr_n80392880)
print v(xbgr.mr_n80394048)
print v(xbgr.mr_n80394656)
print v(xbgr.mr_n80394768)
print v(xbgr.mr_n80395712)
print v(xbgr.mr_n80396864)
print v(xbgr.mr_n80396976)
print v(xbgr.mr_n80398752)
print v(xbgr.mr_n80398864)
print v(xbgr.mr_n80399808)
print v(xbgr.mr_n80400960)
print v(xbgr.mr_n80401072)
print v(xbgr.mr_n80402240)
print v(xbgr.mr_n80402848)
print v(xbgr.mr_n80402960)
print v(xbgr.mr_n80404272)
print v(xbgr.mr_n80405376)
print v(xbgr.mr_n80407472)
print v(xbgr.mr_n80409040)
print v(xbgr.mr_n80410608)
print v(xbgr.mr_n80412176)
print v(xbgr.mr_n80413744)
print v(xbgr.mr_n80415312)
print v(xbgr.mr_n80416880)
print v(xbgr.mr_n80421184)
print v(xbgr.mr_n80422048)
print v(xbgr.mr_n80425568)
print v(xbgr.mr_n80426928)
print v(xbgr.mr_n80433056)
print v(xbgr.mr_n80435072)
print v(xbgr.mr_n80435744)
print v(xbgr.mr_n80437008)
print v(xbgr.mr_n80437200)
print v(xbgr.mr_n80437392)
print v(xbgr.mr_n80437584)
print v(xbgr.mr_n80437920)
print v(xbgr.mr_n80439904)
print v(xbgr.mr_n80440176)
print v(xbgr.mr_n80440368)
print v(xbgr.mr_n80440880)
print v(xbgr.mr_n80443840)
print v(xbgr.mr_n80446560)
print v(xbgr.mr_n80446752)
print v(xbgr.mr_n80446944)
print v(xbgr.mr_n80447536)
print v(xbgr.mr_n80450272)
print v(xbgr.mr_n80450544)
print v(xbgr.mr_n80450736)
print v(xbgr.mr_n80451248)
print v(xbgr.mr_n80453392)
print v(xbgr.mr_n80453504)
print v(xbgr.mr_n80455248)
print v(xbgr.mr_n80455520)
print v(xbgr.mr_n80455712)
print v(xbgr.mr_n80456224)
print v(xbgr.mr_n80457456)
print v(xbgr.mr_n80457968)
print v(xbgr.mr_n80458384)
print v(xbgr.mr_n80461408)
print v(xbgr.mr_n80462160)
print v(xbgr.mr_n80462864)
print v(xbgr.mr_n80462976)
print v(xbgr.mr_n80463168)
print v(xbgr.mr_n80463360)
print v(xbgr.mr_n80463552)
print v(xbgr.mr_n80465040)
print v(xbgr.mr_n80465312)
print v(xbgr.mr_n80465504)
print v(xbgr.mr_n80466016)
print v(xbgr.mr_n80467792)
print v(xbgr.mr_n80469744)
print v(xbgr.mr_n80471552)
print v(xbgr.mr_n80471744)
print v(xbgr.mr_n80472256)
print v(xbgr.mr_n80475008)
print v(xbgr.mr_n80475120)
print v(xbgr.mr_n80476864)
print v(xbgr.mr_n80477136)
print v(xbgr.mr_n80477328)
print v(xbgr.mr_n80477840)
print v(xbgr.mr_n80479072)
print v(xbgr.mr_n80479584)
print v(xbgr.mr_n80483024)
print v(xbgr.mr_n80483296)
print v(xbgr.mr_n80483488)
print v(xbgr.mr_n80484000)
print v(xbgr.mr_n80486144)
print v(xbgr.mr_n80486256)
print v(xbgr.mr_n80488000)
print v(xbgr.mr_n80488272)
print v(xbgr.mr_n80488464)
print v(xbgr.mr_n80488976)
print v(xbgr.mr_n80490208)
print v(xbgr.mr_n80490720)
print v(xbgr.mr_n80492688)
print v(xbgr.mr_n80494496)
print v(xbgr.mr_n80494688)
print v(xbgr.mr_n80495200)
print v(xbgr.mr_n80497280)
print v(xbgr.mr_n80497472)
print v(xbgr.mr_n80497664)
print v(xbgr.mr_n80499472)
print v(xbgr.mr_n80499664)
print v(xbgr.mr_n80500176)
print v(xbgr.mr_n80501344)
print v(xbgr.mr_n80501856)
print v(xbgr.mr_n80508912)
print v(xbgr.mr_n80509024)
print v(xbgr.mr_n80509792)
print v(xbgr.mr_n80509904)
print v(xbgr.mr_n80510800)
print v(xbgr.mr_n80510912)
print v(xbgr.mr_n80511936)
print v(xbgr.mr_n80512048)
print v(xbgr.mr_n80513264)
print v(xbgr.mr_n80513376)
print v(xbgr.mr_n80514528)
print v(xbgr.mr_n80514640)
print v(xbgr.mr_n80515792)
print v(xbgr.mr_n80515904)
print v(xbgr.mr_n80517056)
print v(xbgr.mr_n80517168)
print v(xbgr.mr_n80518320)
print v(xbgr.mr_n80518432)
print v(xbgr.mr_n80519584)
print v(xbgr.mr_n80519696)
print v(xbgr.mr_n80520848)
print v(xbgr.mr_n80520960)
print v(xbgr.mr_n80522048)
print v(xbgr.mr_n80522160)
print v(xbgr.mr_n80523376)
print v(xbgr.mr_n80523488)
print v(xbgr.mr_n80524576)
print v(xbgr.mr_n80524688)
print v(xbgr.mr_n80525904)
print v(xbgr.mr_n80526016)
print v(xbgr.mr_n80526512)
print v(xbgr.mr_n80526976)
print v(xbgr.mr_n80527920)
print v(xbgr.mr_n80528304)
print v(xbgr.mr_n80529152)
print v(xbgr.mr_n80532528)
print v(xbgr.mr_n80533216)
print v(xbgr.mr_n80533904)
print v(xbgr.mr_n80534624)
print v(xbgr.mr_n80535568)
print v(xbgr.mr_n80536512)
print v(xbgr.mr_n80537456)
print v(xbgr.mr_n80538400)
print v(xbgr.mr_n80539344)
print v(xbgr.mr_n80540288)
print v(xbgr.mr_n80541232)
print v(xbgr.mr_n80542176)
print v(xbgr.mr_n80543120)
print v(xbgr.mr_n80544064)
print v(xbgr.mr_n80545008)
print v(xbgr.mr_n80545952)
print v(xbgr.mr_n80546896)
print v(xbgr.mr_n80547840)
print v(xbgr.mr_n80548784)
print v(xbgr.mr_n80561376)
print v(xbgr.mr_n80562912)
print v(xbgr.mr_n80563632)
print v(xbgr.mr_n80564320)
print v(xbgr.mr_n80565888)
print v(xbgr.mr_n80568368)
print v(xbgr.mr_n80569344)
print v(xbgr.mr_n80569456)
print v(xbgr.mr_n80570400)
print v(xbgr.mr_n80571616)
print v(xbgr.mr_n80571728)
print v(xbgr.mr_n80572976)
print v(xbgr.mr_n80573504)
print v(xbgr.mr_n80573616)
print v(xbgr.mr_n80574560)
print v(xbgr.mr_n80575648)
print v(xbgr.mr_n80575760)
print v(xbgr.mr_n80577072)
print v(xbgr.mr_n80577600)
print v(xbgr.mr_n80577712)
print v(xbgr.mr_n80578656)
print v(xbgr.mr_n80579808)
print v(xbgr.mr_n80579920)
print v(xbgr.mr_n80581696)
print v(xbgr.mr_n80581808)
print v(xbgr.mr_n80582752)
print v(xbgr.mr_n80583904)
print v(xbgr.mr_n80584016)
print v(xbgr.mr_n80585184)
print v(xbgr.mr_n80585792)
print v(xbgr.mr_n80585904)
print v(xbgr.mr_n80586848)
print v(xbgr.mr_n80588000)
print v(xbgr.mr_n80588112)
print v(xbgr.mr_n80589824)
print v(xbgr.mr_n80589936)
print v(xbgr.mr_n80590880)
print v(xbgr.mr_n80592096)
print v(xbgr.mr_n80592208)
print v(xbgr.mr_n80593984)
print v(xbgr.mr_n80594096)
print v(xbgr.mr_n80595040)
print v(xbgr.mr_n80596192)
print v(xbgr.mr_n80596304)
print v(xbgr.mr_n80597056)
print v(xbgr.mr_n80597168)
print v(xbgr.mr_n80597856)
print v(xbgr.mr_n80597968)
print v(xbgr.mr_n80599440)
print v(xbgr.mr_n80600976)
print v(xbgr.mr_n80602848)
print v(xbgr.mr_n80603808)
print v(xbgr.mr_n80605376)
print v(xbgr.mr_n80606944)
print v(xbgr.mr_n80608512)
print v(xbgr.mr_n80610080)
print v(xbgr.mr_n80611648)
print v(xbgr.mr_n80613216)
print v(xbgr.mr_n80613968)
print v(xbgr.mr_n80619344)
print v(xbgr.mr_n80625552)
print v(xbgr.mr_n80627232)
print v(xbgr.mr_n80628304)
print v(xbgr.mr_n80629248)
print v(xbgr.mr_n80630416)
print v(xbgr.mr_n80634160)
print v(xbgr.mr_n80635952)
print v(xbgr.mr_n80636688)
print v(xbgr.mr_n80637808)
print v(xbgr.mr_n80638896)
print v(xbgr.mr_n80639088)
print v(xbgr.mr_n80639920)
print v(xbgr.mr_n80640352)
print v(xbgr.mr_n80641184)
print v(xbgr.mr_n80641760)
print v(xbgr.mr_n80642448)
print v(xbgr.mr_n80643024)
print v(xbgr.mr_n80643712)
print v(xbgr.mr_n80644288)
print v(xbgr.mr_n80644976)
print v(xbgr.mr_n80645680)
print v(xbgr.mr_n80646240)
print v(xbgr.mr_n80646816)
print v(xbgr.mr_n80647504)
print v(xbgr.mr_n80647936)
print v(xbgr.mr_n80648768)
print v(xbgr.mr_n80649200)
print v(xbgr.mr_n80650032)
print v(xbgr.mr_n80650464)
print v(xbgr.mr_n80651296)
print v(xbgr.mr_n80651872)
print v(xbgr.mr_n80652560)
print v(xbgr.mr_n80653136)
print v(xbgr.mr_n80653824)
print v(xbgr.mr_n80654400)
print v(xbgr.mr_n80655088)
print v(xbgr.mr_n80655792)
print v(xbgr.mr_n80656352)
print v(xbgr.mr_n80656928)
print v(xbgr.mr_n80657616)
print v(xbgr.mr_n80658048)
print v(xbgr.mr_n80658880)
print v(xbgr.mr_n80659312)
print v(xbgr.mr_n80660144)
print v(xbgr.mr_n80662176)
print v(xbgr.mr_n80663648)
print v(xbgr.mr_n80663760)
print v(xbgr.mr_n80663872)
print v(xbgr.mr_n80663984)
print v(xbgr.mr_n80666304)
print v(xbgr.mr_n80666576)
print v(xbgr.mr_n80666768)
print v(xbgr.mr_n80667280)
print v(xbgr.mr_n80668512)
print v(xbgr.mr_n80669024)
print v(xbgr.mr_n80669792)
print v(xbgr.mr_n80670576)
print v(xbgr.mr_n80671088)
print v(xbgr.mr_n80673024)
print v(xbgr.mr_n80673536)
print v(xbgr.mr_n80675472)
print v(xbgr.mr_n80675984)
print v(xbgr.mr_n80677136)
print v(xbgr.mr_n80677920)
print v(xbgr.mr_n80678432)
print v(xbgr.mr_n80680368)
print v(xbgr.mr_n80680880)
print v(xbgr.mr_n80682816)
print v(xbgr.mr_n80683328)
print v(xbgr.mr_n80685328)
print v(xbgr.mr_n80685840)
print v(xbgr.mr_n80687712)
print v(xbgr.mr_n80688224)
print v(xbgr.mr_n80690080)
print v(xbgr.mr_n80690672)
print v(xbgr.mr_n80692608)
print v(xbgr.mr_n80693120)
print v(xbgr.mr_n80695056)
print v(xbgr.mr_n80695568)
print v(xbgr.mr_n80697504)
print v(xbgr.mr_n80698016)
print v(xbgr.mr_n80699952)
print v(xbgr.mr_n80700464)
print v(xbgr.mr_n80702400)
print v(xbgr.mr_n80702912)
print v(xbgr.mr_n80704848)
print v(xbgr.mr_n80705360)
print v(xbgr.mr_n80713280)
print v(xbgr.mr_n80714432)
print v(xbgr.mr_n80714544)
print v(xbgr.mr_n80715696)
print v(xbgr.mr_n80715808)
print v(xbgr.mr_n80716112)
print v(xbgr.mr_n80716960)
print v(xbgr.mr_n80717072)
print v(xbgr.mr_n80718224)
print v(xbgr.mr_n80718336)
print v(xbgr.mr_n80719488)
print v(xbgr.mr_n80719600)
print v(xbgr.mr_n80720752)
print v(xbgr.mr_n80720864)
print v(xbgr.mr_n80722016)
print v(xbgr.mr_n80722128)
print v(xbgr.mr_n80723280)
print v(xbgr.mr_n80723392)
print v(xbgr.mr_n80724544)
print v(xbgr.mr_n80724656)
print v(xbgr.mr_n80725808)
print v(xbgr.mr_n80725920)
print v(xbgr.mr_n80727072)
print v(xbgr.mr_n80727184)
print v(xbgr.mr_n80728336)
print v(xbgr.mr_n80728448)
print v(xbgr.mr_n80729600)
print v(xbgr.mr_n80729712)
print v(xbgr.mr_n80729824)
print v(xbgr.mr_n80730864)
print v(xbgr.mr_n80730976)
print v(xbgr.mr_n80732128)
print v(xbgr.mr_n80732240)
print v(xbgr.mr_n80732352)
print v(xbgr.mr_n80732464)
print v(xbgr.mr_n80732576)
print v(xbgr.mr_n80732896)
print v(xbgr.mr_n80734144)
print v(xbgr.mr_n80734832)
print v(xbgr.mr_n80736800)
print v(xbgr.mr_n80738288)
print v(xbgr.mr_n80739232)
print v(xbgr.mr_n80740176)
print v(xbgr.mr_n80750944)
print v(xbgr.mr_n80752752)
print v(xbgr.mr_n80758800)
print v(xbgr.mr_n80761392)
print v(xbgr.mr_n80763808)
print v(xbgr.mr_n80765376)
print v(xbgr.mr_n80768496)
print v(xbgr.mr_n80768992)
print v(xbgr.mr_n80769728)
print v(xbgr.mr_n80769840)
print v(xbgr.mr_n80770784)
print v(xbgr.mr_n80771936)
print v(xbgr.mr_n80772048)
print v(xbgr.mr_n80773296)
print v(xbgr.mr_n80773824)
print v(xbgr.mr_n80773936)
print v(xbgr.mr_n80774880)
print v(xbgr.mr_n80776032)
print v(xbgr.mr_n80776144)
print v(xbgr.mr_n80777920)
print v(xbgr.mr_n80778032)
print v(xbgr.mr_n80778976)
print v(xbgr.mr_n80780064)
print v(xbgr.mr_n80780176)
print v(xbgr.mr_n80782016)
print v(xbgr.mr_n80782128)
print v(xbgr.mr_n80783072)
print v(xbgr.mr_n80784224)
print v(xbgr.mr_n80784336)
print v(xbgr.mr_n80786112)
print v(xbgr.mr_n80786224)
print v(xbgr.mr_n80787168)
print v(xbgr.mr_n80788320)
print v(xbgr.mr_n80788432)
print v(xbgr.mr_n80790208)
print v(xbgr.mr_n80790320)
print v(xbgr.mr_n80791264)
print v(xbgr.mr_n80792416)
print v(xbgr.mr_n80792528)
print v(xbgr.mr_n80794240)
print v(xbgr.mr_n80794352)
print v(xbgr.mr_n80795296)
print v(xbgr.mr_n80796512)
print v(xbgr.mr_n80796624)
print v(xbgr.mr_n80797872)
print v(xbgr.mr_n80798400)
print v(xbgr.mr_n80798512)
print v(xbgr.mr_n80799456)
print v(xbgr.mr_n80800608)
print v(xbgr.mr_n80800720)
print v(xbgr.mr_n80801888)
print v(xbgr.mr_n80802496)
print v(xbgr.mr_n80802608)
print v(xbgr.mr_n80803920)
print v(xbgr.mr_n80805040)
print v(xbgr.mr_n80807136)
print v(xbgr.mr_n80808704)
print v(xbgr.mr_n80810272)
print v(xbgr.mr_n80811840)
print v(xbgr.mr_n80813408)
print v(xbgr.mr_n80814976)
print v(xbgr.mr_n80816544)
print v(xbgr.mr_n80817424)
print v(xbgr.mr_n80822672)
print v(xbgr.mr_n80825232)
print v(xbgr.mr_n80827408)
print v(xbgr.mr_n80829456)
print v(xbgr.mr_n80830736)
print v(xbgr.mr_n80834288)
print v(xbgr.mr_n80836144)
print v(xbgr.mr_n80836256)
print v(xbgr.mr_n80837200)
print v(xbgr.mr_n80837392)
print v(xbgr.mr_n80837584)
print v(xbgr.mr_n80837776)
print v(xbgr.mr_n80840032)
print v(xbgr.mr_n80840304)
print v(xbgr.mr_n80840496)
print v(xbgr.mr_n80841008)
print v(xbgr.mr_n80842048)
print v(xbgr.mr_n80845136)
print v(xbgr.mr_n80845248)
print v(xbgr.mr_n80846992)
print v(xbgr.mr_n80847264)
print v(xbgr.mr_n80847456)
print v(xbgr.mr_n80847968)
print v(xbgr.mr_n80850112)
print v(xbgr.mr_n80850224)
print v(xbgr.mr_n80851968)
print v(xbgr.mr_n80852160)
print v(xbgr.mr_n80852352)
print v(xbgr.mr_n80852944)
print v(xbgr.mr_n80855088)
print v(xbgr.mr_n80855200)
print v(xbgr.mr_n80855392)
print v(xbgr.mr_n80856944)
print v(xbgr.mr_n80857216)
print v(xbgr.mr_n80857408)
print v(xbgr.mr_n80857920)
print v(xbgr.mr_n80860064)
print v(xbgr.mr_n80860176)
print v(xbgr.mr_n80861920)
print v(xbgr.mr_n80862192)
print v(xbgr.mr_n80862384)
print v(xbgr.mr_n80862896)
print v(xbgr.mr_n80865040)
print v(xbgr.mr_n80865152)
print v(xbgr.mr_n80866896)
print v(xbgr.mr_n80867168)
print v(xbgr.mr_n80867536)
print v(xbgr.mr_n80868848)
print v(xbgr.mr_n80869040)
print v(xbgr.mr_n80871280)
print v(xbgr.mr_n80871392)
print v(xbgr.mr_n80871504)
print v(xbgr.mr_n80871616)
print v(xbgr.mr_n80873360)
print v(xbgr.mr_n80873632)
print v(xbgr.mr_n80873824)
print v(xbgr.mr_n80874336)
print v(xbgr.mr_n80878048)
print v(xbgr.mr_n80878160)
print v(xbgr.mr_n80879904)
print v(xbgr.mr_n80880176)
print v(xbgr.mr_n80880368)
print v(xbgr.mr_n80880880)
print v(xbgr.mr_n80883024)
print v(xbgr.mr_n80883136)
print v(xbgr.mr_n80884880)
print v(xbgr.mr_n80885152)
print v(xbgr.mr_n80885344)
print v(xbgr.mr_n80885856)
print v(xbgr.mr_n80888000)
print v(xbgr.mr_n80888112)
print v(xbgr.mr_n80889856)
print v(xbgr.mr_n80890128)
print v(xbgr.mr_n80890320)
print v(xbgr.mr_n80890832)
print v(xbgr.mr_n80892976)
print v(xbgr.mr_n80893088)
print v(xbgr.mr_n80894832)
print v(xbgr.mr_n80895104)
print v(xbgr.mr_n80895296)
print v(xbgr.mr_n80895808)
print v(xbgr.mr_n80897952)
print v(xbgr.mr_n80898144)
print v(xbgr.mr_n80898336)
print v(xbgr.mr_n80900144)
print v(xbgr.mr_n80900336)
print v(xbgr.mr_n80900848)
print v(xbgr.mr_n80902928)
print v(xbgr.mr_n80903040)
print v(xbgr.mr_n80904784)
print v(xbgr.mr_n80905056)
print v(xbgr.mr_n80905248)
print v(xbgr.mr_n80905760)
print v(xbgr.mr_n80907904)
print v(xbgr.mr_n80908016)
print v(xbgr.mr_n80909760)
print v(xbgr.mr_n80910032)
print v(xbgr.mr_n80910224)
print v(xbgr.mr_n80910736)
print v(xbgr.mr_n80912880)
print v(xbgr.mr_n80912992)
print v(xbgr.mr_n80914736)
print v(xbgr.mr_n80915008)
print v(xbgr.mr_n80915200)
print v(xbgr.mr_n80915712)
print v(xbgr.mr_n80917856)
print v(xbgr.mr_n80917968)
print v(xbgr.mr_n80918304)
print v(xbgr.mr_n80919712)
print v(xbgr.mr_n80919984)
print v(xbgr.mr_n80920176)
print v(xbgr.mr_n80920688)
print v(xbgr.mr_n80923344)
print v(xbgr.mr_n80929168)
print v(xbgr.mr_n80929728)
print v(xbgr.mr_n80938368)
print v(xbgr.mr_n80938656)
print v(xbgr.mr_n80940896)
print v(xbgr.mr_n80943360)
print v(xbgr.mr_n80944192)
print v(xbgr.mr_n80952352)
print v(xbgr.mr_n80954528)
print v(xbgr.mr_n80956032)
print v(xbgr.mr_n80958368)
print v(xbgr.mr_n80958480)
print v(xbgr.mr_n80959632)
print v(xbgr.mr_n80959744)
print v(xbgr.mr_n80960896)
print v(xbgr.mr_n80961008)
print v(xbgr.mr_n80962160)
print v(xbgr.mr_n80962272)
print v(xbgr.mr_n80963360)
print v(xbgr.mr_n80963472)
print v(xbgr.mr_n80964688)
print v(xbgr.mr_n80964800)
print v(xbgr.mr_n80965952)
print v(xbgr.mr_n80966064)
print v(xbgr.mr_n80967152)
print v(xbgr.mr_n80967264)
print v(xbgr.mr_n80968480)
print v(xbgr.mr_n80968592)
print v(xbgr.mr_n80969744)
print v(xbgr.mr_n80969856)
print v(xbgr.mr_n80970944)
print v(xbgr.mr_n80971056)
print v(xbgr.mr_n80972272)
print v(xbgr.mr_n80972384)
print v(xbgr.mr_n80973536)
print v(xbgr.mr_n80973648)
print v(xbgr.mr_n80974800)
print v(xbgr.mr_n80974912)
print v(xbgr.mr_n80976064)
print v(xbgr.mr_n80976176)
print v(xbgr.mr_n80977840)
print v(xbgr.mr_n80983776)
print v(xbgr.mr_n80986336)
print v(xbgr.mr_n80987024)
print v(xbgr.mr_n80987712)
print v(xbgr.mr_n80988432)
print v(xbgr.mr_n80989376)
print v(xbgr.mr_n80990320)
print v(xbgr.mr_n80991264)
print v(xbgr.mr_n80992208)
print v(xbgr.mr_n80993152)
print v(xbgr.mr_n80994096)
print v(xbgr.mr_n80995040)
print v(xbgr.mr_n80995984)
print v(xbgr.mr_n80996928)
print v(xbgr.mr_n80997872)
print v(xbgr.mr_n80998816)
print v(xbgr.mr_n80999760)
print v(xbgr.mr_n81000704)
print v(xbgr.mr_n81001648)
print v(xbgr.mr_n81002864)
print v(xbgr.mr_n81002976)
print v(xbgr.mr_n81003248)
print v(xbgr.mr_n81003520)
print v(xbgr.mr_n81004128)
print v(xbgr.mr_n81005424)
print v(xbgr.mr_n81007232)
print v(xbgr.mr_n81008176)
print v(xbgr.mr_n81009120)
print v(xbgr.mr_n81010320)
print v(xbgr.mr_n81014992)
print v(xbgr.mr_n81017024)
print v(xbgr.mr_n81019728)
print v(xbgr.mr_n81024704)
print v(xbgr.mr_n81025760)
print v(xbgr.mr_n81026816)
print v(xbgr.mr_n81027088)
print v(xbgr.mr_n81027488)
print v(xbgr.mr_n81029040)
print v(xbgr.mr_n81029392)
print v(xbgr.mr_n81029920)
print v(xbgr.mr_n81032032)
print v(xbgr.mr_n81033264)
print v(xbgr.mr_n81034320)
print v(xbgr.mr_n81034496)
print v(xbgr.mr_n81035440)
print v(xbgr.mr_n81036080)
print v(xbgr.mr_n81036320)
print v(xbgr.mr_n81036432)
print v(xbgr.mr_n81037312)
print v(xbgr.mr_n81037840)
print v(xbgr.mr_n81039072)
print v(xbgr.mr_n81039840)
print v(xbgr.mr_n81039952)
print v(xbgr.mr_n81040896)
print v(xbgr.mr_n81041072)
print v(xbgr.mr_n81043296)
print v(xbgr.mr_n81043472)
print v(xbgr.mr_n81046112)
print v(xbgr.mr_n81046704)
print v(xbgr.mr_n81047344)
print v(xbgr.mr_n81047520)
print v(xbgr.mr_n81049456)
print v(xbgr.mr_n81050688)
print v(xbgr.mr_n81050928)
print v(xbgr.mr_n81051280)
print v(xbgr.mr_n81052464)
print v(xbgr.mr_n81052816)
print v(xbgr.mr_n81053776)
print v(xbgr.mr_n81055008)
print v(xbgr.mr_n81055776)
print v(xbgr.mr_n81056720)
print v(xbgr.mr_n81057664)
print v(xbgr.mr_n81058608)
print v(xbgr.mr_n81059552)
print v(xbgr.mr_n81060496)
print v(xbgr.mr_n81061440)
print v(xbgr.mr_n81062384)
print v(xbgr.mr_n81063328)
print v(xbgr.mr_n81064272)
print v(xbgr.mr_n81065216)
print v(xbgr.mr_n81066160)
print v(xbgr.mr_n81067104)
print v(xbgr.mr_n81068048)
print v(xbgr.mr_n81068992)
print v(xbgr.mr_n81069936)
print v(xbgr.mr_n81070880)
print v(xbgr.mr_n81071824)
print v(xbgr.mr_n81072768)
print v(xbgr.mr_n81073712)
print v(xbgr.mr_n81074656)
print v(xbgr.mr_n81075600)
print v(xbgr.mr_n81076544)
print v(xbgr.mr_n81077488)
print v(xbgr.mr_n81078432)
print v(xbgr.mr_n81079376)
print v(xbgr.mr_n81080320)
print v(xbgr.mr_n81081264)
print v(xbgr.mr_n81082208)
print v(xbgr.mr_n81083152)
print v(xbgr.mr_n81084096)
print v(xbgr.mr_n81085040)
print v(xbgr.mr_n81085984)
print v(xbgr.mr_n81086928)
print v(xbgr.mr_n81087872)
print v(xbgr.mr_n81088816)
print v(xbgr.mr_n81089760)
print v(xbgr.mr_n81090704)
print v(xbgr.mr_n81091648)
print v(xbgr.mr_n81092592)
print v(xbgr.mr_n81093536)
print v(xbgr.mr_n81094480)
print v(xbgr.mr_n81095424)
print v(xbgr.mr_n81096368)
print v(xbgr.mr_n81097312)
print v(xbgr.mr_n81098256)
print v(xbgr.mr_n81099200)
print v(xbgr.mr_n81100144)
print v(xbgr.mr_n81101088)
print v(xbgr.mr_n81102032)
print v(xbgr.mr_n81102976)
print v(xbgr.mr_n81103920)
print v(xbgr.mr_n81104864)
print v(xbgr.mr_n81105808)
print v(xbgr.mr_n81106752)
print v(xbgr.mr_n81107696)
print v(xbgr.mr_n81108640)
print v(xbgr.mr_n81109584)
print v(xbgr.mr_n81110528)
print v(xbgr.mr_n81111472)
print v(xbgr.mr_n81112416)
print v(xbgr.mr_n81113360)
print v(xbgr.mr_n81114304)
print v(xbgr.mr_n81115248)
print v(xbgr.mr_n81116192)
print v(xbgr.mr_n81117136)
print v(xbgr.mr_n81118080)
print v(xbgr.mr_n81119024)
print v(xbgr.mr_n81119968)
print v(xbgr.mr_n81120912)
print v(xbgr.mr_n81121856)
print v(xbgr.mr_n81122800)
print v(xbgr.mr_n81123744)
print v(xbgr.mr_n81124688)
print v(xbgr.mr_n81125632)
print v(xbgr.mr_n81126576)
print v(xbgr.mr_n81127520)
print v(xbgr.mr_n81128464)
print v(xbgr.mr_n81129408)
print v(xbgr.mr_n81130352)
print v(xbgr.mr_n81131296)
print v(xbgr.mr_n81132240)
print v(xbgr.mr_n81133184)
print v(xbgr.mr_n81134128)
print v(xbgr.mr_n81135072)
print v(xbgr.mr_n81136016)
print v(xbgr.mr_n81136960)
print v(xbgr.mr_n81137744)
print v(xbgr.mr_n81138064)
print v(xbgr.mr_n81139200)
print v(xbgr.mr_n81140352)
print v(xbgr.mr_n81141056)
print v(xbgr.mr_n81141168)
print v(xbgr.mr_n81143936)
print v(xbgr.mr_n81144128)
print v(xbgr.mr_n81144320)
print v(xbgr.mr_n81144512)
print v(xbgr.mr_n81145424)
print v(xbgr.mr_n81145696)
print v(xbgr.mr_n81145888)
print v(xbgr.mr_n81146400)
print v(xbgr.mr_n81152096)
print v(xbgr.mr_n81152208)
print v(xbgr.mr_n81153120)
print v(xbgr.mr_n81153392)
print v(xbgr.mr_n81153584)
print v(xbgr.mr_n81154096)
print v(xbgr.mr_n81156896)
print v(xbgr.mr_n81157008)
print v(xbgr.mr_n81157120)
print v(xbgr.mr_n81157232)
print v(xbgr.mr_n81158976)
print v(xbgr.mr_n81159248)
print v(xbgr.mr_n81159440)
print v(xbgr.mr_n81159952)
print v(xbgr.mr_n81161184)
print v(xbgr.mr_n81161696)
print v(xbgr.mr_n81164544)
print v(xbgr.mr_n81164656)
print v(xbgr.mr_n81166400)
print v(xbgr.mr_n81166672)
print v(xbgr.mr_n81166864)
print v(xbgr.mr_n81167376)
print v(xbgr.mr_n81170560)
print v(xbgr.mr_n81170672)
print v(xbgr.mr_n81170784)
print v(xbgr.mr_n81170896)
print v(xbgr.mr_n81172640)
print v(xbgr.mr_n81172912)
print v(xbgr.mr_n81173104)
print v(xbgr.mr_n81173616)
print v(xbgr.mr_n81176800)
print v(xbgr.mr_n81176912)
print v(xbgr.mr_n81177024)
print v(xbgr.mr_n81177136)
print v(xbgr.mr_n81177424)
print v(xbgr.mr_n81178880)
print v(xbgr.mr_n81179072)
print v(xbgr.mr_n81179264)
print v(xbgr.mr_n81179856)
print v(xbgr.mr_n81181152)
print v(xbgr.mr_n81181664)
print v(xbgr.mr_n81184448)
print v(xbgr.mr_n81184560)
print v(xbgr.mr_n81186304)
print v(xbgr.mr_n81186576)
print v(xbgr.mr_n81186768)
print v(xbgr.mr_n81187280)
print v(xbgr.mr_n81190464)
print v(xbgr.mr_n81190576)
print v(xbgr.mr_n81190688)
print v(xbgr.mr_n81190880)
print v(xbgr.mr_n81191072)
print v(xbgr.mr_n81192880)
print v(xbgr.mr_n81193072)
print v(xbgr.mr_n81193584)
print v(xbgr.mr_n81196704)
print v(xbgr.mr_n81196816)
print v(xbgr.mr_n81196928)
print v(xbgr.mr_n81197040)
print v(xbgr.mr_n81198784)
print v(xbgr.mr_n81199056)
print v(xbgr.mr_n81199248)
print v(xbgr.mr_n81199760)
print v(xbgr.mr_n81199952)
print v(xbgr.mr_n81200992)
print v(xbgr.mr_n81201504)
print v(xbgr.mr_n81204352)
print v(xbgr.mr_n81204464)
print v(xbgr.mr_n81206208)
print v(xbgr.mr_n81206480)
print v(xbgr.mr_n81206672)
print v(xbgr.mr_n81207184)
print v(xbgr.mr_n81210368)
print v(xbgr.mr_n81210480)
print v(xbgr.mr_n81210592)
print v(xbgr.mr_n81210704)
print v(xbgr.mr_n81212448)
print v(xbgr.mr_n81212720)
print v(xbgr.mr_n81212912)
print v(xbgr.mr_n81213424)
print v(xbgr.mr_n81216608)
print v(xbgr.mr_n81216720)
print v(xbgr.mr_n81216832)
print v(xbgr.mr_n81216944)
print v(xbgr.mr_n81218688)
print v(xbgr.mr_n81218960)
print v(xbgr.mr_n81219152)
print v(xbgr.mr_n81219664)
print v(xbgr.mr_n81220112)
print v(xbgr.mr_n81220816)
print v(xbgr.mr_n81221408)
print v(xbgr.mr_n81224256)
print v(xbgr.mr_n81224368)
print v(xbgr.mr_n81226112)
print v(xbgr.mr_n81226384)
print v(xbgr.mr_n81226576)
print v(xbgr.mr_n81227088)
print v(xbgr.mr_n81229152)
print v(xbgr.mr_n81229264)
print v(xbgr.mr_n81229776)
print v(xbgr.mr_n81229888)
print v(xbgr.mr_n81230400)
print v(xbgr.mr_n81230512)
print v(xbgr.mr_n81231280)
print v(xbgr.mr_n81231392)
print v(xbgr.mr_n81232224)
print v(xbgr.mr_n81232336)
print v(xbgr.mr_n81233424)
print v(xbgr.mr_n81233536)
print v(xbgr.mr_n81234688)
print v(xbgr.mr_n81234800)
print v(xbgr.mr_n81235952)
print v(xbgr.mr_n81236064)
print v(xbgr.mr_n81237216)
print v(xbgr.mr_n81237328)
print v(xbgr.mr_n81238480)
print v(xbgr.mr_n81238592)
print v(xbgr.mr_n81238800)
print v(xbgr.mr_n81239744)
print v(xbgr.mr_n81239856)
print v(xbgr.mr_n81241008)
print v(xbgr.mr_n81241120)
print v(xbgr.mr_n81242272)
print v(xbgr.mr_n81242384)
print v(xbgr.mr_n81243536)
print v(xbgr.mr_n81243648)
print v(xbgr.mr_n81244800)
print v(xbgr.mr_n81244912)
print v(xbgr.mr_n81246064)
print v(xbgr.mr_n81246176)
print v(xbgr.mr_n81253200)
print v(xbgr.mr_n81254416)
print v(xbgr.mr_n81259856)
print v(xbgr.mr_n81265040)
print v(xbgr.mr_n81265360)
print v(xbgr.mr_n81267200)
print v(xbgr.mr_n81268944)
print v(xbgr.mr_n81274480)
print v(xbgr.mr_n81274592)
print v(xbgr.mr_n81274896)
print v(xbgr.mr_n81275008)
print v(xbgr.mr_n81276512)
print v(xbgr.mr_n81276624)
print v(xbgr.mr_n81276928)
print v(xbgr.mr_n81277776)
print v(xbgr.mr_n81284016)
print v(xbgr.mr_n81285280)
print v(xbgr.mr_n81285792)
print v(xbgr.mr_n81288576)
print v(xbgr.mr_n81289264)
print v(xbgr.mr_n81295104)
print v(xbgr.mr_n81295952)
print v(xbgr.mr_n81301296)
print v(xbgr.mr_n81301536)
print v(xbgr.mr_n81311360)
print v(xbgr.mr_n81312304)
print v(xbgr.mr_n81313248)
print v(xbgr.mr_n81314192)
print v(xbgr.mr_n81315136)
print v(xbgr.mr_n81316080)
print v(xbgr.mr_n81317024)
print v(xbgr.mr_n81317968)
print v(xbgr.mr_n81318912)
print v(xbgr.mr_n81319856)
print v(xbgr.mr_n81320800)
print v(xbgr.mr_n81321744)
print v(xbgr.mr_n81322688)
print v(xbgr.mr_n81323632)
print v(xbgr.mr_n81324576)
print v(xbgr.mr_n81325520)
print v(xbgr.mr_n81326464)
print v(xbgr.mr_n81327408)
print v(xbgr.mr_n81328352)
print v(xbgr.mr_n81329296)
print v(xbgr.mr_n81330240)
print v(xbgr.mr_n81331184)
print v(xbgr.mr_n81332128)
print v(xbgr.mr_n81333072)
print v(xbgr.mr_n81333392)
print v(xbgr.mr_n81339008)
print v(xbgr.mr_n81339952)
print v(xbgr.mr_n81340896)
print v(xbgr.mr_n81343536)
print v(xbgr.mr_n81347216)
print v(xbgr.mr_n81347408)
print v(xbgr.mr_n81348240)
print v(xbgr.mr_n81348352)
print v(xbgr.mr_n81348464)
print v(xbgr.mr_n81348576)
print v(xbgr.mr_n81348688)
print v(xbgr.mr_n81350432)
print v(xbgr.mr_n81350704)
print v(xbgr.mr_n81350896)
print v(xbgr.mr_n81351408)
print v(xbgr.mr_n81353344)
print v(xbgr.mr_n81355088)
print v(xbgr.mr_n81355360)
print v(xbgr.mr_n81355552)
print v(xbgr.mr_n81356064)
print v(xbgr.mr_n81358080)
print v(xbgr.mr_n81358272)
print v(xbgr.mr_n81360080)
print v(xbgr.mr_n81360272)
print v(xbgr.mr_n81360784)
print v(xbgr.mr_n81362656)
print v(xbgr.mr_n81364400)
print v(xbgr.mr_n81364672)
print v(xbgr.mr_n81364864)
print v(xbgr.mr_n81365376)
print v(xbgr.mr_n81367312)
print v(xbgr.mr_n81369056)
print v(xbgr.mr_n81369328)
print v(xbgr.mr_n81369520)
print v(xbgr.mr_n81370032)
print v(xbgr.mr_n81371968)
print v(xbgr.mr_n81373712)
print v(xbgr.mr_n81373984)
print v(xbgr.mr_n81374176)
print v(xbgr.mr_n81374688)
print v(xbgr.mr_n81376704)
print v(xbgr.mr_n81376896)
print v(xbgr.mr_n81378704)
print v(xbgr.mr_n81378896)
print v(xbgr.mr_n81379408)
print v(xbgr.mr_n81381280)
print v(xbgr.mr_n81383024)
print v(xbgr.mr_n81383296)
print v(xbgr.mr_n81383488)
print v(xbgr.mr_n81384000)
print v(xbgr.mr_n81385936)
print v(xbgr.mr_n81387680)
print v(xbgr.mr_n81387952)
print v(xbgr.mr_n81388144)
print v(xbgr.mr_n81388656)
print v(xbgr.mr_n81390592)
print v(xbgr.mr_n81392336)
print v(xbgr.mr_n81392608)
print v(xbgr.mr_n81392800)
print v(xbgr.mr_n81393312)
print v(xbgr.mr_n81395248)
print v(xbgr.mr_n81396992)
print v(xbgr.mr_n81397264)
print v(xbgr.mr_n81397456)
print v(xbgr.mr_n81397968)
print v(xbgr.mr_n81399904)
print v(xbgr.mr_n81401648)
print v(xbgr.mr_n81401920)
print v(xbgr.mr_n81402112)
print v(xbgr.mr_n81402624)
print v(xbgr.mr_n81404560)
print v(xbgr.mr_n81404944)
print v(xbgr.mr_n81405152)
print v(xbgr.mr_n81406576)
print v(xbgr.mr_n81406768)
print v(xbgr.mr_n81407280)
print v(xbgr.mr_n81408736)
print v(xbgr.mr_n81408928)
print v(xbgr.mr_n81409120)
print v(xbgr.mr_n81409312)
print v(xbgr.mr_n81411056)
print v(xbgr.mr_n81411328)
print v(xbgr.mr_n81411520)
print v(xbgr.mr_n81412032)
print v(xbgr.mr_n81413200)
print v(xbgr.mr_n81415616)
print v(xbgr.mr_n81418944)
print v(xbgr.mr_n81419488)
print v(xbgr.mr_n81421328)
print v(xbgr.mr_n81425120)
print v(xbgr.mr_n81425696)
print v(xbgr.mr_n81426320)
print v(xbgr.mr_n81427072)
print v(xbgr.mr_n81427424)
print v(xbgr.mr_n81428656)
print v(xbgr.mr_n81428944)
print v(xbgr.mr_n81430672)
print v(xbgr.mr_n81430880)
print v(xbgr.mr_n81432800)
print v(xbgr.mr_n81435488)
print v(xbgr.mr_n81437600)
print v(xbgr.mr_n81438976)
print v(xbgr.mr_n81439616)
print v(xbgr.mr_n81442592)
print v(xbgr.mr_n81443536)
print v(xbgr.mr_n81446992)
print v(xbgr.mr_n81447984)
print v(xbgr.mr_n81449520)
print v(xbgr.mr_n81451408)
print v(xbgr.mr_n81454480)
print v(xbgr.mr_n81455808)
print v(xbgr.mr_n81457312)
print v(xbgr.mr_n81457456)
print v(xbgr.mr_n81458816)
print v(xbgr.mr_n81460464)
print v(xbgr.mr_n81461488)
print v(xbgr.mr_n81463808)
print v(xbgr.mr_n81466512)
print v(xbgr.mr_n81467760)
print v(xbgr.mr_n81468304)
print v(xbgr.mr_n81469200)
print v(xbgr.mr_n81473856)
print v(xbgr.mr_n81475248)
print v(xbgr.mr_n81475360)
print v(xbgr.mr_n81477008)
print v(xbgr.mr_n81478512)
print v(xbgr.mr_n81479872)
print v(xbgr.mr_n81481264)
print v(xbgr.mr_n81483872)
print v(xbgr.mr_n81484304)
print v(xbgr.mr_n81484816)
print v(xbgr.mr_n81484928)
print v(xbgr.mr_n81485360)
print v(xbgr.mr_n81485872)
print v(xbgr.mr_n81485984)
print v(xbgr.mr_n81486416)
print v(xbgr.mr_n81486928)
print v(xbgr.mr_n81487280)
print v(xbgr.mr_n81488528)
print v(xbgr.mr_n81489872)
print v(xbgr.mr_n81490336)
print v(xbgr.mr_n81490912)
print v(xbgr.mr_n81491408)
print v(xbgr.mr_n81491776)
print v(xbgr.mr_n81491968)
print v(xbgr.mr_n81492512)
print v(xbgr.mr_n81492848)
print v(xbgr.mr_n81493184)
print v(xbgr.mr_n81495584)
print v(xbgr.mr_n81496592)
print v(xbgr.mr_n81496896)
print v(xbgr.mr_n81497296)
print v(xbgr.mr_n81497744)
print v(xbgr.mr_n81498016)
print v(xbgr.mr_n81500272)
print v(xbgr.mr_n81503152)
print v(xbgr.mr_n81503472)
print v(xbgr.mr_n81507360)
print v(xbgr.mr_n81507568)
print v(xbgr.mr_n81507680)
print v(xbgr.mr_n81508512)
print v(xbgr.mr_n81508832)
print v(xbgr.mr_n81509136)
print v(xbgr.mr_n81510208)
print v(xbgr.mr_n81513616)
print v(xbgr.mr_n81514016)
print v(xbgr.mr_n81514416)
print v(xbgr.mr_n81514656)
print v(xbgr.mr_n81515408)
print v(xbgr.mr_n81516192)
print v(xbgr.mr_n81516384)
print v(xbgr.mr_n81516816)
print v(xbgr.mr_n81517760)
print v(xbgr.mr_n81518096)
print v(xbgr.mr_n81518496)
print v(xbgr.mr_n81519440)
print v(xbgr.mr_n81519776)
print v(xbgr.mr_n81519968)
print v(xbgr.mr_n81520432)
print v(xbgr.mr_n81520896)
print v(xbgr.mr_n81521360)
print v(xbgr.mr_n81523232)
print v(xbgr.mr_n81523600)
print v(xbgr.mr_n81523936)
print v(xbgr.mr_n81524336)
print v(xbgr.mr_n81525152)
print v(xbgr.mr_n81525488)
print v(xbgr.mr_n81525744)
print v(xbgr.mr_n81527728)
print v(xbgr.mr_n81532352)
print v(xbgr.mr_n81532784)
print v(xbgr.mr_n81533296)
print v(xbgr.mr_n81533408)
print v(xbgr.mr_n81534160)
print v(xbgr.mr_n81534784)
print v(xbgr.mr_n81535472)
print v(xbgr.mr_n81536160)
print v(xbgr.mr_n81536848)
print v(xbgr.mr_n81537536)
print v(xbgr.mr_n81538224)
print v(xbgr.mr_n81538912)
print v(xbgr.mr_n81539600)
print v(xbgr.mr_n81540288)
print v(xbgr.mr_n81540976)
print v(xbgr.mr_n81541664)
print v(xbgr.mr_n81542352)
print v(xbgr.mr_n81543040)
print v(xbgr.mr_n81543472)
print v(xbgr.mr_n81543584)
print v(xbgr.mr_n81547024)
print v(xbgr.mr_n81548400)
print v(xbgr.mr_n81548512)
print v(xbgr.mr_n81549344)
print v(xbgr.mr_n81549456)
print v(xbgr.mr_n81550288)
print v(xbgr.mr_n81550400)
print v(xbgr.mr_n81551232)
print v(xbgr.mr_n81551344)
print v(xbgr.mr_n81552176)
print v(xbgr.mr_n81552288)
print v(xbgr.mr_n81553120)
print v(xbgr.mr_n81553232)
print v(xbgr.mr_n81554064)
print v(xbgr.mr_n81554176)
print v(xbgr.mr_n81555008)
print v(xbgr.mr_n81555120)
print v(xbgr.mr_n81555952)
print v(xbgr.mr_n81556064)
print v(xbgr.mr_n81556896)
print v(xbgr.mr_n81557008)
print v(xbgr.mr_n81557840)
print v(xbgr.mr_n81557952)
print v(xbgr.mr_n81558784)
print v(xbgr.mr_n81558896)
print v(xbgr.mr_n81559920)
print v(xbgr.mr_n81560032)
print v(xbgr.mr_n81561184)
print v(xbgr.mr_n81561296)
print v(xbgr.mr_n81562448)
print v(xbgr.mr_n81562560)
print v(xbgr.mr_n81566640)
print v(xbgr.mr_n81568112)
print v(xbgr.mr_n81569152)
print v(xbgr.mr_n81574416)
print v(xbgr.mr_n81574848)
print v(xbgr.mr_n81580416)
print v(xbgr.mr_n81581168)
print v(xbgr.mr_n81581360)
print v(xbgr.mr_n81581552)
print v(xbgr.mr_n81581744)
print v(xbgr.mr_n81582656)
print v(xbgr.mr_n81584064)
print v(xbgr.mr_n81584336)
print v(xbgr.mr_n81584528)
print v(xbgr.mr_n81585040)
print v(xbgr.mr_n81585152)
print v(xbgr.mr_n81585264)
print v(xbgr.mr_n81585376)
print v(xbgr.mr_n81585568)
print v(xbgr.mr_n81585760)
print v(xbgr.mr_n81585952)
print v(xbgr.mr_n81589520)
print v(xbgr.mr_n81596496)
print v(xbgr.mr_n81609072)
print v(xbgr.mr_n81610688)
print v(xbgr.mr_n81612368)
print v(xbgr.mr_n81614624)
print v(xbgr.mr_n81616880)
print v(xbgr.mr_n81619136)
print v(xbgr.mr_n81621392)
print v(xbgr.mr_n81625552)
print v(xbgr.mr_n81630672)
print v(xbgr.mr_n81642688)
print v(xbgr.mr_n81643120)
print v(xbgr.mr_n81643952)
print v(xbgr.mr_n81644528)
print v(xbgr.mr_n81645216)
print v(xbgr.mr_n81645792)
print v(xbgr.mr_n81646480)
print v(xbgr.mr_n81647056)
print v(xbgr.mr_n81647744)
print v(xbgr.mr_n81648176)
print v(xbgr.mr_n81649008)
print v(xbgr.mr_n81649584)
print v(xbgr.mr_n81650272)
print v(xbgr.mr_n81650848)
print v(xbgr.mr_n81651536)
print v(xbgr.mr_n81653584)
print v(xbgr.mr_n81662544)
print v(xbgr.mr_n81663824)
print v(xbgr.mr_n81670304)
print v(xbgr.mr_n81678192)
print v(xbgr.mr_n81679088)
print v(xbgr.mr_n81679728)
print v(xbgr.mr_n81680336)
print v(xbgr.mr_n81681392)
print v(xbgr.mr_n81681712)
print v(xbgr.mr_n81682320)
print v(xbgr.mr_n81684592)
print v(xbgr.mr_n81684704)
print v(xbgr.mr_n81684816)
print v(xbgr.mr_n81684928)
print v(xbgr.mr_n81685040)
print v(xbgr.mr_n81685152)
print v(xbgr.mr_n81685264)
print v(xbgr.mr_n81685456)
print v(xbgr.mr_n81685568)
print v(xbgr.mr_n81686272)
print v(xbgr.mr_n81686736)
print v(xbgr.mr_n81686928)
print v(xbgr.mr_n81687328)
print v(xbgr.mr_n81689120)
print v(xbgr.mr_n81689872)
print v(xbgr.mr_n81690144)
print v(xbgr.mr_n81690336)
print v(xbgr.mr_n81691152)
print v(xbgr.mr_n81691424)
print v(xbgr.mr_n81691616)
print v(xbgr.mr_n81691808)
print v(xbgr.mr_n81692480)
print v(xbgr.mr_n81693024)
print v(xbgr.mr_n81695408)
print v(xbgr.mr_n81695520)
print v(xbgr.mr_n81696032)
print v(xbgr.mr_n81696144)
print v(xbgr.mr_n81696656)
print v(xbgr.mr_n81696768)
print v(xbgr.mr_n81697280)
print v(xbgr.mr_n81697392)
print v(xbgr.mr_n81697904)
print v(xbgr.mr_n81698016)
print v(xbgr.mr_n81698528)
print v(xbgr.mr_n81698640)
print v(xbgr.mr_n81699152)
print v(xbgr.mr_n81699264)
print v(xbgr.mr_n81699776)
print v(xbgr.mr_n81699888)
print v(xbgr.mr_n81701552)
print v(xbgr.mr_n81701984)
print v(xbgr.mr_n81703840)
print v(xbgr.mr_n81708384)
print v(xbgr.mr_n81713440)
print v(xbgr.mr_n81714384)
print v(xbgr.mr_n81715616)
print v(xbgr.mr_n81716560)
print v(xbgr.mr_n81717504)
print v(xbgr.mr_n81718448)
print v(xbgr.mr_n81719392)
print v(xbgr.mr_n81720336)
print v(xbgr.mr_n81721280)
print v(xbgr.mr_n81722224)
print v(xbgr.mr_n81723168)
print v(xbgr.mr_n81724112)
print v(xbgr.mr_n81725056)
print v(xbgr.mr_n81726000)
print v(xbgr.mr_n81726944)
print v(xbgr.mr_n81727888)
print v(xbgr.mr_n81728832)
print v(xbgr.mr_n81729776)
print v(xbgr.mr_n81737344)
print v(xbgr.mr_n81738112)
print v(xbgr.mr_n81738880)
print v(xbgr.mr_n81739264)
print v(xbgr.mr_n81740112)
print v(xbgr.mr_n81740496)
print v(xbgr.mr_n81740800)
print v(xbgr.mr_n81741184)
print v(xbgr.mr_n81741568)
print v(xbgr.mr_n81741952)
print v(xbgr.mr_n81742336)
print v(xbgr.mr_n81743104)
print v(xbgr.mr_n81743488)
print v(xbgr.mr_n81744640)
print v(xbgr.mr_n81745408)
print v(xbgr.mr_n81746944)
print v(xbgr.mr_n81747328)
print v(xbgr.mr_n81747712)
print v(xbgr.mr_n81750368)
print v(xbgr.mr_n81750880)
print v(xbgr.mr_n81752416)
print v(xbgr.mr_n81752528)
print v(xbgr.mr_n81753440)
print v(xbgr.mr_n81755104)
print v(xbgr.mr_n81755488)
print v(xbgr.mr_n81755712)
print v(xbgr.mr_n81756160)
print v(xbgr.mr_n81759968)
print v(xbgr.mr_n81763376)
print v(xbgr.mr_n81763488)
print v(xbgr.mr_n81764896)
print v(xbgr.mr_n81770384)
print v(xbgr.mr_n81771664)
print v(xbgr.mr_n81773008)
print v(xbgr.mr_n81774000)
print v(xbgr.mr_n81775264)
print v(xbgr.mr_n81777008)
print v(xbgr.mr_n81777200)
print v(xbgr.mr_n81777936)
print v(xbgr.mr_n81778048)
print v(xbgr.mr_n81778592)
print v(xbgr.mr_n81779104)
print v(xbgr.mr_n81783216)
print v(xbgr.mr_n81784976)
print v(xbgr.mr_n81786400)
print v(xbgr.mr_n81786912)
print v(xbgr.mr_n81787024)
print v(xbgr.mr_n81787456)
print v(xbgr.mr_n81787968)
print v(xbgr.mr_n81788080)
print v(xbgr.mr_n81788512)
print v(xbgr.mr_n81789024)
print v(xbgr.mr_n81789136)
print v(xbgr.mr_n81789568)
print v(xbgr.mr_n81790400)
print v(xbgr.mr_n81791232)
print v(xbgr.mr_n81796480)
print v(xbgr.mr_n81797504)
print v(xbgr.mr_n81798752)
print v(xbgr.mr_n81800736)
print v(xbgr.mr_n81801024)
print v(xbgr.mr_n81801328)
print v(xbgr.mr_n81801536)
print v(xbgr.mr_n81801840)
print v(xbgr.mr_n81803824)
print v(xbgr.mr_n81804512)
print v(xbgr.mr_n81807072)
print v(xbgr.mr_n81807248)
print v(xbgr.mr_n81809120)
print v(xbgr.mr_n81809232)
print v(xbgr.mr_n81809888)
print v(xbgr.mr_n81810560)
print v(xbgr.mr_n81810672)
print v(xbgr.mr_n81811168)
print v(xbgr.mr_n81818112)
print v(xbgr.mr_n81818752)
print v(xbgr.mr_n81821040)
print v(xbgr.mr_n81821328)
print v(xbgr.mr_n81824048)
print v(xbgr.mr_n81824192)
print v(xbgr.mr_n81825536)
print v(xbgr.mr_n81826752)
print v(xbgr.mr_n81827488)
print v(xbgr.mr_n81828000)
print v(xbgr.mr_n81828992)
print v(xbgr.mr_n81829216)
print v(xbgr.mr_n81829504)
print v(xbgr.mr_n81830432)
print v(xbgr.mr_n81831392)
print v(xbgr.mr_n81831744)
print v(xbgr.mr_n81834368)
print v(xbgr.mr_n81834816)
print v(xbgr.mr_n81835008)
print v(xbgr.mr_n81840112)
print v(xbgr.mr_n81840640)
print v(xbgr.mr_n81841040)
print v(xbgr.mr_n81841504)
print v(xbgr.mr_n81842176)
print v(xbgr.mr_n81842432)
print v(xbgr.mr_n81842624)
print v(xbgr.mr_n81842848)
print v(xbgr.mr_n81843792)
print v(xbgr.mr_n81844128)
print v(xbgr.mr_n81844320)
print v(xbgr.mr_n81844784)
print v(xbgr.mr_n81845792)
print v(xbgr.mr_n81846128)
print v(xbgr.mr_n81846800)
print v(xbgr.mr_n81846992)
print v(xbgr.mr_n81847936)
print v(xbgr.mr_n81848272)
print v(xbgr.mr_n81849216)
print v(xbgr.mr_n81849552)
print v(xbgr.mr_n81849744)
print v(xbgr.mr_n81850208)
print v(xbgr.mr_n81850672)
print v(xbgr.mr_n81851616)
print v(xbgr.mr_n81851952)
print v(xbgr.mr_n81852416)
print v(xbgr.mr_n81853504)
print v(xbgr.mr_n81854064)
print v(xbgr.mr_n81854256)
print v(xbgr.mr_n81854688)
print v(xbgr.mr_n81858656)
print v(xbgr.mr_n81859552)
print v(xbgr.mr_n81859744)
print v(xbgr.mr_n81860208)
print v(xbgr.mr_n81860400)
print v(xbgr.mr_n81860544)
print v(xbgr.mr_n81860928)
print v(xbgr.mr_n81861120)
print v(xbgr.mr_n81861472)
print v(xbgr.mr_n81861808)
print v(xbgr.mr_n81862144)
print v(xbgr.mr_n81863200)
print v(xbgr.mr_n81863344)
print v(xbgr.mr_n81867264)
print v(xbgr.mr_n81867968)
print v(xbgr.mr_n81868160)
print v(xbgr.mr_n81871488)
print v(xbgr.mr_n81871600)
print v(xbgr.mr_n81872032)
print v(xbgr.mr_n81872544)
print v(xbgr.mr_n81872656)
print v(xbgr.mr_n81873088)
print v(xbgr.mr_n81873600)
print v(xbgr.mr_n81873712)
print v(xbgr.mr_n81874144)
print v(xbgr.mr_n81874656)
print v(xbgr.mr_n81874768)
print v(xbgr.mr_n81875200)
print v(xbgr.mr_n81875712)
print v(xbgr.mr_n81875824)
print v(xbgr.mr_n81876256)
print v(xbgr.mr_n81876768)
print v(xbgr.mr_n81876880)
print v(xbgr.mr_n81877312)
print v(xbgr.mr_n81877824)
print v(xbgr.mr_n81877936)
print v(xbgr.mr_n81878368)
print v(xbgr.mr_n81878880)
print v(xbgr.mr_n81878992)
print v(xbgr.mr_n81879424)
print v(xbgr.mr_n81879936)
print v(xbgr.mr_n81880048)
print v(xbgr.mr_n81880480)
print v(xbgr.mr_n81881376)
print v(xbgr.mr_n81881488)
print v(xbgr.mr_n81882368)
print v(xbgr.mr_n81883056)
print v(xbgr.mr_n81883744)
print v(xbgr.mr_n81884432)
print v(xbgr.mr_n81885120)
print v(xbgr.mr_n81885808)
print v(xbgr.mr_n81886496)
print v(xbgr.mr_n81887184)
print v(xbgr.mr_n81887872)
print v(xbgr.mr_n81888560)
print v(xbgr.mr_n81889248)
print v(xbgr.mr_n81889936)
print v(xbgr.mr_n81890624)
print v(xbgr.mr_n81891312)
print v(xbgr.mr_n81892000)
print v(xbgr.mr_n81892688)
print v(xbgr.mr_n81893376)
print v(xbgr.mr_n81894064)
print v(xbgr.mr_n81894752)
print v(xbgr.mr_n81895440)
print v(xbgr.mr_n81896768)
print v(xbgr.mr_n81897872)
print v(xbgr.mr_n81898816)
print v(xbgr.mr_n81899760)
print v(xbgr.mr_n81900704)
print v(xbgr.mr_n81901648)
print v(xbgr.mr_n81902592)
print v(xbgr.mr_n81903536)
print v(xbgr.mr_n81904480)
print v(xbgr.mr_n81905424)
print v(xbgr.mr_n81906368)
print v(xbgr.mr_n81907312)
print v(xbgr.mr_n81908256)
print v(xbgr.mr_n81909200)
print v(xbgr.mr_n81910144)
print v(xbgr.mr_n81911088)
print v(xbgr.mr_n81912032)
print v(xbgr.mr_n81912976)
print v(xbgr.mr_n81913920)
print v(xbgr.mr_n81914864)
print v(xbgr.mr_n81915808)
print v(xbgr.mr_n81916752)
print v(xbgr.mr_n81917696)
print v(xbgr.mr_n81918640)
print v(xbgr.mr_n81919584)
print v(xbgr.mr_n81920528)
print v(xbgr.mr_n81925328)
print v(xbgr.mr_n81925584)
print v(xbgr.mr_n81925840)
print v(xbgr.mr_n81926096)
print v(xbgr.mr_n81926352)
print v(xbgr.mr_n81926608)
print v(xbgr.mr_n81929408)
print v(xbgr.mr_n81929856)
print v(xbgr.mr_n81930048)
print v(xbgr.mr_n81930240)
print v(xbgr.mr_n81930432)
print v(xbgr.mr_n81930624)
print v(xbgr.mr_n81930816)
print v(xbgr.mr_n81931072)
print v(xbgr.mr_n81936080)
print v(xbgr.mr_n81950368)
print v(xbgr.mr_n81953760)
print v(xbgr.mr_n81955808)
print v(xbgr.mr_n81956768)
print v(xbgr.mr_n81970336)
print v(xbgr.mr_n81972608)
print v(xbgr.mr_n81974112)
print v(xbgr.mr_n81974224)
print v(xbgr.mr_n81975216)
print v(xbgr.mr_n81978160)
print v(xbgr.mr_n81978640)
print v(xbgr.mr_n81981216)
print v(xbgr.mr_n81981408)
print v(xbgr.mr_n81981600)
print v(xbgr.mr_n81982864)
print v(xbgr.mr_n81984368)
print v(xbgr.mr_n82253904)
print v(xbgr.mr_n82254096)
print v(xbgr.mr_n82268528)
print v(xbgr.mr_n82311376)
print v(xbgr.mr_n82312256)
print v(xbgr.mr_n82334896)
print v(xbgr.mr_n82356000)
print v(xbgr.mr_n82356192)
print v(xbgr.mr_n82356384)
print v(xbgr.mr_n82356576)
print v(xbgr.mr_n82356768)
print v(xbgr.mr_n82374512)
print v(xbgr.mr_n82374704)
print v(xbgr.mr_n82375136)
print v(xbgr.mr_n82375328)
print v(xbgr.mr_n82375520)
print v(xbgr.mr_n82375952)
print v(xbgr.mr_n82376064)
print v(xbgr.mr_n82394352)
print v(xbgr.mr_n82394544)
print v(xbgr.mr_n82402320)
print v(xbgr.mr_n82402592)
print v(xbgr.mr_n82402864)
print v(xbgr.mr_n82403056)
print v(xbgr.mr_n82403248)
print v(xbgr.mr_n82403488)
print v(xbgr.mr_n82403680)
print v(xbgr.mr_n82419408)
print v(xbgr.mr_n82419952)
print v(xbgr.mr_n82490896)
print v(xbgr.mr_n82491088)
print v(xbgr.mr_n82523024)
print v(xbgr.mr_n82539312)
print v(xbgr.mr_n82563792)
print v(xbgr.mr_n82570960)
print v(xbgr.mr_n82591520)
print v(xbgr.mr_n82653744)
print v(xbgr.mr_n82654368)
print v(xbgr.mr_n82654560)
print v(xbgr.mr_n82719184)
print v(xbgr.mr_n82751776)
print v(xbgr.mr_n82751888)
print v(xbgr.mr_n82752256)
print v(xbgr.mr_n82786528)
print v(xbgr.mr_n82786912)
print v(xbgr.mr_n82787104)
print v(xbgr.mr_n82787488)
print v(xbgr.mr_n82797248)
print v(xbgr.mr_n82814160)
print v(xbgr.mr_n82815120)
print v(xbgr.mr_n82815264)
print v(xbgr.mr_n82815616)
print v(xbgr.mr_n82842176)
print v(xbgr.mr_n82858704)
print v(xbgr.mr_n82865712)
print v(xbgr.mr_n82866656)
print v(xbgr.mr_n82896768)
print v(xbgr.mr_n82901776)
print v(xbgr.mr_n82902672)
print v(xbgr.mr_n82903232)
print v(xbgr.mr_n82923824)
print v(xbgr.mr_n82933248)
print v(xbgr.mr_n82933664)
print v(xbgr.mr_n82937840)
print v(xbgr.mr_n82967024)
print v(xbgr.mr_n82969360)
print v(xbgr.mr_n82969552)
print v(xbgr.mr_n82971872)
print v(xbgr.mr_n82977376)
print v(xbgr.mr_n82980848)
print v(xbgr.mr_n82981040)
print v(xbgr.mr_n82983024)
print v(xbgr.mr_n82983216)
print v(xbgr.mr_n83019536)
print v(xbgr.mr_n83063760)
print v(xbgr.mr_n83074288)
print v(xbgr.n1)
print v(xbgr.n_10)
print v(xbgr.n_11)
print v(xbgr.n_12)
print v(xbgr.n_13)
print v(xbgr.n_14)
print v(xbgr.n_15)
print v(xbgr.n_16)
print v(xbgr.n_17)
print v(xbgr.n_18)
print v(xbgr.n_19)
print v(xbgr.n_2)
print v(xbgr.n_21)
print v(xbgr.n_22)
print v(xbgr.n_23)
print v(xbgr.n_24)
print v(xbgr.n_25)
print v(xbgr.n_26)
print v(xbgr.n_27)
print v(xbgr.n_3)
print v(xbgr.n_30)
print v(xbgr.n_31)
print v(xbgr.n_33)
print v(xbgr.n_34)
print v(xbgr.n_36)
print v(xbgr.n_37)
print v(xbgr.n_4)
print v(xbgr.n_5)
print v(xbgr.n_6)
print v(xbgr.n_7)
print v(xbgr.n_8)
print v(xbgr.n_9)
print v(pbias)
print v(pcasc)
print v(r4)
print v(xbgr.r4n)
print v(xbgr.vb2)
print v(vbe)
print v(xbgr.vbe3)
print v(xbgr.vd1)
print v(xbgr.vd2)
print v(vdd)
print v(vref)
print v(vdd)-v(vdd)
echo METALLIC_ALL_NODE_VOLTAGES_END
quit
.endc
.end
