* G1_BGR standalone capacitance-PEX qualification
.lib /foss/pdks/ihp-sg13g2/libs.tech/ngspice/models/cornerHBT.lib hbt_typ
.lib /foss/pdks/ihp-sg13g2/libs.tech/ngspice/models/cornerMOShv.lib mos_tt
.lib /foss/pdks/ihp-sg13g2/libs.tech/ngspice/models/cornerRES.lib res_typ
.include conditional_metal.spice
.option seed=44001 gmin=1e-15 abstol=1e-14 reltol=1e-5 vntol=1e-7
.global sub!
Vsub sub! 0 0
Vdd vdd 0 3.3
Vr4 r4 0 0
Xbgr vdd 0 r4 vref iptat pbias pcasc vbe dvbe g1_bgr
Vload iptat 0 1
Cload vref 0 1e-12
.control
set num_threads=1
set numdgt=15
set wr_singlescale
set wr_vecnames
op
echo RAW_CURRENT_LEDGER_BEGIN
print @n.xbgr.xr1.nr1[ibody]
print @n.xbgr.xr2.nr1[ibody]
print @n.xbgr.xr3.nr1[ibody]
print @n.xbgr.xr4.nr1[ibody]
print @n.xbgr.xr5.nr1[ibody]
print @n.xbgr.xr6.nr1[ibody]
print @n.xbgr.xr7.nr1[ibody]
print @n.xbgr.xr8.nr1[ibody]
print @n.xbgr.xr9.nr1[ibody]
print @n.xbgr.xr10.nr1[ibody]
print @n.xbgr.xr11.nr1[ibody]
print @n.xbgr.xr12.nr1[ibody]
print @n.xbgr.xr13.nr1[ibody]
print @n.xbgr.xr14.nr1[ibody]
print @n.xbgr.xr15.nr1[ibody]
print @n.xbgr.xr16.nr1[ibody]
print @n.xbgr.xr17.nr1[ibody]
print @n.xbgr.xr18.nr1[ibody]
print @n.xbgr.xr19.nr1[ibody]
print @n.xbgr.xr20.nr1[ibody]
print @n.xbgr.xr21.nr1[ibody]
print @n.xbgr.xr22.nr1[ibody]
print @n.xbgr.xr23.nr1[ibody]
print @n.xbgr.xr24.nr1[ibody]
print @n.xbgr.xr25.nr1[ibody]
print @n.xbgr.xr26.nr1[ibody]
print @n.xbgr.xm27.nsg13_hv_pmos[ide]
print @n.xbgr.xm27.nsg13_hv_pmos[ige]
print @n.xbgr.xm27.nsg13_hv_pmos[ise]
print @n.xbgr.xm27.nsg13_hv_pmos[ibe]
print @n.xbgr.xm27.nsg13_hv_pmos[ctype]
print @n.xbgr.xm28.nsg13_hv_pmos[ide]
print @n.xbgr.xm28.nsg13_hv_pmos[ige]
print @n.xbgr.xm28.nsg13_hv_pmos[ise]
print @n.xbgr.xm28.nsg13_hv_pmos[ibe]
print @n.xbgr.xm28.nsg13_hv_pmos[ctype]
print @n.xbgr.xm29.nsg13_hv_nmos[ide]
print @n.xbgr.xm29.nsg13_hv_nmos[ige]
print @n.xbgr.xm29.nsg13_hv_nmos[ise]
print @n.xbgr.xm29.nsg13_hv_nmos[ibe]
print @n.xbgr.xm29.nsg13_hv_nmos[ctype]
print @n.xbgr.xm30.nsg13_hv_nmos[ide]
print @n.xbgr.xm30.nsg13_hv_nmos[ige]
print @n.xbgr.xm30.nsg13_hv_nmos[ise]
print @n.xbgr.xm30.nsg13_hv_nmos[ibe]
print @n.xbgr.xm30.nsg13_hv_nmos[ctype]
print @n.xbgr.xm31.nsg13_hv_nmos[ide]
print @n.xbgr.xm31.nsg13_hv_nmos[ige]
print @n.xbgr.xm31.nsg13_hv_nmos[ise]
print @n.xbgr.xm31.nsg13_hv_nmos[ibe]
print @n.xbgr.xm31.nsg13_hv_nmos[ctype]
print @n.xbgr.xm32.nsg13_hv_nmos[ide]
print @n.xbgr.xm32.nsg13_hv_nmos[ige]
print @n.xbgr.xm32.nsg13_hv_nmos[ise]
print @n.xbgr.xm32.nsg13_hv_nmos[ibe]
print @n.xbgr.xm32.nsg13_hv_nmos[ctype]
print @n.xbgr.xm33.nsg13_hv_nmos[ide]
print @n.xbgr.xm33.nsg13_hv_nmos[ige]
print @n.xbgr.xm33.nsg13_hv_nmos[ise]
print @n.xbgr.xm33.nsg13_hv_nmos[ibe]
print @n.xbgr.xm33.nsg13_hv_nmos[ctype]
print @n.xbgr.xm34.nsg13_hv_nmos[ide]
print @n.xbgr.xm34.nsg13_hv_nmos[ige]
print @n.xbgr.xm34.nsg13_hv_nmos[ise]
print @n.xbgr.xm34.nsg13_hv_nmos[ibe]
print @n.xbgr.xm34.nsg13_hv_nmos[ctype]
print @n.xbgr.xm35.nsg13_hv_nmos[ide]
print @n.xbgr.xm35.nsg13_hv_nmos[ige]
print @n.xbgr.xm35.nsg13_hv_nmos[ise]
print @n.xbgr.xm35.nsg13_hv_nmos[ibe]
print @n.xbgr.xm35.nsg13_hv_nmos[ctype]
print @n.xbgr.xm36.nsg13_hv_nmos[ide]
print @n.xbgr.xm36.nsg13_hv_nmos[ige]
print @n.xbgr.xm36.nsg13_hv_nmos[ise]
print @n.xbgr.xm36.nsg13_hv_nmos[ibe]
print @n.xbgr.xm36.nsg13_hv_nmos[ctype]
print @n.xbgr.xm37.nsg13_hv_nmos[ide]
print @n.xbgr.xm37.nsg13_hv_nmos[ige]
print @n.xbgr.xm37.nsg13_hv_nmos[ise]
print @n.xbgr.xm37.nsg13_hv_nmos[ibe]
print @n.xbgr.xm37.nsg13_hv_nmos[ctype]
print @n.xbgr.xm38.nsg13_hv_pmos[ide]
print @n.xbgr.xm38.nsg13_hv_pmos[ige]
print @n.xbgr.xm38.nsg13_hv_pmos[ise]
print @n.xbgr.xm38.nsg13_hv_pmos[ibe]
print @n.xbgr.xm38.nsg13_hv_pmos[ctype]
print @n.xbgr.xm39.nsg13_hv_pmos[ide]
print @n.xbgr.xm39.nsg13_hv_pmos[ige]
print @n.xbgr.xm39.nsg13_hv_pmos[ise]
print @n.xbgr.xm39.nsg13_hv_pmos[ibe]
print @n.xbgr.xm39.nsg13_hv_pmos[ctype]
print @n.xbgr.xm40.nsg13_hv_pmos[ide]
print @n.xbgr.xm40.nsg13_hv_pmos[ige]
print @n.xbgr.xm40.nsg13_hv_pmos[ise]
print @n.xbgr.xm40.nsg13_hv_pmos[ibe]
print @n.xbgr.xm40.nsg13_hv_pmos[ctype]
print @n.xbgr.xm41.nsg13_hv_pmos[ide]
print @n.xbgr.xm41.nsg13_hv_pmos[ige]
print @n.xbgr.xm41.nsg13_hv_pmos[ise]
print @n.xbgr.xm41.nsg13_hv_pmos[ibe]
print @n.xbgr.xm41.nsg13_hv_pmos[ctype]
print @n.xbgr.xm42.nsg13_hv_pmos[ide]
print @n.xbgr.xm42.nsg13_hv_pmos[ige]
print @n.xbgr.xm42.nsg13_hv_pmos[ise]
print @n.xbgr.xm42.nsg13_hv_pmos[ibe]
print @n.xbgr.xm42.nsg13_hv_pmos[ctype]
print @n.xbgr.xm43.nsg13_hv_pmos[ide]
print @n.xbgr.xm43.nsg13_hv_pmos[ige]
print @n.xbgr.xm43.nsg13_hv_pmos[ise]
print @n.xbgr.xm43.nsg13_hv_pmos[ibe]
print @n.xbgr.xm43.nsg13_hv_pmos[ctype]
print @n.xbgr.xm44.nsg13_hv_pmos[ide]
print @n.xbgr.xm44.nsg13_hv_pmos[ige]
print @n.xbgr.xm44.nsg13_hv_pmos[ise]
print @n.xbgr.xm44.nsg13_hv_pmos[ibe]
print @n.xbgr.xm44.nsg13_hv_pmos[ctype]
print @n.xbgr.xm45.nsg13_hv_pmos[ide]
print @n.xbgr.xm45.nsg13_hv_pmos[ige]
print @n.xbgr.xm45.nsg13_hv_pmos[ise]
print @n.xbgr.xm45.nsg13_hv_pmos[ibe]
print @n.xbgr.xm45.nsg13_hv_pmos[ctype]
print @n.xbgr.xm46.nsg13_hv_pmos[ide]
print @n.xbgr.xm46.nsg13_hv_pmos[ige]
print @n.xbgr.xm46.nsg13_hv_pmos[ise]
print @n.xbgr.xm46.nsg13_hv_pmos[ibe]
print @n.xbgr.xm46.nsg13_hv_pmos[ctype]
print @n.xbgr.xm47.nsg13_hv_pmos[ide]
print @n.xbgr.xm47.nsg13_hv_pmos[ige]
print @n.xbgr.xm47.nsg13_hv_pmos[ise]
print @n.xbgr.xm47.nsg13_hv_pmos[ibe]
print @n.xbgr.xm47.nsg13_hv_pmos[ctype]
print @n.xbgr.xm48.nsg13_hv_pmos[ide]
print @n.xbgr.xm48.nsg13_hv_pmos[ige]
print @n.xbgr.xm48.nsg13_hv_pmos[ise]
print @n.xbgr.xm48.nsg13_hv_pmos[ibe]
print @n.xbgr.xm48.nsg13_hv_pmos[ctype]
print @n.xbgr.xm49.nsg13_hv_pmos[ide]
print @n.xbgr.xm49.nsg13_hv_pmos[ige]
print @n.xbgr.xm49.nsg13_hv_pmos[ise]
print @n.xbgr.xm49.nsg13_hv_pmos[ibe]
print @n.xbgr.xm49.nsg13_hv_pmos[ctype]
print @n.xbgr.xm50.nsg13_hv_pmos[ide]
print @n.xbgr.xm50.nsg13_hv_pmos[ige]
print @n.xbgr.xm50.nsg13_hv_pmos[ise]
print @n.xbgr.xm50.nsg13_hv_pmos[ibe]
print @n.xbgr.xm50.nsg13_hv_pmos[ctype]
print @n.xbgr.xm51.nsg13_hv_pmos[ide]
print @n.xbgr.xm51.nsg13_hv_pmos[ige]
print @n.xbgr.xm51.nsg13_hv_pmos[ise]
print @n.xbgr.xm51.nsg13_hv_pmos[ibe]
print @n.xbgr.xm51.nsg13_hv_pmos[ctype]
print @n.xbgr.xm52.nsg13_hv_pmos[ide]
print @n.xbgr.xm52.nsg13_hv_pmos[ige]
print @n.xbgr.xm52.nsg13_hv_pmos[ise]
print @n.xbgr.xm52.nsg13_hv_pmos[ibe]
print @n.xbgr.xm52.nsg13_hv_pmos[ctype]
print @n.xbgr.xm53.nsg13_hv_pmos[ide]
print @n.xbgr.xm53.nsg13_hv_pmos[ige]
print @n.xbgr.xm53.nsg13_hv_pmos[ise]
print @n.xbgr.xm53.nsg13_hv_pmos[ibe]
print @n.xbgr.xm53.nsg13_hv_pmos[ctype]
print @n.xbgr.xm54.nsg13_hv_pmos[ide]
print @n.xbgr.xm54.nsg13_hv_pmos[ige]
print @n.xbgr.xm54.nsg13_hv_pmos[ise]
print @n.xbgr.xm54.nsg13_hv_pmos[ibe]
print @n.xbgr.xm54.nsg13_hv_pmos[ctype]
print @q.xbgr.xq55.qnpn13g2[ic]
print @q.xbgr.xq55.qnpn13g2[ib]
print @q.xbgr.xq55.qnpn13g2[ie]
print @q.xbgr.xq55.qnpn13g2[is]
print @r.xbgr.xq55.rsub[i]
print @c.xbgr.xq55.csub[i]
print @q.xbgr.xq56.qnpn13g2[ic]
print @q.xbgr.xq56.qnpn13g2[ib]
print @q.xbgr.xq56.qnpn13g2[ie]
print @q.xbgr.xq56.qnpn13g2[is]
print @r.xbgr.xq56.rsub[i]
print @c.xbgr.xq56.csub[i]
print @q.xbgr.xq57.qnpn13g2[ic]
print @q.xbgr.xq57.qnpn13g2[ib]
print @q.xbgr.xq57.qnpn13g2[ie]
print @q.xbgr.xq57.qnpn13g2[is]
print @r.xbgr.xq57.rsub[i]
print @c.xbgr.xq57.csub[i]
print @q.xbgr.xq58.qnpn13g2[ic]
print @q.xbgr.xq58.qnpn13g2[ib]
print @q.xbgr.xq58.qnpn13g2[ie]
print @q.xbgr.xq58.qnpn13g2[is]
print @r.xbgr.xq58.rsub[i]
print @c.xbgr.xq58.csub[i]
print @q.xbgr.xq59.qnpn13g2[ic]
print @q.xbgr.xq59.qnpn13g2[ib]
print @q.xbgr.xq59.qnpn13g2[ie]
print @q.xbgr.xq59.qnpn13g2[is]
print @r.xbgr.xq59.rsub[i]
print @c.xbgr.xq59.csub[i]
print @q.xbgr.xq60.qnpn13g2[ic]
print @q.xbgr.xq60.qnpn13g2[ib]
print @q.xbgr.xq60.qnpn13g2[ie]
print @q.xbgr.xq60.qnpn13g2[is]
print @r.xbgr.xq60.rsub[i]
print @c.xbgr.xq60.csub[i]
print @q.xbgr.xq61.qnpn13g2[ic]
print @q.xbgr.xq61.qnpn13g2[ib]
print @q.xbgr.xq61.qnpn13g2[ie]
print @q.xbgr.xq61.qnpn13g2[is]
print @r.xbgr.xq61.rsub[i]
print @c.xbgr.xq61.csub[i]
print @q.xbgr.xq62.qnpn13g2[ic]
print @q.xbgr.xq62.qnpn13g2[ib]
print @q.xbgr.xq62.qnpn13g2[ie]
print @q.xbgr.xq62.qnpn13g2[is]
print @r.xbgr.xq62.rsub[i]
print @c.xbgr.xq62.csub[i]
print @q.xbgr.xq63.qnpn13g2[ic]
print @q.xbgr.xq63.qnpn13g2[ib]
print @q.xbgr.xq63.qnpn13g2[ie]
print @q.xbgr.xq63.qnpn13g2[is]
print @r.xbgr.xq63.rsub[i]
print @c.xbgr.xq63.csub[i]
print @q.xbgr.xq64.qnpn13g2[ic]
print @q.xbgr.xq64.qnpn13g2[ib]
print @q.xbgr.xq64.qnpn13g2[ie]
print @q.xbgr.xq64.qnpn13g2[is]
print @r.xbgr.xq64.rsub[i]
print @c.xbgr.xq64.csub[i]
print @q.xbgr.xq65.qnpn13g2[ic]
print @q.xbgr.xq65.qnpn13g2[ib]
print @q.xbgr.xq65.qnpn13g2[ie]
print @q.xbgr.xq65.qnpn13g2[is]
print @r.xbgr.xq65.rsub[i]
print @c.xbgr.xq65.csub[i]
print @q.xbgr.xq66.qnpn13g2[ic]
print @q.xbgr.xq66.qnpn13g2[ib]
print @q.xbgr.xq66.qnpn13g2[ie]
print @q.xbgr.xq66.qnpn13g2[is]
print @r.xbgr.xq66.rsub[i]
print @c.xbgr.xq66.csub[i]
print @q.xbgr.xq67.qnpn13g2[ic]
print @q.xbgr.xq67.qnpn13g2[ib]
print @q.xbgr.xq67.qnpn13g2[ie]
print @q.xbgr.xq67.qnpn13g2[is]
print @r.xbgr.xq67.rsub[i]
print @c.xbgr.xq67.csub[i]
print @q.xbgr.xq68.qnpn13g2[ic]
print @q.xbgr.xq68.qnpn13g2[ib]
print @q.xbgr.xq68.qnpn13g2[ie]
print @q.xbgr.xq68.qnpn13g2[is]
print @r.xbgr.xq68.rsub[i]
print @c.xbgr.xq68.csub[i]
print @q.xbgr.xq69.qnpn13g2[ic]
print @q.xbgr.xq69.qnpn13g2[ib]
print @q.xbgr.xq69.qnpn13g2[ie]
print @q.xbgr.xq69.qnpn13g2[is]
print @r.xbgr.xq69.rsub[i]
print @c.xbgr.xq69.csub[i]
print @q.xbgr.xq70.qnpn13g2[ic]
print @q.xbgr.xq70.qnpn13g2[ib]
print @q.xbgr.xq70.qnpn13g2[ie]
print @q.xbgr.xq70.qnpn13g2[is]
print @r.xbgr.xq70.rsub[i]
print @c.xbgr.xq70.csub[i]
print @q.xbgr.xq71.qnpn13g2[ic]
print @q.xbgr.xq71.qnpn13g2[ib]
print @q.xbgr.xq71.qnpn13g2[ie]
print @q.xbgr.xq71.qnpn13g2[is]
print @r.xbgr.xq71.rsub[i]
print @c.xbgr.xq71.csub[i]
print @q.xbgr.xq72.qnpn13g2[ic]
print @q.xbgr.xq72.qnpn13g2[ib]
print @q.xbgr.xq72.qnpn13g2[ie]
print @q.xbgr.xq72.qnpn13g2[is]
print @r.xbgr.xq72.rsub[i]
print @c.xbgr.xq72.csub[i]
print @q.xbgr.xq73.qnpn13g2[ic]
print @q.xbgr.xq73.qnpn13g2[ib]
print @q.xbgr.xq73.qnpn13g2[ie]
print @q.xbgr.xq73.qnpn13g2[is]
print @r.xbgr.xq73.rsub[i]
print @c.xbgr.xq73.csub[i]
print @q.xbgr.xq74.qnpn13g2[ic]
print @q.xbgr.xq74.qnpn13g2[ib]
print @q.xbgr.xq74.qnpn13g2[ie]
print @q.xbgr.xq74.qnpn13g2[is]
print @r.xbgr.xq74.rsub[i]
print @c.xbgr.xq74.csub[i]
print @q.xbgr.xq75.qnpn13g2[ic]
print @q.xbgr.xq75.qnpn13g2[ib]
print @q.xbgr.xq75.qnpn13g2[ie]
print @q.xbgr.xq75.qnpn13g2[is]
print @r.xbgr.xq75.rsub[i]
print @c.xbgr.xq75.csub[i]
print @q.xbgr.xq76.qnpn13g2[ic]
print @q.xbgr.xq76.qnpn13g2[ib]
print @q.xbgr.xq76.qnpn13g2[ie]
print @q.xbgr.xq76.qnpn13g2[is]
print @r.xbgr.xq76.rsub[i]
print @c.xbgr.xq76.csub[i]
print @n.xbgr.xr77.nr1[ibody]
print @n.xbgr.xr78.nr1[ibody]
print @n.xbgr.xr79.nr1[ibody]
print @n.xbgr.xr80.nr1[ibody]
print @n.xbgr.xr81.nr1[ibody]
print @n.xbgr.xr82.nr1[ibody]
print @n.xbgr.xr83.nr1[ibody]
print @n.xbgr.xr84.nr1[ibody]
print @n.xbgr.xr85.nr1[ibody]
print @n.xbgr.xr86.nr1[ibody]
print @n.xbgr.xr16_u2.nr1[ibody]
print @n.xbgr.xr16_u3.nr1[ibody]
print @n.xbgr.xr16_u4.nr1[ibody]
print @n.xbgr.xr16_u5.nr1[ibody]
print @n.xbgr.xr16_u6.nr1[ibody]
print @n.xbgr.xr16_u7.nr1[ibody]
print @n.xbgr.xr16_u8.nr1[ibody]
print @n.xbgr.xr16_u9.nr1[ibody]
print @n.xbgr.xr16_u10.nr1[ibody]
print @n.xbgr.xr16_u11.nr1[ibody]
print @n.xbgr.xr16_u12.nr1[ibody]
print @n.xbgr.xr16_u13.nr1[ibody]
print @n.xbgr.xr16_u14.nr1[ibody]
print @n.xbgr.xr16_u15.nr1[ibody]
print @n.xbgr.xr16_u16.nr1[ibody]
print @n.xbgr.xr16_u17.nr1[ibody]
print @n.xbgr.xr16_u18.nr1[ibody]
print @n.xbgr.xr16_u19.nr1[ibody]
print @n.xbgr.xr16_u20.nr1[ibody]
print @n.xbgr.xr16_u21.nr1[ibody]
print @n.xbgr.xr16_u22.nr1[ibody]
print @n.xbgr.xr16_u23.nr1[ibody]
print @n.xbgr.xr16_u24.nr1[ibody]
print @n.xbgr.xr17_u2.nr1[ibody]
print @n.xbgr.xr17_u3.nr1[ibody]
print @n.xbgr.xr17_u4.nr1[ibody]
print @n.xbgr.xr18_u2.nr1[ibody]
print @n.xbgr.xr18_u3.nr1[ibody]
print @n.xbgr.xr18_u4.nr1[ibody]
print @n.xbgr.xr19_u2.nr1[ibody]
print @n.xbgr.xr19_u3.nr1[ibody]
print @n.xbgr.xr19_u4.nr1[ibody]
print @n.xbgr.xr20_u2.nr1[ibody]
print @n.xbgr.xr20_u3.nr1[ibody]
print @n.xbgr.xr20_u4.nr1[ibody]
print @n.xbgr.xr21_u2.nr1[ibody]
print @n.xbgr.xr21_u3.nr1[ibody]
print @n.xbgr.xr21_u4.nr1[ibody]
print @n.xbgr.xr22_u2.nr1[ibody]
print @n.xbgr.xr22_u3.nr1[ibody]
print @n.xbgr.xr22_u4.nr1[ibody]
print @n.xbgr.xr23_u2.nr1[ibody]
print @n.xbgr.xr23_u3.nr1[ibody]
print @n.xbgr.xr23_u4.nr1[ibody]
print @n.xbgr.xr23_u5.nr1[ibody]
print @n.xbgr.xr23_u6.nr1[ibody]
print @n.xbgr.xr23_u7.nr1[ibody]
print @n.xbgr.xr23_u8.nr1[ibody]
print @n.xbgr.xr23_u9.nr1[ibody]
print @n.xbgr.xr23_u10.nr1[ibody]
print @n.xbgr.xr23_u11.nr1[ibody]
print @n.xbgr.xr23_u12.nr1[ibody]
print @n.xbgr.xr23_u13.nr1[ibody]
print @n.xbgr.xr23_u14.nr1[ibody]
print @n.xbgr.xr23_u15.nr1[ibody]
print @n.xbgr.xr23_u16.nr1[ibody]
print @n.xbgr.xr23_u17.nr1[ibody]
print @n.xbgr.xr23_u18.nr1[ibody]
print @n.xbgr.xr23_u19.nr1[ibody]
print @n.xbgr.xr23_u20.nr1[ibody]
print @n.xbgr.xr23_u21.nr1[ibody]
print @n.xbgr.xr23_u22.nr1[ibody]
print @n.xbgr.xr23_u23.nr1[ibody]
print @n.xbgr.xr23_u24.nr1[ibody]
print @n.xbgr.xr24_u2.nr1[ibody]
print @n.xbgr.xr24_u3.nr1[ibody]
print @n.xbgr.xr24_u4.nr1[ibody]
print @n.xbgr.xr24_u5.nr1[ibody]
print @n.xbgr.xr24_u6.nr1[ibody]
print @n.xbgr.xr24_u7.nr1[ibody]
print @n.xbgr.xr24_u8.nr1[ibody]
print @n.xbgr.xr24_u9.nr1[ibody]
print @n.xbgr.xr24_u10.nr1[ibody]
print @n.xbgr.xr24_u11.nr1[ibody]
print @n.xbgr.xr24_u12.nr1[ibody]
print @n.xbgr.xr24_u13.nr1[ibody]
print @n.xbgr.xr24_u14.nr1[ibody]
print @n.xbgr.xr24_u15.nr1[ibody]
print @n.xbgr.xr24_u16.nr1[ibody]
print @n.xbgr.xr24_u17.nr1[ibody]
print @n.xbgr.xr24_u18.nr1[ibody]
print @n.xbgr.xr24_u19.nr1[ibody]
print @n.xbgr.xr24_u20.nr1[ibody]
print @n.xbgr.xr24_u21.nr1[ibody]
print @n.xbgr.xr24_u22.nr1[ibody]
print @n.xbgr.xr24_u23.nr1[ibody]
print @n.xbgr.xr24_u24.nr1[ibody]
print @n.xbgr.xr25_u2.nr1[ibody]
print @n.xbgr.xr25_u3.nr1[ibody]
print @n.xbgr.xr25_u4.nr1[ibody]
print @n.xbgr.xr25_u5.nr1[ibody]
print @n.xbgr.xr25_u6.nr1[ibody]
print @n.xbgr.xr25_u7.nr1[ibody]
print @n.xbgr.xr25_u8.nr1[ibody]
print @n.xbgr.xr25_u9.nr1[ibody]
print @n.xbgr.xr25_u10.nr1[ibody]
print @n.xbgr.xr25_u11.nr1[ibody]
print @n.xbgr.xr25_u12.nr1[ibody]
print @n.xbgr.xr25_u13.nr1[ibody]
print @n.xbgr.xr25_u14.nr1[ibody]
print @n.xbgr.xr25_u15.nr1[ibody]
print @n.xbgr.xr25_u16.nr1[ibody]
print @n.xbgr.xr25_u17.nr1[ibody]
print @n.xbgr.xr25_u18.nr1[ibody]
print @n.xbgr.xr25_u19.nr1[ibody]
print @n.xbgr.xr25_u20.nr1[ibody]
print @n.xbgr.xr25_u21.nr1[ibody]
print @n.xbgr.xr25_u22.nr1[ibody]
print @n.xbgr.xr25_u23.nr1[ibody]
print @n.xbgr.xr25_u24.nr1[ibody]
print @n.xbgr.xr26_u2.nr1[ibody]
print @n.xbgr.xr26_u3.nr1[ibody]
print @n.xbgr.xr26_u4.nr1[ibody]
print @n.xbgr.xr26_u5.nr1[ibody]
print @n.xbgr.xr26_u6.nr1[ibody]
print @n.xbgr.xr26_u7.nr1[ibody]
print @n.xbgr.xr26_u8.nr1[ibody]
print @n.xbgr.xr26_u9.nr1[ibody]
print @n.xbgr.xr26_u10.nr1[ibody]
print @n.xbgr.xr26_u11.nr1[ibody]
print @n.xbgr.xr26_u12.nr1[ibody]
print @n.xbgr.xr26_u13.nr1[ibody]
print @n.xbgr.xr26_u14.nr1[ibody]
print @n.xbgr.xr26_u15.nr1[ibody]
print @n.xbgr.xr26_u16.nr1[ibody]
print @n.xbgr.xr26_u17.nr1[ibody]
print @n.xbgr.xr26_u18.nr1[ibody]
print @n.xbgr.xr26_u19.nr1[ibody]
print @n.xbgr.xr26_u20.nr1[ibody]
print @n.xbgr.xr26_u21.nr1[ibody]
print @n.xbgr.xr26_u22.nr1[ibody]
print @n.xbgr.xr26_u23.nr1[ibody]
print @n.xbgr.xr26_u24.nr1[ibody]
print @n.xbgr.xm34_u2.nsg13_hv_nmos[ide]
print @n.xbgr.xm34_u2.nsg13_hv_nmos[ige]
print @n.xbgr.xm34_u2.nsg13_hv_nmos[ise]
print @n.xbgr.xm34_u2.nsg13_hv_nmos[ibe]
print @n.xbgr.xm34_u2.nsg13_hv_nmos[ctype]
print @n.xbgr.xm34_u3.nsg13_hv_nmos[ide]
print @n.xbgr.xm34_u3.nsg13_hv_nmos[ige]
print @n.xbgr.xm34_u3.nsg13_hv_nmos[ise]
print @n.xbgr.xm34_u3.nsg13_hv_nmos[ibe]
print @n.xbgr.xm34_u3.nsg13_hv_nmos[ctype]
print @n.xbgr.xm34_u4.nsg13_hv_nmos[ide]
print @n.xbgr.xm34_u4.nsg13_hv_nmos[ige]
print @n.xbgr.xm34_u4.nsg13_hv_nmos[ise]
print @n.xbgr.xm34_u4.nsg13_hv_nmos[ibe]
print @n.xbgr.xm34_u4.nsg13_hv_nmos[ctype]
print @n.xbgr.xm34_u5.nsg13_hv_nmos[ide]
print @n.xbgr.xm34_u5.nsg13_hv_nmos[ige]
print @n.xbgr.xm34_u5.nsg13_hv_nmos[ise]
print @n.xbgr.xm34_u5.nsg13_hv_nmos[ibe]
print @n.xbgr.xm34_u5.nsg13_hv_nmos[ctype]
print @n.xbgr.xm34_u6.nsg13_hv_nmos[ide]
print @n.xbgr.xm34_u6.nsg13_hv_nmos[ige]
print @n.xbgr.xm34_u6.nsg13_hv_nmos[ise]
print @n.xbgr.xm34_u6.nsg13_hv_nmos[ibe]
print @n.xbgr.xm34_u6.nsg13_hv_nmos[ctype]
print @n.xbgr.xm34_u7.nsg13_hv_nmos[ide]
print @n.xbgr.xm34_u7.nsg13_hv_nmos[ige]
print @n.xbgr.xm34_u7.nsg13_hv_nmos[ise]
print @n.xbgr.xm34_u7.nsg13_hv_nmos[ibe]
print @n.xbgr.xm34_u7.nsg13_hv_nmos[ctype]
print @n.xbgr.xm34_u8.nsg13_hv_nmos[ide]
print @n.xbgr.xm34_u8.nsg13_hv_nmos[ige]
print @n.xbgr.xm34_u8.nsg13_hv_nmos[ise]
print @n.xbgr.xm34_u8.nsg13_hv_nmos[ibe]
print @n.xbgr.xm34_u8.nsg13_hv_nmos[ctype]
print @n.xbgr.xm34_u9.nsg13_hv_nmos[ide]
print @n.xbgr.xm34_u9.nsg13_hv_nmos[ige]
print @n.xbgr.xm34_u9.nsg13_hv_nmos[ise]
print @n.xbgr.xm34_u9.nsg13_hv_nmos[ibe]
print @n.xbgr.xm34_u9.nsg13_hv_nmos[ctype]
print @n.xbgr.xm34_u10.nsg13_hv_nmos[ide]
print @n.xbgr.xm34_u10.nsg13_hv_nmos[ige]
print @n.xbgr.xm34_u10.nsg13_hv_nmos[ise]
print @n.xbgr.xm34_u10.nsg13_hv_nmos[ibe]
print @n.xbgr.xm34_u10.nsg13_hv_nmos[ctype]
print @n.xbgr.xm34_u11.nsg13_hv_nmos[ide]
print @n.xbgr.xm34_u11.nsg13_hv_nmos[ige]
print @n.xbgr.xm34_u11.nsg13_hv_nmos[ise]
print @n.xbgr.xm34_u11.nsg13_hv_nmos[ibe]
print @n.xbgr.xm34_u11.nsg13_hv_nmos[ctype]
print @n.xbgr.xm34_u12.nsg13_hv_nmos[ide]
print @n.xbgr.xm34_u12.nsg13_hv_nmos[ige]
print @n.xbgr.xm34_u12.nsg13_hv_nmos[ise]
print @n.xbgr.xm34_u12.nsg13_hv_nmos[ibe]
print @n.xbgr.xm34_u12.nsg13_hv_nmos[ctype]
print @n.xbgr.xm34_u13.nsg13_hv_nmos[ide]
print @n.xbgr.xm34_u13.nsg13_hv_nmos[ige]
print @n.xbgr.xm34_u13.nsg13_hv_nmos[ise]
print @n.xbgr.xm34_u13.nsg13_hv_nmos[ibe]
print @n.xbgr.xm34_u13.nsg13_hv_nmos[ctype]
print @n.xbgr.xm34_u14.nsg13_hv_nmos[ide]
print @n.xbgr.xm34_u14.nsg13_hv_nmos[ige]
print @n.xbgr.xm34_u14.nsg13_hv_nmos[ise]
print @n.xbgr.xm34_u14.nsg13_hv_nmos[ibe]
print @n.xbgr.xm34_u14.nsg13_hv_nmos[ctype]
print @n.xbgr.xm34_u15.nsg13_hv_nmos[ide]
print @n.xbgr.xm34_u15.nsg13_hv_nmos[ige]
print @n.xbgr.xm34_u15.nsg13_hv_nmos[ise]
print @n.xbgr.xm34_u15.nsg13_hv_nmos[ibe]
print @n.xbgr.xm34_u15.nsg13_hv_nmos[ctype]
print @n.xbgr.xm34_u16.nsg13_hv_nmos[ide]
print @n.xbgr.xm34_u16.nsg13_hv_nmos[ige]
print @n.xbgr.xm34_u16.nsg13_hv_nmos[ise]
print @n.xbgr.xm34_u16.nsg13_hv_nmos[ibe]
print @n.xbgr.xm34_u16.nsg13_hv_nmos[ctype]
print @n.xbgr.xm34_u17.nsg13_hv_nmos[ide]
print @n.xbgr.xm34_u17.nsg13_hv_nmos[ige]
print @n.xbgr.xm34_u17.nsg13_hv_nmos[ise]
print @n.xbgr.xm34_u17.nsg13_hv_nmos[ibe]
print @n.xbgr.xm34_u17.nsg13_hv_nmos[ctype]
print @n.xbgr.xm34_u18.nsg13_hv_nmos[ide]
print @n.xbgr.xm34_u18.nsg13_hv_nmos[ige]
print @n.xbgr.xm34_u18.nsg13_hv_nmos[ise]
print @n.xbgr.xm34_u18.nsg13_hv_nmos[ibe]
print @n.xbgr.xm34_u18.nsg13_hv_nmos[ctype]
print @n.xbgr.xm34_u19.nsg13_hv_nmos[ide]
print @n.xbgr.xm34_u19.nsg13_hv_nmos[ige]
print @n.xbgr.xm34_u19.nsg13_hv_nmos[ise]
print @n.xbgr.xm34_u19.nsg13_hv_nmos[ibe]
print @n.xbgr.xm34_u19.nsg13_hv_nmos[ctype]
print @n.xbgr.xm34_u20.nsg13_hv_nmos[ide]
print @n.xbgr.xm34_u20.nsg13_hv_nmos[ige]
print @n.xbgr.xm34_u20.nsg13_hv_nmos[ise]
print @n.xbgr.xm34_u20.nsg13_hv_nmos[ibe]
print @n.xbgr.xm34_u20.nsg13_hv_nmos[ctype]
print @n.xbgr.xm34_u21.nsg13_hv_nmos[ide]
print @n.xbgr.xm34_u21.nsg13_hv_nmos[ige]
print @n.xbgr.xm34_u21.nsg13_hv_nmos[ise]
print @n.xbgr.xm34_u21.nsg13_hv_nmos[ibe]
print @n.xbgr.xm34_u21.nsg13_hv_nmos[ctype]
print @n.xbgr.xm34_u22.nsg13_hv_nmos[ide]
print @n.xbgr.xm34_u22.nsg13_hv_nmos[ige]
print @n.xbgr.xm34_u22.nsg13_hv_nmos[ise]
print @n.xbgr.xm34_u22.nsg13_hv_nmos[ibe]
print @n.xbgr.xm34_u22.nsg13_hv_nmos[ctype]
print @n.xbgr.xm34_u23.nsg13_hv_nmos[ide]
print @n.xbgr.xm34_u23.nsg13_hv_nmos[ige]
print @n.xbgr.xm34_u23.nsg13_hv_nmos[ise]
print @n.xbgr.xm34_u23.nsg13_hv_nmos[ibe]
print @n.xbgr.xm34_u23.nsg13_hv_nmos[ctype]
print @n.xbgr.xm34_u24.nsg13_hv_nmos[ide]
print @n.xbgr.xm34_u24.nsg13_hv_nmos[ige]
print @n.xbgr.xm34_u24.nsg13_hv_nmos[ise]
print @n.xbgr.xm34_u24.nsg13_hv_nmos[ibe]
print @n.xbgr.xm34_u24.nsg13_hv_nmos[ctype]
print @n.xbgr.xm35_u2.nsg13_hv_nmos[ide]
print @n.xbgr.xm35_u2.nsg13_hv_nmos[ige]
print @n.xbgr.xm35_u2.nsg13_hv_nmos[ise]
print @n.xbgr.xm35_u2.nsg13_hv_nmos[ibe]
print @n.xbgr.xm35_u2.nsg13_hv_nmos[ctype]
print @n.xbgr.xm35_u3.nsg13_hv_nmos[ide]
print @n.xbgr.xm35_u3.nsg13_hv_nmos[ige]
print @n.xbgr.xm35_u3.nsg13_hv_nmos[ise]
print @n.xbgr.xm35_u3.nsg13_hv_nmos[ibe]
print @n.xbgr.xm35_u3.nsg13_hv_nmos[ctype]
print @n.xbgr.xm35_u4.nsg13_hv_nmos[ide]
print @n.xbgr.xm35_u4.nsg13_hv_nmos[ige]
print @n.xbgr.xm35_u4.nsg13_hv_nmos[ise]
print @n.xbgr.xm35_u4.nsg13_hv_nmos[ibe]
print @n.xbgr.xm35_u4.nsg13_hv_nmos[ctype]
print @n.xbgr.xm35_u5.nsg13_hv_nmos[ide]
print @n.xbgr.xm35_u5.nsg13_hv_nmos[ige]
print @n.xbgr.xm35_u5.nsg13_hv_nmos[ise]
print @n.xbgr.xm35_u5.nsg13_hv_nmos[ibe]
print @n.xbgr.xm35_u5.nsg13_hv_nmos[ctype]
print @n.xbgr.xm35_u6.nsg13_hv_nmos[ide]
print @n.xbgr.xm35_u6.nsg13_hv_nmos[ige]
print @n.xbgr.xm35_u6.nsg13_hv_nmos[ise]
print @n.xbgr.xm35_u6.nsg13_hv_nmos[ibe]
print @n.xbgr.xm35_u6.nsg13_hv_nmos[ctype]
print @n.xbgr.xm35_u7.nsg13_hv_nmos[ide]
print @n.xbgr.xm35_u7.nsg13_hv_nmos[ige]
print @n.xbgr.xm35_u7.nsg13_hv_nmos[ise]
print @n.xbgr.xm35_u7.nsg13_hv_nmos[ibe]
print @n.xbgr.xm35_u7.nsg13_hv_nmos[ctype]
print @n.xbgr.xm35_u8.nsg13_hv_nmos[ide]
print @n.xbgr.xm35_u8.nsg13_hv_nmos[ige]
print @n.xbgr.xm35_u8.nsg13_hv_nmos[ise]
print @n.xbgr.xm35_u8.nsg13_hv_nmos[ibe]
print @n.xbgr.xm35_u8.nsg13_hv_nmos[ctype]
print @n.xbgr.xm35_u9.nsg13_hv_nmos[ide]
print @n.xbgr.xm35_u9.nsg13_hv_nmos[ige]
print @n.xbgr.xm35_u9.nsg13_hv_nmos[ise]
print @n.xbgr.xm35_u9.nsg13_hv_nmos[ibe]
print @n.xbgr.xm35_u9.nsg13_hv_nmos[ctype]
print @n.xbgr.xm35_u10.nsg13_hv_nmos[ide]
print @n.xbgr.xm35_u10.nsg13_hv_nmos[ige]
print @n.xbgr.xm35_u10.nsg13_hv_nmos[ise]
print @n.xbgr.xm35_u10.nsg13_hv_nmos[ibe]
print @n.xbgr.xm35_u10.nsg13_hv_nmos[ctype]
print @n.xbgr.xm35_u11.nsg13_hv_nmos[ide]
print @n.xbgr.xm35_u11.nsg13_hv_nmos[ige]
print @n.xbgr.xm35_u11.nsg13_hv_nmos[ise]
print @n.xbgr.xm35_u11.nsg13_hv_nmos[ibe]
print @n.xbgr.xm35_u11.nsg13_hv_nmos[ctype]
print @n.xbgr.xm35_u12.nsg13_hv_nmos[ide]
print @n.xbgr.xm35_u12.nsg13_hv_nmos[ige]
print @n.xbgr.xm35_u12.nsg13_hv_nmos[ise]
print @n.xbgr.xm35_u12.nsg13_hv_nmos[ibe]
print @n.xbgr.xm35_u12.nsg13_hv_nmos[ctype]
print @n.xbgr.xm35_u13.nsg13_hv_nmos[ide]
print @n.xbgr.xm35_u13.nsg13_hv_nmos[ige]
print @n.xbgr.xm35_u13.nsg13_hv_nmos[ise]
print @n.xbgr.xm35_u13.nsg13_hv_nmos[ibe]
print @n.xbgr.xm35_u13.nsg13_hv_nmos[ctype]
print @n.xbgr.xm35_u14.nsg13_hv_nmos[ide]
print @n.xbgr.xm35_u14.nsg13_hv_nmos[ige]
print @n.xbgr.xm35_u14.nsg13_hv_nmos[ise]
print @n.xbgr.xm35_u14.nsg13_hv_nmos[ibe]
print @n.xbgr.xm35_u14.nsg13_hv_nmos[ctype]
print @n.xbgr.xm35_u15.nsg13_hv_nmos[ide]
print @n.xbgr.xm35_u15.nsg13_hv_nmos[ige]
print @n.xbgr.xm35_u15.nsg13_hv_nmos[ise]
print @n.xbgr.xm35_u15.nsg13_hv_nmos[ibe]
print @n.xbgr.xm35_u15.nsg13_hv_nmos[ctype]
print @n.xbgr.xm35_u16.nsg13_hv_nmos[ide]
print @n.xbgr.xm35_u16.nsg13_hv_nmos[ige]
print @n.xbgr.xm35_u16.nsg13_hv_nmos[ise]
print @n.xbgr.xm35_u16.nsg13_hv_nmos[ibe]
print @n.xbgr.xm35_u16.nsg13_hv_nmos[ctype]
print @n.xbgr.xm35_u17.nsg13_hv_nmos[ide]
print @n.xbgr.xm35_u17.nsg13_hv_nmos[ige]
print @n.xbgr.xm35_u17.nsg13_hv_nmos[ise]
print @n.xbgr.xm35_u17.nsg13_hv_nmos[ibe]
print @n.xbgr.xm35_u17.nsg13_hv_nmos[ctype]
print @n.xbgr.xm35_u18.nsg13_hv_nmos[ide]
print @n.xbgr.xm35_u18.nsg13_hv_nmos[ige]
print @n.xbgr.xm35_u18.nsg13_hv_nmos[ise]
print @n.xbgr.xm35_u18.nsg13_hv_nmos[ibe]
print @n.xbgr.xm35_u18.nsg13_hv_nmos[ctype]
print @n.xbgr.xm35_u19.nsg13_hv_nmos[ide]
print @n.xbgr.xm35_u19.nsg13_hv_nmos[ige]
print @n.xbgr.xm35_u19.nsg13_hv_nmos[ise]
print @n.xbgr.xm35_u19.nsg13_hv_nmos[ibe]
print @n.xbgr.xm35_u19.nsg13_hv_nmos[ctype]
print @n.xbgr.xm35_u20.nsg13_hv_nmos[ide]
print @n.xbgr.xm35_u20.nsg13_hv_nmos[ige]
print @n.xbgr.xm35_u20.nsg13_hv_nmos[ise]
print @n.xbgr.xm35_u20.nsg13_hv_nmos[ibe]
print @n.xbgr.xm35_u20.nsg13_hv_nmos[ctype]
print @n.xbgr.xm35_u21.nsg13_hv_nmos[ide]
print @n.xbgr.xm35_u21.nsg13_hv_nmos[ige]
print @n.xbgr.xm35_u21.nsg13_hv_nmos[ise]
print @n.xbgr.xm35_u21.nsg13_hv_nmos[ibe]
print @n.xbgr.xm35_u21.nsg13_hv_nmos[ctype]
print @n.xbgr.xm35_u22.nsg13_hv_nmos[ide]
print @n.xbgr.xm35_u22.nsg13_hv_nmos[ige]
print @n.xbgr.xm35_u22.nsg13_hv_nmos[ise]
print @n.xbgr.xm35_u22.nsg13_hv_nmos[ibe]
print @n.xbgr.xm35_u22.nsg13_hv_nmos[ctype]
print @n.xbgr.xm35_u23.nsg13_hv_nmos[ide]
print @n.xbgr.xm35_u23.nsg13_hv_nmos[ige]
print @n.xbgr.xm35_u23.nsg13_hv_nmos[ise]
print @n.xbgr.xm35_u23.nsg13_hv_nmos[ibe]
print @n.xbgr.xm35_u23.nsg13_hv_nmos[ctype]
print @n.xbgr.xm35_u24.nsg13_hv_nmos[ide]
print @n.xbgr.xm35_u24.nsg13_hv_nmos[ige]
print @n.xbgr.xm35_u24.nsg13_hv_nmos[ise]
print @n.xbgr.xm35_u24.nsg13_hv_nmos[ibe]
print @n.xbgr.xm35_u24.nsg13_hv_nmos[ctype]
print @n.xbgr.xm36_u2.nsg13_hv_nmos[ide]
print @n.xbgr.xm36_u2.nsg13_hv_nmos[ige]
print @n.xbgr.xm36_u2.nsg13_hv_nmos[ise]
print @n.xbgr.xm36_u2.nsg13_hv_nmos[ibe]
print @n.xbgr.xm36_u2.nsg13_hv_nmos[ctype]
print @n.xbgr.xm36_u3.nsg13_hv_nmos[ide]
print @n.xbgr.xm36_u3.nsg13_hv_nmos[ige]
print @n.xbgr.xm36_u3.nsg13_hv_nmos[ise]
print @n.xbgr.xm36_u3.nsg13_hv_nmos[ibe]
print @n.xbgr.xm36_u3.nsg13_hv_nmos[ctype]
print @n.xbgr.xm36_u4.nsg13_hv_nmos[ide]
print @n.xbgr.xm36_u4.nsg13_hv_nmos[ige]
print @n.xbgr.xm36_u4.nsg13_hv_nmos[ise]
print @n.xbgr.xm36_u4.nsg13_hv_nmos[ibe]
print @n.xbgr.xm36_u4.nsg13_hv_nmos[ctype]
print @n.xbgr.xm36_u5.nsg13_hv_nmos[ide]
print @n.xbgr.xm36_u5.nsg13_hv_nmos[ige]
print @n.xbgr.xm36_u5.nsg13_hv_nmos[ise]
print @n.xbgr.xm36_u5.nsg13_hv_nmos[ibe]
print @n.xbgr.xm36_u5.nsg13_hv_nmos[ctype]
print @n.xbgr.xm36_u6.nsg13_hv_nmos[ide]
print @n.xbgr.xm36_u6.nsg13_hv_nmos[ige]
print @n.xbgr.xm36_u6.nsg13_hv_nmos[ise]
print @n.xbgr.xm36_u6.nsg13_hv_nmos[ibe]
print @n.xbgr.xm36_u6.nsg13_hv_nmos[ctype]
print @n.xbgr.xm36_u7.nsg13_hv_nmos[ide]
print @n.xbgr.xm36_u7.nsg13_hv_nmos[ige]
print @n.xbgr.xm36_u7.nsg13_hv_nmos[ise]
print @n.xbgr.xm36_u7.nsg13_hv_nmos[ibe]
print @n.xbgr.xm36_u7.nsg13_hv_nmos[ctype]
print @n.xbgr.xm36_u8.nsg13_hv_nmos[ide]
print @n.xbgr.xm36_u8.nsg13_hv_nmos[ige]
print @n.xbgr.xm36_u8.nsg13_hv_nmos[ise]
print @n.xbgr.xm36_u8.nsg13_hv_nmos[ibe]
print @n.xbgr.xm36_u8.nsg13_hv_nmos[ctype]
print @n.xbgr.xm36_u9.nsg13_hv_nmos[ide]
print @n.xbgr.xm36_u9.nsg13_hv_nmos[ige]
print @n.xbgr.xm36_u9.nsg13_hv_nmos[ise]
print @n.xbgr.xm36_u9.nsg13_hv_nmos[ibe]
print @n.xbgr.xm36_u9.nsg13_hv_nmos[ctype]
print @n.xbgr.xm36_u10.nsg13_hv_nmos[ide]
print @n.xbgr.xm36_u10.nsg13_hv_nmos[ige]
print @n.xbgr.xm36_u10.nsg13_hv_nmos[ise]
print @n.xbgr.xm36_u10.nsg13_hv_nmos[ibe]
print @n.xbgr.xm36_u10.nsg13_hv_nmos[ctype]
print @n.xbgr.xm36_u11.nsg13_hv_nmos[ide]
print @n.xbgr.xm36_u11.nsg13_hv_nmos[ige]
print @n.xbgr.xm36_u11.nsg13_hv_nmos[ise]
print @n.xbgr.xm36_u11.nsg13_hv_nmos[ibe]
print @n.xbgr.xm36_u11.nsg13_hv_nmos[ctype]
print @n.xbgr.xm36_u12.nsg13_hv_nmos[ide]
print @n.xbgr.xm36_u12.nsg13_hv_nmos[ige]
print @n.xbgr.xm36_u12.nsg13_hv_nmos[ise]
print @n.xbgr.xm36_u12.nsg13_hv_nmos[ibe]
print @n.xbgr.xm36_u12.nsg13_hv_nmos[ctype]
print @n.xbgr.xm36_u13.nsg13_hv_nmos[ide]
print @n.xbgr.xm36_u13.nsg13_hv_nmos[ige]
print @n.xbgr.xm36_u13.nsg13_hv_nmos[ise]
print @n.xbgr.xm36_u13.nsg13_hv_nmos[ibe]
print @n.xbgr.xm36_u13.nsg13_hv_nmos[ctype]
print @n.xbgr.xm36_u14.nsg13_hv_nmos[ide]
print @n.xbgr.xm36_u14.nsg13_hv_nmos[ige]
print @n.xbgr.xm36_u14.nsg13_hv_nmos[ise]
print @n.xbgr.xm36_u14.nsg13_hv_nmos[ibe]
print @n.xbgr.xm36_u14.nsg13_hv_nmos[ctype]
print @n.xbgr.xm36_u15.nsg13_hv_nmos[ide]
print @n.xbgr.xm36_u15.nsg13_hv_nmos[ige]
print @n.xbgr.xm36_u15.nsg13_hv_nmos[ise]
print @n.xbgr.xm36_u15.nsg13_hv_nmos[ibe]
print @n.xbgr.xm36_u15.nsg13_hv_nmos[ctype]
print @n.xbgr.xm36_u16.nsg13_hv_nmos[ide]
print @n.xbgr.xm36_u16.nsg13_hv_nmos[ige]
print @n.xbgr.xm36_u16.nsg13_hv_nmos[ise]
print @n.xbgr.xm36_u16.nsg13_hv_nmos[ibe]
print @n.xbgr.xm36_u16.nsg13_hv_nmos[ctype]
print @n.xbgr.xm36_u17.nsg13_hv_nmos[ide]
print @n.xbgr.xm36_u17.nsg13_hv_nmos[ige]
print @n.xbgr.xm36_u17.nsg13_hv_nmos[ise]
print @n.xbgr.xm36_u17.nsg13_hv_nmos[ibe]
print @n.xbgr.xm36_u17.nsg13_hv_nmos[ctype]
print @n.xbgr.xm36_u18.nsg13_hv_nmos[ide]
print @n.xbgr.xm36_u18.nsg13_hv_nmos[ige]
print @n.xbgr.xm36_u18.nsg13_hv_nmos[ise]
print @n.xbgr.xm36_u18.nsg13_hv_nmos[ibe]
print @n.xbgr.xm36_u18.nsg13_hv_nmos[ctype]
print @n.xbgr.xm36_u19.nsg13_hv_nmos[ide]
print @n.xbgr.xm36_u19.nsg13_hv_nmos[ige]
print @n.xbgr.xm36_u19.nsg13_hv_nmos[ise]
print @n.xbgr.xm36_u19.nsg13_hv_nmos[ibe]
print @n.xbgr.xm36_u19.nsg13_hv_nmos[ctype]
print @n.xbgr.xm36_u20.nsg13_hv_nmos[ide]
print @n.xbgr.xm36_u20.nsg13_hv_nmos[ige]
print @n.xbgr.xm36_u20.nsg13_hv_nmos[ise]
print @n.xbgr.xm36_u20.nsg13_hv_nmos[ibe]
print @n.xbgr.xm36_u20.nsg13_hv_nmos[ctype]
print @n.xbgr.xm36_u21.nsg13_hv_nmos[ide]
print @n.xbgr.xm36_u21.nsg13_hv_nmos[ige]
print @n.xbgr.xm36_u21.nsg13_hv_nmos[ise]
print @n.xbgr.xm36_u21.nsg13_hv_nmos[ibe]
print @n.xbgr.xm36_u21.nsg13_hv_nmos[ctype]
print @n.xbgr.xm36_u22.nsg13_hv_nmos[ide]
print @n.xbgr.xm36_u22.nsg13_hv_nmos[ige]
print @n.xbgr.xm36_u22.nsg13_hv_nmos[ise]
print @n.xbgr.xm36_u22.nsg13_hv_nmos[ibe]
print @n.xbgr.xm36_u22.nsg13_hv_nmos[ctype]
print @n.xbgr.xm36_u23.nsg13_hv_nmos[ide]
print @n.xbgr.xm36_u23.nsg13_hv_nmos[ige]
print @n.xbgr.xm36_u23.nsg13_hv_nmos[ise]
print @n.xbgr.xm36_u23.nsg13_hv_nmos[ibe]
print @n.xbgr.xm36_u23.nsg13_hv_nmos[ctype]
print @n.xbgr.xm36_u24.nsg13_hv_nmos[ide]
print @n.xbgr.xm36_u24.nsg13_hv_nmos[ige]
print @n.xbgr.xm36_u24.nsg13_hv_nmos[ise]
print @n.xbgr.xm36_u24.nsg13_hv_nmos[ibe]
print @n.xbgr.xm36_u24.nsg13_hv_nmos[ctype]
print @n.xbgr.xm37_u2.nsg13_hv_nmos[ide]
print @n.xbgr.xm37_u2.nsg13_hv_nmos[ige]
print @n.xbgr.xm37_u2.nsg13_hv_nmos[ise]
print @n.xbgr.xm37_u2.nsg13_hv_nmos[ibe]
print @n.xbgr.xm37_u2.nsg13_hv_nmos[ctype]
print @n.xbgr.xm37_u3.nsg13_hv_nmos[ide]
print @n.xbgr.xm37_u3.nsg13_hv_nmos[ige]
print @n.xbgr.xm37_u3.nsg13_hv_nmos[ise]
print @n.xbgr.xm37_u3.nsg13_hv_nmos[ibe]
print @n.xbgr.xm37_u3.nsg13_hv_nmos[ctype]
print @n.xbgr.xm37_u4.nsg13_hv_nmos[ide]
print @n.xbgr.xm37_u4.nsg13_hv_nmos[ige]
print @n.xbgr.xm37_u4.nsg13_hv_nmos[ise]
print @n.xbgr.xm37_u4.nsg13_hv_nmos[ibe]
print @n.xbgr.xm37_u4.nsg13_hv_nmos[ctype]
print @n.xbgr.xm37_u5.nsg13_hv_nmos[ide]
print @n.xbgr.xm37_u5.nsg13_hv_nmos[ige]
print @n.xbgr.xm37_u5.nsg13_hv_nmos[ise]
print @n.xbgr.xm37_u5.nsg13_hv_nmos[ibe]
print @n.xbgr.xm37_u5.nsg13_hv_nmos[ctype]
print @n.xbgr.xm37_u6.nsg13_hv_nmos[ide]
print @n.xbgr.xm37_u6.nsg13_hv_nmos[ige]
print @n.xbgr.xm37_u6.nsg13_hv_nmos[ise]
print @n.xbgr.xm37_u6.nsg13_hv_nmos[ibe]
print @n.xbgr.xm37_u6.nsg13_hv_nmos[ctype]
print @n.xbgr.xm37_u7.nsg13_hv_nmos[ide]
print @n.xbgr.xm37_u7.nsg13_hv_nmos[ige]
print @n.xbgr.xm37_u7.nsg13_hv_nmos[ise]
print @n.xbgr.xm37_u7.nsg13_hv_nmos[ibe]
print @n.xbgr.xm37_u7.nsg13_hv_nmos[ctype]
print @n.xbgr.xm37_u8.nsg13_hv_nmos[ide]
print @n.xbgr.xm37_u8.nsg13_hv_nmos[ige]
print @n.xbgr.xm37_u8.nsg13_hv_nmos[ise]
print @n.xbgr.xm37_u8.nsg13_hv_nmos[ibe]
print @n.xbgr.xm37_u8.nsg13_hv_nmos[ctype]
print @n.xbgr.xm37_u9.nsg13_hv_nmos[ide]
print @n.xbgr.xm37_u9.nsg13_hv_nmos[ige]
print @n.xbgr.xm37_u9.nsg13_hv_nmos[ise]
print @n.xbgr.xm37_u9.nsg13_hv_nmos[ibe]
print @n.xbgr.xm37_u9.nsg13_hv_nmos[ctype]
print @n.xbgr.xm37_u10.nsg13_hv_nmos[ide]
print @n.xbgr.xm37_u10.nsg13_hv_nmos[ige]
print @n.xbgr.xm37_u10.nsg13_hv_nmos[ise]
print @n.xbgr.xm37_u10.nsg13_hv_nmos[ibe]
print @n.xbgr.xm37_u10.nsg13_hv_nmos[ctype]
print @n.xbgr.xm37_u11.nsg13_hv_nmos[ide]
print @n.xbgr.xm37_u11.nsg13_hv_nmos[ige]
print @n.xbgr.xm37_u11.nsg13_hv_nmos[ise]
print @n.xbgr.xm37_u11.nsg13_hv_nmos[ibe]
print @n.xbgr.xm37_u11.nsg13_hv_nmos[ctype]
print @n.xbgr.xm37_u12.nsg13_hv_nmos[ide]
print @n.xbgr.xm37_u12.nsg13_hv_nmos[ige]
print @n.xbgr.xm37_u12.nsg13_hv_nmos[ise]
print @n.xbgr.xm37_u12.nsg13_hv_nmos[ibe]
print @n.xbgr.xm37_u12.nsg13_hv_nmos[ctype]
print @n.xbgr.xm37_u13.nsg13_hv_nmos[ide]
print @n.xbgr.xm37_u13.nsg13_hv_nmos[ige]
print @n.xbgr.xm37_u13.nsg13_hv_nmos[ise]
print @n.xbgr.xm37_u13.nsg13_hv_nmos[ibe]
print @n.xbgr.xm37_u13.nsg13_hv_nmos[ctype]
print @n.xbgr.xm37_u14.nsg13_hv_nmos[ide]
print @n.xbgr.xm37_u14.nsg13_hv_nmos[ige]
print @n.xbgr.xm37_u14.nsg13_hv_nmos[ise]
print @n.xbgr.xm37_u14.nsg13_hv_nmos[ibe]
print @n.xbgr.xm37_u14.nsg13_hv_nmos[ctype]
print @n.xbgr.xm37_u15.nsg13_hv_nmos[ide]
print @n.xbgr.xm37_u15.nsg13_hv_nmos[ige]
print @n.xbgr.xm37_u15.nsg13_hv_nmos[ise]
print @n.xbgr.xm37_u15.nsg13_hv_nmos[ibe]
print @n.xbgr.xm37_u15.nsg13_hv_nmos[ctype]
print @n.xbgr.xm37_u16.nsg13_hv_nmos[ide]
print @n.xbgr.xm37_u16.nsg13_hv_nmos[ige]
print @n.xbgr.xm37_u16.nsg13_hv_nmos[ise]
print @n.xbgr.xm37_u16.nsg13_hv_nmos[ibe]
print @n.xbgr.xm37_u16.nsg13_hv_nmos[ctype]
print @n.xbgr.xm37_u17.nsg13_hv_nmos[ide]
print @n.xbgr.xm37_u17.nsg13_hv_nmos[ige]
print @n.xbgr.xm37_u17.nsg13_hv_nmos[ise]
print @n.xbgr.xm37_u17.nsg13_hv_nmos[ibe]
print @n.xbgr.xm37_u17.nsg13_hv_nmos[ctype]
print @n.xbgr.xm37_u18.nsg13_hv_nmos[ide]
print @n.xbgr.xm37_u18.nsg13_hv_nmos[ige]
print @n.xbgr.xm37_u18.nsg13_hv_nmos[ise]
print @n.xbgr.xm37_u18.nsg13_hv_nmos[ibe]
print @n.xbgr.xm37_u18.nsg13_hv_nmos[ctype]
print @n.xbgr.xm37_u19.nsg13_hv_nmos[ide]
print @n.xbgr.xm37_u19.nsg13_hv_nmos[ige]
print @n.xbgr.xm37_u19.nsg13_hv_nmos[ise]
print @n.xbgr.xm37_u19.nsg13_hv_nmos[ibe]
print @n.xbgr.xm37_u19.nsg13_hv_nmos[ctype]
print @n.xbgr.xm37_u20.nsg13_hv_nmos[ide]
print @n.xbgr.xm37_u20.nsg13_hv_nmos[ige]
print @n.xbgr.xm37_u20.nsg13_hv_nmos[ise]
print @n.xbgr.xm37_u20.nsg13_hv_nmos[ibe]
print @n.xbgr.xm37_u20.nsg13_hv_nmos[ctype]
print @n.xbgr.xm37_u21.nsg13_hv_nmos[ide]
print @n.xbgr.xm37_u21.nsg13_hv_nmos[ige]
print @n.xbgr.xm37_u21.nsg13_hv_nmos[ise]
print @n.xbgr.xm37_u21.nsg13_hv_nmos[ibe]
print @n.xbgr.xm37_u21.nsg13_hv_nmos[ctype]
print @n.xbgr.xm37_u22.nsg13_hv_nmos[ide]
print @n.xbgr.xm37_u22.nsg13_hv_nmos[ige]
print @n.xbgr.xm37_u22.nsg13_hv_nmos[ise]
print @n.xbgr.xm37_u22.nsg13_hv_nmos[ibe]
print @n.xbgr.xm37_u22.nsg13_hv_nmos[ctype]
print @n.xbgr.xm37_u23.nsg13_hv_nmos[ide]
print @n.xbgr.xm37_u23.nsg13_hv_nmos[ige]
print @n.xbgr.xm37_u23.nsg13_hv_nmos[ise]
print @n.xbgr.xm37_u23.nsg13_hv_nmos[ibe]
print @n.xbgr.xm37_u23.nsg13_hv_nmos[ctype]
print @n.xbgr.xm37_u24.nsg13_hv_nmos[ide]
print @n.xbgr.xm37_u24.nsg13_hv_nmos[ige]
print @n.xbgr.xm37_u24.nsg13_hv_nmos[ise]
print @n.xbgr.xm37_u24.nsg13_hv_nmos[ibe]
print @n.xbgr.xm37_u24.nsg13_hv_nmos[ctype]
print @n.xbgr.xm38_u2.nsg13_hv_pmos[ide]
print @n.xbgr.xm38_u2.nsg13_hv_pmos[ige]
print @n.xbgr.xm38_u2.nsg13_hv_pmos[ise]
print @n.xbgr.xm38_u2.nsg13_hv_pmos[ibe]
print @n.xbgr.xm38_u2.nsg13_hv_pmos[ctype]
print @n.xbgr.xm38_u3.nsg13_hv_pmos[ide]
print @n.xbgr.xm38_u3.nsg13_hv_pmos[ige]
print @n.xbgr.xm38_u3.nsg13_hv_pmos[ise]
print @n.xbgr.xm38_u3.nsg13_hv_pmos[ibe]
print @n.xbgr.xm38_u3.nsg13_hv_pmos[ctype]
print @n.xbgr.xm38_u4.nsg13_hv_pmos[ide]
print @n.xbgr.xm38_u4.nsg13_hv_pmos[ige]
print @n.xbgr.xm38_u4.nsg13_hv_pmos[ise]
print @n.xbgr.xm38_u4.nsg13_hv_pmos[ibe]
print @n.xbgr.xm38_u4.nsg13_hv_pmos[ctype]
print @n.xbgr.xm38_u5.nsg13_hv_pmos[ide]
print @n.xbgr.xm38_u5.nsg13_hv_pmos[ige]
print @n.xbgr.xm38_u5.nsg13_hv_pmos[ise]
print @n.xbgr.xm38_u5.nsg13_hv_pmos[ibe]
print @n.xbgr.xm38_u5.nsg13_hv_pmos[ctype]
print @n.xbgr.xm38_u6.nsg13_hv_pmos[ide]
print @n.xbgr.xm38_u6.nsg13_hv_pmos[ige]
print @n.xbgr.xm38_u6.nsg13_hv_pmos[ise]
print @n.xbgr.xm38_u6.nsg13_hv_pmos[ibe]
print @n.xbgr.xm38_u6.nsg13_hv_pmos[ctype]
print @n.xbgr.xm38_u7.nsg13_hv_pmos[ide]
print @n.xbgr.xm38_u7.nsg13_hv_pmos[ige]
print @n.xbgr.xm38_u7.nsg13_hv_pmos[ise]
print @n.xbgr.xm38_u7.nsg13_hv_pmos[ibe]
print @n.xbgr.xm38_u7.nsg13_hv_pmos[ctype]
print @n.xbgr.xm38_u8.nsg13_hv_pmos[ide]
print @n.xbgr.xm38_u8.nsg13_hv_pmos[ige]
print @n.xbgr.xm38_u8.nsg13_hv_pmos[ise]
print @n.xbgr.xm38_u8.nsg13_hv_pmos[ibe]
print @n.xbgr.xm38_u8.nsg13_hv_pmos[ctype]
print @n.xbgr.xm38_u9.nsg13_hv_pmos[ide]
print @n.xbgr.xm38_u9.nsg13_hv_pmos[ige]
print @n.xbgr.xm38_u9.nsg13_hv_pmos[ise]
print @n.xbgr.xm38_u9.nsg13_hv_pmos[ibe]
print @n.xbgr.xm38_u9.nsg13_hv_pmos[ctype]
print @n.xbgr.xm38_u10.nsg13_hv_pmos[ide]
print @n.xbgr.xm38_u10.nsg13_hv_pmos[ige]
print @n.xbgr.xm38_u10.nsg13_hv_pmos[ise]
print @n.xbgr.xm38_u10.nsg13_hv_pmos[ibe]
print @n.xbgr.xm38_u10.nsg13_hv_pmos[ctype]
print @n.xbgr.xm38_u11.nsg13_hv_pmos[ide]
print @n.xbgr.xm38_u11.nsg13_hv_pmos[ige]
print @n.xbgr.xm38_u11.nsg13_hv_pmos[ise]
print @n.xbgr.xm38_u11.nsg13_hv_pmos[ibe]
print @n.xbgr.xm38_u11.nsg13_hv_pmos[ctype]
print @n.xbgr.xm38_u12.nsg13_hv_pmos[ide]
print @n.xbgr.xm38_u12.nsg13_hv_pmos[ige]
print @n.xbgr.xm38_u12.nsg13_hv_pmos[ise]
print @n.xbgr.xm38_u12.nsg13_hv_pmos[ibe]
print @n.xbgr.xm38_u12.nsg13_hv_pmos[ctype]
print @n.xbgr.xm38_u13.nsg13_hv_pmos[ide]
print @n.xbgr.xm38_u13.nsg13_hv_pmos[ige]
print @n.xbgr.xm38_u13.nsg13_hv_pmos[ise]
print @n.xbgr.xm38_u13.nsg13_hv_pmos[ibe]
print @n.xbgr.xm38_u13.nsg13_hv_pmos[ctype]
print @n.xbgr.xm38_u14.nsg13_hv_pmos[ide]
print @n.xbgr.xm38_u14.nsg13_hv_pmos[ige]
print @n.xbgr.xm38_u14.nsg13_hv_pmos[ise]
print @n.xbgr.xm38_u14.nsg13_hv_pmos[ibe]
print @n.xbgr.xm38_u14.nsg13_hv_pmos[ctype]
print @n.xbgr.xm38_u15.nsg13_hv_pmos[ide]
print @n.xbgr.xm38_u15.nsg13_hv_pmos[ige]
print @n.xbgr.xm38_u15.nsg13_hv_pmos[ise]
print @n.xbgr.xm38_u15.nsg13_hv_pmos[ibe]
print @n.xbgr.xm38_u15.nsg13_hv_pmos[ctype]
print @n.xbgr.xm38_u16.nsg13_hv_pmos[ide]
print @n.xbgr.xm38_u16.nsg13_hv_pmos[ige]
print @n.xbgr.xm38_u16.nsg13_hv_pmos[ise]
print @n.xbgr.xm38_u16.nsg13_hv_pmos[ibe]
print @n.xbgr.xm38_u16.nsg13_hv_pmos[ctype]
print @n.xbgr.xm38_u17.nsg13_hv_pmos[ide]
print @n.xbgr.xm38_u17.nsg13_hv_pmos[ige]
print @n.xbgr.xm38_u17.nsg13_hv_pmos[ise]
print @n.xbgr.xm38_u17.nsg13_hv_pmos[ibe]
print @n.xbgr.xm38_u17.nsg13_hv_pmos[ctype]
print @n.xbgr.xm38_u18.nsg13_hv_pmos[ide]
print @n.xbgr.xm38_u18.nsg13_hv_pmos[ige]
print @n.xbgr.xm38_u18.nsg13_hv_pmos[ise]
print @n.xbgr.xm38_u18.nsg13_hv_pmos[ibe]
print @n.xbgr.xm38_u18.nsg13_hv_pmos[ctype]
print @n.xbgr.xm38_u19.nsg13_hv_pmos[ide]
print @n.xbgr.xm38_u19.nsg13_hv_pmos[ige]
print @n.xbgr.xm38_u19.nsg13_hv_pmos[ise]
print @n.xbgr.xm38_u19.nsg13_hv_pmos[ibe]
print @n.xbgr.xm38_u19.nsg13_hv_pmos[ctype]
print @n.xbgr.xm38_u20.nsg13_hv_pmos[ide]
print @n.xbgr.xm38_u20.nsg13_hv_pmos[ige]
print @n.xbgr.xm38_u20.nsg13_hv_pmos[ise]
print @n.xbgr.xm38_u20.nsg13_hv_pmos[ibe]
print @n.xbgr.xm38_u20.nsg13_hv_pmos[ctype]
print @n.xbgr.xm38_u21.nsg13_hv_pmos[ide]
print @n.xbgr.xm38_u21.nsg13_hv_pmos[ige]
print @n.xbgr.xm38_u21.nsg13_hv_pmos[ise]
print @n.xbgr.xm38_u21.nsg13_hv_pmos[ibe]
print @n.xbgr.xm38_u21.nsg13_hv_pmos[ctype]
print @n.xbgr.xm38_u22.nsg13_hv_pmos[ide]
print @n.xbgr.xm38_u22.nsg13_hv_pmos[ige]
print @n.xbgr.xm38_u22.nsg13_hv_pmos[ise]
print @n.xbgr.xm38_u22.nsg13_hv_pmos[ibe]
print @n.xbgr.xm38_u22.nsg13_hv_pmos[ctype]
print @n.xbgr.xm38_u23.nsg13_hv_pmos[ide]
print @n.xbgr.xm38_u23.nsg13_hv_pmos[ige]
print @n.xbgr.xm38_u23.nsg13_hv_pmos[ise]
print @n.xbgr.xm38_u23.nsg13_hv_pmos[ibe]
print @n.xbgr.xm38_u23.nsg13_hv_pmos[ctype]
print @n.xbgr.xm38_u24.nsg13_hv_pmos[ide]
print @n.xbgr.xm38_u24.nsg13_hv_pmos[ige]
print @n.xbgr.xm38_u24.nsg13_hv_pmos[ise]
print @n.xbgr.xm38_u24.nsg13_hv_pmos[ibe]
print @n.xbgr.xm38_u24.nsg13_hv_pmos[ctype]
print @n.xbgr.xm39_u2.nsg13_hv_pmos[ide]
print @n.xbgr.xm39_u2.nsg13_hv_pmos[ige]
print @n.xbgr.xm39_u2.nsg13_hv_pmos[ise]
print @n.xbgr.xm39_u2.nsg13_hv_pmos[ibe]
print @n.xbgr.xm39_u2.nsg13_hv_pmos[ctype]
print @n.xbgr.xm39_u3.nsg13_hv_pmos[ide]
print @n.xbgr.xm39_u3.nsg13_hv_pmos[ige]
print @n.xbgr.xm39_u3.nsg13_hv_pmos[ise]
print @n.xbgr.xm39_u3.nsg13_hv_pmos[ibe]
print @n.xbgr.xm39_u3.nsg13_hv_pmos[ctype]
print @n.xbgr.xm39_u4.nsg13_hv_pmos[ide]
print @n.xbgr.xm39_u4.nsg13_hv_pmos[ige]
print @n.xbgr.xm39_u4.nsg13_hv_pmos[ise]
print @n.xbgr.xm39_u4.nsg13_hv_pmos[ibe]
print @n.xbgr.xm39_u4.nsg13_hv_pmos[ctype]
print @n.xbgr.xm39_u5.nsg13_hv_pmos[ide]
print @n.xbgr.xm39_u5.nsg13_hv_pmos[ige]
print @n.xbgr.xm39_u5.nsg13_hv_pmos[ise]
print @n.xbgr.xm39_u5.nsg13_hv_pmos[ibe]
print @n.xbgr.xm39_u5.nsg13_hv_pmos[ctype]
print @n.xbgr.xm39_u6.nsg13_hv_pmos[ide]
print @n.xbgr.xm39_u6.nsg13_hv_pmos[ige]
print @n.xbgr.xm39_u6.nsg13_hv_pmos[ise]
print @n.xbgr.xm39_u6.nsg13_hv_pmos[ibe]
print @n.xbgr.xm39_u6.nsg13_hv_pmos[ctype]
print @n.xbgr.xm39_u7.nsg13_hv_pmos[ide]
print @n.xbgr.xm39_u7.nsg13_hv_pmos[ige]
print @n.xbgr.xm39_u7.nsg13_hv_pmos[ise]
print @n.xbgr.xm39_u7.nsg13_hv_pmos[ibe]
print @n.xbgr.xm39_u7.nsg13_hv_pmos[ctype]
print @n.xbgr.xm39_u8.nsg13_hv_pmos[ide]
print @n.xbgr.xm39_u8.nsg13_hv_pmos[ige]
print @n.xbgr.xm39_u8.nsg13_hv_pmos[ise]
print @n.xbgr.xm39_u8.nsg13_hv_pmos[ibe]
print @n.xbgr.xm39_u8.nsg13_hv_pmos[ctype]
print @n.xbgr.xm39_u9.nsg13_hv_pmos[ide]
print @n.xbgr.xm39_u9.nsg13_hv_pmos[ige]
print @n.xbgr.xm39_u9.nsg13_hv_pmos[ise]
print @n.xbgr.xm39_u9.nsg13_hv_pmos[ibe]
print @n.xbgr.xm39_u9.nsg13_hv_pmos[ctype]
print @n.xbgr.xm39_u10.nsg13_hv_pmos[ide]
print @n.xbgr.xm39_u10.nsg13_hv_pmos[ige]
print @n.xbgr.xm39_u10.nsg13_hv_pmos[ise]
print @n.xbgr.xm39_u10.nsg13_hv_pmos[ibe]
print @n.xbgr.xm39_u10.nsg13_hv_pmos[ctype]
print @n.xbgr.xm39_u11.nsg13_hv_pmos[ide]
print @n.xbgr.xm39_u11.nsg13_hv_pmos[ige]
print @n.xbgr.xm39_u11.nsg13_hv_pmos[ise]
print @n.xbgr.xm39_u11.nsg13_hv_pmos[ibe]
print @n.xbgr.xm39_u11.nsg13_hv_pmos[ctype]
print @n.xbgr.xm39_u12.nsg13_hv_pmos[ide]
print @n.xbgr.xm39_u12.nsg13_hv_pmos[ige]
print @n.xbgr.xm39_u12.nsg13_hv_pmos[ise]
print @n.xbgr.xm39_u12.nsg13_hv_pmos[ibe]
print @n.xbgr.xm39_u12.nsg13_hv_pmos[ctype]
print @n.xbgr.xm39_u13.nsg13_hv_pmos[ide]
print @n.xbgr.xm39_u13.nsg13_hv_pmos[ige]
print @n.xbgr.xm39_u13.nsg13_hv_pmos[ise]
print @n.xbgr.xm39_u13.nsg13_hv_pmos[ibe]
print @n.xbgr.xm39_u13.nsg13_hv_pmos[ctype]
print @n.xbgr.xm39_u14.nsg13_hv_pmos[ide]
print @n.xbgr.xm39_u14.nsg13_hv_pmos[ige]
print @n.xbgr.xm39_u14.nsg13_hv_pmos[ise]
print @n.xbgr.xm39_u14.nsg13_hv_pmos[ibe]
print @n.xbgr.xm39_u14.nsg13_hv_pmos[ctype]
print @n.xbgr.xm39_u15.nsg13_hv_pmos[ide]
print @n.xbgr.xm39_u15.nsg13_hv_pmos[ige]
print @n.xbgr.xm39_u15.nsg13_hv_pmos[ise]
print @n.xbgr.xm39_u15.nsg13_hv_pmos[ibe]
print @n.xbgr.xm39_u15.nsg13_hv_pmos[ctype]
print @n.xbgr.xm39_u16.nsg13_hv_pmos[ide]
print @n.xbgr.xm39_u16.nsg13_hv_pmos[ige]
print @n.xbgr.xm39_u16.nsg13_hv_pmos[ise]
print @n.xbgr.xm39_u16.nsg13_hv_pmos[ibe]
print @n.xbgr.xm39_u16.nsg13_hv_pmos[ctype]
print @n.xbgr.xm39_u17.nsg13_hv_pmos[ide]
print @n.xbgr.xm39_u17.nsg13_hv_pmos[ige]
print @n.xbgr.xm39_u17.nsg13_hv_pmos[ise]
print @n.xbgr.xm39_u17.nsg13_hv_pmos[ibe]
print @n.xbgr.xm39_u17.nsg13_hv_pmos[ctype]
print @n.xbgr.xm39_u18.nsg13_hv_pmos[ide]
print @n.xbgr.xm39_u18.nsg13_hv_pmos[ige]
print @n.xbgr.xm39_u18.nsg13_hv_pmos[ise]
print @n.xbgr.xm39_u18.nsg13_hv_pmos[ibe]
print @n.xbgr.xm39_u18.nsg13_hv_pmos[ctype]
print @n.xbgr.xm39_u19.nsg13_hv_pmos[ide]
print @n.xbgr.xm39_u19.nsg13_hv_pmos[ige]
print @n.xbgr.xm39_u19.nsg13_hv_pmos[ise]
print @n.xbgr.xm39_u19.nsg13_hv_pmos[ibe]
print @n.xbgr.xm39_u19.nsg13_hv_pmos[ctype]
print @n.xbgr.xm39_u20.nsg13_hv_pmos[ide]
print @n.xbgr.xm39_u20.nsg13_hv_pmos[ige]
print @n.xbgr.xm39_u20.nsg13_hv_pmos[ise]
print @n.xbgr.xm39_u20.nsg13_hv_pmos[ibe]
print @n.xbgr.xm39_u20.nsg13_hv_pmos[ctype]
print @n.xbgr.xm39_u21.nsg13_hv_pmos[ide]
print @n.xbgr.xm39_u21.nsg13_hv_pmos[ige]
print @n.xbgr.xm39_u21.nsg13_hv_pmos[ise]
print @n.xbgr.xm39_u21.nsg13_hv_pmos[ibe]
print @n.xbgr.xm39_u21.nsg13_hv_pmos[ctype]
print @n.xbgr.xm39_u22.nsg13_hv_pmos[ide]
print @n.xbgr.xm39_u22.nsg13_hv_pmos[ige]
print @n.xbgr.xm39_u22.nsg13_hv_pmos[ise]
print @n.xbgr.xm39_u22.nsg13_hv_pmos[ibe]
print @n.xbgr.xm39_u22.nsg13_hv_pmos[ctype]
print @n.xbgr.xm39_u23.nsg13_hv_pmos[ide]
print @n.xbgr.xm39_u23.nsg13_hv_pmos[ige]
print @n.xbgr.xm39_u23.nsg13_hv_pmos[ise]
print @n.xbgr.xm39_u23.nsg13_hv_pmos[ibe]
print @n.xbgr.xm39_u23.nsg13_hv_pmos[ctype]
print @n.xbgr.xm39_u24.nsg13_hv_pmos[ide]
print @n.xbgr.xm39_u24.nsg13_hv_pmos[ige]
print @n.xbgr.xm39_u24.nsg13_hv_pmos[ise]
print @n.xbgr.xm39_u24.nsg13_hv_pmos[ibe]
print @n.xbgr.xm39_u24.nsg13_hv_pmos[ctype]
print @n.xbgr.xm41_u2.nsg13_hv_pmos[ide]
print @n.xbgr.xm41_u2.nsg13_hv_pmos[ige]
print @n.xbgr.xm41_u2.nsg13_hv_pmos[ise]
print @n.xbgr.xm41_u2.nsg13_hv_pmos[ibe]
print @n.xbgr.xm41_u2.nsg13_hv_pmos[ctype]
print @n.xbgr.xm41_u3.nsg13_hv_pmos[ide]
print @n.xbgr.xm41_u3.nsg13_hv_pmos[ige]
print @n.xbgr.xm41_u3.nsg13_hv_pmos[ise]
print @n.xbgr.xm41_u3.nsg13_hv_pmos[ibe]
print @n.xbgr.xm41_u3.nsg13_hv_pmos[ctype]
print @n.xbgr.xm41_u4.nsg13_hv_pmos[ide]
print @n.xbgr.xm41_u4.nsg13_hv_pmos[ige]
print @n.xbgr.xm41_u4.nsg13_hv_pmos[ise]
print @n.xbgr.xm41_u4.nsg13_hv_pmos[ibe]
print @n.xbgr.xm41_u4.nsg13_hv_pmos[ctype]
print @n.xbgr.xm41_u5.nsg13_hv_pmos[ide]
print @n.xbgr.xm41_u5.nsg13_hv_pmos[ige]
print @n.xbgr.xm41_u5.nsg13_hv_pmos[ise]
print @n.xbgr.xm41_u5.nsg13_hv_pmos[ibe]
print @n.xbgr.xm41_u5.nsg13_hv_pmos[ctype]
print @n.xbgr.xm41_u6.nsg13_hv_pmos[ide]
print @n.xbgr.xm41_u6.nsg13_hv_pmos[ige]
print @n.xbgr.xm41_u6.nsg13_hv_pmos[ise]
print @n.xbgr.xm41_u6.nsg13_hv_pmos[ibe]
print @n.xbgr.xm41_u6.nsg13_hv_pmos[ctype]
print @n.xbgr.xm41_u7.nsg13_hv_pmos[ide]
print @n.xbgr.xm41_u7.nsg13_hv_pmos[ige]
print @n.xbgr.xm41_u7.nsg13_hv_pmos[ise]
print @n.xbgr.xm41_u7.nsg13_hv_pmos[ibe]
print @n.xbgr.xm41_u7.nsg13_hv_pmos[ctype]
print @n.xbgr.xm41_u8.nsg13_hv_pmos[ide]
print @n.xbgr.xm41_u8.nsg13_hv_pmos[ige]
print @n.xbgr.xm41_u8.nsg13_hv_pmos[ise]
print @n.xbgr.xm41_u8.nsg13_hv_pmos[ibe]
print @n.xbgr.xm41_u8.nsg13_hv_pmos[ctype]
print @n.xbgr.xm41_u9.nsg13_hv_pmos[ide]
print @n.xbgr.xm41_u9.nsg13_hv_pmos[ige]
print @n.xbgr.xm41_u9.nsg13_hv_pmos[ise]
print @n.xbgr.xm41_u9.nsg13_hv_pmos[ibe]
print @n.xbgr.xm41_u9.nsg13_hv_pmos[ctype]
print @n.xbgr.xm41_u10.nsg13_hv_pmos[ide]
print @n.xbgr.xm41_u10.nsg13_hv_pmos[ige]
print @n.xbgr.xm41_u10.nsg13_hv_pmos[ise]
print @n.xbgr.xm41_u10.nsg13_hv_pmos[ibe]
print @n.xbgr.xm41_u10.nsg13_hv_pmos[ctype]
print @n.xbgr.xm41_u11.nsg13_hv_pmos[ide]
print @n.xbgr.xm41_u11.nsg13_hv_pmos[ige]
print @n.xbgr.xm41_u11.nsg13_hv_pmos[ise]
print @n.xbgr.xm41_u11.nsg13_hv_pmos[ibe]
print @n.xbgr.xm41_u11.nsg13_hv_pmos[ctype]
print @n.xbgr.xm41_u12.nsg13_hv_pmos[ide]
print @n.xbgr.xm41_u12.nsg13_hv_pmos[ige]
print @n.xbgr.xm41_u12.nsg13_hv_pmos[ise]
print @n.xbgr.xm41_u12.nsg13_hv_pmos[ibe]
print @n.xbgr.xm41_u12.nsg13_hv_pmos[ctype]
print @n.xbgr.xm41_u13.nsg13_hv_pmos[ide]
print @n.xbgr.xm41_u13.nsg13_hv_pmos[ige]
print @n.xbgr.xm41_u13.nsg13_hv_pmos[ise]
print @n.xbgr.xm41_u13.nsg13_hv_pmos[ibe]
print @n.xbgr.xm41_u13.nsg13_hv_pmos[ctype]
print @n.xbgr.xm41_u14.nsg13_hv_pmos[ide]
print @n.xbgr.xm41_u14.nsg13_hv_pmos[ige]
print @n.xbgr.xm41_u14.nsg13_hv_pmos[ise]
print @n.xbgr.xm41_u14.nsg13_hv_pmos[ibe]
print @n.xbgr.xm41_u14.nsg13_hv_pmos[ctype]
print @n.xbgr.xm41_u15.nsg13_hv_pmos[ide]
print @n.xbgr.xm41_u15.nsg13_hv_pmos[ige]
print @n.xbgr.xm41_u15.nsg13_hv_pmos[ise]
print @n.xbgr.xm41_u15.nsg13_hv_pmos[ibe]
print @n.xbgr.xm41_u15.nsg13_hv_pmos[ctype]
print @n.xbgr.xm41_u16.nsg13_hv_pmos[ide]
print @n.xbgr.xm41_u16.nsg13_hv_pmos[ige]
print @n.xbgr.xm41_u16.nsg13_hv_pmos[ise]
print @n.xbgr.xm41_u16.nsg13_hv_pmos[ibe]
print @n.xbgr.xm41_u16.nsg13_hv_pmos[ctype]
print @n.xbgr.xm41_u17.nsg13_hv_pmos[ide]
print @n.xbgr.xm41_u17.nsg13_hv_pmos[ige]
print @n.xbgr.xm41_u17.nsg13_hv_pmos[ise]
print @n.xbgr.xm41_u17.nsg13_hv_pmos[ibe]
print @n.xbgr.xm41_u17.nsg13_hv_pmos[ctype]
print @n.xbgr.xm41_u18.nsg13_hv_pmos[ide]
print @n.xbgr.xm41_u18.nsg13_hv_pmos[ige]
print @n.xbgr.xm41_u18.nsg13_hv_pmos[ise]
print @n.xbgr.xm41_u18.nsg13_hv_pmos[ibe]
print @n.xbgr.xm41_u18.nsg13_hv_pmos[ctype]
print @n.xbgr.xm41_u19.nsg13_hv_pmos[ide]
print @n.xbgr.xm41_u19.nsg13_hv_pmos[ige]
print @n.xbgr.xm41_u19.nsg13_hv_pmos[ise]
print @n.xbgr.xm41_u19.nsg13_hv_pmos[ibe]
print @n.xbgr.xm41_u19.nsg13_hv_pmos[ctype]
print @n.xbgr.xm41_u20.nsg13_hv_pmos[ide]
print @n.xbgr.xm41_u20.nsg13_hv_pmos[ige]
print @n.xbgr.xm41_u20.nsg13_hv_pmos[ise]
print @n.xbgr.xm41_u20.nsg13_hv_pmos[ibe]
print @n.xbgr.xm41_u20.nsg13_hv_pmos[ctype]
print @n.xbgr.xm41_u21.nsg13_hv_pmos[ide]
print @n.xbgr.xm41_u21.nsg13_hv_pmos[ige]
print @n.xbgr.xm41_u21.nsg13_hv_pmos[ise]
print @n.xbgr.xm41_u21.nsg13_hv_pmos[ibe]
print @n.xbgr.xm41_u21.nsg13_hv_pmos[ctype]
print @n.xbgr.xm41_u22.nsg13_hv_pmos[ide]
print @n.xbgr.xm41_u22.nsg13_hv_pmos[ige]
print @n.xbgr.xm41_u22.nsg13_hv_pmos[ise]
print @n.xbgr.xm41_u22.nsg13_hv_pmos[ibe]
print @n.xbgr.xm41_u22.nsg13_hv_pmos[ctype]
print @n.xbgr.xm41_u23.nsg13_hv_pmos[ide]
print @n.xbgr.xm41_u23.nsg13_hv_pmos[ige]
print @n.xbgr.xm41_u23.nsg13_hv_pmos[ise]
print @n.xbgr.xm41_u23.nsg13_hv_pmos[ibe]
print @n.xbgr.xm41_u23.nsg13_hv_pmos[ctype]
print @n.xbgr.xm41_u24.nsg13_hv_pmos[ide]
print @n.xbgr.xm41_u24.nsg13_hv_pmos[ige]
print @n.xbgr.xm41_u24.nsg13_hv_pmos[ise]
print @n.xbgr.xm41_u24.nsg13_hv_pmos[ibe]
print @n.xbgr.xm41_u24.nsg13_hv_pmos[ctype]
print @n.xbgr.xm43_u2.nsg13_hv_pmos[ide]
print @n.xbgr.xm43_u2.nsg13_hv_pmos[ige]
print @n.xbgr.xm43_u2.nsg13_hv_pmos[ise]
print @n.xbgr.xm43_u2.nsg13_hv_pmos[ibe]
print @n.xbgr.xm43_u2.nsg13_hv_pmos[ctype]
print @n.xbgr.xm43_u3.nsg13_hv_pmos[ide]
print @n.xbgr.xm43_u3.nsg13_hv_pmos[ige]
print @n.xbgr.xm43_u3.nsg13_hv_pmos[ise]
print @n.xbgr.xm43_u3.nsg13_hv_pmos[ibe]
print @n.xbgr.xm43_u3.nsg13_hv_pmos[ctype]
print @n.xbgr.xm43_u4.nsg13_hv_pmos[ide]
print @n.xbgr.xm43_u4.nsg13_hv_pmos[ige]
print @n.xbgr.xm43_u4.nsg13_hv_pmos[ise]
print @n.xbgr.xm43_u4.nsg13_hv_pmos[ibe]
print @n.xbgr.xm43_u4.nsg13_hv_pmos[ctype]
print @n.xbgr.xm44_u2.nsg13_hv_pmos[ide]
print @n.xbgr.xm44_u2.nsg13_hv_pmos[ige]
print @n.xbgr.xm44_u2.nsg13_hv_pmos[ise]
print @n.xbgr.xm44_u2.nsg13_hv_pmos[ibe]
print @n.xbgr.xm44_u2.nsg13_hv_pmos[ctype]
print @n.xbgr.xm44_u3.nsg13_hv_pmos[ide]
print @n.xbgr.xm44_u3.nsg13_hv_pmos[ige]
print @n.xbgr.xm44_u3.nsg13_hv_pmos[ise]
print @n.xbgr.xm44_u3.nsg13_hv_pmos[ibe]
print @n.xbgr.xm44_u3.nsg13_hv_pmos[ctype]
print @n.xbgr.xm44_u4.nsg13_hv_pmos[ide]
print @n.xbgr.xm44_u4.nsg13_hv_pmos[ige]
print @n.xbgr.xm44_u4.nsg13_hv_pmos[ise]
print @n.xbgr.xm44_u4.nsg13_hv_pmos[ibe]
print @n.xbgr.xm44_u4.nsg13_hv_pmos[ctype]
print @n.xbgr.xm45_u2.nsg13_hv_pmos[ide]
print @n.xbgr.xm45_u2.nsg13_hv_pmos[ige]
print @n.xbgr.xm45_u2.nsg13_hv_pmos[ise]
print @n.xbgr.xm45_u2.nsg13_hv_pmos[ibe]
print @n.xbgr.xm45_u2.nsg13_hv_pmos[ctype]
print @n.xbgr.xm45_u3.nsg13_hv_pmos[ide]
print @n.xbgr.xm45_u3.nsg13_hv_pmos[ige]
print @n.xbgr.xm45_u3.nsg13_hv_pmos[ise]
print @n.xbgr.xm45_u3.nsg13_hv_pmos[ibe]
print @n.xbgr.xm45_u3.nsg13_hv_pmos[ctype]
print @n.xbgr.xm45_u4.nsg13_hv_pmos[ide]
print @n.xbgr.xm45_u4.nsg13_hv_pmos[ige]
print @n.xbgr.xm45_u4.nsg13_hv_pmos[ise]
print @n.xbgr.xm45_u4.nsg13_hv_pmos[ibe]
print @n.xbgr.xm45_u4.nsg13_hv_pmos[ctype]
print @n.xbgr.xm45_u5.nsg13_hv_pmos[ide]
print @n.xbgr.xm45_u5.nsg13_hv_pmos[ige]
print @n.xbgr.xm45_u5.nsg13_hv_pmos[ise]
print @n.xbgr.xm45_u5.nsg13_hv_pmos[ibe]
print @n.xbgr.xm45_u5.nsg13_hv_pmos[ctype]
print @n.xbgr.xm45_u6.nsg13_hv_pmos[ide]
print @n.xbgr.xm45_u6.nsg13_hv_pmos[ige]
print @n.xbgr.xm45_u6.nsg13_hv_pmos[ise]
print @n.xbgr.xm45_u6.nsg13_hv_pmos[ibe]
print @n.xbgr.xm45_u6.nsg13_hv_pmos[ctype]
print @n.xbgr.xm45_u7.nsg13_hv_pmos[ide]
print @n.xbgr.xm45_u7.nsg13_hv_pmos[ige]
print @n.xbgr.xm45_u7.nsg13_hv_pmos[ise]
print @n.xbgr.xm45_u7.nsg13_hv_pmos[ibe]
print @n.xbgr.xm45_u7.nsg13_hv_pmos[ctype]
print @n.xbgr.xm45_u8.nsg13_hv_pmos[ide]
print @n.xbgr.xm45_u8.nsg13_hv_pmos[ige]
print @n.xbgr.xm45_u8.nsg13_hv_pmos[ise]
print @n.xbgr.xm45_u8.nsg13_hv_pmos[ibe]
print @n.xbgr.xm45_u8.nsg13_hv_pmos[ctype]
print @n.xbgr.xm45_u9.nsg13_hv_pmos[ide]
print @n.xbgr.xm45_u9.nsg13_hv_pmos[ige]
print @n.xbgr.xm45_u9.nsg13_hv_pmos[ise]
print @n.xbgr.xm45_u9.nsg13_hv_pmos[ibe]
print @n.xbgr.xm45_u9.nsg13_hv_pmos[ctype]
print @n.xbgr.xm45_u10.nsg13_hv_pmos[ide]
print @n.xbgr.xm45_u10.nsg13_hv_pmos[ige]
print @n.xbgr.xm45_u10.nsg13_hv_pmos[ise]
print @n.xbgr.xm45_u10.nsg13_hv_pmos[ibe]
print @n.xbgr.xm45_u10.nsg13_hv_pmos[ctype]
print @n.xbgr.xm45_u11.nsg13_hv_pmos[ide]
print @n.xbgr.xm45_u11.nsg13_hv_pmos[ige]
print @n.xbgr.xm45_u11.nsg13_hv_pmos[ise]
print @n.xbgr.xm45_u11.nsg13_hv_pmos[ibe]
print @n.xbgr.xm45_u11.nsg13_hv_pmos[ctype]
print @n.xbgr.xm45_u12.nsg13_hv_pmos[ide]
print @n.xbgr.xm45_u12.nsg13_hv_pmos[ige]
print @n.xbgr.xm45_u12.nsg13_hv_pmos[ise]
print @n.xbgr.xm45_u12.nsg13_hv_pmos[ibe]
print @n.xbgr.xm45_u12.nsg13_hv_pmos[ctype]
print @n.xbgr.xm45_u13.nsg13_hv_pmos[ide]
print @n.xbgr.xm45_u13.nsg13_hv_pmos[ige]
print @n.xbgr.xm45_u13.nsg13_hv_pmos[ise]
print @n.xbgr.xm45_u13.nsg13_hv_pmos[ibe]
print @n.xbgr.xm45_u13.nsg13_hv_pmos[ctype]
print @n.xbgr.xm45_u14.nsg13_hv_pmos[ide]
print @n.xbgr.xm45_u14.nsg13_hv_pmos[ige]
print @n.xbgr.xm45_u14.nsg13_hv_pmos[ise]
print @n.xbgr.xm45_u14.nsg13_hv_pmos[ibe]
print @n.xbgr.xm45_u14.nsg13_hv_pmos[ctype]
print @n.xbgr.xm45_u15.nsg13_hv_pmos[ide]
print @n.xbgr.xm45_u15.nsg13_hv_pmos[ige]
print @n.xbgr.xm45_u15.nsg13_hv_pmos[ise]
print @n.xbgr.xm45_u15.nsg13_hv_pmos[ibe]
print @n.xbgr.xm45_u15.nsg13_hv_pmos[ctype]
print @n.xbgr.xm45_u16.nsg13_hv_pmos[ide]
print @n.xbgr.xm45_u16.nsg13_hv_pmos[ige]
print @n.xbgr.xm45_u16.nsg13_hv_pmos[ise]
print @n.xbgr.xm45_u16.nsg13_hv_pmos[ibe]
print @n.xbgr.xm45_u16.nsg13_hv_pmos[ctype]
print @n.xbgr.xm45_u17.nsg13_hv_pmos[ide]
print @n.xbgr.xm45_u17.nsg13_hv_pmos[ige]
print @n.xbgr.xm45_u17.nsg13_hv_pmos[ise]
print @n.xbgr.xm45_u17.nsg13_hv_pmos[ibe]
print @n.xbgr.xm45_u17.nsg13_hv_pmos[ctype]
print @n.xbgr.xm45_u18.nsg13_hv_pmos[ide]
print @n.xbgr.xm45_u18.nsg13_hv_pmos[ige]
print @n.xbgr.xm45_u18.nsg13_hv_pmos[ise]
print @n.xbgr.xm45_u18.nsg13_hv_pmos[ibe]
print @n.xbgr.xm45_u18.nsg13_hv_pmos[ctype]
print @n.xbgr.xm45_u19.nsg13_hv_pmos[ide]
print @n.xbgr.xm45_u19.nsg13_hv_pmos[ige]
print @n.xbgr.xm45_u19.nsg13_hv_pmos[ise]
print @n.xbgr.xm45_u19.nsg13_hv_pmos[ibe]
print @n.xbgr.xm45_u19.nsg13_hv_pmos[ctype]
print @n.xbgr.xm45_u20.nsg13_hv_pmos[ide]
print @n.xbgr.xm45_u20.nsg13_hv_pmos[ige]
print @n.xbgr.xm45_u20.nsg13_hv_pmos[ise]
print @n.xbgr.xm45_u20.nsg13_hv_pmos[ibe]
print @n.xbgr.xm45_u20.nsg13_hv_pmos[ctype]
print @n.xbgr.xm45_u21.nsg13_hv_pmos[ide]
print @n.xbgr.xm45_u21.nsg13_hv_pmos[ige]
print @n.xbgr.xm45_u21.nsg13_hv_pmos[ise]
print @n.xbgr.xm45_u21.nsg13_hv_pmos[ibe]
print @n.xbgr.xm45_u21.nsg13_hv_pmos[ctype]
print @n.xbgr.xm45_u22.nsg13_hv_pmos[ide]
print @n.xbgr.xm45_u22.nsg13_hv_pmos[ige]
print @n.xbgr.xm45_u22.nsg13_hv_pmos[ise]
print @n.xbgr.xm45_u22.nsg13_hv_pmos[ibe]
print @n.xbgr.xm45_u22.nsg13_hv_pmos[ctype]
print @n.xbgr.xm45_u23.nsg13_hv_pmos[ide]
print @n.xbgr.xm45_u23.nsg13_hv_pmos[ige]
print @n.xbgr.xm45_u23.nsg13_hv_pmos[ise]
print @n.xbgr.xm45_u23.nsg13_hv_pmos[ibe]
print @n.xbgr.xm45_u23.nsg13_hv_pmos[ctype]
print @n.xbgr.xm45_u24.nsg13_hv_pmos[ide]
print @n.xbgr.xm45_u24.nsg13_hv_pmos[ige]
print @n.xbgr.xm45_u24.nsg13_hv_pmos[ise]
print @n.xbgr.xm45_u24.nsg13_hv_pmos[ibe]
print @n.xbgr.xm45_u24.nsg13_hv_pmos[ctype]
print @n.xbgr.xm47_u2.nsg13_hv_pmos[ide]
print @n.xbgr.xm47_u2.nsg13_hv_pmos[ige]
print @n.xbgr.xm47_u2.nsg13_hv_pmos[ise]
print @n.xbgr.xm47_u2.nsg13_hv_pmos[ibe]
print @n.xbgr.xm47_u2.nsg13_hv_pmos[ctype]
print @n.xbgr.xm47_u3.nsg13_hv_pmos[ide]
print @n.xbgr.xm47_u3.nsg13_hv_pmos[ige]
print @n.xbgr.xm47_u3.nsg13_hv_pmos[ise]
print @n.xbgr.xm47_u3.nsg13_hv_pmos[ibe]
print @n.xbgr.xm47_u3.nsg13_hv_pmos[ctype]
print @n.xbgr.xm47_u4.nsg13_hv_pmos[ide]
print @n.xbgr.xm47_u4.nsg13_hv_pmos[ige]
print @n.xbgr.xm47_u4.nsg13_hv_pmos[ise]
print @n.xbgr.xm47_u4.nsg13_hv_pmos[ibe]
print @n.xbgr.xm47_u4.nsg13_hv_pmos[ctype]
print @n.xbgr.xm47_u5.nsg13_hv_pmos[ide]
print @n.xbgr.xm47_u5.nsg13_hv_pmos[ige]
print @n.xbgr.xm47_u5.nsg13_hv_pmos[ise]
print @n.xbgr.xm47_u5.nsg13_hv_pmos[ibe]
print @n.xbgr.xm47_u5.nsg13_hv_pmos[ctype]
print @n.xbgr.xm47_u6.nsg13_hv_pmos[ide]
print @n.xbgr.xm47_u6.nsg13_hv_pmos[ige]
print @n.xbgr.xm47_u6.nsg13_hv_pmos[ise]
print @n.xbgr.xm47_u6.nsg13_hv_pmos[ibe]
print @n.xbgr.xm47_u6.nsg13_hv_pmos[ctype]
print @n.xbgr.xm47_u7.nsg13_hv_pmos[ide]
print @n.xbgr.xm47_u7.nsg13_hv_pmos[ige]
print @n.xbgr.xm47_u7.nsg13_hv_pmos[ise]
print @n.xbgr.xm47_u7.nsg13_hv_pmos[ibe]
print @n.xbgr.xm47_u7.nsg13_hv_pmos[ctype]
print @n.xbgr.xm47_u8.nsg13_hv_pmos[ide]
print @n.xbgr.xm47_u8.nsg13_hv_pmos[ige]
print @n.xbgr.xm47_u8.nsg13_hv_pmos[ise]
print @n.xbgr.xm47_u8.nsg13_hv_pmos[ibe]
print @n.xbgr.xm47_u8.nsg13_hv_pmos[ctype]
print @n.xbgr.xm47_u9.nsg13_hv_pmos[ide]
print @n.xbgr.xm47_u9.nsg13_hv_pmos[ige]
print @n.xbgr.xm47_u9.nsg13_hv_pmos[ise]
print @n.xbgr.xm47_u9.nsg13_hv_pmos[ibe]
print @n.xbgr.xm47_u9.nsg13_hv_pmos[ctype]
print @n.xbgr.xm47_u10.nsg13_hv_pmos[ide]
print @n.xbgr.xm47_u10.nsg13_hv_pmos[ige]
print @n.xbgr.xm47_u10.nsg13_hv_pmos[ise]
print @n.xbgr.xm47_u10.nsg13_hv_pmos[ibe]
print @n.xbgr.xm47_u10.nsg13_hv_pmos[ctype]
print @n.xbgr.xm47_u11.nsg13_hv_pmos[ide]
print @n.xbgr.xm47_u11.nsg13_hv_pmos[ige]
print @n.xbgr.xm47_u11.nsg13_hv_pmos[ise]
print @n.xbgr.xm47_u11.nsg13_hv_pmos[ibe]
print @n.xbgr.xm47_u11.nsg13_hv_pmos[ctype]
print @n.xbgr.xm47_u12.nsg13_hv_pmos[ide]
print @n.xbgr.xm47_u12.nsg13_hv_pmos[ige]
print @n.xbgr.xm47_u12.nsg13_hv_pmos[ise]
print @n.xbgr.xm47_u12.nsg13_hv_pmos[ibe]
print @n.xbgr.xm47_u12.nsg13_hv_pmos[ctype]
print @n.xbgr.xm47_u13.nsg13_hv_pmos[ide]
print @n.xbgr.xm47_u13.nsg13_hv_pmos[ige]
print @n.xbgr.xm47_u13.nsg13_hv_pmos[ise]
print @n.xbgr.xm47_u13.nsg13_hv_pmos[ibe]
print @n.xbgr.xm47_u13.nsg13_hv_pmos[ctype]
print @n.xbgr.xm47_u14.nsg13_hv_pmos[ide]
print @n.xbgr.xm47_u14.nsg13_hv_pmos[ige]
print @n.xbgr.xm47_u14.nsg13_hv_pmos[ise]
print @n.xbgr.xm47_u14.nsg13_hv_pmos[ibe]
print @n.xbgr.xm47_u14.nsg13_hv_pmos[ctype]
print @n.xbgr.xm47_u15.nsg13_hv_pmos[ide]
print @n.xbgr.xm47_u15.nsg13_hv_pmos[ige]
print @n.xbgr.xm47_u15.nsg13_hv_pmos[ise]
print @n.xbgr.xm47_u15.nsg13_hv_pmos[ibe]
print @n.xbgr.xm47_u15.nsg13_hv_pmos[ctype]
print @n.xbgr.xm47_u16.nsg13_hv_pmos[ide]
print @n.xbgr.xm47_u16.nsg13_hv_pmos[ige]
print @n.xbgr.xm47_u16.nsg13_hv_pmos[ise]
print @n.xbgr.xm47_u16.nsg13_hv_pmos[ibe]
print @n.xbgr.xm47_u16.nsg13_hv_pmos[ctype]
print @n.xbgr.xm47_u17.nsg13_hv_pmos[ide]
print @n.xbgr.xm47_u17.nsg13_hv_pmos[ige]
print @n.xbgr.xm47_u17.nsg13_hv_pmos[ise]
print @n.xbgr.xm47_u17.nsg13_hv_pmos[ibe]
print @n.xbgr.xm47_u17.nsg13_hv_pmos[ctype]
print @n.xbgr.xm47_u18.nsg13_hv_pmos[ide]
print @n.xbgr.xm47_u18.nsg13_hv_pmos[ige]
print @n.xbgr.xm47_u18.nsg13_hv_pmos[ise]
print @n.xbgr.xm47_u18.nsg13_hv_pmos[ibe]
print @n.xbgr.xm47_u18.nsg13_hv_pmos[ctype]
print @n.xbgr.xm47_u19.nsg13_hv_pmos[ide]
print @n.xbgr.xm47_u19.nsg13_hv_pmos[ige]
print @n.xbgr.xm47_u19.nsg13_hv_pmos[ise]
print @n.xbgr.xm47_u19.nsg13_hv_pmos[ibe]
print @n.xbgr.xm47_u19.nsg13_hv_pmos[ctype]
print @n.xbgr.xm47_u20.nsg13_hv_pmos[ide]
print @n.xbgr.xm47_u20.nsg13_hv_pmos[ige]
print @n.xbgr.xm47_u20.nsg13_hv_pmos[ise]
print @n.xbgr.xm47_u20.nsg13_hv_pmos[ibe]
print @n.xbgr.xm47_u20.nsg13_hv_pmos[ctype]
print @n.xbgr.xm47_u21.nsg13_hv_pmos[ide]
print @n.xbgr.xm47_u21.nsg13_hv_pmos[ige]
print @n.xbgr.xm47_u21.nsg13_hv_pmos[ise]
print @n.xbgr.xm47_u21.nsg13_hv_pmos[ibe]
print @n.xbgr.xm47_u21.nsg13_hv_pmos[ctype]
print @n.xbgr.xm47_u22.nsg13_hv_pmos[ide]
print @n.xbgr.xm47_u22.nsg13_hv_pmos[ige]
print @n.xbgr.xm47_u22.nsg13_hv_pmos[ise]
print @n.xbgr.xm47_u22.nsg13_hv_pmos[ibe]
print @n.xbgr.xm47_u22.nsg13_hv_pmos[ctype]
print @n.xbgr.xm47_u23.nsg13_hv_pmos[ide]
print @n.xbgr.xm47_u23.nsg13_hv_pmos[ige]
print @n.xbgr.xm47_u23.nsg13_hv_pmos[ise]
print @n.xbgr.xm47_u23.nsg13_hv_pmos[ibe]
print @n.xbgr.xm47_u23.nsg13_hv_pmos[ctype]
print @n.xbgr.xm47_u24.nsg13_hv_pmos[ide]
print @n.xbgr.xm47_u24.nsg13_hv_pmos[ige]
print @n.xbgr.xm47_u24.nsg13_hv_pmos[ise]
print @n.xbgr.xm47_u24.nsg13_hv_pmos[ibe]
print @n.xbgr.xm47_u24.nsg13_hv_pmos[ctype]
print @n.xbgr.xm48_u2.nsg13_hv_pmos[ide]
print @n.xbgr.xm48_u2.nsg13_hv_pmos[ige]
print @n.xbgr.xm48_u2.nsg13_hv_pmos[ise]
print @n.xbgr.xm48_u2.nsg13_hv_pmos[ibe]
print @n.xbgr.xm48_u2.nsg13_hv_pmos[ctype]
print @n.xbgr.xm48_u3.nsg13_hv_pmos[ide]
print @n.xbgr.xm48_u3.nsg13_hv_pmos[ige]
print @n.xbgr.xm48_u3.nsg13_hv_pmos[ise]
print @n.xbgr.xm48_u3.nsg13_hv_pmos[ibe]
print @n.xbgr.xm48_u3.nsg13_hv_pmos[ctype]
print @n.xbgr.xm48_u4.nsg13_hv_pmos[ide]
print @n.xbgr.xm48_u4.nsg13_hv_pmos[ige]
print @n.xbgr.xm48_u4.nsg13_hv_pmos[ise]
print @n.xbgr.xm48_u4.nsg13_hv_pmos[ibe]
print @n.xbgr.xm48_u4.nsg13_hv_pmos[ctype]
print @n.xbgr.xm48_u5.nsg13_hv_pmos[ide]
print @n.xbgr.xm48_u5.nsg13_hv_pmos[ige]
print @n.xbgr.xm48_u5.nsg13_hv_pmos[ise]
print @n.xbgr.xm48_u5.nsg13_hv_pmos[ibe]
print @n.xbgr.xm48_u5.nsg13_hv_pmos[ctype]
print @n.xbgr.xm48_u6.nsg13_hv_pmos[ide]
print @n.xbgr.xm48_u6.nsg13_hv_pmos[ige]
print @n.xbgr.xm48_u6.nsg13_hv_pmos[ise]
print @n.xbgr.xm48_u6.nsg13_hv_pmos[ibe]
print @n.xbgr.xm48_u6.nsg13_hv_pmos[ctype]
print @n.xbgr.xm48_u7.nsg13_hv_pmos[ide]
print @n.xbgr.xm48_u7.nsg13_hv_pmos[ige]
print @n.xbgr.xm48_u7.nsg13_hv_pmos[ise]
print @n.xbgr.xm48_u7.nsg13_hv_pmos[ibe]
print @n.xbgr.xm48_u7.nsg13_hv_pmos[ctype]
print @n.xbgr.xm48_u8.nsg13_hv_pmos[ide]
print @n.xbgr.xm48_u8.nsg13_hv_pmos[ige]
print @n.xbgr.xm48_u8.nsg13_hv_pmos[ise]
print @n.xbgr.xm48_u8.nsg13_hv_pmos[ibe]
print @n.xbgr.xm48_u8.nsg13_hv_pmos[ctype]
print @n.xbgr.xm48_u9.nsg13_hv_pmos[ide]
print @n.xbgr.xm48_u9.nsg13_hv_pmos[ige]
print @n.xbgr.xm48_u9.nsg13_hv_pmos[ise]
print @n.xbgr.xm48_u9.nsg13_hv_pmos[ibe]
print @n.xbgr.xm48_u9.nsg13_hv_pmos[ctype]
print @n.xbgr.xm48_u10.nsg13_hv_pmos[ide]
print @n.xbgr.xm48_u10.nsg13_hv_pmos[ige]
print @n.xbgr.xm48_u10.nsg13_hv_pmos[ise]
print @n.xbgr.xm48_u10.nsg13_hv_pmos[ibe]
print @n.xbgr.xm48_u10.nsg13_hv_pmos[ctype]
print @n.xbgr.xm48_u11.nsg13_hv_pmos[ide]
print @n.xbgr.xm48_u11.nsg13_hv_pmos[ige]
print @n.xbgr.xm48_u11.nsg13_hv_pmos[ise]
print @n.xbgr.xm48_u11.nsg13_hv_pmos[ibe]
print @n.xbgr.xm48_u11.nsg13_hv_pmos[ctype]
print @n.xbgr.xm48_u12.nsg13_hv_pmos[ide]
print @n.xbgr.xm48_u12.nsg13_hv_pmos[ige]
print @n.xbgr.xm48_u12.nsg13_hv_pmos[ise]
print @n.xbgr.xm48_u12.nsg13_hv_pmos[ibe]
print @n.xbgr.xm48_u12.nsg13_hv_pmos[ctype]
print @n.xbgr.xm48_u13.nsg13_hv_pmos[ide]
print @n.xbgr.xm48_u13.nsg13_hv_pmos[ige]
print @n.xbgr.xm48_u13.nsg13_hv_pmos[ise]
print @n.xbgr.xm48_u13.nsg13_hv_pmos[ibe]
print @n.xbgr.xm48_u13.nsg13_hv_pmos[ctype]
print @n.xbgr.xm48_u14.nsg13_hv_pmos[ide]
print @n.xbgr.xm48_u14.nsg13_hv_pmos[ige]
print @n.xbgr.xm48_u14.nsg13_hv_pmos[ise]
print @n.xbgr.xm48_u14.nsg13_hv_pmos[ibe]
print @n.xbgr.xm48_u14.nsg13_hv_pmos[ctype]
print @n.xbgr.xm48_u15.nsg13_hv_pmos[ide]
print @n.xbgr.xm48_u15.nsg13_hv_pmos[ige]
print @n.xbgr.xm48_u15.nsg13_hv_pmos[ise]
print @n.xbgr.xm48_u15.nsg13_hv_pmos[ibe]
print @n.xbgr.xm48_u15.nsg13_hv_pmos[ctype]
print @n.xbgr.xm48_u16.nsg13_hv_pmos[ide]
print @n.xbgr.xm48_u16.nsg13_hv_pmos[ige]
print @n.xbgr.xm48_u16.nsg13_hv_pmos[ise]
print @n.xbgr.xm48_u16.nsg13_hv_pmos[ibe]
print @n.xbgr.xm48_u16.nsg13_hv_pmos[ctype]
print @n.xbgr.xm48_u17.nsg13_hv_pmos[ide]
print @n.xbgr.xm48_u17.nsg13_hv_pmos[ige]
print @n.xbgr.xm48_u17.nsg13_hv_pmos[ise]
print @n.xbgr.xm48_u17.nsg13_hv_pmos[ibe]
print @n.xbgr.xm48_u17.nsg13_hv_pmos[ctype]
print @n.xbgr.xm48_u18.nsg13_hv_pmos[ide]
print @n.xbgr.xm48_u18.nsg13_hv_pmos[ige]
print @n.xbgr.xm48_u18.nsg13_hv_pmos[ise]
print @n.xbgr.xm48_u18.nsg13_hv_pmos[ibe]
print @n.xbgr.xm48_u18.nsg13_hv_pmos[ctype]
print @n.xbgr.xm48_u19.nsg13_hv_pmos[ide]
print @n.xbgr.xm48_u19.nsg13_hv_pmos[ige]
print @n.xbgr.xm48_u19.nsg13_hv_pmos[ise]
print @n.xbgr.xm48_u19.nsg13_hv_pmos[ibe]
print @n.xbgr.xm48_u19.nsg13_hv_pmos[ctype]
print @n.xbgr.xm48_u20.nsg13_hv_pmos[ide]
print @n.xbgr.xm48_u20.nsg13_hv_pmos[ige]
print @n.xbgr.xm48_u20.nsg13_hv_pmos[ise]
print @n.xbgr.xm48_u20.nsg13_hv_pmos[ibe]
print @n.xbgr.xm48_u20.nsg13_hv_pmos[ctype]
print @n.xbgr.xm48_u21.nsg13_hv_pmos[ide]
print @n.xbgr.xm48_u21.nsg13_hv_pmos[ige]
print @n.xbgr.xm48_u21.nsg13_hv_pmos[ise]
print @n.xbgr.xm48_u21.nsg13_hv_pmos[ibe]
print @n.xbgr.xm48_u21.nsg13_hv_pmos[ctype]
print @n.xbgr.xm48_u22.nsg13_hv_pmos[ide]
print @n.xbgr.xm48_u22.nsg13_hv_pmos[ige]
print @n.xbgr.xm48_u22.nsg13_hv_pmos[ise]
print @n.xbgr.xm48_u22.nsg13_hv_pmos[ibe]
print @n.xbgr.xm48_u22.nsg13_hv_pmos[ctype]
print @n.xbgr.xm48_u23.nsg13_hv_pmos[ide]
print @n.xbgr.xm48_u23.nsg13_hv_pmos[ige]
print @n.xbgr.xm48_u23.nsg13_hv_pmos[ise]
print @n.xbgr.xm48_u23.nsg13_hv_pmos[ibe]
print @n.xbgr.xm48_u23.nsg13_hv_pmos[ctype]
print @n.xbgr.xm48_u24.nsg13_hv_pmos[ide]
print @n.xbgr.xm48_u24.nsg13_hv_pmos[ige]
print @n.xbgr.xm48_u24.nsg13_hv_pmos[ise]
print @n.xbgr.xm48_u24.nsg13_hv_pmos[ibe]
print @n.xbgr.xm48_u24.nsg13_hv_pmos[ctype]
print @n.xbgr.xm50_u2.nsg13_hv_pmos[ide]
print @n.xbgr.xm50_u2.nsg13_hv_pmos[ige]
print @n.xbgr.xm50_u2.nsg13_hv_pmos[ise]
print @n.xbgr.xm50_u2.nsg13_hv_pmos[ibe]
print @n.xbgr.xm50_u2.nsg13_hv_pmos[ctype]
print @n.xbgr.xm50_u3.nsg13_hv_pmos[ide]
print @n.xbgr.xm50_u3.nsg13_hv_pmos[ige]
print @n.xbgr.xm50_u3.nsg13_hv_pmos[ise]
print @n.xbgr.xm50_u3.nsg13_hv_pmos[ibe]
print @n.xbgr.xm50_u3.nsg13_hv_pmos[ctype]
print @n.xbgr.xm50_u4.nsg13_hv_pmos[ide]
print @n.xbgr.xm50_u4.nsg13_hv_pmos[ige]
print @n.xbgr.xm50_u4.nsg13_hv_pmos[ise]
print @n.xbgr.xm50_u4.nsg13_hv_pmos[ibe]
print @n.xbgr.xm50_u4.nsg13_hv_pmos[ctype]
print @n.xbgr.xm50_u5.nsg13_hv_pmos[ide]
print @n.xbgr.xm50_u5.nsg13_hv_pmos[ige]
print @n.xbgr.xm50_u5.nsg13_hv_pmos[ise]
print @n.xbgr.xm50_u5.nsg13_hv_pmos[ibe]
print @n.xbgr.xm50_u5.nsg13_hv_pmos[ctype]
print @n.xbgr.xm50_u6.nsg13_hv_pmos[ide]
print @n.xbgr.xm50_u6.nsg13_hv_pmos[ige]
print @n.xbgr.xm50_u6.nsg13_hv_pmos[ise]
print @n.xbgr.xm50_u6.nsg13_hv_pmos[ibe]
print @n.xbgr.xm50_u6.nsg13_hv_pmos[ctype]
print @n.xbgr.xm50_u7.nsg13_hv_pmos[ide]
print @n.xbgr.xm50_u7.nsg13_hv_pmos[ige]
print @n.xbgr.xm50_u7.nsg13_hv_pmos[ise]
print @n.xbgr.xm50_u7.nsg13_hv_pmos[ibe]
print @n.xbgr.xm50_u7.nsg13_hv_pmos[ctype]
print @n.xbgr.xm50_u8.nsg13_hv_pmos[ide]
print @n.xbgr.xm50_u8.nsg13_hv_pmos[ige]
print @n.xbgr.xm50_u8.nsg13_hv_pmos[ise]
print @n.xbgr.xm50_u8.nsg13_hv_pmos[ibe]
print @n.xbgr.xm50_u8.nsg13_hv_pmos[ctype]
print @n.xbgr.xm50_u9.nsg13_hv_pmos[ide]
print @n.xbgr.xm50_u9.nsg13_hv_pmos[ige]
print @n.xbgr.xm50_u9.nsg13_hv_pmos[ise]
print @n.xbgr.xm50_u9.nsg13_hv_pmos[ibe]
print @n.xbgr.xm50_u9.nsg13_hv_pmos[ctype]
print @n.xbgr.xm50_u10.nsg13_hv_pmos[ide]
print @n.xbgr.xm50_u10.nsg13_hv_pmos[ige]
print @n.xbgr.xm50_u10.nsg13_hv_pmos[ise]
print @n.xbgr.xm50_u10.nsg13_hv_pmos[ibe]
print @n.xbgr.xm50_u10.nsg13_hv_pmos[ctype]
print @n.xbgr.xm50_u11.nsg13_hv_pmos[ide]
print @n.xbgr.xm50_u11.nsg13_hv_pmos[ige]
print @n.xbgr.xm50_u11.nsg13_hv_pmos[ise]
print @n.xbgr.xm50_u11.nsg13_hv_pmos[ibe]
print @n.xbgr.xm50_u11.nsg13_hv_pmos[ctype]
print @n.xbgr.xm50_u12.nsg13_hv_pmos[ide]
print @n.xbgr.xm50_u12.nsg13_hv_pmos[ige]
print @n.xbgr.xm50_u12.nsg13_hv_pmos[ise]
print @n.xbgr.xm50_u12.nsg13_hv_pmos[ibe]
print @n.xbgr.xm50_u12.nsg13_hv_pmos[ctype]
print @n.xbgr.xm50_u13.nsg13_hv_pmos[ide]
print @n.xbgr.xm50_u13.nsg13_hv_pmos[ige]
print @n.xbgr.xm50_u13.nsg13_hv_pmos[ise]
print @n.xbgr.xm50_u13.nsg13_hv_pmos[ibe]
print @n.xbgr.xm50_u13.nsg13_hv_pmos[ctype]
print @n.xbgr.xm50_u14.nsg13_hv_pmos[ide]
print @n.xbgr.xm50_u14.nsg13_hv_pmos[ige]
print @n.xbgr.xm50_u14.nsg13_hv_pmos[ise]
print @n.xbgr.xm50_u14.nsg13_hv_pmos[ibe]
print @n.xbgr.xm50_u14.nsg13_hv_pmos[ctype]
print @n.xbgr.xm50_u15.nsg13_hv_pmos[ide]
print @n.xbgr.xm50_u15.nsg13_hv_pmos[ige]
print @n.xbgr.xm50_u15.nsg13_hv_pmos[ise]
print @n.xbgr.xm50_u15.nsg13_hv_pmos[ibe]
print @n.xbgr.xm50_u15.nsg13_hv_pmos[ctype]
print @n.xbgr.xm50_u16.nsg13_hv_pmos[ide]
print @n.xbgr.xm50_u16.nsg13_hv_pmos[ige]
print @n.xbgr.xm50_u16.nsg13_hv_pmos[ise]
print @n.xbgr.xm50_u16.nsg13_hv_pmos[ibe]
print @n.xbgr.xm50_u16.nsg13_hv_pmos[ctype]
print @n.xbgr.xm50_u17.nsg13_hv_pmos[ide]
print @n.xbgr.xm50_u17.nsg13_hv_pmos[ige]
print @n.xbgr.xm50_u17.nsg13_hv_pmos[ise]
print @n.xbgr.xm50_u17.nsg13_hv_pmos[ibe]
print @n.xbgr.xm50_u17.nsg13_hv_pmos[ctype]
print @n.xbgr.xm50_u18.nsg13_hv_pmos[ide]
print @n.xbgr.xm50_u18.nsg13_hv_pmos[ige]
print @n.xbgr.xm50_u18.nsg13_hv_pmos[ise]
print @n.xbgr.xm50_u18.nsg13_hv_pmos[ibe]
print @n.xbgr.xm50_u18.nsg13_hv_pmos[ctype]
print @n.xbgr.xm50_u19.nsg13_hv_pmos[ide]
print @n.xbgr.xm50_u19.nsg13_hv_pmos[ige]
print @n.xbgr.xm50_u19.nsg13_hv_pmos[ise]
print @n.xbgr.xm50_u19.nsg13_hv_pmos[ibe]
print @n.xbgr.xm50_u19.nsg13_hv_pmos[ctype]
print @n.xbgr.xm50_u20.nsg13_hv_pmos[ide]
print @n.xbgr.xm50_u20.nsg13_hv_pmos[ige]
print @n.xbgr.xm50_u20.nsg13_hv_pmos[ise]
print @n.xbgr.xm50_u20.nsg13_hv_pmos[ibe]
print @n.xbgr.xm50_u20.nsg13_hv_pmos[ctype]
print @n.xbgr.xm50_u21.nsg13_hv_pmos[ide]
print @n.xbgr.xm50_u21.nsg13_hv_pmos[ige]
print @n.xbgr.xm50_u21.nsg13_hv_pmos[ise]
print @n.xbgr.xm50_u21.nsg13_hv_pmos[ibe]
print @n.xbgr.xm50_u21.nsg13_hv_pmos[ctype]
print @n.xbgr.xm50_u22.nsg13_hv_pmos[ide]
print @n.xbgr.xm50_u22.nsg13_hv_pmos[ige]
print @n.xbgr.xm50_u22.nsg13_hv_pmos[ise]
print @n.xbgr.xm50_u22.nsg13_hv_pmos[ibe]
print @n.xbgr.xm50_u22.nsg13_hv_pmos[ctype]
print @n.xbgr.xm50_u23.nsg13_hv_pmos[ide]
print @n.xbgr.xm50_u23.nsg13_hv_pmos[ige]
print @n.xbgr.xm50_u23.nsg13_hv_pmos[ise]
print @n.xbgr.xm50_u23.nsg13_hv_pmos[ibe]
print @n.xbgr.xm50_u23.nsg13_hv_pmos[ctype]
print @n.xbgr.xm50_u24.nsg13_hv_pmos[ide]
print @n.xbgr.xm50_u24.nsg13_hv_pmos[ige]
print @n.xbgr.xm50_u24.nsg13_hv_pmos[ise]
print @n.xbgr.xm50_u24.nsg13_hv_pmos[ibe]
print @n.xbgr.xm50_u24.nsg13_hv_pmos[ctype]
print @n.xbgr.xm51_u2.nsg13_hv_pmos[ide]
print @n.xbgr.xm51_u2.nsg13_hv_pmos[ige]
print @n.xbgr.xm51_u2.nsg13_hv_pmos[ise]
print @n.xbgr.xm51_u2.nsg13_hv_pmos[ibe]
print @n.xbgr.xm51_u2.nsg13_hv_pmos[ctype]
print @n.xbgr.xm51_u3.nsg13_hv_pmos[ide]
print @n.xbgr.xm51_u3.nsg13_hv_pmos[ige]
print @n.xbgr.xm51_u3.nsg13_hv_pmos[ise]
print @n.xbgr.xm51_u3.nsg13_hv_pmos[ibe]
print @n.xbgr.xm51_u3.nsg13_hv_pmos[ctype]
print @n.xbgr.xm51_u4.nsg13_hv_pmos[ide]
print @n.xbgr.xm51_u4.nsg13_hv_pmos[ige]
print @n.xbgr.xm51_u4.nsg13_hv_pmos[ise]
print @n.xbgr.xm51_u4.nsg13_hv_pmos[ibe]
print @n.xbgr.xm51_u4.nsg13_hv_pmos[ctype]
print @n.xbgr.xm52_u2.nsg13_hv_pmos[ide]
print @n.xbgr.xm52_u2.nsg13_hv_pmos[ige]
print @n.xbgr.xm52_u2.nsg13_hv_pmos[ise]
print @n.xbgr.xm52_u2.nsg13_hv_pmos[ibe]
print @n.xbgr.xm52_u2.nsg13_hv_pmos[ctype]
print @n.xbgr.xm52_u3.nsg13_hv_pmos[ide]
print @n.xbgr.xm52_u3.nsg13_hv_pmos[ige]
print @n.xbgr.xm52_u3.nsg13_hv_pmos[ise]
print @n.xbgr.xm52_u3.nsg13_hv_pmos[ibe]
print @n.xbgr.xm52_u3.nsg13_hv_pmos[ctype]
print @n.xbgr.xm52_u4.nsg13_hv_pmos[ide]
print @n.xbgr.xm52_u4.nsg13_hv_pmos[ige]
print @n.xbgr.xm52_u4.nsg13_hv_pmos[ise]
print @n.xbgr.xm52_u4.nsg13_hv_pmos[ibe]
print @n.xbgr.xm52_u4.nsg13_hv_pmos[ctype]
print @n.xbgr.xm52_u5.nsg13_hv_pmos[ide]
print @n.xbgr.xm52_u5.nsg13_hv_pmos[ige]
print @n.xbgr.xm52_u5.nsg13_hv_pmos[ise]
print @n.xbgr.xm52_u5.nsg13_hv_pmos[ibe]
print @n.xbgr.xm52_u5.nsg13_hv_pmos[ctype]
print @n.xbgr.xm52_u6.nsg13_hv_pmos[ide]
print @n.xbgr.xm52_u6.nsg13_hv_pmos[ige]
print @n.xbgr.xm52_u6.nsg13_hv_pmos[ise]
print @n.xbgr.xm52_u6.nsg13_hv_pmos[ibe]
print @n.xbgr.xm52_u6.nsg13_hv_pmos[ctype]
print @n.xbgr.xm52_u7.nsg13_hv_pmos[ide]
print @n.xbgr.xm52_u7.nsg13_hv_pmos[ige]
print @n.xbgr.xm52_u7.nsg13_hv_pmos[ise]
print @n.xbgr.xm52_u7.nsg13_hv_pmos[ibe]
print @n.xbgr.xm52_u7.nsg13_hv_pmos[ctype]
print @n.xbgr.xm52_u8.nsg13_hv_pmos[ide]
print @n.xbgr.xm52_u8.nsg13_hv_pmos[ige]
print @n.xbgr.xm52_u8.nsg13_hv_pmos[ise]
print @n.xbgr.xm52_u8.nsg13_hv_pmos[ibe]
print @n.xbgr.xm52_u8.nsg13_hv_pmos[ctype]
print @n.xbgr.xm52_u9.nsg13_hv_pmos[ide]
print @n.xbgr.xm52_u9.nsg13_hv_pmos[ige]
print @n.xbgr.xm52_u9.nsg13_hv_pmos[ise]
print @n.xbgr.xm52_u9.nsg13_hv_pmos[ibe]
print @n.xbgr.xm52_u9.nsg13_hv_pmos[ctype]
print @n.xbgr.xm52_u10.nsg13_hv_pmos[ide]
print @n.xbgr.xm52_u10.nsg13_hv_pmos[ige]
print @n.xbgr.xm52_u10.nsg13_hv_pmos[ise]
print @n.xbgr.xm52_u10.nsg13_hv_pmos[ibe]
print @n.xbgr.xm52_u10.nsg13_hv_pmos[ctype]
print @n.xbgr.xm52_u11.nsg13_hv_pmos[ide]
print @n.xbgr.xm52_u11.nsg13_hv_pmos[ige]
print @n.xbgr.xm52_u11.nsg13_hv_pmos[ise]
print @n.xbgr.xm52_u11.nsg13_hv_pmos[ibe]
print @n.xbgr.xm52_u11.nsg13_hv_pmos[ctype]
print @n.xbgr.xm52_u12.nsg13_hv_pmos[ide]
print @n.xbgr.xm52_u12.nsg13_hv_pmos[ige]
print @n.xbgr.xm52_u12.nsg13_hv_pmos[ise]
print @n.xbgr.xm52_u12.nsg13_hv_pmos[ibe]
print @n.xbgr.xm52_u12.nsg13_hv_pmos[ctype]
print @n.xbgr.xm52_u13.nsg13_hv_pmos[ide]
print @n.xbgr.xm52_u13.nsg13_hv_pmos[ige]
print @n.xbgr.xm52_u13.nsg13_hv_pmos[ise]
print @n.xbgr.xm52_u13.nsg13_hv_pmos[ibe]
print @n.xbgr.xm52_u13.nsg13_hv_pmos[ctype]
print @n.xbgr.xm52_u14.nsg13_hv_pmos[ide]
print @n.xbgr.xm52_u14.nsg13_hv_pmos[ige]
print @n.xbgr.xm52_u14.nsg13_hv_pmos[ise]
print @n.xbgr.xm52_u14.nsg13_hv_pmos[ibe]
print @n.xbgr.xm52_u14.nsg13_hv_pmos[ctype]
print @n.xbgr.xm52_u15.nsg13_hv_pmos[ide]
print @n.xbgr.xm52_u15.nsg13_hv_pmos[ige]
print @n.xbgr.xm52_u15.nsg13_hv_pmos[ise]
print @n.xbgr.xm52_u15.nsg13_hv_pmos[ibe]
print @n.xbgr.xm52_u15.nsg13_hv_pmos[ctype]
print @n.xbgr.xm52_u16.nsg13_hv_pmos[ide]
print @n.xbgr.xm52_u16.nsg13_hv_pmos[ige]
print @n.xbgr.xm52_u16.nsg13_hv_pmos[ise]
print @n.xbgr.xm52_u16.nsg13_hv_pmos[ibe]
print @n.xbgr.xm52_u16.nsg13_hv_pmos[ctype]
print @n.xbgr.xm52_u17.nsg13_hv_pmos[ide]
print @n.xbgr.xm52_u17.nsg13_hv_pmos[ige]
print @n.xbgr.xm52_u17.nsg13_hv_pmos[ise]
print @n.xbgr.xm52_u17.nsg13_hv_pmos[ibe]
print @n.xbgr.xm52_u17.nsg13_hv_pmos[ctype]
print @n.xbgr.xm52_u18.nsg13_hv_pmos[ide]
print @n.xbgr.xm52_u18.nsg13_hv_pmos[ige]
print @n.xbgr.xm52_u18.nsg13_hv_pmos[ise]
print @n.xbgr.xm52_u18.nsg13_hv_pmos[ibe]
print @n.xbgr.xm52_u18.nsg13_hv_pmos[ctype]
print @n.xbgr.xm52_u19.nsg13_hv_pmos[ide]
print @n.xbgr.xm52_u19.nsg13_hv_pmos[ige]
print @n.xbgr.xm52_u19.nsg13_hv_pmos[ise]
print @n.xbgr.xm52_u19.nsg13_hv_pmos[ibe]
print @n.xbgr.xm52_u19.nsg13_hv_pmos[ctype]
print @n.xbgr.xm52_u20.nsg13_hv_pmos[ide]
print @n.xbgr.xm52_u20.nsg13_hv_pmos[ige]
print @n.xbgr.xm52_u20.nsg13_hv_pmos[ise]
print @n.xbgr.xm52_u20.nsg13_hv_pmos[ibe]
print @n.xbgr.xm52_u20.nsg13_hv_pmos[ctype]
print @n.xbgr.xm52_u21.nsg13_hv_pmos[ide]
print @n.xbgr.xm52_u21.nsg13_hv_pmos[ige]
print @n.xbgr.xm52_u21.nsg13_hv_pmos[ise]
print @n.xbgr.xm52_u21.nsg13_hv_pmos[ibe]
print @n.xbgr.xm52_u21.nsg13_hv_pmos[ctype]
print @n.xbgr.xm52_u22.nsg13_hv_pmos[ide]
print @n.xbgr.xm52_u22.nsg13_hv_pmos[ige]
print @n.xbgr.xm52_u22.nsg13_hv_pmos[ise]
print @n.xbgr.xm52_u22.nsg13_hv_pmos[ibe]
print @n.xbgr.xm52_u22.nsg13_hv_pmos[ctype]
print @n.xbgr.xm52_u23.nsg13_hv_pmos[ide]
print @n.xbgr.xm52_u23.nsg13_hv_pmos[ige]
print @n.xbgr.xm52_u23.nsg13_hv_pmos[ise]
print @n.xbgr.xm52_u23.nsg13_hv_pmos[ibe]
print @n.xbgr.xm52_u23.nsg13_hv_pmos[ctype]
print @n.xbgr.xm52_u24.nsg13_hv_pmos[ide]
print @n.xbgr.xm52_u24.nsg13_hv_pmos[ige]
print @n.xbgr.xm52_u24.nsg13_hv_pmos[ise]
print @n.xbgr.xm52_u24.nsg13_hv_pmos[ibe]
print @n.xbgr.xm52_u24.nsg13_hv_pmos[ctype]
print @n.xbgr.xm54_u2.nsg13_hv_pmos[ide]
print @n.xbgr.xm54_u2.nsg13_hv_pmos[ige]
print @n.xbgr.xm54_u2.nsg13_hv_pmos[ise]
print @n.xbgr.xm54_u2.nsg13_hv_pmos[ibe]
print @n.xbgr.xm54_u2.nsg13_hv_pmos[ctype]
print @n.xbgr.xm54_u3.nsg13_hv_pmos[ide]
print @n.xbgr.xm54_u3.nsg13_hv_pmos[ige]
print @n.xbgr.xm54_u3.nsg13_hv_pmos[ise]
print @n.xbgr.xm54_u3.nsg13_hv_pmos[ibe]
print @n.xbgr.xm54_u3.nsg13_hv_pmos[ctype]
print @n.xbgr.xm54_u4.nsg13_hv_pmos[ide]
print @n.xbgr.xm54_u4.nsg13_hv_pmos[ige]
print @n.xbgr.xm54_u4.nsg13_hv_pmos[ise]
print @n.xbgr.xm54_u4.nsg13_hv_pmos[ibe]
print @n.xbgr.xm54_u4.nsg13_hv_pmos[ctype]
print @n.xbgr.xm54_u5.nsg13_hv_pmos[ide]
print @n.xbgr.xm54_u5.nsg13_hv_pmos[ige]
print @n.xbgr.xm54_u5.nsg13_hv_pmos[ise]
print @n.xbgr.xm54_u5.nsg13_hv_pmos[ibe]
print @n.xbgr.xm54_u5.nsg13_hv_pmos[ctype]
print @n.xbgr.xm54_u6.nsg13_hv_pmos[ide]
print @n.xbgr.xm54_u6.nsg13_hv_pmos[ige]
print @n.xbgr.xm54_u6.nsg13_hv_pmos[ise]
print @n.xbgr.xm54_u6.nsg13_hv_pmos[ibe]
print @n.xbgr.xm54_u6.nsg13_hv_pmos[ctype]
print @n.xbgr.xm54_u7.nsg13_hv_pmos[ide]
print @n.xbgr.xm54_u7.nsg13_hv_pmos[ige]
print @n.xbgr.xm54_u7.nsg13_hv_pmos[ise]
print @n.xbgr.xm54_u7.nsg13_hv_pmos[ibe]
print @n.xbgr.xm54_u7.nsg13_hv_pmos[ctype]
print @n.xbgr.xm54_u8.nsg13_hv_pmos[ide]
print @n.xbgr.xm54_u8.nsg13_hv_pmos[ige]
print @n.xbgr.xm54_u8.nsg13_hv_pmos[ise]
print @n.xbgr.xm54_u8.nsg13_hv_pmos[ibe]
print @n.xbgr.xm54_u8.nsg13_hv_pmos[ctype]
print @n.xbgr.xm54_u9.nsg13_hv_pmos[ide]
print @n.xbgr.xm54_u9.nsg13_hv_pmos[ige]
print @n.xbgr.xm54_u9.nsg13_hv_pmos[ise]
print @n.xbgr.xm54_u9.nsg13_hv_pmos[ibe]
print @n.xbgr.xm54_u9.nsg13_hv_pmos[ctype]
print @n.xbgr.xm54_u10.nsg13_hv_pmos[ide]
print @n.xbgr.xm54_u10.nsg13_hv_pmos[ige]
print @n.xbgr.xm54_u10.nsg13_hv_pmos[ise]
print @n.xbgr.xm54_u10.nsg13_hv_pmos[ibe]
print @n.xbgr.xm54_u10.nsg13_hv_pmos[ctype]
print @n.xbgr.xm54_u11.nsg13_hv_pmos[ide]
print @n.xbgr.xm54_u11.nsg13_hv_pmos[ige]
print @n.xbgr.xm54_u11.nsg13_hv_pmos[ise]
print @n.xbgr.xm54_u11.nsg13_hv_pmos[ibe]
print @n.xbgr.xm54_u11.nsg13_hv_pmos[ctype]
print @n.xbgr.xm54_u12.nsg13_hv_pmos[ide]
print @n.xbgr.xm54_u12.nsg13_hv_pmos[ige]
print @n.xbgr.xm54_u12.nsg13_hv_pmos[ise]
print @n.xbgr.xm54_u12.nsg13_hv_pmos[ibe]
print @n.xbgr.xm54_u12.nsg13_hv_pmos[ctype]
print @n.xbgr.xm54_u13.nsg13_hv_pmos[ide]
print @n.xbgr.xm54_u13.nsg13_hv_pmos[ige]
print @n.xbgr.xm54_u13.nsg13_hv_pmos[ise]
print @n.xbgr.xm54_u13.nsg13_hv_pmos[ibe]
print @n.xbgr.xm54_u13.nsg13_hv_pmos[ctype]
print @n.xbgr.xm54_u14.nsg13_hv_pmos[ide]
print @n.xbgr.xm54_u14.nsg13_hv_pmos[ige]
print @n.xbgr.xm54_u14.nsg13_hv_pmos[ise]
print @n.xbgr.xm54_u14.nsg13_hv_pmos[ibe]
print @n.xbgr.xm54_u14.nsg13_hv_pmos[ctype]
print @n.xbgr.xm54_u15.nsg13_hv_pmos[ide]
print @n.xbgr.xm54_u15.nsg13_hv_pmos[ige]
print @n.xbgr.xm54_u15.nsg13_hv_pmos[ise]
print @n.xbgr.xm54_u15.nsg13_hv_pmos[ibe]
print @n.xbgr.xm54_u15.nsg13_hv_pmos[ctype]
print @n.xbgr.xm54_u16.nsg13_hv_pmos[ide]
print @n.xbgr.xm54_u16.nsg13_hv_pmos[ige]
print @n.xbgr.xm54_u16.nsg13_hv_pmos[ise]
print @n.xbgr.xm54_u16.nsg13_hv_pmos[ibe]
print @n.xbgr.xm54_u16.nsg13_hv_pmos[ctype]
print @n.xbgr.xm54_u17.nsg13_hv_pmos[ide]
print @n.xbgr.xm54_u17.nsg13_hv_pmos[ige]
print @n.xbgr.xm54_u17.nsg13_hv_pmos[ise]
print @n.xbgr.xm54_u17.nsg13_hv_pmos[ibe]
print @n.xbgr.xm54_u17.nsg13_hv_pmos[ctype]
print @n.xbgr.xm54_u18.nsg13_hv_pmos[ide]
print @n.xbgr.xm54_u18.nsg13_hv_pmos[ige]
print @n.xbgr.xm54_u18.nsg13_hv_pmos[ise]
print @n.xbgr.xm54_u18.nsg13_hv_pmos[ibe]
print @n.xbgr.xm54_u18.nsg13_hv_pmos[ctype]
print @n.xbgr.xm54_u19.nsg13_hv_pmos[ide]
print @n.xbgr.xm54_u19.nsg13_hv_pmos[ige]
print @n.xbgr.xm54_u19.nsg13_hv_pmos[ise]
print @n.xbgr.xm54_u19.nsg13_hv_pmos[ibe]
print @n.xbgr.xm54_u19.nsg13_hv_pmos[ctype]
print @n.xbgr.xm54_u20.nsg13_hv_pmos[ide]
print @n.xbgr.xm54_u20.nsg13_hv_pmos[ige]
print @n.xbgr.xm54_u20.nsg13_hv_pmos[ise]
print @n.xbgr.xm54_u20.nsg13_hv_pmos[ibe]
print @n.xbgr.xm54_u20.nsg13_hv_pmos[ctype]
print @n.xbgr.xm54_u21.nsg13_hv_pmos[ide]
print @n.xbgr.xm54_u21.nsg13_hv_pmos[ige]
print @n.xbgr.xm54_u21.nsg13_hv_pmos[ise]
print @n.xbgr.xm54_u21.nsg13_hv_pmos[ibe]
print @n.xbgr.xm54_u21.nsg13_hv_pmos[ctype]
print @n.xbgr.xm54_u22.nsg13_hv_pmos[ide]
print @n.xbgr.xm54_u22.nsg13_hv_pmos[ige]
print @n.xbgr.xm54_u22.nsg13_hv_pmos[ise]
print @n.xbgr.xm54_u22.nsg13_hv_pmos[ibe]
print @n.xbgr.xm54_u22.nsg13_hv_pmos[ctype]
print @n.xbgr.xm54_u23.nsg13_hv_pmos[ide]
print @n.xbgr.xm54_u23.nsg13_hv_pmos[ige]
print @n.xbgr.xm54_u23.nsg13_hv_pmos[ise]
print @n.xbgr.xm54_u23.nsg13_hv_pmos[ibe]
print @n.xbgr.xm54_u23.nsg13_hv_pmos[ctype]
print @n.xbgr.xm54_u24.nsg13_hv_pmos[ide]
print @n.xbgr.xm54_u24.nsg13_hv_pmos[ige]
print @n.xbgr.xm54_u24.nsg13_hv_pmos[ise]
print @n.xbgr.xm54_u24.nsg13_hv_pmos[ibe]
print @n.xbgr.xm54_u24.nsg13_hv_pmos[ctype]
print @q.xbgr.xq56_u2.qnpn13g2[ic]
print @q.xbgr.xq56_u2.qnpn13g2[ib]
print @q.xbgr.xq56_u2.qnpn13g2[ie]
print @q.xbgr.xq56_u2.qnpn13g2[is]
print @r.xbgr.xq56_u2.rsub[i]
print @c.xbgr.xq56_u2.csub[i]
print @q.xbgr.xq56_u3.qnpn13g2[ic]
print @q.xbgr.xq56_u3.qnpn13g2[ib]
print @q.xbgr.xq56_u3.qnpn13g2[ie]
print @q.xbgr.xq56_u3.qnpn13g2[is]
print @r.xbgr.xq56_u3.rsub[i]
print @c.xbgr.xq56_u3.csub[i]
print @q.xbgr.xq56_u4.qnpn13g2[ic]
print @q.xbgr.xq56_u4.qnpn13g2[ib]
print @q.xbgr.xq56_u4.qnpn13g2[ie]
print @q.xbgr.xq56_u4.qnpn13g2[is]
print @r.xbgr.xq56_u4.rsub[i]
print @c.xbgr.xq56_u4.csub[i]
print @q.xbgr.xq56_u5.qnpn13g2[ic]
print @q.xbgr.xq56_u5.qnpn13g2[ib]
print @q.xbgr.xq56_u5.qnpn13g2[ie]
print @q.xbgr.xq56_u5.qnpn13g2[is]
print @r.xbgr.xq56_u5.rsub[i]
print @c.xbgr.xq56_u5.csub[i]
print @q.xbgr.xq56_u6.qnpn13g2[ic]
print @q.xbgr.xq56_u6.qnpn13g2[ib]
print @q.xbgr.xq56_u6.qnpn13g2[ie]
print @q.xbgr.xq56_u6.qnpn13g2[is]
print @r.xbgr.xq56_u6.rsub[i]
print @c.xbgr.xq56_u6.csub[i]
print @q.xbgr.xq56_u7.qnpn13g2[ic]
print @q.xbgr.xq56_u7.qnpn13g2[ib]
print @q.xbgr.xq56_u7.qnpn13g2[ie]
print @q.xbgr.xq56_u7.qnpn13g2[is]
print @r.xbgr.xq56_u7.rsub[i]
print @c.xbgr.xq56_u7.csub[i]
print @q.xbgr.xq56_u8.qnpn13g2[ic]
print @q.xbgr.xq56_u8.qnpn13g2[ib]
print @q.xbgr.xq56_u8.qnpn13g2[ie]
print @q.xbgr.xq56_u8.qnpn13g2[is]
print @r.xbgr.xq56_u8.rsub[i]
print @c.xbgr.xq56_u8.csub[i]
print @q.xbgr.xq56_u9.qnpn13g2[ic]
print @q.xbgr.xq56_u9.qnpn13g2[ib]
print @q.xbgr.xq56_u9.qnpn13g2[ie]
print @q.xbgr.xq56_u9.qnpn13g2[is]
print @r.xbgr.xq56_u9.rsub[i]
print @c.xbgr.xq56_u9.csub[i]
print @q.xbgr.xq56_u10.qnpn13g2[ic]
print @q.xbgr.xq56_u10.qnpn13g2[ib]
print @q.xbgr.xq56_u10.qnpn13g2[ie]
print @q.xbgr.xq56_u10.qnpn13g2[is]
print @r.xbgr.xq56_u10.rsub[i]
print @c.xbgr.xq56_u10.csub[i]
print @q.xbgr.xq56_u11.qnpn13g2[ic]
print @q.xbgr.xq56_u11.qnpn13g2[ib]
print @q.xbgr.xq56_u11.qnpn13g2[ie]
print @q.xbgr.xq56_u11.qnpn13g2[is]
print @r.xbgr.xq56_u11.rsub[i]
print @c.xbgr.xq56_u11.csub[i]
print @q.xbgr.xq56_u12.qnpn13g2[ic]
print @q.xbgr.xq56_u12.qnpn13g2[ib]
print @q.xbgr.xq56_u12.qnpn13g2[ie]
print @q.xbgr.xq56_u12.qnpn13g2[is]
print @r.xbgr.xq56_u12.rsub[i]
print @c.xbgr.xq56_u12.csub[i]
print @q.xbgr.xq56_u13.qnpn13g2[ic]
print @q.xbgr.xq56_u13.qnpn13g2[ib]
print @q.xbgr.xq56_u13.qnpn13g2[ie]
print @q.xbgr.xq56_u13.qnpn13g2[is]
print @r.xbgr.xq56_u13.rsub[i]
print @c.xbgr.xq56_u13.csub[i]
print @q.xbgr.xq56_u14.qnpn13g2[ic]
print @q.xbgr.xq56_u14.qnpn13g2[ib]
print @q.xbgr.xq56_u14.qnpn13g2[ie]
print @q.xbgr.xq56_u14.qnpn13g2[is]
print @r.xbgr.xq56_u14.rsub[i]
print @c.xbgr.xq56_u14.csub[i]
print @q.xbgr.xq56_u15.qnpn13g2[ic]
print @q.xbgr.xq56_u15.qnpn13g2[ib]
print @q.xbgr.xq56_u15.qnpn13g2[ie]
print @q.xbgr.xq56_u15.qnpn13g2[is]
print @r.xbgr.xq56_u15.rsub[i]
print @c.xbgr.xq56_u15.csub[i]
print @q.xbgr.xq56_u16.qnpn13g2[ic]
print @q.xbgr.xq56_u16.qnpn13g2[ib]
print @q.xbgr.xq56_u16.qnpn13g2[ie]
print @q.xbgr.xq56_u16.qnpn13g2[is]
print @r.xbgr.xq56_u16.rsub[i]
print @c.xbgr.xq56_u16.csub[i]
print @q.xbgr.xq56_u17.qnpn13g2[ic]
print @q.xbgr.xq56_u17.qnpn13g2[ib]
print @q.xbgr.xq56_u17.qnpn13g2[ie]
print @q.xbgr.xq56_u17.qnpn13g2[is]
print @r.xbgr.xq56_u17.rsub[i]
print @c.xbgr.xq56_u17.csub[i]
print @q.xbgr.xq56_u18.qnpn13g2[ic]
print @q.xbgr.xq56_u18.qnpn13g2[ib]
print @q.xbgr.xq56_u18.qnpn13g2[ie]
print @q.xbgr.xq56_u18.qnpn13g2[is]
print @r.xbgr.xq56_u18.rsub[i]
print @c.xbgr.xq56_u18.csub[i]
print @q.xbgr.xq56_u19.qnpn13g2[ic]
print @q.xbgr.xq56_u19.qnpn13g2[ib]
print @q.xbgr.xq56_u19.qnpn13g2[ie]
print @q.xbgr.xq56_u19.qnpn13g2[is]
print @r.xbgr.xq56_u19.rsub[i]
print @c.xbgr.xq56_u19.csub[i]
print @q.xbgr.xq56_u20.qnpn13g2[ic]
print @q.xbgr.xq56_u20.qnpn13g2[ib]
print @q.xbgr.xq56_u20.qnpn13g2[ie]
print @q.xbgr.xq56_u20.qnpn13g2[is]
print @r.xbgr.xq56_u20.rsub[i]
print @c.xbgr.xq56_u20.csub[i]
print @q.xbgr.xq56_u21.qnpn13g2[ic]
print @q.xbgr.xq56_u21.qnpn13g2[ib]
print @q.xbgr.xq56_u21.qnpn13g2[ie]
print @q.xbgr.xq56_u21.qnpn13g2[is]
print @r.xbgr.xq56_u21.rsub[i]
print @c.xbgr.xq56_u21.csub[i]
print @q.xbgr.xq56_u22.qnpn13g2[ic]
print @q.xbgr.xq56_u22.qnpn13g2[ib]
print @q.xbgr.xq56_u22.qnpn13g2[ie]
print @q.xbgr.xq56_u22.qnpn13g2[is]
print @r.xbgr.xq56_u22.rsub[i]
print @c.xbgr.xq56_u22.csub[i]
print @q.xbgr.xq56_u23.qnpn13g2[ic]
print @q.xbgr.xq56_u23.qnpn13g2[ib]
print @q.xbgr.xq56_u23.qnpn13g2[ie]
print @q.xbgr.xq56_u23.qnpn13g2[is]
print @r.xbgr.xq56_u23.rsub[i]
print @c.xbgr.xq56_u23.csub[i]
print @q.xbgr.xq56_u24.qnpn13g2[ic]
print @q.xbgr.xq56_u24.qnpn13g2[ib]
print @q.xbgr.xq56_u24.qnpn13g2[ie]
print @q.xbgr.xq56_u24.qnpn13g2[is]
print @r.xbgr.xq56_u24.rsub[i]
print @c.xbgr.xq56_u24.csub[i]
print @q.xbgr.xq60_u2.qnpn13g2[ic]
print @q.xbgr.xq60_u2.qnpn13g2[ib]
print @q.xbgr.xq60_u2.qnpn13g2[ie]
print @q.xbgr.xq60_u2.qnpn13g2[is]
print @r.xbgr.xq60_u2.rsub[i]
print @c.xbgr.xq60_u2.csub[i]
print @q.xbgr.xq60_u3.qnpn13g2[ic]
print @q.xbgr.xq60_u3.qnpn13g2[ib]
print @q.xbgr.xq60_u3.qnpn13g2[ie]
print @q.xbgr.xq60_u3.qnpn13g2[is]
print @r.xbgr.xq60_u3.rsub[i]
print @c.xbgr.xq60_u3.csub[i]
print @q.xbgr.xq60_u4.qnpn13g2[ic]
print @q.xbgr.xq60_u4.qnpn13g2[ib]
print @q.xbgr.xq60_u4.qnpn13g2[ie]
print @q.xbgr.xq60_u4.qnpn13g2[is]
print @r.xbgr.xq60_u4.rsub[i]
print @c.xbgr.xq60_u4.csub[i]
print @q.xbgr.xq62_u2.qnpn13g2[ic]
print @q.xbgr.xq62_u2.qnpn13g2[ib]
print @q.xbgr.xq62_u2.qnpn13g2[ie]
print @q.xbgr.xq62_u2.qnpn13g2[is]
print @r.xbgr.xq62_u2.rsub[i]
print @c.xbgr.xq62_u2.csub[i]
print @q.xbgr.xq62_u3.qnpn13g2[ic]
print @q.xbgr.xq62_u3.qnpn13g2[ib]
print @q.xbgr.xq62_u3.qnpn13g2[ie]
print @q.xbgr.xq62_u3.qnpn13g2[is]
print @r.xbgr.xq62_u3.rsub[i]
print @c.xbgr.xq62_u3.csub[i]
print @q.xbgr.xq62_u4.qnpn13g2[ic]
print @q.xbgr.xq62_u4.qnpn13g2[ib]
print @q.xbgr.xq62_u4.qnpn13g2[ie]
print @q.xbgr.xq62_u4.qnpn13g2[is]
print @r.xbgr.xq62_u4.rsub[i]
print @c.xbgr.xq62_u4.csub[i]
print @q.xbgr.xq62_u5.qnpn13g2[ic]
print @q.xbgr.xq62_u5.qnpn13g2[ib]
print @q.xbgr.xq62_u5.qnpn13g2[ie]
print @q.xbgr.xq62_u5.qnpn13g2[is]
print @r.xbgr.xq62_u5.rsub[i]
print @c.xbgr.xq62_u5.csub[i]
print @q.xbgr.xq62_u6.qnpn13g2[ic]
print @q.xbgr.xq62_u6.qnpn13g2[ib]
print @q.xbgr.xq62_u6.qnpn13g2[ie]
print @q.xbgr.xq62_u6.qnpn13g2[is]
print @r.xbgr.xq62_u6.rsub[i]
print @c.xbgr.xq62_u6.csub[i]
print @q.xbgr.xq62_u7.qnpn13g2[ic]
print @q.xbgr.xq62_u7.qnpn13g2[ib]
print @q.xbgr.xq62_u7.qnpn13g2[ie]
print @q.xbgr.xq62_u7.qnpn13g2[is]
print @r.xbgr.xq62_u7.rsub[i]
print @c.xbgr.xq62_u7.csub[i]
print @q.xbgr.xq62_u8.qnpn13g2[ic]
print @q.xbgr.xq62_u8.qnpn13g2[ib]
print @q.xbgr.xq62_u8.qnpn13g2[ie]
print @q.xbgr.xq62_u8.qnpn13g2[is]
print @r.xbgr.xq62_u8.rsub[i]
print @c.xbgr.xq62_u8.csub[i]
print @q.xbgr.xq62_u9.qnpn13g2[ic]
print @q.xbgr.xq62_u9.qnpn13g2[ib]
print @q.xbgr.xq62_u9.qnpn13g2[ie]
print @q.xbgr.xq62_u9.qnpn13g2[is]
print @r.xbgr.xq62_u9.rsub[i]
print @c.xbgr.xq62_u9.csub[i]
print @q.xbgr.xq62_u10.qnpn13g2[ic]
print @q.xbgr.xq62_u10.qnpn13g2[ib]
print @q.xbgr.xq62_u10.qnpn13g2[ie]
print @q.xbgr.xq62_u10.qnpn13g2[is]
print @r.xbgr.xq62_u10.rsub[i]
print @c.xbgr.xq62_u10.csub[i]
print @q.xbgr.xq62_u11.qnpn13g2[ic]
print @q.xbgr.xq62_u11.qnpn13g2[ib]
print @q.xbgr.xq62_u11.qnpn13g2[ie]
print @q.xbgr.xq62_u11.qnpn13g2[is]
print @r.xbgr.xq62_u11.rsub[i]
print @c.xbgr.xq62_u11.csub[i]
print @q.xbgr.xq62_u12.qnpn13g2[ic]
print @q.xbgr.xq62_u12.qnpn13g2[ib]
print @q.xbgr.xq62_u12.qnpn13g2[ie]
print @q.xbgr.xq62_u12.qnpn13g2[is]
print @r.xbgr.xq62_u12.rsub[i]
print @c.xbgr.xq62_u12.csub[i]
print @q.xbgr.xq62_u13.qnpn13g2[ic]
print @q.xbgr.xq62_u13.qnpn13g2[ib]
print @q.xbgr.xq62_u13.qnpn13g2[ie]
print @q.xbgr.xq62_u13.qnpn13g2[is]
print @r.xbgr.xq62_u13.rsub[i]
print @c.xbgr.xq62_u13.csub[i]
print @q.xbgr.xq62_u14.qnpn13g2[ic]
print @q.xbgr.xq62_u14.qnpn13g2[ib]
print @q.xbgr.xq62_u14.qnpn13g2[ie]
print @q.xbgr.xq62_u14.qnpn13g2[is]
print @r.xbgr.xq62_u14.rsub[i]
print @c.xbgr.xq62_u14.csub[i]
print @q.xbgr.xq62_u15.qnpn13g2[ic]
print @q.xbgr.xq62_u15.qnpn13g2[ib]
print @q.xbgr.xq62_u15.qnpn13g2[ie]
print @q.xbgr.xq62_u15.qnpn13g2[is]
print @r.xbgr.xq62_u15.rsub[i]
print @c.xbgr.xq62_u15.csub[i]
print @q.xbgr.xq62_u16.qnpn13g2[ic]
print @q.xbgr.xq62_u16.qnpn13g2[ib]
print @q.xbgr.xq62_u16.qnpn13g2[ie]
print @q.xbgr.xq62_u16.qnpn13g2[is]
print @r.xbgr.xq62_u16.rsub[i]
print @c.xbgr.xq62_u16.csub[i]
print @q.xbgr.xq62_u17.qnpn13g2[ic]
print @q.xbgr.xq62_u17.qnpn13g2[ib]
print @q.xbgr.xq62_u17.qnpn13g2[ie]
print @q.xbgr.xq62_u17.qnpn13g2[is]
print @r.xbgr.xq62_u17.rsub[i]
print @c.xbgr.xq62_u17.csub[i]
print @q.xbgr.xq62_u18.qnpn13g2[ic]
print @q.xbgr.xq62_u18.qnpn13g2[ib]
print @q.xbgr.xq62_u18.qnpn13g2[ie]
print @q.xbgr.xq62_u18.qnpn13g2[is]
print @r.xbgr.xq62_u18.rsub[i]
print @c.xbgr.xq62_u18.csub[i]
print @q.xbgr.xq62_u19.qnpn13g2[ic]
print @q.xbgr.xq62_u19.qnpn13g2[ib]
print @q.xbgr.xq62_u19.qnpn13g2[ie]
print @q.xbgr.xq62_u19.qnpn13g2[is]
print @r.xbgr.xq62_u19.rsub[i]
print @c.xbgr.xq62_u19.csub[i]
print @q.xbgr.xq62_u20.qnpn13g2[ic]
print @q.xbgr.xq62_u20.qnpn13g2[ib]
print @q.xbgr.xq62_u20.qnpn13g2[ie]
print @q.xbgr.xq62_u20.qnpn13g2[is]
print @r.xbgr.xq62_u20.rsub[i]
print @c.xbgr.xq62_u20.csub[i]
print @q.xbgr.xq62_u21.qnpn13g2[ic]
print @q.xbgr.xq62_u21.qnpn13g2[ib]
print @q.xbgr.xq62_u21.qnpn13g2[ie]
print @q.xbgr.xq62_u21.qnpn13g2[is]
print @r.xbgr.xq62_u21.rsub[i]
print @c.xbgr.xq62_u21.csub[i]
print @q.xbgr.xq62_u22.qnpn13g2[ic]
print @q.xbgr.xq62_u22.qnpn13g2[ib]
print @q.xbgr.xq62_u22.qnpn13g2[ie]
print @q.xbgr.xq62_u22.qnpn13g2[is]
print @r.xbgr.xq62_u22.rsub[i]
print @c.xbgr.xq62_u22.csub[i]
print @q.xbgr.xq62_u23.qnpn13g2[ic]
print @q.xbgr.xq62_u23.qnpn13g2[ib]
print @q.xbgr.xq62_u23.qnpn13g2[ie]
print @q.xbgr.xq62_u23.qnpn13g2[is]
print @r.xbgr.xq62_u23.rsub[i]
print @c.xbgr.xq62_u23.csub[i]
print @q.xbgr.xq62_u24.qnpn13g2[ic]
print @q.xbgr.xq62_u24.qnpn13g2[ib]
print @q.xbgr.xq62_u24.qnpn13g2[ie]
print @q.xbgr.xq62_u24.qnpn13g2[is]
print @r.xbgr.xq62_u24.rsub[i]
print @c.xbgr.xq62_u24.csub[i]
print @q.xbgr.xq67_u2.qnpn13g2[ic]
print @q.xbgr.xq67_u2.qnpn13g2[ib]
print @q.xbgr.xq67_u2.qnpn13g2[ie]
print @q.xbgr.xq67_u2.qnpn13g2[is]
print @r.xbgr.xq67_u2.rsub[i]
print @c.xbgr.xq67_u2.csub[i]
print @q.xbgr.xq67_u3.qnpn13g2[ic]
print @q.xbgr.xq67_u3.qnpn13g2[ib]
print @q.xbgr.xq67_u3.qnpn13g2[ie]
print @q.xbgr.xq67_u3.qnpn13g2[is]
print @r.xbgr.xq67_u3.rsub[i]
print @c.xbgr.xq67_u3.csub[i]
print @q.xbgr.xq67_u4.qnpn13g2[ic]
print @q.xbgr.xq67_u4.qnpn13g2[ib]
print @q.xbgr.xq67_u4.qnpn13g2[ie]
print @q.xbgr.xq67_u4.qnpn13g2[is]
print @r.xbgr.xq67_u4.rsub[i]
print @c.xbgr.xq67_u4.csub[i]
print @q.xbgr.xq67_u5.qnpn13g2[ic]
print @q.xbgr.xq67_u5.qnpn13g2[ib]
print @q.xbgr.xq67_u5.qnpn13g2[ie]
print @q.xbgr.xq67_u5.qnpn13g2[is]
print @r.xbgr.xq67_u5.rsub[i]
print @c.xbgr.xq67_u5.csub[i]
print @q.xbgr.xq67_u6.qnpn13g2[ic]
print @q.xbgr.xq67_u6.qnpn13g2[ib]
print @q.xbgr.xq67_u6.qnpn13g2[ie]
print @q.xbgr.xq67_u6.qnpn13g2[is]
print @r.xbgr.xq67_u6.rsub[i]
print @c.xbgr.xq67_u6.csub[i]
print @q.xbgr.xq67_u7.qnpn13g2[ic]
print @q.xbgr.xq67_u7.qnpn13g2[ib]
print @q.xbgr.xq67_u7.qnpn13g2[ie]
print @q.xbgr.xq67_u7.qnpn13g2[is]
print @r.xbgr.xq67_u7.rsub[i]
print @c.xbgr.xq67_u7.csub[i]
print @q.xbgr.xq67_u8.qnpn13g2[ic]
print @q.xbgr.xq67_u8.qnpn13g2[ib]
print @q.xbgr.xq67_u8.qnpn13g2[ie]
print @q.xbgr.xq67_u8.qnpn13g2[is]
print @r.xbgr.xq67_u8.rsub[i]
print @c.xbgr.xq67_u8.csub[i]
print @q.xbgr.xq67_u9.qnpn13g2[ic]
print @q.xbgr.xq67_u9.qnpn13g2[ib]
print @q.xbgr.xq67_u9.qnpn13g2[ie]
print @q.xbgr.xq67_u9.qnpn13g2[is]
print @r.xbgr.xq67_u9.rsub[i]
print @c.xbgr.xq67_u9.csub[i]
print @q.xbgr.xq67_u10.qnpn13g2[ic]
print @q.xbgr.xq67_u10.qnpn13g2[ib]
print @q.xbgr.xq67_u10.qnpn13g2[ie]
print @q.xbgr.xq67_u10.qnpn13g2[is]
print @r.xbgr.xq67_u10.rsub[i]
print @c.xbgr.xq67_u10.csub[i]
print @q.xbgr.xq67_u11.qnpn13g2[ic]
print @q.xbgr.xq67_u11.qnpn13g2[ib]
print @q.xbgr.xq67_u11.qnpn13g2[ie]
print @q.xbgr.xq67_u11.qnpn13g2[is]
print @r.xbgr.xq67_u11.rsub[i]
print @c.xbgr.xq67_u11.csub[i]
print @q.xbgr.xq67_u12.qnpn13g2[ic]
print @q.xbgr.xq67_u12.qnpn13g2[ib]
print @q.xbgr.xq67_u12.qnpn13g2[ie]
print @q.xbgr.xq67_u12.qnpn13g2[is]
print @r.xbgr.xq67_u12.rsub[i]
print @c.xbgr.xq67_u12.csub[i]
print @q.xbgr.xq67_u13.qnpn13g2[ic]
print @q.xbgr.xq67_u13.qnpn13g2[ib]
print @q.xbgr.xq67_u13.qnpn13g2[ie]
print @q.xbgr.xq67_u13.qnpn13g2[is]
print @r.xbgr.xq67_u13.rsub[i]
print @c.xbgr.xq67_u13.csub[i]
print @q.xbgr.xq67_u14.qnpn13g2[ic]
print @q.xbgr.xq67_u14.qnpn13g2[ib]
print @q.xbgr.xq67_u14.qnpn13g2[ie]
print @q.xbgr.xq67_u14.qnpn13g2[is]
print @r.xbgr.xq67_u14.rsub[i]
print @c.xbgr.xq67_u14.csub[i]
print @q.xbgr.xq67_u15.qnpn13g2[ic]
print @q.xbgr.xq67_u15.qnpn13g2[ib]
print @q.xbgr.xq67_u15.qnpn13g2[ie]
print @q.xbgr.xq67_u15.qnpn13g2[is]
print @r.xbgr.xq67_u15.rsub[i]
print @c.xbgr.xq67_u15.csub[i]
print @q.xbgr.xq67_u16.qnpn13g2[ic]
print @q.xbgr.xq67_u16.qnpn13g2[ib]
print @q.xbgr.xq67_u16.qnpn13g2[ie]
print @q.xbgr.xq67_u16.qnpn13g2[is]
print @r.xbgr.xq67_u16.rsub[i]
print @c.xbgr.xq67_u16.csub[i]
print @q.xbgr.xq67_u17.qnpn13g2[ic]
print @q.xbgr.xq67_u17.qnpn13g2[ib]
print @q.xbgr.xq67_u17.qnpn13g2[ie]
print @q.xbgr.xq67_u17.qnpn13g2[is]
print @r.xbgr.xq67_u17.rsub[i]
print @c.xbgr.xq67_u17.csub[i]
print @q.xbgr.xq67_u18.qnpn13g2[ic]
print @q.xbgr.xq67_u18.qnpn13g2[ib]
print @q.xbgr.xq67_u18.qnpn13g2[ie]
print @q.xbgr.xq67_u18.qnpn13g2[is]
print @r.xbgr.xq67_u18.rsub[i]
print @c.xbgr.xq67_u18.csub[i]
print @q.xbgr.xq67_u19.qnpn13g2[ic]
print @q.xbgr.xq67_u19.qnpn13g2[ib]
print @q.xbgr.xq67_u19.qnpn13g2[ie]
print @q.xbgr.xq67_u19.qnpn13g2[is]
print @r.xbgr.xq67_u19.rsub[i]
print @c.xbgr.xq67_u19.csub[i]
print @q.xbgr.xq67_u20.qnpn13g2[ic]
print @q.xbgr.xq67_u20.qnpn13g2[ib]
print @q.xbgr.xq67_u20.qnpn13g2[ie]
print @q.xbgr.xq67_u20.qnpn13g2[is]
print @r.xbgr.xq67_u20.rsub[i]
print @c.xbgr.xq67_u20.csub[i]
print @q.xbgr.xq67_u21.qnpn13g2[ic]
print @q.xbgr.xq67_u21.qnpn13g2[ib]
print @q.xbgr.xq67_u21.qnpn13g2[ie]
print @q.xbgr.xq67_u21.qnpn13g2[is]
print @r.xbgr.xq67_u21.rsub[i]
print @c.xbgr.xq67_u21.csub[i]
print @q.xbgr.xq67_u22.qnpn13g2[ic]
print @q.xbgr.xq67_u22.qnpn13g2[ib]
print @q.xbgr.xq67_u22.qnpn13g2[ie]
print @q.xbgr.xq67_u22.qnpn13g2[is]
print @r.xbgr.xq67_u22.rsub[i]
print @c.xbgr.xq67_u22.csub[i]
print @q.xbgr.xq67_u23.qnpn13g2[ic]
print @q.xbgr.xq67_u23.qnpn13g2[ib]
print @q.xbgr.xq67_u23.qnpn13g2[ie]
print @q.xbgr.xq67_u23.qnpn13g2[is]
print @r.xbgr.xq67_u23.rsub[i]
print @c.xbgr.xq67_u23.csub[i]
print @q.xbgr.xq67_u24.qnpn13g2[ic]
print @q.xbgr.xq67_u24.qnpn13g2[ib]
print @q.xbgr.xq67_u24.qnpn13g2[ie]
print @q.xbgr.xq67_u24.qnpn13g2[is]
print @r.xbgr.xq67_u24.rsub[i]
print @c.xbgr.xq67_u24.csub[i]
print @q.xbgr.xq68_u2.qnpn13g2[ic]
print @q.xbgr.xq68_u2.qnpn13g2[ib]
print @q.xbgr.xq68_u2.qnpn13g2[ie]
print @q.xbgr.xq68_u2.qnpn13g2[is]
print @r.xbgr.xq68_u2.rsub[i]
print @c.xbgr.xq68_u2.csub[i]
print @q.xbgr.xq68_u3.qnpn13g2[ic]
print @q.xbgr.xq68_u3.qnpn13g2[ib]
print @q.xbgr.xq68_u3.qnpn13g2[ie]
print @q.xbgr.xq68_u3.qnpn13g2[is]
print @r.xbgr.xq68_u3.rsub[i]
print @c.xbgr.xq68_u3.csub[i]
print @q.xbgr.xq68_u4.qnpn13g2[ic]
print @q.xbgr.xq68_u4.qnpn13g2[ib]
print @q.xbgr.xq68_u4.qnpn13g2[ie]
print @q.xbgr.xq68_u4.qnpn13g2[is]
print @r.xbgr.xq68_u4.rsub[i]
print @c.xbgr.xq68_u4.csub[i]
print @q.xbgr.xq68_u5.qnpn13g2[ic]
print @q.xbgr.xq68_u5.qnpn13g2[ib]
print @q.xbgr.xq68_u5.qnpn13g2[ie]
print @q.xbgr.xq68_u5.qnpn13g2[is]
print @r.xbgr.xq68_u5.rsub[i]
print @c.xbgr.xq68_u5.csub[i]
print @q.xbgr.xq68_u6.qnpn13g2[ic]
print @q.xbgr.xq68_u6.qnpn13g2[ib]
print @q.xbgr.xq68_u6.qnpn13g2[ie]
print @q.xbgr.xq68_u6.qnpn13g2[is]
print @r.xbgr.xq68_u6.rsub[i]
print @c.xbgr.xq68_u6.csub[i]
print @q.xbgr.xq68_u7.qnpn13g2[ic]
print @q.xbgr.xq68_u7.qnpn13g2[ib]
print @q.xbgr.xq68_u7.qnpn13g2[ie]
print @q.xbgr.xq68_u7.qnpn13g2[is]
print @r.xbgr.xq68_u7.rsub[i]
print @c.xbgr.xq68_u7.csub[i]
print @q.xbgr.xq68_u8.qnpn13g2[ic]
print @q.xbgr.xq68_u8.qnpn13g2[ib]
print @q.xbgr.xq68_u8.qnpn13g2[ie]
print @q.xbgr.xq68_u8.qnpn13g2[is]
print @r.xbgr.xq68_u8.rsub[i]
print @c.xbgr.xq68_u8.csub[i]
print @q.xbgr.xq68_u9.qnpn13g2[ic]
print @q.xbgr.xq68_u9.qnpn13g2[ib]
print @q.xbgr.xq68_u9.qnpn13g2[ie]
print @q.xbgr.xq68_u9.qnpn13g2[is]
print @r.xbgr.xq68_u9.rsub[i]
print @c.xbgr.xq68_u9.csub[i]
print @q.xbgr.xq68_u10.qnpn13g2[ic]
print @q.xbgr.xq68_u10.qnpn13g2[ib]
print @q.xbgr.xq68_u10.qnpn13g2[ie]
print @q.xbgr.xq68_u10.qnpn13g2[is]
print @r.xbgr.xq68_u10.rsub[i]
print @c.xbgr.xq68_u10.csub[i]
print @q.xbgr.xq68_u11.qnpn13g2[ic]
print @q.xbgr.xq68_u11.qnpn13g2[ib]
print @q.xbgr.xq68_u11.qnpn13g2[ie]
print @q.xbgr.xq68_u11.qnpn13g2[is]
print @r.xbgr.xq68_u11.rsub[i]
print @c.xbgr.xq68_u11.csub[i]
print @q.xbgr.xq68_u12.qnpn13g2[ic]
print @q.xbgr.xq68_u12.qnpn13g2[ib]
print @q.xbgr.xq68_u12.qnpn13g2[ie]
print @q.xbgr.xq68_u12.qnpn13g2[is]
print @r.xbgr.xq68_u12.rsub[i]
print @c.xbgr.xq68_u12.csub[i]
print @q.xbgr.xq68_u13.qnpn13g2[ic]
print @q.xbgr.xq68_u13.qnpn13g2[ib]
print @q.xbgr.xq68_u13.qnpn13g2[ie]
print @q.xbgr.xq68_u13.qnpn13g2[is]
print @r.xbgr.xq68_u13.rsub[i]
print @c.xbgr.xq68_u13.csub[i]
print @q.xbgr.xq68_u14.qnpn13g2[ic]
print @q.xbgr.xq68_u14.qnpn13g2[ib]
print @q.xbgr.xq68_u14.qnpn13g2[ie]
print @q.xbgr.xq68_u14.qnpn13g2[is]
print @r.xbgr.xq68_u14.rsub[i]
print @c.xbgr.xq68_u14.csub[i]
print @q.xbgr.xq68_u15.qnpn13g2[ic]
print @q.xbgr.xq68_u15.qnpn13g2[ib]
print @q.xbgr.xq68_u15.qnpn13g2[ie]
print @q.xbgr.xq68_u15.qnpn13g2[is]
print @r.xbgr.xq68_u15.rsub[i]
print @c.xbgr.xq68_u15.csub[i]
print @q.xbgr.xq68_u16.qnpn13g2[ic]
print @q.xbgr.xq68_u16.qnpn13g2[ib]
print @q.xbgr.xq68_u16.qnpn13g2[ie]
print @q.xbgr.xq68_u16.qnpn13g2[is]
print @r.xbgr.xq68_u16.rsub[i]
print @c.xbgr.xq68_u16.csub[i]
print @q.xbgr.xq68_u17.qnpn13g2[ic]
print @q.xbgr.xq68_u17.qnpn13g2[ib]
print @q.xbgr.xq68_u17.qnpn13g2[ie]
print @q.xbgr.xq68_u17.qnpn13g2[is]
print @r.xbgr.xq68_u17.rsub[i]
print @c.xbgr.xq68_u17.csub[i]
print @q.xbgr.xq68_u18.qnpn13g2[ic]
print @q.xbgr.xq68_u18.qnpn13g2[ib]
print @q.xbgr.xq68_u18.qnpn13g2[ie]
print @q.xbgr.xq68_u18.qnpn13g2[is]
print @r.xbgr.xq68_u18.rsub[i]
print @c.xbgr.xq68_u18.csub[i]
print @q.xbgr.xq68_u19.qnpn13g2[ic]
print @q.xbgr.xq68_u19.qnpn13g2[ib]
print @q.xbgr.xq68_u19.qnpn13g2[ie]
print @q.xbgr.xq68_u19.qnpn13g2[is]
print @r.xbgr.xq68_u19.rsub[i]
print @c.xbgr.xq68_u19.csub[i]
print @q.xbgr.xq68_u20.qnpn13g2[ic]
print @q.xbgr.xq68_u20.qnpn13g2[ib]
print @q.xbgr.xq68_u20.qnpn13g2[ie]
print @q.xbgr.xq68_u20.qnpn13g2[is]
print @r.xbgr.xq68_u20.rsub[i]
print @c.xbgr.xq68_u20.csub[i]
print @q.xbgr.xq68_u21.qnpn13g2[ic]
print @q.xbgr.xq68_u21.qnpn13g2[ib]
print @q.xbgr.xq68_u21.qnpn13g2[ie]
print @q.xbgr.xq68_u21.qnpn13g2[is]
print @r.xbgr.xq68_u21.rsub[i]
print @c.xbgr.xq68_u21.csub[i]
print @q.xbgr.xq68_u22.qnpn13g2[ic]
print @q.xbgr.xq68_u22.qnpn13g2[ib]
print @q.xbgr.xq68_u22.qnpn13g2[ie]
print @q.xbgr.xq68_u22.qnpn13g2[is]
print @r.xbgr.xq68_u22.rsub[i]
print @c.xbgr.xq68_u22.csub[i]
print @q.xbgr.xq68_u23.qnpn13g2[ic]
print @q.xbgr.xq68_u23.qnpn13g2[ib]
print @q.xbgr.xq68_u23.qnpn13g2[ie]
print @q.xbgr.xq68_u23.qnpn13g2[is]
print @r.xbgr.xq68_u23.rsub[i]
print @c.xbgr.xq68_u23.csub[i]
print @q.xbgr.xq68_u24.qnpn13g2[ic]
print @q.xbgr.xq68_u24.qnpn13g2[ib]
print @q.xbgr.xq68_u24.qnpn13g2[ie]
print @q.xbgr.xq68_u24.qnpn13g2[is]
print @r.xbgr.xq68_u24.rsub[i]
print @c.xbgr.xq68_u24.csub[i]
print @q.xbgr.xq69_u2.qnpn13g2[ic]
print @q.xbgr.xq69_u2.qnpn13g2[ib]
print @q.xbgr.xq69_u2.qnpn13g2[ie]
print @q.xbgr.xq69_u2.qnpn13g2[is]
print @r.xbgr.xq69_u2.rsub[i]
print @c.xbgr.xq69_u2.csub[i]
print @q.xbgr.xq69_u3.qnpn13g2[ic]
print @q.xbgr.xq69_u3.qnpn13g2[ib]
print @q.xbgr.xq69_u3.qnpn13g2[ie]
print @q.xbgr.xq69_u3.qnpn13g2[is]
print @r.xbgr.xq69_u3.rsub[i]
print @c.xbgr.xq69_u3.csub[i]
print @q.xbgr.xq69_u4.qnpn13g2[ic]
print @q.xbgr.xq69_u4.qnpn13g2[ib]
print @q.xbgr.xq69_u4.qnpn13g2[ie]
print @q.xbgr.xq69_u4.qnpn13g2[is]
print @r.xbgr.xq69_u4.rsub[i]
print @c.xbgr.xq69_u4.csub[i]
print @q.xbgr.xq69_u5.qnpn13g2[ic]
print @q.xbgr.xq69_u5.qnpn13g2[ib]
print @q.xbgr.xq69_u5.qnpn13g2[ie]
print @q.xbgr.xq69_u5.qnpn13g2[is]
print @r.xbgr.xq69_u5.rsub[i]
print @c.xbgr.xq69_u5.csub[i]
print @q.xbgr.xq69_u6.qnpn13g2[ic]
print @q.xbgr.xq69_u6.qnpn13g2[ib]
print @q.xbgr.xq69_u6.qnpn13g2[ie]
print @q.xbgr.xq69_u6.qnpn13g2[is]
print @r.xbgr.xq69_u6.rsub[i]
print @c.xbgr.xq69_u6.csub[i]
print @q.xbgr.xq69_u7.qnpn13g2[ic]
print @q.xbgr.xq69_u7.qnpn13g2[ib]
print @q.xbgr.xq69_u7.qnpn13g2[ie]
print @q.xbgr.xq69_u7.qnpn13g2[is]
print @r.xbgr.xq69_u7.rsub[i]
print @c.xbgr.xq69_u7.csub[i]
print @q.xbgr.xq69_u8.qnpn13g2[ic]
print @q.xbgr.xq69_u8.qnpn13g2[ib]
print @q.xbgr.xq69_u8.qnpn13g2[ie]
print @q.xbgr.xq69_u8.qnpn13g2[is]
print @r.xbgr.xq69_u8.rsub[i]
print @c.xbgr.xq69_u8.csub[i]
print @q.xbgr.xq69_u9.qnpn13g2[ic]
print @q.xbgr.xq69_u9.qnpn13g2[ib]
print @q.xbgr.xq69_u9.qnpn13g2[ie]
print @q.xbgr.xq69_u9.qnpn13g2[is]
print @r.xbgr.xq69_u9.rsub[i]
print @c.xbgr.xq69_u9.csub[i]
print @q.xbgr.xq69_u10.qnpn13g2[ic]
print @q.xbgr.xq69_u10.qnpn13g2[ib]
print @q.xbgr.xq69_u10.qnpn13g2[ie]
print @q.xbgr.xq69_u10.qnpn13g2[is]
print @r.xbgr.xq69_u10.rsub[i]
print @c.xbgr.xq69_u10.csub[i]
print @q.xbgr.xq69_u11.qnpn13g2[ic]
print @q.xbgr.xq69_u11.qnpn13g2[ib]
print @q.xbgr.xq69_u11.qnpn13g2[ie]
print @q.xbgr.xq69_u11.qnpn13g2[is]
print @r.xbgr.xq69_u11.rsub[i]
print @c.xbgr.xq69_u11.csub[i]
print @q.xbgr.xq69_u12.qnpn13g2[ic]
print @q.xbgr.xq69_u12.qnpn13g2[ib]
print @q.xbgr.xq69_u12.qnpn13g2[ie]
print @q.xbgr.xq69_u12.qnpn13g2[is]
print @r.xbgr.xq69_u12.rsub[i]
print @c.xbgr.xq69_u12.csub[i]
print @q.xbgr.xq69_u13.qnpn13g2[ic]
print @q.xbgr.xq69_u13.qnpn13g2[ib]
print @q.xbgr.xq69_u13.qnpn13g2[ie]
print @q.xbgr.xq69_u13.qnpn13g2[is]
print @r.xbgr.xq69_u13.rsub[i]
print @c.xbgr.xq69_u13.csub[i]
print @q.xbgr.xq69_u14.qnpn13g2[ic]
print @q.xbgr.xq69_u14.qnpn13g2[ib]
print @q.xbgr.xq69_u14.qnpn13g2[ie]
print @q.xbgr.xq69_u14.qnpn13g2[is]
print @r.xbgr.xq69_u14.rsub[i]
print @c.xbgr.xq69_u14.csub[i]
print @q.xbgr.xq69_u15.qnpn13g2[ic]
print @q.xbgr.xq69_u15.qnpn13g2[ib]
print @q.xbgr.xq69_u15.qnpn13g2[ie]
print @q.xbgr.xq69_u15.qnpn13g2[is]
print @r.xbgr.xq69_u15.rsub[i]
print @c.xbgr.xq69_u15.csub[i]
print @q.xbgr.xq69_u16.qnpn13g2[ic]
print @q.xbgr.xq69_u16.qnpn13g2[ib]
print @q.xbgr.xq69_u16.qnpn13g2[ie]
print @q.xbgr.xq69_u16.qnpn13g2[is]
print @r.xbgr.xq69_u16.rsub[i]
print @c.xbgr.xq69_u16.csub[i]
print @q.xbgr.xq69_u17.qnpn13g2[ic]
print @q.xbgr.xq69_u17.qnpn13g2[ib]
print @q.xbgr.xq69_u17.qnpn13g2[ie]
print @q.xbgr.xq69_u17.qnpn13g2[is]
print @r.xbgr.xq69_u17.rsub[i]
print @c.xbgr.xq69_u17.csub[i]
print @q.xbgr.xq69_u18.qnpn13g2[ic]
print @q.xbgr.xq69_u18.qnpn13g2[ib]
print @q.xbgr.xq69_u18.qnpn13g2[ie]
print @q.xbgr.xq69_u18.qnpn13g2[is]
print @r.xbgr.xq69_u18.rsub[i]
print @c.xbgr.xq69_u18.csub[i]
print @q.xbgr.xq69_u19.qnpn13g2[ic]
print @q.xbgr.xq69_u19.qnpn13g2[ib]
print @q.xbgr.xq69_u19.qnpn13g2[ie]
print @q.xbgr.xq69_u19.qnpn13g2[is]
print @r.xbgr.xq69_u19.rsub[i]
print @c.xbgr.xq69_u19.csub[i]
print @q.xbgr.xq69_u20.qnpn13g2[ic]
print @q.xbgr.xq69_u20.qnpn13g2[ib]
print @q.xbgr.xq69_u20.qnpn13g2[ie]
print @q.xbgr.xq69_u20.qnpn13g2[is]
print @r.xbgr.xq69_u20.rsub[i]
print @c.xbgr.xq69_u20.csub[i]
print @q.xbgr.xq69_u21.qnpn13g2[ic]
print @q.xbgr.xq69_u21.qnpn13g2[ib]
print @q.xbgr.xq69_u21.qnpn13g2[ie]
print @q.xbgr.xq69_u21.qnpn13g2[is]
print @r.xbgr.xq69_u21.rsub[i]
print @c.xbgr.xq69_u21.csub[i]
print @q.xbgr.xq69_u22.qnpn13g2[ic]
print @q.xbgr.xq69_u22.qnpn13g2[ib]
print @q.xbgr.xq69_u22.qnpn13g2[ie]
print @q.xbgr.xq69_u22.qnpn13g2[is]
print @r.xbgr.xq69_u22.rsub[i]
print @c.xbgr.xq69_u22.csub[i]
print @q.xbgr.xq69_u23.qnpn13g2[ic]
print @q.xbgr.xq69_u23.qnpn13g2[ib]
print @q.xbgr.xq69_u23.qnpn13g2[ie]
print @q.xbgr.xq69_u23.qnpn13g2[is]
print @r.xbgr.xq69_u23.rsub[i]
print @c.xbgr.xq69_u23.csub[i]
print @q.xbgr.xq69_u24.qnpn13g2[ic]
print @q.xbgr.xq69_u24.qnpn13g2[ib]
print @q.xbgr.xq69_u24.qnpn13g2[ie]
print @q.xbgr.xq69_u24.qnpn13g2[is]
print @r.xbgr.xq69_u24.rsub[i]
print @c.xbgr.xq69_u24.csub[i]
print @q.xbgr.xq70_u2.qnpn13g2[ic]
print @q.xbgr.xq70_u2.qnpn13g2[ib]
print @q.xbgr.xq70_u2.qnpn13g2[ie]
print @q.xbgr.xq70_u2.qnpn13g2[is]
print @r.xbgr.xq70_u2.rsub[i]
print @c.xbgr.xq70_u2.csub[i]
print @q.xbgr.xq70_u3.qnpn13g2[ic]
print @q.xbgr.xq70_u3.qnpn13g2[ib]
print @q.xbgr.xq70_u3.qnpn13g2[ie]
print @q.xbgr.xq70_u3.qnpn13g2[is]
print @r.xbgr.xq70_u3.rsub[i]
print @c.xbgr.xq70_u3.csub[i]
print @q.xbgr.xq70_u4.qnpn13g2[ic]
print @q.xbgr.xq70_u4.qnpn13g2[ib]
print @q.xbgr.xq70_u4.qnpn13g2[ie]
print @q.xbgr.xq70_u4.qnpn13g2[is]
print @r.xbgr.xq70_u4.rsub[i]
print @c.xbgr.xq70_u4.csub[i]
print @q.xbgr.xq70_u5.qnpn13g2[ic]
print @q.xbgr.xq70_u5.qnpn13g2[ib]
print @q.xbgr.xq70_u5.qnpn13g2[ie]
print @q.xbgr.xq70_u5.qnpn13g2[is]
print @r.xbgr.xq70_u5.rsub[i]
print @c.xbgr.xq70_u5.csub[i]
print @q.xbgr.xq70_u6.qnpn13g2[ic]
print @q.xbgr.xq70_u6.qnpn13g2[ib]
print @q.xbgr.xq70_u6.qnpn13g2[ie]
print @q.xbgr.xq70_u6.qnpn13g2[is]
print @r.xbgr.xq70_u6.rsub[i]
print @c.xbgr.xq70_u6.csub[i]
print @q.xbgr.xq70_u7.qnpn13g2[ic]
print @q.xbgr.xq70_u7.qnpn13g2[ib]
print @q.xbgr.xq70_u7.qnpn13g2[ie]
print @q.xbgr.xq70_u7.qnpn13g2[is]
print @r.xbgr.xq70_u7.rsub[i]
print @c.xbgr.xq70_u7.csub[i]
print @q.xbgr.xq70_u8.qnpn13g2[ic]
print @q.xbgr.xq70_u8.qnpn13g2[ib]
print @q.xbgr.xq70_u8.qnpn13g2[ie]
print @q.xbgr.xq70_u8.qnpn13g2[is]
print @r.xbgr.xq70_u8.rsub[i]
print @c.xbgr.xq70_u8.csub[i]
print @q.xbgr.xq70_u9.qnpn13g2[ic]
print @q.xbgr.xq70_u9.qnpn13g2[ib]
print @q.xbgr.xq70_u9.qnpn13g2[ie]
print @q.xbgr.xq70_u9.qnpn13g2[is]
print @r.xbgr.xq70_u9.rsub[i]
print @c.xbgr.xq70_u9.csub[i]
print @q.xbgr.xq70_u10.qnpn13g2[ic]
print @q.xbgr.xq70_u10.qnpn13g2[ib]
print @q.xbgr.xq70_u10.qnpn13g2[ie]
print @q.xbgr.xq70_u10.qnpn13g2[is]
print @r.xbgr.xq70_u10.rsub[i]
print @c.xbgr.xq70_u10.csub[i]
print @q.xbgr.xq70_u11.qnpn13g2[ic]
print @q.xbgr.xq70_u11.qnpn13g2[ib]
print @q.xbgr.xq70_u11.qnpn13g2[ie]
print @q.xbgr.xq70_u11.qnpn13g2[is]
print @r.xbgr.xq70_u11.rsub[i]
print @c.xbgr.xq70_u11.csub[i]
print @q.xbgr.xq70_u12.qnpn13g2[ic]
print @q.xbgr.xq70_u12.qnpn13g2[ib]
print @q.xbgr.xq70_u12.qnpn13g2[ie]
print @q.xbgr.xq70_u12.qnpn13g2[is]
print @r.xbgr.xq70_u12.rsub[i]
print @c.xbgr.xq70_u12.csub[i]
print @q.xbgr.xq70_u13.qnpn13g2[ic]
print @q.xbgr.xq70_u13.qnpn13g2[ib]
print @q.xbgr.xq70_u13.qnpn13g2[ie]
print @q.xbgr.xq70_u13.qnpn13g2[is]
print @r.xbgr.xq70_u13.rsub[i]
print @c.xbgr.xq70_u13.csub[i]
print @q.xbgr.xq70_u14.qnpn13g2[ic]
print @q.xbgr.xq70_u14.qnpn13g2[ib]
print @q.xbgr.xq70_u14.qnpn13g2[ie]
print @q.xbgr.xq70_u14.qnpn13g2[is]
print @r.xbgr.xq70_u14.rsub[i]
print @c.xbgr.xq70_u14.csub[i]
print @q.xbgr.xq70_u15.qnpn13g2[ic]
print @q.xbgr.xq70_u15.qnpn13g2[ib]
print @q.xbgr.xq70_u15.qnpn13g2[ie]
print @q.xbgr.xq70_u15.qnpn13g2[is]
print @r.xbgr.xq70_u15.rsub[i]
print @c.xbgr.xq70_u15.csub[i]
print @q.xbgr.xq70_u16.qnpn13g2[ic]
print @q.xbgr.xq70_u16.qnpn13g2[ib]
print @q.xbgr.xq70_u16.qnpn13g2[ie]
print @q.xbgr.xq70_u16.qnpn13g2[is]
print @r.xbgr.xq70_u16.rsub[i]
print @c.xbgr.xq70_u16.csub[i]
print @q.xbgr.xq70_u17.qnpn13g2[ic]
print @q.xbgr.xq70_u17.qnpn13g2[ib]
print @q.xbgr.xq70_u17.qnpn13g2[ie]
print @q.xbgr.xq70_u17.qnpn13g2[is]
print @r.xbgr.xq70_u17.rsub[i]
print @c.xbgr.xq70_u17.csub[i]
print @q.xbgr.xq70_u18.qnpn13g2[ic]
print @q.xbgr.xq70_u18.qnpn13g2[ib]
print @q.xbgr.xq70_u18.qnpn13g2[ie]
print @q.xbgr.xq70_u18.qnpn13g2[is]
print @r.xbgr.xq70_u18.rsub[i]
print @c.xbgr.xq70_u18.csub[i]
print @q.xbgr.xq70_u19.qnpn13g2[ic]
print @q.xbgr.xq70_u19.qnpn13g2[ib]
print @q.xbgr.xq70_u19.qnpn13g2[ie]
print @q.xbgr.xq70_u19.qnpn13g2[is]
print @r.xbgr.xq70_u19.rsub[i]
print @c.xbgr.xq70_u19.csub[i]
print @q.xbgr.xq70_u20.qnpn13g2[ic]
print @q.xbgr.xq70_u20.qnpn13g2[ib]
print @q.xbgr.xq70_u20.qnpn13g2[ie]
print @q.xbgr.xq70_u20.qnpn13g2[is]
print @r.xbgr.xq70_u20.rsub[i]
print @c.xbgr.xq70_u20.csub[i]
print @q.xbgr.xq70_u21.qnpn13g2[ic]
print @q.xbgr.xq70_u21.qnpn13g2[ib]
print @q.xbgr.xq70_u21.qnpn13g2[ie]
print @q.xbgr.xq70_u21.qnpn13g2[is]
print @r.xbgr.xq70_u21.rsub[i]
print @c.xbgr.xq70_u21.csub[i]
print @q.xbgr.xq70_u22.qnpn13g2[ic]
print @q.xbgr.xq70_u22.qnpn13g2[ib]
print @q.xbgr.xq70_u22.qnpn13g2[ie]
print @q.xbgr.xq70_u22.qnpn13g2[is]
print @r.xbgr.xq70_u22.rsub[i]
print @c.xbgr.xq70_u22.csub[i]
print @q.xbgr.xq70_u23.qnpn13g2[ic]
print @q.xbgr.xq70_u23.qnpn13g2[ib]
print @q.xbgr.xq70_u23.qnpn13g2[ie]
print @q.xbgr.xq70_u23.qnpn13g2[is]
print @r.xbgr.xq70_u23.rsub[i]
print @c.xbgr.xq70_u23.csub[i]
print @q.xbgr.xq70_u24.qnpn13g2[ic]
print @q.xbgr.xq70_u24.qnpn13g2[ib]
print @q.xbgr.xq70_u24.qnpn13g2[ie]
print @q.xbgr.xq70_u24.qnpn13g2[is]
print @r.xbgr.xq70_u24.rsub[i]
print @c.xbgr.xq70_u24.csub[i]
print @q.xbgr.xq71_u2.qnpn13g2[ic]
print @q.xbgr.xq71_u2.qnpn13g2[ib]
print @q.xbgr.xq71_u2.qnpn13g2[ie]
print @q.xbgr.xq71_u2.qnpn13g2[is]
print @r.xbgr.xq71_u2.rsub[i]
print @c.xbgr.xq71_u2.csub[i]
print @q.xbgr.xq71_u3.qnpn13g2[ic]
print @q.xbgr.xq71_u3.qnpn13g2[ib]
print @q.xbgr.xq71_u3.qnpn13g2[ie]
print @q.xbgr.xq71_u3.qnpn13g2[is]
print @r.xbgr.xq71_u3.rsub[i]
print @c.xbgr.xq71_u3.csub[i]
print @q.xbgr.xq71_u4.qnpn13g2[ic]
print @q.xbgr.xq71_u4.qnpn13g2[ib]
print @q.xbgr.xq71_u4.qnpn13g2[ie]
print @q.xbgr.xq71_u4.qnpn13g2[is]
print @r.xbgr.xq71_u4.rsub[i]
print @c.xbgr.xq71_u4.csub[i]
print @q.xbgr.xq71_u5.qnpn13g2[ic]
print @q.xbgr.xq71_u5.qnpn13g2[ib]
print @q.xbgr.xq71_u5.qnpn13g2[ie]
print @q.xbgr.xq71_u5.qnpn13g2[is]
print @r.xbgr.xq71_u5.rsub[i]
print @c.xbgr.xq71_u5.csub[i]
print @q.xbgr.xq71_u6.qnpn13g2[ic]
print @q.xbgr.xq71_u6.qnpn13g2[ib]
print @q.xbgr.xq71_u6.qnpn13g2[ie]
print @q.xbgr.xq71_u6.qnpn13g2[is]
print @r.xbgr.xq71_u6.rsub[i]
print @c.xbgr.xq71_u6.csub[i]
print @q.xbgr.xq71_u7.qnpn13g2[ic]
print @q.xbgr.xq71_u7.qnpn13g2[ib]
print @q.xbgr.xq71_u7.qnpn13g2[ie]
print @q.xbgr.xq71_u7.qnpn13g2[is]
print @r.xbgr.xq71_u7.rsub[i]
print @c.xbgr.xq71_u7.csub[i]
print @q.xbgr.xq71_u8.qnpn13g2[ic]
print @q.xbgr.xq71_u8.qnpn13g2[ib]
print @q.xbgr.xq71_u8.qnpn13g2[ie]
print @q.xbgr.xq71_u8.qnpn13g2[is]
print @r.xbgr.xq71_u8.rsub[i]
print @c.xbgr.xq71_u8.csub[i]
print @q.xbgr.xq71_u9.qnpn13g2[ic]
print @q.xbgr.xq71_u9.qnpn13g2[ib]
print @q.xbgr.xq71_u9.qnpn13g2[ie]
print @q.xbgr.xq71_u9.qnpn13g2[is]
print @r.xbgr.xq71_u9.rsub[i]
print @c.xbgr.xq71_u9.csub[i]
print @q.xbgr.xq71_u10.qnpn13g2[ic]
print @q.xbgr.xq71_u10.qnpn13g2[ib]
print @q.xbgr.xq71_u10.qnpn13g2[ie]
print @q.xbgr.xq71_u10.qnpn13g2[is]
print @r.xbgr.xq71_u10.rsub[i]
print @c.xbgr.xq71_u10.csub[i]
print @q.xbgr.xq71_u11.qnpn13g2[ic]
print @q.xbgr.xq71_u11.qnpn13g2[ib]
print @q.xbgr.xq71_u11.qnpn13g2[ie]
print @q.xbgr.xq71_u11.qnpn13g2[is]
print @r.xbgr.xq71_u11.rsub[i]
print @c.xbgr.xq71_u11.csub[i]
print @q.xbgr.xq71_u12.qnpn13g2[ic]
print @q.xbgr.xq71_u12.qnpn13g2[ib]
print @q.xbgr.xq71_u12.qnpn13g2[ie]
print @q.xbgr.xq71_u12.qnpn13g2[is]
print @r.xbgr.xq71_u12.rsub[i]
print @c.xbgr.xq71_u12.csub[i]
print @q.xbgr.xq71_u13.qnpn13g2[ic]
print @q.xbgr.xq71_u13.qnpn13g2[ib]
print @q.xbgr.xq71_u13.qnpn13g2[ie]
print @q.xbgr.xq71_u13.qnpn13g2[is]
print @r.xbgr.xq71_u13.rsub[i]
print @c.xbgr.xq71_u13.csub[i]
print @q.xbgr.xq71_u14.qnpn13g2[ic]
print @q.xbgr.xq71_u14.qnpn13g2[ib]
print @q.xbgr.xq71_u14.qnpn13g2[ie]
print @q.xbgr.xq71_u14.qnpn13g2[is]
print @r.xbgr.xq71_u14.rsub[i]
print @c.xbgr.xq71_u14.csub[i]
print @q.xbgr.xq71_u15.qnpn13g2[ic]
print @q.xbgr.xq71_u15.qnpn13g2[ib]
print @q.xbgr.xq71_u15.qnpn13g2[ie]
print @q.xbgr.xq71_u15.qnpn13g2[is]
print @r.xbgr.xq71_u15.rsub[i]
print @c.xbgr.xq71_u15.csub[i]
print @q.xbgr.xq71_u16.qnpn13g2[ic]
print @q.xbgr.xq71_u16.qnpn13g2[ib]
print @q.xbgr.xq71_u16.qnpn13g2[ie]
print @q.xbgr.xq71_u16.qnpn13g2[is]
print @r.xbgr.xq71_u16.rsub[i]
print @c.xbgr.xq71_u16.csub[i]
print @q.xbgr.xq71_u17.qnpn13g2[ic]
print @q.xbgr.xq71_u17.qnpn13g2[ib]
print @q.xbgr.xq71_u17.qnpn13g2[ie]
print @q.xbgr.xq71_u17.qnpn13g2[is]
print @r.xbgr.xq71_u17.rsub[i]
print @c.xbgr.xq71_u17.csub[i]
print @q.xbgr.xq71_u18.qnpn13g2[ic]
print @q.xbgr.xq71_u18.qnpn13g2[ib]
print @q.xbgr.xq71_u18.qnpn13g2[ie]
print @q.xbgr.xq71_u18.qnpn13g2[is]
print @r.xbgr.xq71_u18.rsub[i]
print @c.xbgr.xq71_u18.csub[i]
print @q.xbgr.xq71_u19.qnpn13g2[ic]
print @q.xbgr.xq71_u19.qnpn13g2[ib]
print @q.xbgr.xq71_u19.qnpn13g2[ie]
print @q.xbgr.xq71_u19.qnpn13g2[is]
print @r.xbgr.xq71_u19.rsub[i]
print @c.xbgr.xq71_u19.csub[i]
print @q.xbgr.xq71_u20.qnpn13g2[ic]
print @q.xbgr.xq71_u20.qnpn13g2[ib]
print @q.xbgr.xq71_u20.qnpn13g2[ie]
print @q.xbgr.xq71_u20.qnpn13g2[is]
print @r.xbgr.xq71_u20.rsub[i]
print @c.xbgr.xq71_u20.csub[i]
print @q.xbgr.xq71_u21.qnpn13g2[ic]
print @q.xbgr.xq71_u21.qnpn13g2[ib]
print @q.xbgr.xq71_u21.qnpn13g2[ie]
print @q.xbgr.xq71_u21.qnpn13g2[is]
print @r.xbgr.xq71_u21.rsub[i]
print @c.xbgr.xq71_u21.csub[i]
print @q.xbgr.xq71_u22.qnpn13g2[ic]
print @q.xbgr.xq71_u22.qnpn13g2[ib]
print @q.xbgr.xq71_u22.qnpn13g2[ie]
print @q.xbgr.xq71_u22.qnpn13g2[is]
print @r.xbgr.xq71_u22.rsub[i]
print @c.xbgr.xq71_u22.csub[i]
print @q.xbgr.xq71_u23.qnpn13g2[ic]
print @q.xbgr.xq71_u23.qnpn13g2[ib]
print @q.xbgr.xq71_u23.qnpn13g2[ie]
print @q.xbgr.xq71_u23.qnpn13g2[is]
print @r.xbgr.xq71_u23.rsub[i]
print @c.xbgr.xq71_u23.csub[i]
print @q.xbgr.xq71_u24.qnpn13g2[ic]
print @q.xbgr.xq71_u24.qnpn13g2[ib]
print @q.xbgr.xq71_u24.qnpn13g2[ie]
print @q.xbgr.xq71_u24.qnpn13g2[is]
print @r.xbgr.xq71_u24.rsub[i]
print @c.xbgr.xq71_u24.csub[i]
print @q.xbgr.xq72_u2.qnpn13g2[ic]
print @q.xbgr.xq72_u2.qnpn13g2[ib]
print @q.xbgr.xq72_u2.qnpn13g2[ie]
print @q.xbgr.xq72_u2.qnpn13g2[is]
print @r.xbgr.xq72_u2.rsub[i]
print @c.xbgr.xq72_u2.csub[i]
print @q.xbgr.xq72_u3.qnpn13g2[ic]
print @q.xbgr.xq72_u3.qnpn13g2[ib]
print @q.xbgr.xq72_u3.qnpn13g2[ie]
print @q.xbgr.xq72_u3.qnpn13g2[is]
print @r.xbgr.xq72_u3.rsub[i]
print @c.xbgr.xq72_u3.csub[i]
print @q.xbgr.xq72_u4.qnpn13g2[ic]
print @q.xbgr.xq72_u4.qnpn13g2[ib]
print @q.xbgr.xq72_u4.qnpn13g2[ie]
print @q.xbgr.xq72_u4.qnpn13g2[is]
print @r.xbgr.xq72_u4.rsub[i]
print @c.xbgr.xq72_u4.csub[i]
print @q.xbgr.xq72_u5.qnpn13g2[ic]
print @q.xbgr.xq72_u5.qnpn13g2[ib]
print @q.xbgr.xq72_u5.qnpn13g2[ie]
print @q.xbgr.xq72_u5.qnpn13g2[is]
print @r.xbgr.xq72_u5.rsub[i]
print @c.xbgr.xq72_u5.csub[i]
print @q.xbgr.xq72_u6.qnpn13g2[ic]
print @q.xbgr.xq72_u6.qnpn13g2[ib]
print @q.xbgr.xq72_u6.qnpn13g2[ie]
print @q.xbgr.xq72_u6.qnpn13g2[is]
print @r.xbgr.xq72_u6.rsub[i]
print @c.xbgr.xq72_u6.csub[i]
print @q.xbgr.xq72_u7.qnpn13g2[ic]
print @q.xbgr.xq72_u7.qnpn13g2[ib]
print @q.xbgr.xq72_u7.qnpn13g2[ie]
print @q.xbgr.xq72_u7.qnpn13g2[is]
print @r.xbgr.xq72_u7.rsub[i]
print @c.xbgr.xq72_u7.csub[i]
print @q.xbgr.xq72_u8.qnpn13g2[ic]
print @q.xbgr.xq72_u8.qnpn13g2[ib]
print @q.xbgr.xq72_u8.qnpn13g2[ie]
print @q.xbgr.xq72_u8.qnpn13g2[is]
print @r.xbgr.xq72_u8.rsub[i]
print @c.xbgr.xq72_u8.csub[i]
print @q.xbgr.xq72_u9.qnpn13g2[ic]
print @q.xbgr.xq72_u9.qnpn13g2[ib]
print @q.xbgr.xq72_u9.qnpn13g2[ie]
print @q.xbgr.xq72_u9.qnpn13g2[is]
print @r.xbgr.xq72_u9.rsub[i]
print @c.xbgr.xq72_u9.csub[i]
print @q.xbgr.xq72_u10.qnpn13g2[ic]
print @q.xbgr.xq72_u10.qnpn13g2[ib]
print @q.xbgr.xq72_u10.qnpn13g2[ie]
print @q.xbgr.xq72_u10.qnpn13g2[is]
print @r.xbgr.xq72_u10.rsub[i]
print @c.xbgr.xq72_u10.csub[i]
print @q.xbgr.xq72_u11.qnpn13g2[ic]
print @q.xbgr.xq72_u11.qnpn13g2[ib]
print @q.xbgr.xq72_u11.qnpn13g2[ie]
print @q.xbgr.xq72_u11.qnpn13g2[is]
print @r.xbgr.xq72_u11.rsub[i]
print @c.xbgr.xq72_u11.csub[i]
print @q.xbgr.xq72_u12.qnpn13g2[ic]
print @q.xbgr.xq72_u12.qnpn13g2[ib]
print @q.xbgr.xq72_u12.qnpn13g2[ie]
print @q.xbgr.xq72_u12.qnpn13g2[is]
print @r.xbgr.xq72_u12.rsub[i]
print @c.xbgr.xq72_u12.csub[i]
print @q.xbgr.xq72_u13.qnpn13g2[ic]
print @q.xbgr.xq72_u13.qnpn13g2[ib]
print @q.xbgr.xq72_u13.qnpn13g2[ie]
print @q.xbgr.xq72_u13.qnpn13g2[is]
print @r.xbgr.xq72_u13.rsub[i]
print @c.xbgr.xq72_u13.csub[i]
print @q.xbgr.xq72_u14.qnpn13g2[ic]
print @q.xbgr.xq72_u14.qnpn13g2[ib]
print @q.xbgr.xq72_u14.qnpn13g2[ie]
print @q.xbgr.xq72_u14.qnpn13g2[is]
print @r.xbgr.xq72_u14.rsub[i]
print @c.xbgr.xq72_u14.csub[i]
print @q.xbgr.xq72_u15.qnpn13g2[ic]
print @q.xbgr.xq72_u15.qnpn13g2[ib]
print @q.xbgr.xq72_u15.qnpn13g2[ie]
print @q.xbgr.xq72_u15.qnpn13g2[is]
print @r.xbgr.xq72_u15.rsub[i]
print @c.xbgr.xq72_u15.csub[i]
print @q.xbgr.xq72_u16.qnpn13g2[ic]
print @q.xbgr.xq72_u16.qnpn13g2[ib]
print @q.xbgr.xq72_u16.qnpn13g2[ie]
print @q.xbgr.xq72_u16.qnpn13g2[is]
print @r.xbgr.xq72_u16.rsub[i]
print @c.xbgr.xq72_u16.csub[i]
print @q.xbgr.xq72_u17.qnpn13g2[ic]
print @q.xbgr.xq72_u17.qnpn13g2[ib]
print @q.xbgr.xq72_u17.qnpn13g2[ie]
print @q.xbgr.xq72_u17.qnpn13g2[is]
print @r.xbgr.xq72_u17.rsub[i]
print @c.xbgr.xq72_u17.csub[i]
print @q.xbgr.xq72_u18.qnpn13g2[ic]
print @q.xbgr.xq72_u18.qnpn13g2[ib]
print @q.xbgr.xq72_u18.qnpn13g2[ie]
print @q.xbgr.xq72_u18.qnpn13g2[is]
print @r.xbgr.xq72_u18.rsub[i]
print @c.xbgr.xq72_u18.csub[i]
print @q.xbgr.xq72_u19.qnpn13g2[ic]
print @q.xbgr.xq72_u19.qnpn13g2[ib]
print @q.xbgr.xq72_u19.qnpn13g2[ie]
print @q.xbgr.xq72_u19.qnpn13g2[is]
print @r.xbgr.xq72_u19.rsub[i]
print @c.xbgr.xq72_u19.csub[i]
print @q.xbgr.xq72_u20.qnpn13g2[ic]
print @q.xbgr.xq72_u20.qnpn13g2[ib]
print @q.xbgr.xq72_u20.qnpn13g2[ie]
print @q.xbgr.xq72_u20.qnpn13g2[is]
print @r.xbgr.xq72_u20.rsub[i]
print @c.xbgr.xq72_u20.csub[i]
print @q.xbgr.xq72_u21.qnpn13g2[ic]
print @q.xbgr.xq72_u21.qnpn13g2[ib]
print @q.xbgr.xq72_u21.qnpn13g2[ie]
print @q.xbgr.xq72_u21.qnpn13g2[is]
print @r.xbgr.xq72_u21.rsub[i]
print @c.xbgr.xq72_u21.csub[i]
print @q.xbgr.xq72_u22.qnpn13g2[ic]
print @q.xbgr.xq72_u22.qnpn13g2[ib]
print @q.xbgr.xq72_u22.qnpn13g2[ie]
print @q.xbgr.xq72_u22.qnpn13g2[is]
print @r.xbgr.xq72_u22.rsub[i]
print @c.xbgr.xq72_u22.csub[i]
print @q.xbgr.xq72_u23.qnpn13g2[ic]
print @q.xbgr.xq72_u23.qnpn13g2[ib]
print @q.xbgr.xq72_u23.qnpn13g2[ie]
print @q.xbgr.xq72_u23.qnpn13g2[is]
print @r.xbgr.xq72_u23.rsub[i]
print @c.xbgr.xq72_u23.csub[i]
print @q.xbgr.xq72_u24.qnpn13g2[ic]
print @q.xbgr.xq72_u24.qnpn13g2[ib]
print @q.xbgr.xq72_u24.qnpn13g2[ie]
print @q.xbgr.xq72_u24.qnpn13g2[is]
print @r.xbgr.xq72_u24.rsub[i]
print @c.xbgr.xq72_u24.csub[i]
print @q.xbgr.xq73_u2.qnpn13g2[ic]
print @q.xbgr.xq73_u2.qnpn13g2[ib]
print @q.xbgr.xq73_u2.qnpn13g2[ie]
print @q.xbgr.xq73_u2.qnpn13g2[is]
print @r.xbgr.xq73_u2.rsub[i]
print @c.xbgr.xq73_u2.csub[i]
print @q.xbgr.xq73_u3.qnpn13g2[ic]
print @q.xbgr.xq73_u3.qnpn13g2[ib]
print @q.xbgr.xq73_u3.qnpn13g2[ie]
print @q.xbgr.xq73_u3.qnpn13g2[is]
print @r.xbgr.xq73_u3.rsub[i]
print @c.xbgr.xq73_u3.csub[i]
print @q.xbgr.xq73_u4.qnpn13g2[ic]
print @q.xbgr.xq73_u4.qnpn13g2[ib]
print @q.xbgr.xq73_u4.qnpn13g2[ie]
print @q.xbgr.xq73_u4.qnpn13g2[is]
print @r.xbgr.xq73_u4.rsub[i]
print @c.xbgr.xq73_u4.csub[i]
print @q.xbgr.xq73_u5.qnpn13g2[ic]
print @q.xbgr.xq73_u5.qnpn13g2[ib]
print @q.xbgr.xq73_u5.qnpn13g2[ie]
print @q.xbgr.xq73_u5.qnpn13g2[is]
print @r.xbgr.xq73_u5.rsub[i]
print @c.xbgr.xq73_u5.csub[i]
print @q.xbgr.xq73_u6.qnpn13g2[ic]
print @q.xbgr.xq73_u6.qnpn13g2[ib]
print @q.xbgr.xq73_u6.qnpn13g2[ie]
print @q.xbgr.xq73_u6.qnpn13g2[is]
print @r.xbgr.xq73_u6.rsub[i]
print @c.xbgr.xq73_u6.csub[i]
print @q.xbgr.xq73_u7.qnpn13g2[ic]
print @q.xbgr.xq73_u7.qnpn13g2[ib]
print @q.xbgr.xq73_u7.qnpn13g2[ie]
print @q.xbgr.xq73_u7.qnpn13g2[is]
print @r.xbgr.xq73_u7.rsub[i]
print @c.xbgr.xq73_u7.csub[i]
print @q.xbgr.xq73_u8.qnpn13g2[ic]
print @q.xbgr.xq73_u8.qnpn13g2[ib]
print @q.xbgr.xq73_u8.qnpn13g2[ie]
print @q.xbgr.xq73_u8.qnpn13g2[is]
print @r.xbgr.xq73_u8.rsub[i]
print @c.xbgr.xq73_u8.csub[i]
print @q.xbgr.xq73_u9.qnpn13g2[ic]
print @q.xbgr.xq73_u9.qnpn13g2[ib]
print @q.xbgr.xq73_u9.qnpn13g2[ie]
print @q.xbgr.xq73_u9.qnpn13g2[is]
print @r.xbgr.xq73_u9.rsub[i]
print @c.xbgr.xq73_u9.csub[i]
print @q.xbgr.xq73_u10.qnpn13g2[ic]
print @q.xbgr.xq73_u10.qnpn13g2[ib]
print @q.xbgr.xq73_u10.qnpn13g2[ie]
print @q.xbgr.xq73_u10.qnpn13g2[is]
print @r.xbgr.xq73_u10.rsub[i]
print @c.xbgr.xq73_u10.csub[i]
print @q.xbgr.xq73_u11.qnpn13g2[ic]
print @q.xbgr.xq73_u11.qnpn13g2[ib]
print @q.xbgr.xq73_u11.qnpn13g2[ie]
print @q.xbgr.xq73_u11.qnpn13g2[is]
print @r.xbgr.xq73_u11.rsub[i]
print @c.xbgr.xq73_u11.csub[i]
print @q.xbgr.xq73_u12.qnpn13g2[ic]
print @q.xbgr.xq73_u12.qnpn13g2[ib]
print @q.xbgr.xq73_u12.qnpn13g2[ie]
print @q.xbgr.xq73_u12.qnpn13g2[is]
print @r.xbgr.xq73_u12.rsub[i]
print @c.xbgr.xq73_u12.csub[i]
print @q.xbgr.xq73_u13.qnpn13g2[ic]
print @q.xbgr.xq73_u13.qnpn13g2[ib]
print @q.xbgr.xq73_u13.qnpn13g2[ie]
print @q.xbgr.xq73_u13.qnpn13g2[is]
print @r.xbgr.xq73_u13.rsub[i]
print @c.xbgr.xq73_u13.csub[i]
print @q.xbgr.xq73_u14.qnpn13g2[ic]
print @q.xbgr.xq73_u14.qnpn13g2[ib]
print @q.xbgr.xq73_u14.qnpn13g2[ie]
print @q.xbgr.xq73_u14.qnpn13g2[is]
print @r.xbgr.xq73_u14.rsub[i]
print @c.xbgr.xq73_u14.csub[i]
print @q.xbgr.xq73_u15.qnpn13g2[ic]
print @q.xbgr.xq73_u15.qnpn13g2[ib]
print @q.xbgr.xq73_u15.qnpn13g2[ie]
print @q.xbgr.xq73_u15.qnpn13g2[is]
print @r.xbgr.xq73_u15.rsub[i]
print @c.xbgr.xq73_u15.csub[i]
print @q.xbgr.xq73_u16.qnpn13g2[ic]
print @q.xbgr.xq73_u16.qnpn13g2[ib]
print @q.xbgr.xq73_u16.qnpn13g2[ie]
print @q.xbgr.xq73_u16.qnpn13g2[is]
print @r.xbgr.xq73_u16.rsub[i]
print @c.xbgr.xq73_u16.csub[i]
print @q.xbgr.xq73_u17.qnpn13g2[ic]
print @q.xbgr.xq73_u17.qnpn13g2[ib]
print @q.xbgr.xq73_u17.qnpn13g2[ie]
print @q.xbgr.xq73_u17.qnpn13g2[is]
print @r.xbgr.xq73_u17.rsub[i]
print @c.xbgr.xq73_u17.csub[i]
print @q.xbgr.xq73_u18.qnpn13g2[ic]
print @q.xbgr.xq73_u18.qnpn13g2[ib]
print @q.xbgr.xq73_u18.qnpn13g2[ie]
print @q.xbgr.xq73_u18.qnpn13g2[is]
print @r.xbgr.xq73_u18.rsub[i]
print @c.xbgr.xq73_u18.csub[i]
print @q.xbgr.xq73_u19.qnpn13g2[ic]
print @q.xbgr.xq73_u19.qnpn13g2[ib]
print @q.xbgr.xq73_u19.qnpn13g2[ie]
print @q.xbgr.xq73_u19.qnpn13g2[is]
print @r.xbgr.xq73_u19.rsub[i]
print @c.xbgr.xq73_u19.csub[i]
print @q.xbgr.xq73_u20.qnpn13g2[ic]
print @q.xbgr.xq73_u20.qnpn13g2[ib]
print @q.xbgr.xq73_u20.qnpn13g2[ie]
print @q.xbgr.xq73_u20.qnpn13g2[is]
print @r.xbgr.xq73_u20.rsub[i]
print @c.xbgr.xq73_u20.csub[i]
print @q.xbgr.xq73_u21.qnpn13g2[ic]
print @q.xbgr.xq73_u21.qnpn13g2[ib]
print @q.xbgr.xq73_u21.qnpn13g2[ie]
print @q.xbgr.xq73_u21.qnpn13g2[is]
print @r.xbgr.xq73_u21.rsub[i]
print @c.xbgr.xq73_u21.csub[i]
print @q.xbgr.xq73_u22.qnpn13g2[ic]
print @q.xbgr.xq73_u22.qnpn13g2[ib]
print @q.xbgr.xq73_u22.qnpn13g2[ie]
print @q.xbgr.xq73_u22.qnpn13g2[is]
print @r.xbgr.xq73_u22.rsub[i]
print @c.xbgr.xq73_u22.csub[i]
print @q.xbgr.xq73_u23.qnpn13g2[ic]
print @q.xbgr.xq73_u23.qnpn13g2[ib]
print @q.xbgr.xq73_u23.qnpn13g2[ie]
print @q.xbgr.xq73_u23.qnpn13g2[is]
print @r.xbgr.xq73_u23.rsub[i]
print @c.xbgr.xq73_u23.csub[i]
print @q.xbgr.xq73_u24.qnpn13g2[ic]
print @q.xbgr.xq73_u24.qnpn13g2[ib]
print @q.xbgr.xq73_u24.qnpn13g2[ie]
print @q.xbgr.xq73_u24.qnpn13g2[is]
print @r.xbgr.xq73_u24.rsub[i]
print @c.xbgr.xq73_u24.csub[i]
print @q.xbgr.xq74_u2.qnpn13g2[ic]
print @q.xbgr.xq74_u2.qnpn13g2[ib]
print @q.xbgr.xq74_u2.qnpn13g2[ie]
print @q.xbgr.xq74_u2.qnpn13g2[is]
print @r.xbgr.xq74_u2.rsub[i]
print @c.xbgr.xq74_u2.csub[i]
print @q.xbgr.xq74_u3.qnpn13g2[ic]
print @q.xbgr.xq74_u3.qnpn13g2[ib]
print @q.xbgr.xq74_u3.qnpn13g2[ie]
print @q.xbgr.xq74_u3.qnpn13g2[is]
print @r.xbgr.xq74_u3.rsub[i]
print @c.xbgr.xq74_u3.csub[i]
print @q.xbgr.xq74_u4.qnpn13g2[ic]
print @q.xbgr.xq74_u4.qnpn13g2[ib]
print @q.xbgr.xq74_u4.qnpn13g2[ie]
print @q.xbgr.xq74_u4.qnpn13g2[is]
print @r.xbgr.xq74_u4.rsub[i]
print @c.xbgr.xq74_u4.csub[i]
print @q.xbgr.xq74_u5.qnpn13g2[ic]
print @q.xbgr.xq74_u5.qnpn13g2[ib]
print @q.xbgr.xq74_u5.qnpn13g2[ie]
print @q.xbgr.xq74_u5.qnpn13g2[is]
print @r.xbgr.xq74_u5.rsub[i]
print @c.xbgr.xq74_u5.csub[i]
print @q.xbgr.xq74_u6.qnpn13g2[ic]
print @q.xbgr.xq74_u6.qnpn13g2[ib]
print @q.xbgr.xq74_u6.qnpn13g2[ie]
print @q.xbgr.xq74_u6.qnpn13g2[is]
print @r.xbgr.xq74_u6.rsub[i]
print @c.xbgr.xq74_u6.csub[i]
print @q.xbgr.xq74_u7.qnpn13g2[ic]
print @q.xbgr.xq74_u7.qnpn13g2[ib]
print @q.xbgr.xq74_u7.qnpn13g2[ie]
print @q.xbgr.xq74_u7.qnpn13g2[is]
print @r.xbgr.xq74_u7.rsub[i]
print @c.xbgr.xq74_u7.csub[i]
print @q.xbgr.xq74_u8.qnpn13g2[ic]
print @q.xbgr.xq74_u8.qnpn13g2[ib]
print @q.xbgr.xq74_u8.qnpn13g2[ie]
print @q.xbgr.xq74_u8.qnpn13g2[is]
print @r.xbgr.xq74_u8.rsub[i]
print @c.xbgr.xq74_u8.csub[i]
print @q.xbgr.xq74_u9.qnpn13g2[ic]
print @q.xbgr.xq74_u9.qnpn13g2[ib]
print @q.xbgr.xq74_u9.qnpn13g2[ie]
print @q.xbgr.xq74_u9.qnpn13g2[is]
print @r.xbgr.xq74_u9.rsub[i]
print @c.xbgr.xq74_u9.csub[i]
print @q.xbgr.xq74_u10.qnpn13g2[ic]
print @q.xbgr.xq74_u10.qnpn13g2[ib]
print @q.xbgr.xq74_u10.qnpn13g2[ie]
print @q.xbgr.xq74_u10.qnpn13g2[is]
print @r.xbgr.xq74_u10.rsub[i]
print @c.xbgr.xq74_u10.csub[i]
print @q.xbgr.xq74_u11.qnpn13g2[ic]
print @q.xbgr.xq74_u11.qnpn13g2[ib]
print @q.xbgr.xq74_u11.qnpn13g2[ie]
print @q.xbgr.xq74_u11.qnpn13g2[is]
print @r.xbgr.xq74_u11.rsub[i]
print @c.xbgr.xq74_u11.csub[i]
print @q.xbgr.xq74_u12.qnpn13g2[ic]
print @q.xbgr.xq74_u12.qnpn13g2[ib]
print @q.xbgr.xq74_u12.qnpn13g2[ie]
print @q.xbgr.xq74_u12.qnpn13g2[is]
print @r.xbgr.xq74_u12.rsub[i]
print @c.xbgr.xq74_u12.csub[i]
print @q.xbgr.xq74_u13.qnpn13g2[ic]
print @q.xbgr.xq74_u13.qnpn13g2[ib]
print @q.xbgr.xq74_u13.qnpn13g2[ie]
print @q.xbgr.xq74_u13.qnpn13g2[is]
print @r.xbgr.xq74_u13.rsub[i]
print @c.xbgr.xq74_u13.csub[i]
print @q.xbgr.xq74_u14.qnpn13g2[ic]
print @q.xbgr.xq74_u14.qnpn13g2[ib]
print @q.xbgr.xq74_u14.qnpn13g2[ie]
print @q.xbgr.xq74_u14.qnpn13g2[is]
print @r.xbgr.xq74_u14.rsub[i]
print @c.xbgr.xq74_u14.csub[i]
print @q.xbgr.xq74_u15.qnpn13g2[ic]
print @q.xbgr.xq74_u15.qnpn13g2[ib]
print @q.xbgr.xq74_u15.qnpn13g2[ie]
print @q.xbgr.xq74_u15.qnpn13g2[is]
print @r.xbgr.xq74_u15.rsub[i]
print @c.xbgr.xq74_u15.csub[i]
print @q.xbgr.xq74_u16.qnpn13g2[ic]
print @q.xbgr.xq74_u16.qnpn13g2[ib]
print @q.xbgr.xq74_u16.qnpn13g2[ie]
print @q.xbgr.xq74_u16.qnpn13g2[is]
print @r.xbgr.xq74_u16.rsub[i]
print @c.xbgr.xq74_u16.csub[i]
print @q.xbgr.xq74_u17.qnpn13g2[ic]
print @q.xbgr.xq74_u17.qnpn13g2[ib]
print @q.xbgr.xq74_u17.qnpn13g2[ie]
print @q.xbgr.xq74_u17.qnpn13g2[is]
print @r.xbgr.xq74_u17.rsub[i]
print @c.xbgr.xq74_u17.csub[i]
print @q.xbgr.xq74_u18.qnpn13g2[ic]
print @q.xbgr.xq74_u18.qnpn13g2[ib]
print @q.xbgr.xq74_u18.qnpn13g2[ie]
print @q.xbgr.xq74_u18.qnpn13g2[is]
print @r.xbgr.xq74_u18.rsub[i]
print @c.xbgr.xq74_u18.csub[i]
print @q.xbgr.xq74_u19.qnpn13g2[ic]
print @q.xbgr.xq74_u19.qnpn13g2[ib]
print @q.xbgr.xq74_u19.qnpn13g2[ie]
print @q.xbgr.xq74_u19.qnpn13g2[is]
print @r.xbgr.xq74_u19.rsub[i]
print @c.xbgr.xq74_u19.csub[i]
print @q.xbgr.xq74_u20.qnpn13g2[ic]
print @q.xbgr.xq74_u20.qnpn13g2[ib]
print @q.xbgr.xq74_u20.qnpn13g2[ie]
print @q.xbgr.xq74_u20.qnpn13g2[is]
print @r.xbgr.xq74_u20.rsub[i]
print @c.xbgr.xq74_u20.csub[i]
print @q.xbgr.xq74_u21.qnpn13g2[ic]
print @q.xbgr.xq74_u21.qnpn13g2[ib]
print @q.xbgr.xq74_u21.qnpn13g2[ie]
print @q.xbgr.xq74_u21.qnpn13g2[is]
print @r.xbgr.xq74_u21.rsub[i]
print @c.xbgr.xq74_u21.csub[i]
print @q.xbgr.xq74_u22.qnpn13g2[ic]
print @q.xbgr.xq74_u22.qnpn13g2[ib]
print @q.xbgr.xq74_u22.qnpn13g2[ie]
print @q.xbgr.xq74_u22.qnpn13g2[is]
print @r.xbgr.xq74_u22.rsub[i]
print @c.xbgr.xq74_u22.csub[i]
print @q.xbgr.xq74_u23.qnpn13g2[ic]
print @q.xbgr.xq74_u23.qnpn13g2[ib]
print @q.xbgr.xq74_u23.qnpn13g2[ie]
print @q.xbgr.xq74_u23.qnpn13g2[is]
print @r.xbgr.xq74_u23.rsub[i]
print @c.xbgr.xq74_u23.csub[i]
print @q.xbgr.xq74_u24.qnpn13g2[ic]
print @q.xbgr.xq74_u24.qnpn13g2[ib]
print @q.xbgr.xq74_u24.qnpn13g2[ie]
print @q.xbgr.xq74_u24.qnpn13g2[is]
print @r.xbgr.xq74_u24.rsub[i]
print @c.xbgr.xq74_u24.csub[i]
print @q.xbgr.xq75_u2.qnpn13g2[ic]
print @q.xbgr.xq75_u2.qnpn13g2[ib]
print @q.xbgr.xq75_u2.qnpn13g2[ie]
print @q.xbgr.xq75_u2.qnpn13g2[is]
print @r.xbgr.xq75_u2.rsub[i]
print @c.xbgr.xq75_u2.csub[i]
print @q.xbgr.xq75_u3.qnpn13g2[ic]
print @q.xbgr.xq75_u3.qnpn13g2[ib]
print @q.xbgr.xq75_u3.qnpn13g2[ie]
print @q.xbgr.xq75_u3.qnpn13g2[is]
print @r.xbgr.xq75_u3.rsub[i]
print @c.xbgr.xq75_u3.csub[i]
print @q.xbgr.xq75_u4.qnpn13g2[ic]
print @q.xbgr.xq75_u4.qnpn13g2[ib]
print @q.xbgr.xq75_u4.qnpn13g2[ie]
print @q.xbgr.xq75_u4.qnpn13g2[is]
print @r.xbgr.xq75_u4.rsub[i]
print @c.xbgr.xq75_u4.csub[i]
print @q.xbgr.xq75_u5.qnpn13g2[ic]
print @q.xbgr.xq75_u5.qnpn13g2[ib]
print @q.xbgr.xq75_u5.qnpn13g2[ie]
print @q.xbgr.xq75_u5.qnpn13g2[is]
print @r.xbgr.xq75_u5.rsub[i]
print @c.xbgr.xq75_u5.csub[i]
print @q.xbgr.xq75_u6.qnpn13g2[ic]
print @q.xbgr.xq75_u6.qnpn13g2[ib]
print @q.xbgr.xq75_u6.qnpn13g2[ie]
print @q.xbgr.xq75_u6.qnpn13g2[is]
print @r.xbgr.xq75_u6.rsub[i]
print @c.xbgr.xq75_u6.csub[i]
print @q.xbgr.xq75_u7.qnpn13g2[ic]
print @q.xbgr.xq75_u7.qnpn13g2[ib]
print @q.xbgr.xq75_u7.qnpn13g2[ie]
print @q.xbgr.xq75_u7.qnpn13g2[is]
print @r.xbgr.xq75_u7.rsub[i]
print @c.xbgr.xq75_u7.csub[i]
print @q.xbgr.xq75_u8.qnpn13g2[ic]
print @q.xbgr.xq75_u8.qnpn13g2[ib]
print @q.xbgr.xq75_u8.qnpn13g2[ie]
print @q.xbgr.xq75_u8.qnpn13g2[is]
print @r.xbgr.xq75_u8.rsub[i]
print @c.xbgr.xq75_u8.csub[i]
print @q.xbgr.xq75_u9.qnpn13g2[ic]
print @q.xbgr.xq75_u9.qnpn13g2[ib]
print @q.xbgr.xq75_u9.qnpn13g2[ie]
print @q.xbgr.xq75_u9.qnpn13g2[is]
print @r.xbgr.xq75_u9.rsub[i]
print @c.xbgr.xq75_u9.csub[i]
print @q.xbgr.xq75_u10.qnpn13g2[ic]
print @q.xbgr.xq75_u10.qnpn13g2[ib]
print @q.xbgr.xq75_u10.qnpn13g2[ie]
print @q.xbgr.xq75_u10.qnpn13g2[is]
print @r.xbgr.xq75_u10.rsub[i]
print @c.xbgr.xq75_u10.csub[i]
print @q.xbgr.xq75_u11.qnpn13g2[ic]
print @q.xbgr.xq75_u11.qnpn13g2[ib]
print @q.xbgr.xq75_u11.qnpn13g2[ie]
print @q.xbgr.xq75_u11.qnpn13g2[is]
print @r.xbgr.xq75_u11.rsub[i]
print @c.xbgr.xq75_u11.csub[i]
print @q.xbgr.xq75_u12.qnpn13g2[ic]
print @q.xbgr.xq75_u12.qnpn13g2[ib]
print @q.xbgr.xq75_u12.qnpn13g2[ie]
print @q.xbgr.xq75_u12.qnpn13g2[is]
print @r.xbgr.xq75_u12.rsub[i]
print @c.xbgr.xq75_u12.csub[i]
print @q.xbgr.xq75_u13.qnpn13g2[ic]
print @q.xbgr.xq75_u13.qnpn13g2[ib]
print @q.xbgr.xq75_u13.qnpn13g2[ie]
print @q.xbgr.xq75_u13.qnpn13g2[is]
print @r.xbgr.xq75_u13.rsub[i]
print @c.xbgr.xq75_u13.csub[i]
print @q.xbgr.xq75_u14.qnpn13g2[ic]
print @q.xbgr.xq75_u14.qnpn13g2[ib]
print @q.xbgr.xq75_u14.qnpn13g2[ie]
print @q.xbgr.xq75_u14.qnpn13g2[is]
print @r.xbgr.xq75_u14.rsub[i]
print @c.xbgr.xq75_u14.csub[i]
print @q.xbgr.xq75_u15.qnpn13g2[ic]
print @q.xbgr.xq75_u15.qnpn13g2[ib]
print @q.xbgr.xq75_u15.qnpn13g2[ie]
print @q.xbgr.xq75_u15.qnpn13g2[is]
print @r.xbgr.xq75_u15.rsub[i]
print @c.xbgr.xq75_u15.csub[i]
print @q.xbgr.xq75_u16.qnpn13g2[ic]
print @q.xbgr.xq75_u16.qnpn13g2[ib]
print @q.xbgr.xq75_u16.qnpn13g2[ie]
print @q.xbgr.xq75_u16.qnpn13g2[is]
print @r.xbgr.xq75_u16.rsub[i]
print @c.xbgr.xq75_u16.csub[i]
print @q.xbgr.xq75_u17.qnpn13g2[ic]
print @q.xbgr.xq75_u17.qnpn13g2[ib]
print @q.xbgr.xq75_u17.qnpn13g2[ie]
print @q.xbgr.xq75_u17.qnpn13g2[is]
print @r.xbgr.xq75_u17.rsub[i]
print @c.xbgr.xq75_u17.csub[i]
print @q.xbgr.xq75_u18.qnpn13g2[ic]
print @q.xbgr.xq75_u18.qnpn13g2[ib]
print @q.xbgr.xq75_u18.qnpn13g2[ie]
print @q.xbgr.xq75_u18.qnpn13g2[is]
print @r.xbgr.xq75_u18.rsub[i]
print @c.xbgr.xq75_u18.csub[i]
print @q.xbgr.xq75_u19.qnpn13g2[ic]
print @q.xbgr.xq75_u19.qnpn13g2[ib]
print @q.xbgr.xq75_u19.qnpn13g2[ie]
print @q.xbgr.xq75_u19.qnpn13g2[is]
print @r.xbgr.xq75_u19.rsub[i]
print @c.xbgr.xq75_u19.csub[i]
print @q.xbgr.xq75_u20.qnpn13g2[ic]
print @q.xbgr.xq75_u20.qnpn13g2[ib]
print @q.xbgr.xq75_u20.qnpn13g2[ie]
print @q.xbgr.xq75_u20.qnpn13g2[is]
print @r.xbgr.xq75_u20.rsub[i]
print @c.xbgr.xq75_u20.csub[i]
print @q.xbgr.xq75_u21.qnpn13g2[ic]
print @q.xbgr.xq75_u21.qnpn13g2[ib]
print @q.xbgr.xq75_u21.qnpn13g2[ie]
print @q.xbgr.xq75_u21.qnpn13g2[is]
print @r.xbgr.xq75_u21.rsub[i]
print @c.xbgr.xq75_u21.csub[i]
print @q.xbgr.xq75_u22.qnpn13g2[ic]
print @q.xbgr.xq75_u22.qnpn13g2[ib]
print @q.xbgr.xq75_u22.qnpn13g2[ie]
print @q.xbgr.xq75_u22.qnpn13g2[is]
print @r.xbgr.xq75_u22.rsub[i]
print @c.xbgr.xq75_u22.csub[i]
print @q.xbgr.xq75_u23.qnpn13g2[ic]
print @q.xbgr.xq75_u23.qnpn13g2[ib]
print @q.xbgr.xq75_u23.qnpn13g2[ie]
print @q.xbgr.xq75_u23.qnpn13g2[is]
print @r.xbgr.xq75_u23.rsub[i]
print @c.xbgr.xq75_u23.csub[i]
print @q.xbgr.xq75_u24.qnpn13g2[ic]
print @q.xbgr.xq75_u24.qnpn13g2[ib]
print @q.xbgr.xq75_u24.qnpn13g2[ie]
print @q.xbgr.xq75_u24.qnpn13g2[is]
print @r.xbgr.xq75_u24.rsub[i]
print @c.xbgr.xq75_u24.csub[i]
print @q.xbgr.xq76_u2.qnpn13g2[ic]
print @q.xbgr.xq76_u2.qnpn13g2[ib]
print @q.xbgr.xq76_u2.qnpn13g2[ie]
print @q.xbgr.xq76_u2.qnpn13g2[is]
print @r.xbgr.xq76_u2.rsub[i]
print @c.xbgr.xq76_u2.csub[i]
print @q.xbgr.xq76_u3.qnpn13g2[ic]
print @q.xbgr.xq76_u3.qnpn13g2[ib]
print @q.xbgr.xq76_u3.qnpn13g2[ie]
print @q.xbgr.xq76_u3.qnpn13g2[is]
print @r.xbgr.xq76_u3.rsub[i]
print @c.xbgr.xq76_u3.csub[i]
print @q.xbgr.xq76_u4.qnpn13g2[ic]
print @q.xbgr.xq76_u4.qnpn13g2[ib]
print @q.xbgr.xq76_u4.qnpn13g2[ie]
print @q.xbgr.xq76_u4.qnpn13g2[is]
print @r.xbgr.xq76_u4.rsub[i]
print @c.xbgr.xq76_u4.csub[i]
print @q.xbgr.xq76_u5.qnpn13g2[ic]
print @q.xbgr.xq76_u5.qnpn13g2[ib]
print @q.xbgr.xq76_u5.qnpn13g2[ie]
print @q.xbgr.xq76_u5.qnpn13g2[is]
print @r.xbgr.xq76_u5.rsub[i]
print @c.xbgr.xq76_u5.csub[i]
print @q.xbgr.xq76_u6.qnpn13g2[ic]
print @q.xbgr.xq76_u6.qnpn13g2[ib]
print @q.xbgr.xq76_u6.qnpn13g2[ie]
print @q.xbgr.xq76_u6.qnpn13g2[is]
print @r.xbgr.xq76_u6.rsub[i]
print @c.xbgr.xq76_u6.csub[i]
print @q.xbgr.xq76_u7.qnpn13g2[ic]
print @q.xbgr.xq76_u7.qnpn13g2[ib]
print @q.xbgr.xq76_u7.qnpn13g2[ie]
print @q.xbgr.xq76_u7.qnpn13g2[is]
print @r.xbgr.xq76_u7.rsub[i]
print @c.xbgr.xq76_u7.csub[i]
print @q.xbgr.xq76_u8.qnpn13g2[ic]
print @q.xbgr.xq76_u8.qnpn13g2[ib]
print @q.xbgr.xq76_u8.qnpn13g2[ie]
print @q.xbgr.xq76_u8.qnpn13g2[is]
print @r.xbgr.xq76_u8.rsub[i]
print @c.xbgr.xq76_u8.csub[i]
print @q.xbgr.xq76_u9.qnpn13g2[ic]
print @q.xbgr.xq76_u9.qnpn13g2[ib]
print @q.xbgr.xq76_u9.qnpn13g2[ie]
print @q.xbgr.xq76_u9.qnpn13g2[is]
print @r.xbgr.xq76_u9.rsub[i]
print @c.xbgr.xq76_u9.csub[i]
print @q.xbgr.xq76_u10.qnpn13g2[ic]
print @q.xbgr.xq76_u10.qnpn13g2[ib]
print @q.xbgr.xq76_u10.qnpn13g2[ie]
print @q.xbgr.xq76_u10.qnpn13g2[is]
print @r.xbgr.xq76_u10.rsub[i]
print @c.xbgr.xq76_u10.csub[i]
print @q.xbgr.xq76_u11.qnpn13g2[ic]
print @q.xbgr.xq76_u11.qnpn13g2[ib]
print @q.xbgr.xq76_u11.qnpn13g2[ie]
print @q.xbgr.xq76_u11.qnpn13g2[is]
print @r.xbgr.xq76_u11.rsub[i]
print @c.xbgr.xq76_u11.csub[i]
print @q.xbgr.xq76_u12.qnpn13g2[ic]
print @q.xbgr.xq76_u12.qnpn13g2[ib]
print @q.xbgr.xq76_u12.qnpn13g2[ie]
print @q.xbgr.xq76_u12.qnpn13g2[is]
print @r.xbgr.xq76_u12.rsub[i]
print @c.xbgr.xq76_u12.csub[i]
print @q.xbgr.xq76_u13.qnpn13g2[ic]
print @q.xbgr.xq76_u13.qnpn13g2[ib]
print @q.xbgr.xq76_u13.qnpn13g2[ie]
print @q.xbgr.xq76_u13.qnpn13g2[is]
print @r.xbgr.xq76_u13.rsub[i]
print @c.xbgr.xq76_u13.csub[i]
print @q.xbgr.xq76_u14.qnpn13g2[ic]
print @q.xbgr.xq76_u14.qnpn13g2[ib]
print @q.xbgr.xq76_u14.qnpn13g2[ie]
print @q.xbgr.xq76_u14.qnpn13g2[is]
print @r.xbgr.xq76_u14.rsub[i]
print @c.xbgr.xq76_u14.csub[i]
print @q.xbgr.xq76_u15.qnpn13g2[ic]
print @q.xbgr.xq76_u15.qnpn13g2[ib]
print @q.xbgr.xq76_u15.qnpn13g2[ie]
print @q.xbgr.xq76_u15.qnpn13g2[is]
print @r.xbgr.xq76_u15.rsub[i]
print @c.xbgr.xq76_u15.csub[i]
print @q.xbgr.xq76_u16.qnpn13g2[ic]
print @q.xbgr.xq76_u16.qnpn13g2[ib]
print @q.xbgr.xq76_u16.qnpn13g2[ie]
print @q.xbgr.xq76_u16.qnpn13g2[is]
print @r.xbgr.xq76_u16.rsub[i]
print @c.xbgr.xq76_u16.csub[i]
print @q.xbgr.xq76_u17.qnpn13g2[ic]
print @q.xbgr.xq76_u17.qnpn13g2[ib]
print @q.xbgr.xq76_u17.qnpn13g2[ie]
print @q.xbgr.xq76_u17.qnpn13g2[is]
print @r.xbgr.xq76_u17.rsub[i]
print @c.xbgr.xq76_u17.csub[i]
print @q.xbgr.xq76_u18.qnpn13g2[ic]
print @q.xbgr.xq76_u18.qnpn13g2[ib]
print @q.xbgr.xq76_u18.qnpn13g2[ie]
print @q.xbgr.xq76_u18.qnpn13g2[is]
print @r.xbgr.xq76_u18.rsub[i]
print @c.xbgr.xq76_u18.csub[i]
print @q.xbgr.xq76_u19.qnpn13g2[ic]
print @q.xbgr.xq76_u19.qnpn13g2[ib]
print @q.xbgr.xq76_u19.qnpn13g2[ie]
print @q.xbgr.xq76_u19.qnpn13g2[is]
print @r.xbgr.xq76_u19.rsub[i]
print @c.xbgr.xq76_u19.csub[i]
print @q.xbgr.xq76_u20.qnpn13g2[ic]
print @q.xbgr.xq76_u20.qnpn13g2[ib]
print @q.xbgr.xq76_u20.qnpn13g2[ie]
print @q.xbgr.xq76_u20.qnpn13g2[is]
print @r.xbgr.xq76_u20.rsub[i]
print @c.xbgr.xq76_u20.csub[i]
print @q.xbgr.xq76_u21.qnpn13g2[ic]
print @q.xbgr.xq76_u21.qnpn13g2[ib]
print @q.xbgr.xq76_u21.qnpn13g2[ie]
print @q.xbgr.xq76_u21.qnpn13g2[is]
print @r.xbgr.xq76_u21.rsub[i]
print @c.xbgr.xq76_u21.csub[i]
print @q.xbgr.xq76_u22.qnpn13g2[ic]
print @q.xbgr.xq76_u22.qnpn13g2[ib]
print @q.xbgr.xq76_u22.qnpn13g2[ie]
print @q.xbgr.xq76_u22.qnpn13g2[is]
print @r.xbgr.xq76_u22.rsub[i]
print @c.xbgr.xq76_u22.csub[i]
print @q.xbgr.xq76_u23.qnpn13g2[ic]
print @q.xbgr.xq76_u23.qnpn13g2[ib]
print @q.xbgr.xq76_u23.qnpn13g2[ie]
print @q.xbgr.xq76_u23.qnpn13g2[is]
print @r.xbgr.xq76_u23.rsub[i]
print @c.xbgr.xq76_u23.csub[i]
print @q.xbgr.xq76_u24.qnpn13g2[ic]
print @q.xbgr.xq76_u24.qnpn13g2[ib]
print @q.xbgr.xq76_u24.qnpn13g2[ie]
print @q.xbgr.xq76_u24.qnpn13g2[is]
print @r.xbgr.xq76_u24.rsub[i]
print @c.xbgr.xq76_u24.csub[i]
print @n.xbgr.xr77_u2.nr1[ibody]
print @n.xbgr.xr77_u3.nr1[ibody]
print @n.xbgr.xr77_u4.nr1[ibody]
print @n.xbgr.xr77_u5.nr1[ibody]
print @n.xbgr.xr77_u6.nr1[ibody]
print @n.xbgr.xr77_u7.nr1[ibody]
print @n.xbgr.xr77_u8.nr1[ibody]
print @n.xbgr.xr77_u9.nr1[ibody]
print @n.xbgr.xr77_u10.nr1[ibody]
print @n.xbgr.xr77_u11.nr1[ibody]
print @n.xbgr.xr77_u12.nr1[ibody]
print @n.xbgr.xr77_u13.nr1[ibody]
print @n.xbgr.xr77_u14.nr1[ibody]
print @n.xbgr.xr77_u15.nr1[ibody]
print @n.xbgr.xr77_u16.nr1[ibody]
print @n.xbgr.xr77_u17.nr1[ibody]
print @n.xbgr.xr77_u18.nr1[ibody]
print @n.xbgr.xr77_u19.nr1[ibody]
print @n.xbgr.xr77_u20.nr1[ibody]
print @n.xbgr.xr77_u21.nr1[ibody]
print @n.xbgr.xr77_u22.nr1[ibody]
print @n.xbgr.xr77_u23.nr1[ibody]
print @n.xbgr.xr77_u24.nr1[ibody]
print @n.xbgr.xr78_u2.nr1[ibody]
print @n.xbgr.xr78_u3.nr1[ibody]
print @n.xbgr.xr78_u4.nr1[ibody]
print @n.xbgr.xr78_u5.nr1[ibody]
print @n.xbgr.xr78_u6.nr1[ibody]
print @n.xbgr.xr78_u7.nr1[ibody]
print @n.xbgr.xr78_u8.nr1[ibody]
print @n.xbgr.xr78_u9.nr1[ibody]
print @n.xbgr.xr78_u10.nr1[ibody]
print @n.xbgr.xr78_u11.nr1[ibody]
print @n.xbgr.xr78_u12.nr1[ibody]
print @n.xbgr.xr78_u13.nr1[ibody]
print @n.xbgr.xr78_u14.nr1[ibody]
print @n.xbgr.xr78_u15.nr1[ibody]
print @n.xbgr.xr78_u16.nr1[ibody]
print @n.xbgr.xr78_u17.nr1[ibody]
print @n.xbgr.xr78_u18.nr1[ibody]
print @n.xbgr.xr78_u19.nr1[ibody]
print @n.xbgr.xr78_u20.nr1[ibody]
print @n.xbgr.xr78_u21.nr1[ibody]
print @n.xbgr.xr78_u22.nr1[ibody]
print @n.xbgr.xr78_u23.nr1[ibody]
print @n.xbgr.xr78_u24.nr1[ibody]
print @n.xbgr.xr79_u2.nr1[ibody]
print @n.xbgr.xr79_u3.nr1[ibody]
print @n.xbgr.xr79_u4.nr1[ibody]
print @n.xbgr.xr79_u5.nr1[ibody]
print @n.xbgr.xr79_u6.nr1[ibody]
print @n.xbgr.xr79_u7.nr1[ibody]
print @n.xbgr.xr79_u8.nr1[ibody]
print @n.xbgr.xr79_u9.nr1[ibody]
print @n.xbgr.xr79_u10.nr1[ibody]
print @n.xbgr.xr79_u11.nr1[ibody]
print @n.xbgr.xr79_u12.nr1[ibody]
print @n.xbgr.xr79_u13.nr1[ibody]
print @n.xbgr.xr79_u14.nr1[ibody]
print @n.xbgr.xr79_u15.nr1[ibody]
print @n.xbgr.xr79_u16.nr1[ibody]
print @n.xbgr.xr79_u17.nr1[ibody]
print @n.xbgr.xr79_u18.nr1[ibody]
print @n.xbgr.xr79_u19.nr1[ibody]
print @n.xbgr.xr79_u20.nr1[ibody]
print @n.xbgr.xr79_u21.nr1[ibody]
print @n.xbgr.xr79_u22.nr1[ibody]
print @n.xbgr.xr79_u23.nr1[ibody]
print @n.xbgr.xr79_u24.nr1[ibody]
print @n.xbgr.xr80_u2.nr1[ibody]
print @n.xbgr.xr80_u3.nr1[ibody]
print @n.xbgr.xr80_u4.nr1[ibody]
print @n.xbgr.xr80_u5.nr1[ibody]
print @n.xbgr.xr80_u6.nr1[ibody]
print @n.xbgr.xr80_u7.nr1[ibody]
print @n.xbgr.xr80_u8.nr1[ibody]
print @n.xbgr.xr80_u9.nr1[ibody]
print @n.xbgr.xr80_u10.nr1[ibody]
print @n.xbgr.xr80_u11.nr1[ibody]
print @n.xbgr.xr80_u12.nr1[ibody]
print @n.xbgr.xr80_u13.nr1[ibody]
print @n.xbgr.xr80_u14.nr1[ibody]
print @n.xbgr.xr80_u15.nr1[ibody]
print @n.xbgr.xr80_u16.nr1[ibody]
print @n.xbgr.xr80_u17.nr1[ibody]
print @n.xbgr.xr80_u18.nr1[ibody]
print @n.xbgr.xr80_u19.nr1[ibody]
print @n.xbgr.xr80_u20.nr1[ibody]
print @n.xbgr.xr80_u21.nr1[ibody]
print @n.xbgr.xr80_u22.nr1[ibody]
print @n.xbgr.xr80_u23.nr1[ibody]
print @n.xbgr.xr80_u24.nr1[ibody]
print @n.xbgr.xr81_u2.nr1[ibody]
print @n.xbgr.xr81_u3.nr1[ibody]
print @n.xbgr.xr81_u4.nr1[ibody]
print @n.xbgr.xr81_u5.nr1[ibody]
print @n.xbgr.xr81_u6.nr1[ibody]
print @n.xbgr.xr81_u7.nr1[ibody]
print @n.xbgr.xr81_u8.nr1[ibody]
print @n.xbgr.xr81_u9.nr1[ibody]
print @n.xbgr.xr81_u10.nr1[ibody]
print @n.xbgr.xr81_u11.nr1[ibody]
print @n.xbgr.xr81_u12.nr1[ibody]
print @n.xbgr.xr81_u13.nr1[ibody]
print @n.xbgr.xr81_u14.nr1[ibody]
print @n.xbgr.xr81_u15.nr1[ibody]
print @n.xbgr.xr81_u16.nr1[ibody]
print @n.xbgr.xr81_u17.nr1[ibody]
print @n.xbgr.xr81_u18.nr1[ibody]
print @n.xbgr.xr81_u19.nr1[ibody]
print @n.xbgr.xr81_u20.nr1[ibody]
print @n.xbgr.xr81_u21.nr1[ibody]
print @n.xbgr.xr81_u22.nr1[ibody]
print @n.xbgr.xr81_u23.nr1[ibody]
print @n.xbgr.xr81_u24.nr1[ibody]
print @n.xbgr.xr82_u2.nr1[ibody]
print @n.xbgr.xr82_u3.nr1[ibody]
print @n.xbgr.xr82_u4.nr1[ibody]
print @n.xbgr.xr82_u5.nr1[ibody]
print @n.xbgr.xr82_u6.nr1[ibody]
print @n.xbgr.xr82_u7.nr1[ibody]
print @n.xbgr.xr82_u8.nr1[ibody]
print @n.xbgr.xr82_u9.nr1[ibody]
print @n.xbgr.xr82_u10.nr1[ibody]
print @n.xbgr.xr82_u11.nr1[ibody]
print @n.xbgr.xr82_u12.nr1[ibody]
print @n.xbgr.xr82_u13.nr1[ibody]
print @n.xbgr.xr82_u14.nr1[ibody]
print @n.xbgr.xr82_u15.nr1[ibody]
print @n.xbgr.xr82_u16.nr1[ibody]
print @n.xbgr.xr82_u17.nr1[ibody]
print @n.xbgr.xr82_u18.nr1[ibody]
print @n.xbgr.xr82_u19.nr1[ibody]
print @n.xbgr.xr82_u20.nr1[ibody]
print @n.xbgr.xr82_u21.nr1[ibody]
print @n.xbgr.xr82_u22.nr1[ibody]
print @n.xbgr.xr82_u23.nr1[ibody]
print @n.xbgr.xr82_u24.nr1[ibody]
print @n.xbgr.xr83_u2.nr1[ibody]
print @n.xbgr.xr83_u3.nr1[ibody]
print @n.xbgr.xr83_u4.nr1[ibody]
print @n.xbgr.xr83_u5.nr1[ibody]
print @n.xbgr.xr83_u6.nr1[ibody]
print @n.xbgr.xr83_u7.nr1[ibody]
print @n.xbgr.xr83_u8.nr1[ibody]
print @n.xbgr.xr83_u9.nr1[ibody]
print @n.xbgr.xr83_u10.nr1[ibody]
print @n.xbgr.xr83_u11.nr1[ibody]
print @n.xbgr.xr83_u12.nr1[ibody]
print @n.xbgr.xr83_u13.nr1[ibody]
print @n.xbgr.xr83_u14.nr1[ibody]
print @n.xbgr.xr83_u15.nr1[ibody]
print @n.xbgr.xr83_u16.nr1[ibody]
print @n.xbgr.xr83_u17.nr1[ibody]
print @n.xbgr.xr83_u18.nr1[ibody]
print @n.xbgr.xr83_u19.nr1[ibody]
print @n.xbgr.xr83_u20.nr1[ibody]
print @n.xbgr.xr83_u21.nr1[ibody]
print @n.xbgr.xr83_u22.nr1[ibody]
print @n.xbgr.xr83_u23.nr1[ibody]
print @n.xbgr.xr83_u24.nr1[ibody]
print @n.xbgr.xr84_u2.nr1[ibody]
print @n.xbgr.xr84_u3.nr1[ibody]
print @n.xbgr.xr84_u4.nr1[ibody]
print @n.xbgr.xr84_u5.nr1[ibody]
print @n.xbgr.xr84_u6.nr1[ibody]
print @n.xbgr.xr84_u7.nr1[ibody]
print @n.xbgr.xr84_u8.nr1[ibody]
print @n.xbgr.xr84_u9.nr1[ibody]
print @n.xbgr.xr84_u10.nr1[ibody]
print @n.xbgr.xr84_u11.nr1[ibody]
print @n.xbgr.xr84_u12.nr1[ibody]
print @n.xbgr.xr84_u13.nr1[ibody]
print @n.xbgr.xr84_u14.nr1[ibody]
print @n.xbgr.xr84_u15.nr1[ibody]
print @n.xbgr.xr84_u16.nr1[ibody]
print @n.xbgr.xr84_u17.nr1[ibody]
print @n.xbgr.xr84_u18.nr1[ibody]
print @n.xbgr.xr84_u19.nr1[ibody]
print @n.xbgr.xr84_u20.nr1[ibody]
print @n.xbgr.xr84_u21.nr1[ibody]
print @n.xbgr.xr84_u22.nr1[ibody]
print @n.xbgr.xr84_u23.nr1[ibody]
print @n.xbgr.xr84_u24.nr1[ibody]
print @n.xbgr.xr85_u2.nr1[ibody]
print @n.xbgr.xr85_u3.nr1[ibody]
print @n.xbgr.xr85_u4.nr1[ibody]
print @n.xbgr.xr85_u5.nr1[ibody]
print @n.xbgr.xr85_u6.nr1[ibody]
print @n.xbgr.xr85_u7.nr1[ibody]
print @n.xbgr.xr85_u8.nr1[ibody]
print @n.xbgr.xr85_u9.nr1[ibody]
print @n.xbgr.xr85_u10.nr1[ibody]
print @n.xbgr.xr85_u11.nr1[ibody]
print @n.xbgr.xr85_u12.nr1[ibody]
print @n.xbgr.xr85_u13.nr1[ibody]
print @n.xbgr.xr85_u14.nr1[ibody]
print @n.xbgr.xr85_u15.nr1[ibody]
print @n.xbgr.xr85_u16.nr1[ibody]
print @n.xbgr.xr85_u17.nr1[ibody]
print @n.xbgr.xr85_u18.nr1[ibody]
print @n.xbgr.xr85_u19.nr1[ibody]
print @n.xbgr.xr85_u20.nr1[ibody]
print @n.xbgr.xr85_u21.nr1[ibody]
print @n.xbgr.xr85_u22.nr1[ibody]
print @n.xbgr.xr85_u23.nr1[ibody]
print @n.xbgr.xr85_u24.nr1[ibody]
print @n.xbgr.xr86_u2.nr1[ibody]
print @n.xbgr.xr86_u3.nr1[ibody]
print @n.xbgr.xr86_u4.nr1[ibody]
print @n.xbgr.xr86_u5.nr1[ibody]
print @n.xbgr.xr86_u6.nr1[ibody]
print @n.xbgr.xr86_u7.nr1[ibody]
print @n.xbgr.xr86_u8.nr1[ibody]
print @n.xbgr.xr86_u9.nr1[ibody]
print @n.xbgr.xr86_u10.nr1[ibody]
print @n.xbgr.xr86_u11.nr1[ibody]
print @n.xbgr.xr86_u12.nr1[ibody]
print @n.xbgr.xr86_u13.nr1[ibody]
print @n.xbgr.xr86_u14.nr1[ibody]
print @n.xbgr.xr86_u15.nr1[ibody]
print @n.xbgr.xr86_u16.nr1[ibody]
print @n.xbgr.xr86_u17.nr1[ibody]
print @n.xbgr.xr86_u18.nr1[ibody]
print @n.xbgr.xr86_u19.nr1[ibody]
print @n.xbgr.xr86_u20.nr1[ibody]
print @n.xbgr.xr86_u21.nr1[ibody]
print @n.xbgr.xr86_u22.nr1[ibody]
print @n.xbgr.xr86_u23.nr1[ibody]
print @n.xbgr.xr86_u24.nr1[ibody]
echo RAW_CURRENT_LEDGER_END
wrdata op_nodes.dat v(xbgr.b1b) v(xbgr.c2) v(xbgr.d1) v(xbgr.d2) v(xbgr.d3) v(xbgr.d4) v(xbgr.d5) v(xbgr.det) v(dvbe) v(iptat) v(xbgr.kick) v(xbgr.n1) v(xbgr.n_10) v(xbgr.n_11) v(xbgr.n_12) v(xbgr.n_13) v(xbgr.n_14) v(xbgr.n_15) v(xbgr.n_16) v(xbgr.n_17) v(xbgr.n_18) v(xbgr.n_19) v(xbgr.n_2) v(xbgr.n_21) v(xbgr.n_22) v(xbgr.n_23) v(xbgr.n_24) v(xbgr.n_25) v(xbgr.n_26) v(xbgr.n_27) v(xbgr.n_3) v(xbgr.n_30) v(xbgr.n_31) v(xbgr.n_33) v(xbgr.n_34) v(xbgr.n_36) v(xbgr.n_37) v(xbgr.n_4) v(xbgr.n_5) v(xbgr.n_6) v(xbgr.n_7) v(xbgr.n_8) v(xbgr.n_9) v(pbias) v(pcasc) v(r4) v(xbgr.r4n) v(xbgr.vb2) v(vbe) v(xbgr.vbe3) v(xbgr.vd1) v(xbgr.vd2) v(vdd) v(vref) v(vdd)-v(vdd) i(vdd) i(vload) i(vr4) i(vsub)
print @n.xbgr.xr1.nr1[nsmm_rsh]
print @n.xbgr.xr1.nr1[nsmm_w]
print @n.xbgr.xr1.nr1[nsmm_l]
print @n.xbgr.xr2.nr1[nsmm_rsh]
print @n.xbgr.xr2.nr1[nsmm_w]
print @n.xbgr.xr2.nr1[nsmm_l]
print @n.xbgr.xr3.nr1[nsmm_rsh]
print @n.xbgr.xr3.nr1[nsmm_w]
print @n.xbgr.xr3.nr1[nsmm_l]
print @n.xbgr.xr4.nr1[nsmm_rsh]
print @n.xbgr.xr4.nr1[nsmm_w]
print @n.xbgr.xr4.nr1[nsmm_l]
print @n.xbgr.xr5.nr1[nsmm_rsh]
print @n.xbgr.xr5.nr1[nsmm_w]
print @n.xbgr.xr5.nr1[nsmm_l]
print @n.xbgr.xr6.nr1[nsmm_rsh]
print @n.xbgr.xr6.nr1[nsmm_w]
print @n.xbgr.xr6.nr1[nsmm_l]
print @n.xbgr.xr7.nr1[nsmm_rsh]
print @n.xbgr.xr7.nr1[nsmm_w]
print @n.xbgr.xr7.nr1[nsmm_l]
print @n.xbgr.xr8.nr1[nsmm_rsh]
print @n.xbgr.xr8.nr1[nsmm_w]
print @n.xbgr.xr8.nr1[nsmm_l]
print @n.xbgr.xr9.nr1[nsmm_rsh]
print @n.xbgr.xr9.nr1[nsmm_w]
print @n.xbgr.xr9.nr1[nsmm_l]
print @n.xbgr.xr10.nr1[nsmm_rsh]
print @n.xbgr.xr10.nr1[nsmm_w]
print @n.xbgr.xr10.nr1[nsmm_l]
print @n.xbgr.xr11.nr1[nsmm_rsh]
print @n.xbgr.xr11.nr1[nsmm_w]
print @n.xbgr.xr11.nr1[nsmm_l]
print @n.xbgr.xr12.nr1[nsmm_rsh]
print @n.xbgr.xr12.nr1[nsmm_w]
print @n.xbgr.xr12.nr1[nsmm_l]
print @n.xbgr.xr13.nr1[nsmm_rsh]
print @n.xbgr.xr13.nr1[nsmm_w]
print @n.xbgr.xr13.nr1[nsmm_l]
print @n.xbgr.xr14.nr1[nsmm_rsh]
print @n.xbgr.xr14.nr1[nsmm_w]
print @n.xbgr.xr14.nr1[nsmm_l]
print @n.xbgr.xr15.nr1[nsmm_rsh]
print @n.xbgr.xr15.nr1[nsmm_w]
print @n.xbgr.xr15.nr1[nsmm_l]
print @n.xbgr.xr16.nr1[nsmm_rsh]
print @n.xbgr.xr16.nr1[nsmm_w]
print @n.xbgr.xr16.nr1[nsmm_l]
print @n.xbgr.xr17.nr1[nsmm_rsh]
print @n.xbgr.xr17.nr1[nsmm_w]
print @n.xbgr.xr17.nr1[nsmm_l]
print @n.xbgr.xr18.nr1[nsmm_rsh]
print @n.xbgr.xr18.nr1[nsmm_w]
print @n.xbgr.xr18.nr1[nsmm_l]
print @n.xbgr.xr19.nr1[nsmm_rsh]
print @n.xbgr.xr19.nr1[nsmm_w]
print @n.xbgr.xr19.nr1[nsmm_l]
print @n.xbgr.xr20.nr1[nsmm_rsh]
print @n.xbgr.xr20.nr1[nsmm_w]
print @n.xbgr.xr20.nr1[nsmm_l]
print @n.xbgr.xr21.nr1[nsmm_rsh]
print @n.xbgr.xr21.nr1[nsmm_w]
print @n.xbgr.xr21.nr1[nsmm_l]
print @n.xbgr.xr22.nr1[nsmm_rsh]
print @n.xbgr.xr22.nr1[nsmm_w]
print @n.xbgr.xr22.nr1[nsmm_l]
print @n.xbgr.xr23.nr1[nsmm_rsh]
print @n.xbgr.xr23.nr1[nsmm_w]
print @n.xbgr.xr23.nr1[nsmm_l]
print @n.xbgr.xr24.nr1[nsmm_rsh]
print @n.xbgr.xr24.nr1[nsmm_w]
print @n.xbgr.xr24.nr1[nsmm_l]
print @n.xbgr.xr25.nr1[nsmm_rsh]
print @n.xbgr.xr25.nr1[nsmm_w]
print @n.xbgr.xr25.nr1[nsmm_l]
print @n.xbgr.xr26.nr1[nsmm_rsh]
print @n.xbgr.xr26.nr1[nsmm_w]
print @n.xbgr.xr26.nr1[nsmm_l]
print @n.xbgr.xm27.nsg13_hv_pmos[w]
print @n.xbgr.xm27.nsg13_hv_pmos[l]
print @n.xbgr.xm27.nsg13_hv_pmos[delvto]
print @n.xbgr.xm27.nsg13_hv_pmos[factuo]
print @n.xbgr.xm28.nsg13_hv_pmos[w]
print @n.xbgr.xm28.nsg13_hv_pmos[l]
print @n.xbgr.xm28.nsg13_hv_pmos[delvto]
print @n.xbgr.xm28.nsg13_hv_pmos[factuo]
print @n.xbgr.xm29.nsg13_hv_nmos[w]
print @n.xbgr.xm29.nsg13_hv_nmos[l]
print @n.xbgr.xm29.nsg13_hv_nmos[delvto]
print @n.xbgr.xm29.nsg13_hv_nmos[factuo]
print @n.xbgr.xm30.nsg13_hv_nmos[w]
print @n.xbgr.xm30.nsg13_hv_nmos[l]
print @n.xbgr.xm30.nsg13_hv_nmos[delvto]
print @n.xbgr.xm30.nsg13_hv_nmos[factuo]
print @n.xbgr.xm31.nsg13_hv_nmos[w]
print @n.xbgr.xm31.nsg13_hv_nmos[l]
print @n.xbgr.xm31.nsg13_hv_nmos[delvto]
print @n.xbgr.xm31.nsg13_hv_nmos[factuo]
print @n.xbgr.xm32.nsg13_hv_nmos[w]
print @n.xbgr.xm32.nsg13_hv_nmos[l]
print @n.xbgr.xm32.nsg13_hv_nmos[delvto]
print @n.xbgr.xm32.nsg13_hv_nmos[factuo]
print @n.xbgr.xm33.nsg13_hv_nmos[w]
print @n.xbgr.xm33.nsg13_hv_nmos[l]
print @n.xbgr.xm33.nsg13_hv_nmos[delvto]
print @n.xbgr.xm33.nsg13_hv_nmos[factuo]
print @n.xbgr.xm34.nsg13_hv_nmos[w]
print @n.xbgr.xm34.nsg13_hv_nmos[l]
print @n.xbgr.xm34.nsg13_hv_nmos[delvto]
print @n.xbgr.xm34.nsg13_hv_nmos[factuo]
print @n.xbgr.xm35.nsg13_hv_nmos[w]
print @n.xbgr.xm35.nsg13_hv_nmos[l]
print @n.xbgr.xm35.nsg13_hv_nmos[delvto]
print @n.xbgr.xm35.nsg13_hv_nmos[factuo]
print @n.xbgr.xm36.nsg13_hv_nmos[w]
print @n.xbgr.xm36.nsg13_hv_nmos[l]
print @n.xbgr.xm36.nsg13_hv_nmos[delvto]
print @n.xbgr.xm36.nsg13_hv_nmos[factuo]
print @n.xbgr.xm37.nsg13_hv_nmos[w]
print @n.xbgr.xm37.nsg13_hv_nmos[l]
print @n.xbgr.xm37.nsg13_hv_nmos[delvto]
print @n.xbgr.xm37.nsg13_hv_nmos[factuo]
print @n.xbgr.xm38.nsg13_hv_pmos[w]
print @n.xbgr.xm38.nsg13_hv_pmos[l]
print @n.xbgr.xm38.nsg13_hv_pmos[delvto]
print @n.xbgr.xm38.nsg13_hv_pmos[factuo]
print @n.xbgr.xm39.nsg13_hv_pmos[w]
print @n.xbgr.xm39.nsg13_hv_pmos[l]
print @n.xbgr.xm39.nsg13_hv_pmos[delvto]
print @n.xbgr.xm39.nsg13_hv_pmos[factuo]
print @n.xbgr.xm40.nsg13_hv_pmos[w]
print @n.xbgr.xm40.nsg13_hv_pmos[l]
print @n.xbgr.xm40.nsg13_hv_pmos[delvto]
print @n.xbgr.xm40.nsg13_hv_pmos[factuo]
print @n.xbgr.xm41.nsg13_hv_pmos[w]
print @n.xbgr.xm41.nsg13_hv_pmos[l]
print @n.xbgr.xm41.nsg13_hv_pmos[delvto]
print @n.xbgr.xm41.nsg13_hv_pmos[factuo]
print @n.xbgr.xm42.nsg13_hv_pmos[w]
print @n.xbgr.xm42.nsg13_hv_pmos[l]
print @n.xbgr.xm42.nsg13_hv_pmos[delvto]
print @n.xbgr.xm42.nsg13_hv_pmos[factuo]
print @n.xbgr.xm43.nsg13_hv_pmos[w]
print @n.xbgr.xm43.nsg13_hv_pmos[l]
print @n.xbgr.xm43.nsg13_hv_pmos[delvto]
print @n.xbgr.xm43.nsg13_hv_pmos[factuo]
print @n.xbgr.xm44.nsg13_hv_pmos[w]
print @n.xbgr.xm44.nsg13_hv_pmos[l]
print @n.xbgr.xm44.nsg13_hv_pmos[delvto]
print @n.xbgr.xm44.nsg13_hv_pmos[factuo]
print @n.xbgr.xm45.nsg13_hv_pmos[w]
print @n.xbgr.xm45.nsg13_hv_pmos[l]
print @n.xbgr.xm45.nsg13_hv_pmos[delvto]
print @n.xbgr.xm45.nsg13_hv_pmos[factuo]
print @n.xbgr.xm46.nsg13_hv_pmos[w]
print @n.xbgr.xm46.nsg13_hv_pmos[l]
print @n.xbgr.xm46.nsg13_hv_pmos[delvto]
print @n.xbgr.xm46.nsg13_hv_pmos[factuo]
print @n.xbgr.xm47.nsg13_hv_pmos[w]
print @n.xbgr.xm47.nsg13_hv_pmos[l]
print @n.xbgr.xm47.nsg13_hv_pmos[delvto]
print @n.xbgr.xm47.nsg13_hv_pmos[factuo]
print @n.xbgr.xm48.nsg13_hv_pmos[w]
print @n.xbgr.xm48.nsg13_hv_pmos[l]
print @n.xbgr.xm48.nsg13_hv_pmos[delvto]
print @n.xbgr.xm48.nsg13_hv_pmos[factuo]
print @n.xbgr.xm49.nsg13_hv_pmos[w]
print @n.xbgr.xm49.nsg13_hv_pmos[l]
print @n.xbgr.xm49.nsg13_hv_pmos[delvto]
print @n.xbgr.xm49.nsg13_hv_pmos[factuo]
print @n.xbgr.xm50.nsg13_hv_pmos[w]
print @n.xbgr.xm50.nsg13_hv_pmos[l]
print @n.xbgr.xm50.nsg13_hv_pmos[delvto]
print @n.xbgr.xm50.nsg13_hv_pmos[factuo]
print @n.xbgr.xm51.nsg13_hv_pmos[w]
print @n.xbgr.xm51.nsg13_hv_pmos[l]
print @n.xbgr.xm51.nsg13_hv_pmos[delvto]
print @n.xbgr.xm51.nsg13_hv_pmos[factuo]
print @n.xbgr.xm52.nsg13_hv_pmos[w]
print @n.xbgr.xm52.nsg13_hv_pmos[l]
print @n.xbgr.xm52.nsg13_hv_pmos[delvto]
print @n.xbgr.xm52.nsg13_hv_pmos[factuo]
print @n.xbgr.xm53.nsg13_hv_pmos[w]
print @n.xbgr.xm53.nsg13_hv_pmos[l]
print @n.xbgr.xm53.nsg13_hv_pmos[delvto]
print @n.xbgr.xm53.nsg13_hv_pmos[factuo]
print @n.xbgr.xm54.nsg13_hv_pmos[w]
print @n.xbgr.xm54.nsg13_hv_pmos[l]
print @n.xbgr.xm54.nsg13_hv_pmos[delvto]
print @n.xbgr.xm54.nsg13_hv_pmos[factuo]
print @q.xbgr.xq55.qnpn13g2[area]
print @q.xbgr.xq56.qnpn13g2[area]
print @q.xbgr.xq57.qnpn13g2[area]
print @q.xbgr.xq58.qnpn13g2[area]
print @q.xbgr.xq59.qnpn13g2[area]
print @q.xbgr.xq60.qnpn13g2[area]
print @q.xbgr.xq61.qnpn13g2[area]
print @q.xbgr.xq62.qnpn13g2[area]
print @q.xbgr.xq63.qnpn13g2[area]
print @q.xbgr.xq64.qnpn13g2[area]
print @q.xbgr.xq65.qnpn13g2[area]
print @q.xbgr.xq66.qnpn13g2[area]
print @q.xbgr.xq67.qnpn13g2[area]
print @q.xbgr.xq68.qnpn13g2[area]
print @q.xbgr.xq69.qnpn13g2[area]
print @q.xbgr.xq70.qnpn13g2[area]
print @q.xbgr.xq71.qnpn13g2[area]
print @q.xbgr.xq72.qnpn13g2[area]
print @q.xbgr.xq73.qnpn13g2[area]
print @q.xbgr.xq74.qnpn13g2[area]
print @q.xbgr.xq75.qnpn13g2[area]
print @q.xbgr.xq76.qnpn13g2[area]
print @n.xbgr.xr77.nr1[nsmm_rsh]
print @n.xbgr.xr77.nr1[nsmm_w]
print @n.xbgr.xr77.nr1[nsmm_l]
print @n.xbgr.xr78.nr1[nsmm_rsh]
print @n.xbgr.xr78.nr1[nsmm_w]
print @n.xbgr.xr78.nr1[nsmm_l]
print @n.xbgr.xr79.nr1[nsmm_rsh]
print @n.xbgr.xr79.nr1[nsmm_w]
print @n.xbgr.xr79.nr1[nsmm_l]
print @n.xbgr.xr80.nr1[nsmm_rsh]
print @n.xbgr.xr80.nr1[nsmm_w]
print @n.xbgr.xr80.nr1[nsmm_l]
print @n.xbgr.xr81.nr1[nsmm_rsh]
print @n.xbgr.xr81.nr1[nsmm_w]
print @n.xbgr.xr81.nr1[nsmm_l]
print @n.xbgr.xr82.nr1[nsmm_rsh]
print @n.xbgr.xr82.nr1[nsmm_w]
print @n.xbgr.xr82.nr1[nsmm_l]
print @n.xbgr.xr83.nr1[nsmm_rsh]
print @n.xbgr.xr83.nr1[nsmm_w]
print @n.xbgr.xr83.nr1[nsmm_l]
print @n.xbgr.xr84.nr1[nsmm_rsh]
print @n.xbgr.xr84.nr1[nsmm_w]
print @n.xbgr.xr84.nr1[nsmm_l]
print @n.xbgr.xr85.nr1[nsmm_rsh]
print @n.xbgr.xr85.nr1[nsmm_w]
print @n.xbgr.xr85.nr1[nsmm_l]
print @n.xbgr.xr86.nr1[nsmm_rsh]
print @n.xbgr.xr86.nr1[nsmm_w]
print @n.xbgr.xr86.nr1[nsmm_l]
print @n.xbgr.xr16_u2.nr1[nsmm_rsh]
print @n.xbgr.xr16_u2.nr1[nsmm_w]
print @n.xbgr.xr16_u2.nr1[nsmm_l]
print @n.xbgr.xr16_u3.nr1[nsmm_rsh]
print @n.xbgr.xr16_u3.nr1[nsmm_w]
print @n.xbgr.xr16_u3.nr1[nsmm_l]
print @n.xbgr.xr16_u4.nr1[nsmm_rsh]
print @n.xbgr.xr16_u4.nr1[nsmm_w]
print @n.xbgr.xr16_u4.nr1[nsmm_l]
print @n.xbgr.xr16_u5.nr1[nsmm_rsh]
print @n.xbgr.xr16_u5.nr1[nsmm_w]
print @n.xbgr.xr16_u5.nr1[nsmm_l]
print @n.xbgr.xr16_u6.nr1[nsmm_rsh]
print @n.xbgr.xr16_u6.nr1[nsmm_w]
print @n.xbgr.xr16_u6.nr1[nsmm_l]
print @n.xbgr.xr16_u7.nr1[nsmm_rsh]
print @n.xbgr.xr16_u7.nr1[nsmm_w]
print @n.xbgr.xr16_u7.nr1[nsmm_l]
print @n.xbgr.xr16_u8.nr1[nsmm_rsh]
print @n.xbgr.xr16_u8.nr1[nsmm_w]
print @n.xbgr.xr16_u8.nr1[nsmm_l]
print @n.xbgr.xr16_u9.nr1[nsmm_rsh]
print @n.xbgr.xr16_u9.nr1[nsmm_w]
print @n.xbgr.xr16_u9.nr1[nsmm_l]
print @n.xbgr.xr16_u10.nr1[nsmm_rsh]
print @n.xbgr.xr16_u10.nr1[nsmm_w]
print @n.xbgr.xr16_u10.nr1[nsmm_l]
print @n.xbgr.xr16_u11.nr1[nsmm_rsh]
print @n.xbgr.xr16_u11.nr1[nsmm_w]
print @n.xbgr.xr16_u11.nr1[nsmm_l]
print @n.xbgr.xr16_u12.nr1[nsmm_rsh]
print @n.xbgr.xr16_u12.nr1[nsmm_w]
print @n.xbgr.xr16_u12.nr1[nsmm_l]
print @n.xbgr.xr16_u13.nr1[nsmm_rsh]
print @n.xbgr.xr16_u13.nr1[nsmm_w]
print @n.xbgr.xr16_u13.nr1[nsmm_l]
print @n.xbgr.xr16_u14.nr1[nsmm_rsh]
print @n.xbgr.xr16_u14.nr1[nsmm_w]
print @n.xbgr.xr16_u14.nr1[nsmm_l]
print @n.xbgr.xr16_u15.nr1[nsmm_rsh]
print @n.xbgr.xr16_u15.nr1[nsmm_w]
print @n.xbgr.xr16_u15.nr1[nsmm_l]
print @n.xbgr.xr16_u16.nr1[nsmm_rsh]
print @n.xbgr.xr16_u16.nr1[nsmm_w]
print @n.xbgr.xr16_u16.nr1[nsmm_l]
print @n.xbgr.xr16_u17.nr1[nsmm_rsh]
print @n.xbgr.xr16_u17.nr1[nsmm_w]
print @n.xbgr.xr16_u17.nr1[nsmm_l]
print @n.xbgr.xr16_u18.nr1[nsmm_rsh]
print @n.xbgr.xr16_u18.nr1[nsmm_w]
print @n.xbgr.xr16_u18.nr1[nsmm_l]
print @n.xbgr.xr16_u19.nr1[nsmm_rsh]
print @n.xbgr.xr16_u19.nr1[nsmm_w]
print @n.xbgr.xr16_u19.nr1[nsmm_l]
print @n.xbgr.xr16_u20.nr1[nsmm_rsh]
print @n.xbgr.xr16_u20.nr1[nsmm_w]
print @n.xbgr.xr16_u20.nr1[nsmm_l]
print @n.xbgr.xr16_u21.nr1[nsmm_rsh]
print @n.xbgr.xr16_u21.nr1[nsmm_w]
print @n.xbgr.xr16_u21.nr1[nsmm_l]
print @n.xbgr.xr16_u22.nr1[nsmm_rsh]
print @n.xbgr.xr16_u22.nr1[nsmm_w]
print @n.xbgr.xr16_u22.nr1[nsmm_l]
print @n.xbgr.xr16_u23.nr1[nsmm_rsh]
print @n.xbgr.xr16_u23.nr1[nsmm_w]
print @n.xbgr.xr16_u23.nr1[nsmm_l]
print @n.xbgr.xr16_u24.nr1[nsmm_rsh]
print @n.xbgr.xr16_u24.nr1[nsmm_w]
print @n.xbgr.xr16_u24.nr1[nsmm_l]
print @n.xbgr.xr17_u2.nr1[nsmm_rsh]
print @n.xbgr.xr17_u2.nr1[nsmm_w]
print @n.xbgr.xr17_u2.nr1[nsmm_l]
print @n.xbgr.xr17_u3.nr1[nsmm_rsh]
print @n.xbgr.xr17_u3.nr1[nsmm_w]
print @n.xbgr.xr17_u3.nr1[nsmm_l]
print @n.xbgr.xr17_u4.nr1[nsmm_rsh]
print @n.xbgr.xr17_u4.nr1[nsmm_w]
print @n.xbgr.xr17_u4.nr1[nsmm_l]
print @n.xbgr.xr18_u2.nr1[nsmm_rsh]
print @n.xbgr.xr18_u2.nr1[nsmm_w]
print @n.xbgr.xr18_u2.nr1[nsmm_l]
print @n.xbgr.xr18_u3.nr1[nsmm_rsh]
print @n.xbgr.xr18_u3.nr1[nsmm_w]
print @n.xbgr.xr18_u3.nr1[nsmm_l]
print @n.xbgr.xr18_u4.nr1[nsmm_rsh]
print @n.xbgr.xr18_u4.nr1[nsmm_w]
print @n.xbgr.xr18_u4.nr1[nsmm_l]
print @n.xbgr.xr19_u2.nr1[nsmm_rsh]
print @n.xbgr.xr19_u2.nr1[nsmm_w]
print @n.xbgr.xr19_u2.nr1[nsmm_l]
print @n.xbgr.xr19_u3.nr1[nsmm_rsh]
print @n.xbgr.xr19_u3.nr1[nsmm_w]
print @n.xbgr.xr19_u3.nr1[nsmm_l]
print @n.xbgr.xr19_u4.nr1[nsmm_rsh]
print @n.xbgr.xr19_u4.nr1[nsmm_w]
print @n.xbgr.xr19_u4.nr1[nsmm_l]
print @n.xbgr.xr20_u2.nr1[nsmm_rsh]
print @n.xbgr.xr20_u2.nr1[nsmm_w]
print @n.xbgr.xr20_u2.nr1[nsmm_l]
print @n.xbgr.xr20_u3.nr1[nsmm_rsh]
print @n.xbgr.xr20_u3.nr1[nsmm_w]
print @n.xbgr.xr20_u3.nr1[nsmm_l]
print @n.xbgr.xr20_u4.nr1[nsmm_rsh]
print @n.xbgr.xr20_u4.nr1[nsmm_w]
print @n.xbgr.xr20_u4.nr1[nsmm_l]
print @n.xbgr.xr21_u2.nr1[nsmm_rsh]
print @n.xbgr.xr21_u2.nr1[nsmm_w]
print @n.xbgr.xr21_u2.nr1[nsmm_l]
print @n.xbgr.xr21_u3.nr1[nsmm_rsh]
print @n.xbgr.xr21_u3.nr1[nsmm_w]
print @n.xbgr.xr21_u3.nr1[nsmm_l]
print @n.xbgr.xr21_u4.nr1[nsmm_rsh]
print @n.xbgr.xr21_u4.nr1[nsmm_w]
print @n.xbgr.xr21_u4.nr1[nsmm_l]
print @n.xbgr.xr22_u2.nr1[nsmm_rsh]
print @n.xbgr.xr22_u2.nr1[nsmm_w]
print @n.xbgr.xr22_u2.nr1[nsmm_l]
print @n.xbgr.xr22_u3.nr1[nsmm_rsh]
print @n.xbgr.xr22_u3.nr1[nsmm_w]
print @n.xbgr.xr22_u3.nr1[nsmm_l]
print @n.xbgr.xr22_u4.nr1[nsmm_rsh]
print @n.xbgr.xr22_u4.nr1[nsmm_w]
print @n.xbgr.xr22_u4.nr1[nsmm_l]
print @n.xbgr.xr23_u2.nr1[nsmm_rsh]
print @n.xbgr.xr23_u2.nr1[nsmm_w]
print @n.xbgr.xr23_u2.nr1[nsmm_l]
print @n.xbgr.xr23_u3.nr1[nsmm_rsh]
print @n.xbgr.xr23_u3.nr1[nsmm_w]
print @n.xbgr.xr23_u3.nr1[nsmm_l]
print @n.xbgr.xr23_u4.nr1[nsmm_rsh]
print @n.xbgr.xr23_u4.nr1[nsmm_w]
print @n.xbgr.xr23_u4.nr1[nsmm_l]
print @n.xbgr.xr23_u5.nr1[nsmm_rsh]
print @n.xbgr.xr23_u5.nr1[nsmm_w]
print @n.xbgr.xr23_u5.nr1[nsmm_l]
print @n.xbgr.xr23_u6.nr1[nsmm_rsh]
print @n.xbgr.xr23_u6.nr1[nsmm_w]
print @n.xbgr.xr23_u6.nr1[nsmm_l]
print @n.xbgr.xr23_u7.nr1[nsmm_rsh]
print @n.xbgr.xr23_u7.nr1[nsmm_w]
print @n.xbgr.xr23_u7.nr1[nsmm_l]
print @n.xbgr.xr23_u8.nr1[nsmm_rsh]
print @n.xbgr.xr23_u8.nr1[nsmm_w]
print @n.xbgr.xr23_u8.nr1[nsmm_l]
print @n.xbgr.xr23_u9.nr1[nsmm_rsh]
print @n.xbgr.xr23_u9.nr1[nsmm_w]
print @n.xbgr.xr23_u9.nr1[nsmm_l]
print @n.xbgr.xr23_u10.nr1[nsmm_rsh]
print @n.xbgr.xr23_u10.nr1[nsmm_w]
print @n.xbgr.xr23_u10.nr1[nsmm_l]
print @n.xbgr.xr23_u11.nr1[nsmm_rsh]
print @n.xbgr.xr23_u11.nr1[nsmm_w]
print @n.xbgr.xr23_u11.nr1[nsmm_l]
print @n.xbgr.xr23_u12.nr1[nsmm_rsh]
print @n.xbgr.xr23_u12.nr1[nsmm_w]
print @n.xbgr.xr23_u12.nr1[nsmm_l]
print @n.xbgr.xr23_u13.nr1[nsmm_rsh]
print @n.xbgr.xr23_u13.nr1[nsmm_w]
print @n.xbgr.xr23_u13.nr1[nsmm_l]
print @n.xbgr.xr23_u14.nr1[nsmm_rsh]
print @n.xbgr.xr23_u14.nr1[nsmm_w]
print @n.xbgr.xr23_u14.nr1[nsmm_l]
print @n.xbgr.xr23_u15.nr1[nsmm_rsh]
print @n.xbgr.xr23_u15.nr1[nsmm_w]
print @n.xbgr.xr23_u15.nr1[nsmm_l]
print @n.xbgr.xr23_u16.nr1[nsmm_rsh]
print @n.xbgr.xr23_u16.nr1[nsmm_w]
print @n.xbgr.xr23_u16.nr1[nsmm_l]
print @n.xbgr.xr23_u17.nr1[nsmm_rsh]
print @n.xbgr.xr23_u17.nr1[nsmm_w]
print @n.xbgr.xr23_u17.nr1[nsmm_l]
print @n.xbgr.xr23_u18.nr1[nsmm_rsh]
print @n.xbgr.xr23_u18.nr1[nsmm_w]
print @n.xbgr.xr23_u18.nr1[nsmm_l]
print @n.xbgr.xr23_u19.nr1[nsmm_rsh]
print @n.xbgr.xr23_u19.nr1[nsmm_w]
print @n.xbgr.xr23_u19.nr1[nsmm_l]
print @n.xbgr.xr23_u20.nr1[nsmm_rsh]
print @n.xbgr.xr23_u20.nr1[nsmm_w]
print @n.xbgr.xr23_u20.nr1[nsmm_l]
print @n.xbgr.xr23_u21.nr1[nsmm_rsh]
print @n.xbgr.xr23_u21.nr1[nsmm_w]
print @n.xbgr.xr23_u21.nr1[nsmm_l]
print @n.xbgr.xr23_u22.nr1[nsmm_rsh]
print @n.xbgr.xr23_u22.nr1[nsmm_w]
print @n.xbgr.xr23_u22.nr1[nsmm_l]
print @n.xbgr.xr23_u23.nr1[nsmm_rsh]
print @n.xbgr.xr23_u23.nr1[nsmm_w]
print @n.xbgr.xr23_u23.nr1[nsmm_l]
print @n.xbgr.xr23_u24.nr1[nsmm_rsh]
print @n.xbgr.xr23_u24.nr1[nsmm_w]
print @n.xbgr.xr23_u24.nr1[nsmm_l]
print @n.xbgr.xr24_u2.nr1[nsmm_rsh]
print @n.xbgr.xr24_u2.nr1[nsmm_w]
print @n.xbgr.xr24_u2.nr1[nsmm_l]
print @n.xbgr.xr24_u3.nr1[nsmm_rsh]
print @n.xbgr.xr24_u3.nr1[nsmm_w]
print @n.xbgr.xr24_u3.nr1[nsmm_l]
print @n.xbgr.xr24_u4.nr1[nsmm_rsh]
print @n.xbgr.xr24_u4.nr1[nsmm_w]
print @n.xbgr.xr24_u4.nr1[nsmm_l]
print @n.xbgr.xr24_u5.nr1[nsmm_rsh]
print @n.xbgr.xr24_u5.nr1[nsmm_w]
print @n.xbgr.xr24_u5.nr1[nsmm_l]
print @n.xbgr.xr24_u6.nr1[nsmm_rsh]
print @n.xbgr.xr24_u6.nr1[nsmm_w]
print @n.xbgr.xr24_u6.nr1[nsmm_l]
print @n.xbgr.xr24_u7.nr1[nsmm_rsh]
print @n.xbgr.xr24_u7.nr1[nsmm_w]
print @n.xbgr.xr24_u7.nr1[nsmm_l]
print @n.xbgr.xr24_u8.nr1[nsmm_rsh]
print @n.xbgr.xr24_u8.nr1[nsmm_w]
print @n.xbgr.xr24_u8.nr1[nsmm_l]
print @n.xbgr.xr24_u9.nr1[nsmm_rsh]
print @n.xbgr.xr24_u9.nr1[nsmm_w]
print @n.xbgr.xr24_u9.nr1[nsmm_l]
print @n.xbgr.xr24_u10.nr1[nsmm_rsh]
print @n.xbgr.xr24_u10.nr1[nsmm_w]
print @n.xbgr.xr24_u10.nr1[nsmm_l]
print @n.xbgr.xr24_u11.nr1[nsmm_rsh]
print @n.xbgr.xr24_u11.nr1[nsmm_w]
print @n.xbgr.xr24_u11.nr1[nsmm_l]
print @n.xbgr.xr24_u12.nr1[nsmm_rsh]
print @n.xbgr.xr24_u12.nr1[nsmm_w]
print @n.xbgr.xr24_u12.nr1[nsmm_l]
print @n.xbgr.xr24_u13.nr1[nsmm_rsh]
print @n.xbgr.xr24_u13.nr1[nsmm_w]
print @n.xbgr.xr24_u13.nr1[nsmm_l]
print @n.xbgr.xr24_u14.nr1[nsmm_rsh]
print @n.xbgr.xr24_u14.nr1[nsmm_w]
print @n.xbgr.xr24_u14.nr1[nsmm_l]
print @n.xbgr.xr24_u15.nr1[nsmm_rsh]
print @n.xbgr.xr24_u15.nr1[nsmm_w]
print @n.xbgr.xr24_u15.nr1[nsmm_l]
print @n.xbgr.xr24_u16.nr1[nsmm_rsh]
print @n.xbgr.xr24_u16.nr1[nsmm_w]
print @n.xbgr.xr24_u16.nr1[nsmm_l]
print @n.xbgr.xr24_u17.nr1[nsmm_rsh]
print @n.xbgr.xr24_u17.nr1[nsmm_w]
print @n.xbgr.xr24_u17.nr1[nsmm_l]
print @n.xbgr.xr24_u18.nr1[nsmm_rsh]
print @n.xbgr.xr24_u18.nr1[nsmm_w]
print @n.xbgr.xr24_u18.nr1[nsmm_l]
print @n.xbgr.xr24_u19.nr1[nsmm_rsh]
print @n.xbgr.xr24_u19.nr1[nsmm_w]
print @n.xbgr.xr24_u19.nr1[nsmm_l]
print @n.xbgr.xr24_u20.nr1[nsmm_rsh]
print @n.xbgr.xr24_u20.nr1[nsmm_w]
print @n.xbgr.xr24_u20.nr1[nsmm_l]
print @n.xbgr.xr24_u21.nr1[nsmm_rsh]
print @n.xbgr.xr24_u21.nr1[nsmm_w]
print @n.xbgr.xr24_u21.nr1[nsmm_l]
print @n.xbgr.xr24_u22.nr1[nsmm_rsh]
print @n.xbgr.xr24_u22.nr1[nsmm_w]
print @n.xbgr.xr24_u22.nr1[nsmm_l]
print @n.xbgr.xr24_u23.nr1[nsmm_rsh]
print @n.xbgr.xr24_u23.nr1[nsmm_w]
print @n.xbgr.xr24_u23.nr1[nsmm_l]
print @n.xbgr.xr24_u24.nr1[nsmm_rsh]
print @n.xbgr.xr24_u24.nr1[nsmm_w]
print @n.xbgr.xr24_u24.nr1[nsmm_l]
print @n.xbgr.xr25_u2.nr1[nsmm_rsh]
print @n.xbgr.xr25_u2.nr1[nsmm_w]
print @n.xbgr.xr25_u2.nr1[nsmm_l]
print @n.xbgr.xr25_u3.nr1[nsmm_rsh]
print @n.xbgr.xr25_u3.nr1[nsmm_w]
print @n.xbgr.xr25_u3.nr1[nsmm_l]
print @n.xbgr.xr25_u4.nr1[nsmm_rsh]
print @n.xbgr.xr25_u4.nr1[nsmm_w]
print @n.xbgr.xr25_u4.nr1[nsmm_l]
print @n.xbgr.xr25_u5.nr1[nsmm_rsh]
print @n.xbgr.xr25_u5.nr1[nsmm_w]
print @n.xbgr.xr25_u5.nr1[nsmm_l]
print @n.xbgr.xr25_u6.nr1[nsmm_rsh]
print @n.xbgr.xr25_u6.nr1[nsmm_w]
print @n.xbgr.xr25_u6.nr1[nsmm_l]
print @n.xbgr.xr25_u7.nr1[nsmm_rsh]
print @n.xbgr.xr25_u7.nr1[nsmm_w]
print @n.xbgr.xr25_u7.nr1[nsmm_l]
print @n.xbgr.xr25_u8.nr1[nsmm_rsh]
print @n.xbgr.xr25_u8.nr1[nsmm_w]
print @n.xbgr.xr25_u8.nr1[nsmm_l]
print @n.xbgr.xr25_u9.nr1[nsmm_rsh]
print @n.xbgr.xr25_u9.nr1[nsmm_w]
print @n.xbgr.xr25_u9.nr1[nsmm_l]
print @n.xbgr.xr25_u10.nr1[nsmm_rsh]
print @n.xbgr.xr25_u10.nr1[nsmm_w]
print @n.xbgr.xr25_u10.nr1[nsmm_l]
print @n.xbgr.xr25_u11.nr1[nsmm_rsh]
print @n.xbgr.xr25_u11.nr1[nsmm_w]
print @n.xbgr.xr25_u11.nr1[nsmm_l]
print @n.xbgr.xr25_u12.nr1[nsmm_rsh]
print @n.xbgr.xr25_u12.nr1[nsmm_w]
print @n.xbgr.xr25_u12.nr1[nsmm_l]
print @n.xbgr.xr25_u13.nr1[nsmm_rsh]
print @n.xbgr.xr25_u13.nr1[nsmm_w]
print @n.xbgr.xr25_u13.nr1[nsmm_l]
print @n.xbgr.xr25_u14.nr1[nsmm_rsh]
print @n.xbgr.xr25_u14.nr1[nsmm_w]
print @n.xbgr.xr25_u14.nr1[nsmm_l]
print @n.xbgr.xr25_u15.nr1[nsmm_rsh]
print @n.xbgr.xr25_u15.nr1[nsmm_w]
print @n.xbgr.xr25_u15.nr1[nsmm_l]
print @n.xbgr.xr25_u16.nr1[nsmm_rsh]
print @n.xbgr.xr25_u16.nr1[nsmm_w]
print @n.xbgr.xr25_u16.nr1[nsmm_l]
print @n.xbgr.xr25_u17.nr1[nsmm_rsh]
print @n.xbgr.xr25_u17.nr1[nsmm_w]
print @n.xbgr.xr25_u17.nr1[nsmm_l]
print @n.xbgr.xr25_u18.nr1[nsmm_rsh]
print @n.xbgr.xr25_u18.nr1[nsmm_w]
print @n.xbgr.xr25_u18.nr1[nsmm_l]
print @n.xbgr.xr25_u19.nr1[nsmm_rsh]
print @n.xbgr.xr25_u19.nr1[nsmm_w]
print @n.xbgr.xr25_u19.nr1[nsmm_l]
print @n.xbgr.xr25_u20.nr1[nsmm_rsh]
print @n.xbgr.xr25_u20.nr1[nsmm_w]
print @n.xbgr.xr25_u20.nr1[nsmm_l]
print @n.xbgr.xr25_u21.nr1[nsmm_rsh]
print @n.xbgr.xr25_u21.nr1[nsmm_w]
print @n.xbgr.xr25_u21.nr1[nsmm_l]
print @n.xbgr.xr25_u22.nr1[nsmm_rsh]
print @n.xbgr.xr25_u22.nr1[nsmm_w]
print @n.xbgr.xr25_u22.nr1[nsmm_l]
print @n.xbgr.xr25_u23.nr1[nsmm_rsh]
print @n.xbgr.xr25_u23.nr1[nsmm_w]
print @n.xbgr.xr25_u23.nr1[nsmm_l]
print @n.xbgr.xr25_u24.nr1[nsmm_rsh]
print @n.xbgr.xr25_u24.nr1[nsmm_w]
print @n.xbgr.xr25_u24.nr1[nsmm_l]
print @n.xbgr.xr26_u2.nr1[nsmm_rsh]
print @n.xbgr.xr26_u2.nr1[nsmm_w]
print @n.xbgr.xr26_u2.nr1[nsmm_l]
print @n.xbgr.xr26_u3.nr1[nsmm_rsh]
print @n.xbgr.xr26_u3.nr1[nsmm_w]
print @n.xbgr.xr26_u3.nr1[nsmm_l]
print @n.xbgr.xr26_u4.nr1[nsmm_rsh]
print @n.xbgr.xr26_u4.nr1[nsmm_w]
print @n.xbgr.xr26_u4.nr1[nsmm_l]
print @n.xbgr.xr26_u5.nr1[nsmm_rsh]
print @n.xbgr.xr26_u5.nr1[nsmm_w]
print @n.xbgr.xr26_u5.nr1[nsmm_l]
print @n.xbgr.xr26_u6.nr1[nsmm_rsh]
print @n.xbgr.xr26_u6.nr1[nsmm_w]
print @n.xbgr.xr26_u6.nr1[nsmm_l]
print @n.xbgr.xr26_u7.nr1[nsmm_rsh]
print @n.xbgr.xr26_u7.nr1[nsmm_w]
print @n.xbgr.xr26_u7.nr1[nsmm_l]
print @n.xbgr.xr26_u8.nr1[nsmm_rsh]
print @n.xbgr.xr26_u8.nr1[nsmm_w]
print @n.xbgr.xr26_u8.nr1[nsmm_l]
print @n.xbgr.xr26_u9.nr1[nsmm_rsh]
print @n.xbgr.xr26_u9.nr1[nsmm_w]
print @n.xbgr.xr26_u9.nr1[nsmm_l]
print @n.xbgr.xr26_u10.nr1[nsmm_rsh]
print @n.xbgr.xr26_u10.nr1[nsmm_w]
print @n.xbgr.xr26_u10.nr1[nsmm_l]
print @n.xbgr.xr26_u11.nr1[nsmm_rsh]
print @n.xbgr.xr26_u11.nr1[nsmm_w]
print @n.xbgr.xr26_u11.nr1[nsmm_l]
print @n.xbgr.xr26_u12.nr1[nsmm_rsh]
print @n.xbgr.xr26_u12.nr1[nsmm_w]
print @n.xbgr.xr26_u12.nr1[nsmm_l]
print @n.xbgr.xr26_u13.nr1[nsmm_rsh]
print @n.xbgr.xr26_u13.nr1[nsmm_w]
print @n.xbgr.xr26_u13.nr1[nsmm_l]
print @n.xbgr.xr26_u14.nr1[nsmm_rsh]
print @n.xbgr.xr26_u14.nr1[nsmm_w]
print @n.xbgr.xr26_u14.nr1[nsmm_l]
print @n.xbgr.xr26_u15.nr1[nsmm_rsh]
print @n.xbgr.xr26_u15.nr1[nsmm_w]
print @n.xbgr.xr26_u15.nr1[nsmm_l]
print @n.xbgr.xr26_u16.nr1[nsmm_rsh]
print @n.xbgr.xr26_u16.nr1[nsmm_w]
print @n.xbgr.xr26_u16.nr1[nsmm_l]
print @n.xbgr.xr26_u17.nr1[nsmm_rsh]
print @n.xbgr.xr26_u17.nr1[nsmm_w]
print @n.xbgr.xr26_u17.nr1[nsmm_l]
print @n.xbgr.xr26_u18.nr1[nsmm_rsh]
print @n.xbgr.xr26_u18.nr1[nsmm_w]
print @n.xbgr.xr26_u18.nr1[nsmm_l]
print @n.xbgr.xr26_u19.nr1[nsmm_rsh]
print @n.xbgr.xr26_u19.nr1[nsmm_w]
print @n.xbgr.xr26_u19.nr1[nsmm_l]
print @n.xbgr.xr26_u20.nr1[nsmm_rsh]
print @n.xbgr.xr26_u20.nr1[nsmm_w]
print @n.xbgr.xr26_u20.nr1[nsmm_l]
print @n.xbgr.xr26_u21.nr1[nsmm_rsh]
print @n.xbgr.xr26_u21.nr1[nsmm_w]
print @n.xbgr.xr26_u21.nr1[nsmm_l]
print @n.xbgr.xr26_u22.nr1[nsmm_rsh]
print @n.xbgr.xr26_u22.nr1[nsmm_w]
print @n.xbgr.xr26_u22.nr1[nsmm_l]
print @n.xbgr.xr26_u23.nr1[nsmm_rsh]
print @n.xbgr.xr26_u23.nr1[nsmm_w]
print @n.xbgr.xr26_u23.nr1[nsmm_l]
print @n.xbgr.xr26_u24.nr1[nsmm_rsh]
print @n.xbgr.xr26_u24.nr1[nsmm_w]
print @n.xbgr.xr26_u24.nr1[nsmm_l]
print @n.xbgr.xm34_u2.nsg13_hv_nmos[w]
print @n.xbgr.xm34_u2.nsg13_hv_nmos[l]
print @n.xbgr.xm34_u2.nsg13_hv_nmos[delvto]
print @n.xbgr.xm34_u2.nsg13_hv_nmos[factuo]
print @n.xbgr.xm34_u3.nsg13_hv_nmos[w]
print @n.xbgr.xm34_u3.nsg13_hv_nmos[l]
print @n.xbgr.xm34_u3.nsg13_hv_nmos[delvto]
print @n.xbgr.xm34_u3.nsg13_hv_nmos[factuo]
print @n.xbgr.xm34_u4.nsg13_hv_nmos[w]
print @n.xbgr.xm34_u4.nsg13_hv_nmos[l]
print @n.xbgr.xm34_u4.nsg13_hv_nmos[delvto]
print @n.xbgr.xm34_u4.nsg13_hv_nmos[factuo]
print @n.xbgr.xm34_u5.nsg13_hv_nmos[w]
print @n.xbgr.xm34_u5.nsg13_hv_nmos[l]
print @n.xbgr.xm34_u5.nsg13_hv_nmos[delvto]
print @n.xbgr.xm34_u5.nsg13_hv_nmos[factuo]
print @n.xbgr.xm34_u6.nsg13_hv_nmos[w]
print @n.xbgr.xm34_u6.nsg13_hv_nmos[l]
print @n.xbgr.xm34_u6.nsg13_hv_nmos[delvto]
print @n.xbgr.xm34_u6.nsg13_hv_nmos[factuo]
print @n.xbgr.xm34_u7.nsg13_hv_nmos[w]
print @n.xbgr.xm34_u7.nsg13_hv_nmos[l]
print @n.xbgr.xm34_u7.nsg13_hv_nmos[delvto]
print @n.xbgr.xm34_u7.nsg13_hv_nmos[factuo]
print @n.xbgr.xm34_u8.nsg13_hv_nmos[w]
print @n.xbgr.xm34_u8.nsg13_hv_nmos[l]
print @n.xbgr.xm34_u8.nsg13_hv_nmos[delvto]
print @n.xbgr.xm34_u8.nsg13_hv_nmos[factuo]
print @n.xbgr.xm34_u9.nsg13_hv_nmos[w]
print @n.xbgr.xm34_u9.nsg13_hv_nmos[l]
print @n.xbgr.xm34_u9.nsg13_hv_nmos[delvto]
print @n.xbgr.xm34_u9.nsg13_hv_nmos[factuo]
print @n.xbgr.xm34_u10.nsg13_hv_nmos[w]
print @n.xbgr.xm34_u10.nsg13_hv_nmos[l]
print @n.xbgr.xm34_u10.nsg13_hv_nmos[delvto]
print @n.xbgr.xm34_u10.nsg13_hv_nmos[factuo]
print @n.xbgr.xm34_u11.nsg13_hv_nmos[w]
print @n.xbgr.xm34_u11.nsg13_hv_nmos[l]
print @n.xbgr.xm34_u11.nsg13_hv_nmos[delvto]
print @n.xbgr.xm34_u11.nsg13_hv_nmos[factuo]
print @n.xbgr.xm34_u12.nsg13_hv_nmos[w]
print @n.xbgr.xm34_u12.nsg13_hv_nmos[l]
print @n.xbgr.xm34_u12.nsg13_hv_nmos[delvto]
print @n.xbgr.xm34_u12.nsg13_hv_nmos[factuo]
print @n.xbgr.xm34_u13.nsg13_hv_nmos[w]
print @n.xbgr.xm34_u13.nsg13_hv_nmos[l]
print @n.xbgr.xm34_u13.nsg13_hv_nmos[delvto]
print @n.xbgr.xm34_u13.nsg13_hv_nmos[factuo]
print @n.xbgr.xm34_u14.nsg13_hv_nmos[w]
print @n.xbgr.xm34_u14.nsg13_hv_nmos[l]
print @n.xbgr.xm34_u14.nsg13_hv_nmos[delvto]
print @n.xbgr.xm34_u14.nsg13_hv_nmos[factuo]
print @n.xbgr.xm34_u15.nsg13_hv_nmos[w]
print @n.xbgr.xm34_u15.nsg13_hv_nmos[l]
print @n.xbgr.xm34_u15.nsg13_hv_nmos[delvto]
print @n.xbgr.xm34_u15.nsg13_hv_nmos[factuo]
print @n.xbgr.xm34_u16.nsg13_hv_nmos[w]
print @n.xbgr.xm34_u16.nsg13_hv_nmos[l]
print @n.xbgr.xm34_u16.nsg13_hv_nmos[delvto]
print @n.xbgr.xm34_u16.nsg13_hv_nmos[factuo]
print @n.xbgr.xm34_u17.nsg13_hv_nmos[w]
print @n.xbgr.xm34_u17.nsg13_hv_nmos[l]
print @n.xbgr.xm34_u17.nsg13_hv_nmos[delvto]
print @n.xbgr.xm34_u17.nsg13_hv_nmos[factuo]
print @n.xbgr.xm34_u18.nsg13_hv_nmos[w]
print @n.xbgr.xm34_u18.nsg13_hv_nmos[l]
print @n.xbgr.xm34_u18.nsg13_hv_nmos[delvto]
print @n.xbgr.xm34_u18.nsg13_hv_nmos[factuo]
print @n.xbgr.xm34_u19.nsg13_hv_nmos[w]
print @n.xbgr.xm34_u19.nsg13_hv_nmos[l]
print @n.xbgr.xm34_u19.nsg13_hv_nmos[delvto]
print @n.xbgr.xm34_u19.nsg13_hv_nmos[factuo]
print @n.xbgr.xm34_u20.nsg13_hv_nmos[w]
print @n.xbgr.xm34_u20.nsg13_hv_nmos[l]
print @n.xbgr.xm34_u20.nsg13_hv_nmos[delvto]
print @n.xbgr.xm34_u20.nsg13_hv_nmos[factuo]
print @n.xbgr.xm34_u21.nsg13_hv_nmos[w]
print @n.xbgr.xm34_u21.nsg13_hv_nmos[l]
print @n.xbgr.xm34_u21.nsg13_hv_nmos[delvto]
print @n.xbgr.xm34_u21.nsg13_hv_nmos[factuo]
print @n.xbgr.xm34_u22.nsg13_hv_nmos[w]
print @n.xbgr.xm34_u22.nsg13_hv_nmos[l]
print @n.xbgr.xm34_u22.nsg13_hv_nmos[delvto]
print @n.xbgr.xm34_u22.nsg13_hv_nmos[factuo]
print @n.xbgr.xm34_u23.nsg13_hv_nmos[w]
print @n.xbgr.xm34_u23.nsg13_hv_nmos[l]
print @n.xbgr.xm34_u23.nsg13_hv_nmos[delvto]
print @n.xbgr.xm34_u23.nsg13_hv_nmos[factuo]
print @n.xbgr.xm34_u24.nsg13_hv_nmos[w]
print @n.xbgr.xm34_u24.nsg13_hv_nmos[l]
print @n.xbgr.xm34_u24.nsg13_hv_nmos[delvto]
print @n.xbgr.xm34_u24.nsg13_hv_nmos[factuo]
print @n.xbgr.xm35_u2.nsg13_hv_nmos[w]
print @n.xbgr.xm35_u2.nsg13_hv_nmos[l]
print @n.xbgr.xm35_u2.nsg13_hv_nmos[delvto]
print @n.xbgr.xm35_u2.nsg13_hv_nmos[factuo]
print @n.xbgr.xm35_u3.nsg13_hv_nmos[w]
print @n.xbgr.xm35_u3.nsg13_hv_nmos[l]
print @n.xbgr.xm35_u3.nsg13_hv_nmos[delvto]
print @n.xbgr.xm35_u3.nsg13_hv_nmos[factuo]
print @n.xbgr.xm35_u4.nsg13_hv_nmos[w]
print @n.xbgr.xm35_u4.nsg13_hv_nmos[l]
print @n.xbgr.xm35_u4.nsg13_hv_nmos[delvto]
print @n.xbgr.xm35_u4.nsg13_hv_nmos[factuo]
print @n.xbgr.xm35_u5.nsg13_hv_nmos[w]
print @n.xbgr.xm35_u5.nsg13_hv_nmos[l]
print @n.xbgr.xm35_u5.nsg13_hv_nmos[delvto]
print @n.xbgr.xm35_u5.nsg13_hv_nmos[factuo]
print @n.xbgr.xm35_u6.nsg13_hv_nmos[w]
print @n.xbgr.xm35_u6.nsg13_hv_nmos[l]
print @n.xbgr.xm35_u6.nsg13_hv_nmos[delvto]
print @n.xbgr.xm35_u6.nsg13_hv_nmos[factuo]
print @n.xbgr.xm35_u7.nsg13_hv_nmos[w]
print @n.xbgr.xm35_u7.nsg13_hv_nmos[l]
print @n.xbgr.xm35_u7.nsg13_hv_nmos[delvto]
print @n.xbgr.xm35_u7.nsg13_hv_nmos[factuo]
print @n.xbgr.xm35_u8.nsg13_hv_nmos[w]
print @n.xbgr.xm35_u8.nsg13_hv_nmos[l]
print @n.xbgr.xm35_u8.nsg13_hv_nmos[delvto]
print @n.xbgr.xm35_u8.nsg13_hv_nmos[factuo]
print @n.xbgr.xm35_u9.nsg13_hv_nmos[w]
print @n.xbgr.xm35_u9.nsg13_hv_nmos[l]
print @n.xbgr.xm35_u9.nsg13_hv_nmos[delvto]
print @n.xbgr.xm35_u9.nsg13_hv_nmos[factuo]
print @n.xbgr.xm35_u10.nsg13_hv_nmos[w]
print @n.xbgr.xm35_u10.nsg13_hv_nmos[l]
print @n.xbgr.xm35_u10.nsg13_hv_nmos[delvto]
print @n.xbgr.xm35_u10.nsg13_hv_nmos[factuo]
print @n.xbgr.xm35_u11.nsg13_hv_nmos[w]
print @n.xbgr.xm35_u11.nsg13_hv_nmos[l]
print @n.xbgr.xm35_u11.nsg13_hv_nmos[delvto]
print @n.xbgr.xm35_u11.nsg13_hv_nmos[factuo]
print @n.xbgr.xm35_u12.nsg13_hv_nmos[w]
print @n.xbgr.xm35_u12.nsg13_hv_nmos[l]
print @n.xbgr.xm35_u12.nsg13_hv_nmos[delvto]
print @n.xbgr.xm35_u12.nsg13_hv_nmos[factuo]
print @n.xbgr.xm35_u13.nsg13_hv_nmos[w]
print @n.xbgr.xm35_u13.nsg13_hv_nmos[l]
print @n.xbgr.xm35_u13.nsg13_hv_nmos[delvto]
print @n.xbgr.xm35_u13.nsg13_hv_nmos[factuo]
print @n.xbgr.xm35_u14.nsg13_hv_nmos[w]
print @n.xbgr.xm35_u14.nsg13_hv_nmos[l]
print @n.xbgr.xm35_u14.nsg13_hv_nmos[delvto]
print @n.xbgr.xm35_u14.nsg13_hv_nmos[factuo]
print @n.xbgr.xm35_u15.nsg13_hv_nmos[w]
print @n.xbgr.xm35_u15.nsg13_hv_nmos[l]
print @n.xbgr.xm35_u15.nsg13_hv_nmos[delvto]
print @n.xbgr.xm35_u15.nsg13_hv_nmos[factuo]
print @n.xbgr.xm35_u16.nsg13_hv_nmos[w]
print @n.xbgr.xm35_u16.nsg13_hv_nmos[l]
print @n.xbgr.xm35_u16.nsg13_hv_nmos[delvto]
print @n.xbgr.xm35_u16.nsg13_hv_nmos[factuo]
print @n.xbgr.xm35_u17.nsg13_hv_nmos[w]
print @n.xbgr.xm35_u17.nsg13_hv_nmos[l]
print @n.xbgr.xm35_u17.nsg13_hv_nmos[delvto]
print @n.xbgr.xm35_u17.nsg13_hv_nmos[factuo]
print @n.xbgr.xm35_u18.nsg13_hv_nmos[w]
print @n.xbgr.xm35_u18.nsg13_hv_nmos[l]
print @n.xbgr.xm35_u18.nsg13_hv_nmos[delvto]
print @n.xbgr.xm35_u18.nsg13_hv_nmos[factuo]
print @n.xbgr.xm35_u19.nsg13_hv_nmos[w]
print @n.xbgr.xm35_u19.nsg13_hv_nmos[l]
print @n.xbgr.xm35_u19.nsg13_hv_nmos[delvto]
print @n.xbgr.xm35_u19.nsg13_hv_nmos[factuo]
print @n.xbgr.xm35_u20.nsg13_hv_nmos[w]
print @n.xbgr.xm35_u20.nsg13_hv_nmos[l]
print @n.xbgr.xm35_u20.nsg13_hv_nmos[delvto]
print @n.xbgr.xm35_u20.nsg13_hv_nmos[factuo]
print @n.xbgr.xm35_u21.nsg13_hv_nmos[w]
print @n.xbgr.xm35_u21.nsg13_hv_nmos[l]
print @n.xbgr.xm35_u21.nsg13_hv_nmos[delvto]
print @n.xbgr.xm35_u21.nsg13_hv_nmos[factuo]
print @n.xbgr.xm35_u22.nsg13_hv_nmos[w]
print @n.xbgr.xm35_u22.nsg13_hv_nmos[l]
print @n.xbgr.xm35_u22.nsg13_hv_nmos[delvto]
print @n.xbgr.xm35_u22.nsg13_hv_nmos[factuo]
print @n.xbgr.xm35_u23.nsg13_hv_nmos[w]
print @n.xbgr.xm35_u23.nsg13_hv_nmos[l]
print @n.xbgr.xm35_u23.nsg13_hv_nmos[delvto]
print @n.xbgr.xm35_u23.nsg13_hv_nmos[factuo]
print @n.xbgr.xm35_u24.nsg13_hv_nmos[w]
print @n.xbgr.xm35_u24.nsg13_hv_nmos[l]
print @n.xbgr.xm35_u24.nsg13_hv_nmos[delvto]
print @n.xbgr.xm35_u24.nsg13_hv_nmos[factuo]
print @n.xbgr.xm36_u2.nsg13_hv_nmos[w]
print @n.xbgr.xm36_u2.nsg13_hv_nmos[l]
print @n.xbgr.xm36_u2.nsg13_hv_nmos[delvto]
print @n.xbgr.xm36_u2.nsg13_hv_nmos[factuo]
print @n.xbgr.xm36_u3.nsg13_hv_nmos[w]
print @n.xbgr.xm36_u3.nsg13_hv_nmos[l]
print @n.xbgr.xm36_u3.nsg13_hv_nmos[delvto]
print @n.xbgr.xm36_u3.nsg13_hv_nmos[factuo]
print @n.xbgr.xm36_u4.nsg13_hv_nmos[w]
print @n.xbgr.xm36_u4.nsg13_hv_nmos[l]
print @n.xbgr.xm36_u4.nsg13_hv_nmos[delvto]
print @n.xbgr.xm36_u4.nsg13_hv_nmos[factuo]
print @n.xbgr.xm36_u5.nsg13_hv_nmos[w]
print @n.xbgr.xm36_u5.nsg13_hv_nmos[l]
print @n.xbgr.xm36_u5.nsg13_hv_nmos[delvto]
print @n.xbgr.xm36_u5.nsg13_hv_nmos[factuo]
print @n.xbgr.xm36_u6.nsg13_hv_nmos[w]
print @n.xbgr.xm36_u6.nsg13_hv_nmos[l]
print @n.xbgr.xm36_u6.nsg13_hv_nmos[delvto]
print @n.xbgr.xm36_u6.nsg13_hv_nmos[factuo]
print @n.xbgr.xm36_u7.nsg13_hv_nmos[w]
print @n.xbgr.xm36_u7.nsg13_hv_nmos[l]
print @n.xbgr.xm36_u7.nsg13_hv_nmos[delvto]
print @n.xbgr.xm36_u7.nsg13_hv_nmos[factuo]
print @n.xbgr.xm36_u8.nsg13_hv_nmos[w]
print @n.xbgr.xm36_u8.nsg13_hv_nmos[l]
print @n.xbgr.xm36_u8.nsg13_hv_nmos[delvto]
print @n.xbgr.xm36_u8.nsg13_hv_nmos[factuo]
print @n.xbgr.xm36_u9.nsg13_hv_nmos[w]
print @n.xbgr.xm36_u9.nsg13_hv_nmos[l]
print @n.xbgr.xm36_u9.nsg13_hv_nmos[delvto]
print @n.xbgr.xm36_u9.nsg13_hv_nmos[factuo]
print @n.xbgr.xm36_u10.nsg13_hv_nmos[w]
print @n.xbgr.xm36_u10.nsg13_hv_nmos[l]
print @n.xbgr.xm36_u10.nsg13_hv_nmos[delvto]
print @n.xbgr.xm36_u10.nsg13_hv_nmos[factuo]
print @n.xbgr.xm36_u11.nsg13_hv_nmos[w]
print @n.xbgr.xm36_u11.nsg13_hv_nmos[l]
print @n.xbgr.xm36_u11.nsg13_hv_nmos[delvto]
print @n.xbgr.xm36_u11.nsg13_hv_nmos[factuo]
print @n.xbgr.xm36_u12.nsg13_hv_nmos[w]
print @n.xbgr.xm36_u12.nsg13_hv_nmos[l]
print @n.xbgr.xm36_u12.nsg13_hv_nmos[delvto]
print @n.xbgr.xm36_u12.nsg13_hv_nmos[factuo]
print @n.xbgr.xm36_u13.nsg13_hv_nmos[w]
print @n.xbgr.xm36_u13.nsg13_hv_nmos[l]
print @n.xbgr.xm36_u13.nsg13_hv_nmos[delvto]
print @n.xbgr.xm36_u13.nsg13_hv_nmos[factuo]
print @n.xbgr.xm36_u14.nsg13_hv_nmos[w]
print @n.xbgr.xm36_u14.nsg13_hv_nmos[l]
print @n.xbgr.xm36_u14.nsg13_hv_nmos[delvto]
print @n.xbgr.xm36_u14.nsg13_hv_nmos[factuo]
print @n.xbgr.xm36_u15.nsg13_hv_nmos[w]
print @n.xbgr.xm36_u15.nsg13_hv_nmos[l]
print @n.xbgr.xm36_u15.nsg13_hv_nmos[delvto]
print @n.xbgr.xm36_u15.nsg13_hv_nmos[factuo]
print @n.xbgr.xm36_u16.nsg13_hv_nmos[w]
print @n.xbgr.xm36_u16.nsg13_hv_nmos[l]
print @n.xbgr.xm36_u16.nsg13_hv_nmos[delvto]
print @n.xbgr.xm36_u16.nsg13_hv_nmos[factuo]
print @n.xbgr.xm36_u17.nsg13_hv_nmos[w]
print @n.xbgr.xm36_u17.nsg13_hv_nmos[l]
print @n.xbgr.xm36_u17.nsg13_hv_nmos[delvto]
print @n.xbgr.xm36_u17.nsg13_hv_nmos[factuo]
print @n.xbgr.xm36_u18.nsg13_hv_nmos[w]
print @n.xbgr.xm36_u18.nsg13_hv_nmos[l]
print @n.xbgr.xm36_u18.nsg13_hv_nmos[delvto]
print @n.xbgr.xm36_u18.nsg13_hv_nmos[factuo]
print @n.xbgr.xm36_u19.nsg13_hv_nmos[w]
print @n.xbgr.xm36_u19.nsg13_hv_nmos[l]
print @n.xbgr.xm36_u19.nsg13_hv_nmos[delvto]
print @n.xbgr.xm36_u19.nsg13_hv_nmos[factuo]
print @n.xbgr.xm36_u20.nsg13_hv_nmos[w]
print @n.xbgr.xm36_u20.nsg13_hv_nmos[l]
print @n.xbgr.xm36_u20.nsg13_hv_nmos[delvto]
print @n.xbgr.xm36_u20.nsg13_hv_nmos[factuo]
print @n.xbgr.xm36_u21.nsg13_hv_nmos[w]
print @n.xbgr.xm36_u21.nsg13_hv_nmos[l]
print @n.xbgr.xm36_u21.nsg13_hv_nmos[delvto]
print @n.xbgr.xm36_u21.nsg13_hv_nmos[factuo]
print @n.xbgr.xm36_u22.nsg13_hv_nmos[w]
print @n.xbgr.xm36_u22.nsg13_hv_nmos[l]
print @n.xbgr.xm36_u22.nsg13_hv_nmos[delvto]
print @n.xbgr.xm36_u22.nsg13_hv_nmos[factuo]
print @n.xbgr.xm36_u23.nsg13_hv_nmos[w]
print @n.xbgr.xm36_u23.nsg13_hv_nmos[l]
print @n.xbgr.xm36_u23.nsg13_hv_nmos[delvto]
print @n.xbgr.xm36_u23.nsg13_hv_nmos[factuo]
print @n.xbgr.xm36_u24.nsg13_hv_nmos[w]
print @n.xbgr.xm36_u24.nsg13_hv_nmos[l]
print @n.xbgr.xm36_u24.nsg13_hv_nmos[delvto]
print @n.xbgr.xm36_u24.nsg13_hv_nmos[factuo]
print @n.xbgr.xm37_u2.nsg13_hv_nmos[w]
print @n.xbgr.xm37_u2.nsg13_hv_nmos[l]
print @n.xbgr.xm37_u2.nsg13_hv_nmos[delvto]
print @n.xbgr.xm37_u2.nsg13_hv_nmos[factuo]
print @n.xbgr.xm37_u3.nsg13_hv_nmos[w]
print @n.xbgr.xm37_u3.nsg13_hv_nmos[l]
print @n.xbgr.xm37_u3.nsg13_hv_nmos[delvto]
print @n.xbgr.xm37_u3.nsg13_hv_nmos[factuo]
print @n.xbgr.xm37_u4.nsg13_hv_nmos[w]
print @n.xbgr.xm37_u4.nsg13_hv_nmos[l]
print @n.xbgr.xm37_u4.nsg13_hv_nmos[delvto]
print @n.xbgr.xm37_u4.nsg13_hv_nmos[factuo]
print @n.xbgr.xm37_u5.nsg13_hv_nmos[w]
print @n.xbgr.xm37_u5.nsg13_hv_nmos[l]
print @n.xbgr.xm37_u5.nsg13_hv_nmos[delvto]
print @n.xbgr.xm37_u5.nsg13_hv_nmos[factuo]
print @n.xbgr.xm37_u6.nsg13_hv_nmos[w]
print @n.xbgr.xm37_u6.nsg13_hv_nmos[l]
print @n.xbgr.xm37_u6.nsg13_hv_nmos[delvto]
print @n.xbgr.xm37_u6.nsg13_hv_nmos[factuo]
print @n.xbgr.xm37_u7.nsg13_hv_nmos[w]
print @n.xbgr.xm37_u7.nsg13_hv_nmos[l]
print @n.xbgr.xm37_u7.nsg13_hv_nmos[delvto]
print @n.xbgr.xm37_u7.nsg13_hv_nmos[factuo]
print @n.xbgr.xm37_u8.nsg13_hv_nmos[w]
print @n.xbgr.xm37_u8.nsg13_hv_nmos[l]
print @n.xbgr.xm37_u8.nsg13_hv_nmos[delvto]
print @n.xbgr.xm37_u8.nsg13_hv_nmos[factuo]
print @n.xbgr.xm37_u9.nsg13_hv_nmos[w]
print @n.xbgr.xm37_u9.nsg13_hv_nmos[l]
print @n.xbgr.xm37_u9.nsg13_hv_nmos[delvto]
print @n.xbgr.xm37_u9.nsg13_hv_nmos[factuo]
print @n.xbgr.xm37_u10.nsg13_hv_nmos[w]
print @n.xbgr.xm37_u10.nsg13_hv_nmos[l]
print @n.xbgr.xm37_u10.nsg13_hv_nmos[delvto]
print @n.xbgr.xm37_u10.nsg13_hv_nmos[factuo]
print @n.xbgr.xm37_u11.nsg13_hv_nmos[w]
print @n.xbgr.xm37_u11.nsg13_hv_nmos[l]
print @n.xbgr.xm37_u11.nsg13_hv_nmos[delvto]
print @n.xbgr.xm37_u11.nsg13_hv_nmos[factuo]
print @n.xbgr.xm37_u12.nsg13_hv_nmos[w]
print @n.xbgr.xm37_u12.nsg13_hv_nmos[l]
print @n.xbgr.xm37_u12.nsg13_hv_nmos[delvto]
print @n.xbgr.xm37_u12.nsg13_hv_nmos[factuo]
print @n.xbgr.xm37_u13.nsg13_hv_nmos[w]
print @n.xbgr.xm37_u13.nsg13_hv_nmos[l]
print @n.xbgr.xm37_u13.nsg13_hv_nmos[delvto]
print @n.xbgr.xm37_u13.nsg13_hv_nmos[factuo]
print @n.xbgr.xm37_u14.nsg13_hv_nmos[w]
print @n.xbgr.xm37_u14.nsg13_hv_nmos[l]
print @n.xbgr.xm37_u14.nsg13_hv_nmos[delvto]
print @n.xbgr.xm37_u14.nsg13_hv_nmos[factuo]
print @n.xbgr.xm37_u15.nsg13_hv_nmos[w]
print @n.xbgr.xm37_u15.nsg13_hv_nmos[l]
print @n.xbgr.xm37_u15.nsg13_hv_nmos[delvto]
print @n.xbgr.xm37_u15.nsg13_hv_nmos[factuo]
print @n.xbgr.xm37_u16.nsg13_hv_nmos[w]
print @n.xbgr.xm37_u16.nsg13_hv_nmos[l]
print @n.xbgr.xm37_u16.nsg13_hv_nmos[delvto]
print @n.xbgr.xm37_u16.nsg13_hv_nmos[factuo]
print @n.xbgr.xm37_u17.nsg13_hv_nmos[w]
print @n.xbgr.xm37_u17.nsg13_hv_nmos[l]
print @n.xbgr.xm37_u17.nsg13_hv_nmos[delvto]
print @n.xbgr.xm37_u17.nsg13_hv_nmos[factuo]
print @n.xbgr.xm37_u18.nsg13_hv_nmos[w]
print @n.xbgr.xm37_u18.nsg13_hv_nmos[l]
print @n.xbgr.xm37_u18.nsg13_hv_nmos[delvto]
print @n.xbgr.xm37_u18.nsg13_hv_nmos[factuo]
print @n.xbgr.xm37_u19.nsg13_hv_nmos[w]
print @n.xbgr.xm37_u19.nsg13_hv_nmos[l]
print @n.xbgr.xm37_u19.nsg13_hv_nmos[delvto]
print @n.xbgr.xm37_u19.nsg13_hv_nmos[factuo]
print @n.xbgr.xm37_u20.nsg13_hv_nmos[w]
print @n.xbgr.xm37_u20.nsg13_hv_nmos[l]
print @n.xbgr.xm37_u20.nsg13_hv_nmos[delvto]
print @n.xbgr.xm37_u20.nsg13_hv_nmos[factuo]
print @n.xbgr.xm37_u21.nsg13_hv_nmos[w]
print @n.xbgr.xm37_u21.nsg13_hv_nmos[l]
print @n.xbgr.xm37_u21.nsg13_hv_nmos[delvto]
print @n.xbgr.xm37_u21.nsg13_hv_nmos[factuo]
print @n.xbgr.xm37_u22.nsg13_hv_nmos[w]
print @n.xbgr.xm37_u22.nsg13_hv_nmos[l]
print @n.xbgr.xm37_u22.nsg13_hv_nmos[delvto]
print @n.xbgr.xm37_u22.nsg13_hv_nmos[factuo]
print @n.xbgr.xm37_u23.nsg13_hv_nmos[w]
print @n.xbgr.xm37_u23.nsg13_hv_nmos[l]
print @n.xbgr.xm37_u23.nsg13_hv_nmos[delvto]
print @n.xbgr.xm37_u23.nsg13_hv_nmos[factuo]
print @n.xbgr.xm37_u24.nsg13_hv_nmos[w]
print @n.xbgr.xm37_u24.nsg13_hv_nmos[l]
print @n.xbgr.xm37_u24.nsg13_hv_nmos[delvto]
print @n.xbgr.xm37_u24.nsg13_hv_nmos[factuo]
print @n.xbgr.xm38_u2.nsg13_hv_pmos[w]
print @n.xbgr.xm38_u2.nsg13_hv_pmos[l]
print @n.xbgr.xm38_u2.nsg13_hv_pmos[delvto]
print @n.xbgr.xm38_u2.nsg13_hv_pmos[factuo]
print @n.xbgr.xm38_u3.nsg13_hv_pmos[w]
print @n.xbgr.xm38_u3.nsg13_hv_pmos[l]
print @n.xbgr.xm38_u3.nsg13_hv_pmos[delvto]
print @n.xbgr.xm38_u3.nsg13_hv_pmos[factuo]
print @n.xbgr.xm38_u4.nsg13_hv_pmos[w]
print @n.xbgr.xm38_u4.nsg13_hv_pmos[l]
print @n.xbgr.xm38_u4.nsg13_hv_pmos[delvto]
print @n.xbgr.xm38_u4.nsg13_hv_pmos[factuo]
print @n.xbgr.xm38_u5.nsg13_hv_pmos[w]
print @n.xbgr.xm38_u5.nsg13_hv_pmos[l]
print @n.xbgr.xm38_u5.nsg13_hv_pmos[delvto]
print @n.xbgr.xm38_u5.nsg13_hv_pmos[factuo]
print @n.xbgr.xm38_u6.nsg13_hv_pmos[w]
print @n.xbgr.xm38_u6.nsg13_hv_pmos[l]
print @n.xbgr.xm38_u6.nsg13_hv_pmos[delvto]
print @n.xbgr.xm38_u6.nsg13_hv_pmos[factuo]
print @n.xbgr.xm38_u7.nsg13_hv_pmos[w]
print @n.xbgr.xm38_u7.nsg13_hv_pmos[l]
print @n.xbgr.xm38_u7.nsg13_hv_pmos[delvto]
print @n.xbgr.xm38_u7.nsg13_hv_pmos[factuo]
print @n.xbgr.xm38_u8.nsg13_hv_pmos[w]
print @n.xbgr.xm38_u8.nsg13_hv_pmos[l]
print @n.xbgr.xm38_u8.nsg13_hv_pmos[delvto]
print @n.xbgr.xm38_u8.nsg13_hv_pmos[factuo]
print @n.xbgr.xm38_u9.nsg13_hv_pmos[w]
print @n.xbgr.xm38_u9.nsg13_hv_pmos[l]
print @n.xbgr.xm38_u9.nsg13_hv_pmos[delvto]
print @n.xbgr.xm38_u9.nsg13_hv_pmos[factuo]
print @n.xbgr.xm38_u10.nsg13_hv_pmos[w]
print @n.xbgr.xm38_u10.nsg13_hv_pmos[l]
print @n.xbgr.xm38_u10.nsg13_hv_pmos[delvto]
print @n.xbgr.xm38_u10.nsg13_hv_pmos[factuo]
print @n.xbgr.xm38_u11.nsg13_hv_pmos[w]
print @n.xbgr.xm38_u11.nsg13_hv_pmos[l]
print @n.xbgr.xm38_u11.nsg13_hv_pmos[delvto]
print @n.xbgr.xm38_u11.nsg13_hv_pmos[factuo]
print @n.xbgr.xm38_u12.nsg13_hv_pmos[w]
print @n.xbgr.xm38_u12.nsg13_hv_pmos[l]
print @n.xbgr.xm38_u12.nsg13_hv_pmos[delvto]
print @n.xbgr.xm38_u12.nsg13_hv_pmos[factuo]
print @n.xbgr.xm38_u13.nsg13_hv_pmos[w]
print @n.xbgr.xm38_u13.nsg13_hv_pmos[l]
print @n.xbgr.xm38_u13.nsg13_hv_pmos[delvto]
print @n.xbgr.xm38_u13.nsg13_hv_pmos[factuo]
print @n.xbgr.xm38_u14.nsg13_hv_pmos[w]
print @n.xbgr.xm38_u14.nsg13_hv_pmos[l]
print @n.xbgr.xm38_u14.nsg13_hv_pmos[delvto]
print @n.xbgr.xm38_u14.nsg13_hv_pmos[factuo]
print @n.xbgr.xm38_u15.nsg13_hv_pmos[w]
print @n.xbgr.xm38_u15.nsg13_hv_pmos[l]
print @n.xbgr.xm38_u15.nsg13_hv_pmos[delvto]
print @n.xbgr.xm38_u15.nsg13_hv_pmos[factuo]
print @n.xbgr.xm38_u16.nsg13_hv_pmos[w]
print @n.xbgr.xm38_u16.nsg13_hv_pmos[l]
print @n.xbgr.xm38_u16.nsg13_hv_pmos[delvto]
print @n.xbgr.xm38_u16.nsg13_hv_pmos[factuo]
print @n.xbgr.xm38_u17.nsg13_hv_pmos[w]
print @n.xbgr.xm38_u17.nsg13_hv_pmos[l]
print @n.xbgr.xm38_u17.nsg13_hv_pmos[delvto]
print @n.xbgr.xm38_u17.nsg13_hv_pmos[factuo]
print @n.xbgr.xm38_u18.nsg13_hv_pmos[w]
print @n.xbgr.xm38_u18.nsg13_hv_pmos[l]
print @n.xbgr.xm38_u18.nsg13_hv_pmos[delvto]
print @n.xbgr.xm38_u18.nsg13_hv_pmos[factuo]
print @n.xbgr.xm38_u19.nsg13_hv_pmos[w]
print @n.xbgr.xm38_u19.nsg13_hv_pmos[l]
print @n.xbgr.xm38_u19.nsg13_hv_pmos[delvto]
print @n.xbgr.xm38_u19.nsg13_hv_pmos[factuo]
print @n.xbgr.xm38_u20.nsg13_hv_pmos[w]
print @n.xbgr.xm38_u20.nsg13_hv_pmos[l]
print @n.xbgr.xm38_u20.nsg13_hv_pmos[delvto]
print @n.xbgr.xm38_u20.nsg13_hv_pmos[factuo]
print @n.xbgr.xm38_u21.nsg13_hv_pmos[w]
print @n.xbgr.xm38_u21.nsg13_hv_pmos[l]
print @n.xbgr.xm38_u21.nsg13_hv_pmos[delvto]
print @n.xbgr.xm38_u21.nsg13_hv_pmos[factuo]
print @n.xbgr.xm38_u22.nsg13_hv_pmos[w]
print @n.xbgr.xm38_u22.nsg13_hv_pmos[l]
print @n.xbgr.xm38_u22.nsg13_hv_pmos[delvto]
print @n.xbgr.xm38_u22.nsg13_hv_pmos[factuo]
print @n.xbgr.xm38_u23.nsg13_hv_pmos[w]
print @n.xbgr.xm38_u23.nsg13_hv_pmos[l]
print @n.xbgr.xm38_u23.nsg13_hv_pmos[delvto]
print @n.xbgr.xm38_u23.nsg13_hv_pmos[factuo]
print @n.xbgr.xm38_u24.nsg13_hv_pmos[w]
print @n.xbgr.xm38_u24.nsg13_hv_pmos[l]
print @n.xbgr.xm38_u24.nsg13_hv_pmos[delvto]
print @n.xbgr.xm38_u24.nsg13_hv_pmos[factuo]
print @n.xbgr.xm39_u2.nsg13_hv_pmos[w]
print @n.xbgr.xm39_u2.nsg13_hv_pmos[l]
print @n.xbgr.xm39_u2.nsg13_hv_pmos[delvto]
print @n.xbgr.xm39_u2.nsg13_hv_pmos[factuo]
print @n.xbgr.xm39_u3.nsg13_hv_pmos[w]
print @n.xbgr.xm39_u3.nsg13_hv_pmos[l]
print @n.xbgr.xm39_u3.nsg13_hv_pmos[delvto]
print @n.xbgr.xm39_u3.nsg13_hv_pmos[factuo]
print @n.xbgr.xm39_u4.nsg13_hv_pmos[w]
print @n.xbgr.xm39_u4.nsg13_hv_pmos[l]
print @n.xbgr.xm39_u4.nsg13_hv_pmos[delvto]
print @n.xbgr.xm39_u4.nsg13_hv_pmos[factuo]
print @n.xbgr.xm39_u5.nsg13_hv_pmos[w]
print @n.xbgr.xm39_u5.nsg13_hv_pmos[l]
print @n.xbgr.xm39_u5.nsg13_hv_pmos[delvto]
print @n.xbgr.xm39_u5.nsg13_hv_pmos[factuo]
print @n.xbgr.xm39_u6.nsg13_hv_pmos[w]
print @n.xbgr.xm39_u6.nsg13_hv_pmos[l]
print @n.xbgr.xm39_u6.nsg13_hv_pmos[delvto]
print @n.xbgr.xm39_u6.nsg13_hv_pmos[factuo]
print @n.xbgr.xm39_u7.nsg13_hv_pmos[w]
print @n.xbgr.xm39_u7.nsg13_hv_pmos[l]
print @n.xbgr.xm39_u7.nsg13_hv_pmos[delvto]
print @n.xbgr.xm39_u7.nsg13_hv_pmos[factuo]
print @n.xbgr.xm39_u8.nsg13_hv_pmos[w]
print @n.xbgr.xm39_u8.nsg13_hv_pmos[l]
print @n.xbgr.xm39_u8.nsg13_hv_pmos[delvto]
print @n.xbgr.xm39_u8.nsg13_hv_pmos[factuo]
print @n.xbgr.xm39_u9.nsg13_hv_pmos[w]
print @n.xbgr.xm39_u9.nsg13_hv_pmos[l]
print @n.xbgr.xm39_u9.nsg13_hv_pmos[delvto]
print @n.xbgr.xm39_u9.nsg13_hv_pmos[factuo]
print @n.xbgr.xm39_u10.nsg13_hv_pmos[w]
print @n.xbgr.xm39_u10.nsg13_hv_pmos[l]
print @n.xbgr.xm39_u10.nsg13_hv_pmos[delvto]
print @n.xbgr.xm39_u10.nsg13_hv_pmos[factuo]
print @n.xbgr.xm39_u11.nsg13_hv_pmos[w]
print @n.xbgr.xm39_u11.nsg13_hv_pmos[l]
print @n.xbgr.xm39_u11.nsg13_hv_pmos[delvto]
print @n.xbgr.xm39_u11.nsg13_hv_pmos[factuo]
print @n.xbgr.xm39_u12.nsg13_hv_pmos[w]
print @n.xbgr.xm39_u12.nsg13_hv_pmos[l]
print @n.xbgr.xm39_u12.nsg13_hv_pmos[delvto]
print @n.xbgr.xm39_u12.nsg13_hv_pmos[factuo]
print @n.xbgr.xm39_u13.nsg13_hv_pmos[w]
print @n.xbgr.xm39_u13.nsg13_hv_pmos[l]
print @n.xbgr.xm39_u13.nsg13_hv_pmos[delvto]
print @n.xbgr.xm39_u13.nsg13_hv_pmos[factuo]
print @n.xbgr.xm39_u14.nsg13_hv_pmos[w]
print @n.xbgr.xm39_u14.nsg13_hv_pmos[l]
print @n.xbgr.xm39_u14.nsg13_hv_pmos[delvto]
print @n.xbgr.xm39_u14.nsg13_hv_pmos[factuo]
print @n.xbgr.xm39_u15.nsg13_hv_pmos[w]
print @n.xbgr.xm39_u15.nsg13_hv_pmos[l]
print @n.xbgr.xm39_u15.nsg13_hv_pmos[delvto]
print @n.xbgr.xm39_u15.nsg13_hv_pmos[factuo]
print @n.xbgr.xm39_u16.nsg13_hv_pmos[w]
print @n.xbgr.xm39_u16.nsg13_hv_pmos[l]
print @n.xbgr.xm39_u16.nsg13_hv_pmos[delvto]
print @n.xbgr.xm39_u16.nsg13_hv_pmos[factuo]
print @n.xbgr.xm39_u17.nsg13_hv_pmos[w]
print @n.xbgr.xm39_u17.nsg13_hv_pmos[l]
print @n.xbgr.xm39_u17.nsg13_hv_pmos[delvto]
print @n.xbgr.xm39_u17.nsg13_hv_pmos[factuo]
print @n.xbgr.xm39_u18.nsg13_hv_pmos[w]
print @n.xbgr.xm39_u18.nsg13_hv_pmos[l]
print @n.xbgr.xm39_u18.nsg13_hv_pmos[delvto]
print @n.xbgr.xm39_u18.nsg13_hv_pmos[factuo]
print @n.xbgr.xm39_u19.nsg13_hv_pmos[w]
print @n.xbgr.xm39_u19.nsg13_hv_pmos[l]
print @n.xbgr.xm39_u19.nsg13_hv_pmos[delvto]
print @n.xbgr.xm39_u19.nsg13_hv_pmos[factuo]
print @n.xbgr.xm39_u20.nsg13_hv_pmos[w]
print @n.xbgr.xm39_u20.nsg13_hv_pmos[l]
print @n.xbgr.xm39_u20.nsg13_hv_pmos[delvto]
print @n.xbgr.xm39_u20.nsg13_hv_pmos[factuo]
print @n.xbgr.xm39_u21.nsg13_hv_pmos[w]
print @n.xbgr.xm39_u21.nsg13_hv_pmos[l]
print @n.xbgr.xm39_u21.nsg13_hv_pmos[delvto]
print @n.xbgr.xm39_u21.nsg13_hv_pmos[factuo]
print @n.xbgr.xm39_u22.nsg13_hv_pmos[w]
print @n.xbgr.xm39_u22.nsg13_hv_pmos[l]
print @n.xbgr.xm39_u22.nsg13_hv_pmos[delvto]
print @n.xbgr.xm39_u22.nsg13_hv_pmos[factuo]
print @n.xbgr.xm39_u23.nsg13_hv_pmos[w]
print @n.xbgr.xm39_u23.nsg13_hv_pmos[l]
print @n.xbgr.xm39_u23.nsg13_hv_pmos[delvto]
print @n.xbgr.xm39_u23.nsg13_hv_pmos[factuo]
print @n.xbgr.xm39_u24.nsg13_hv_pmos[w]
print @n.xbgr.xm39_u24.nsg13_hv_pmos[l]
print @n.xbgr.xm39_u24.nsg13_hv_pmos[delvto]
print @n.xbgr.xm39_u24.nsg13_hv_pmos[factuo]
print @n.xbgr.xm41_u2.nsg13_hv_pmos[w]
print @n.xbgr.xm41_u2.nsg13_hv_pmos[l]
print @n.xbgr.xm41_u2.nsg13_hv_pmos[delvto]
print @n.xbgr.xm41_u2.nsg13_hv_pmos[factuo]
print @n.xbgr.xm41_u3.nsg13_hv_pmos[w]
print @n.xbgr.xm41_u3.nsg13_hv_pmos[l]
print @n.xbgr.xm41_u3.nsg13_hv_pmos[delvto]
print @n.xbgr.xm41_u3.nsg13_hv_pmos[factuo]
print @n.xbgr.xm41_u4.nsg13_hv_pmos[w]
print @n.xbgr.xm41_u4.nsg13_hv_pmos[l]
print @n.xbgr.xm41_u4.nsg13_hv_pmos[delvto]
print @n.xbgr.xm41_u4.nsg13_hv_pmos[factuo]
print @n.xbgr.xm41_u5.nsg13_hv_pmos[w]
print @n.xbgr.xm41_u5.nsg13_hv_pmos[l]
print @n.xbgr.xm41_u5.nsg13_hv_pmos[delvto]
print @n.xbgr.xm41_u5.nsg13_hv_pmos[factuo]
print @n.xbgr.xm41_u6.nsg13_hv_pmos[w]
print @n.xbgr.xm41_u6.nsg13_hv_pmos[l]
print @n.xbgr.xm41_u6.nsg13_hv_pmos[delvto]
print @n.xbgr.xm41_u6.nsg13_hv_pmos[factuo]
print @n.xbgr.xm41_u7.nsg13_hv_pmos[w]
print @n.xbgr.xm41_u7.nsg13_hv_pmos[l]
print @n.xbgr.xm41_u7.nsg13_hv_pmos[delvto]
print @n.xbgr.xm41_u7.nsg13_hv_pmos[factuo]
print @n.xbgr.xm41_u8.nsg13_hv_pmos[w]
print @n.xbgr.xm41_u8.nsg13_hv_pmos[l]
print @n.xbgr.xm41_u8.nsg13_hv_pmos[delvto]
print @n.xbgr.xm41_u8.nsg13_hv_pmos[factuo]
print @n.xbgr.xm41_u9.nsg13_hv_pmos[w]
print @n.xbgr.xm41_u9.nsg13_hv_pmos[l]
print @n.xbgr.xm41_u9.nsg13_hv_pmos[delvto]
print @n.xbgr.xm41_u9.nsg13_hv_pmos[factuo]
print @n.xbgr.xm41_u10.nsg13_hv_pmos[w]
print @n.xbgr.xm41_u10.nsg13_hv_pmos[l]
print @n.xbgr.xm41_u10.nsg13_hv_pmos[delvto]
print @n.xbgr.xm41_u10.nsg13_hv_pmos[factuo]
print @n.xbgr.xm41_u11.nsg13_hv_pmos[w]
print @n.xbgr.xm41_u11.nsg13_hv_pmos[l]
print @n.xbgr.xm41_u11.nsg13_hv_pmos[delvto]
print @n.xbgr.xm41_u11.nsg13_hv_pmos[factuo]
print @n.xbgr.xm41_u12.nsg13_hv_pmos[w]
print @n.xbgr.xm41_u12.nsg13_hv_pmos[l]
print @n.xbgr.xm41_u12.nsg13_hv_pmos[delvto]
print @n.xbgr.xm41_u12.nsg13_hv_pmos[factuo]
print @n.xbgr.xm41_u13.nsg13_hv_pmos[w]
print @n.xbgr.xm41_u13.nsg13_hv_pmos[l]
print @n.xbgr.xm41_u13.nsg13_hv_pmos[delvto]
print @n.xbgr.xm41_u13.nsg13_hv_pmos[factuo]
print @n.xbgr.xm41_u14.nsg13_hv_pmos[w]
print @n.xbgr.xm41_u14.nsg13_hv_pmos[l]
print @n.xbgr.xm41_u14.nsg13_hv_pmos[delvto]
print @n.xbgr.xm41_u14.nsg13_hv_pmos[factuo]
print @n.xbgr.xm41_u15.nsg13_hv_pmos[w]
print @n.xbgr.xm41_u15.nsg13_hv_pmos[l]
print @n.xbgr.xm41_u15.nsg13_hv_pmos[delvto]
print @n.xbgr.xm41_u15.nsg13_hv_pmos[factuo]
print @n.xbgr.xm41_u16.nsg13_hv_pmos[w]
print @n.xbgr.xm41_u16.nsg13_hv_pmos[l]
print @n.xbgr.xm41_u16.nsg13_hv_pmos[delvto]
print @n.xbgr.xm41_u16.nsg13_hv_pmos[factuo]
print @n.xbgr.xm41_u17.nsg13_hv_pmos[w]
print @n.xbgr.xm41_u17.nsg13_hv_pmos[l]
print @n.xbgr.xm41_u17.nsg13_hv_pmos[delvto]
print @n.xbgr.xm41_u17.nsg13_hv_pmos[factuo]
print @n.xbgr.xm41_u18.nsg13_hv_pmos[w]
print @n.xbgr.xm41_u18.nsg13_hv_pmos[l]
print @n.xbgr.xm41_u18.nsg13_hv_pmos[delvto]
print @n.xbgr.xm41_u18.nsg13_hv_pmos[factuo]
print @n.xbgr.xm41_u19.nsg13_hv_pmos[w]
print @n.xbgr.xm41_u19.nsg13_hv_pmos[l]
print @n.xbgr.xm41_u19.nsg13_hv_pmos[delvto]
print @n.xbgr.xm41_u19.nsg13_hv_pmos[factuo]
print @n.xbgr.xm41_u20.nsg13_hv_pmos[w]
print @n.xbgr.xm41_u20.nsg13_hv_pmos[l]
print @n.xbgr.xm41_u20.nsg13_hv_pmos[delvto]
print @n.xbgr.xm41_u20.nsg13_hv_pmos[factuo]
print @n.xbgr.xm41_u21.nsg13_hv_pmos[w]
print @n.xbgr.xm41_u21.nsg13_hv_pmos[l]
print @n.xbgr.xm41_u21.nsg13_hv_pmos[delvto]
print @n.xbgr.xm41_u21.nsg13_hv_pmos[factuo]
print @n.xbgr.xm41_u22.nsg13_hv_pmos[w]
print @n.xbgr.xm41_u22.nsg13_hv_pmos[l]
print @n.xbgr.xm41_u22.nsg13_hv_pmos[delvto]
print @n.xbgr.xm41_u22.nsg13_hv_pmos[factuo]
print @n.xbgr.xm41_u23.nsg13_hv_pmos[w]
print @n.xbgr.xm41_u23.nsg13_hv_pmos[l]
print @n.xbgr.xm41_u23.nsg13_hv_pmos[delvto]
print @n.xbgr.xm41_u23.nsg13_hv_pmos[factuo]
print @n.xbgr.xm41_u24.nsg13_hv_pmos[w]
print @n.xbgr.xm41_u24.nsg13_hv_pmos[l]
print @n.xbgr.xm41_u24.nsg13_hv_pmos[delvto]
print @n.xbgr.xm41_u24.nsg13_hv_pmos[factuo]
print @n.xbgr.xm43_u2.nsg13_hv_pmos[w]
print @n.xbgr.xm43_u2.nsg13_hv_pmos[l]
print @n.xbgr.xm43_u2.nsg13_hv_pmos[delvto]
print @n.xbgr.xm43_u2.nsg13_hv_pmos[factuo]
print @n.xbgr.xm43_u3.nsg13_hv_pmos[w]
print @n.xbgr.xm43_u3.nsg13_hv_pmos[l]
print @n.xbgr.xm43_u3.nsg13_hv_pmos[delvto]
print @n.xbgr.xm43_u3.nsg13_hv_pmos[factuo]
print @n.xbgr.xm43_u4.nsg13_hv_pmos[w]
print @n.xbgr.xm43_u4.nsg13_hv_pmos[l]
print @n.xbgr.xm43_u4.nsg13_hv_pmos[delvto]
print @n.xbgr.xm43_u4.nsg13_hv_pmos[factuo]
print @n.xbgr.xm44_u2.nsg13_hv_pmos[w]
print @n.xbgr.xm44_u2.nsg13_hv_pmos[l]
print @n.xbgr.xm44_u2.nsg13_hv_pmos[delvto]
print @n.xbgr.xm44_u2.nsg13_hv_pmos[factuo]
print @n.xbgr.xm44_u3.nsg13_hv_pmos[w]
print @n.xbgr.xm44_u3.nsg13_hv_pmos[l]
print @n.xbgr.xm44_u3.nsg13_hv_pmos[delvto]
print @n.xbgr.xm44_u3.nsg13_hv_pmos[factuo]
print @n.xbgr.xm44_u4.nsg13_hv_pmos[w]
print @n.xbgr.xm44_u4.nsg13_hv_pmos[l]
print @n.xbgr.xm44_u4.nsg13_hv_pmos[delvto]
print @n.xbgr.xm44_u4.nsg13_hv_pmos[factuo]
print @n.xbgr.xm45_u2.nsg13_hv_pmos[w]
print @n.xbgr.xm45_u2.nsg13_hv_pmos[l]
print @n.xbgr.xm45_u2.nsg13_hv_pmos[delvto]
print @n.xbgr.xm45_u2.nsg13_hv_pmos[factuo]
print @n.xbgr.xm45_u3.nsg13_hv_pmos[w]
print @n.xbgr.xm45_u3.nsg13_hv_pmos[l]
print @n.xbgr.xm45_u3.nsg13_hv_pmos[delvto]
print @n.xbgr.xm45_u3.nsg13_hv_pmos[factuo]
print @n.xbgr.xm45_u4.nsg13_hv_pmos[w]
print @n.xbgr.xm45_u4.nsg13_hv_pmos[l]
print @n.xbgr.xm45_u4.nsg13_hv_pmos[delvto]
print @n.xbgr.xm45_u4.nsg13_hv_pmos[factuo]
print @n.xbgr.xm45_u5.nsg13_hv_pmos[w]
print @n.xbgr.xm45_u5.nsg13_hv_pmos[l]
print @n.xbgr.xm45_u5.nsg13_hv_pmos[delvto]
print @n.xbgr.xm45_u5.nsg13_hv_pmos[factuo]
print @n.xbgr.xm45_u6.nsg13_hv_pmos[w]
print @n.xbgr.xm45_u6.nsg13_hv_pmos[l]
print @n.xbgr.xm45_u6.nsg13_hv_pmos[delvto]
print @n.xbgr.xm45_u6.nsg13_hv_pmos[factuo]
print @n.xbgr.xm45_u7.nsg13_hv_pmos[w]
print @n.xbgr.xm45_u7.nsg13_hv_pmos[l]
print @n.xbgr.xm45_u7.nsg13_hv_pmos[delvto]
print @n.xbgr.xm45_u7.nsg13_hv_pmos[factuo]
print @n.xbgr.xm45_u8.nsg13_hv_pmos[w]
print @n.xbgr.xm45_u8.nsg13_hv_pmos[l]
print @n.xbgr.xm45_u8.nsg13_hv_pmos[delvto]
print @n.xbgr.xm45_u8.nsg13_hv_pmos[factuo]
print @n.xbgr.xm45_u9.nsg13_hv_pmos[w]
print @n.xbgr.xm45_u9.nsg13_hv_pmos[l]
print @n.xbgr.xm45_u9.nsg13_hv_pmos[delvto]
print @n.xbgr.xm45_u9.nsg13_hv_pmos[factuo]
print @n.xbgr.xm45_u10.nsg13_hv_pmos[w]
print @n.xbgr.xm45_u10.nsg13_hv_pmos[l]
print @n.xbgr.xm45_u10.nsg13_hv_pmos[delvto]
print @n.xbgr.xm45_u10.nsg13_hv_pmos[factuo]
print @n.xbgr.xm45_u11.nsg13_hv_pmos[w]
print @n.xbgr.xm45_u11.nsg13_hv_pmos[l]
print @n.xbgr.xm45_u11.nsg13_hv_pmos[delvto]
print @n.xbgr.xm45_u11.nsg13_hv_pmos[factuo]
print @n.xbgr.xm45_u12.nsg13_hv_pmos[w]
print @n.xbgr.xm45_u12.nsg13_hv_pmos[l]
print @n.xbgr.xm45_u12.nsg13_hv_pmos[delvto]
print @n.xbgr.xm45_u12.nsg13_hv_pmos[factuo]
print @n.xbgr.xm45_u13.nsg13_hv_pmos[w]
print @n.xbgr.xm45_u13.nsg13_hv_pmos[l]
print @n.xbgr.xm45_u13.nsg13_hv_pmos[delvto]
print @n.xbgr.xm45_u13.nsg13_hv_pmos[factuo]
print @n.xbgr.xm45_u14.nsg13_hv_pmos[w]
print @n.xbgr.xm45_u14.nsg13_hv_pmos[l]
print @n.xbgr.xm45_u14.nsg13_hv_pmos[delvto]
print @n.xbgr.xm45_u14.nsg13_hv_pmos[factuo]
print @n.xbgr.xm45_u15.nsg13_hv_pmos[w]
print @n.xbgr.xm45_u15.nsg13_hv_pmos[l]
print @n.xbgr.xm45_u15.nsg13_hv_pmos[delvto]
print @n.xbgr.xm45_u15.nsg13_hv_pmos[factuo]
print @n.xbgr.xm45_u16.nsg13_hv_pmos[w]
print @n.xbgr.xm45_u16.nsg13_hv_pmos[l]
print @n.xbgr.xm45_u16.nsg13_hv_pmos[delvto]
print @n.xbgr.xm45_u16.nsg13_hv_pmos[factuo]
print @n.xbgr.xm45_u17.nsg13_hv_pmos[w]
print @n.xbgr.xm45_u17.nsg13_hv_pmos[l]
print @n.xbgr.xm45_u17.nsg13_hv_pmos[delvto]
print @n.xbgr.xm45_u17.nsg13_hv_pmos[factuo]
print @n.xbgr.xm45_u18.nsg13_hv_pmos[w]
print @n.xbgr.xm45_u18.nsg13_hv_pmos[l]
print @n.xbgr.xm45_u18.nsg13_hv_pmos[delvto]
print @n.xbgr.xm45_u18.nsg13_hv_pmos[factuo]
print @n.xbgr.xm45_u19.nsg13_hv_pmos[w]
print @n.xbgr.xm45_u19.nsg13_hv_pmos[l]
print @n.xbgr.xm45_u19.nsg13_hv_pmos[delvto]
print @n.xbgr.xm45_u19.nsg13_hv_pmos[factuo]
print @n.xbgr.xm45_u20.nsg13_hv_pmos[w]
print @n.xbgr.xm45_u20.nsg13_hv_pmos[l]
print @n.xbgr.xm45_u20.nsg13_hv_pmos[delvto]
print @n.xbgr.xm45_u20.nsg13_hv_pmos[factuo]
print @n.xbgr.xm45_u21.nsg13_hv_pmos[w]
print @n.xbgr.xm45_u21.nsg13_hv_pmos[l]
print @n.xbgr.xm45_u21.nsg13_hv_pmos[delvto]
print @n.xbgr.xm45_u21.nsg13_hv_pmos[factuo]
print @n.xbgr.xm45_u22.nsg13_hv_pmos[w]
print @n.xbgr.xm45_u22.nsg13_hv_pmos[l]
print @n.xbgr.xm45_u22.nsg13_hv_pmos[delvto]
print @n.xbgr.xm45_u22.nsg13_hv_pmos[factuo]
print @n.xbgr.xm45_u23.nsg13_hv_pmos[w]
print @n.xbgr.xm45_u23.nsg13_hv_pmos[l]
print @n.xbgr.xm45_u23.nsg13_hv_pmos[delvto]
print @n.xbgr.xm45_u23.nsg13_hv_pmos[factuo]
print @n.xbgr.xm45_u24.nsg13_hv_pmos[w]
print @n.xbgr.xm45_u24.nsg13_hv_pmos[l]
print @n.xbgr.xm45_u24.nsg13_hv_pmos[delvto]
print @n.xbgr.xm45_u24.nsg13_hv_pmos[factuo]
print @n.xbgr.xm47_u2.nsg13_hv_pmos[w]
print @n.xbgr.xm47_u2.nsg13_hv_pmos[l]
print @n.xbgr.xm47_u2.nsg13_hv_pmos[delvto]
print @n.xbgr.xm47_u2.nsg13_hv_pmos[factuo]
print @n.xbgr.xm47_u3.nsg13_hv_pmos[w]
print @n.xbgr.xm47_u3.nsg13_hv_pmos[l]
print @n.xbgr.xm47_u3.nsg13_hv_pmos[delvto]
print @n.xbgr.xm47_u3.nsg13_hv_pmos[factuo]
print @n.xbgr.xm47_u4.nsg13_hv_pmos[w]
print @n.xbgr.xm47_u4.nsg13_hv_pmos[l]
print @n.xbgr.xm47_u4.nsg13_hv_pmos[delvto]
print @n.xbgr.xm47_u4.nsg13_hv_pmos[factuo]
print @n.xbgr.xm47_u5.nsg13_hv_pmos[w]
print @n.xbgr.xm47_u5.nsg13_hv_pmos[l]
print @n.xbgr.xm47_u5.nsg13_hv_pmos[delvto]
print @n.xbgr.xm47_u5.nsg13_hv_pmos[factuo]
print @n.xbgr.xm47_u6.nsg13_hv_pmos[w]
print @n.xbgr.xm47_u6.nsg13_hv_pmos[l]
print @n.xbgr.xm47_u6.nsg13_hv_pmos[delvto]
print @n.xbgr.xm47_u6.nsg13_hv_pmos[factuo]
print @n.xbgr.xm47_u7.nsg13_hv_pmos[w]
print @n.xbgr.xm47_u7.nsg13_hv_pmos[l]
print @n.xbgr.xm47_u7.nsg13_hv_pmos[delvto]
print @n.xbgr.xm47_u7.nsg13_hv_pmos[factuo]
print @n.xbgr.xm47_u8.nsg13_hv_pmos[w]
print @n.xbgr.xm47_u8.nsg13_hv_pmos[l]
print @n.xbgr.xm47_u8.nsg13_hv_pmos[delvto]
print @n.xbgr.xm47_u8.nsg13_hv_pmos[factuo]
print @n.xbgr.xm47_u9.nsg13_hv_pmos[w]
print @n.xbgr.xm47_u9.nsg13_hv_pmos[l]
print @n.xbgr.xm47_u9.nsg13_hv_pmos[delvto]
print @n.xbgr.xm47_u9.nsg13_hv_pmos[factuo]
print @n.xbgr.xm47_u10.nsg13_hv_pmos[w]
print @n.xbgr.xm47_u10.nsg13_hv_pmos[l]
print @n.xbgr.xm47_u10.nsg13_hv_pmos[delvto]
print @n.xbgr.xm47_u10.nsg13_hv_pmos[factuo]
print @n.xbgr.xm47_u11.nsg13_hv_pmos[w]
print @n.xbgr.xm47_u11.nsg13_hv_pmos[l]
print @n.xbgr.xm47_u11.nsg13_hv_pmos[delvto]
print @n.xbgr.xm47_u11.nsg13_hv_pmos[factuo]
print @n.xbgr.xm47_u12.nsg13_hv_pmos[w]
print @n.xbgr.xm47_u12.nsg13_hv_pmos[l]
print @n.xbgr.xm47_u12.nsg13_hv_pmos[delvto]
print @n.xbgr.xm47_u12.nsg13_hv_pmos[factuo]
print @n.xbgr.xm47_u13.nsg13_hv_pmos[w]
print @n.xbgr.xm47_u13.nsg13_hv_pmos[l]
print @n.xbgr.xm47_u13.nsg13_hv_pmos[delvto]
print @n.xbgr.xm47_u13.nsg13_hv_pmos[factuo]
print @n.xbgr.xm47_u14.nsg13_hv_pmos[w]
print @n.xbgr.xm47_u14.nsg13_hv_pmos[l]
print @n.xbgr.xm47_u14.nsg13_hv_pmos[delvto]
print @n.xbgr.xm47_u14.nsg13_hv_pmos[factuo]
print @n.xbgr.xm47_u15.nsg13_hv_pmos[w]
print @n.xbgr.xm47_u15.nsg13_hv_pmos[l]
print @n.xbgr.xm47_u15.nsg13_hv_pmos[delvto]
print @n.xbgr.xm47_u15.nsg13_hv_pmos[factuo]
print @n.xbgr.xm47_u16.nsg13_hv_pmos[w]
print @n.xbgr.xm47_u16.nsg13_hv_pmos[l]
print @n.xbgr.xm47_u16.nsg13_hv_pmos[delvto]
print @n.xbgr.xm47_u16.nsg13_hv_pmos[factuo]
print @n.xbgr.xm47_u17.nsg13_hv_pmos[w]
print @n.xbgr.xm47_u17.nsg13_hv_pmos[l]
print @n.xbgr.xm47_u17.nsg13_hv_pmos[delvto]
print @n.xbgr.xm47_u17.nsg13_hv_pmos[factuo]
print @n.xbgr.xm47_u18.nsg13_hv_pmos[w]
print @n.xbgr.xm47_u18.nsg13_hv_pmos[l]
print @n.xbgr.xm47_u18.nsg13_hv_pmos[delvto]
print @n.xbgr.xm47_u18.nsg13_hv_pmos[factuo]
print @n.xbgr.xm47_u19.nsg13_hv_pmos[w]
print @n.xbgr.xm47_u19.nsg13_hv_pmos[l]
print @n.xbgr.xm47_u19.nsg13_hv_pmos[delvto]
print @n.xbgr.xm47_u19.nsg13_hv_pmos[factuo]
print @n.xbgr.xm47_u20.nsg13_hv_pmos[w]
print @n.xbgr.xm47_u20.nsg13_hv_pmos[l]
print @n.xbgr.xm47_u20.nsg13_hv_pmos[delvto]
print @n.xbgr.xm47_u20.nsg13_hv_pmos[factuo]
print @n.xbgr.xm47_u21.nsg13_hv_pmos[w]
print @n.xbgr.xm47_u21.nsg13_hv_pmos[l]
print @n.xbgr.xm47_u21.nsg13_hv_pmos[delvto]
print @n.xbgr.xm47_u21.nsg13_hv_pmos[factuo]
print @n.xbgr.xm47_u22.nsg13_hv_pmos[w]
print @n.xbgr.xm47_u22.nsg13_hv_pmos[l]
print @n.xbgr.xm47_u22.nsg13_hv_pmos[delvto]
print @n.xbgr.xm47_u22.nsg13_hv_pmos[factuo]
print @n.xbgr.xm47_u23.nsg13_hv_pmos[w]
print @n.xbgr.xm47_u23.nsg13_hv_pmos[l]
print @n.xbgr.xm47_u23.nsg13_hv_pmos[delvto]
print @n.xbgr.xm47_u23.nsg13_hv_pmos[factuo]
print @n.xbgr.xm47_u24.nsg13_hv_pmos[w]
print @n.xbgr.xm47_u24.nsg13_hv_pmos[l]
print @n.xbgr.xm47_u24.nsg13_hv_pmos[delvto]
print @n.xbgr.xm47_u24.nsg13_hv_pmos[factuo]
print @n.xbgr.xm48_u2.nsg13_hv_pmos[w]
print @n.xbgr.xm48_u2.nsg13_hv_pmos[l]
print @n.xbgr.xm48_u2.nsg13_hv_pmos[delvto]
print @n.xbgr.xm48_u2.nsg13_hv_pmos[factuo]
print @n.xbgr.xm48_u3.nsg13_hv_pmos[w]
print @n.xbgr.xm48_u3.nsg13_hv_pmos[l]
print @n.xbgr.xm48_u3.nsg13_hv_pmos[delvto]
print @n.xbgr.xm48_u3.nsg13_hv_pmos[factuo]
print @n.xbgr.xm48_u4.nsg13_hv_pmos[w]
print @n.xbgr.xm48_u4.nsg13_hv_pmos[l]
print @n.xbgr.xm48_u4.nsg13_hv_pmos[delvto]
print @n.xbgr.xm48_u4.nsg13_hv_pmos[factuo]
print @n.xbgr.xm48_u5.nsg13_hv_pmos[w]
print @n.xbgr.xm48_u5.nsg13_hv_pmos[l]
print @n.xbgr.xm48_u5.nsg13_hv_pmos[delvto]
print @n.xbgr.xm48_u5.nsg13_hv_pmos[factuo]
print @n.xbgr.xm48_u6.nsg13_hv_pmos[w]
print @n.xbgr.xm48_u6.nsg13_hv_pmos[l]
print @n.xbgr.xm48_u6.nsg13_hv_pmos[delvto]
print @n.xbgr.xm48_u6.nsg13_hv_pmos[factuo]
print @n.xbgr.xm48_u7.nsg13_hv_pmos[w]
print @n.xbgr.xm48_u7.nsg13_hv_pmos[l]
print @n.xbgr.xm48_u7.nsg13_hv_pmos[delvto]
print @n.xbgr.xm48_u7.nsg13_hv_pmos[factuo]
print @n.xbgr.xm48_u8.nsg13_hv_pmos[w]
print @n.xbgr.xm48_u8.nsg13_hv_pmos[l]
print @n.xbgr.xm48_u8.nsg13_hv_pmos[delvto]
print @n.xbgr.xm48_u8.nsg13_hv_pmos[factuo]
print @n.xbgr.xm48_u9.nsg13_hv_pmos[w]
print @n.xbgr.xm48_u9.nsg13_hv_pmos[l]
print @n.xbgr.xm48_u9.nsg13_hv_pmos[delvto]
print @n.xbgr.xm48_u9.nsg13_hv_pmos[factuo]
print @n.xbgr.xm48_u10.nsg13_hv_pmos[w]
print @n.xbgr.xm48_u10.nsg13_hv_pmos[l]
print @n.xbgr.xm48_u10.nsg13_hv_pmos[delvto]
print @n.xbgr.xm48_u10.nsg13_hv_pmos[factuo]
print @n.xbgr.xm48_u11.nsg13_hv_pmos[w]
print @n.xbgr.xm48_u11.nsg13_hv_pmos[l]
print @n.xbgr.xm48_u11.nsg13_hv_pmos[delvto]
print @n.xbgr.xm48_u11.nsg13_hv_pmos[factuo]
print @n.xbgr.xm48_u12.nsg13_hv_pmos[w]
print @n.xbgr.xm48_u12.nsg13_hv_pmos[l]
print @n.xbgr.xm48_u12.nsg13_hv_pmos[delvto]
print @n.xbgr.xm48_u12.nsg13_hv_pmos[factuo]
print @n.xbgr.xm48_u13.nsg13_hv_pmos[w]
print @n.xbgr.xm48_u13.nsg13_hv_pmos[l]
print @n.xbgr.xm48_u13.nsg13_hv_pmos[delvto]
print @n.xbgr.xm48_u13.nsg13_hv_pmos[factuo]
print @n.xbgr.xm48_u14.nsg13_hv_pmos[w]
print @n.xbgr.xm48_u14.nsg13_hv_pmos[l]
print @n.xbgr.xm48_u14.nsg13_hv_pmos[delvto]
print @n.xbgr.xm48_u14.nsg13_hv_pmos[factuo]
print @n.xbgr.xm48_u15.nsg13_hv_pmos[w]
print @n.xbgr.xm48_u15.nsg13_hv_pmos[l]
print @n.xbgr.xm48_u15.nsg13_hv_pmos[delvto]
print @n.xbgr.xm48_u15.nsg13_hv_pmos[factuo]
print @n.xbgr.xm48_u16.nsg13_hv_pmos[w]
print @n.xbgr.xm48_u16.nsg13_hv_pmos[l]
print @n.xbgr.xm48_u16.nsg13_hv_pmos[delvto]
print @n.xbgr.xm48_u16.nsg13_hv_pmos[factuo]
print @n.xbgr.xm48_u17.nsg13_hv_pmos[w]
print @n.xbgr.xm48_u17.nsg13_hv_pmos[l]
print @n.xbgr.xm48_u17.nsg13_hv_pmos[delvto]
print @n.xbgr.xm48_u17.nsg13_hv_pmos[factuo]
print @n.xbgr.xm48_u18.nsg13_hv_pmos[w]
print @n.xbgr.xm48_u18.nsg13_hv_pmos[l]
print @n.xbgr.xm48_u18.nsg13_hv_pmos[delvto]
print @n.xbgr.xm48_u18.nsg13_hv_pmos[factuo]
print @n.xbgr.xm48_u19.nsg13_hv_pmos[w]
print @n.xbgr.xm48_u19.nsg13_hv_pmos[l]
print @n.xbgr.xm48_u19.nsg13_hv_pmos[delvto]
print @n.xbgr.xm48_u19.nsg13_hv_pmos[factuo]
print @n.xbgr.xm48_u20.nsg13_hv_pmos[w]
print @n.xbgr.xm48_u20.nsg13_hv_pmos[l]
print @n.xbgr.xm48_u20.nsg13_hv_pmos[delvto]
print @n.xbgr.xm48_u20.nsg13_hv_pmos[factuo]
print @n.xbgr.xm48_u21.nsg13_hv_pmos[w]
print @n.xbgr.xm48_u21.nsg13_hv_pmos[l]
print @n.xbgr.xm48_u21.nsg13_hv_pmos[delvto]
print @n.xbgr.xm48_u21.nsg13_hv_pmos[factuo]
print @n.xbgr.xm48_u22.nsg13_hv_pmos[w]
print @n.xbgr.xm48_u22.nsg13_hv_pmos[l]
print @n.xbgr.xm48_u22.nsg13_hv_pmos[delvto]
print @n.xbgr.xm48_u22.nsg13_hv_pmos[factuo]
print @n.xbgr.xm48_u23.nsg13_hv_pmos[w]
print @n.xbgr.xm48_u23.nsg13_hv_pmos[l]
print @n.xbgr.xm48_u23.nsg13_hv_pmos[delvto]
print @n.xbgr.xm48_u23.nsg13_hv_pmos[factuo]
print @n.xbgr.xm48_u24.nsg13_hv_pmos[w]
print @n.xbgr.xm48_u24.nsg13_hv_pmos[l]
print @n.xbgr.xm48_u24.nsg13_hv_pmos[delvto]
print @n.xbgr.xm48_u24.nsg13_hv_pmos[factuo]
print @n.xbgr.xm50_u2.nsg13_hv_pmos[w]
print @n.xbgr.xm50_u2.nsg13_hv_pmos[l]
print @n.xbgr.xm50_u2.nsg13_hv_pmos[delvto]
print @n.xbgr.xm50_u2.nsg13_hv_pmos[factuo]
print @n.xbgr.xm50_u3.nsg13_hv_pmos[w]
print @n.xbgr.xm50_u3.nsg13_hv_pmos[l]
print @n.xbgr.xm50_u3.nsg13_hv_pmos[delvto]
print @n.xbgr.xm50_u3.nsg13_hv_pmos[factuo]
print @n.xbgr.xm50_u4.nsg13_hv_pmos[w]
print @n.xbgr.xm50_u4.nsg13_hv_pmos[l]
print @n.xbgr.xm50_u4.nsg13_hv_pmos[delvto]
print @n.xbgr.xm50_u4.nsg13_hv_pmos[factuo]
print @n.xbgr.xm50_u5.nsg13_hv_pmos[w]
print @n.xbgr.xm50_u5.nsg13_hv_pmos[l]
print @n.xbgr.xm50_u5.nsg13_hv_pmos[delvto]
print @n.xbgr.xm50_u5.nsg13_hv_pmos[factuo]
print @n.xbgr.xm50_u6.nsg13_hv_pmos[w]
print @n.xbgr.xm50_u6.nsg13_hv_pmos[l]
print @n.xbgr.xm50_u6.nsg13_hv_pmos[delvto]
print @n.xbgr.xm50_u6.nsg13_hv_pmos[factuo]
print @n.xbgr.xm50_u7.nsg13_hv_pmos[w]
print @n.xbgr.xm50_u7.nsg13_hv_pmos[l]
print @n.xbgr.xm50_u7.nsg13_hv_pmos[delvto]
print @n.xbgr.xm50_u7.nsg13_hv_pmos[factuo]
print @n.xbgr.xm50_u8.nsg13_hv_pmos[w]
print @n.xbgr.xm50_u8.nsg13_hv_pmos[l]
print @n.xbgr.xm50_u8.nsg13_hv_pmos[delvto]
print @n.xbgr.xm50_u8.nsg13_hv_pmos[factuo]
print @n.xbgr.xm50_u9.nsg13_hv_pmos[w]
print @n.xbgr.xm50_u9.nsg13_hv_pmos[l]
print @n.xbgr.xm50_u9.nsg13_hv_pmos[delvto]
print @n.xbgr.xm50_u9.nsg13_hv_pmos[factuo]
print @n.xbgr.xm50_u10.nsg13_hv_pmos[w]
print @n.xbgr.xm50_u10.nsg13_hv_pmos[l]
print @n.xbgr.xm50_u10.nsg13_hv_pmos[delvto]
print @n.xbgr.xm50_u10.nsg13_hv_pmos[factuo]
print @n.xbgr.xm50_u11.nsg13_hv_pmos[w]
print @n.xbgr.xm50_u11.nsg13_hv_pmos[l]
print @n.xbgr.xm50_u11.nsg13_hv_pmos[delvto]
print @n.xbgr.xm50_u11.nsg13_hv_pmos[factuo]
print @n.xbgr.xm50_u12.nsg13_hv_pmos[w]
print @n.xbgr.xm50_u12.nsg13_hv_pmos[l]
print @n.xbgr.xm50_u12.nsg13_hv_pmos[delvto]
print @n.xbgr.xm50_u12.nsg13_hv_pmos[factuo]
print @n.xbgr.xm50_u13.nsg13_hv_pmos[w]
print @n.xbgr.xm50_u13.nsg13_hv_pmos[l]
print @n.xbgr.xm50_u13.nsg13_hv_pmos[delvto]
print @n.xbgr.xm50_u13.nsg13_hv_pmos[factuo]
print @n.xbgr.xm50_u14.nsg13_hv_pmos[w]
print @n.xbgr.xm50_u14.nsg13_hv_pmos[l]
print @n.xbgr.xm50_u14.nsg13_hv_pmos[delvto]
print @n.xbgr.xm50_u14.nsg13_hv_pmos[factuo]
print @n.xbgr.xm50_u15.nsg13_hv_pmos[w]
print @n.xbgr.xm50_u15.nsg13_hv_pmos[l]
print @n.xbgr.xm50_u15.nsg13_hv_pmos[delvto]
print @n.xbgr.xm50_u15.nsg13_hv_pmos[factuo]
print @n.xbgr.xm50_u16.nsg13_hv_pmos[w]
print @n.xbgr.xm50_u16.nsg13_hv_pmos[l]
print @n.xbgr.xm50_u16.nsg13_hv_pmos[delvto]
print @n.xbgr.xm50_u16.nsg13_hv_pmos[factuo]
print @n.xbgr.xm50_u17.nsg13_hv_pmos[w]
print @n.xbgr.xm50_u17.nsg13_hv_pmos[l]
print @n.xbgr.xm50_u17.nsg13_hv_pmos[delvto]
print @n.xbgr.xm50_u17.nsg13_hv_pmos[factuo]
print @n.xbgr.xm50_u18.nsg13_hv_pmos[w]
print @n.xbgr.xm50_u18.nsg13_hv_pmos[l]
print @n.xbgr.xm50_u18.nsg13_hv_pmos[delvto]
print @n.xbgr.xm50_u18.nsg13_hv_pmos[factuo]
print @n.xbgr.xm50_u19.nsg13_hv_pmos[w]
print @n.xbgr.xm50_u19.nsg13_hv_pmos[l]
print @n.xbgr.xm50_u19.nsg13_hv_pmos[delvto]
print @n.xbgr.xm50_u19.nsg13_hv_pmos[factuo]
print @n.xbgr.xm50_u20.nsg13_hv_pmos[w]
print @n.xbgr.xm50_u20.nsg13_hv_pmos[l]
print @n.xbgr.xm50_u20.nsg13_hv_pmos[delvto]
print @n.xbgr.xm50_u20.nsg13_hv_pmos[factuo]
print @n.xbgr.xm50_u21.nsg13_hv_pmos[w]
print @n.xbgr.xm50_u21.nsg13_hv_pmos[l]
print @n.xbgr.xm50_u21.nsg13_hv_pmos[delvto]
print @n.xbgr.xm50_u21.nsg13_hv_pmos[factuo]
print @n.xbgr.xm50_u22.nsg13_hv_pmos[w]
print @n.xbgr.xm50_u22.nsg13_hv_pmos[l]
print @n.xbgr.xm50_u22.nsg13_hv_pmos[delvto]
print @n.xbgr.xm50_u22.nsg13_hv_pmos[factuo]
print @n.xbgr.xm50_u23.nsg13_hv_pmos[w]
print @n.xbgr.xm50_u23.nsg13_hv_pmos[l]
print @n.xbgr.xm50_u23.nsg13_hv_pmos[delvto]
print @n.xbgr.xm50_u23.nsg13_hv_pmos[factuo]
print @n.xbgr.xm50_u24.nsg13_hv_pmos[w]
print @n.xbgr.xm50_u24.nsg13_hv_pmos[l]
print @n.xbgr.xm50_u24.nsg13_hv_pmos[delvto]
print @n.xbgr.xm50_u24.nsg13_hv_pmos[factuo]
print @n.xbgr.xm51_u2.nsg13_hv_pmos[w]
print @n.xbgr.xm51_u2.nsg13_hv_pmos[l]
print @n.xbgr.xm51_u2.nsg13_hv_pmos[delvto]
print @n.xbgr.xm51_u2.nsg13_hv_pmos[factuo]
print @n.xbgr.xm51_u3.nsg13_hv_pmos[w]
print @n.xbgr.xm51_u3.nsg13_hv_pmos[l]
print @n.xbgr.xm51_u3.nsg13_hv_pmos[delvto]
print @n.xbgr.xm51_u3.nsg13_hv_pmos[factuo]
print @n.xbgr.xm51_u4.nsg13_hv_pmos[w]
print @n.xbgr.xm51_u4.nsg13_hv_pmos[l]
print @n.xbgr.xm51_u4.nsg13_hv_pmos[delvto]
print @n.xbgr.xm51_u4.nsg13_hv_pmos[factuo]
print @n.xbgr.xm52_u2.nsg13_hv_pmos[w]
print @n.xbgr.xm52_u2.nsg13_hv_pmos[l]
print @n.xbgr.xm52_u2.nsg13_hv_pmos[delvto]
print @n.xbgr.xm52_u2.nsg13_hv_pmos[factuo]
print @n.xbgr.xm52_u3.nsg13_hv_pmos[w]
print @n.xbgr.xm52_u3.nsg13_hv_pmos[l]
print @n.xbgr.xm52_u3.nsg13_hv_pmos[delvto]
print @n.xbgr.xm52_u3.nsg13_hv_pmos[factuo]
print @n.xbgr.xm52_u4.nsg13_hv_pmos[w]
print @n.xbgr.xm52_u4.nsg13_hv_pmos[l]
print @n.xbgr.xm52_u4.nsg13_hv_pmos[delvto]
print @n.xbgr.xm52_u4.nsg13_hv_pmos[factuo]
print @n.xbgr.xm52_u5.nsg13_hv_pmos[w]
print @n.xbgr.xm52_u5.nsg13_hv_pmos[l]
print @n.xbgr.xm52_u5.nsg13_hv_pmos[delvto]
print @n.xbgr.xm52_u5.nsg13_hv_pmos[factuo]
print @n.xbgr.xm52_u6.nsg13_hv_pmos[w]
print @n.xbgr.xm52_u6.nsg13_hv_pmos[l]
print @n.xbgr.xm52_u6.nsg13_hv_pmos[delvto]
print @n.xbgr.xm52_u6.nsg13_hv_pmos[factuo]
print @n.xbgr.xm52_u7.nsg13_hv_pmos[w]
print @n.xbgr.xm52_u7.nsg13_hv_pmos[l]
print @n.xbgr.xm52_u7.nsg13_hv_pmos[delvto]
print @n.xbgr.xm52_u7.nsg13_hv_pmos[factuo]
print @n.xbgr.xm52_u8.nsg13_hv_pmos[w]
print @n.xbgr.xm52_u8.nsg13_hv_pmos[l]
print @n.xbgr.xm52_u8.nsg13_hv_pmos[delvto]
print @n.xbgr.xm52_u8.nsg13_hv_pmos[factuo]
print @n.xbgr.xm52_u9.nsg13_hv_pmos[w]
print @n.xbgr.xm52_u9.nsg13_hv_pmos[l]
print @n.xbgr.xm52_u9.nsg13_hv_pmos[delvto]
print @n.xbgr.xm52_u9.nsg13_hv_pmos[factuo]
print @n.xbgr.xm52_u10.nsg13_hv_pmos[w]
print @n.xbgr.xm52_u10.nsg13_hv_pmos[l]
print @n.xbgr.xm52_u10.nsg13_hv_pmos[delvto]
print @n.xbgr.xm52_u10.nsg13_hv_pmos[factuo]
print @n.xbgr.xm52_u11.nsg13_hv_pmos[w]
print @n.xbgr.xm52_u11.nsg13_hv_pmos[l]
print @n.xbgr.xm52_u11.nsg13_hv_pmos[delvto]
print @n.xbgr.xm52_u11.nsg13_hv_pmos[factuo]
print @n.xbgr.xm52_u12.nsg13_hv_pmos[w]
print @n.xbgr.xm52_u12.nsg13_hv_pmos[l]
print @n.xbgr.xm52_u12.nsg13_hv_pmos[delvto]
print @n.xbgr.xm52_u12.nsg13_hv_pmos[factuo]
print @n.xbgr.xm52_u13.nsg13_hv_pmos[w]
print @n.xbgr.xm52_u13.nsg13_hv_pmos[l]
print @n.xbgr.xm52_u13.nsg13_hv_pmos[delvto]
print @n.xbgr.xm52_u13.nsg13_hv_pmos[factuo]
print @n.xbgr.xm52_u14.nsg13_hv_pmos[w]
print @n.xbgr.xm52_u14.nsg13_hv_pmos[l]
print @n.xbgr.xm52_u14.nsg13_hv_pmos[delvto]
print @n.xbgr.xm52_u14.nsg13_hv_pmos[factuo]
print @n.xbgr.xm52_u15.nsg13_hv_pmos[w]
print @n.xbgr.xm52_u15.nsg13_hv_pmos[l]
print @n.xbgr.xm52_u15.nsg13_hv_pmos[delvto]
print @n.xbgr.xm52_u15.nsg13_hv_pmos[factuo]
print @n.xbgr.xm52_u16.nsg13_hv_pmos[w]
print @n.xbgr.xm52_u16.nsg13_hv_pmos[l]
print @n.xbgr.xm52_u16.nsg13_hv_pmos[delvto]
print @n.xbgr.xm52_u16.nsg13_hv_pmos[factuo]
print @n.xbgr.xm52_u17.nsg13_hv_pmos[w]
print @n.xbgr.xm52_u17.nsg13_hv_pmos[l]
print @n.xbgr.xm52_u17.nsg13_hv_pmos[delvto]
print @n.xbgr.xm52_u17.nsg13_hv_pmos[factuo]
print @n.xbgr.xm52_u18.nsg13_hv_pmos[w]
print @n.xbgr.xm52_u18.nsg13_hv_pmos[l]
print @n.xbgr.xm52_u18.nsg13_hv_pmos[delvto]
print @n.xbgr.xm52_u18.nsg13_hv_pmos[factuo]
print @n.xbgr.xm52_u19.nsg13_hv_pmos[w]
print @n.xbgr.xm52_u19.nsg13_hv_pmos[l]
print @n.xbgr.xm52_u19.nsg13_hv_pmos[delvto]
print @n.xbgr.xm52_u19.nsg13_hv_pmos[factuo]
print @n.xbgr.xm52_u20.nsg13_hv_pmos[w]
print @n.xbgr.xm52_u20.nsg13_hv_pmos[l]
print @n.xbgr.xm52_u20.nsg13_hv_pmos[delvto]
print @n.xbgr.xm52_u20.nsg13_hv_pmos[factuo]
print @n.xbgr.xm52_u21.nsg13_hv_pmos[w]
print @n.xbgr.xm52_u21.nsg13_hv_pmos[l]
print @n.xbgr.xm52_u21.nsg13_hv_pmos[delvto]
print @n.xbgr.xm52_u21.nsg13_hv_pmos[factuo]
print @n.xbgr.xm52_u22.nsg13_hv_pmos[w]
print @n.xbgr.xm52_u22.nsg13_hv_pmos[l]
print @n.xbgr.xm52_u22.nsg13_hv_pmos[delvto]
print @n.xbgr.xm52_u22.nsg13_hv_pmos[factuo]
print @n.xbgr.xm52_u23.nsg13_hv_pmos[w]
print @n.xbgr.xm52_u23.nsg13_hv_pmos[l]
print @n.xbgr.xm52_u23.nsg13_hv_pmos[delvto]
print @n.xbgr.xm52_u23.nsg13_hv_pmos[factuo]
print @n.xbgr.xm52_u24.nsg13_hv_pmos[w]
print @n.xbgr.xm52_u24.nsg13_hv_pmos[l]
print @n.xbgr.xm52_u24.nsg13_hv_pmos[delvto]
print @n.xbgr.xm52_u24.nsg13_hv_pmos[factuo]
print @n.xbgr.xm54_u2.nsg13_hv_pmos[w]
print @n.xbgr.xm54_u2.nsg13_hv_pmos[l]
print @n.xbgr.xm54_u2.nsg13_hv_pmos[delvto]
print @n.xbgr.xm54_u2.nsg13_hv_pmos[factuo]
print @n.xbgr.xm54_u3.nsg13_hv_pmos[w]
print @n.xbgr.xm54_u3.nsg13_hv_pmos[l]
print @n.xbgr.xm54_u3.nsg13_hv_pmos[delvto]
print @n.xbgr.xm54_u3.nsg13_hv_pmos[factuo]
print @n.xbgr.xm54_u4.nsg13_hv_pmos[w]
print @n.xbgr.xm54_u4.nsg13_hv_pmos[l]
print @n.xbgr.xm54_u4.nsg13_hv_pmos[delvto]
print @n.xbgr.xm54_u4.nsg13_hv_pmos[factuo]
print @n.xbgr.xm54_u5.nsg13_hv_pmos[w]
print @n.xbgr.xm54_u5.nsg13_hv_pmos[l]
print @n.xbgr.xm54_u5.nsg13_hv_pmos[delvto]
print @n.xbgr.xm54_u5.nsg13_hv_pmos[factuo]
print @n.xbgr.xm54_u6.nsg13_hv_pmos[w]
print @n.xbgr.xm54_u6.nsg13_hv_pmos[l]
print @n.xbgr.xm54_u6.nsg13_hv_pmos[delvto]
print @n.xbgr.xm54_u6.nsg13_hv_pmos[factuo]
print @n.xbgr.xm54_u7.nsg13_hv_pmos[w]
print @n.xbgr.xm54_u7.nsg13_hv_pmos[l]
print @n.xbgr.xm54_u7.nsg13_hv_pmos[delvto]
print @n.xbgr.xm54_u7.nsg13_hv_pmos[factuo]
print @n.xbgr.xm54_u8.nsg13_hv_pmos[w]
print @n.xbgr.xm54_u8.nsg13_hv_pmos[l]
print @n.xbgr.xm54_u8.nsg13_hv_pmos[delvto]
print @n.xbgr.xm54_u8.nsg13_hv_pmos[factuo]
print @n.xbgr.xm54_u9.nsg13_hv_pmos[w]
print @n.xbgr.xm54_u9.nsg13_hv_pmos[l]
print @n.xbgr.xm54_u9.nsg13_hv_pmos[delvto]
print @n.xbgr.xm54_u9.nsg13_hv_pmos[factuo]
print @n.xbgr.xm54_u10.nsg13_hv_pmos[w]
print @n.xbgr.xm54_u10.nsg13_hv_pmos[l]
print @n.xbgr.xm54_u10.nsg13_hv_pmos[delvto]
print @n.xbgr.xm54_u10.nsg13_hv_pmos[factuo]
print @n.xbgr.xm54_u11.nsg13_hv_pmos[w]
print @n.xbgr.xm54_u11.nsg13_hv_pmos[l]
print @n.xbgr.xm54_u11.nsg13_hv_pmos[delvto]
print @n.xbgr.xm54_u11.nsg13_hv_pmos[factuo]
print @n.xbgr.xm54_u12.nsg13_hv_pmos[w]
print @n.xbgr.xm54_u12.nsg13_hv_pmos[l]
print @n.xbgr.xm54_u12.nsg13_hv_pmos[delvto]
print @n.xbgr.xm54_u12.nsg13_hv_pmos[factuo]
print @n.xbgr.xm54_u13.nsg13_hv_pmos[w]
print @n.xbgr.xm54_u13.nsg13_hv_pmos[l]
print @n.xbgr.xm54_u13.nsg13_hv_pmos[delvto]
print @n.xbgr.xm54_u13.nsg13_hv_pmos[factuo]
print @n.xbgr.xm54_u14.nsg13_hv_pmos[w]
print @n.xbgr.xm54_u14.nsg13_hv_pmos[l]
print @n.xbgr.xm54_u14.nsg13_hv_pmos[delvto]
print @n.xbgr.xm54_u14.nsg13_hv_pmos[factuo]
print @n.xbgr.xm54_u15.nsg13_hv_pmos[w]
print @n.xbgr.xm54_u15.nsg13_hv_pmos[l]
print @n.xbgr.xm54_u15.nsg13_hv_pmos[delvto]
print @n.xbgr.xm54_u15.nsg13_hv_pmos[factuo]
print @n.xbgr.xm54_u16.nsg13_hv_pmos[w]
print @n.xbgr.xm54_u16.nsg13_hv_pmos[l]
print @n.xbgr.xm54_u16.nsg13_hv_pmos[delvto]
print @n.xbgr.xm54_u16.nsg13_hv_pmos[factuo]
print @n.xbgr.xm54_u17.nsg13_hv_pmos[w]
print @n.xbgr.xm54_u17.nsg13_hv_pmos[l]
print @n.xbgr.xm54_u17.nsg13_hv_pmos[delvto]
print @n.xbgr.xm54_u17.nsg13_hv_pmos[factuo]
print @n.xbgr.xm54_u18.nsg13_hv_pmos[w]
print @n.xbgr.xm54_u18.nsg13_hv_pmos[l]
print @n.xbgr.xm54_u18.nsg13_hv_pmos[delvto]
print @n.xbgr.xm54_u18.nsg13_hv_pmos[factuo]
print @n.xbgr.xm54_u19.nsg13_hv_pmos[w]
print @n.xbgr.xm54_u19.nsg13_hv_pmos[l]
print @n.xbgr.xm54_u19.nsg13_hv_pmos[delvto]
print @n.xbgr.xm54_u19.nsg13_hv_pmos[factuo]
print @n.xbgr.xm54_u20.nsg13_hv_pmos[w]
print @n.xbgr.xm54_u20.nsg13_hv_pmos[l]
print @n.xbgr.xm54_u20.nsg13_hv_pmos[delvto]
print @n.xbgr.xm54_u20.nsg13_hv_pmos[factuo]
print @n.xbgr.xm54_u21.nsg13_hv_pmos[w]
print @n.xbgr.xm54_u21.nsg13_hv_pmos[l]
print @n.xbgr.xm54_u21.nsg13_hv_pmos[delvto]
print @n.xbgr.xm54_u21.nsg13_hv_pmos[factuo]
print @n.xbgr.xm54_u22.nsg13_hv_pmos[w]
print @n.xbgr.xm54_u22.nsg13_hv_pmos[l]
print @n.xbgr.xm54_u22.nsg13_hv_pmos[delvto]
print @n.xbgr.xm54_u22.nsg13_hv_pmos[factuo]
print @n.xbgr.xm54_u23.nsg13_hv_pmos[w]
print @n.xbgr.xm54_u23.nsg13_hv_pmos[l]
print @n.xbgr.xm54_u23.nsg13_hv_pmos[delvto]
print @n.xbgr.xm54_u23.nsg13_hv_pmos[factuo]
print @n.xbgr.xm54_u24.nsg13_hv_pmos[w]
print @n.xbgr.xm54_u24.nsg13_hv_pmos[l]
print @n.xbgr.xm54_u24.nsg13_hv_pmos[delvto]
print @n.xbgr.xm54_u24.nsg13_hv_pmos[factuo]
print @q.xbgr.xq56_u2.qnpn13g2[area]
print @q.xbgr.xq56_u3.qnpn13g2[area]
print @q.xbgr.xq56_u4.qnpn13g2[area]
print @q.xbgr.xq56_u5.qnpn13g2[area]
print @q.xbgr.xq56_u6.qnpn13g2[area]
print @q.xbgr.xq56_u7.qnpn13g2[area]
print @q.xbgr.xq56_u8.qnpn13g2[area]
print @q.xbgr.xq56_u9.qnpn13g2[area]
print @q.xbgr.xq56_u10.qnpn13g2[area]
print @q.xbgr.xq56_u11.qnpn13g2[area]
print @q.xbgr.xq56_u12.qnpn13g2[area]
print @q.xbgr.xq56_u13.qnpn13g2[area]
print @q.xbgr.xq56_u14.qnpn13g2[area]
print @q.xbgr.xq56_u15.qnpn13g2[area]
print @q.xbgr.xq56_u16.qnpn13g2[area]
print @q.xbgr.xq56_u17.qnpn13g2[area]
print @q.xbgr.xq56_u18.qnpn13g2[area]
print @q.xbgr.xq56_u19.qnpn13g2[area]
print @q.xbgr.xq56_u20.qnpn13g2[area]
print @q.xbgr.xq56_u21.qnpn13g2[area]
print @q.xbgr.xq56_u22.qnpn13g2[area]
print @q.xbgr.xq56_u23.qnpn13g2[area]
print @q.xbgr.xq56_u24.qnpn13g2[area]
print @q.xbgr.xq60_u2.qnpn13g2[area]
print @q.xbgr.xq60_u3.qnpn13g2[area]
print @q.xbgr.xq60_u4.qnpn13g2[area]
print @q.xbgr.xq62_u2.qnpn13g2[area]
print @q.xbgr.xq62_u3.qnpn13g2[area]
print @q.xbgr.xq62_u4.qnpn13g2[area]
print @q.xbgr.xq62_u5.qnpn13g2[area]
print @q.xbgr.xq62_u6.qnpn13g2[area]
print @q.xbgr.xq62_u7.qnpn13g2[area]
print @q.xbgr.xq62_u8.qnpn13g2[area]
print @q.xbgr.xq62_u9.qnpn13g2[area]
print @q.xbgr.xq62_u10.qnpn13g2[area]
print @q.xbgr.xq62_u11.qnpn13g2[area]
print @q.xbgr.xq62_u12.qnpn13g2[area]
print @q.xbgr.xq62_u13.qnpn13g2[area]
print @q.xbgr.xq62_u14.qnpn13g2[area]
print @q.xbgr.xq62_u15.qnpn13g2[area]
print @q.xbgr.xq62_u16.qnpn13g2[area]
print @q.xbgr.xq62_u17.qnpn13g2[area]
print @q.xbgr.xq62_u18.qnpn13g2[area]
print @q.xbgr.xq62_u19.qnpn13g2[area]
print @q.xbgr.xq62_u20.qnpn13g2[area]
print @q.xbgr.xq62_u21.qnpn13g2[area]
print @q.xbgr.xq62_u22.qnpn13g2[area]
print @q.xbgr.xq62_u23.qnpn13g2[area]
print @q.xbgr.xq62_u24.qnpn13g2[area]
print @q.xbgr.xq67_u2.qnpn13g2[area]
print @q.xbgr.xq67_u3.qnpn13g2[area]
print @q.xbgr.xq67_u4.qnpn13g2[area]
print @q.xbgr.xq67_u5.qnpn13g2[area]
print @q.xbgr.xq67_u6.qnpn13g2[area]
print @q.xbgr.xq67_u7.qnpn13g2[area]
print @q.xbgr.xq67_u8.qnpn13g2[area]
print @q.xbgr.xq67_u9.qnpn13g2[area]
print @q.xbgr.xq67_u10.qnpn13g2[area]
print @q.xbgr.xq67_u11.qnpn13g2[area]
print @q.xbgr.xq67_u12.qnpn13g2[area]
print @q.xbgr.xq67_u13.qnpn13g2[area]
print @q.xbgr.xq67_u14.qnpn13g2[area]
print @q.xbgr.xq67_u15.qnpn13g2[area]
print @q.xbgr.xq67_u16.qnpn13g2[area]
print @q.xbgr.xq67_u17.qnpn13g2[area]
print @q.xbgr.xq67_u18.qnpn13g2[area]
print @q.xbgr.xq67_u19.qnpn13g2[area]
print @q.xbgr.xq67_u20.qnpn13g2[area]
print @q.xbgr.xq67_u21.qnpn13g2[area]
print @q.xbgr.xq67_u22.qnpn13g2[area]
print @q.xbgr.xq67_u23.qnpn13g2[area]
print @q.xbgr.xq67_u24.qnpn13g2[area]
print @q.xbgr.xq68_u2.qnpn13g2[area]
print @q.xbgr.xq68_u3.qnpn13g2[area]
print @q.xbgr.xq68_u4.qnpn13g2[area]
print @q.xbgr.xq68_u5.qnpn13g2[area]
print @q.xbgr.xq68_u6.qnpn13g2[area]
print @q.xbgr.xq68_u7.qnpn13g2[area]
print @q.xbgr.xq68_u8.qnpn13g2[area]
print @q.xbgr.xq68_u9.qnpn13g2[area]
print @q.xbgr.xq68_u10.qnpn13g2[area]
print @q.xbgr.xq68_u11.qnpn13g2[area]
print @q.xbgr.xq68_u12.qnpn13g2[area]
print @q.xbgr.xq68_u13.qnpn13g2[area]
print @q.xbgr.xq68_u14.qnpn13g2[area]
print @q.xbgr.xq68_u15.qnpn13g2[area]
print @q.xbgr.xq68_u16.qnpn13g2[area]
print @q.xbgr.xq68_u17.qnpn13g2[area]
print @q.xbgr.xq68_u18.qnpn13g2[area]
print @q.xbgr.xq68_u19.qnpn13g2[area]
print @q.xbgr.xq68_u20.qnpn13g2[area]
print @q.xbgr.xq68_u21.qnpn13g2[area]
print @q.xbgr.xq68_u22.qnpn13g2[area]
print @q.xbgr.xq68_u23.qnpn13g2[area]
print @q.xbgr.xq68_u24.qnpn13g2[area]
print @q.xbgr.xq69_u2.qnpn13g2[area]
print @q.xbgr.xq69_u3.qnpn13g2[area]
print @q.xbgr.xq69_u4.qnpn13g2[area]
print @q.xbgr.xq69_u5.qnpn13g2[area]
print @q.xbgr.xq69_u6.qnpn13g2[area]
print @q.xbgr.xq69_u7.qnpn13g2[area]
print @q.xbgr.xq69_u8.qnpn13g2[area]
print @q.xbgr.xq69_u9.qnpn13g2[area]
print @q.xbgr.xq69_u10.qnpn13g2[area]
print @q.xbgr.xq69_u11.qnpn13g2[area]
print @q.xbgr.xq69_u12.qnpn13g2[area]
print @q.xbgr.xq69_u13.qnpn13g2[area]
print @q.xbgr.xq69_u14.qnpn13g2[area]
print @q.xbgr.xq69_u15.qnpn13g2[area]
print @q.xbgr.xq69_u16.qnpn13g2[area]
print @q.xbgr.xq69_u17.qnpn13g2[area]
print @q.xbgr.xq69_u18.qnpn13g2[area]
print @q.xbgr.xq69_u19.qnpn13g2[area]
print @q.xbgr.xq69_u20.qnpn13g2[area]
print @q.xbgr.xq69_u21.qnpn13g2[area]
print @q.xbgr.xq69_u22.qnpn13g2[area]
print @q.xbgr.xq69_u23.qnpn13g2[area]
print @q.xbgr.xq69_u24.qnpn13g2[area]
print @q.xbgr.xq70_u2.qnpn13g2[area]
print @q.xbgr.xq70_u3.qnpn13g2[area]
print @q.xbgr.xq70_u4.qnpn13g2[area]
print @q.xbgr.xq70_u5.qnpn13g2[area]
print @q.xbgr.xq70_u6.qnpn13g2[area]
print @q.xbgr.xq70_u7.qnpn13g2[area]
print @q.xbgr.xq70_u8.qnpn13g2[area]
print @q.xbgr.xq70_u9.qnpn13g2[area]
print @q.xbgr.xq70_u10.qnpn13g2[area]
print @q.xbgr.xq70_u11.qnpn13g2[area]
print @q.xbgr.xq70_u12.qnpn13g2[area]
print @q.xbgr.xq70_u13.qnpn13g2[area]
print @q.xbgr.xq70_u14.qnpn13g2[area]
print @q.xbgr.xq70_u15.qnpn13g2[area]
print @q.xbgr.xq70_u16.qnpn13g2[area]
print @q.xbgr.xq70_u17.qnpn13g2[area]
print @q.xbgr.xq70_u18.qnpn13g2[area]
print @q.xbgr.xq70_u19.qnpn13g2[area]
print @q.xbgr.xq70_u20.qnpn13g2[area]
print @q.xbgr.xq70_u21.qnpn13g2[area]
print @q.xbgr.xq70_u22.qnpn13g2[area]
print @q.xbgr.xq70_u23.qnpn13g2[area]
print @q.xbgr.xq70_u24.qnpn13g2[area]
print @q.xbgr.xq71_u2.qnpn13g2[area]
print @q.xbgr.xq71_u3.qnpn13g2[area]
print @q.xbgr.xq71_u4.qnpn13g2[area]
print @q.xbgr.xq71_u5.qnpn13g2[area]
print @q.xbgr.xq71_u6.qnpn13g2[area]
print @q.xbgr.xq71_u7.qnpn13g2[area]
print @q.xbgr.xq71_u8.qnpn13g2[area]
print @q.xbgr.xq71_u9.qnpn13g2[area]
print @q.xbgr.xq71_u10.qnpn13g2[area]
print @q.xbgr.xq71_u11.qnpn13g2[area]
print @q.xbgr.xq71_u12.qnpn13g2[area]
print @q.xbgr.xq71_u13.qnpn13g2[area]
print @q.xbgr.xq71_u14.qnpn13g2[area]
print @q.xbgr.xq71_u15.qnpn13g2[area]
print @q.xbgr.xq71_u16.qnpn13g2[area]
print @q.xbgr.xq71_u17.qnpn13g2[area]
print @q.xbgr.xq71_u18.qnpn13g2[area]
print @q.xbgr.xq71_u19.qnpn13g2[area]
print @q.xbgr.xq71_u20.qnpn13g2[area]
print @q.xbgr.xq71_u21.qnpn13g2[area]
print @q.xbgr.xq71_u22.qnpn13g2[area]
print @q.xbgr.xq71_u23.qnpn13g2[area]
print @q.xbgr.xq71_u24.qnpn13g2[area]
print @q.xbgr.xq72_u2.qnpn13g2[area]
print @q.xbgr.xq72_u3.qnpn13g2[area]
print @q.xbgr.xq72_u4.qnpn13g2[area]
print @q.xbgr.xq72_u5.qnpn13g2[area]
print @q.xbgr.xq72_u6.qnpn13g2[area]
print @q.xbgr.xq72_u7.qnpn13g2[area]
print @q.xbgr.xq72_u8.qnpn13g2[area]
print @q.xbgr.xq72_u9.qnpn13g2[area]
print @q.xbgr.xq72_u10.qnpn13g2[area]
print @q.xbgr.xq72_u11.qnpn13g2[area]
print @q.xbgr.xq72_u12.qnpn13g2[area]
print @q.xbgr.xq72_u13.qnpn13g2[area]
print @q.xbgr.xq72_u14.qnpn13g2[area]
print @q.xbgr.xq72_u15.qnpn13g2[area]
print @q.xbgr.xq72_u16.qnpn13g2[area]
print @q.xbgr.xq72_u17.qnpn13g2[area]
print @q.xbgr.xq72_u18.qnpn13g2[area]
print @q.xbgr.xq72_u19.qnpn13g2[area]
print @q.xbgr.xq72_u20.qnpn13g2[area]
print @q.xbgr.xq72_u21.qnpn13g2[area]
print @q.xbgr.xq72_u22.qnpn13g2[area]
print @q.xbgr.xq72_u23.qnpn13g2[area]
print @q.xbgr.xq72_u24.qnpn13g2[area]
print @q.xbgr.xq73_u2.qnpn13g2[area]
print @q.xbgr.xq73_u3.qnpn13g2[area]
print @q.xbgr.xq73_u4.qnpn13g2[area]
print @q.xbgr.xq73_u5.qnpn13g2[area]
print @q.xbgr.xq73_u6.qnpn13g2[area]
print @q.xbgr.xq73_u7.qnpn13g2[area]
print @q.xbgr.xq73_u8.qnpn13g2[area]
print @q.xbgr.xq73_u9.qnpn13g2[area]
print @q.xbgr.xq73_u10.qnpn13g2[area]
print @q.xbgr.xq73_u11.qnpn13g2[area]
print @q.xbgr.xq73_u12.qnpn13g2[area]
print @q.xbgr.xq73_u13.qnpn13g2[area]
print @q.xbgr.xq73_u14.qnpn13g2[area]
print @q.xbgr.xq73_u15.qnpn13g2[area]
print @q.xbgr.xq73_u16.qnpn13g2[area]
print @q.xbgr.xq73_u17.qnpn13g2[area]
print @q.xbgr.xq73_u18.qnpn13g2[area]
print @q.xbgr.xq73_u19.qnpn13g2[area]
print @q.xbgr.xq73_u20.qnpn13g2[area]
print @q.xbgr.xq73_u21.qnpn13g2[area]
print @q.xbgr.xq73_u22.qnpn13g2[area]
print @q.xbgr.xq73_u23.qnpn13g2[area]
print @q.xbgr.xq73_u24.qnpn13g2[area]
print @q.xbgr.xq74_u2.qnpn13g2[area]
print @q.xbgr.xq74_u3.qnpn13g2[area]
print @q.xbgr.xq74_u4.qnpn13g2[area]
print @q.xbgr.xq74_u5.qnpn13g2[area]
print @q.xbgr.xq74_u6.qnpn13g2[area]
print @q.xbgr.xq74_u7.qnpn13g2[area]
print @q.xbgr.xq74_u8.qnpn13g2[area]
print @q.xbgr.xq74_u9.qnpn13g2[area]
print @q.xbgr.xq74_u10.qnpn13g2[area]
print @q.xbgr.xq74_u11.qnpn13g2[area]
print @q.xbgr.xq74_u12.qnpn13g2[area]
print @q.xbgr.xq74_u13.qnpn13g2[area]
print @q.xbgr.xq74_u14.qnpn13g2[area]
print @q.xbgr.xq74_u15.qnpn13g2[area]
print @q.xbgr.xq74_u16.qnpn13g2[area]
print @q.xbgr.xq74_u17.qnpn13g2[area]
print @q.xbgr.xq74_u18.qnpn13g2[area]
print @q.xbgr.xq74_u19.qnpn13g2[area]
print @q.xbgr.xq74_u20.qnpn13g2[area]
print @q.xbgr.xq74_u21.qnpn13g2[area]
print @q.xbgr.xq74_u22.qnpn13g2[area]
print @q.xbgr.xq74_u23.qnpn13g2[area]
print @q.xbgr.xq74_u24.qnpn13g2[area]
print @q.xbgr.xq75_u2.qnpn13g2[area]
print @q.xbgr.xq75_u3.qnpn13g2[area]
print @q.xbgr.xq75_u4.qnpn13g2[area]
print @q.xbgr.xq75_u5.qnpn13g2[area]
print @q.xbgr.xq75_u6.qnpn13g2[area]
print @q.xbgr.xq75_u7.qnpn13g2[area]
print @q.xbgr.xq75_u8.qnpn13g2[area]
print @q.xbgr.xq75_u9.qnpn13g2[area]
print @q.xbgr.xq75_u10.qnpn13g2[area]
print @q.xbgr.xq75_u11.qnpn13g2[area]
print @q.xbgr.xq75_u12.qnpn13g2[area]
print @q.xbgr.xq75_u13.qnpn13g2[area]
print @q.xbgr.xq75_u14.qnpn13g2[area]
print @q.xbgr.xq75_u15.qnpn13g2[area]
print @q.xbgr.xq75_u16.qnpn13g2[area]
print @q.xbgr.xq75_u17.qnpn13g2[area]
print @q.xbgr.xq75_u18.qnpn13g2[area]
print @q.xbgr.xq75_u19.qnpn13g2[area]
print @q.xbgr.xq75_u20.qnpn13g2[area]
print @q.xbgr.xq75_u21.qnpn13g2[area]
print @q.xbgr.xq75_u22.qnpn13g2[area]
print @q.xbgr.xq75_u23.qnpn13g2[area]
print @q.xbgr.xq75_u24.qnpn13g2[area]
print @q.xbgr.xq76_u2.qnpn13g2[area]
print @q.xbgr.xq76_u3.qnpn13g2[area]
print @q.xbgr.xq76_u4.qnpn13g2[area]
print @q.xbgr.xq76_u5.qnpn13g2[area]
print @q.xbgr.xq76_u6.qnpn13g2[area]
print @q.xbgr.xq76_u7.qnpn13g2[area]
print @q.xbgr.xq76_u8.qnpn13g2[area]
print @q.xbgr.xq76_u9.qnpn13g2[area]
print @q.xbgr.xq76_u10.qnpn13g2[area]
print @q.xbgr.xq76_u11.qnpn13g2[area]
print @q.xbgr.xq76_u12.qnpn13g2[area]
print @q.xbgr.xq76_u13.qnpn13g2[area]
print @q.xbgr.xq76_u14.qnpn13g2[area]
print @q.xbgr.xq76_u15.qnpn13g2[area]
print @q.xbgr.xq76_u16.qnpn13g2[area]
print @q.xbgr.xq76_u17.qnpn13g2[area]
print @q.xbgr.xq76_u18.qnpn13g2[area]
print @q.xbgr.xq76_u19.qnpn13g2[area]
print @q.xbgr.xq76_u20.qnpn13g2[area]
print @q.xbgr.xq76_u21.qnpn13g2[area]
print @q.xbgr.xq76_u22.qnpn13g2[area]
print @q.xbgr.xq76_u23.qnpn13g2[area]
print @q.xbgr.xq76_u24.qnpn13g2[area]
print @n.xbgr.xr77_u2.nr1[nsmm_rsh]
print @n.xbgr.xr77_u2.nr1[nsmm_w]
print @n.xbgr.xr77_u2.nr1[nsmm_l]
print @n.xbgr.xr77_u3.nr1[nsmm_rsh]
print @n.xbgr.xr77_u3.nr1[nsmm_w]
print @n.xbgr.xr77_u3.nr1[nsmm_l]
print @n.xbgr.xr77_u4.nr1[nsmm_rsh]
print @n.xbgr.xr77_u4.nr1[nsmm_w]
print @n.xbgr.xr77_u4.nr1[nsmm_l]
print @n.xbgr.xr77_u5.nr1[nsmm_rsh]
print @n.xbgr.xr77_u5.nr1[nsmm_w]
print @n.xbgr.xr77_u5.nr1[nsmm_l]
print @n.xbgr.xr77_u6.nr1[nsmm_rsh]
print @n.xbgr.xr77_u6.nr1[nsmm_w]
print @n.xbgr.xr77_u6.nr1[nsmm_l]
print @n.xbgr.xr77_u7.nr1[nsmm_rsh]
print @n.xbgr.xr77_u7.nr1[nsmm_w]
print @n.xbgr.xr77_u7.nr1[nsmm_l]
print @n.xbgr.xr77_u8.nr1[nsmm_rsh]
print @n.xbgr.xr77_u8.nr1[nsmm_w]
print @n.xbgr.xr77_u8.nr1[nsmm_l]
print @n.xbgr.xr77_u9.nr1[nsmm_rsh]
print @n.xbgr.xr77_u9.nr1[nsmm_w]
print @n.xbgr.xr77_u9.nr1[nsmm_l]
print @n.xbgr.xr77_u10.nr1[nsmm_rsh]
print @n.xbgr.xr77_u10.nr1[nsmm_w]
print @n.xbgr.xr77_u10.nr1[nsmm_l]
print @n.xbgr.xr77_u11.nr1[nsmm_rsh]
print @n.xbgr.xr77_u11.nr1[nsmm_w]
print @n.xbgr.xr77_u11.nr1[nsmm_l]
print @n.xbgr.xr77_u12.nr1[nsmm_rsh]
print @n.xbgr.xr77_u12.nr1[nsmm_w]
print @n.xbgr.xr77_u12.nr1[nsmm_l]
print @n.xbgr.xr77_u13.nr1[nsmm_rsh]
print @n.xbgr.xr77_u13.nr1[nsmm_w]
print @n.xbgr.xr77_u13.nr1[nsmm_l]
print @n.xbgr.xr77_u14.nr1[nsmm_rsh]
print @n.xbgr.xr77_u14.nr1[nsmm_w]
print @n.xbgr.xr77_u14.nr1[nsmm_l]
print @n.xbgr.xr77_u15.nr1[nsmm_rsh]
print @n.xbgr.xr77_u15.nr1[nsmm_w]
print @n.xbgr.xr77_u15.nr1[nsmm_l]
print @n.xbgr.xr77_u16.nr1[nsmm_rsh]
print @n.xbgr.xr77_u16.nr1[nsmm_w]
print @n.xbgr.xr77_u16.nr1[nsmm_l]
print @n.xbgr.xr77_u17.nr1[nsmm_rsh]
print @n.xbgr.xr77_u17.nr1[nsmm_w]
print @n.xbgr.xr77_u17.nr1[nsmm_l]
print @n.xbgr.xr77_u18.nr1[nsmm_rsh]
print @n.xbgr.xr77_u18.nr1[nsmm_w]
print @n.xbgr.xr77_u18.nr1[nsmm_l]
print @n.xbgr.xr77_u19.nr1[nsmm_rsh]
print @n.xbgr.xr77_u19.nr1[nsmm_w]
print @n.xbgr.xr77_u19.nr1[nsmm_l]
print @n.xbgr.xr77_u20.nr1[nsmm_rsh]
print @n.xbgr.xr77_u20.nr1[nsmm_w]
print @n.xbgr.xr77_u20.nr1[nsmm_l]
print @n.xbgr.xr77_u21.nr1[nsmm_rsh]
print @n.xbgr.xr77_u21.nr1[nsmm_w]
print @n.xbgr.xr77_u21.nr1[nsmm_l]
print @n.xbgr.xr77_u22.nr1[nsmm_rsh]
print @n.xbgr.xr77_u22.nr1[nsmm_w]
print @n.xbgr.xr77_u22.nr1[nsmm_l]
print @n.xbgr.xr77_u23.nr1[nsmm_rsh]
print @n.xbgr.xr77_u23.nr1[nsmm_w]
print @n.xbgr.xr77_u23.nr1[nsmm_l]
print @n.xbgr.xr77_u24.nr1[nsmm_rsh]
print @n.xbgr.xr77_u24.nr1[nsmm_w]
print @n.xbgr.xr77_u24.nr1[nsmm_l]
print @n.xbgr.xr78_u2.nr1[nsmm_rsh]
print @n.xbgr.xr78_u2.nr1[nsmm_w]
print @n.xbgr.xr78_u2.nr1[nsmm_l]
print @n.xbgr.xr78_u3.nr1[nsmm_rsh]
print @n.xbgr.xr78_u3.nr1[nsmm_w]
print @n.xbgr.xr78_u3.nr1[nsmm_l]
print @n.xbgr.xr78_u4.nr1[nsmm_rsh]
print @n.xbgr.xr78_u4.nr1[nsmm_w]
print @n.xbgr.xr78_u4.nr1[nsmm_l]
print @n.xbgr.xr78_u5.nr1[nsmm_rsh]
print @n.xbgr.xr78_u5.nr1[nsmm_w]
print @n.xbgr.xr78_u5.nr1[nsmm_l]
print @n.xbgr.xr78_u6.nr1[nsmm_rsh]
print @n.xbgr.xr78_u6.nr1[nsmm_w]
print @n.xbgr.xr78_u6.nr1[nsmm_l]
print @n.xbgr.xr78_u7.nr1[nsmm_rsh]
print @n.xbgr.xr78_u7.nr1[nsmm_w]
print @n.xbgr.xr78_u7.nr1[nsmm_l]
print @n.xbgr.xr78_u8.nr1[nsmm_rsh]
print @n.xbgr.xr78_u8.nr1[nsmm_w]
print @n.xbgr.xr78_u8.nr1[nsmm_l]
print @n.xbgr.xr78_u9.nr1[nsmm_rsh]
print @n.xbgr.xr78_u9.nr1[nsmm_w]
print @n.xbgr.xr78_u9.nr1[nsmm_l]
print @n.xbgr.xr78_u10.nr1[nsmm_rsh]
print @n.xbgr.xr78_u10.nr1[nsmm_w]
print @n.xbgr.xr78_u10.nr1[nsmm_l]
print @n.xbgr.xr78_u11.nr1[nsmm_rsh]
print @n.xbgr.xr78_u11.nr1[nsmm_w]
print @n.xbgr.xr78_u11.nr1[nsmm_l]
print @n.xbgr.xr78_u12.nr1[nsmm_rsh]
print @n.xbgr.xr78_u12.nr1[nsmm_w]
print @n.xbgr.xr78_u12.nr1[nsmm_l]
print @n.xbgr.xr78_u13.nr1[nsmm_rsh]
print @n.xbgr.xr78_u13.nr1[nsmm_w]
print @n.xbgr.xr78_u13.nr1[nsmm_l]
print @n.xbgr.xr78_u14.nr1[nsmm_rsh]
print @n.xbgr.xr78_u14.nr1[nsmm_w]
print @n.xbgr.xr78_u14.nr1[nsmm_l]
print @n.xbgr.xr78_u15.nr1[nsmm_rsh]
print @n.xbgr.xr78_u15.nr1[nsmm_w]
print @n.xbgr.xr78_u15.nr1[nsmm_l]
print @n.xbgr.xr78_u16.nr1[nsmm_rsh]
print @n.xbgr.xr78_u16.nr1[nsmm_w]
print @n.xbgr.xr78_u16.nr1[nsmm_l]
print @n.xbgr.xr78_u17.nr1[nsmm_rsh]
print @n.xbgr.xr78_u17.nr1[nsmm_w]
print @n.xbgr.xr78_u17.nr1[nsmm_l]
print @n.xbgr.xr78_u18.nr1[nsmm_rsh]
print @n.xbgr.xr78_u18.nr1[nsmm_w]
print @n.xbgr.xr78_u18.nr1[nsmm_l]
print @n.xbgr.xr78_u19.nr1[nsmm_rsh]
print @n.xbgr.xr78_u19.nr1[nsmm_w]
print @n.xbgr.xr78_u19.nr1[nsmm_l]
print @n.xbgr.xr78_u20.nr1[nsmm_rsh]
print @n.xbgr.xr78_u20.nr1[nsmm_w]
print @n.xbgr.xr78_u20.nr1[nsmm_l]
print @n.xbgr.xr78_u21.nr1[nsmm_rsh]
print @n.xbgr.xr78_u21.nr1[nsmm_w]
print @n.xbgr.xr78_u21.nr1[nsmm_l]
print @n.xbgr.xr78_u22.nr1[nsmm_rsh]
print @n.xbgr.xr78_u22.nr1[nsmm_w]
print @n.xbgr.xr78_u22.nr1[nsmm_l]
print @n.xbgr.xr78_u23.nr1[nsmm_rsh]
print @n.xbgr.xr78_u23.nr1[nsmm_w]
print @n.xbgr.xr78_u23.nr1[nsmm_l]
print @n.xbgr.xr78_u24.nr1[nsmm_rsh]
print @n.xbgr.xr78_u24.nr1[nsmm_w]
print @n.xbgr.xr78_u24.nr1[nsmm_l]
print @n.xbgr.xr79_u2.nr1[nsmm_rsh]
print @n.xbgr.xr79_u2.nr1[nsmm_w]
print @n.xbgr.xr79_u2.nr1[nsmm_l]
print @n.xbgr.xr79_u3.nr1[nsmm_rsh]
print @n.xbgr.xr79_u3.nr1[nsmm_w]
print @n.xbgr.xr79_u3.nr1[nsmm_l]
print @n.xbgr.xr79_u4.nr1[nsmm_rsh]
print @n.xbgr.xr79_u4.nr1[nsmm_w]
print @n.xbgr.xr79_u4.nr1[nsmm_l]
print @n.xbgr.xr79_u5.nr1[nsmm_rsh]
print @n.xbgr.xr79_u5.nr1[nsmm_w]
print @n.xbgr.xr79_u5.nr1[nsmm_l]
print @n.xbgr.xr79_u6.nr1[nsmm_rsh]
print @n.xbgr.xr79_u6.nr1[nsmm_w]
print @n.xbgr.xr79_u6.nr1[nsmm_l]
print @n.xbgr.xr79_u7.nr1[nsmm_rsh]
print @n.xbgr.xr79_u7.nr1[nsmm_w]
print @n.xbgr.xr79_u7.nr1[nsmm_l]
print @n.xbgr.xr79_u8.nr1[nsmm_rsh]
print @n.xbgr.xr79_u8.nr1[nsmm_w]
print @n.xbgr.xr79_u8.nr1[nsmm_l]
print @n.xbgr.xr79_u9.nr1[nsmm_rsh]
print @n.xbgr.xr79_u9.nr1[nsmm_w]
print @n.xbgr.xr79_u9.nr1[nsmm_l]
print @n.xbgr.xr79_u10.nr1[nsmm_rsh]
print @n.xbgr.xr79_u10.nr1[nsmm_w]
print @n.xbgr.xr79_u10.nr1[nsmm_l]
print @n.xbgr.xr79_u11.nr1[nsmm_rsh]
print @n.xbgr.xr79_u11.nr1[nsmm_w]
print @n.xbgr.xr79_u11.nr1[nsmm_l]
print @n.xbgr.xr79_u12.nr1[nsmm_rsh]
print @n.xbgr.xr79_u12.nr1[nsmm_w]
print @n.xbgr.xr79_u12.nr1[nsmm_l]
print @n.xbgr.xr79_u13.nr1[nsmm_rsh]
print @n.xbgr.xr79_u13.nr1[nsmm_w]
print @n.xbgr.xr79_u13.nr1[nsmm_l]
print @n.xbgr.xr79_u14.nr1[nsmm_rsh]
print @n.xbgr.xr79_u14.nr1[nsmm_w]
print @n.xbgr.xr79_u14.nr1[nsmm_l]
print @n.xbgr.xr79_u15.nr1[nsmm_rsh]
print @n.xbgr.xr79_u15.nr1[nsmm_w]
print @n.xbgr.xr79_u15.nr1[nsmm_l]
print @n.xbgr.xr79_u16.nr1[nsmm_rsh]
print @n.xbgr.xr79_u16.nr1[nsmm_w]
print @n.xbgr.xr79_u16.nr1[nsmm_l]
print @n.xbgr.xr79_u17.nr1[nsmm_rsh]
print @n.xbgr.xr79_u17.nr1[nsmm_w]
print @n.xbgr.xr79_u17.nr1[nsmm_l]
print @n.xbgr.xr79_u18.nr1[nsmm_rsh]
print @n.xbgr.xr79_u18.nr1[nsmm_w]
print @n.xbgr.xr79_u18.nr1[nsmm_l]
print @n.xbgr.xr79_u19.nr1[nsmm_rsh]
print @n.xbgr.xr79_u19.nr1[nsmm_w]
print @n.xbgr.xr79_u19.nr1[nsmm_l]
print @n.xbgr.xr79_u20.nr1[nsmm_rsh]
print @n.xbgr.xr79_u20.nr1[nsmm_w]
print @n.xbgr.xr79_u20.nr1[nsmm_l]
print @n.xbgr.xr79_u21.nr1[nsmm_rsh]
print @n.xbgr.xr79_u21.nr1[nsmm_w]
print @n.xbgr.xr79_u21.nr1[nsmm_l]
print @n.xbgr.xr79_u22.nr1[nsmm_rsh]
print @n.xbgr.xr79_u22.nr1[nsmm_w]
print @n.xbgr.xr79_u22.nr1[nsmm_l]
print @n.xbgr.xr79_u23.nr1[nsmm_rsh]
print @n.xbgr.xr79_u23.nr1[nsmm_w]
print @n.xbgr.xr79_u23.nr1[nsmm_l]
print @n.xbgr.xr79_u24.nr1[nsmm_rsh]
print @n.xbgr.xr79_u24.nr1[nsmm_w]
print @n.xbgr.xr79_u24.nr1[nsmm_l]
print @n.xbgr.xr80_u2.nr1[nsmm_rsh]
print @n.xbgr.xr80_u2.nr1[nsmm_w]
print @n.xbgr.xr80_u2.nr1[nsmm_l]
print @n.xbgr.xr80_u3.nr1[nsmm_rsh]
print @n.xbgr.xr80_u3.nr1[nsmm_w]
print @n.xbgr.xr80_u3.nr1[nsmm_l]
print @n.xbgr.xr80_u4.nr1[nsmm_rsh]
print @n.xbgr.xr80_u4.nr1[nsmm_w]
print @n.xbgr.xr80_u4.nr1[nsmm_l]
print @n.xbgr.xr80_u5.nr1[nsmm_rsh]
print @n.xbgr.xr80_u5.nr1[nsmm_w]
print @n.xbgr.xr80_u5.nr1[nsmm_l]
print @n.xbgr.xr80_u6.nr1[nsmm_rsh]
print @n.xbgr.xr80_u6.nr1[nsmm_w]
print @n.xbgr.xr80_u6.nr1[nsmm_l]
print @n.xbgr.xr80_u7.nr1[nsmm_rsh]
print @n.xbgr.xr80_u7.nr1[nsmm_w]
print @n.xbgr.xr80_u7.nr1[nsmm_l]
print @n.xbgr.xr80_u8.nr1[nsmm_rsh]
print @n.xbgr.xr80_u8.nr1[nsmm_w]
print @n.xbgr.xr80_u8.nr1[nsmm_l]
print @n.xbgr.xr80_u9.nr1[nsmm_rsh]
print @n.xbgr.xr80_u9.nr1[nsmm_w]
print @n.xbgr.xr80_u9.nr1[nsmm_l]
print @n.xbgr.xr80_u10.nr1[nsmm_rsh]
print @n.xbgr.xr80_u10.nr1[nsmm_w]
print @n.xbgr.xr80_u10.nr1[nsmm_l]
print @n.xbgr.xr80_u11.nr1[nsmm_rsh]
print @n.xbgr.xr80_u11.nr1[nsmm_w]
print @n.xbgr.xr80_u11.nr1[nsmm_l]
print @n.xbgr.xr80_u12.nr1[nsmm_rsh]
print @n.xbgr.xr80_u12.nr1[nsmm_w]
print @n.xbgr.xr80_u12.nr1[nsmm_l]
print @n.xbgr.xr80_u13.nr1[nsmm_rsh]
print @n.xbgr.xr80_u13.nr1[nsmm_w]
print @n.xbgr.xr80_u13.nr1[nsmm_l]
print @n.xbgr.xr80_u14.nr1[nsmm_rsh]
print @n.xbgr.xr80_u14.nr1[nsmm_w]
print @n.xbgr.xr80_u14.nr1[nsmm_l]
print @n.xbgr.xr80_u15.nr1[nsmm_rsh]
print @n.xbgr.xr80_u15.nr1[nsmm_w]
print @n.xbgr.xr80_u15.nr1[nsmm_l]
print @n.xbgr.xr80_u16.nr1[nsmm_rsh]
print @n.xbgr.xr80_u16.nr1[nsmm_w]
print @n.xbgr.xr80_u16.nr1[nsmm_l]
print @n.xbgr.xr80_u17.nr1[nsmm_rsh]
print @n.xbgr.xr80_u17.nr1[nsmm_w]
print @n.xbgr.xr80_u17.nr1[nsmm_l]
print @n.xbgr.xr80_u18.nr1[nsmm_rsh]
print @n.xbgr.xr80_u18.nr1[nsmm_w]
print @n.xbgr.xr80_u18.nr1[nsmm_l]
print @n.xbgr.xr80_u19.nr1[nsmm_rsh]
print @n.xbgr.xr80_u19.nr1[nsmm_w]
print @n.xbgr.xr80_u19.nr1[nsmm_l]
print @n.xbgr.xr80_u20.nr1[nsmm_rsh]
print @n.xbgr.xr80_u20.nr1[nsmm_w]
print @n.xbgr.xr80_u20.nr1[nsmm_l]
print @n.xbgr.xr80_u21.nr1[nsmm_rsh]
print @n.xbgr.xr80_u21.nr1[nsmm_w]
print @n.xbgr.xr80_u21.nr1[nsmm_l]
print @n.xbgr.xr80_u22.nr1[nsmm_rsh]
print @n.xbgr.xr80_u22.nr1[nsmm_w]
print @n.xbgr.xr80_u22.nr1[nsmm_l]
print @n.xbgr.xr80_u23.nr1[nsmm_rsh]
print @n.xbgr.xr80_u23.nr1[nsmm_w]
print @n.xbgr.xr80_u23.nr1[nsmm_l]
print @n.xbgr.xr80_u24.nr1[nsmm_rsh]
print @n.xbgr.xr80_u24.nr1[nsmm_w]
print @n.xbgr.xr80_u24.nr1[nsmm_l]
print @n.xbgr.xr81_u2.nr1[nsmm_rsh]
print @n.xbgr.xr81_u2.nr1[nsmm_w]
print @n.xbgr.xr81_u2.nr1[nsmm_l]
print @n.xbgr.xr81_u3.nr1[nsmm_rsh]
print @n.xbgr.xr81_u3.nr1[nsmm_w]
print @n.xbgr.xr81_u3.nr1[nsmm_l]
print @n.xbgr.xr81_u4.nr1[nsmm_rsh]
print @n.xbgr.xr81_u4.nr1[nsmm_w]
print @n.xbgr.xr81_u4.nr1[nsmm_l]
print @n.xbgr.xr81_u5.nr1[nsmm_rsh]
print @n.xbgr.xr81_u5.nr1[nsmm_w]
print @n.xbgr.xr81_u5.nr1[nsmm_l]
print @n.xbgr.xr81_u6.nr1[nsmm_rsh]
print @n.xbgr.xr81_u6.nr1[nsmm_w]
print @n.xbgr.xr81_u6.nr1[nsmm_l]
print @n.xbgr.xr81_u7.nr1[nsmm_rsh]
print @n.xbgr.xr81_u7.nr1[nsmm_w]
print @n.xbgr.xr81_u7.nr1[nsmm_l]
print @n.xbgr.xr81_u8.nr1[nsmm_rsh]
print @n.xbgr.xr81_u8.nr1[nsmm_w]
print @n.xbgr.xr81_u8.nr1[nsmm_l]
print @n.xbgr.xr81_u9.nr1[nsmm_rsh]
print @n.xbgr.xr81_u9.nr1[nsmm_w]
print @n.xbgr.xr81_u9.nr1[nsmm_l]
print @n.xbgr.xr81_u10.nr1[nsmm_rsh]
print @n.xbgr.xr81_u10.nr1[nsmm_w]
print @n.xbgr.xr81_u10.nr1[nsmm_l]
print @n.xbgr.xr81_u11.nr1[nsmm_rsh]
print @n.xbgr.xr81_u11.nr1[nsmm_w]
print @n.xbgr.xr81_u11.nr1[nsmm_l]
print @n.xbgr.xr81_u12.nr1[nsmm_rsh]
print @n.xbgr.xr81_u12.nr1[nsmm_w]
print @n.xbgr.xr81_u12.nr1[nsmm_l]
print @n.xbgr.xr81_u13.nr1[nsmm_rsh]
print @n.xbgr.xr81_u13.nr1[nsmm_w]
print @n.xbgr.xr81_u13.nr1[nsmm_l]
print @n.xbgr.xr81_u14.nr1[nsmm_rsh]
print @n.xbgr.xr81_u14.nr1[nsmm_w]
print @n.xbgr.xr81_u14.nr1[nsmm_l]
print @n.xbgr.xr81_u15.nr1[nsmm_rsh]
print @n.xbgr.xr81_u15.nr1[nsmm_w]
print @n.xbgr.xr81_u15.nr1[nsmm_l]
print @n.xbgr.xr81_u16.nr1[nsmm_rsh]
print @n.xbgr.xr81_u16.nr1[nsmm_w]
print @n.xbgr.xr81_u16.nr1[nsmm_l]
print @n.xbgr.xr81_u17.nr1[nsmm_rsh]
print @n.xbgr.xr81_u17.nr1[nsmm_w]
print @n.xbgr.xr81_u17.nr1[nsmm_l]
print @n.xbgr.xr81_u18.nr1[nsmm_rsh]
print @n.xbgr.xr81_u18.nr1[nsmm_w]
print @n.xbgr.xr81_u18.nr1[nsmm_l]
print @n.xbgr.xr81_u19.nr1[nsmm_rsh]
print @n.xbgr.xr81_u19.nr1[nsmm_w]
print @n.xbgr.xr81_u19.nr1[nsmm_l]
print @n.xbgr.xr81_u20.nr1[nsmm_rsh]
print @n.xbgr.xr81_u20.nr1[nsmm_w]
print @n.xbgr.xr81_u20.nr1[nsmm_l]
print @n.xbgr.xr81_u21.nr1[nsmm_rsh]
print @n.xbgr.xr81_u21.nr1[nsmm_w]
print @n.xbgr.xr81_u21.nr1[nsmm_l]
print @n.xbgr.xr81_u22.nr1[nsmm_rsh]
print @n.xbgr.xr81_u22.nr1[nsmm_w]
print @n.xbgr.xr81_u22.nr1[nsmm_l]
print @n.xbgr.xr81_u23.nr1[nsmm_rsh]
print @n.xbgr.xr81_u23.nr1[nsmm_w]
print @n.xbgr.xr81_u23.nr1[nsmm_l]
print @n.xbgr.xr81_u24.nr1[nsmm_rsh]
print @n.xbgr.xr81_u24.nr1[nsmm_w]
print @n.xbgr.xr81_u24.nr1[nsmm_l]
print @n.xbgr.xr82_u2.nr1[nsmm_rsh]
print @n.xbgr.xr82_u2.nr1[nsmm_w]
print @n.xbgr.xr82_u2.nr1[nsmm_l]
print @n.xbgr.xr82_u3.nr1[nsmm_rsh]
print @n.xbgr.xr82_u3.nr1[nsmm_w]
print @n.xbgr.xr82_u3.nr1[nsmm_l]
print @n.xbgr.xr82_u4.nr1[nsmm_rsh]
print @n.xbgr.xr82_u4.nr1[nsmm_w]
print @n.xbgr.xr82_u4.nr1[nsmm_l]
print @n.xbgr.xr82_u5.nr1[nsmm_rsh]
print @n.xbgr.xr82_u5.nr1[nsmm_w]
print @n.xbgr.xr82_u5.nr1[nsmm_l]
print @n.xbgr.xr82_u6.nr1[nsmm_rsh]
print @n.xbgr.xr82_u6.nr1[nsmm_w]
print @n.xbgr.xr82_u6.nr1[nsmm_l]
print @n.xbgr.xr82_u7.nr1[nsmm_rsh]
print @n.xbgr.xr82_u7.nr1[nsmm_w]
print @n.xbgr.xr82_u7.nr1[nsmm_l]
print @n.xbgr.xr82_u8.nr1[nsmm_rsh]
print @n.xbgr.xr82_u8.nr1[nsmm_w]
print @n.xbgr.xr82_u8.nr1[nsmm_l]
print @n.xbgr.xr82_u9.nr1[nsmm_rsh]
print @n.xbgr.xr82_u9.nr1[nsmm_w]
print @n.xbgr.xr82_u9.nr1[nsmm_l]
print @n.xbgr.xr82_u10.nr1[nsmm_rsh]
print @n.xbgr.xr82_u10.nr1[nsmm_w]
print @n.xbgr.xr82_u10.nr1[nsmm_l]
print @n.xbgr.xr82_u11.nr1[nsmm_rsh]
print @n.xbgr.xr82_u11.nr1[nsmm_w]
print @n.xbgr.xr82_u11.nr1[nsmm_l]
print @n.xbgr.xr82_u12.nr1[nsmm_rsh]
print @n.xbgr.xr82_u12.nr1[nsmm_w]
print @n.xbgr.xr82_u12.nr1[nsmm_l]
print @n.xbgr.xr82_u13.nr1[nsmm_rsh]
print @n.xbgr.xr82_u13.nr1[nsmm_w]
print @n.xbgr.xr82_u13.nr1[nsmm_l]
print @n.xbgr.xr82_u14.nr1[nsmm_rsh]
print @n.xbgr.xr82_u14.nr1[nsmm_w]
print @n.xbgr.xr82_u14.nr1[nsmm_l]
print @n.xbgr.xr82_u15.nr1[nsmm_rsh]
print @n.xbgr.xr82_u15.nr1[nsmm_w]
print @n.xbgr.xr82_u15.nr1[nsmm_l]
print @n.xbgr.xr82_u16.nr1[nsmm_rsh]
print @n.xbgr.xr82_u16.nr1[nsmm_w]
print @n.xbgr.xr82_u16.nr1[nsmm_l]
print @n.xbgr.xr82_u17.nr1[nsmm_rsh]
print @n.xbgr.xr82_u17.nr1[nsmm_w]
print @n.xbgr.xr82_u17.nr1[nsmm_l]
print @n.xbgr.xr82_u18.nr1[nsmm_rsh]
print @n.xbgr.xr82_u18.nr1[nsmm_w]
print @n.xbgr.xr82_u18.nr1[nsmm_l]
print @n.xbgr.xr82_u19.nr1[nsmm_rsh]
print @n.xbgr.xr82_u19.nr1[nsmm_w]
print @n.xbgr.xr82_u19.nr1[nsmm_l]
print @n.xbgr.xr82_u20.nr1[nsmm_rsh]
print @n.xbgr.xr82_u20.nr1[nsmm_w]
print @n.xbgr.xr82_u20.nr1[nsmm_l]
print @n.xbgr.xr82_u21.nr1[nsmm_rsh]
print @n.xbgr.xr82_u21.nr1[nsmm_w]
print @n.xbgr.xr82_u21.nr1[nsmm_l]
print @n.xbgr.xr82_u22.nr1[nsmm_rsh]
print @n.xbgr.xr82_u22.nr1[nsmm_w]
print @n.xbgr.xr82_u22.nr1[nsmm_l]
print @n.xbgr.xr82_u23.nr1[nsmm_rsh]
print @n.xbgr.xr82_u23.nr1[nsmm_w]
print @n.xbgr.xr82_u23.nr1[nsmm_l]
print @n.xbgr.xr82_u24.nr1[nsmm_rsh]
print @n.xbgr.xr82_u24.nr1[nsmm_w]
print @n.xbgr.xr82_u24.nr1[nsmm_l]
print @n.xbgr.xr83_u2.nr1[nsmm_rsh]
print @n.xbgr.xr83_u2.nr1[nsmm_w]
print @n.xbgr.xr83_u2.nr1[nsmm_l]
print @n.xbgr.xr83_u3.nr1[nsmm_rsh]
print @n.xbgr.xr83_u3.nr1[nsmm_w]
print @n.xbgr.xr83_u3.nr1[nsmm_l]
print @n.xbgr.xr83_u4.nr1[nsmm_rsh]
print @n.xbgr.xr83_u4.nr1[nsmm_w]
print @n.xbgr.xr83_u4.nr1[nsmm_l]
print @n.xbgr.xr83_u5.nr1[nsmm_rsh]
print @n.xbgr.xr83_u5.nr1[nsmm_w]
print @n.xbgr.xr83_u5.nr1[nsmm_l]
print @n.xbgr.xr83_u6.nr1[nsmm_rsh]
print @n.xbgr.xr83_u6.nr1[nsmm_w]
print @n.xbgr.xr83_u6.nr1[nsmm_l]
print @n.xbgr.xr83_u7.nr1[nsmm_rsh]
print @n.xbgr.xr83_u7.nr1[nsmm_w]
print @n.xbgr.xr83_u7.nr1[nsmm_l]
print @n.xbgr.xr83_u8.nr1[nsmm_rsh]
print @n.xbgr.xr83_u8.nr1[nsmm_w]
print @n.xbgr.xr83_u8.nr1[nsmm_l]
print @n.xbgr.xr83_u9.nr1[nsmm_rsh]
print @n.xbgr.xr83_u9.nr1[nsmm_w]
print @n.xbgr.xr83_u9.nr1[nsmm_l]
print @n.xbgr.xr83_u10.nr1[nsmm_rsh]
print @n.xbgr.xr83_u10.nr1[nsmm_w]
print @n.xbgr.xr83_u10.nr1[nsmm_l]
print @n.xbgr.xr83_u11.nr1[nsmm_rsh]
print @n.xbgr.xr83_u11.nr1[nsmm_w]
print @n.xbgr.xr83_u11.nr1[nsmm_l]
print @n.xbgr.xr83_u12.nr1[nsmm_rsh]
print @n.xbgr.xr83_u12.nr1[nsmm_w]
print @n.xbgr.xr83_u12.nr1[nsmm_l]
print @n.xbgr.xr83_u13.nr1[nsmm_rsh]
print @n.xbgr.xr83_u13.nr1[nsmm_w]
print @n.xbgr.xr83_u13.nr1[nsmm_l]
print @n.xbgr.xr83_u14.nr1[nsmm_rsh]
print @n.xbgr.xr83_u14.nr1[nsmm_w]
print @n.xbgr.xr83_u14.nr1[nsmm_l]
print @n.xbgr.xr83_u15.nr1[nsmm_rsh]
print @n.xbgr.xr83_u15.nr1[nsmm_w]
print @n.xbgr.xr83_u15.nr1[nsmm_l]
print @n.xbgr.xr83_u16.nr1[nsmm_rsh]
print @n.xbgr.xr83_u16.nr1[nsmm_w]
print @n.xbgr.xr83_u16.nr1[nsmm_l]
print @n.xbgr.xr83_u17.nr1[nsmm_rsh]
print @n.xbgr.xr83_u17.nr1[nsmm_w]
print @n.xbgr.xr83_u17.nr1[nsmm_l]
print @n.xbgr.xr83_u18.nr1[nsmm_rsh]
print @n.xbgr.xr83_u18.nr1[nsmm_w]
print @n.xbgr.xr83_u18.nr1[nsmm_l]
print @n.xbgr.xr83_u19.nr1[nsmm_rsh]
print @n.xbgr.xr83_u19.nr1[nsmm_w]
print @n.xbgr.xr83_u19.nr1[nsmm_l]
print @n.xbgr.xr83_u20.nr1[nsmm_rsh]
print @n.xbgr.xr83_u20.nr1[nsmm_w]
print @n.xbgr.xr83_u20.nr1[nsmm_l]
print @n.xbgr.xr83_u21.nr1[nsmm_rsh]
print @n.xbgr.xr83_u21.nr1[nsmm_w]
print @n.xbgr.xr83_u21.nr1[nsmm_l]
print @n.xbgr.xr83_u22.nr1[nsmm_rsh]
print @n.xbgr.xr83_u22.nr1[nsmm_w]
print @n.xbgr.xr83_u22.nr1[nsmm_l]
print @n.xbgr.xr83_u23.nr1[nsmm_rsh]
print @n.xbgr.xr83_u23.nr1[nsmm_w]
print @n.xbgr.xr83_u23.nr1[nsmm_l]
print @n.xbgr.xr83_u24.nr1[nsmm_rsh]
print @n.xbgr.xr83_u24.nr1[nsmm_w]
print @n.xbgr.xr83_u24.nr1[nsmm_l]
print @n.xbgr.xr84_u2.nr1[nsmm_rsh]
print @n.xbgr.xr84_u2.nr1[nsmm_w]
print @n.xbgr.xr84_u2.nr1[nsmm_l]
print @n.xbgr.xr84_u3.nr1[nsmm_rsh]
print @n.xbgr.xr84_u3.nr1[nsmm_w]
print @n.xbgr.xr84_u3.nr1[nsmm_l]
print @n.xbgr.xr84_u4.nr1[nsmm_rsh]
print @n.xbgr.xr84_u4.nr1[nsmm_w]
print @n.xbgr.xr84_u4.nr1[nsmm_l]
print @n.xbgr.xr84_u5.nr1[nsmm_rsh]
print @n.xbgr.xr84_u5.nr1[nsmm_w]
print @n.xbgr.xr84_u5.nr1[nsmm_l]
print @n.xbgr.xr84_u6.nr1[nsmm_rsh]
print @n.xbgr.xr84_u6.nr1[nsmm_w]
print @n.xbgr.xr84_u6.nr1[nsmm_l]
print @n.xbgr.xr84_u7.nr1[nsmm_rsh]
print @n.xbgr.xr84_u7.nr1[nsmm_w]
print @n.xbgr.xr84_u7.nr1[nsmm_l]
print @n.xbgr.xr84_u8.nr1[nsmm_rsh]
print @n.xbgr.xr84_u8.nr1[nsmm_w]
print @n.xbgr.xr84_u8.nr1[nsmm_l]
print @n.xbgr.xr84_u9.nr1[nsmm_rsh]
print @n.xbgr.xr84_u9.nr1[nsmm_w]
print @n.xbgr.xr84_u9.nr1[nsmm_l]
print @n.xbgr.xr84_u10.nr1[nsmm_rsh]
print @n.xbgr.xr84_u10.nr1[nsmm_w]
print @n.xbgr.xr84_u10.nr1[nsmm_l]
print @n.xbgr.xr84_u11.nr1[nsmm_rsh]
print @n.xbgr.xr84_u11.nr1[nsmm_w]
print @n.xbgr.xr84_u11.nr1[nsmm_l]
print @n.xbgr.xr84_u12.nr1[nsmm_rsh]
print @n.xbgr.xr84_u12.nr1[nsmm_w]
print @n.xbgr.xr84_u12.nr1[nsmm_l]
print @n.xbgr.xr84_u13.nr1[nsmm_rsh]
print @n.xbgr.xr84_u13.nr1[nsmm_w]
print @n.xbgr.xr84_u13.nr1[nsmm_l]
print @n.xbgr.xr84_u14.nr1[nsmm_rsh]
print @n.xbgr.xr84_u14.nr1[nsmm_w]
print @n.xbgr.xr84_u14.nr1[nsmm_l]
print @n.xbgr.xr84_u15.nr1[nsmm_rsh]
print @n.xbgr.xr84_u15.nr1[nsmm_w]
print @n.xbgr.xr84_u15.nr1[nsmm_l]
print @n.xbgr.xr84_u16.nr1[nsmm_rsh]
print @n.xbgr.xr84_u16.nr1[nsmm_w]
print @n.xbgr.xr84_u16.nr1[nsmm_l]
print @n.xbgr.xr84_u17.nr1[nsmm_rsh]
print @n.xbgr.xr84_u17.nr1[nsmm_w]
print @n.xbgr.xr84_u17.nr1[nsmm_l]
print @n.xbgr.xr84_u18.nr1[nsmm_rsh]
print @n.xbgr.xr84_u18.nr1[nsmm_w]
print @n.xbgr.xr84_u18.nr1[nsmm_l]
print @n.xbgr.xr84_u19.nr1[nsmm_rsh]
print @n.xbgr.xr84_u19.nr1[nsmm_w]
print @n.xbgr.xr84_u19.nr1[nsmm_l]
print @n.xbgr.xr84_u20.nr1[nsmm_rsh]
print @n.xbgr.xr84_u20.nr1[nsmm_w]
print @n.xbgr.xr84_u20.nr1[nsmm_l]
print @n.xbgr.xr84_u21.nr1[nsmm_rsh]
print @n.xbgr.xr84_u21.nr1[nsmm_w]
print @n.xbgr.xr84_u21.nr1[nsmm_l]
print @n.xbgr.xr84_u22.nr1[nsmm_rsh]
print @n.xbgr.xr84_u22.nr1[nsmm_w]
print @n.xbgr.xr84_u22.nr1[nsmm_l]
print @n.xbgr.xr84_u23.nr1[nsmm_rsh]
print @n.xbgr.xr84_u23.nr1[nsmm_w]
print @n.xbgr.xr84_u23.nr1[nsmm_l]
print @n.xbgr.xr84_u24.nr1[nsmm_rsh]
print @n.xbgr.xr84_u24.nr1[nsmm_w]
print @n.xbgr.xr84_u24.nr1[nsmm_l]
print @n.xbgr.xr85_u2.nr1[nsmm_rsh]
print @n.xbgr.xr85_u2.nr1[nsmm_w]
print @n.xbgr.xr85_u2.nr1[nsmm_l]
print @n.xbgr.xr85_u3.nr1[nsmm_rsh]
print @n.xbgr.xr85_u3.nr1[nsmm_w]
print @n.xbgr.xr85_u3.nr1[nsmm_l]
print @n.xbgr.xr85_u4.nr1[nsmm_rsh]
print @n.xbgr.xr85_u4.nr1[nsmm_w]
print @n.xbgr.xr85_u4.nr1[nsmm_l]
print @n.xbgr.xr85_u5.nr1[nsmm_rsh]
print @n.xbgr.xr85_u5.nr1[nsmm_w]
print @n.xbgr.xr85_u5.nr1[nsmm_l]
print @n.xbgr.xr85_u6.nr1[nsmm_rsh]
print @n.xbgr.xr85_u6.nr1[nsmm_w]
print @n.xbgr.xr85_u6.nr1[nsmm_l]
print @n.xbgr.xr85_u7.nr1[nsmm_rsh]
print @n.xbgr.xr85_u7.nr1[nsmm_w]
print @n.xbgr.xr85_u7.nr1[nsmm_l]
print @n.xbgr.xr85_u8.nr1[nsmm_rsh]
print @n.xbgr.xr85_u8.nr1[nsmm_w]
print @n.xbgr.xr85_u8.nr1[nsmm_l]
print @n.xbgr.xr85_u9.nr1[nsmm_rsh]
print @n.xbgr.xr85_u9.nr1[nsmm_w]
print @n.xbgr.xr85_u9.nr1[nsmm_l]
print @n.xbgr.xr85_u10.nr1[nsmm_rsh]
print @n.xbgr.xr85_u10.nr1[nsmm_w]
print @n.xbgr.xr85_u10.nr1[nsmm_l]
print @n.xbgr.xr85_u11.nr1[nsmm_rsh]
print @n.xbgr.xr85_u11.nr1[nsmm_w]
print @n.xbgr.xr85_u11.nr1[nsmm_l]
print @n.xbgr.xr85_u12.nr1[nsmm_rsh]
print @n.xbgr.xr85_u12.nr1[nsmm_w]
print @n.xbgr.xr85_u12.nr1[nsmm_l]
print @n.xbgr.xr85_u13.nr1[nsmm_rsh]
print @n.xbgr.xr85_u13.nr1[nsmm_w]
print @n.xbgr.xr85_u13.nr1[nsmm_l]
print @n.xbgr.xr85_u14.nr1[nsmm_rsh]
print @n.xbgr.xr85_u14.nr1[nsmm_w]
print @n.xbgr.xr85_u14.nr1[nsmm_l]
print @n.xbgr.xr85_u15.nr1[nsmm_rsh]
print @n.xbgr.xr85_u15.nr1[nsmm_w]
print @n.xbgr.xr85_u15.nr1[nsmm_l]
print @n.xbgr.xr85_u16.nr1[nsmm_rsh]
print @n.xbgr.xr85_u16.nr1[nsmm_w]
print @n.xbgr.xr85_u16.nr1[nsmm_l]
print @n.xbgr.xr85_u17.nr1[nsmm_rsh]
print @n.xbgr.xr85_u17.nr1[nsmm_w]
print @n.xbgr.xr85_u17.nr1[nsmm_l]
print @n.xbgr.xr85_u18.nr1[nsmm_rsh]
print @n.xbgr.xr85_u18.nr1[nsmm_w]
print @n.xbgr.xr85_u18.nr1[nsmm_l]
print @n.xbgr.xr85_u19.nr1[nsmm_rsh]
print @n.xbgr.xr85_u19.nr1[nsmm_w]
print @n.xbgr.xr85_u19.nr1[nsmm_l]
print @n.xbgr.xr85_u20.nr1[nsmm_rsh]
print @n.xbgr.xr85_u20.nr1[nsmm_w]
print @n.xbgr.xr85_u20.nr1[nsmm_l]
print @n.xbgr.xr85_u21.nr1[nsmm_rsh]
print @n.xbgr.xr85_u21.nr1[nsmm_w]
print @n.xbgr.xr85_u21.nr1[nsmm_l]
print @n.xbgr.xr85_u22.nr1[nsmm_rsh]
print @n.xbgr.xr85_u22.nr1[nsmm_w]
print @n.xbgr.xr85_u22.nr1[nsmm_l]
print @n.xbgr.xr85_u23.nr1[nsmm_rsh]
print @n.xbgr.xr85_u23.nr1[nsmm_w]
print @n.xbgr.xr85_u23.nr1[nsmm_l]
print @n.xbgr.xr85_u24.nr1[nsmm_rsh]
print @n.xbgr.xr85_u24.nr1[nsmm_w]
print @n.xbgr.xr85_u24.nr1[nsmm_l]
print @n.xbgr.xr86_u2.nr1[nsmm_rsh]
print @n.xbgr.xr86_u2.nr1[nsmm_w]
print @n.xbgr.xr86_u2.nr1[nsmm_l]
print @n.xbgr.xr86_u3.nr1[nsmm_rsh]
print @n.xbgr.xr86_u3.nr1[nsmm_w]
print @n.xbgr.xr86_u3.nr1[nsmm_l]
print @n.xbgr.xr86_u4.nr1[nsmm_rsh]
print @n.xbgr.xr86_u4.nr1[nsmm_w]
print @n.xbgr.xr86_u4.nr1[nsmm_l]
print @n.xbgr.xr86_u5.nr1[nsmm_rsh]
print @n.xbgr.xr86_u5.nr1[nsmm_w]
print @n.xbgr.xr86_u5.nr1[nsmm_l]
print @n.xbgr.xr86_u6.nr1[nsmm_rsh]
print @n.xbgr.xr86_u6.nr1[nsmm_w]
print @n.xbgr.xr86_u6.nr1[nsmm_l]
print @n.xbgr.xr86_u7.nr1[nsmm_rsh]
print @n.xbgr.xr86_u7.nr1[nsmm_w]
print @n.xbgr.xr86_u7.nr1[nsmm_l]
print @n.xbgr.xr86_u8.nr1[nsmm_rsh]
print @n.xbgr.xr86_u8.nr1[nsmm_w]
print @n.xbgr.xr86_u8.nr1[nsmm_l]
print @n.xbgr.xr86_u9.nr1[nsmm_rsh]
print @n.xbgr.xr86_u9.nr1[nsmm_w]
print @n.xbgr.xr86_u9.nr1[nsmm_l]
print @n.xbgr.xr86_u10.nr1[nsmm_rsh]
print @n.xbgr.xr86_u10.nr1[nsmm_w]
print @n.xbgr.xr86_u10.nr1[nsmm_l]
print @n.xbgr.xr86_u11.nr1[nsmm_rsh]
print @n.xbgr.xr86_u11.nr1[nsmm_w]
print @n.xbgr.xr86_u11.nr1[nsmm_l]
print @n.xbgr.xr86_u12.nr1[nsmm_rsh]
print @n.xbgr.xr86_u12.nr1[nsmm_w]
print @n.xbgr.xr86_u12.nr1[nsmm_l]
print @n.xbgr.xr86_u13.nr1[nsmm_rsh]
print @n.xbgr.xr86_u13.nr1[nsmm_w]
print @n.xbgr.xr86_u13.nr1[nsmm_l]
print @n.xbgr.xr86_u14.nr1[nsmm_rsh]
print @n.xbgr.xr86_u14.nr1[nsmm_w]
print @n.xbgr.xr86_u14.nr1[nsmm_l]
print @n.xbgr.xr86_u15.nr1[nsmm_rsh]
print @n.xbgr.xr86_u15.nr1[nsmm_w]
print @n.xbgr.xr86_u15.nr1[nsmm_l]
print @n.xbgr.xr86_u16.nr1[nsmm_rsh]
print @n.xbgr.xr86_u16.nr1[nsmm_w]
print @n.xbgr.xr86_u16.nr1[nsmm_l]
print @n.xbgr.xr86_u17.nr1[nsmm_rsh]
print @n.xbgr.xr86_u17.nr1[nsmm_w]
print @n.xbgr.xr86_u17.nr1[nsmm_l]
print @n.xbgr.xr86_u18.nr1[nsmm_rsh]
print @n.xbgr.xr86_u18.nr1[nsmm_w]
print @n.xbgr.xr86_u18.nr1[nsmm_l]
print @n.xbgr.xr86_u19.nr1[nsmm_rsh]
print @n.xbgr.xr86_u19.nr1[nsmm_w]
print @n.xbgr.xr86_u19.nr1[nsmm_l]
print @n.xbgr.xr86_u20.nr1[nsmm_rsh]
print @n.xbgr.xr86_u20.nr1[nsmm_w]
print @n.xbgr.xr86_u20.nr1[nsmm_l]
print @n.xbgr.xr86_u21.nr1[nsmm_rsh]
print @n.xbgr.xr86_u21.nr1[nsmm_w]
print @n.xbgr.xr86_u21.nr1[nsmm_l]
print @n.xbgr.xr86_u22.nr1[nsmm_rsh]
print @n.xbgr.xr86_u22.nr1[nsmm_w]
print @n.xbgr.xr86_u22.nr1[nsmm_l]
print @n.xbgr.xr86_u23.nr1[nsmm_rsh]
print @n.xbgr.xr86_u23.nr1[nsmm_w]
print @n.xbgr.xr86_u23.nr1[nsmm_l]
print @n.xbgr.xr86_u24.nr1[nsmm_rsh]
print @n.xbgr.xr86_u24.nr1[nsmm_w]
print @n.xbgr.xr86_u24.nr1[nsmm_l]
set numdgt=17
echo METALLIC_POINT_VOLTAGES_BEGIN
print v(xbgr.mr_n80885152)
print v(xbgr.vd2)
print v(xbgr.mr_n80175712)
print v(xbgr.c2)
print v(xbgr.mr_n81174704)
print v(xbgr.mr_n81276432)
print v(xbgr.mr_n81391680)
print v(xbgr.mr_n81443360)
print v(xbgr.mr_n81626192)
print v(xbgr.mr_n81763552)
print v(xbgr.mr_n81828896)
print v(xbgr.mr_n82060448)
print v(xbgr.mr_n82228992)
print v(xbgr.mr_n82351056)
print v(xbgr.mr_n82375840)
print v(xbgr.mr_n82666624)
print v(xbgr.mr_n82758064)
print v(xbgr.mr_n82822000)
print v(xbgr.mr_n83285168)
print v(xbgr.mr_n83435296)
print v(xbgr.mr_n83607776)
print v(xbgr.mr_n83805728)
print v(xbgr.mr_n83976400)
print v(xbgr.mr_n84109984)
print v(xbgr.mr_n84318080)
print v(xbgr.mr_n84520112)
print v(xbgr.mr_n84731152)
print v(xbgr.mr_n81713472)
print v(xbgr.mr_n84817088)
print v(xbgr.mr_n85110048)
print v(xbgr.mr_n85293184)
print v(xbgr.mr_n85503264)
print v(xbgr.mr_n85691072)
print v(xbgr.mr_n85999120)
print v(xbgr.mr_n86200304)
print v(xbgr.mr_n86413376)
print v(xbgr.mr_n86768288)
print v(xbgr.mr_n80885600)
print v(xbgr.mr_n80949232)
print v(xbgr.b1b)
print v(xbgr.mr_n81033888)
print v(xbgr.mr_n81131792)
print v(xbgr.mr_n81242624)
print v(xbgr.mr_n81317456)
print v(xbgr.mr_n81451200)
print v(xbgr.mr_n81563248)
print v(xbgr.mr_n81905408)
print v(xbgr.mr_n82022848)
print v(xbgr.mr_n82154368)
print v(xbgr.mr_n82229104)
print v(xbgr.mr_n82429136)
print v(xbgr.mr_n82544192)
print v(xbgr.mr_n82697584)
print v(xbgr.mr_n82946688)
print v(xbgr.mr_n80916032)
print v(xbgr.mr_n80982112)
print v(xbgr.mr_n80718080)
print v(xbgr.mr_n81120512)
print v(xbgr.mr_n81220576)
print v(xbgr.mr_n81336048)
print v(xbgr.mr_n81378240)
print v(xbgr.mr_n81542256)
print v(xbgr.mr_n81646768)
print v(xbgr.mr_n81763888)
print v(xbgr.mr_n81950560)
print v(xbgr.mr_n82070544)
print v(xbgr.mr_n82231984)
print v(xbgr.mr_n82351168)
print v(xbgr.mr_n82552704)
print v(xbgr.mr_n82669584)
print v(xbgr.mr_n82758656)
print v(xbgr.mr_n82948400)
print v(xbgr.mr_n80154704)
print v(xbgr.mr_n80419104)
print v(xbgr.n_13)
print v(xbgr.n_24)
print v(xbgr.mr_n80064688)
print v(xbgr.mr_n80421008)
print v(xbgr.n_14)
print v(xbgr.mr_n80763392)
print v(xbgr.mr_n80666352)
print v(xbgr.mr_n80949424)
print v(xbgr.mr_n80081648)
print v(xbgr.mr_n81035456)
print v(xbgr.mr_n81177376)
print v(xbgr.mr_n81252528)
print v(xbgr.mr_n81393152)
print v(xbgr.vd1)
print v(xbgr.mr_n81565408)
print v(xbgr.mr_n81712848)
print v(xbgr.mr_n81873760)
print v(xbgr.mr_n82000240)
print v(xbgr.mr_n82228640)
print v(xbgr.mr_n82354464)
print v(xbgr.mr_n82464640)
print v(xbgr.mr_n82605168)
print v(xbgr.mr_n82759248)
print v(xbgr.mr_n82947024)
print v(xbgr.mr_n83294288)
print v(xbgr.mr_n83436560)
print v(xbgr.mr_n83611920)
print v(xbgr.mr_n83814752)
print v(xbgr.mr_n83917280)
print v(xbgr.mr_n84157168)
print v(xbgr.mr_n84359136)
print v(xbgr.mr_n84521216)
print v(xbgr.mr_n84735600)
print v(xbgr.mr_n81764560)
print v(xbgr.mr_n84822624)
print v(xbgr.mr_n85078480)
print v(xbgr.mr_n85258192)
print v(xbgr.mr_n85510992)
print v(xbgr.mr_n85698736)
print v(xbgr.mr_n85991648)
print v(xbgr.mr_n86186144)
print v(xbgr.mr_n86434624)
print v(xbgr.mr_n86771120)
print v(xbgr.mr_n80886176)
print v(xbgr.mr_n80950368)
print v(xbgr.mr_n80091984)
print v(xbgr.mr_n81061136)
print v(xbgr.mr_n81133184)
print v(xbgr.mr_n81226960)
print v(xbgr.mr_n81264304)
print v(xbgr.mr_n81507808)
print v(xbgr.mr_n81566416)
print v(xbgr.mr_n81906800)
print v(xbgr.mr_n82024240)
print v(xbgr.mr_n82155760)
print v(xbgr.mr_n82303200)
print v(xbgr.mr_n82430592)
print v(xbgr.mr_n82550784)
print v(xbgr.mr_n82695776)
print v(xbgr.mr_n82946352)
print v(xbgr.mr_n80155696)
print v(xbgr.mr_n80421520)
print v(xbgr.mr_n80648640)
print v(xbgr.n_26)
print v(xbgr.mr_n80155232)
print v(xbgr.mr_n80422112)
print v(xbgr.n_15)
print v(xbgr.mr_n80764832)
print v(xbgr.mr_n80922064)
print v(xbgr.mr_n80982752)
print v(xbgr.mr_n80290176)
print v(xbgr.mr_n81121952)
print v(xbgr.mr_n81221376)
print v(xbgr.mr_n81336816)
print v(xbgr.mr_n81333008)
print v(xbgr.mr_n81543440)
print v(xbgr.mr_n81648496)
print v(xbgr.mr_n81667088)
print v(xbgr.mr_n81952560)
print v(xbgr.mr_n81942384)
print v(xbgr.mr_n82246960)
print v(xbgr.mr_n82368016)
print v(xbgr.mr_n82553776)
print v(xbgr.mr_n82667216)
print v(xbgr.mr_n82756288)
print v(xbgr.mr_n82821456)
print v(xbgr.mr_n80156624)
print v(xbgr.mr_n80422704)
print v(xbgr.mr_n80649568)
print v(xbgr.n_27)
print v(xbgr.mr_n80156160)
print v(xbgr.mr_n80423296)
print v(xbgr.n_16)
print v(xbgr.mr_n80766272)
print v(xbgr.mr_n80157552)
print v(xbgr.mr_n80423888)
print v(xbgr.mr_n80650032)
print v(xbgr.n_21)
print v(xbgr.mr_n80885792)
print v(xbgr.mr_n80949040)
print v(xbgr.mr_n80107984)
print v(xbgr.mr_n81098048)
print v(xbgr.mr_n81069904)
print v(xbgr.mr_n81277136)
print v(xbgr.mr_n81393712)
print v(xbgr.mr_n81505328)
print v(xbgr.mr_n81626384)
print v(xbgr.mr_n81875920)
print v(xbgr.mr_n82071184)
print v(xbgr.mr_n82233216)
print v(xbgr.mr_n82355280)
print v(xbgr.mr_n82462224)
print v(xbgr.mr_n82623120)
print v(xbgr.mr_n82755696)
print v(xbgr.mr_n82819824)
print v(xbgr.mr_n80157088)
print v(xbgr.mr_n80424480)
print v(xbgr.mr_n83301856)
print v(xbgr.mr_n83469248)
print v(xbgr.mr_n83685280)
print v(xbgr.mr_n83798000)
print v(xbgr.mr_n83973392)
print v(xbgr.mr_n83939280)
print v(xbgr.mr_n84348000)
print v(xbgr.mr_n84508800)
print v(xbgr.mr_n84740256)
print v(xbgr.mr_n85109536)
print v(xbgr.mr_n85308528)
print v(xbgr.mr_n85516512)
print v(xbgr.mr_n85703712)
print v(xbgr.mr_n86009904)
print v(xbgr.mr_n86200496)
print v(xbgr.mr_n86414640)
print v(xbgr.mr_n86782336)
print v(xbgr.mr_n80892128)
print v(xbgr.mr_n80968688)
print v(xbgr.mr_n80050144)
print v(xbgr.mr_n81062528)
print v(xbgr.mr_n81134576)
print v(xbgr.mr_n81248944)
print v(xbgr.mr_n81373840)
print v(xbgr.mr_n81505584)
print v(xbgr.mr_n81580208)
print v(xbgr.mr_n81906336)
print v(xbgr.mr_n82025632)
print v(xbgr.mr_n82157152)
print v(xbgr.mr_n82304976)
print v(xbgr.mr_n82432368)
print v(xbgr.mr_n82551120)
print v(xbgr.mr_n82725968)
print v(xbgr.mr_n82948912)
print v(xbgr.mr_n80158480)
print v(xbgr.mr_n80425072)
print v(xbgr.n_8)
print v(xbgr.vbe3)
print v(xbgr.mr_n80923440)
print v(xbgr.mr_n80983152)
print v(xbgr.mr_n80405376)
print v(xbgr.mr_n81122912)
print v(xbgr.mr_n81222176)
print v(xbgr.mr_n81337216)
print v(xbgr.mr_n81397712)
print v(xbgr.mr_n81544320)
print v(xbgr.mr_n81649376)
print v(xbgr.mr_n81954448)
print v(xbgr.mr_n82072496)
print v(xbgr.mr_n82247760)
print v(xbgr.mr_n82368816)
print v(xbgr.mr_n82555376)
print v(xbgr.mr_n82666880)
print v(xbgr.mr_n82776064)
print v(xbgr.mr_n82947360)
print v(xbgr.mr_n80065600)
print v(xbgr.mr_n80426256)
print v(xbgr.mr_n80499136)
print v(xbgr.mr_n80811408)
print v(xbgr.mr_n80159344)
print v(xbgr.mr_n80428032)
print v(xbgr.mr_n80470480)
print v(xbgr.n_37)
print v(xbgr.mr_n80068448)
print v(xbgr.mr_n80429808)
print v(xbgr.mr_n80499616)
print v(xbgr.mr_n80812336)
print v(xbgr.n_6)
print v(xbgr.vb2)
print v(xbgr.n_2)
print v(xbgr.mr_n80812864)
print v(xbgr.mr_n80859568)
print v(xbgr.mr_n80969392)
print v(xbgr.mr_n80410416)
print v(xbgr.mr_n81122480)
print v(xbgr.mr_n81181216)
print v(xbgr.mr_n81301968)
print v(xbgr.mr_n81396192)
print v(xbgr.mr_n81505840)
print v(xbgr.mr_n81648160)
print v(xbgr.mr_n81938592)
print v(xbgr.mr_n82060640)
print v(xbgr.mr_n82246784)
print v(xbgr.mr_n82368640)
print v(xbgr.mr_n82530976)
print v(xbgr.mr_n82672160)
print v(xbgr.mr_n82779488)
print v(xbgr.mr_n82949024)
print v(xbgr.mr_n83289120)
print v(xbgr.mr_n83459648)
print v(xbgr.mr_n83687872)
print v(xbgr.mr_n83812144)
print v(xbgr.mr_n83914752)
print v(xbgr.mr_n84168304)
print v(xbgr.mr_n84358672)
print v(xbgr.mr_n84520304)
print v(xbgr.mr_n84745232)
print v(xbgr.mr_n85096608)
print v(xbgr.mr_n85310272)
print v(xbgr.mr_n85521312)
print v(xbgr.mr_n85708576)
print v(xbgr.mr_n86010016)
print v(xbgr.mr_n86208496)
print v(xbgr.mr_n86435008)
print v(xbgr.mr_n86770176)
print v(xbgr.mr_n80260096)
print v(xbgr.mr_n80296784)
print v(xbgr.mr_n80500256)
print v(xbgr.mr_n80813456)
print v(xbgr.mr_n80893040)
print v(xbgr.mr_n80969744)
print v(xbgr.mr_n80803504)
print v(xbgr.mr_n81063920)
print v(xbgr.mr_n81135968)
print v(xbgr.mr_n81227488)
print v(xbgr.mr_n81374992)
print v(xbgr.mr_n81531680)
print v(xbgr.mr_n81581600)
print v(xbgr.mr_n81905872)
print v(xbgr.mr_n82027344)
print v(xbgr.mr_n82158864)
print v(xbgr.mr_n82306752)
print v(xbgr.mr_n82434144)
print v(xbgr.mr_n82461968)
print v(xbgr.mr_n82727360)
print v(xbgr.mr_n82950976)
print v(xbgr.mr_n80262496)
print v(xbgr.mr_n80297312)
print v(xbgr.n_7)
print v(xbgr.n_36)
print v(xbgr.mr_n80924576)
print v(xbgr.mr_n80983552)
print v(xbgr.mr_n80990800)
print v(xbgr.mr_n81123792)
print v(xbgr.mr_n81222976)
print v(xbgr.mr_n81337616)
print v(xbgr.mr_n81395920)
print v(xbgr.mr_n81544880)
print v(xbgr.mr_n81650176)
print v(xbgr.mr_n81956176)
print v(xbgr.mr_n82075488)
print v(xbgr.mr_n82248560)
print v(xbgr.mr_n82369616)
print v(xbgr.mr_n82556720)
print v(xbgr.mr_n82667552)
print v(xbgr.mr_n82776400)
print v(xbgr.mr_n82949136)
print v(xbgr.mr_n80263232)
print v(xbgr.mr_n80268048)
print v(xbgr.mr_n80501056)
print v(xbgr.mr_n80814640)
print v(xbgr.mr_n80263968)
print v(xbgr.mr_n80271584)
print v(xbgr.mr_n80501456)
print v(xbgr.mr_n80815232)
print v(xbgr.mr_n80264704)
print v(xbgr.mr_n80299088)
print v(xbgr.mr_n80501856)
print v(xbgr.mr_n80815824)
print v(xbgr.mr_n80265440)
print v(xbgr.mr_n80299680)
print v(xbgr.mr_n80502256)
print v(xbgr.mr_n80816416)
print v(xbgr.mr_n80885984)
print v(xbgr.mr_n80970448)
print v(xbgr.mr_n80727472)
print v(xbgr.mr_n81123616)
print v(xbgr.mr_n81182544)
print v(xbgr.mr_n81302768)
print v(xbgr.mr_n81398464)
print v(xbgr.mr_n81452416)
print v(xbgr.mr_n81650000)
print v(xbgr.mr_n81876800)
print v(xbgr.mr_n82031488)
print v(xbgr.mr_n82248384)
print v(xbgr.mr_n82347376)
print v(xbgr.mr_n82532160)
print v(xbgr.mr_n82605984)
print v(xbgr.mr_n82779376)
print v(xbgr.mr_n82955104)
print v(xbgr.mr_n83301664)
print v(xbgr.mr_n83416368)
print v(xbgr.mr_n83689808)
print v(xbgr.mr_n83787296)
print v(xbgr.mr_n83960944)
print v(xbgr.mr_n83957936)
print v(xbgr.mr_n84371440)
print v(xbgr.mr_n84527024)
print v(xbgr.mr_n84750208)
print v(xbgr.mr_n85142736)
print v(xbgr.mr_n85190000)
print v(xbgr.mr_n85525824)
print v(xbgr.mr_n85450720)
print v(xbgr.mr_n86023344)
print v(xbgr.mr_n86201408)
print v(xbgr.mr_n86438720)
print v(xbgr.mr_n86781888)
print v(xbgr.mr_n80897120)
print v(xbgr.mr_n80970800)
print v(xbgr.mr_n80161728)
print v(xbgr.mr_n81065312)
print v(xbgr.mr_n81137360)
print v(xbgr.mr_n81245072)
print v(xbgr.mr_n81376384)
print v(xbgr.mr_n81533152)
print v(xbgr.mr_n81582992)
print v(xbgr.mr_n81936368)
print v(xbgr.mr_n82029120)
print v(xbgr.mr_n82160640)
print v(xbgr.mr_n82308528)
print v(xbgr.mr_n82435920)
print v(xbgr.mr_n82554784)
print v(xbgr.mr_n82728880)
print v(xbgr.mr_n82951088)
print v(xbgr.mr_n80265952)
print v(xbgr.mr_n80266880)
print v(xbgr.mr_n80487648)
print v(xbgr.mr_n80808848)
print v(xbgr.mr_n80266496)
print v(xbgr.mr_n80277744)
print v(xbgr.n_11)
print v(xbgr.mr_n80817008)
print v(xbgr.mr_n80924224)
print v(xbgr.mr_n80983952)
print v(xbgr.mr_n80993296)
print v(xbgr.mr_n81124992)
print v(xbgr.mr_n81223776)
print v(xbgr.mr_n81338016)
print v(xbgr.mr_n81319264)
print v(xbgr.mr_n81545696)
print v(xbgr.mr_n81650976)
print v(xbgr.mr_n81958320)
print v(xbgr.mr_n82077216)
print v(xbgr.mr_n82249360)
print v(xbgr.mr_n82370416)
print v(xbgr.mr_n82558864)
print v(xbgr.mr_n82670336)
print v(xbgr.mr_n82777680)
print v(xbgr.mr_n82951200)
print v(xbgr.mr_n80266992)
print v(xbgr.mr_n80301520)
print v(xbgr.mr_n80582512)
print v(xbgr.mr_n80818192)
print v(xbgr.mr_n80265216)
print v(xbgr.mr_n80302048)
print v(xbgr.mr_n80583104)
print v(xbgr.mr_n80818784)
print v(xbgr.mr_n80268320)
print v(xbgr.mr_n80272944)
print v(xbgr.mr_n80583696)
print v(xbgr.mr_n80819376)
print v(xbgr.mr_n80891376)
print v(xbgr.mr_n80971504)
print v(xbgr.mr_n80804064)
print v(xbgr.mr_n81124816)
print v(xbgr.mr_n81187360)
print v(xbgr.mr_n81303568)
print v(xbgr.mr_n81392016)
print v(xbgr.mr_n81534080)
print v(xbgr.mr_n81629824)
print v(xbgr.mr_n81954960)
print v(xbgr.mr_n81700448)
print v(xbgr.mr_n82202704)
print v(xbgr.mr_n82354576)
print v(xbgr.mr_n82533344)
print v(xbgr.mr_n82674080)
print v(xbgr.mr_n82781296)
print v(xbgr.mr_n82953264)
print v(xbgr.n_9)
print v(xbgr.mr_n80303168)
print v(xbgr.mr_n80584288)
print v(xbgr.mr_n80819968)
print v(xbgr.mr_n83306016)
print v(xbgr.mr_n83481024)
print v(xbgr.mr_n83692640)
print v(xbgr.mr_n83834112)
print v(xbgr.mr_n83980240)
print v(xbgr.mr_n84179440)
print v(xbgr.mr_n84380640)
print v(xbgr.mr_n84521328)
print v(xbgr.mr_n84755184)
print v(xbgr.mr_n85126832)
print v(xbgr.mr_n85299376)
print v(xbgr.mr_n85530720)
print v(xbgr.mr_n85718528)
print v(xbgr.mr_n86029920)
print v(xbgr.mr_n86185200)
print v(xbgr.mr_n86462528)
print v(xbgr.mr_n86682304)
print v(xbgr.mr_n80898032)
print v(xbgr.mr_n80971856)
print v(xbgr.mr_n80719552)
print v(xbgr.mr_n81066704)
print v(xbgr.mr_n81138752)
print v(xbgr.mr_n81249984)
print v(xbgr.mr_n81377776)
print v(xbgr.mr_n81533968)
print v(xbgr.mr_n81584384)
print v(xbgr.mr_n81957664)
print v(xbgr.mr_n82030896)
print v(xbgr.mr_n82162416)
print v(xbgr.mr_n82310304)
print v(xbgr.mr_n82437696)
print v(xbgr.mr_n82557344)
print v(xbgr.mr_n82730656)
print v(xbgr.mr_n82957168)
print v(xbgr.mr_n80269408)
print v(xbgr.mr_n80303824)
print v(xbgr.mr_n80573872)
print v(xbgr.mr_n80820560)
print v(xbgr.mr_n80927488)
print v(xbgr.mr_n80981120)
print v(xbgr.mr_n80408400)
print v(xbgr.mr_n81122656)
print v(xbgr.mr_n81224576)
print v(xbgr.mr_n81338416)
print v(xbgr.mr_n81401168)
print v(xbgr.mr_n81546576)
print v(xbgr.mr_n81649200)
print v(xbgr.mr_n81960384)
print v(xbgr.mr_n82079104)
print v(xbgr.mr_n82250160)
print v(xbgr.mr_n82371216)
print v(xbgr.mr_n82560464)
print v(xbgr.mr_n82600032)
print v(xbgr.mr_n82753328)
print v(xbgr.mr_n82823088)
print v(xbgr.mr_n80269952)
print v(xbgr.mr_n80304416)
print v(xbgr.mr_n80577248)
print v(xbgr.mr_n80821152)
print v(xbgr.mr_n80270496)
print v(xbgr.mr_n80305008)
print v(xbgr.mr_n80584864)
print v(xbgr.mr_n80821744)
print v(xbgr.mr_n80271040)
print v(xbgr.mr_n80305600)
print v(xbgr.mr_n80585264)
print v(xbgr.mr_n80822336)
print v(xbgr.mr_n80222656)
print v(xbgr.mr_n80306192)
print v(xbgr.mr_n80585888)
print v(xbgr.mr_n80822928)
print v(xbgr.mr_n80893792)
print v(xbgr.mr_n80972560)
print v(xbgr.mr_n80389280)
print v(xbgr.mr_n81077008)
print v(xbgr.mr_n81188688)
print v(xbgr.mr_n81304432)
print v(xbgr.mr_n81395280)
print v(xbgr.mr_n81533504)
print v(xbgr.mr_n81651600)
print v(xbgr.mr_n81951344)
print v(xbgr.mr_n81998432)
print v(xbgr.mr_n82249984)
print v(xbgr.mr_n82350640)
print v(xbgr.mr_n82534528)
print v(xbgr.mr_n82670224)
print v(xbgr.mr_n82777568)
print v(xbgr.mr_n82955328)
print v(xbgr.mr_n83309952)
print v(xbgr.mr_n83476944)
print v(xbgr.mr_n83692912)
print v(xbgr.mr_n83831600)
print v(xbgr.mr_n83984896)
print v(xbgr.mr_n84167840)
print v(xbgr.mr_n84371248)
print v(xbgr.mr_n84536272)
print v(xbgr.mr_n84768288)
print v(xbgr.mr_n85131664)
print v(xbgr.mr_n85330000)
print v(xbgr.mr_n85555776)
print v(xbgr.mr_n85727648)
print v(xbgr.mr_n86031664)
print v(xbgr.mr_n86232352)
print v(xbgr.mr_n86135328)
print v(xbgr.mr_n86681152)
print v(xbgr.mr_n80272128)
print v(xbgr.mr_n80300784)
print v(xbgr.mr_n80586800)
print v(xbgr.mr_n80811872)
print v(xbgr.mr_n80902112)
print v(xbgr.mr_n80972912)
print v(xbgr.mr_n80077632)
print v(xbgr.mr_n81068096)
print v(xbgr.mr_n81138288)
print v(xbgr.mr_n81259120)
print v(xbgr.mr_n81377312)
print v(xbgr.mr_n81535008)
print v(xbgr.mr_n81585776)
print v(xbgr.mr_n81829072)
print v(xbgr.mr_n82030304)
print v(xbgr.mr_n82161824)
print v(xbgr.mr_n82312080)
print v(xbgr.mr_n82437104)
print v(xbgr.mr_n82561536)
print v(xbgr.mr_n82732432)
print v(xbgr.mr_n82953152)
print v(xbgr.mr_n80264592)
print v(xbgr.mr_n80307296)
print v(xbgr.mr_n80587392)
print v(xbgr.mr_n80824112)
print v(xbgr.mr_n80929344)
print v(xbgr.mr_n80984752)
print v(xbgr.mr_n80997600)
print v(xbgr.mr_n81069664)
print v(xbgr.mr_n81225376)
print v(xbgr.mr_n81338816)
print v(xbgr.mr_n81408752)
print v(xbgr.mr_n81547552)
print v(xbgr.mr_n81652576)
print v(xbgr.mr_n81962368)
print v(xbgr.mr_n82080912)
print v(xbgr.mr_n82250960)
print v(xbgr.mr_n82372016)
print v(xbgr.mr_n82562208)
print v(xbgr.mr_n82675776)
print v(xbgr.mr_n82783104)
print v(xbgr.mr_n82953040)
print v(xbgr.mr_n80273216)
print v(xbgr.mr_n80307968)
print v(xbgr.n_3)
print v(xbgr.n_33)
print v(xbgr.mr_n80273760)
print v(xbgr.mr_n80272400)
print v(xbgr.mr_n80588576)
print v(xbgr.mr_n80825232)
print v(xbgr.mr_n80274496)
print v(xbgr.mr_n80300272)
print v(xbgr.mr_n80589168)
print v(xbgr.mr_n80825888)
print v(xbgr.mr_n80275888)
print v(xbgr.mr_n80309664)
print v(xbgr.mr_n80589760)
print v(xbgr.mr_n80826480)
print v(xbgr.mr_n80896368)
print v(xbgr.mr_n80980448)
print v(xbgr.mr_n80732384)
print v(xbgr.mr_n80165440)
print v(xbgr.mr_n81193504)
print v(xbgr.mr_n81305616)
print v(xbgr.mr_n81401552)
print v(xbgr.mr_n81534432)
print v(xbgr.mr_n81652400)
print v(xbgr.mr_n81821168)
print v(xbgr.mr_n81956768)
print v(xbgr.mr_n82076000)
print v(xbgr.mr_n82249184)
print v(xbgr.mr_n82367840)
print v(xbgr.mr_n82535712)
print v(xbgr.mr_n82679392)
print v(xbgr.mr_n82786720)
print v(xbgr.mr_n82959456)
print v(xbgr.mr_n83307696)
print v(xbgr.mr_n83502528)
print v(xbgr.mr_n83706096)
print v(xbgr.mr_n83833600)
print v(xbgr.mr_n84009472)
print v(xbgr.mr_n84185600)
print v(xbgr.mr_n84391776)
print v(xbgr.mr_n84555536)
print v(xbgr.mr_n84765296)
print v(xbgr.mr_n84936624)
print v(xbgr.mr_n85127776)
print v(xbgr.mr_n85317312)
print v(xbgr.mr_n85536944)
print v(xbgr.mr_n85724752)
print v(xbgr.mr_n86037344)
print v(xbgr.mr_n86201296)
print v(xbgr.mr_n86437984)
print v(xbgr.mr_n86634672)
print v(xbgr.mr_n80903024)
print v(xbgr.mr_n80948416)
print v(xbgr.mr_n80173888)
print v(xbgr.mr_n81068560)
print v(xbgr.mr_n81137824)
print v(xbgr.mr_n81156128)
print v(xbgr.mr_n81376848)
print v(xbgr.mr_n81535936)
print v(xbgr.mr_n81587168)
print v(xbgr.mr_n81821360)
print v(xbgr.mr_n81907264)
print v(xbgr.mr_n82029712)
print v(xbgr.mr_n82161232)
print v(xbgr.mr_n82313856)
print v(xbgr.mr_n82436512)
print v(xbgr.mr_n82559872)
print v(xbgr.mr_n82734208)
print v(xbgr.mr_n82957280)
print v(xbgr.mr_n80276352)
print v(xbgr.n_19)
print v(xbgr.mr_n80499376)
print v(xbgr.mr_n80827072)
print v(xbgr.mr_n80930800)
print v(xbgr.mr_n80985152)
print v(xbgr.mr_n80999408)
print v(xbgr.mr_n80140368)
print v(xbgr.mr_n81226176)
print v(xbgr.mr_n81339216)
print v(xbgr.mr_n81411472)
print v(xbgr.mr_n81548928)
print v(xbgr.mr_n81653376)
print v(xbgr.mr_n81831808)
print v(xbgr.mr_n81964512)
print v(xbgr.mr_n82082640)
print v(xbgr.mr_n82251760)
print v(xbgr.mr_n82372816)
print v(xbgr.mr_n82563408)
print v(xbgr.mr_n82673968)
print v(xbgr.mr_n82784800)
print v(xbgr.mr_n82955216)
print v(xbgr.mr_n80277280)
print v(xbgr.mr_n80310928)
print v(xbgr.mr_n80584752)
print v(xbgr.mr_n80827664)
print v(xbgr.mr_n80278208)
print v(xbgr.mr_n80311520)
print v(xbgr.mr_n80591536)
print v(xbgr.mr_n80766880)
print v(xbgr.mr_n80279600)
print v(xbgr.mr_n80312112)
print v(xbgr.mr_n80592128)
print v(xbgr.mr_n80828848)
print v(xbgr.mr_n80279136)
print v(xbgr.mr_n80312704)
print v(xbgr.mr_n80592720)
print v(xbgr.mr_n80829440)
print v(xbgr.mr_n80898784)
print v(xbgr.mr_n80984352)
print v(xbgr.mr_n80991472)
print v(xbgr.mr_n81051216)
print v(xbgr.mr_n81194832)
print v(xbgr.mr_n81306800)
print v(xbgr.mr_n81404336)
print v(xbgr.mr_n81534896)
print v(xbgr.mr_n81624016)
print v(xbgr.mr_n81822064)
print v(xbgr.mr_n81959728)
print v(xbgr.mr_n82071584)
print v(xbgr.mr_n82251584)
print v(xbgr.mr_n82372640)
print v(xbgr.mr_n82536304)
print v(xbgr.mr_n82681200)
print v(xbgr.mr_n82784912)
print v(xbgr.mr_n82959344)
print v(xbgr.mr_n80278672)
print v(xbgr.mr_n80313296)
print v(xbgr.mr_n80590352)
print v(xbgr.mr_n80830032)
print v(xbgr.mr_n83304400)
print v(xbgr.mr_n83507312)
print v(xbgr.mr_n83702576)
print v(xbgr.mr_n83831216)
print v(xbgr.mr_n83973280)
print v(xbgr.mr_n84163328)
print v(xbgr.mr_n84380448)
print v(xbgr.mr_n84545520)
print v(xbgr.mr_n84670112)
print v(xbgr.mr_n84939824)
print v(xbgr.mr_n85145056)
print v(xbgr.mr_n85341056)
print v(xbgr.mr_n85533168)
print v(xbgr.mr_n85731760)
print v(xbgr.mr_n86049824)
print v(xbgr.mr_n86208032)
print v(xbgr.mr_n86415904)
print v(xbgr.mr_n86528720)
print v(xbgr.mr_n80907104)
print v(xbgr.mr_n80948144)
print v(xbgr.mr_n80130512)
print v(xbgr.mr_n81067632)
print v(xbgr.mr_n81136896)
print v(xbgr.mr_n81178624)
print v(xbgr.mr_n81375920)
print v(xbgr.mr_n81536592)
print v(xbgr.mr_n81591072)
print v(xbgr.mr_n81791200)
print v(xbgr.mr_n81953152)
print v(xbgr.mr_n82028528)
print v(xbgr.mr_n82160048)
print v(xbgr.mr_n82315632)
print v(xbgr.mr_n82435328)
print v(xbgr.mr_n82564032)
print v(xbgr.mr_n82735984)
print v(xbgr.mr_n82959232)
print v(xbgr.mr_n80269680)
print v(xbgr.mr_n80313888)
print v(xbgr.mr_n80593904)
print v(xbgr.mr_n80830624)
print v(xbgr.mr_n80931856)
print v(xbgr.mr_n80985792)
print v(xbgr.mr_n81001216)
print v(xbgr.mr_n81121216)
print v(xbgr.mr_n81226576)
print v(xbgr.mr_n81339616)
print v(xbgr.mr_n81413808)
print v(xbgr.mr_n81549888)
print v(xbgr.mr_n81654176)
print v(xbgr.mr_n81835504)
print v(xbgr.mr_n81966576)
print v(xbgr.mr_n82084528)
print v(xbgr.mr_n82252560)
print v(xbgr.mr_n82373616)
print v(xbgr.mr_n82566496)
print v(xbgr.mr_n82677584)
print v(xbgr.mr_n82788528)
print v(xbgr.mr_n82961296)
print v(xbgr.mr_n80276816)
print v(xbgr.mr_n80102144)
print v(xbgr.mr_n80594496)
print v(xbgr.mr_n80831216)
print v(xbgr.mr_n80275424)
print v(xbgr.mr_n80119040)
print v(xbgr.n_4)
print v(xbgr.n_30)
print v(xbgr.mr_n80274960)
print v(xbgr.mr_n80130304)
print v(xbgr.mr_n80578960)
print v(xbgr.mr_n80832400)
print v(xbgr.mr_n80274032)
print v(xbgr.mr_n80141568)
print v(xbgr.mr_n80596272)
print v(xbgr.mr_n80832992)
print v(xbgr.mr_n80901360)
print v(xbgr.mr_n80972736)
print v(xbgr.mr_n80998192)
print v(xbgr.mr_n81039376)
print v(xbgr.mr_n81199648)
print v(xbgr.mr_n81307984)
print v(xbgr.mr_n81414448)
print v(xbgr.mr_n81533040)
print v(xbgr.mr_n81566784)
print v(xbgr.mr_n81794800)
print v(xbgr.mr_n81965024)
print v(xbgr.mr_n82081424)
print v(xbgr.mr_n82247584)
print v(xbgr.mr_n82371840)
print v(xbgr.mr_n82535120)
print v(xbgr.mr_n82679504)
print v(xbgr.mr_n82776816)
print v(xbgr.mr_n82963584)
print v(xbgr.mr_n79220880)
print v(xbgr.mr_n83513088)
print v(xbgr.mr_n83717232)
print v(xbgr.mr_n83845824)
print v(xbgr.mr_n84007248)
print v(xbgr.mr_n84208448)
print v(xbgr.mr_n84409904)
print v(xbgr.mr_n84511200)
print v(xbgr.mr_n84673536)
print v(xbgr.mr_n84971136)
print v(xbgr.mr_n85105296)
print v(xbgr.mr_n85329536)
print v(xbgr.mr_n85528272)
print v(xbgr.mr_n85736624)
print v(xbgr.mr_n86051568)
print v(xbgr.mr_n86226656)
print v(xbgr.mr_n86439408)
print v(xbgr.mr_n86534352)
print v(xbgr.mr_n80273488)
print v(xbgr.mr_n80100736)
print v(xbgr.mr_n80596864)
print v(xbgr.mr_n80833584)
print v(xbgr.mr_n80908016)
print v(xbgr.mr_n80947872)
print v(xbgr.mr_n80137552)
print v(xbgr.mr_n81067168)
print v(xbgr.mr_n81136432)
print v(xbgr.mr_n81261904)
print v(xbgr.mr_n81375456)
print v(xbgr.mr_n81535472)
print v(xbgr.mr_n81567472)
print v(xbgr.mr_n81657216)
print v(xbgr.mr_n81961792)
print v(xbgr.mr_n82027936)
print v(xbgr.mr_n82159456)
print v(xbgr.mr_n82317408)
print v(xbgr.mr_n82434736)
print v(xbgr.mr_n82564144)
print v(xbgr.mr_n82737760)
print v(xbgr.mr_n82961408)
print v(xbgr.mr_n80272672)
print v(xbgr.mr_n80126080)
print v(xbgr.mr_n80597456)
print v(xbgr.mr_n80808960)
print v(xbgr.mr_n80933632)
print v(xbgr.mr_n80986592)
print v(xbgr.mr_n81003104)
print v(xbgr.mr_n81073424)
print v(xbgr.mr_n81225776)
print v(xbgr.mr_n81340016)
print v(xbgr.mr_n81406640)
print v(xbgr.mr_n81550864)
print v(xbgr.mr_n81654736)
print v(xbgr.mr_n81837232)
print v(xbgr.mr_n81968640)
print v(xbgr.mr_n82086336)
print v(xbgr.mr_n82253360)
print v(xbgr.mr_n82374416)
print v(xbgr.mr_n82567376)
print v(xbgr.mr_n82683008)
print v(xbgr.mr_n82790224)
print v(xbgr.mr_n82961520)
print v(xbgr.mr_n80252208)
print v(xbgr.mr_n80135936)
print v(xbgr.mr_n80598048)
print v(xbgr.mr_n80834768)
print v(xbgr.mr_n80271856)
print v(xbgr.mr_n80298432)
print v(xbgr.mr_n80598640)
print v(xbgr.mr_n80835360)
print v(xbgr.mr_n80271312)
print v(xbgr.mr_n80125376)
print v(xbgr.mr_n80599232)
print v(xbgr.mr_n80835952)
print v(xbgr.mr_n80903776)
print v(xbgr.mr_n80973968)
print v(xbgr.mr_n80990288)
print v(xbgr.mr_n81045776)
print v(xbgr.mr_n81200976)
print v(xbgr.mr_n81309168)
print v(xbgr.mr_n81410768)
print v(xbgr.mr_n81532416)
print v(xbgr.mr_n81651776)
print v(xbgr.mr_n81832448)
print v(xbgr.mr_n81967088)
print v(xbgr.mr_n82060896)
print v(xbgr.mr_n82232512)
print v(xbgr.mr_n82374240)
print v(xbgr.mr_n82533936)
print v(xbgr.mr_n82672272)
print v(xbgr.mr_n82792032)
print v(xbgr.mr_n82957392)
print v(xbgr.mr_n80270768)
print v(xbgr.mr_n80147200)
print v(xbgr.mr_n80599824)
print v(xbgr.mr_n80828256)
print v(xbgr.mr_n83297344)
print v(xbgr.mr_n83505872)
print v(xbgr.mr_n83713712)
print v(xbgr.mr_n83856496)
print v(xbgr.mr_n83973888)
print v(xbgr.mr_n84196272)
print v(xbgr.mr_n84397936)
print v(xbgr.mr_n84554832)
print v(xbgr.mr_n81623504)
print v(xbgr.mr_n84673648)
print v(xbgr.mr_n84968432)
print v(xbgr.mr_n85137584)
print v(xbgr.mr_n85292992)
print v(xbgr.mr_n85523376)
print v(xbgr.mr_n85741600)
print v(xbgr.mr_n86057248)
print v(xbgr.mr_n86217344)
print v(xbgr.mr_n86300752)
print v(xbgr.mr_n86610208)
print v(xbgr.mr_n80912096)
print v(xbgr.mr_n80947600)
print v(xbgr.mr_n80193136)
print v(xbgr.mr_n81066240)
print v(xbgr.mr_n81135504)
print v(xbgr.mr_n81262912)
print v(xbgr.mr_n81374528)
print v(xbgr.mr_n81534544)
print v(xbgr.mr_n81656704)
print v(xbgr.mr_n81967984)
print v(xbgr.mr_n82026752)
print v(xbgr.mr_n82158272)
print v(xbgr.mr_n82316576)
print v(xbgr.mr_n82433552)
print v(xbgr.mr_n82567200)
print v(xbgr.mr_n82782992)
print v(xbgr.mr_n82967488)
print v(xbgr.mr_n80270224)
print v(xbgr.mr_n80117632)
print v(xbgr.mr_n80492304)
print v(xbgr.mr_n80837136)
print v(xbgr.mr_n80935168)
print v(xbgr.mr_n80985616)
print v(xbgr.mr_n81004912)
print v(xbgr.mr_n81042960)
print v(xbgr.mr_n81224976)
print v(xbgr.mr_n81340416)
print v(xbgr.mr_n81416256)
print v(xbgr.mr_n81551744)
print v(xbgr.mr_n81647984)
print v(xbgr.mr_n81839040)
print v(xbgr.mr_n81970704)
print v(xbgr.mr_n82088064)
print v(xbgr.mr_n82254160)
print v(xbgr.mr_n82375216)
print v(xbgr.mr_n82569840)
print v(xbgr.mr_n82675888)
print v(xbgr.mr_n82781184)
print v(xbgr.mr_n82963360)
print v(xbgr.mr_n80261648)
print v(xbgr.mr_n80306784)
print v(xbgr.mr_n80601008)
print v(xbgr.mr_n80837728)
print v(xbgr.mr_n80269136)
print v(xbgr.mr_n80124672)
print v(xbgr.mr_n80595680)
print v(xbgr.mr_n80838304)
print v(xbgr.mr_n80268592)
print v(xbgr.mr_n80120448)
print v(xbgr.n_5)
print v(xbgr.mr_n80838896)
print v(xbgr.mr_n80267776)
print v(xbgr.mr_n80147904)
print v(xbgr.mr_n80590944)
print v(xbgr.mr_n80839488)
print v(xbgr.mr_n80911040)
print v(xbgr.mr_n80987216)
print v(xbgr.mr_n80993808)
print v(xbgr.mr_n80411424)
print v(xbgr.mr_n81175152)
print v(xbgr.mr_n81310352)
print v(xbgr.mr_n81409392)
print v(xbgr.mr_n81532304)
print v(xbgr.mr_n81647552)
print v(xbgr.mr_n81836016)
print v(xbgr.mr_n81969152)
print v(xbgr.mr_n82079616)
print v(xbgr.mr_n82252384)
print v(xbgr.mr_n82370240)
print v(xbgr.mr_n82532752)
print v(xbgr.mr_n82684928)
print v(xbgr.mr_n82793952)
print v(xbgr.mr_n82969552)
print v(xbgr.mr_n83058064)
print v(xbgr.mr_n83472992)
print v(xbgr.mr_n83728368)
print v(xbgr.mr_n83845360)
print v(xbgr.mr_n84027840)
print v(xbgr.mr_n84185136)
print v(xbgr.mr_n84394096)
print v(xbgr.mr_n84563744)
print v(xbgr.mr_n81676464)
print v(xbgr.mr_n84662288)
print v(xbgr.mr_n84973216)
print v(xbgr.mr_n85080672)
print v(xbgr.mr_n85314496)
print v(xbgr.mr_n85538896)
print v(xbgr.mr_n85746576)
print v(xbgr.mr_n86069616)
print v(xbgr.mr_n86222000)
print v(xbgr.mr_n86437520)
print v(xbgr.mr_n86668608)
print v(xbgr.mr_n80267504)
print v(xbgr.mr_n80309152)
print v(xbgr.mr_n80603376)
print v(xbgr.mr_n80824704)
print v(xbgr.mr_n80911152)
print v(xbgr.mr_n80947328)
print v(xbgr.mr_n80171824)
print v(xbgr.mr_n81065776)
print v(xbgr.mr_n81135040)
print v(xbgr.mr_n81263840)
print v(xbgr.mr_n81374144)
print v(xbgr.mr_n81533616)
print v(xbgr.mr_n81698688)
print v(xbgr.mr_n81970048)
print v(xbgr.mr_n82026160)
print v(xbgr.mr_n82157680)
print v(xbgr.mr_n82320496)
print v(xbgr.mr_n82432960)
print v(xbgr.mr_n82568928)
print v(xbgr.mr_n82786608)
print v(xbgr.mr_n82967712)
print v(xbgr.mr_n80266224)
print v(xbgr.mr_n80144416)
print v(xbgr.mr_n80603968)
print v(xbgr.mr_n80840672)
print v(xbgr.mr_n80936544)
print v(xbgr.mr_n80988192)
print v(xbgr.mr_n81006720)
print v(xbgr.mr_n81077696)
print v(xbgr.mr_n81224176)
print v(xbgr.mr_n81340816)
print v(xbgr.mr_n81419216)
print v(xbgr.mr_n81552720)
print v(xbgr.mr_n81650800)
print v(xbgr.mr_n81840848)
print v(xbgr.mr_n81972688)
print v(xbgr.mr_n82089952)
print v(xbgr.mr_n82254960)
print v(xbgr.mr_n82376016)
print v(xbgr.mr_n82570720)
print v(xbgr.mr_n82681312)
print v(xbgr.mr_n82792144)
print v(xbgr.mr_n82965424)
print v(xbgr.mr_n80227616)
print v(xbgr.mr_n80434544)
print v(xbgr.mr_n80604560)
print v(xbgr.mr_n80841264)
print v(xbgr.mr_n80218944)
print v(xbgr.mr_n80435136)
print v(xbgr.mr_n80605152)
print v(xbgr.mr_n80841856)
print v(xbgr.mr_n80228480)
print v(xbgr.mr_n80435728)
print v(xbgr.mr_n80605744)
print v(xbgr.mr_n80834176)
print v(xbgr.mr_n80219872)
print v(xbgr.mr_n80436320)
print v(xbgr.mr_n80606336)
print v(xbgr.mr_n80843040)
print v(xbgr.mr_n80906048)
print v(xbgr.mr_n80980784)
print v(xbgr.mr_n80990176)
print v(xbgr.mr_n81087648)
print v(xbgr.mr_n81175408)
print v(xbgr.mr_n81311536)
print v(xbgr.mr_n81416368)
print v(xbgr.mr_n81531568)
print v(xbgr.mr_n81676128)
print v(xbgr.mr_n81834848)
print v(xbgr.mr_n81963856)
print v(xbgr.mr_n82083232)
print v(xbgr.mr_n82225696)
print v(xbgr.mr_n82339712)
print v(xbgr.mr_n82531568)
print v(xbgr.mr_n82686736)
print v(xbgr.mr_n82790336)
print v(xbgr.mr_n82967600)
print v(xbgr.mr_n79459552)
print v(xbgr.mr_n83473456)
print v(xbgr.mr_n83719552)
print v(xbgr.mr_n83850336)
print v(xbgr.mr_n83998864)
print v(xbgr.mr_n84174000)
print v(xbgr.mr_n84373648)
print v(xbgr.mr_n84568208)
print v(xbgr.mr_n81692864)
print v(xbgr.mr_n84667968)
print v(xbgr.mr_n84978192)
print v(xbgr.mr_n85132176)
print v(xbgr.mr_n85314688)
print v(xbgr.mr_n85502144)
print v(xbgr.mr_n85751552)
print v(xbgr.mr_n86049712)
print v(xbgr.mr_n86240624)
print v(xbgr.mr_n86438496)
print v(xbgr.mr_n86601760)
print v(xbgr.mr_n80906160)
print v(xbgr.mr_n80947056)
print v(xbgr.mr_n80192128)
print v(xbgr.mr_n81064848)
print v(xbgr.mr_n81134112)
print v(xbgr.mr_n81263376)
print v(xbgr.mr_n81373536)
print v(xbgr.mr_n81532528)
print v(xbgr.mr_n81755856)
print v(xbgr.mr_n81962960)
print v(xbgr.mr_n82025168)
print v(xbgr.mr_n82156688)
print v(xbgr.mr_n82321104)
print v(xbgr.mr_n82431776)
print v(xbgr.mr_n82571152)
print v(xbgr.mr_n82788416)
print v(xbgr.mr_n82969664)
print v(xbgr.mr_n80229408)
print v(xbgr.mr_n80436912)
print v(xbgr.mr_n80606928)
print v(xbgr.mr_n80843632)
print v(xbgr.mr_n80229936)
print v(xbgr.mr_n80437504)
print v(xbgr.mr_n80601600)
print v(xbgr.mr_n80844224)
print v(xbgr.mr_n80936112)
print v(xbgr.mr_n80988992)
print v(xbgr.mr_n81008528)
print v(xbgr.mr_n80107072)
print v(xbgr.mr_n81223376)
print v(xbgr.mr_n81341216)
print v(xbgr.mr_n81423920)
print v(xbgr.mr_n81553360)
print v(xbgr.mr_n81680544)
print v(xbgr.mr_n81842736)
print v(xbgr.mr_n81974752)
print v(xbgr.mr_n82091680)
print v(xbgr.mr_n82255760)
print v(xbgr.mr_n82376816)
print v(xbgr.mr_n82572384)
print v(xbgr.mr_n82677696)
print v(xbgr.mr_n82795648)
print v(xbgr.mr_n82965648)
print v(xbgr.mr_n80230400)
print v(xbgr.mr_n80438096)
print v(xbgr.mr_n80608112)
print v(xbgr.mr_n80844816)
print v(xbgr.mr_n80230864)
print v(xbgr.mr_n80438688)
print v(xbgr.mr_n80608704)
print v(xbgr.mr_n80845408)
print v(xbgr.mr_n80231328)
print v(xbgr.mr_n80439280)
print v(xbgr.mr_n80609296)
print v(xbgr.n_31)
print v(xbgr.mr_n80901056)
print v(xbgr.mr_n80973616)
print v(xbgr.mr_n80996384)
print v(xbgr.mr_n81056464)
print v(xbgr.mr_n80800864)
print v(xbgr.mr_n81312720)
print v(xbgr.mr_n81421024)
print v(xbgr.mr_n81531792)
print v(xbgr.mr_n81681808)
print v(xbgr.mr_n81824032)
print v(xbgr.mr_n81973280)
print v(xbgr.mr_n82085040)
print v(xbgr.mr_n82254784)
print v(xbgr.mr_n82373440)
print v(xbgr.mr_n82530384)
print v(xbgr.mr_n82684816)
print v(xbgr.mr_n82795760)
print v(xbgr.mr_n82971616)
print v(xbgr.mr_n80231792)
print v(xbgr.mr_n80439872)
print v(xbgr.mr_n80609888)
print v(xbgr.mr_n80846560)
print v(xbgr.mr_n79582816)
print v(xbgr.mr_n83437824)
print v(xbgr.mr_n83708416)
print v(xbgr.mr_n83839200)
print v(xbgr.mr_n84017488)
print v(xbgr.mr_n84170624)
print v(xbgr.mr_n84317136)
print v(xbgr.mr_n84568672)
print v(xbgr.mr_n81698016)
print v(xbgr.mr_n84670224)
print v(xbgr.mr_n84983280)
print v(xbgr.mr_n85129856)
print v(xbgr.mr_n85308336)
print v(xbgr.mr_n85509728)
print v(xbgr.mr_n85756528)
print v(xbgr.mr_n86039472)
print v(xbgr.mr_n86245280)
print v(xbgr.mr_n86439216)
print v(xbgr.mr_n86674848)
print v(xbgr.mr_n80901168)
print v(xbgr.mr_n80946864)
print v(xbgr.mr_n80373712)
print v(xbgr.mr_n81064384)
print v(xbgr.mr_n81133648)
print v(xbgr.mr_n81262448)
print v(xbgr.mr_n81373232)
print v(xbgr.mr_n81457936)
print v(xbgr.mr_n81756944)
print v(xbgr.mr_n81936624)
print v(xbgr.mr_n82024704)
print v(xbgr.mr_n82156224)
print v(xbgr.mr_n82320768)
print v(xbgr.mr_n82431184)
print v(xbgr.mr_n82571712)
print v(xbgr.mr_n82797712)
print v(xbgr.mr_n82965536)
print v(xbgr.mr_n80232256)
print v(xbgr.mr_n80440464)
print v(xbgr.mr_n80610480)
print v(xbgr.mr_n80847152)
print v(xbgr.mr_n80939056)
print v(xbgr.mr_n80989792)
print v(xbgr.mr_n81010336)
print v(xbgr.mr_n81097392)
print v(xbgr.mr_n81222576)
print v(xbgr.mr_n81341616)
print v(xbgr.mr_n81404448)
print v(xbgr.mr_n81554496)
print v(xbgr.mr_n81681920)
print v(xbgr.mr_n81844464)
print v(xbgr.mr_n81976896)
print v(xbgr.mr_n82093488)
print v(xbgr.mr_n82256560)
print v(xbgr.mr_n82377616)
print v(xbgr.mr_n82574128)
print v(xbgr.mr_n82688432)
print v(xbgr.mr_n82795872)
print v(xbgr.mr_n82963472)
print v(xbgr.mr_n80223584)
print v(xbgr.mr_n80441056)
print v(xbgr.mr_n80611072)
print v(xbgr.mr_n80847744)
print v(xbgr.mr_n80233120)
print v(xbgr.n_34)
print v(xbgr.mr_n80611664)
print v(xbgr.mr_n80836544)
print v(xbgr.mr_n80224448)
print v(xbgr.mr_n80442240)
print v(xbgr.mr_n80612256)
print v(xbgr.mr_n80848864)
print v(xbgr.mr_n80234048)
print v(xbgr.mr_n80049936)
print v(xbgr.mr_n80612848)
print v(xbgr.mr_n80849520)
print v(xbgr.mr_n80896064)
print v(xbgr.mr_n80988816)
print v(xbgr.mr_n81007232)
print v(xbgr.mr_n81121392)
print v(xbgr.mr_n81139216)
print v(xbgr.mr_n81313904)
print v(xbgr.mr_n81424560)
print v(xbgr.mr_n81530864)
print v(xbgr.mr_n81630576)
print v(xbgr.mr_n81830704)
print v(xbgr.mr_n81974176)
print v(xbgr.mr_n82061152)
print v(xbgr.mr_n82232400)
print v(xbgr.mr_n82369440)
print v(xbgr.mr_n82462480)
print v(xbgr.mr_n82692048)
print v(xbgr.mr_n82802064)
print v(xbgr.mr_n82971728)
print v(xbgr.mr_n83288656)
print v(xbgr.mr_n83471248)
print v(xbgr.mr_n83697280)
print v(xbgr.mr_n83827504)
print v(xbgr.mr_n84006864)
print v(xbgr.mr_n84151728)
print v(xbgr.mr_n84320912)
print v(xbgr.mr_n84580224)
print v(xbgr.mr_n81696176)
print v(xbgr.mr_n84667776)
print v(xbgr.mr_n84988144)
print v(xbgr.mr_n85112240)
print v(xbgr.mr_n85292720)
print v(xbgr.mr_n85512256)
print v(xbgr.mr_n85761504)
print v(xbgr.mr_n86034704)
print v(xbgr.mr_n86249936)
print v(xbgr.mr_n86442976)
print v(xbgr.mr_n86675616)
print v(xbgr.mr_n80234576)
print v(xbgr.mr_n80443344)
print v(xbgr.mr_n80613440)
print v(xbgr.mr_n80850112)
print v(xbgr.mr_n80896176)
print v(xbgr.mr_n80945200)
print v(xbgr.mr_n80113616)
print v(xbgr.mr_n81063456)
print v(xbgr.mr_n81132720)
print v(xbgr.mr_n81262176)
print v(xbgr.mr_n81261312)
print v(xbgr.mr_n81457632)
print v(xbgr.mr_n81735952)
print v(xbgr.mr_n81958832)
print v(xbgr.mr_n82023776)
print v(xbgr.mr_n82155296)
print v(xbgr.mr_n82320224)
print v(xbgr.mr_n82430064)
print v(xbgr.mr_n82563152)
print v(xbgr.mr_n82797824)
print v(xbgr.mr_n82973680)
print v(xbgr.mr_n80235040)
print v(xbgr.mr_n80444016)
print v(xbgr.mr_n80593312)
print v(xbgr.mr_n80850704)
print v(xbgr.mr_n80940592)
print v(xbgr.mr_n80107280)
print v(xbgr.mr_n81012144)
print v(xbgr.mr_n80384112)
print v(xbgr.mr_n81209168)
print v(xbgr.mr_n81342016)
print v(xbgr.mr_n81426368)
print v(xbgr.mr_n81550688)
print v(xbgr.mr_n81692128)
print v(xbgr.mr_n81846352)
print v(xbgr.mr_n81978960)
print v(xbgr.mr_n82095376)
print v(xbgr.mr_n82257360)
print v(xbgr.mr_n82378416)
print v(xbgr.mr_n82575728)
print v(xbgr.mr_n82683120)
print v(xbgr.mr_n82797936)
print v(xbgr.mr_n82969776)
print v(xbgr.mr_n80235504)
print v(xbgr.mr_n80444608)
print v(xbgr.mr_n80602784)
print v(xbgr.mr_n80851296)
print v(xbgr.mr_n80235968)
print v(xbgr.mr_n80430400)
print v(xbgr.mr_n80615216)
print v(xbgr.mr_n80851888)
print v(xbgr.mr_n80236432)
print v(xbgr.mr_n80445728)
print v(xbgr.mr_n80615808)
print v(xbgr.mr_n80852480)
print v(xbgr.mr_n80236896)
print v(xbgr.mr_n80446384)
print v(xbgr.n_10)
print v(xbgr.mr_n80842448)
print v(xbgr.mr_n80891072)
print v(xbgr.mr_n80988016)
print v(xbgr.mr_n81005424)
print v(xbgr.mr_n80105872)
print v(xbgr.mr_n81174896)
print v(xbgr.mr_n81315088)
print v(xbgr.mr_n81429136)
print v(xbgr.mr_n81446496)
print v(xbgr.mr_n81671584)
print v(xbgr.mr_n81821808)
print v(xbgr.mr_n81971216)
print v(xbgr.mr_n82088656)
print v(xbgr.mr_n82253184)
print v(xbgr.mr_n82376640)
print v(xbgr.mr_n82371040)
print v(xbgr.mr_n82686624)
print v(xbgr.mr_n82800000)
print v(xbgr.mr_n82971840)
print v(xbgr.mr_n79238352)
print v(xbgr.mr_n83469136)
print v(xbgr.mr_n83693104)
print v(xbgr.mr_n83818112)
print v(xbgr.mr_n84003520)
print v(xbgr.mr_n84142176)
print v(xbgr.mr_n84345104)
print v(xbgr.mr_n84585200)
print v(xbgr.mr_n81705360)
print v(xbgr.mr_n84667200)
print v(xbgr.mr_n84993120)
print v(xbgr.mr_n85125536)
print v(xbgr.mr_n85289824)
print v(xbgr.mr_n85504800)
print v(xbgr.mr_n85766480)
print v(xbgr.mr_n86014544)
print v(xbgr.mr_n86129488)
print v(xbgr.mr_n86320576)
print v(xbgr.mr_n86686016)
print v(xbgr.mr_n80891184)
print v(xbgr.mr_n80944240)
print v(xbgr.mr_n80093024)
print v(xbgr.mr_n81062992)
print v(xbgr.mr_n81132256)
print v(xbgr.mr_n81260160)
print v(xbgr.mr_n81333344)
print v(xbgr.mr_n81429024)
print v(xbgr.mr_n81738512)
print v(xbgr.mr_n81965920)
print v(xbgr.mr_n82023312)
print v(xbgr.mr_n82154832)
print v(xbgr.mr_n82314800)
print v(xbgr.mr_n82429600)
print v(xbgr.mr_n82576240)
print v(xbgr.mr_n82799776)
print v(xbgr.mr_n82976448)
print v(xbgr.mr_n80228080)
print v(xbgr.mr_n80446976)
print v(xbgr.mr_n80614032)
print v(xbgr.mr_n80853664)
print v(xbgr.mr_n80237760)
print v(xbgr.mr_n80447568)
print v(xbgr.mr_n80617584)
print v(xbgr.mr_n80854256)
print v(xbgr.mr_n80942448)
print v(xbgr.mr_n80083536)
print v(xbgr.mr_n81013952)
print v(xbgr.mr_n81124352)
print v(xbgr.mr_n81220976)
print v(xbgr.mr_n81342416)
print v(xbgr.mr_n81416480)
print v(xbgr.mr_n81556432)
print v(xbgr.mr_n81680688)
print v(xbgr.mr_n81848080)
print v(xbgr.mr_n81980864)
print v(xbgr.mr_n82097104)
print v(xbgr.mr_n82258160)
print v(xbgr.mr_n82379216)
print v(xbgr.mr_n82577072)
print v(xbgr.mr_n82693856)
print v(xbgr.mr_n82801840)
print v(xbgr.mr_n82973904)
print v(xbgr.mr_n80229008)
print v(xbgr.mr_n80448160)
print v(xbgr.mr_n80618176)
print v(xbgr.mr_n80854848)
print v(xbgr.mr_n80238688)
print v(xbgr.mr_n80448752)
print v(xbgr.mr_n80595088)
print v(xbgr.mr_n80823520)
print v(xbgr.mr_n80239216)
print v(xbgr.mr_n80449344)
print v(xbgr.mr_n80607520)
print v(xbgr.mr_n80806208)
print v(xbgr.mr_n80577392)
print v(xbgr.mr_n80987392)
print v(xbgr.mr_n81001808)
print v(xbgr.mr_n81100256)
print v(xbgr.mr_n81041424)
print v(xbgr.mr_n81316272)
print v(xbgr.mr_n81429328)
print v(xbgr.mr_n81505136)
print v(xbgr.mr_n81696752)
print v(xbgr.mr_n81793232)
print v(xbgr.mr_n81976240)
print v(xbgr.mr_n82086848)
print v(xbgr.mr_n82255584)
print v(xbgr.mr_n82378240)
print v(xbgr.mr_n82461776)
print v(xbgr.mr_n82688544)
print v(xbgr.mr_n82804016)
print v(xbgr.mr_n82980912)
print v(xbgr.mr_n80239680)
print v(xbgr.mr_n80402912)
print v(xbgr.mr_n80619952)
print v(xbgr.mr_n80805568)
print v(xbgr.mr_n79232624)
print v(xbgr.mr_n83459536)
print v(xbgr.mr_n79241936)
print v(xbgr.mr_n83820896)
print v(xbgr.mr_n84051376)
print v(xbgr.mr_n84108720)
print v(xbgr.mr_n84316192)
print v(xbgr.mr_n84590176)
print v(xbgr.mr_n81663408)
print v(xbgr.mr_n84667392)
print v(xbgr.mr_n84954080)
print v(xbgr.mr_n85076912)
print v(xbgr.mr_n85257072)
print v(xbgr.mr_n85520400)
print v(xbgr.mr_n85670032)
print v(xbgr.mr_n85993504)
print v(xbgr.mr_n86127424)
print v(xbgr.mr_n86412112)
print v(xbgr.mr_n86676544)
print v(xbgr.mr_n80887120)
print v(xbgr.mr_n80946400)
print v(xbgr.mr_n80392560)
print v(xbgr.mr_n81062064)
print v(xbgr.mr_n81131680)
print v(xbgr.mr_n81258640)
print v(xbgr.mr_n81334016)
print v(xbgr.mr_n81449632)
print v(xbgr.mr_n81797504)
print v(xbgr.mr_n81870528)
print v(xbgr.mr_n81993728)
print v(xbgr.mr_n82123712)
print v(xbgr.mr_n82318352)
print v(xbgr.mr_n82375040)
print v(xbgr.mr_n82575312)
print v(xbgr.mr_n82801952)
print v(xbgr.mr_n82976560)
print v(xbgr.mr_n80240144)
print v(xbgr.mr_n80302640)
print v(xbgr.mr_n80620544)
print v(xbgr.mr_n80705584)
print v(xbgr.mr_n80943504)
print v(xbgr.mr_n80174864)
print v(xbgr.mr_n81015760)
print v(xbgr.mr_n81100960)
print v(xbgr.mr_n81203024)
print v(xbgr.mr_n81342816)
print v(xbgr.mr_n81431360)
print v(xbgr.mr_n81556256)
print v(xbgr.mr_n81699680)
print v(xbgr.mr_n81849888)
print v(xbgr.mr_n81982832)
print v(xbgr.mr_n82098912)
print v(xbgr.mr_n82258960)
print v(xbgr.mr_n82380016)
print v(xbgr.mr_n82580016)
print v(xbgr.mr_n82692160)
print v(xbgr.mr_n82793840)
print v(xbgr.mr_n82976928)
print v(xbgr.mr_n80240608)
print v(xbgr.mr_n80412432)
print v(xbgr.mr_n80621136)
print v(xbgr.mr_n80808560)
print v(xbgr.mr_n80241072)
print v(xbgr.mr_n80047824)
print v(xbgr.mr_n80621728)
print v(xbgr.mr_n80804960)
print v(xbgr.mr_n80241536)
print v(xbgr.mr_n80433360)
print v(xbgr.mr_n80622320)
print v(xbgr.mr_n80766160)
print v(xbgr.mr_n80232720)
print v(xbgr.mr_n80413872)
print v(xbgr.mr_n80622912)
print v(xbgr.mr_n80806416)
print v(xbgr.mr_n80242400)
print v(xbgr.mr_n80411984)
print v(xbgr.mr_n80623504)
print v(xbgr.mr_n80727168)
print v(xbgr.mr_n80233648)
print v(xbgr.mr_n80359952)
print v(xbgr.mr_n80624096)
print v(xbgr.mr_n80848336)
print v(xbgr.mr_n80243392)
print v(xbgr.mr_n80428624)
print v(xbgr.mr_n80624688)
print v(xbgr.mr_n80807472)
print v(xbgr.mr_n80243856)
print v(xbgr.mr_n80196896)
print v(xbgr.mr_n80619360)
print v(xbgr.mr_n80840080)
print v(xbgr.mr_n81074096)
print v(xbgr.mr_n82577808)
print v(xbgr.mr_n82799888)
print v(xbgr.mr_n82984896)
print v(xbgr.mr_n80244320)
print v(xbgr.mr_n80418928)
print v(xbgr.mr_n80625872)
print v(xbgr.mr_n80727776)
print v(xbgr.d5)
print v(xbgr.d1)
print v(xbgr.mr_n81091008)
print v(xbgr.mr_n81431584)
print v(xbgr.mr_n80941216)
print v(xbgr.mr_n81010848)
print v(xbgr.mr_n81434384)
print v(xbgr.mr_n82579104)
print v(xbgr.n1)
print v(xbgr.mr_n82984528)
print v(xbgr.mr_n80244784)
print v(xbgr.mr_n80198816)
print v(xbgr.mr_n80614624)
print v(xbgr.mr_n80810304)
print v(xbgr.mr_n82377440)
print v(xbgr.mr_n82604912)
print v(xbgr.mr_n82817104)
print v(xbgr.mr_n80884336)
print v(xbgr.mr_n80976640)
print v(xbgr.kick)
print v(xbgr.mr_n81276624)
print v(xbgr.mr_n82577584)
print v(xbgr.mr_n82748736)
print v(xbgr.mr_n82984416)
print v(xbgr.mr_n80245248)
print v(xbgr.mr_n80449600)
print v(xbgr.mr_n80627056)
print v(xbgr.mr_n80855648)
print v(xbgr.mr_n80245712)
print v(xbgr.mr_n80450208)
print v(xbgr.mr_n80627648)
print v(xbgr.mr_n80856352)
print v(xbgr.mr_n80940256)
print v(xbgr.mr_n81016272)
print v(xbgr.mr_n81073088)
print v(xbgr.mr_n81419024)
print v(xbgr.mr_n82580528)
print v(xbgr.mr_n82806080)
print v(xbgr.mr_n82973792)
print v(xbgr.mr_n81553632)
print v(xbgr.mr_n81704688)
print v(xbgr.mr_n81771136)
print v(xbgr.mr_n81845056)
print v(xbgr.mr_n82097696)
print v(xbgr.mr_n82215472)
print v(xbgr.mr_n82343248)
print v(xbgr.mr_n81555456)
print v(xbgr.mr_n81705968)
print v(xbgr.mr_n81767600)
print v(xbgr.mr_n81821552)
print v(xbgr.mr_n82095888)
print v(xbgr.mr_n82225232)
print v(xbgr.mr_n81938976)
print v(xbgr.mr_n80246176)
print v(xbgr.mr_n80450912)
print v(xbgr.mr_n80628240)
print v(xbgr.mr_n80856816)
print v(xbgr.mr_n82577696)
print v(xbgr.mr_n82659040)
print v(xbgr.mr_n82988512)
print v(xbgr.mr_n81458320)
print v(xbgr.mr_n81588560)
print v(xbgr.mr_n81665344)
print v(xbgr.mr_n81794320)
print v(xbgr.mr_n81996864)
print v(xbgr.mr_n82122496)
print v(xbgr.mr_n82256384)
print v(xbgr.mr_n82392560)
print v(xbgr.mr_n82622656)
print v(xbgr.mr_n82825360)
print v(xbgr.mr_n80242928)
print v(xbgr.mr_n80451472)
print v(xbgr.mr_n80628832)
print v(xbgr.mr_n80858112)
print v(xbgr.mr_n82578928)
print v(xbgr.mr_n82744032)
print v(xbgr.mr_n82988400)
print v(xbgr.mr_n81099568)
print v(xbgr.mr_n81556080)
print v(xbgr.d2)
print v(xbgr.mr_n81779472)
print v(xbgr.mr_n81848672)
print v(xbgr.mr_n82077808)
print v(xbgr.mr_n82190240)
print v(xbgr.mr_n82301184)
print v(xbgr.mr_n80944352)
print v(xbgr.mr_n81016384)
print v(xbgr.mr_n81434080)
print v(xbgr.mr_n80247040)
print v(xbgr.mr_n80452704)
print v(xbgr.mr_n80629424)
print v(xbgr.mr_n80806960)
print v(xbgr.mr_n80944128)
print v(xbgr.mr_n81016496)
print v(xbgr.mr_n81434896)
print v(xbgr.mr_n82581920)
print v(xbgr.mr_n82808032)
print v(xbgr.mr_n82980432)
print v(xbgr.mr_n81098560)
print v(xbgr.mr_n80238288)
print v(xbgr.mr_n80453328)
print v(xbgr.mr_n80630016)
print v(xbgr.mr_n80860240)
print v(xbgr.mr_n80884880)
print v(xbgr.mr_n80976368)
print v(xbgr.mr_n81318528)
print v(xbgr.det)
print v(xbgr.mr_n82581808)
print v(xbgr.mr_n82747376)
print v(xbgr.mr_n82988880)
print v(xbgr.mr_n81076416)
print v(xbgr.mr_n80247968)
print v(xbgr.mr_n80453920)
print v(xbgr.mr_n80630608)
print v(xbgr.mr_n80853072)
print v(xbgr.mr_n82394336)
print v(xbgr.mr_n82622192)
print v(xbgr.mr_n82827216)
print v(xbgr.mr_n80943328)
print v(xbgr.mr_n81003616)
print v(xbgr.mr_n81434192)
print v(xbgr.mr_n82583664)
print v(xbgr.mr_n82751552)
print v(xbgr.mr_n82980544)
print v(xbgr.mr_n81557680)
print v(xbgr.mr_n81701632)
print v(xbgr.mr_n81771024)
print v(xbgr.mr_n81841440)
print v(xbgr.mr_n82092272)
print v(xbgr.mr_n82222288)
print v(xbgr.mr_n82347264)
print v(xbgr.mr_n81557456)
print v(xbgr.mr_n81670016)
print v(xbgr.mr_n81733760)
print v(xbgr.mr_n81850592)
print v(xbgr.mr_n82099728)
print v(xbgr.mr_n82229808)
print v(xbgr.mr_n82351872)
print v(xbgr.mr_n80248496)
print v(xbgr.mr_n80454512)
print v(xbgr.mr_n80625280)
print v(xbgr.mr_n80807680)
print v(xbgr.mr_n81481600)
print v(xbgr.mr_n81590480)
print v(xbgr.mr_n81714288)
print v(xbgr.mr_n81798320)
print v(xbgr.mr_n82000896)
print v(xbgr.mr_n82126528)
print v(xbgr.mr_n82259504)
print v(xbgr.mr_n82584080)
print v(xbgr.mr_n82810576)
print v(xbgr.mr_n82991584)
print v(xbgr.mr_n80248960)
print v(xbgr.mr_n80455104)
print v(xbgr.mr_n80631792)
print v(xbgr.mr_n80810112)
print v(xbgr.mr_n82584192)
print v(xbgr.mr_n82750960)
print v(xbgr.mr_n82993088)
print v(xbgr.mr_n80249424)
print v(xbgr.mr_n80455680)
print v(xbgr.mr_n80632384)
print v(xbgr.mr_n80866000)
print v(xbgr.mr_n81097856)
print v(xbgr.mr_n81557344)
print v(xbgr.mr_n81676640)
print v(xbgr.mr_n81763216)
print v(xbgr.mr_n81843248)
print v(xbgr.mr_n82100224)
print v(xbgr.mr_n82191424)
print v(xbgr.mr_n82317232)
print v(xbgr.mr_n80945088)
print v(xbgr.mr_n81017344)
print v(xbgr.mr_n81435584)
print v(xbgr.mr_n82396192)
print v(xbgr.mr_n82621728)
print v(xbgr.mr_n82829072)
print v(xbgr.mr_n80944464)
print v(xbgr.mr_n81017456)
print v(xbgr.mr_n81426864)
print v(xbgr.mr_n82586256)
print v(xbgr.mr_n82749776)
print v(xbgr.mr_n82995552)
print v(xbgr.mr_n80249888)
print v(xbgr.mr_n80456272)
print v(xbgr.mr_n80632976)
print v(xbgr.mr_n80866224)
print v(xbgr.mr_n81073760)
print v(xbgr.mr_n80884608)
print v(xbgr.mr_n80976096)
print v(xbgr.mr_n81036560)
print v(xbgr.mr_n81318800)
print v(xbgr.r4n)
print v(xbgr.mr_n80250352)
print v(xbgr.mr_n80456864)
print v(xbgr.mr_n80633568)
print v(xbgr.mr_n80866336)
print v(xbgr.mr_n82574640)
print v(xbgr.mr_n82811120)
print v(xbgr.mr_n82991472)
print v(xbgr.mr_n80944736)
print v(xbgr.mr_n81018080)
print v(xbgr.mr_n81426592)
print v(xbgr.mr_n81558416)
print v(xbgr.mr_n81710000)
print v(xbgr.mr_n81778384)
print v(xbgr.mr_n81846864)
print v(xbgr.mr_n81995536)
print v(xbgr.mr_n82221760)
print v(xbgr.mr_n82346912)
print v(xbgr.mr_n81548064)
print v(xbgr.mr_n81708272)
print v(xbgr.mr_n81733648)
print v(xbgr.mr_n81839632)
print v(xbgr.mr_n82090464)
print v(xbgr.mr_n82225584)
print v(xbgr.mr_n82342304)
print v(xbgr.mr_n80250816)
print v(xbgr.mr_n80457456)
print v(xbgr.mr_n80634160)
print v(xbgr.mr_n80866448)
print v(xbgr.mr_n82580640)
print v(xbgr.mr_n82752736)
print v(xbgr.mr_n82993984)
print v(xbgr.mr_n82398048)
print v(xbgr.mr_n82621264)
print v(xbgr.mr_n82830928)
print v(xbgr.mr_n81481136)
print v(xbgr.mr_n81589952)
print v(xbgr.mr_n81715104)
print v(xbgr.mr_n81799136)
print v(xbgr.mr_n82001712)
print v(xbgr.mr_n82127344)
print v(xbgr.mr_n82259920)
print v(xbgr.mr_n80242000)
print v(xbgr.mr_n80458048)
print v(xbgr.mr_n80634752)
print v(xbgr.mr_n80866560)
print v(xbgr.mr_n82585008)
print v(xbgr.mr_n82755104)
print v(xbgr.mr_n82996544)
print v(xbgr.mr_n80226224)
print v(xbgr.mr_n80458640)
print v(xbgr.mr_n80635344)
print v(xbgr.mr_n80866672)
print v(xbgr.mr_n81096928)
print v(xbgr.mr_n81557568)
print v(xbgr.mr_n81670240)
print v(xbgr.mr_n81777712)
print v(xbgr.mr_n81851120)
print v(xbgr.mr_n82100688)
print v(xbgr.mr_n82190832)
print v(xbgr.mr_n82311248)
print v(xbgr.mr_n82588224)
print v(xbgr.mr_n82804128)
print v(xbgr.mr_n82993808)
print v(xbgr.mr_n80945824)
print v(xbgr.mr_n81018192)
print v(xbgr.mr_n81436208)
print v(xbgr.mr_n80946064)
print v(xbgr.mr_n81017728)
print v(xbgr.mr_n81437776)
print v(xbgr.mr_n80237360)
print v(xbgr.mr_n80459232)
print v(xbgr.mr_n80635936)
print v(xbgr.mr_n80867056)
print v(xbgr.mr_n82589440)
print v(xbgr.mr_n82754512)
print v(xbgr.mr_n83001488)
print v(xbgr.mr_n81091152)
print v(xbgr.mr_n80884064)
print v(xbgr.mr_n80975824)
print v(xbgr.mr_n81318336)
print v(xbgr.mr_n81038656)
print v(xbgr.mr_n82399904)
print v(xbgr.mr_n82620800)
print v(xbgr.mr_n82832784)
print v(xbgr.mr_n80252608)
print v(xbgr.mr_n80459824)
print v(xbgr.mr_n80636528)
print v(xbgr.mr_n80867328)
print v(xbgr.mr_n81069024)
print v(xbgr.mr_n82590384)
print v(xbgr.mr_n82756880)
print v(xbgr.mr_n83000672)
print v(xbgr.mr_n80945472)
print v(xbgr.mr_n81018560)
print v(xbgr.mr_n81436592)
print v(xbgr.mr_n80253136)
print v(xbgr.mr_n80460416)
print v(xbgr.mr_n80637120)
print v(xbgr.mr_n80867600)
print v(xbgr.mr_n81559552)
print v(xbgr.mr_n81709488)
print v(xbgr.mr_n81778192)
print v(xbgr.mr_n81850928)
print v(xbgr.mr_n82101312)
print v(xbgr.mr_n82218880)
print v(xbgr.mr_n81825040)
print v(xbgr.mr_n81560448)
print v(xbgr.mr_n81696960)
print v(xbgr.mr_n81780560)
print v(xbgr.mr_n81851664)
print v(xbgr.mr_n82099616)
print v(xbgr.mr_n82226400)
print v(xbgr.mr_n82348080)
print v(xbgr.mr_n82590800)
print v(xbgr.mr_n82814384)
print v(xbgr.mr_n82996368)
print v(xbgr.mr_n80253600)
print v(xbgr.mr_n80413264)
print v(xbgr.mr_n80637712)
print v(xbgr.mr_n80867872)
print v(xbgr.mr_n81480672)
print v(xbgr.mr_n81589488)
print v(xbgr.mr_n81715920)
print v(xbgr.mr_n81799872)
print v(xbgr.mr_n82002528)
print v(xbgr.mr_n82128160)
print v(xbgr.mr_n82260736)
print v(xbgr.mr_n82591728)
print v(xbgr.mr_n82757472)
print v(xbgr.mr_n83004048)
print v(xbgr.mr_n80254064)
print v(xbgr.mr_n80461520)
print v(xbgr.mr_n80626464)
print v(xbgr.mr_n80868144)
print v(xbgr.mr_n82401760)
print v(xbgr.mr_n82620336)
print v(xbgr.mr_n82834672)
print v(xbgr.mr_n81557792)
print v(xbgr.mr_n81703504)
print v(xbgr.mr_n81733536)
print v(xbgr.mr_n81850480)
print v(xbgr.mr_n82101424)
print v(xbgr.mr_n82188464)
print v(xbgr.mr_n82304800)
print v(xbgr.mr_n82592672)
print v(xbgr.mr_n82753920)
print v(xbgr.mr_n82998928)
print v(xbgr.mr_n80934832)
print v(xbgr.mr_n81020192)
print v(xbgr.d3)
print v(xbgr.mr_n81431472)
print v(xbgr.mr_n80943152)
print v(xbgr.mr_n81016880)
print v(xbgr.mr_n81255072)
print v(xbgr.mr_n81439344)
print v(xbgr.mr_n80254528)
print v(xbgr.mr_n80462192)
print v(xbgr.mr_n80638896)
print v(xbgr.mr_n80868416)
print v(xbgr.mr_n80883792)
print v(xbgr.mr_n80975552)
print v(xbgr.mr_n80762336)
print v(xbgr.mr_n81317152)
print v(xbgr.mr_n82593200)
print v(xbgr.mr_n82814928)
print v(xbgr.mr_n83001664)
print v(xbgr.mr_n80254992)
print v(xbgr.mr_n80462784)
print v(xbgr.mr_n80639488)
print v(xbgr.mr_n80868688)
print v(xbgr.mr_n82588112)
print v(xbgr.mr_n82752144)
print v(xbgr.mr_n83006608)
print v(xbgr.mr_n80255456)
print v(xbgr.mr_n80463376)
print v(xbgr.mr_n80640080)
print v(xbgr.mr_n80869392)
print v(xbgr.mr_n80941952)
print v(xbgr.mr_n81009040)
print v(xbgr.mr_n81229120)
print v(xbgr.mr_n81439872)
print v(xbgr.mr_n81561136)
print v(xbgr.mr_n81675760)
print v(xbgr.mr_n81764816)
print v(xbgr.mr_n81850816)
print v(xbgr.mr_n81983344)
print v(xbgr.mr_n82101792)
print v(xbgr.mr_n82211024)
print v(xbgr.mr_n82342192)
print v(xbgr.mr_n81558528)
print v(xbgr.mr_n81662848)
print v(xbgr.mr_n81765152)
print v(xbgr.mr_n81852528)
print v(xbgr.mr_n81983952)
print v(xbgr.mr_n82100576)
print v(xbgr.mr_n82222176)
print v(xbgr.mr_n82346416)
print v(xbgr.mr_n82403616)
print v(xbgr.mr_n82619872)
print v(xbgr.mr_n82837040)
print v(xbgr.mr_n82594080)
print v(xbgr.mr_n82750368)
print v(xbgr.mr_n82998112)
print v(xbgr.mr_n80246640)
print v(xbgr.mr_n80463968)
print v(xbgr.mr_n80616992)
print v(xbgr.mr_n80869792)
print v(xbgr.mr_n81480208)
print v(xbgr.mr_n81589024)
print v(xbgr.mr_n81716736)
print v(xbgr.mr_n81799408)
print v(xbgr.mr_n81875232)
print v(xbgr.mr_n82003344)
print v(xbgr.mr_n82128976)
print v(xbgr.mr_n82261552)
print v(xbgr.mr_n80256320)
print v(xbgr.mr_n80464560)
print v(xbgr.mr_n80641264)
print v(xbgr.mr_n80870192)
print v(xbgr.mr_n82582720)
print v(xbgr.mr_n82818192)
print v(xbgr.mr_n83004224)
print v(xbgr.mr_n81562896)
print v(xbgr.mr_n81708464)
print v(xbgr.mr_n81779808)
print v(xbgr.mr_n81837824)
print v(xbgr.mr_n81983680)
print v(xbgr.mr_n82102208)
print v(xbgr.mr_n82189648)
print v(xbgr.mr_n82313024)
print v(xbgr.mr_n80941104)
print v(xbgr.mr_n81021760)
print v(xbgr.mr_n81178160)
print v(xbgr.mr_n81435232)
print v(xbgr.mr_n80939648)
print v(xbgr.mr_n81022448)
print v(xbgr.mr_n81178272)
print v(xbgr.mr_n81437088)
print v(xbgr.mr_n80247568)
print v(xbgr.mr_n80465152)
print v(xbgr.mr_n80641856)
print v(xbgr.mr_n80870592)
print v(xbgr.mr_n82593088)
print v(xbgr.mr_n82747824)
print v(xbgr.mr_n83009168)
print v(xbgr.mr_n82404544)
print v(xbgr.mr_n82619408)
print v(xbgr.mr_n82838224)
print v(xbgr.mr_n80257312)
print v(xbgr.mr_n80465744)
print v(xbgr.mr_n80618768)
print v(xbgr.mr_n80761280)
print v(xbgr.mr_n80883520)
print v(xbgr.mr_n80975280)
print v(xbgr.mr_n80292352)
print v(xbgr.mr_n81315968)
print v(xbgr.mr_n82596784)
print v(xbgr.mr_n82747600)
print v(xbgr.mr_n83008352)
print v(xbgr.mr_n80257776)
print v(xbgr.mr_n80466336)
print v(xbgr.mr_n80631200)
print v(xbgr.mr_n80871792)
print v(xbgr.mr_n80938800)
print v(xbgr.mr_n81021344)
print v(xbgr.mr_n81228848)
print v(xbgr.mr_n81438656)
print v(xbgr.mr_n82597632)
print v(xbgr.mr_n82820368)
print v(xbgr.mr_n82999104)
print v(xbgr.mr_n81561744)
print v(xbgr.mr_n81693200)
print v(xbgr.mr_n81767008)
print v(xbgr.mr_n81853280)
print v(xbgr.mr_n81984416)
print v(xbgr.mr_n82103328)
print v(xbgr.mr_n82218768)
print v(xbgr.mr_n82335056)
print v(xbgr.mr_n81560080)
print v(xbgr.mr_n81678720)
print v(xbgr.mr_n81765760)
print v(xbgr.mr_n81850704)
print v(xbgr.mr_n81960896)
print v(xbgr.mr_n82106368)
print v(xbgr.mr_n82222992)
print v(xbgr.mr_n82338288)
print v(xbgr.mr_n80258240)
print v(xbgr.mr_n80466928)
print v(xbgr.mr_n80643632)
print v(xbgr.mr_n80872192)
print v(xbgr.mr_n82598448)
print v(xbgr.mr_n82747712)
print v(xbgr.mr_n83011728)
print v(xbgr.mr_n81479744)
print v(xbgr.mr_n81588096)
print v(xbgr.mr_n81717808)
print v(xbgr.mr_n81798864)
print v(xbgr.mr_n81877696)
print v(xbgr.mr_n82004160)
print v(xbgr.mr_n82129792)
print v(xbgr.mr_n82262368)
print v(xbgr.mr_n82404080)
print v(xbgr.mr_n82618944)
print v(xbgr.mr_n82837632)
print v(xbgr.mr_n80258704)
print v(xbgr.mr_n80467520)
print v(xbgr.mr_n80644224)
print v(xbgr.mr_n80872592)
print v(xbgr.mr_n82599392)
print v(xbgr.mr_n82742848)
print v(xbgr.mr_n83010912)
print v(xbgr.mr_n81563616)
print v(xbgr.mr_n81688336)
print v(xbgr.mr_n81766656)
print v(xbgr.mr_n81852288)
print v(xbgr.mr_n81975344)
print v(xbgr.mr_n82107968)
print v(xbgr.mr_n82189056)
print v(xbgr.mr_n82313680)
print v(xbgr.mr_n80259168)
print v(xbgr.mr_n80442832)
print v(xbgr.mr_n80644816)
print v(xbgr.mr_n80872992)
print v(xbgr.mr_n80940080)
print v(xbgr.mr_n81023328)
print v(xbgr.mr_n81173952)
print v(xbgr.mr_n81438304)
print v(xbgr.mr_n80937504)
print v(xbgr.mr_n81019840)
print v(xbgr.mr_n81260336)
print v(xbgr.mr_n81440912)
print v(xbgr.mr_n82599920)
print v(xbgr.mr_n82820912)
print v(xbgr.mr_n83003232)
print v(xbgr.mr_n80259632)
print v(xbgr.mr_n80468704)
print v(xbgr.mr_n80645408)
print v(xbgr.mr_n80873792)
print v(xbgr.mr_n80883248)
print v(xbgr.mr_n80975008)
print v(xbgr.mr_n80777536)
print v(xbgr.mr_n81314784)
print v(xbgr.mr_n82598192)
print v(xbgr.mr_n82661952)
print v(xbgr.mr_n83009344)
print v(xbgr.mr_n80218480)
print v(xbgr.mr_n80469296)
print v(xbgr.mr_n80646000)
print v(xbgr.mr_n80874192)
print v(xbgr.mr_n82403152)
print v(xbgr.mr_n82618496)
print v(xbgr.mr_n82836448)
print v(xbgr.mr_n80938192)
print v(xbgr.mr_n81022976)
print v(xbgr.mr_n81227760)
print v(xbgr.mr_n81440224)
print v(xbgr.mr_n81561248)
print v(xbgr.mr_n81642864)
print v(xbgr.mr_n81766544)
print v(xbgr.mr_n81853712)
print v(xbgr.mr_n81984528)
print v(xbgr.mr_n82105680)
print v(xbgr.mr_n82219584)
print v(xbgr.mr_n81945872)
print v(xbgr.mr_n82594416)
print v(xbgr.mr_n82654848)
print v(xbgr.mr_n83013472)
print v(xbgr.mr_n81564912)
print v(xbgr.mr_n81709712)
print v(xbgr.mr_n81781664)
print v(xbgr.mr_n81855568)
print v(xbgr.mr_n81985552)
print v(xbgr.mr_n82107536)
print v(xbgr.mr_n82218352)
print v(xbgr.mr_n82331472)
print v(xbgr.mr_n80256848)
print v(xbgr.mr_n80469888)
print v(xbgr.mr_n80646592)
print v(xbgr.mr_n80874592)
print v(xbgr.mr_n81479280)
print v(xbgr.mr_n81587632)
print v(xbgr.mr_n81718272)
print v(xbgr.mr_n81798592)
print v(xbgr.mr_n81878512)
print v(xbgr.mr_n82004976)
print v(xbgr.mr_n82130608)
print v(xbgr.mr_n82263184)
print v(xbgr.mr_n80227152)
print v(xbgr.mr_n80159968)
print v(xbgr.mr_n80647184)
print v(xbgr.mr_n80874992)
print v(xbgr.mr_n82601952)
print v(xbgr.mr_n82818736)
print v(xbgr.mr_n83005792)
print v(xbgr.mr_n82602880)
print v(xbgr.mr_n82746992)
print v(xbgr.mr_n83011904)
print v(xbgr.mr_n80226688)
print v(xbgr.mr_n80470992)
print v(xbgr.mr_n80581328)
print v(xbgr.mr_n80875392)
print v(xbgr.mr_n81566064)
print v(xbgr.mr_n81657920)
print v(xbgr.mr_n81765536)
print v(xbgr.mr_n81855024)
print v(xbgr.mr_n81985072)
print v(xbgr.mr_n82109072)
print v(xbgr.mr_n82186688)
print v(xbgr.mr_n82307696)
print v(xbgr.mr_n80938624)
print v(xbgr.mr_n81024896)
print v(xbgr.mr_n81228576)
print v(xbgr.mr_n81441376)
print v(xbgr.mr_n80935680)
print v(xbgr.mr_n81025584)
print v(xbgr.mr_n81259552)
print v(xbgr.mr_n81442480)
print v(xbgr.mr_n82402688)
print v(xbgr.mr_n82618032)
print v(xbgr.mr_n82835856)
print v(xbgr.mr_n82603824)
print v(xbgr.mr_n82746400)
print v(xbgr.mr_n83014464)
print v(xbgr.mr_n80223920)
print v(xbgr.mr_n80471664)
print v(xbgr.mr_n80580736)
print v(xbgr.mr_n80876192)
print v(xbgr.mr_n80882976)
print v(xbgr.mr_n80974736)
print v(xbgr.mr_n80048272)
print v(xbgr.mr_n81313600)
print v(xbgr.mr_n80225760)
print v(xbgr.mr_n80472256)
print v(xbgr.mr_n80580144)
print v(xbgr.mr_n80876592)
print v(xbgr.mr_n82604240)
print v(xbgr.mr_n82819280)
print v(xbgr.mr_n82947776)
print v(xbgr.mr_n80934224)
print v(xbgr.mr_n81024480)
print v(xbgr.mr_n81228304)
print v(xbgr.mr_n81444512)
print v(xbgr.mr_n81564416)
print v(xbgr.mr_n81658224)
print v(xbgr.mr_n81782352)
print v(xbgr.mr_n81856000)
print v(xbgr.mr_n81987136)
print v(xbgr.mr_n82109952)
print v(xbgr.mr_n82211552)
print v(xbgr.mr_n82334880)
print v(xbgr.mr_n80225296)
print v(xbgr.mr_n80472848)
print v(xbgr.mr_n80579552)
print v(xbgr.mr_n80876992)
print v(xbgr.mr_n81565888)
print v(xbgr.mr_n81651888)
print v(xbgr.mr_n81765648)
print v(xbgr.mr_n81859104)
print v(xbgr.mr_n81985728)
print v(xbgr.mr_n82103680)
print v(xbgr.mr_n82215360)
print v(xbgr.mr_n81820144)
print v(xbgr.mr_n82604352)
print v(xbgr.mr_n82655456)
print v(xbgr.mr_n83006784)
print v(xbgr.mr_n82402224)
print v(xbgr.mr_n82617568)
print v(xbgr.mr_n82835264)
print v(xbgr.mr_n80224784)
print v(xbgr.mr_n80473440)
print v(xbgr.mr_n80502656)
print v(xbgr.mr_n80877392)
print v(xbgr.mr_n81478816)
print v(xbgr.mr_n81586704)
print v(xbgr.mr_n81717344)
print v(xbgr.mr_n81798048)
print v(xbgr.mr_n81879328)
print v(xbgr.mr_n82004704)
print v(xbgr.mr_n82130336)
print v(xbgr.mr_n82262912)
print v(xbgr.mr_n82606416)
print v(xbgr.mr_n82543072)
print v(xbgr.mr_n83016848)
print v(xbgr.mr_n80158016)
print v(xbgr.mr_n80474032)
print v(xbgr.mr_n80578368)
print v(xbgr.mr_n80877792)
print v(xbgr.mr_n81564304)
print v(xbgr.mr_n81680384)
print v(xbgr.mr_n81782784)
print v(xbgr.mr_n81860768)
print v(xbgr.mr_n81988896)
print v(xbgr.mr_n82112736)
print v(xbgr.mr_n82187872)
print v(xbgr.mr_n82311904)
print v(xbgr.mr_n80937328)
print v(xbgr.mr_n81026464)
print v(xbgr.mr_n81257616)
print v(xbgr.mr_n81442944)
print v(xbgr.mr_n82601136)
print v(xbgr.mr_n82816560)
print v(xbgr.mr_n83017024)
print v(xbgr.mr_n80937680)
print v(xbgr.mr_n81027152)
print v(xbgr.mr_n81256096)
print v(xbgr.mr_n81444048)
print v(xbgr.mr_n80203648)
print v(xbgr.mr_n80474624)
print v(xbgr.mr_n80576368)
print v(xbgr.mr_n80878592)
print v(xbgr.mr_n82600800)
print v(xbgr.mr_n82745216)
print v(xbgr.mr_n82939136)
print v(xbgr.mr_n80882704)
print v(xbgr.mr_n80974544)
print v(xbgr.mr_n81092896)
print v(xbgr.mr_n81312416)
print v(xbgr.mr_n80214304)
print v(xbgr.mr_n80475216)
print v(xbgr.mr_n80652112)
print v(xbgr.mr_n80717424)
print v(xbgr.mr_n82401296)
print v(xbgr.mr_n82617104)
print v(xbgr.mr_n82834176)
print v(xbgr.mr_n82602624)
print v(xbgr.mr_n82745808)
print v(xbgr.mr_n83014288)
print v(xbgr.mr_n80932480)
print v(xbgr.mr_n81026112)
print v(xbgr.mr_n81228032)
print v(xbgr.mr_n81446080)
print v(xbgr.mr_n80223120)
print v(xbgr.mr_n80475808)
print v(xbgr.mr_n80640672)
print v(xbgr.mr_n80716832)
print v(xbgr.mr_n81563952)
print v(xbgr.mr_n81674928)
print v(xbgr.mr_n81781552)
print v(xbgr.mr_n81856416)
print v(xbgr.mr_n81988720)
print v(xbgr.mr_n82113776)
print v(xbgr.mr_n82216176)
print v(xbgr.mr_n82340528)
print v(xbgr.mr_n81562240)
print v(xbgr.mr_n81711024)
print v(xbgr.mr_n81785280)
print v(xbgr.mr_n81861808)
print v(xbgr.mr_n81989616)
print v(xbgr.mr_n82108384)
print v(xbgr.mr_n82215008)
print v(xbgr.mr_n82337584)
print v(xbgr.mr_n82602064)
print v(xbgr.mr_n82817648)
print v(xbgr.mr_n83016032)
print v(xbgr.mr_n80064800)
print v(xbgr.mr_n80476400)
print v(xbgr.mr_n80653952)
print v(xbgr.mr_n80716240)
print v(xbgr.mr_n81478352)
print v(xbgr.mr_n81586240)
print v(xbgr.mr_n81717008)
print v(xbgr.mr_n81797776)
print v(xbgr.mr_n81880144)
print v(xbgr.mr_n82004432)
print v(xbgr.mr_n82130064)
print v(xbgr.mr_n82262640)
print v(xbgr.mr_n82599808)
print v(xbgr.mr_n82741664)
print v(xbgr.mr_n82934112)
print v(xbgr.mr_n80222192)
print v(xbgr.mr_n80476992)
print v(xbgr.mr_n80404928)
print v(xbgr.mr_n80715648)
print v(xbgr.mr_n82400832)
print v(xbgr.mr_n82616640)
print v(xbgr.mr_n82833712)
print v(xbgr.mr_n81559072)
print v(xbgr.mr_n81700816)
print v(xbgr.mr_n81766192)
print v(xbgr.mr_n81857984)
print v(xbgr.mr_n81988240)
print v(xbgr.mr_n82107056)
print v(xbgr.mr_n82180848)
print v(xbgr.mr_n82309472)
print v(xbgr.mr_n80928672)
print v(xbgr.mr_n81028032)
print v(xbgr.mr_n81257072)
print v(xbgr.mr_n81445616)
print v(xbgr.mr_n82596608)
print v(xbgr.mr_n82744624)
print v(xbgr.mr_n82891584)
print v(xbgr.mr_n80936288)
print v(xbgr.mr_n81028720)
print v(xbgr.mr_n81257792)
print v(xbgr.mr_n81447184)
print v(xbgr.mr_n80221728)
print v(xbgr.mr_n80477584)
print v(xbgr.mr_n80655952)
print v(xbgr.mr_n80715056)
print v(xbgr.mr_n80882432)
print v(xbgr.mr_n80973792)
print v(xbgr.mr_n80414192)
print v(xbgr.mr_n81311232)
print v(xbgr.mr_n80221264)
print v(xbgr.mr_n80478176)
print v(xbgr.mr_n80656352)
print v(xbgr.mr_n80714464)
print v(xbgr.mr_n82597520)
print v(xbgr.mr_n82931136)
print v(xbgr.mr_n80220800)
print v(xbgr.mr_n80478768)
print v(xbgr.mr_n80651776)
print v(xbgr.mr_n80713872)
print v(xbgr.mr_n82595424)
print v(xbgr.mr_n82948016)
print v(xbgr.mr_n80934656)
print v(xbgr.mr_n81020880)
print v(xbgr.mr_n81227184)
print v(xbgr.mr_n81447712)
print v(xbgr.mr_n81560784)
print v(xbgr.mr_n81656096)
print v(xbgr.mr_n81783088)
print v(xbgr.mr_n81851552)
print v(xbgr.mr_n81990304)
print v(xbgr.mr_n82111072)
print v(xbgr.mr_n82206816)
print v(xbgr.mr_n82334176)
print v(xbgr.mr_n81562720)
print v(xbgr.mr_n81702752)
print v(xbgr.mr_n81786832)
print v(xbgr.mr_n81863808)
print v(xbgr.mr_n81987248)
print v(xbgr.mr_n82115776)
print v(xbgr.mr_n82208064)
print v(xbgr.mr_n82341696)
print v(xbgr.mr_n82400368)
print v(xbgr.mr_n82833248)
print v(xbgr.mr_n80220272)
print v(xbgr.mr_n80479360)
print v(xbgr.mr_n80657952)
print v(xbgr.mr_n80713280)
print v(xbgr.mr_n82596176)
print v(xbgr.mr_n82928272)
print v(xbgr.mr_n81477888)
print v(xbgr.mr_n81585312)
print v(xbgr.mr_n81716464)
print v(xbgr.mr_n81797232)
print v(xbgr.mr_n81880688)
print v(xbgr.mr_n82003888)
print v(xbgr.mr_n82129520)
print v(xbgr.mr_n82262096)
print v(xbgr.mr_n80210592)
print v(xbgr.mr_n80479952)
print v(xbgr.mr_n80653552)
print v(xbgr.mr_n80712688)
print v(xbgr.mr_n82585824)
print v(xbgr.mr_n82897728)
print v(xbgr.mr_n81559728)
print v(xbgr.mr_n81694864)
print v(xbgr.mr_n81788240)
print v(xbgr.mr_n81861120)
print v(xbgr.mr_n81992064)
print v(xbgr.mr_n82117376)
print v(xbgr.mr_n82184912)
print v(xbgr.mr_n82310128)
print v(xbgr.mr_n80930464)
print v(xbgr.mr_n81029600)
print v(xbgr.mr_n81253552)
print v(xbgr.mr_n81441792)
print v(xbgr.mr_n80219344)
print v(xbgr.mr_n80480544)
print v(xbgr.mr_n80659952)
print v(xbgr.mr_n80712032)
print v(xbgr.mr_n80926192)
print v(xbgr.mr_n81014464)
print v(xbgr.mr_n81256576)
print v(xbgr.mr_n81444928)
print v(xbgr.mr_n82593312)
print v(xbgr.mr_n82915744)
print v(xbgr.mr_n82399440)
print v(xbgr.mr_n82832320)
print v(xbgr.mr_n80215232)
print v(xbgr.mr_n80481136)
print v(xbgr.mr_n80660352)
print v(xbgr.mr_n80711504)
print v(xbgr.mr_n80882160)
print v(xbgr.mr_n80971680)
print v(xbgr.mr_n81093568)
print v(xbgr.mr_n81310048)
print v(xbgr.mr_n82589104)
print v(xbgr.mr_n82942192)
print v(xbgr.mr_n80158944)
print v(xbgr.mr_n80481728)
print v(xbgr.mr_n80661152)
print v(xbgr.mr_n80710848)
print v(xbgr.mr_n80931680)
print v(xbgr.mr_n81029248)
print v(xbgr.mr_n81227072)
print v(xbgr.mr_n81449136)
print v(xbgr.mr_n81558640)
print v(xbgr.mr_n81695264)
print v(xbgr.mr_n81784848)
print v(xbgr.mr_n81864976)
print v(xbgr.mr_n81990416)
print v(xbgr.mr_n82115088)
print v(xbgr.mr_n82192016)
print v(xbgr.mr_n82337120)
print v(xbgr.mr_n82590912)
print v(xbgr.mr_n83017712)
print v(xbgr.mr_n81555280)
print v(xbgr.mr_n81664288)
print v(xbgr.mr_n81789024)
print v(xbgr.mr_n81866512)
print v(xbgr.mr_n81991888)
print v(xbgr.mr_n82116944)
print v(xbgr.mr_n82211440)
print v(xbgr.mr_n82337472)
print v(xbgr.mr_n80218016)
print v(xbgr.mr_n80482320)
print v(xbgr.mr_n80661952)
print v(xbgr.mr_n80671952)
print v(xbgr.mr_n82591472)
print v(xbgr.mr_n82936928)
print v(xbgr.mr_n81477424)
print v(xbgr.mr_n81584848)
print v(xbgr.mr_n81716192)
print v(xbgr.mr_n81796960)
print v(xbgr.mr_n81880416)
print v(xbgr.mr_n82003616)
print v(xbgr.mr_n82129248)
print v(xbgr.mr_n82261824)
print v(xbgr.mr_n80217552)
print v(xbgr.mr_n80468112)
print v(xbgr.mr_n80657552)
print v(xbgr.mr_n80709728)
print v(xbgr.mr_n82398976)
print v(xbgr.mr_n82831856)
print v(xbgr.mr_n82586432)
print v(xbgr.mr_n83017824)
print v(xbgr.mr_n80217088)
print v(xbgr.mr_n80483424)
print v(xbgr.mr_n80663552)
print v(xbgr.mr_n80709136)
print v(xbgr.mr_n81558064)
print v(xbgr.mr_n81707280)
print v(xbgr.mr_n81787456)
print v(xbgr.mr_n81862688)
print v(xbgr.mr_n81991408)
print v(xbgr.mr_n82118480)
print v(xbgr.mr_n82184320)
print v(xbgr.mr_n82304144)
print v(xbgr.mr_n80932368)
print v(xbgr.mr_n81031168)
print v(xbgr.mr_n81254528)
print v(xbgr.mr_n81450320)
print v(xbgr.mr_n80933216)
print v(xbgr.mr_n81024016)
print v(xbgr.mr_n81255248)
print v(xbgr.mr_n81448752)
print v(xbgr.mr_n82588336)
print v(xbgr.mr_n82813840)
print v(xbgr.mr_n82934416)
print v(xbgr.mr_n80216624)
print v(xbgr.mr_n80484096)
print v(xbgr.mr_n80664352)
print v(xbgr.mr_n80708544)
print v(xbgr.mr_n80881888)
print v(xbgr.mr_n80970624)
print v(xbgr.mr_n81115152)
print v(xbgr.mr_n81308864)
print v(xbgr.mr_n82587536)
print v(xbgr.mr_n82742256)
print v(xbgr.mr_n82936320)
print v(xbgr.mr_n80216160)
print v(xbgr.mr_n80449488)
print v(xbgr.mr_n80658352)
print v(xbgr.mr_n80707952)
print v(xbgr.mr_n82398512)
print v(xbgr.mr_n82616176)
print v(xbgr.mr_n82831392)
print v(xbgr.mr_n80925200)
print v(xbgr.mr_n81027680)
print v(xbgr.mr_n81227296)
print v(xbgr.mr_n81450848)
print v(xbgr.mr_n81557072)
print v(xbgr.mr_n81660256)
print v(xbgr.mr_n81785744)
print v(xbgr.mr_n81867392)
print v(xbgr.mr_n81989248)
print v(xbgr.mr_n82113088)
print v(xbgr.mr_n82207872)
print v(xbgr.mr_n82328064)
print v(xbgr.mr_n82587360)
print v(xbgr.mr_n82743440)
print v(xbgr.mr_n82910256)
print v(xbgr.mr_n81552544)
print v(xbgr.mr_n81667776)
print v(xbgr.mr_n81790576)
print v(xbgr.mr_n81863120)
print v(xbgr.mr_n81994848)
print v(xbgr.mr_n82120480)
print v(xbgr.mr_n82212256)
print v(xbgr.mr_n82330768)
print v(xbgr.mr_n80215696)
print v(xbgr.mr_n80485280)
print v(xbgr.mr_n80665952)
print v(xbgr.mr_n80707360)
print v(xbgr.mr_n81476960)
print v(xbgr.mr_n81583920)
print v(xbgr.mr_n81715648)
print v(xbgr.mr_n81796688)
print v(xbgr.mr_n81879872)
print v(xbgr.mr_n82003072)
print v(xbgr.mr_n82128704)
print v(xbgr.mr_n82261280)
print v(xbgr.mr_n80205952)
print v(xbgr.mr_n80485872)
print v(xbgr.mr_n80661552)
print v(xbgr.mr_n80706768)
print v(xbgr.mr_n82582384)
print v(xbgr.mr_n82816016)
print v(xbgr.mr_n83018704)
print v(xbgr.mr_n80214704)
print v(xbgr.mr_n80486464)
print v(xbgr.mr_n80667744)
print v(xbgr.mr_n80706112)
print v(xbgr.mr_n82584752)
print v(xbgr.mr_n82741072)
print v(xbgr.mr_n83020368)
print v(xbgr.mr_n81547200)
print v(xbgr.mr_n81655088)
print v(xbgr.mr_n81791920)
print v(xbgr.mr_n81865824)
print v(xbgr.mr_n81996512)
print v(xbgr.mr_n82122080)
print v(xbgr.mr_n82185504)
print v(xbgr.mr_n82308352)
print v(xbgr.mr_n80929856)
print v(xbgr.mr_n81032736)
print v(xbgr.mr_n81251008)
print v(xbgr.mr_n81451888)
print v(xbgr.mr_n80931504)
print v(xbgr.mr_n81031856)
print v(xbgr.mr_n81254032)
print v(xbgr.mr_n81448064)
print v(xbgr.mr_n82397584)
print v(xbgr.mr_n82615712)
print v(xbgr.mr_n82830464)
print v(xbgr.mr_n80071232)
print v(xbgr.mr_n80487056)
print v(xbgr.mr_n80669584)
print v(xbgr.mr_n80649456)
print v(xbgr.mr_n82581296)
print v(xbgr.mr_n82740480)
print v(xbgr.mr_n83023216)
print v(xbgr.mr_n80881616)
print v(xbgr.mr_n80969568)
print v(xbgr.mr_n81049552)
print v(xbgr.mr_n81307680)
print v(xbgr.mr_n80213840)
print v(xbgr.mr_n80484688)
print v(xbgr.mr_n80662352)
print v(xbgr.mr_n80704992)
print v(xbgr.mr_n82582032)
print v(xbgr.mr_n82813296)
print v(xbgr.mr_n83018432)
print v(xbgr.mr_n80925760)
print v(xbgr.mr_n81030288)
print v(xbgr.mr_n81226848)
print v(xbgr.mr_n81431856)
print v(xbgr.mr_n80213376)
print v(xbgr.mr_n80488160)
print v(xbgr.mr_n80671296)
print v(xbgr.mr_n80704400)
print v(xbgr.mr_n81554240)
print v(xbgr.mr_n81670864)
print v(xbgr.mr_n81791552)
print v(xbgr.mr_n81871216)
print v(xbgr.mr_n81986448)
print v(xbgr.mr_n82121648)
print v(xbgr.mr_n82207360)
print v(xbgr.mr_n82333712)
print v(xbgr.mr_n81551568)
print v(xbgr.mr_n81668352)
print v(xbgr.mr_n81792768)
print v(xbgr.mr_n81869680)
print v(xbgr.mr_n81992416)
print v(xbgr.mr_n82123184)
print v(xbgr.mr_n82206704)
print v(xbgr.mr_n82334064)
print v(xbgr.mr_n82580832)
print v(xbgr.mr_n82697472)
print v(xbgr.mr_n83020976)
print v(xbgr.mr_n82397120)
print v(xbgr.mr_n82615248)
print v(xbgr.mr_n82830000)
print v(xbgr.mr_n80212912)
print v(xbgr.mr_n80488832)
print v(xbgr.mr_n80672480)
print v(xbgr.mr_n80703808)
print v(xbgr.mr_n81476496)
print v(xbgr.mr_n81583456)
print v(xbgr.mr_n81715376)
print v(xbgr.mr_n81796416)
print v(xbgr.mr_n81879600)
print v(xbgr.mr_n82002800)
print v(xbgr.mr_n82128432)
print v(xbgr.mr_n82261008)
print v(xbgr.mr_n82581184)
print v(xbgr.mr_n82738704)
print v(xbgr.mr_n83026352)
print v(xbgr.mr_n80212448)
print v(xbgr.mr_n80489424)
print v(xbgr.mr_n80665552)
print v(xbgr.mr_n80649920)
print v(xbgr.mr_n81554064)
print v(xbgr.mr_n81668960)
print v(xbgr.mr_n81789840)
print v(xbgr.mr_n81869136)
print v(xbgr.mr_n81997552)
print v(xbgr.mr_n82121168)
print v(xbgr.mr_n82183136)
print v(xbgr.mr_n82305920)
print v(xbgr.mr_n80928112)
print v(xbgr.mr_n81034304)
print v(xbgr.mr_n81251984)
print v(xbgr.mr_n81420688)
print v(xbgr.mr_n80930288)
print v(xbgr.mr_n81033424)
print v(xbgr.mr_n81252704)
print v(xbgr.mr_n81424672)
print v(xbgr.mr_n82579360)
print v(xbgr.mr_n82812208)
print v(xbgr.mr_n83020864)
print v(xbgr.mr_n80211984)
print v(xbgr.mr_n80490016)
print v(xbgr.mr_n80663152)
print v(xbgr.mr_n80702560)
print v(xbgr.mr_n82575136)
print v(xbgr.mr_n82739360)
print v(xbgr.mr_n83029728)
print v(xbgr.mr_n80881344)
print v(xbgr.mr_n80968512)
print v(xbgr.mr_n81043984)
print v(xbgr.mr_n81306496)
print v(xbgr.mr_n80211520)
print v(xbgr.mr_n80490608)
print v(xbgr.mr_n80670176)
print v(xbgr.mr_n80673136)
print v(xbgr.mr_n82396656)
print v(xbgr.mr_n82614784)
print v(xbgr.mr_n82829536)
print v(xbgr.mr_n82573008)
print v(xbgr.mr_n82739536)
print v(xbgr.mr_n83028912)
print v(xbgr.mr_n80210992)
print v(xbgr.mr_n80491200)
print v(xbgr.mr_n80668992)
print v(xbgr.mr_n80701440)
print v(xbgr.mr_n80927312)
print v(xbgr.mr_n81030816)
print v(xbgr.mr_n81221776)
print v(xbgr.mr_n81426480)
print v(xbgr.mr_n81549712)
print v(xbgr.mr_n81664912)
print v(xbgr.mr_n81793584)
print v(xbgr.mr_n81872096)
print v(xbgr.mr_n81994160)
print v(xbgr.mr_n82119792)
print v(xbgr.mr_n82206928)
print v(xbgr.mr_n82321920)
print v(xbgr.mr_n81537904)
print v(xbgr.mr_n81659840)
print v(xbgr.mr_n81790272)
print v(xbgr.mr_n81867824)
print v(xbgr.mr_n81999552)
print v(xbgr.mr_n82125184)
print v(xbgr.mr_n82209008)
print v(xbgr.mr_n82327360)
print v(xbgr.mr_n80209664)
print v(xbgr.mr_n80482912)
print v(xbgr.mr_n80668400)
print v(xbgr.mr_n80700848)
print v(xbgr.mr_n82567920)
print v(xbgr.mr_n82812752)
print v(xbgr.mr_n83027344)
print v(xbgr.mr_n81476032)
print v(xbgr.mr_n81582528)
print v(xbgr.mr_n81714832)
print v(xbgr.mr_n81796144)
print v(xbgr.mr_n81879056)
print v(xbgr.mr_n82002256)
print v(xbgr.mr_n82127888)
print v(xbgr.mr_n82260464)
print v(xbgr.mr_n82576736)
print v(xbgr.mr_n82695664)
print v(xbgr.mr_n83024608)
print v(xbgr.mr_n80210128)
print v(xbgr.mr_n80412864)
print v(xbgr.mr_n80666752)
print v(xbgr.mr_n80700256)
print v(xbgr.mr_n82395728)
print v(xbgr.mr_n82614320)
print v(xbgr.mr_n82828608)
print v(xbgr.mr_n81552368)
print v(xbgr.mr_n81674368)
print v(xbgr.mr_n81788592)
print v(xbgr.mr_n81874816)
print v(xbgr.mr_n81998016)
print v(xbgr.mr_n82117792)
print v(xbgr.mr_n82119360)
print v(xbgr.mr_n82306576)
print v(xbgr.mr_n80928000)
print v(xbgr.mr_n81035872)
print v(xbgr.mr_n81248464)
print v(xbgr.mr_n81422224)
print v(xbgr.mr_n80928848)
print v(xbgr.mr_n81034992)
print v(xbgr.mr_n81251488)
print v(xbgr.mr_n81422336)
print v(xbgr.mr_n82572896)
print v(xbgr.mr_n82734032)
print v(xbgr.mr_n83031472)
print v(xbgr.mr_n80072160)
print v(xbgr.mr_n80461008)
print v(xbgr.mr_n80659152)
print v(xbgr.mr_n80699664)
print v(xbgr.mr_n80881072)
print v(xbgr.mr_n80944016)
print v(xbgr.mr_n81056336)
print v(xbgr.mr_n81305312)
print v(xbgr.mr_n80209200)
print v(xbgr.mr_n80493568)
print v(xbgr.mr_n80665152)
print v(xbgr.mr_n80699072)
print v(xbgr.mr_n82573712)
print v(xbgr.mr_n82815472)
print v(xbgr.mr_n83029904)
print v(xbgr.mr_n80208736)
print v(xbgr.mr_n80494160)
print v(xbgr.mr_n80664752)
print v(xbgr.mr_n80698480)
print v(xbgr.mr_n82565920)
print v(xbgr.mr_n82736928)
print v(xbgr.mr_n83027168)
print v(xbgr.mr_n80923184)
print v(xbgr.mr_n81032320)
print v(xbgr.mr_n81190736)
print v(xbgr.mr_n81418912)
print v(xbgr.mr_n81548496)
print v(xbgr.mr_n81675040)
print v(xbgr.mr_n81786528)
print v(xbgr.mr_n81872528)
print v(xbgr.mr_n81992848)
print v(xbgr.mr_n82114656)
print v(xbgr.mr_n82193792)
print v(xbgr.mr_n82330304)
print v(xbgr.mr_n81550512)
print v(xbgr.mr_n81670416)
print v(xbgr.mr_n81786096)
print v(xbgr.mr_n81874384)
print v(xbgr.mr_n81996016)
print v(xbgr.mr_n82116464)
print v(xbgr.mr_n82207040)
print v(xbgr.mr_n82330656)
print v(xbgr.mr_n82395264)
print v(xbgr.mr_n82613856)
print v(xbgr.mr_n82828144)
print v(xbgr.mr_n80208272)
print v(xbgr.mr_n80494752)
print v(xbgr.mr_n80663952)
print v(xbgr.mr_n80697888)
print v(xbgr.mr_n82571888)
print v(xbgr.mr_n82737584)
print v(xbgr.mr_n83034032)
print v(xbgr.mr_n81475568)
print v(xbgr.mr_n81582064)
print v(xbgr.mr_n81714560)
print v(xbgr.mr_n81795872)
print v(xbgr.mr_n81878784)
print v(xbgr.mr_n82001984)
print v(xbgr.mr_n82127616)
print v(xbgr.mr_n82260192)
print v(xbgr.mr_n80207808)
print v(xbgr.mr_n80495344)
print v(xbgr.mr_n80662752)
print v(xbgr.mr_n80697296)
print v(xbgr.mr_n82565744)
print v(xbgr.mr_n82811664)
print v(xbgr.mr_n83032464)
print v(xbgr.mr_n81548672)
print v(xbgr.mr_n81689296)
print v(xbgr.mr_n81789488)
print v(xbgr.mr_n81864496)
print v(xbgr.mr_n81993232)
print v(xbgr.mr_n82118944)
print v(xbgr.mr_n82183728)
print v(xbgr.mr_n82257184)
print v(xbgr.mr_n80207344)
print v(xbgr.mr_n80495936)
print v(xbgr.mr_n80655152)
print v(xbgr.mr_n80696704)
print v(xbgr.mr_n80927136)
print v(xbgr.mr_n81037440)
print v(xbgr.mr_n81249376)
print v(xbgr.mr_n81414560)
print v(xbgr.mr_n80924400)
print v(xbgr.mr_n81038128)
print v(xbgr.mr_n81250160)
print v(xbgr.mr_n81416752)
print v(xbgr.mr_n82568752)
print v(xbgr.mr_n82735152)
print v(xbgr.mr_n83024784)
print v(xbgr.mr_n80206880)
print v(xbgr.mr_n80496528)
print v(xbgr.mr_n80654352)
print v(xbgr.mr_n80696112)
print v(xbgr.mr_n82394800)
print v(xbgr.mr_n82613392)
print v(xbgr.mr_n82827680)
print v(xbgr.mr_n80880800)
print v(xbgr.mr_n80949616)
print v(xbgr.mr_n81086400)
print v(xbgr.mr_n81304128)
print v(xbgr.mr_n82569184)
print v(xbgr.mr_n82735808)
print v(xbgr.mr_n83032288)
print v(xbgr.mr_n80206352)
print v(xbgr.mr_n80497120)
print v(xbgr.mr_n80660752)
print v(xbgr.mr_n80695520)
print v(xbgr.mr_n80925088)
print v(xbgr.mr_n81037024)
print v(xbgr.mr_n81196880)
print v(xbgr.mr_n81412224)
print v(xbgr.mr_n81547376)
print v(xbgr.mr_n81657072)
print v(xbgr.mr_n81783648)
print v(xbgr.mr_n81873216)
print v(xbgr.mr_n81990912)
print v(xbgr.mr_n82110384)
print v(xbgr.mr_n82204096)
print v(xbgr.mr_n82319184)
print v(xbgr.mr_n81541600)
print v(xbgr.mr_n81684784)
print v(xbgr.mr_n81787808)
print v(xbgr.mr_n81870112)
print v(xbgr.mr_n81989952)
print v(xbgr.mr_n82111696)
print v(xbgr.mr_n82204208)
print v(xbgr.mr_n82322496)
print v(xbgr.mr_n82570544)
print v(xbgr.mr_n82808144)
print v(xbgr.mr_n83035024)
print v(xbgr.mr_n80152896)
print v(xbgr.mr_n80497712)
print v(xbgr.mr_n80659552)
print v(xbgr.mr_n80667216)
print v(xbgr.mr_n82560976)
print v(xbgr.mr_n82733376)
print v(xbgr.mr_n83036592)
print v(xbgr.mr_n81475104)
print v(xbgr.mr_n81581136)
print v(xbgr.mr_n81714016)
print v(xbgr.mr_n81795600)
print v(xbgr.mr_n81878240)
print v(xbgr.mr_n82001440)
print v(xbgr.mr_n82127072)
print v(xbgr.mr_n82259728)
print v(xbgr.mr_n80203840)
print v(xbgr.mr_n80498304)
print v(xbgr.mr_n80658752)
print v(xbgr.mr_n80694336)
print v(xbgr.mr_n82393872)
print v(xbgr.mr_n82612928)
print v(xbgr.mr_n82826752)
print v(xbgr.mr_n82567808)
print v(xbgr.mr_n82727248)
print v(xbgr.mr_n83039152)
print v(xbgr.mr_n80072624)
print v(xbgr.mr_n80433888)
print v(xbgr.mr_n80651520)
print v(xbgr.mr_n80693744)
print v(xbgr.mr_n81545344)
print v(xbgr.mr_n81666544)
print v(xbgr.mr_n81784496)
print v(xbgr.mr_n81871744)
print v(xbgr.mr_n81986080)
print v(xbgr.mr_n82114304)
print v(xbgr.mr_n82163008)
print v(xbgr.mr_n82303024)
print v(xbgr.mr_n80917088)
print v(xbgr.mr_n81016608)
print v(xbgr.mr_n81247440)
print v(xbgr.mr_n81406368)
print v(xbgr.mr_n80925936)
print v(xbgr.mr_n81019536)
print v(xbgr.mr_n81245856)
print v(xbgr.mr_n81412112)
print v(xbgr.mr_n80065328)
print v(xbgr.mr_n80366496)
print v(xbgr.mr_n80657152)
print v(xbgr.mr_n80693152)
print v(xbgr.mr_n82564256)
print v(xbgr.mr_n82810032)
print v(xbgr.mr_n83034848)
print v(xbgr.mr_n80880528)
print v(xbgr.mr_n80946752)
print v(xbgr.mr_n81095200)
print v(xbgr.mr_n81303264)
print v(xbgr.mr_n80071696)
print v(xbgr.mr_n80432768)
print v(xbgr.mr_n80656752)
print v(xbgr.mr_n80692560)
print v(xbgr.mr_n82557232)
print v(xbgr.mr_n82731600)
print v(xbgr.mr_n83037584)
print v(xbgr.mr_n82393408)
print v(xbgr.mr_n82612304)
print v(xbgr.mr_n82826288)
print v(xbgr.mr_n80921120)
print v(xbgr.mr_n81016992)
print v(xbgr.mr_n81205792)
print v(xbgr.mr_n81406256)
print v(xbgr.mr_n81545520)
print v(xbgr.mr_n81674640)
print v(xbgr.mr_n81782000)
print v(xbgr.mr_n81868512)
print v(xbgr.mr_n81987744)
print v(xbgr.mr_n82105248)
print v(xbgr.mr_n82204912)
print v(xbgr.mr_n82326832)
print v(xbgr.mr_n80065024)
print v(xbgr.mr_n80432176)
print v(xbgr.mr_n80655552)
print v(xbgr.mr_n80691968)
print v(xbgr.mr_n81546400)
print v(xbgr.mr_n81703936)
print v(xbgr.mr_n81784064)
print v(xbgr.mr_n81865408)
print v(xbgr.mr_n81972112)
print v(xbgr.mr_n82112240)
print v(xbgr.mr_n82203680)
print v(xbgr.mr_n82327248)
print v(xbgr.mr_n82556384)
print v(xbgr.mr_n82732256)
print v(xbgr.mr_n83040144)
print v(xbgr.mr_n80070768)
print v(xbgr.mr_n80431584)
print v(xbgr.mr_n80654752)
print v(xbgr.mr_n80691376)
print v(xbgr.mr_n81474640)
print v(xbgr.mr_n81580672)
print v(xbgr.mr_n81713744)
print v(xbgr.mr_n81795408)
print v(xbgr.mr_n81877968)
print v(xbgr.mr_n82001168)
print v(xbgr.mr_n82126800)
print v(xbgr.mr_n82259616)
print v(xbgr.mr_n82563920)
print v(xbgr.mr_n82809520)
print v(xbgr.mr_n83037408)
print v(xbgr.mr_n80070304)
print v(xbgr.mr_n80430912)
print v(xbgr.mr_n80365552)
print v(xbgr.mr_n80690784)
print v(xbgr.mr_n82554960)
print v(xbgr.mr_n82729824)
print v(xbgr.mr_n83041712)
print v(xbgr.mr_n81543088)
print v(xbgr.mr_n81711776)
print v(xbgr.mr_n81765040)
print v(xbgr.d4)
print v(xbgr.mr_n81986784)
print v(xbgr.mr_n82109536)
print v(xbgr.mr_n82181360)
print v(xbgr.mr_n82300672)
print v(xbgr.mr_n80923008)
print v(xbgr.mr_n80995632)
print v(xbgr.mr_n81246896)
print v(xbgr.mr_n81403200)
print v(xbgr.mr_n80922576)
print v(xbgr.mr_n81000000)
print v(xbgr.mr_n81247616)
print v(xbgr.mr_n81409504)
print v(xbgr.mr_n82392944)
print v(xbgr.mr_n82612192)
print v(xbgr.mr_n82825824)
print v(xbgr.mr_n80069840)
print v(xbgr.mr_n80418752)
print v(xbgr.mr_n80653152)
print v(xbgr.mr_n80690192)
print v(xbgr.mr_n82562976)
print v(xbgr.mr_n82730480)
print v(xbgr.mr_n83042704)
print v(xbgr.mr_n80865888)
print v(xbgr.mr_n80941776)
print v(xbgr.mr_n81051600)
print v(xbgr.mr_n81302464)
print v(xbgr.mr_n80069376)
print v(xbgr.mr_n80429152)
print v(xbgr.mr_n80652752)
print v(xbgr.mr_n80688512)
print v(xbgr.mr_n82561712)
print v(xbgr.mr_n82809168)
print v(xbgr.mr_n83039968)
print v(xbgr.mr_n80921552)
print v(xbgr.mr_n80799552)
print v(xbgr.mr_n81207120)
print v(xbgr.mr_n81406144)
print v(xbgr.mr_n80068848)
print v(xbgr.mr_n80308560)
print v(xbgr.mr_n80539248)
print v(xbgr.mr_n80859056)
print v(xbgr.mr_n81535824)
print v(xbgr.mr_n81708656)
print v(xbgr.mr_n81765264)
print v(xbgr.mr_n81862336)
print v(xbgr.mr_n81984640)
print v(xbgr.mr_n82099840)
print v(xbgr.mr_n82187280)
print v(xbgr.mr_n82322112)
print v(xbgr.mr_n81544144)
print v(xbgr.mr_n81707648)
print v(xbgr.mr_n81733424)
print v(xbgr.mr_n81859792)
print v(xbgr.mr_n81983456)
print v(xbgr.mr_n82104368)
print v(xbgr.mr_n82203248)
print v(xbgr.mr_n82322304)
print v(xbgr.mr_n82559376)
print v(xbgr.mr_n82728176)
print v(xbgr.mr_n83044272)
print v(xbgr.mr_n80064912)
print v(xbgr.mr_n80427440)
print v(xbgr.mr_n80539840)
print v(xbgr.mr_n80879792)
print v(xbgr.mr_n82392256)
print v(xbgr.mr_n82539856)
print v(xbgr.mr_n82824896)
print v(xbgr.mr_n81474176)
print v(xbgr.mr_n81579744)
print v(xbgr.mr_n81713280)
print v(xbgr.mr_n81795296)
print v(xbgr.mr_n81877424)
print v(xbgr.mr_n82000704)
print v(xbgr.mr_n82126336)
print v(xbgr.mr_n82259392)
print v(xbgr.mr_n82560048)
print v(xbgr.mr_n82728704)
print v(xbgr.mr_n83046832)
print v(xbgr.mr_n80067984)
print v(xbgr.mr_n80426848)
print v(xbgr.mr_n80538064)
print v(xbgr.mr_n80879392)
print v(xbgr.mr_n81543264)
print v(xbgr.mr_n81690704)
print v(xbgr.mr_n81764928)
print v(xbgr.mr_n81858416)
print v(xbgr.mr_n81984064)
print v(xbgr.mr_n82104832)
print v(xbgr.mr_n82124064)
print v(xbgr.mr_n82257984)
print v(xbgr.mr_n80906352)
print v(xbgr.mr_n81244896)
print v(xbgr.mr_n81401056)
print v(xbgr.mr_n80916144)
print v(xbgr.mr_n81246400)
print v(xbgr.mr_n81401280)
print v(xbgr.mr_n82558448)
print v(xbgr.mr_n82805968)
print v(xbgr.mr_n83042528)
print v(xbgr.mr_n80065872)
print v(xbgr.mr_n80425664)
print v(xbgr.mr_n80538656)
print v(xbgr.mr_n80878992)
print v(xbgr.mr_n80408160)
print v(xbgr.mr_n80163008)
print v(xbgr.mr_n82554288)
print v(xbgr.mr_n82726784)
print v(xbgr.mr_n83045264)
print v(xbgr.mr_n80871392)
print v(xbgr.mr_n80986416)
print v(xbgr.mr_n80322736)
print v(xbgr.mr_n81276880)
print v(xbgr.mr_n80263856)
print v(xbgr.n_23)
print v(xbgr.mr_n80536880)
print v(xbgr.mr_n80878192)
print v(xbgr.mr_n80989616)
print v(xbgr.mr_n82391952)
print v(xbgr.mr_n82539392)
print v(xbgr.mr_n82824592)
print v(xbgr.mr_n82557456)
print v(xbgr.mr_n82725856)
print v(xbgr.mr_n83049392)
print v(xbgr.n_12)
print v(xbgr.n_25)
print v(xbgr.mr_n80537472)
print v(xbgr.mr_n80875792)
print v(xbgr.mr_n80921728)
print v(xbgr.mr_n81184592)
print v(xbgr.mr_n81395424)
print v(xbgr.mr_n81537728)
print v(xbgr.mr_n81655504)
print v(xbgr.mr_n81767120)
print v(xbgr.mr_n81857104)
print v(xbgr.mr_n81979472)
print v(xbgr.mr_n82102832)
print v(xbgr.mr_n82201040)
print v(xbgr.mr_n82323248)
print v(xbgr.mr_n81537248)
print v(xbgr.mr_n81710752)
print v(xbgr.mr_n81767712)
print v(xbgr.mr_n81860272)
print v(xbgr.mr_n81983568)
print v(xbgr.mr_n82099504)
print v(xbgr.mr_n82186096)
print v(xbgr.mr_n82315456)
print v(xbgr.mr_n80255920)
print v(xbgr.mr_n80364944)
print v(xbgr.mr_n80535696)
print v(xbgr.mr_n80873392)
print v(xbgr.mr_n82379040)
print v(xbgr.mr_n82803904)
print v(xbgr.mr_n83047824)
print v(xbgr.mr_n81473712)
print v(xbgr.mr_n81579360)
print v(xbgr.mr_n81660880)
print v(xbgr.mr_n81792336)
print v(xbgr.mr_n81877232)
print v(xbgr.mr_n82000592)
print v(xbgr.mr_n82126224)
print v(xbgr.mr_n82250784)
print v(xbgr.n_17)
print v(xbgr.n_22)
print v(xbgr.mr_n80536288)
print v(xbgr.mr_n80870992)
print v(xbgr.mr_n82536896)
print v(xbgr.mr_n82725392)
print v(xbgr.mr_n83045088)
print v(xbgr.mr_n82391648)
print v(xbgr.mr_n82538928)
print v(xbgr.mr_n82824288)
print v(xbgr.mr_n81537072)
print v(xbgr.mr_n81704800)
print v(xbgr.mr_n81778576)
print v(xbgr.mr_n81857568)
print v(xbgr.mr_n81980368)
print v(xbgr.mr_n82100880)
print v(xbgr.mr_n82181024)
print v(xbgr.mr_n82300848)
print v(xbgr.mr_n80911344)
print v(xbgr.mr_n81230128)
print v(xbgr.mr_n81330832)
print v(xbgr.n_18)
print v(xbgr.mr_n80363504)
print v(xbgr.mr_n80534512)
print v(xbgr.mr_n80868992)
print v(xbgr.mr_n80920448)
print v(xbgr.mr_n81244288)
print v(xbgr.mr_n81398352)
print v(xbgr.mr_n82555888)
print v(xbgr.mr_n82690240)
print v(xbgr.mr_n83051952)
print v(xbgr.mr_n80981456)
print v(xbgr.mr_n80195152)
print v(xbgr.mr_n80261072)
print v(xbgr.mr_n80362784)
print v(xbgr.mr_n80535104)
print v(xbgr.mr_n80866784)
print v(xbgr.mr_n80880192)
print v(xbgr.mr_n80380464)
print v(xbgr.mr_n81041040)
print v(xbgr.mr_n81279104)
print v(xbgr.mr_n82553600)
print v(xbgr.mr_n82806192)
print v(xbgr.mr_n83050384)
print v(xbgr.mr_n80372800)
print v(xbgr.mr_n80260560)
print v(xbgr.mr_n80362064)
print v(xbgr.mr_n80533920)
print v(xbgr.mr_n80866112)
print v(xbgr.mr_n80913760)
print v(xbgr.mr_n81213264)
print v(xbgr.mr_n81395536)
print v(xbgr.mr_n82543840)
print v(xbgr.mr_n82699392)
print v(xbgr.mr_n83055328)
print v(xbgr.mr_n81535360)
print v(xbgr.mr_n81626080)
print v(xbgr.mr_n81773008)
print v(xbgr.mr_n81854400)
print v(xbgr.mr_n81978304)
print v(xbgr.mr_n82094080)
print v(xbgr.mr_n82193200)
print v(xbgr.mr_n82319008)
print v(xbgr.mr_n81541264)
print v(xbgr.mr_n81627136)
print v(xbgr.mr_n81771248)
print v(xbgr.mr_n81851936)
print v(xbgr.mr_n81981536)
print v(xbgr.mr_n82100112)
print v(xbgr.mr_n82192608)
print v(xbgr.mr_n82321568)
print v(xbgr.mr_n82354048)
print v(xbgr.mr_n82606592)
print v(xbgr.mr_n82822544)
print v(xbgr.mr_n80251680)
print v(xbgr.mr_n80361344)
print v(xbgr.mr_n80532016)
print v(xbgr.mr_n80854992)
print v(xbgr.mr_n82545984)
print v(xbgr.mr_n82699280)
print v(xbgr.mr_n83054512)
print v(xbgr.mr_n81473248)
print v(xbgr.mr_n81567120)
print v(xbgr.mr_n81671296)
print v(xbgr.mr_n81794016)
print v(xbgr.mr_n81876384)
print v(xbgr.mr_n81998864)
print v(xbgr.mr_n82124496)
print v(xbgr.mr_n82258784)
print v(xbgr.mr_n82550448)
print v(xbgr.mr_n82808256)
print v(xbgr.mr_n83050208)
print v(xbgr.mr_n80976912)
print v(xbgr.mr_n81536416)
print v(xbgr.mr_n81623680)
print v(xbgr.mr_n81777072)
print v(xbgr.mr_n81852928)
print v(xbgr.mr_n81977408)
print v(xbgr.mr_n82063312)
print v(xbgr.mr_n82125872)
print v(xbgr.mr_n82253984)
print v(xbgr.mr_n80908768)
print v(xbgr.mr_n81229728)
print v(xbgr.mr_n81333680)
print v(xbgr.mr_n80916336)
print v(xbgr.mr_n81229392)
print v(xbgr.mr_n81391344)
print v(xbgr.mr_n82544016)
print v(xbgr.mr_n82693968)
print v(xbgr.mr_n83057888)
print v(xbgr.mr_n80191120)
print v(xbgr.mr_n82379840)
print v(xbgr.mr_n82595600)
print v(xbgr.mr_n82823552)
print v(xbgr.mr_n80864336)
print v(xbgr.mr_n80162400)
print v(xbgr.mr_n80334288)
print v(xbgr.mr_n81260624)
print v(xbgr.mr_n80409408)
print v(xbgr.mr_n82438288)
print v(xbgr.mr_n82690352)
print v(xbgr.mr_n83057072)
print v(xbgr.mr_n80913008)
print v(xbgr.mr_n81211936)
print v(xbgr.mr_n81391008)
print v(dvbe)
print v(iptat)
print v(pbias)
print v(pcasc)
print v(r4)
print v(vbe)
print v(vdd)
print v(vref)
print v(vdd)-v(vdd)
echo METALLIC_POINT_VOLTAGES_END
echo METALLIC_ALL_NODE_VOLTAGES_BEGIN
print v(xbgr.b1b)
print v(xbgr.c2)
print v(xbgr.d1)
print v(xbgr.d2)
print v(xbgr.d3)
print v(xbgr.d4)
print v(xbgr.d5)
print v(xbgr.det)
print v(dvbe)
print v(iptat)
print v(xbgr.kick)
print v(xbgr.mr_n66937600)
print v(xbgr.mr_n66983216)
print v(xbgr.mr_n68055632)
print v(xbgr.mr_n69421168)
print v(xbgr.mr_n69428176)
print v(xbgr.mr_n69461840)
print v(xbgr.mr_n69483184)
print v(xbgr.mr_n69489360)
print v(xbgr.mr_n70344896)
print v(xbgr.mr_n70347632)
print v(xbgr.mr_n70347744)
print v(xbgr.mr_n70348160)
print v(xbgr.mr_n70348272)
print v(xbgr.mr_n70348592)
print v(xbgr.mr_n70348704)
print v(xbgr.mr_n70349136)
print v(xbgr.mr_n70349376)
print v(xbgr.mr_n70349488)
print v(xbgr.mr_n70349840)
print v(xbgr.mr_n70350160)
print v(xbgr.mr_n70350272)
print v(xbgr.mr_n70350704)
print v(xbgr.mr_n70351024)
print v(xbgr.mr_n70351136)
print v(xbgr.mr_n70351568)
print v(xbgr.mr_n70351888)
print v(xbgr.mr_n70352000)
print v(xbgr.mr_n70352432)
print v(xbgr.mr_n70352752)
print v(xbgr.mr_n70352864)
print v(xbgr.mr_n70353296)
print v(xbgr.mr_n70353616)
print v(xbgr.mr_n70353728)
print v(xbgr.mr_n70354160)
print v(xbgr.mr_n70354480)
print v(xbgr.mr_n70354592)
print v(xbgr.mr_n70355024)
print v(xbgr.mr_n70355344)
print v(xbgr.mr_n70355456)
print v(xbgr.mr_n70355888)
print v(xbgr.mr_n70356208)
print v(xbgr.mr_n70356320)
print v(xbgr.mr_n70356752)
print v(xbgr.mr_n70357072)
print v(xbgr.mr_n70357184)
print v(xbgr.mr_n70357616)
print v(xbgr.mr_n70357936)
print v(xbgr.mr_n70358048)
print v(xbgr.mr_n70358480)
print v(xbgr.mr_n70358800)
print v(xbgr.mr_n70358912)
print v(xbgr.mr_n70359344)
print v(xbgr.mr_n70359664)
print v(xbgr.mr_n70359776)
print v(xbgr.mr_n70360208)
print v(xbgr.mr_n70360528)
print v(xbgr.mr_n70360640)
print v(xbgr.mr_n70361072)
print v(xbgr.mr_n70361392)
print v(xbgr.mr_n70361504)
print v(xbgr.mr_n70361936)
print v(xbgr.mr_n70362256)
print v(xbgr.mr_n70362368)
print v(xbgr.mr_n70362800)
print v(xbgr.mr_n70363120)
print v(xbgr.mr_n70363232)
print v(xbgr.mr_n70363552)
print v(xbgr.mr_n70363664)
print v(xbgr.mr_n70363984)
print v(xbgr.mr_n70364096)
print v(xbgr.mr_n70364416)
print v(xbgr.mr_n70364528)
print v(xbgr.mr_n70364848)
print v(xbgr.mr_n70364960)
print v(xbgr.mr_n70365280)
print v(xbgr.mr_n70365392)
print v(xbgr.mr_n70365712)
print v(xbgr.mr_n70365824)
print v(xbgr.mr_n70366144)
print v(xbgr.mr_n70366256)
print v(xbgr.mr_n70366576)
print v(xbgr.mr_n70366688)
print v(xbgr.mr_n70367008)
print v(xbgr.mr_n70367120)
print v(xbgr.mr_n70367440)
print v(xbgr.mr_n70367552)
print v(xbgr.mr_n70367872)
print v(xbgr.mr_n70367984)
print v(xbgr.mr_n70368304)
print v(xbgr.mr_n70368416)
print v(xbgr.mr_n70368736)
print v(xbgr.mr_n70368848)
print v(xbgr.mr_n70369168)
print v(xbgr.mr_n70369280)
print v(xbgr.mr_n70369600)
print v(xbgr.mr_n70369712)
print v(xbgr.mr_n70370032)
print v(xbgr.mr_n70370144)
print v(xbgr.mr_n70370464)
print v(xbgr.mr_n70370576)
print v(xbgr.mr_n70370896)
print v(xbgr.mr_n70371008)
print v(xbgr.mr_n70371328)
print v(xbgr.mr_n70371440)
print v(xbgr.mr_n70371760)
print v(xbgr.mr_n70371872)
print v(xbgr.mr_n70372192)
print v(xbgr.mr_n70372304)
print v(xbgr.mr_n70372624)
print v(xbgr.mr_n70372736)
print v(xbgr.mr_n70373056)
print v(xbgr.mr_n70373168)
print v(xbgr.mr_n70373488)
print v(xbgr.mr_n70373600)
print v(xbgr.mr_n70373920)
print v(xbgr.mr_n70374032)
print v(xbgr.mr_n70374352)
print v(xbgr.mr_n70374464)
print v(xbgr.mr_n70374784)
print v(xbgr.mr_n70374896)
print v(xbgr.mr_n70375216)
print v(xbgr.mr_n70375328)
print v(xbgr.mr_n70375648)
print v(xbgr.mr_n70375760)
print v(xbgr.mr_n70376080)
print v(xbgr.mr_n70376192)
print v(xbgr.mr_n70376512)
print v(xbgr.mr_n70376624)
print v(xbgr.mr_n70376944)
print v(xbgr.mr_n70377056)
print v(xbgr.mr_n70377376)
print v(xbgr.mr_n70377488)
print v(xbgr.mr_n70377808)
print v(xbgr.mr_n70377920)
print v(xbgr.mr_n70378240)
print v(xbgr.mr_n70378352)
print v(xbgr.mr_n70378672)
print v(xbgr.mr_n70378784)
print v(xbgr.mr_n70378912)
print v(xbgr.mr_n70379024)
print v(xbgr.mr_n70379344)
print v(xbgr.mr_n70379456)
print v(xbgr.mr_n70379776)
print v(xbgr.mr_n70379888)
print v(xbgr.mr_n70380208)
print v(xbgr.mr_n70380320)
print v(xbgr.mr_n70380640)
print v(xbgr.mr_n70380752)
print v(xbgr.mr_n70381072)
print v(xbgr.mr_n70381184)
print v(xbgr.mr_n70381504)
print v(xbgr.mr_n70381616)
print v(xbgr.mr_n70381936)
print v(xbgr.mr_n70382048)
print v(xbgr.mr_n70382368)
print v(xbgr.mr_n70382480)
print v(xbgr.mr_n70382800)
print v(xbgr.mr_n70382912)
print v(xbgr.mr_n70383232)
print v(xbgr.mr_n70383344)
print v(xbgr.mr_n70383664)
print v(xbgr.mr_n70383776)
print v(xbgr.mr_n70384096)
print v(xbgr.mr_n70384208)
print v(xbgr.mr_n70384528)
print v(xbgr.mr_n70384640)
print v(xbgr.mr_n70384960)
print v(xbgr.mr_n70385072)
print v(xbgr.mr_n70385392)
print v(xbgr.mr_n70385504)
print v(xbgr.mr_n70385824)
print v(xbgr.mr_n70385936)
print v(xbgr.mr_n70386256)
print v(xbgr.mr_n70386368)
print v(xbgr.mr_n70386688)
print v(xbgr.mr_n70386800)
print v(xbgr.mr_n70387120)
print v(xbgr.mr_n70387232)
print v(xbgr.mr_n70387552)
print v(xbgr.mr_n70387664)
print v(xbgr.mr_n70387984)
print v(xbgr.mr_n70388096)
print v(xbgr.mr_n70388416)
print v(xbgr.mr_n70388528)
print v(xbgr.mr_n70388848)
print v(xbgr.mr_n70388960)
print v(xbgr.mr_n70389280)
print v(xbgr.mr_n70389392)
print v(xbgr.mr_n70389712)
print v(xbgr.mr_n70389824)
print v(xbgr.mr_n70390144)
print v(xbgr.mr_n70390256)
print v(xbgr.mr_n70390576)
print v(xbgr.mr_n70390688)
print v(xbgr.mr_n70391008)
print v(xbgr.mr_n70391120)
print v(xbgr.mr_n70391440)
print v(xbgr.mr_n70391552)
print v(xbgr.mr_n70391872)
print v(xbgr.mr_n70391984)
print v(xbgr.mr_n70392304)
print v(xbgr.mr_n70392416)
print v(xbgr.mr_n70392736)
print v(xbgr.mr_n70392848)
print v(xbgr.mr_n70393168)
print v(xbgr.mr_n70393280)
print v(xbgr.mr_n70393600)
print v(xbgr.mr_n70393712)
print v(xbgr.mr_n70394032)
print v(xbgr.mr_n70394144)
print v(xbgr.mr_n70394464)
print v(xbgr.mr_n70394576)
print v(xbgr.mr_n70394896)
print v(xbgr.mr_n70395008)
print v(xbgr.mr_n70395328)
print v(xbgr.mr_n70395440)
print v(xbgr.mr_n70395760)
print v(xbgr.mr_n70395872)
print v(xbgr.mr_n70396192)
print v(xbgr.mr_n70396304)
print v(xbgr.mr_n70396624)
print v(xbgr.mr_n70396736)
print v(xbgr.mr_n70397056)
print v(xbgr.mr_n70397168)
print v(xbgr.mr_n70397488)
print v(xbgr.mr_n70397600)
print v(xbgr.mr_n70397920)
print v(xbgr.mr_n70398032)
print v(xbgr.mr_n70398352)
print v(xbgr.mr_n70398464)
print v(xbgr.mr_n70398784)
print v(xbgr.mr_n70398896)
print v(xbgr.mr_n70399216)
print v(xbgr.mr_n70399328)
print v(xbgr.mr_n70399648)
print v(xbgr.mr_n70399760)
print v(xbgr.mr_n70400080)
print v(xbgr.mr_n70400192)
print v(xbgr.mr_n70400512)
print v(xbgr.mr_n70400624)
print v(xbgr.mr_n70400944)
print v(xbgr.mr_n70401056)
print v(xbgr.mr_n70401376)
print v(xbgr.mr_n70401488)
print v(xbgr.mr_n70401808)
print v(xbgr.mr_n70401920)
print v(xbgr.mr_n70402240)
print v(xbgr.mr_n70402352)
print v(xbgr.mr_n70402672)
print v(xbgr.mr_n70402784)
print v(xbgr.mr_n70403104)
print v(xbgr.mr_n70403216)
print v(xbgr.mr_n70403536)
print v(xbgr.mr_n70403648)
print v(xbgr.mr_n70403968)
print v(xbgr.mr_n70404080)
print v(xbgr.mr_n70404400)
print v(xbgr.mr_n70404512)
print v(xbgr.mr_n70404832)
print v(xbgr.mr_n70404944)
print v(xbgr.mr_n70405264)
print v(xbgr.mr_n70405376)
print v(xbgr.mr_n70405696)
print v(xbgr.mr_n70405808)
print v(xbgr.mr_n70406128)
print v(xbgr.mr_n70406240)
print v(xbgr.mr_n70406560)
print v(xbgr.mr_n70406672)
print v(xbgr.mr_n70406992)
print v(xbgr.mr_n70407104)
print v(xbgr.mr_n70407424)
print v(xbgr.mr_n70407536)
print v(xbgr.mr_n70407856)
print v(xbgr.mr_n70407968)
print v(xbgr.mr_n70408288)
print v(xbgr.mr_n70408400)
print v(xbgr.mr_n70408720)
print v(xbgr.mr_n70408832)
print v(xbgr.mr_n70409152)
print v(xbgr.mr_n70409264)
print v(xbgr.mr_n70409584)
print v(xbgr.mr_n70409696)
print v(xbgr.mr_n70410016)
print v(xbgr.mr_n70410128)
print v(xbgr.mr_n70410448)
print v(xbgr.mr_n70410560)
print v(xbgr.mr_n70410880)
print v(xbgr.mr_n70410992)
print v(xbgr.mr_n70411312)
print v(xbgr.mr_n70411424)
print v(xbgr.mr_n70411744)
print v(xbgr.mr_n70411856)
print v(xbgr.mr_n70412176)
print v(xbgr.mr_n70412288)
print v(xbgr.mr_n70412608)
print v(xbgr.mr_n70412720)
print v(xbgr.mr_n70413040)
print v(xbgr.mr_n70413152)
print v(xbgr.mr_n70413472)
print v(xbgr.mr_n70413584)
print v(xbgr.mr_n70413904)
print v(xbgr.mr_n70414016)
print v(xbgr.mr_n70414336)
print v(xbgr.mr_n70414448)
print v(xbgr.mr_n70414992)
print v(xbgr.mr_n70415104)
print v(xbgr.mr_n70415424)
print v(xbgr.mr_n70415536)
print v(xbgr.mr_n70415856)
print v(xbgr.mr_n70415968)
print v(xbgr.mr_n70416288)
print v(xbgr.mr_n70416400)
print v(xbgr.mr_n70416720)
print v(xbgr.mr_n70416832)
print v(xbgr.mr_n70417152)
print v(xbgr.mr_n70417264)
print v(xbgr.mr_n70417584)
print v(xbgr.mr_n70417696)
print v(xbgr.mr_n70418016)
print v(xbgr.mr_n70418128)
print v(xbgr.mr_n70418448)
print v(xbgr.mr_n70418560)
print v(xbgr.mr_n70418880)
print v(xbgr.mr_n70418992)
print v(xbgr.mr_n70419312)
print v(xbgr.mr_n70419424)
print v(xbgr.mr_n70419744)
print v(xbgr.mr_n70419856)
print v(xbgr.mr_n70420176)
print v(xbgr.mr_n70420288)
print v(xbgr.mr_n70420608)
print v(xbgr.mr_n70420720)
print v(xbgr.mr_n70421040)
print v(xbgr.mr_n70421152)
print v(xbgr.mr_n70421472)
print v(xbgr.mr_n70421584)
print v(xbgr.mr_n70421904)
print v(xbgr.mr_n70422016)
print v(xbgr.mr_n70422336)
print v(xbgr.mr_n70422448)
print v(xbgr.mr_n70422768)
print v(xbgr.mr_n70422880)
print v(xbgr.mr_n70423200)
print v(xbgr.mr_n70423312)
print v(xbgr.mr_n70423632)
print v(xbgr.mr_n70423744)
print v(xbgr.mr_n70424064)
print v(xbgr.mr_n70424176)
print v(xbgr.mr_n70424496)
print v(xbgr.mr_n70424608)
print v(xbgr.mr_n70424928)
print v(xbgr.mr_n70425040)
print v(xbgr.mr_n70425360)
print v(xbgr.mr_n70425472)
print v(xbgr.mr_n70425792)
print v(xbgr.mr_n70425904)
print v(xbgr.mr_n70426224)
print v(xbgr.mr_n70426336)
print v(xbgr.mr_n70426656)
print v(xbgr.mr_n70426768)
print v(xbgr.mr_n70427088)
print v(xbgr.mr_n70427200)
print v(xbgr.mr_n70427520)
print v(xbgr.mr_n70427632)
print v(xbgr.mr_n70427952)
print v(xbgr.mr_n70428064)
print v(xbgr.mr_n70428384)
print v(xbgr.mr_n70428496)
print v(xbgr.mr_n70428816)
print v(xbgr.mr_n70428928)
print v(xbgr.mr_n70429248)
print v(xbgr.mr_n70429360)
print v(xbgr.mr_n70429680)
print v(xbgr.mr_n70429792)
print v(xbgr.mr_n70430112)
print v(xbgr.mr_n70430224)
print v(xbgr.mr_n70430544)
print v(xbgr.mr_n70430656)
print v(xbgr.mr_n70430976)
print v(xbgr.mr_n70431088)
print v(xbgr.mr_n70431408)
print v(xbgr.mr_n70431520)
print v(xbgr.mr_n70431840)
print v(xbgr.mr_n70431952)
print v(xbgr.mr_n70432272)
print v(xbgr.mr_n70432384)
print v(xbgr.mr_n70432704)
print v(xbgr.mr_n70432816)
print v(xbgr.mr_n70433136)
print v(xbgr.mr_n70433248)
print v(xbgr.mr_n70433568)
print v(xbgr.mr_n70433680)
print v(xbgr.mr_n70434000)
print v(xbgr.mr_n70434112)
print v(xbgr.mr_n70434432)
print v(xbgr.mr_n70434544)
print v(xbgr.mr_n70434864)
print v(xbgr.mr_n70434976)
print v(xbgr.mr_n70435296)
print v(xbgr.mr_n70435408)
print v(xbgr.mr_n70435728)
print v(xbgr.mr_n70435840)
print v(xbgr.mr_n70436160)
print v(xbgr.mr_n70436272)
print v(xbgr.mr_n70436592)
print v(xbgr.mr_n70436704)
print v(xbgr.mr_n70437024)
print v(xbgr.mr_n70437136)
print v(xbgr.mr_n70437456)
print v(xbgr.mr_n70437568)
print v(xbgr.mr_n70437888)
print v(xbgr.mr_n70438000)
print v(xbgr.mr_n70438320)
print v(xbgr.mr_n70438432)
print v(xbgr.mr_n70438752)
print v(xbgr.mr_n70438864)
print v(xbgr.mr_n70439184)
print v(xbgr.mr_n70439296)
print v(xbgr.mr_n70439616)
print v(xbgr.mr_n70439728)
print v(xbgr.mr_n70440048)
print v(xbgr.mr_n70440160)
print v(xbgr.mr_n70440480)
print v(xbgr.mr_n70440592)
print v(xbgr.mr_n70440912)
print v(xbgr.mr_n70441024)
print v(xbgr.mr_n70441344)
print v(xbgr.mr_n70441456)
print v(xbgr.mr_n70441776)
print v(xbgr.mr_n70441888)
print v(xbgr.mr_n70442208)
print v(xbgr.mr_n70442320)
print v(xbgr.mr_n70442640)
print v(xbgr.mr_n70442752)
print v(xbgr.mr_n70443072)
print v(xbgr.mr_n70443184)
print v(xbgr.mr_n70443504)
print v(xbgr.mr_n70443616)
print v(xbgr.mr_n70443936)
print v(xbgr.mr_n70444048)
print v(xbgr.mr_n70444368)
print v(xbgr.mr_n70444480)
print v(xbgr.mr_n70444800)
print v(xbgr.mr_n70444912)
print v(xbgr.mr_n70445232)
print v(xbgr.mr_n70445344)
print v(xbgr.mr_n70445664)
print v(xbgr.mr_n70445776)
print v(xbgr.mr_n70446096)
print v(xbgr.mr_n70446208)
print v(xbgr.mr_n70446528)
print v(xbgr.mr_n70446640)
print v(xbgr.mr_n70446960)
print v(xbgr.mr_n70447072)
print v(xbgr.mr_n70447392)
print v(xbgr.mr_n70447504)
print v(xbgr.mr_n70447824)
print v(xbgr.mr_n70447936)
print v(xbgr.mr_n70448256)
print v(xbgr.mr_n70448368)
print v(xbgr.mr_n70448688)
print v(xbgr.mr_n70448800)
print v(xbgr.mr_n70449120)
print v(xbgr.mr_n70449232)
print v(xbgr.mr_n70449552)
print v(xbgr.mr_n70449664)
print v(xbgr.mr_n70449984)
print v(xbgr.mr_n70450096)
print v(xbgr.mr_n70450416)
print v(xbgr.mr_n70450528)
print v(xbgr.mr_n70450848)
print v(xbgr.mr_n70450960)
print v(xbgr.mr_n70451280)
print v(xbgr.mr_n70451392)
print v(xbgr.mr_n70451712)
print v(xbgr.mr_n70451824)
print v(xbgr.mr_n70452144)
print v(xbgr.mr_n70452256)
print v(xbgr.mr_n70452576)
print v(xbgr.mr_n70452688)
print v(xbgr.mr_n70453008)
print v(xbgr.mr_n70453120)
print v(xbgr.mr_n70453440)
print v(xbgr.mr_n70453552)
print v(xbgr.mr_n70453872)
print v(xbgr.mr_n70453984)
print v(xbgr.mr_n70454304)
print v(xbgr.mr_n70454416)
print v(xbgr.mr_n70454736)
print v(xbgr.mr_n70454848)
print v(xbgr.mr_n70455168)
print v(xbgr.mr_n70455280)
print v(xbgr.mr_n70455600)
print v(xbgr.mr_n70455712)
print v(xbgr.mr_n70456032)
print v(xbgr.mr_n70456144)
print v(xbgr.mr_n70456464)
print v(xbgr.mr_n70456576)
print v(xbgr.mr_n70456896)
print v(xbgr.mr_n70457008)
print v(xbgr.mr_n70457328)
print v(xbgr.mr_n70457440)
print v(xbgr.mr_n70457760)
print v(xbgr.mr_n70457872)
print v(xbgr.mr_n70458192)
print v(xbgr.mr_n70458304)
print v(xbgr.mr_n70458624)
print v(xbgr.mr_n70458736)
print v(xbgr.mr_n70459056)
print v(xbgr.mr_n70459168)
print v(xbgr.mr_n70459488)
print v(xbgr.mr_n70459600)
print v(xbgr.mr_n70459920)
print v(xbgr.mr_n70460032)
print v(xbgr.mr_n70460352)
print v(xbgr.mr_n70460464)
print v(xbgr.mr_n70460784)
print v(xbgr.mr_n70460896)
print v(xbgr.mr_n70461216)
print v(xbgr.mr_n70461328)
print v(xbgr.mr_n70461648)
print v(xbgr.mr_n70461760)
print v(xbgr.mr_n70462080)
print v(xbgr.mr_n70462192)
print v(xbgr.mr_n70462512)
print v(xbgr.mr_n70462624)
print v(xbgr.mr_n70462944)
print v(xbgr.mr_n70463056)
print v(xbgr.mr_n70463376)
print v(xbgr.mr_n70463488)
print v(xbgr.mr_n70463808)
print v(xbgr.mr_n70463920)
print v(xbgr.mr_n70464240)
print v(xbgr.mr_n70464352)
print v(xbgr.mr_n70464672)
print v(xbgr.mr_n70464784)
print v(xbgr.mr_n70465104)
print v(xbgr.mr_n70465216)
print v(xbgr.mr_n70465536)
print v(xbgr.mr_n70465648)
print v(xbgr.mr_n70465968)
print v(xbgr.mr_n70466080)
print v(xbgr.mr_n70466400)
print v(xbgr.mr_n70466512)
print v(xbgr.mr_n70466832)
print v(xbgr.mr_n70466944)
print v(xbgr.mr_n70467264)
print v(xbgr.mr_n70467376)
print v(xbgr.mr_n70467696)
print v(xbgr.mr_n70467808)
print v(xbgr.mr_n70468128)
print v(xbgr.mr_n70468240)
print v(xbgr.mr_n70468560)
print v(xbgr.mr_n70468672)
print v(xbgr.mr_n70468992)
print v(xbgr.mr_n70469104)
print v(xbgr.mr_n70469424)
print v(xbgr.mr_n70469536)
print v(xbgr.mr_n70469856)
print v(xbgr.mr_n70469968)
print v(xbgr.mr_n70470288)
print v(xbgr.mr_n70470400)
print v(xbgr.mr_n70470720)
print v(xbgr.mr_n70470832)
print v(xbgr.mr_n70471152)
print v(xbgr.mr_n70471264)
print v(xbgr.mr_n70471584)
print v(xbgr.mr_n70471696)
print v(xbgr.mr_n70472016)
print v(xbgr.mr_n70472128)
print v(xbgr.mr_n70472448)
print v(xbgr.mr_n70472560)
print v(xbgr.mr_n70472880)
print v(xbgr.mr_n70472992)
print v(xbgr.mr_n70473312)
print v(xbgr.mr_n70473424)
print v(xbgr.mr_n70473744)
print v(xbgr.mr_n70473856)
print v(xbgr.mr_n70474176)
print v(xbgr.mr_n70474288)
print v(xbgr.mr_n70474608)
print v(xbgr.mr_n70474720)
print v(xbgr.mr_n70475040)
print v(xbgr.mr_n70475152)
print v(xbgr.mr_n70475472)
print v(xbgr.mr_n70475584)
print v(xbgr.mr_n70475904)
print v(xbgr.mr_n70476016)
print v(xbgr.mr_n70476336)
print v(xbgr.mr_n70476448)
print v(xbgr.mr_n70476768)
print v(xbgr.mr_n70476880)
print v(xbgr.mr_n70477200)
print v(xbgr.mr_n70477312)
print v(xbgr.mr_n70477632)
print v(xbgr.mr_n70477744)
print v(xbgr.mr_n70478064)
print v(xbgr.mr_n70478176)
print v(xbgr.mr_n70478496)
print v(xbgr.mr_n70478608)
print v(xbgr.mr_n70478928)
print v(xbgr.mr_n70479040)
print v(xbgr.mr_n70479360)
print v(xbgr.mr_n70479472)
print v(xbgr.mr_n70479792)
print v(xbgr.mr_n70479904)
print v(xbgr.mr_n70480224)
print v(xbgr.mr_n70480336)
print v(xbgr.mr_n70480656)
print v(xbgr.mr_n70480768)
print v(xbgr.mr_n70481088)
print v(xbgr.mr_n70481200)
print v(xbgr.mr_n70481520)
print v(xbgr.mr_n70481632)
print v(xbgr.mr_n70481952)
print v(xbgr.mr_n70482064)
print v(xbgr.mr_n70482384)
print v(xbgr.mr_n70482496)
print v(xbgr.mr_n70482816)
print v(xbgr.mr_n70482928)
print v(xbgr.mr_n70483248)
print v(xbgr.mr_n70483360)
print v(xbgr.mr_n70483680)
print v(xbgr.mr_n70483792)
print v(xbgr.mr_n70484112)
print v(xbgr.mr_n70484224)
print v(xbgr.mr_n70484544)
print v(xbgr.mr_n70484656)
print v(xbgr.mr_n70484976)
print v(xbgr.mr_n70485088)
print v(xbgr.mr_n70485408)
print v(xbgr.mr_n70485520)
print v(xbgr.mr_n70485840)
print v(xbgr.mr_n70485952)
print v(xbgr.mr_n70486272)
print v(xbgr.mr_n70486384)
print v(xbgr.mr_n70486704)
print v(xbgr.mr_n70486816)
print v(xbgr.mr_n70487136)
print v(xbgr.mr_n70487248)
print v(xbgr.mr_n70487568)
print v(xbgr.mr_n70487680)
print v(xbgr.mr_n70488000)
print v(xbgr.mr_n70488112)
print v(xbgr.mr_n70488432)
print v(xbgr.mr_n70488544)
print v(xbgr.mr_n70488864)
print v(xbgr.mr_n70488976)
print v(xbgr.mr_n70489296)
print v(xbgr.mr_n70489408)
print v(xbgr.mr_n70489728)
print v(xbgr.mr_n70489840)
print v(xbgr.mr_n70490160)
print v(xbgr.mr_n70490272)
print v(xbgr.mr_n70490592)
print v(xbgr.mr_n70490704)
print v(xbgr.mr_n70491024)
print v(xbgr.mr_n70491136)
print v(xbgr.mr_n70491456)
print v(xbgr.mr_n70491568)
print v(xbgr.mr_n70491888)
print v(xbgr.mr_n70492000)
print v(xbgr.mr_n70492320)
print v(xbgr.mr_n70492432)
print v(xbgr.mr_n70492752)
print v(xbgr.mr_n70492864)
print v(xbgr.mr_n70493184)
print v(xbgr.mr_n70493296)
print v(xbgr.mr_n70493616)
print v(xbgr.mr_n70493728)
print v(xbgr.mr_n70494048)
print v(xbgr.mr_n70494160)
print v(xbgr.mr_n70494480)
print v(xbgr.mr_n70494592)
print v(xbgr.mr_n70494912)
print v(xbgr.mr_n70495024)
print v(xbgr.mr_n70495344)
print v(xbgr.mr_n70495456)
print v(xbgr.mr_n70495776)
print v(xbgr.mr_n70495888)
print v(xbgr.mr_n70496208)
print v(xbgr.mr_n70496320)
print v(xbgr.mr_n70496640)
print v(xbgr.mr_n70496752)
print v(xbgr.mr_n70497072)
print v(xbgr.mr_n70497184)
print v(xbgr.mr_n70497504)
print v(xbgr.mr_n70497616)
print v(xbgr.mr_n70497936)
print v(xbgr.mr_n70498048)
print v(xbgr.mr_n70498368)
print v(xbgr.mr_n70498480)
print v(xbgr.mr_n70498800)
print v(xbgr.mr_n70498912)
print v(xbgr.mr_n70499232)
print v(xbgr.mr_n70499344)
print v(xbgr.mr_n70499664)
print v(xbgr.mr_n70499776)
print v(xbgr.mr_n70500096)
print v(xbgr.mr_n70500208)
print v(xbgr.mr_n70500528)
print v(xbgr.mr_n70500640)
print v(xbgr.mr_n70500960)
print v(xbgr.mr_n70501072)
print v(xbgr.mr_n70501392)
print v(xbgr.mr_n70501504)
print v(xbgr.mr_n70501824)
print v(xbgr.mr_n70501936)
print v(xbgr.mr_n70502256)
print v(xbgr.mr_n70502368)
print v(xbgr.mr_n70502688)
print v(xbgr.mr_n70502800)
print v(xbgr.mr_n70503120)
print v(xbgr.mr_n70503232)
print v(xbgr.mr_n70503552)
print v(xbgr.mr_n70503664)
print v(xbgr.mr_n70503984)
print v(xbgr.mr_n70504096)
print v(xbgr.mr_n70504416)
print v(xbgr.mr_n70504528)
print v(xbgr.mr_n70504848)
print v(xbgr.mr_n70504960)
print v(xbgr.mr_n70505280)
print v(xbgr.mr_n70505392)
print v(xbgr.mr_n70505712)
print v(xbgr.mr_n70505824)
print v(xbgr.mr_n70506144)
print v(xbgr.mr_n70506256)
print v(xbgr.mr_n70506576)
print v(xbgr.mr_n70506688)
print v(xbgr.mr_n70507008)
print v(xbgr.mr_n70507120)
print v(xbgr.mr_n70507440)
print v(xbgr.mr_n70507552)
print v(xbgr.mr_n70507872)
print v(xbgr.mr_n70507984)
print v(xbgr.mr_n70508304)
print v(xbgr.mr_n70508416)
print v(xbgr.mr_n70508736)
print v(xbgr.mr_n70508848)
print v(xbgr.mr_n70509168)
print v(xbgr.mr_n70509280)
print v(xbgr.mr_n70509600)
print v(xbgr.mr_n70509712)
print v(xbgr.mr_n70510032)
print v(xbgr.mr_n70510144)
print v(xbgr.mr_n70510464)
print v(xbgr.mr_n70510576)
print v(xbgr.mr_n70510896)
print v(xbgr.mr_n70511008)
print v(xbgr.mr_n70511328)
print v(xbgr.mr_n70511440)
print v(xbgr.mr_n70511760)
print v(xbgr.mr_n70511872)
print v(xbgr.mr_n70512192)
print v(xbgr.mr_n70512304)
print v(xbgr.mr_n70512624)
print v(xbgr.mr_n70512736)
print v(xbgr.mr_n70513056)
print v(xbgr.mr_n70513168)
print v(xbgr.mr_n71517792)
print v(xbgr.mr_n71517904)
print v(xbgr.mr_n71518160)
print v(xbgr.mr_n71518272)
print v(xbgr.mr_n71518528)
print v(xbgr.mr_n71518640)
print v(xbgr.mr_n71518896)
print v(xbgr.mr_n71519008)
print v(xbgr.mr_n71519264)
print v(xbgr.mr_n71519376)
print v(xbgr.mr_n71519632)
print v(xbgr.mr_n71519744)
print v(xbgr.mr_n71520000)
print v(xbgr.mr_n71520112)
print v(xbgr.mr_n71520400)
print v(xbgr.mr_n71520512)
print v(xbgr.mr_n71520832)
print v(xbgr.mr_n71520944)
print v(xbgr.mr_n71521264)
print v(xbgr.mr_n71521376)
print v(xbgr.mr_n71521696)
print v(xbgr.mr_n71521808)
print v(xbgr.mr_n71522128)
print v(xbgr.mr_n71522240)
print v(xbgr.mr_n71522560)
print v(xbgr.mr_n71522672)
print v(xbgr.mr_n71522992)
print v(xbgr.mr_n71523104)
print v(xbgr.mr_n71523424)
print v(xbgr.mr_n71523536)
print v(xbgr.mr_n71523856)
print v(xbgr.mr_n71523968)
print v(xbgr.mr_n71524288)
print v(xbgr.mr_n71524400)
print v(xbgr.mr_n71524720)
print v(xbgr.mr_n71524832)
print v(xbgr.mr_n71525152)
print v(xbgr.mr_n71525264)
print v(xbgr.mr_n71525584)
print v(xbgr.mr_n71525696)
print v(xbgr.mr_n71526016)
print v(xbgr.mr_n71526128)
print v(xbgr.mr_n71526448)
print v(xbgr.mr_n71526560)
print v(xbgr.mr_n71526880)
print v(xbgr.mr_n71526992)
print v(xbgr.mr_n71527312)
print v(xbgr.mr_n71527424)
print v(xbgr.mr_n71527744)
print v(xbgr.mr_n71527856)
print v(xbgr.mr_n71528176)
print v(xbgr.mr_n71528288)
print v(xbgr.mr_n71528608)
print v(xbgr.mr_n71528720)
print v(xbgr.mr_n71529040)
print v(xbgr.mr_n71529152)
print v(xbgr.mr_n71529472)
print v(xbgr.mr_n71529584)
print v(xbgr.mr_n71529904)
print v(xbgr.mr_n71530016)
print v(xbgr.mr_n71530336)
print v(xbgr.mr_n71530448)
print v(xbgr.mr_n71530768)
print v(xbgr.mr_n71530880)
print v(xbgr.mr_n71531200)
print v(xbgr.mr_n71531312)
print v(xbgr.mr_n71531632)
print v(xbgr.mr_n71531744)
print v(xbgr.mr_n71532064)
print v(xbgr.mr_n71532176)
print v(xbgr.mr_n71532496)
print v(xbgr.mr_n71532608)
print v(xbgr.mr_n71532928)
print v(xbgr.mr_n71533040)
print v(xbgr.mr_n71533360)
print v(xbgr.mr_n71533472)
print v(xbgr.mr_n71533792)
print v(xbgr.mr_n71533904)
print v(xbgr.mr_n71534224)
print v(xbgr.mr_n71534336)
print v(xbgr.mr_n71534656)
print v(xbgr.mr_n71534768)
print v(xbgr.mr_n71535088)
print v(xbgr.mr_n71535200)
print v(xbgr.mr_n71535520)
print v(xbgr.mr_n71535632)
print v(xbgr.mr_n71535952)
print v(xbgr.mr_n71536064)
print v(xbgr.mr_n71536384)
print v(xbgr.mr_n71536496)
print v(xbgr.mr_n71536816)
print v(xbgr.mr_n71536928)
print v(xbgr.mr_n71537248)
print v(xbgr.mr_n71537360)
print v(xbgr.mr_n71537680)
print v(xbgr.mr_n71537792)
print v(xbgr.mr_n71538112)
print v(xbgr.mr_n71538224)
print v(xbgr.mr_n71538544)
print v(xbgr.mr_n71538656)
print v(xbgr.mr_n71538976)
print v(xbgr.mr_n71539088)
print v(xbgr.mr_n71539408)
print v(xbgr.mr_n71539520)
print v(xbgr.mr_n71539840)
print v(xbgr.mr_n71539952)
print v(xbgr.mr_n71540272)
print v(xbgr.mr_n71540384)
print v(xbgr.mr_n71540704)
print v(xbgr.mr_n71540816)
print v(xbgr.mr_n71541136)
print v(xbgr.mr_n71541248)
print v(xbgr.mr_n71541568)
print v(xbgr.mr_n71541680)
print v(xbgr.mr_n71542000)
print v(xbgr.mr_n71542112)
print v(xbgr.mr_n71542432)
print v(xbgr.mr_n71542544)
print v(xbgr.mr_n71542864)
print v(xbgr.mr_n71542976)
print v(xbgr.mr_n71543296)
print v(xbgr.mr_n71543408)
print v(xbgr.mr_n71543728)
print v(xbgr.mr_n71543840)
print v(xbgr.mr_n71544160)
print v(xbgr.mr_n71544272)
print v(xbgr.mr_n71544592)
print v(xbgr.mr_n71544704)
print v(xbgr.mr_n71545024)
print v(xbgr.mr_n71545136)
print v(xbgr.mr_n71545456)
print v(xbgr.mr_n71545568)
print v(xbgr.mr_n71545888)
print v(xbgr.mr_n71546000)
print v(xbgr.mr_n71546320)
print v(xbgr.mr_n71546432)
print v(xbgr.mr_n71546752)
print v(xbgr.mr_n71546864)
print v(xbgr.mr_n71547184)
print v(xbgr.mr_n71547296)
print v(xbgr.mr_n71547616)
print v(xbgr.mr_n71547728)
print v(xbgr.mr_n71548048)
print v(xbgr.mr_n71548160)
print v(xbgr.mr_n71548480)
print v(xbgr.mr_n71548592)
print v(xbgr.mr_n71548912)
print v(xbgr.mr_n71549024)
print v(xbgr.mr_n71549344)
print v(xbgr.mr_n71549456)
print v(xbgr.mr_n71549776)
print v(xbgr.mr_n71549888)
print v(xbgr.mr_n71550208)
print v(xbgr.mr_n71550320)
print v(xbgr.mr_n71550640)
print v(xbgr.mr_n71550752)
print v(xbgr.mr_n71551072)
print v(xbgr.mr_n71551184)
print v(xbgr.mr_n71551504)
print v(xbgr.mr_n71551616)
print v(xbgr.mr_n71551936)
print v(xbgr.mr_n71552048)
print v(xbgr.mr_n71552368)
print v(xbgr.mr_n71552480)
print v(xbgr.mr_n71552800)
print v(xbgr.mr_n71552912)
print v(xbgr.mr_n71553232)
print v(xbgr.mr_n71553344)
print v(xbgr.mr_n71553664)
print v(xbgr.mr_n71553776)
print v(xbgr.mr_n71554096)
print v(xbgr.mr_n71554208)
print v(xbgr.mr_n71554528)
print v(xbgr.mr_n71554640)
print v(xbgr.mr_n71554960)
print v(xbgr.mr_n71555072)
print v(xbgr.mr_n71555392)
print v(xbgr.mr_n71555504)
print v(xbgr.mr_n71555824)
print v(xbgr.mr_n71555936)
print v(xbgr.mr_n71556256)
print v(xbgr.mr_n71556368)
print v(xbgr.mr_n71556688)
print v(xbgr.mr_n71556800)
print v(xbgr.mr_n71557120)
print v(xbgr.mr_n71557232)
print v(xbgr.mr_n71557552)
print v(xbgr.mr_n71557664)
print v(xbgr.mr_n71557984)
print v(xbgr.mr_n71558096)
print v(xbgr.mr_n71558416)
print v(xbgr.mr_n71558528)
print v(xbgr.mr_n71558848)
print v(xbgr.mr_n71558960)
print v(xbgr.mr_n71559280)
print v(xbgr.mr_n71559392)
print v(xbgr.mr_n71559712)
print v(xbgr.mr_n71559824)
print v(xbgr.mr_n71560144)
print v(xbgr.mr_n71560256)
print v(xbgr.mr_n71560576)
print v(xbgr.mr_n71560688)
print v(xbgr.mr_n71561008)
print v(xbgr.mr_n71561120)
print v(xbgr.mr_n71561440)
print v(xbgr.mr_n71561552)
print v(xbgr.mr_n71561872)
print v(xbgr.mr_n71561984)
print v(xbgr.mr_n71562304)
print v(xbgr.mr_n71562416)
print v(xbgr.mr_n71562736)
print v(xbgr.mr_n71562848)
print v(xbgr.mr_n71563168)
print v(xbgr.mr_n71563280)
print v(xbgr.mr_n71563600)
print v(xbgr.mr_n71563712)
print v(xbgr.mr_n71564032)
print v(xbgr.mr_n71564144)
print v(xbgr.mr_n71564464)
print v(xbgr.mr_n71564576)
print v(xbgr.mr_n71564896)
print v(xbgr.mr_n71565008)
print v(xbgr.mr_n71565328)
print v(xbgr.mr_n71565440)
print v(xbgr.mr_n71565760)
print v(xbgr.mr_n71565872)
print v(xbgr.mr_n71566192)
print v(xbgr.mr_n71566304)
print v(xbgr.mr_n71566624)
print v(xbgr.mr_n71566736)
print v(xbgr.mr_n71567056)
print v(xbgr.mr_n71567168)
print v(xbgr.mr_n71567488)
print v(xbgr.mr_n71567600)
print v(xbgr.mr_n71567920)
print v(xbgr.mr_n71568032)
print v(xbgr.mr_n71568352)
print v(xbgr.mr_n71568464)
print v(xbgr.mr_n71568784)
print v(xbgr.mr_n71568896)
print v(xbgr.mr_n71569216)
print v(xbgr.mr_n71569328)
print v(xbgr.mr_n71569648)
print v(xbgr.mr_n71569760)
print v(xbgr.mr_n71570080)
print v(xbgr.mr_n71570192)
print v(xbgr.mr_n71570512)
print v(xbgr.mr_n71570624)
print v(xbgr.mr_n71570944)
print v(xbgr.mr_n71571056)
print v(xbgr.mr_n71571376)
print v(xbgr.mr_n71571488)
print v(xbgr.mr_n71571808)
print v(xbgr.mr_n71571920)
print v(xbgr.mr_n71572240)
print v(xbgr.mr_n71572352)
print v(xbgr.mr_n71572672)
print v(xbgr.mr_n71572784)
print v(xbgr.mr_n71573104)
print v(xbgr.mr_n71573216)
print v(xbgr.mr_n71573536)
print v(xbgr.mr_n71573648)
print v(xbgr.mr_n71573968)
print v(xbgr.mr_n71574080)
print v(xbgr.mr_n71574400)
print v(xbgr.mr_n71574512)
print v(xbgr.mr_n71574832)
print v(xbgr.mr_n71574944)
print v(xbgr.mr_n71575264)
print v(xbgr.mr_n71575376)
print v(xbgr.mr_n71575696)
print v(xbgr.mr_n71575808)
print v(xbgr.mr_n71576128)
print v(xbgr.mr_n71576240)
print v(xbgr.mr_n71576560)
print v(xbgr.mr_n71576672)
print v(xbgr.mr_n71576992)
print v(xbgr.mr_n71577104)
print v(xbgr.mr_n71577424)
print v(xbgr.mr_n71577536)
print v(xbgr.mr_n71577856)
print v(xbgr.mr_n71577968)
print v(xbgr.mr_n71578288)
print v(xbgr.mr_n71578400)
print v(xbgr.mr_n71578720)
print v(xbgr.mr_n71578832)
print v(xbgr.mr_n71579152)
print v(xbgr.mr_n71579264)
print v(xbgr.mr_n71579584)
print v(xbgr.mr_n71579696)
print v(xbgr.mr_n71580016)
print v(xbgr.mr_n71580128)
print v(xbgr.mr_n71580448)
print v(xbgr.mr_n71580560)
print v(xbgr.mr_n71580880)
print v(xbgr.mr_n71580992)
print v(xbgr.mr_n71581312)
print v(xbgr.mr_n71581424)
print v(xbgr.mr_n71581744)
print v(xbgr.mr_n71581856)
print v(xbgr.mr_n71582176)
print v(xbgr.mr_n71582288)
print v(xbgr.mr_n71582608)
print v(xbgr.mr_n71582720)
print v(xbgr.mr_n71583040)
print v(xbgr.mr_n71583152)
print v(xbgr.mr_n71583472)
print v(xbgr.mr_n71583584)
print v(xbgr.mr_n71583904)
print v(xbgr.mr_n71584016)
print v(xbgr.mr_n71584336)
print v(xbgr.mr_n71584448)
print v(xbgr.mr_n71584768)
print v(xbgr.mr_n71584880)
print v(xbgr.mr_n71585200)
print v(xbgr.mr_n71585312)
print v(xbgr.mr_n71585632)
print v(xbgr.mr_n71585744)
print v(xbgr.mr_n71586064)
print v(xbgr.mr_n71586176)
print v(xbgr.mr_n71586496)
print v(xbgr.mr_n71586608)
print v(xbgr.mr_n71586928)
print v(xbgr.mr_n71587040)
print v(xbgr.mr_n71587360)
print v(xbgr.mr_n71587472)
print v(xbgr.mr_n71587792)
print v(xbgr.mr_n71587904)
print v(xbgr.mr_n71588224)
print v(xbgr.mr_n71588336)
print v(xbgr.mr_n71588656)
print v(xbgr.mr_n71588768)
print v(xbgr.mr_n71589088)
print v(xbgr.mr_n71589200)
print v(xbgr.mr_n71589520)
print v(xbgr.mr_n71589632)
print v(xbgr.mr_n71589952)
print v(xbgr.mr_n71590064)
print v(xbgr.mr_n71590384)
print v(xbgr.mr_n71590496)
print v(xbgr.mr_n71590816)
print v(xbgr.mr_n71590928)
print v(xbgr.mr_n71591248)
print v(xbgr.mr_n71591360)
print v(xbgr.mr_n71591680)
print v(xbgr.mr_n71591792)
print v(xbgr.mr_n71592112)
print v(xbgr.mr_n71592224)
print v(xbgr.mr_n71592544)
print v(xbgr.mr_n71592656)
print v(xbgr.mr_n71592976)
print v(xbgr.mr_n71593088)
print v(xbgr.mr_n71593408)
print v(xbgr.mr_n71593520)
print v(xbgr.mr_n71593840)
print v(xbgr.mr_n71593952)
print v(xbgr.mr_n71594272)
print v(xbgr.mr_n71594384)
print v(xbgr.mr_n71594704)
print v(xbgr.mr_n71594816)
print v(xbgr.mr_n71595136)
print v(xbgr.mr_n71595248)
print v(xbgr.mr_n71595568)
print v(xbgr.mr_n71595680)
print v(xbgr.mr_n71596000)
print v(xbgr.mr_n71596112)
print v(xbgr.mr_n71596432)
print v(xbgr.mr_n71596544)
print v(xbgr.mr_n71596864)
print v(xbgr.mr_n71596976)
print v(xbgr.mr_n71597296)
print v(xbgr.mr_n71597408)
print v(xbgr.mr_n71597728)
print v(xbgr.mr_n71597840)
print v(xbgr.mr_n71598160)
print v(xbgr.mr_n71598272)
print v(xbgr.mr_n71598592)
print v(xbgr.mr_n71598704)
print v(xbgr.mr_n71599024)
print v(xbgr.mr_n71599136)
print v(xbgr.mr_n71599456)
print v(xbgr.mr_n71599568)
print v(xbgr.mr_n71599888)
print v(xbgr.mr_n71600000)
print v(xbgr.mr_n71600320)
print v(xbgr.mr_n71600432)
print v(xbgr.mr_n71600752)
print v(xbgr.mr_n71600864)
print v(xbgr.mr_n71601184)
print v(xbgr.mr_n71601296)
print v(xbgr.mr_n71601616)
print v(xbgr.mr_n71601728)
print v(xbgr.mr_n71602048)
print v(xbgr.mr_n71602160)
print v(xbgr.mr_n71602480)
print v(xbgr.mr_n71602592)
print v(xbgr.mr_n71602912)
print v(xbgr.mr_n71603024)
print v(xbgr.mr_n71603344)
print v(xbgr.mr_n71603456)
print v(xbgr.mr_n71603776)
print v(xbgr.mr_n71603888)
print v(xbgr.mr_n71604208)
print v(xbgr.mr_n71604320)
print v(xbgr.mr_n71604640)
print v(xbgr.mr_n71604752)
print v(xbgr.mr_n71605072)
print v(xbgr.mr_n71605184)
print v(xbgr.mr_n71605504)
print v(xbgr.mr_n71605616)
print v(xbgr.mr_n71605936)
print v(xbgr.mr_n71606048)
print v(xbgr.mr_n71606368)
print v(xbgr.mr_n71606480)
print v(xbgr.mr_n71606800)
print v(xbgr.mr_n71606912)
print v(xbgr.mr_n71607232)
print v(xbgr.mr_n71607344)
print v(xbgr.mr_n71607664)
print v(xbgr.mr_n71607776)
print v(xbgr.mr_n71608096)
print v(xbgr.mr_n71608208)
print v(xbgr.mr_n71608528)
print v(xbgr.mr_n71608640)
print v(xbgr.mr_n71608960)
print v(xbgr.mr_n71609072)
print v(xbgr.mr_n71609392)
print v(xbgr.mr_n71609504)
print v(xbgr.mr_n71609824)
print v(xbgr.mr_n71609936)
print v(xbgr.mr_n71610256)
print v(xbgr.mr_n71610368)
print v(xbgr.mr_n71610688)
print v(xbgr.mr_n71610800)
print v(xbgr.mr_n71611120)
print v(xbgr.mr_n71611232)
print v(xbgr.mr_n71611552)
print v(xbgr.mr_n71611664)
print v(xbgr.mr_n71611984)
print v(xbgr.mr_n71612096)
print v(xbgr.mr_n71612416)
print v(xbgr.mr_n71612528)
print v(xbgr.mr_n71612848)
print v(xbgr.mr_n71612960)
print v(xbgr.mr_n71613280)
print v(xbgr.mr_n71613392)
print v(xbgr.mr_n71613712)
print v(xbgr.mr_n71613824)
print v(xbgr.mr_n71614144)
print v(xbgr.mr_n71614256)
print v(xbgr.mr_n71614576)
print v(xbgr.mr_n71614688)
print v(xbgr.mr_n71615008)
print v(xbgr.mr_n71615120)
print v(xbgr.mr_n71615440)
print v(xbgr.mr_n71615552)
print v(xbgr.mr_n71615872)
print v(xbgr.mr_n71615984)
print v(xbgr.mr_n71616304)
print v(xbgr.mr_n71616416)
print v(xbgr.mr_n71616736)
print v(xbgr.mr_n71616848)
print v(xbgr.mr_n71617168)
print v(xbgr.mr_n71617280)
print v(xbgr.mr_n71617600)
print v(xbgr.mr_n71617712)
print v(xbgr.mr_n71618032)
print v(xbgr.mr_n71618144)
print v(xbgr.mr_n71618464)
print v(xbgr.mr_n71618576)
print v(xbgr.mr_n71618896)
print v(xbgr.mr_n71619008)
print v(xbgr.mr_n71619328)
print v(xbgr.mr_n71619440)
print v(xbgr.mr_n71619760)
print v(xbgr.mr_n71619872)
print v(xbgr.mr_n71620192)
print v(xbgr.mr_n71620304)
print v(xbgr.mr_n71620624)
print v(xbgr.mr_n71620736)
print v(xbgr.mr_n71621056)
print v(xbgr.mr_n71621168)
print v(xbgr.mr_n71621456)
print v(xbgr.mr_n71621568)
print v(xbgr.mr_n71621888)
print v(xbgr.mr_n71622000)
print v(xbgr.mr_n71622320)
print v(xbgr.mr_n71622432)
print v(xbgr.mr_n71622752)
print v(xbgr.mr_n71622864)
print v(xbgr.mr_n71623184)
print v(xbgr.mr_n71623296)
print v(xbgr.mr_n71623616)
print v(xbgr.mr_n71623728)
print v(xbgr.mr_n71624048)
print v(xbgr.mr_n71624160)
print v(xbgr.mr_n71624480)
print v(xbgr.mr_n71624592)
print v(xbgr.mr_n71624912)
print v(xbgr.mr_n71625024)
print v(xbgr.mr_n71625344)
print v(xbgr.mr_n71625456)
print v(xbgr.mr_n71625776)
print v(xbgr.mr_n71625888)
print v(xbgr.mr_n71626208)
print v(xbgr.mr_n71626320)
print v(xbgr.mr_n71626640)
print v(xbgr.mr_n71626752)
print v(xbgr.mr_n71627072)
print v(xbgr.mr_n71627184)
print v(xbgr.mr_n71627504)
print v(xbgr.mr_n71627616)
print v(xbgr.mr_n71627936)
print v(xbgr.mr_n71628048)
print v(xbgr.mr_n71628368)
print v(xbgr.mr_n71628480)
print v(xbgr.mr_n71628800)
print v(xbgr.mr_n71628912)
print v(xbgr.mr_n71629232)
print v(xbgr.mr_n71629344)
print v(xbgr.mr_n71629664)
print v(xbgr.mr_n71629776)
print v(xbgr.mr_n71630096)
print v(xbgr.mr_n71630208)
print v(xbgr.mr_n71630528)
print v(xbgr.mr_n71630640)
print v(xbgr.mr_n71630960)
print v(xbgr.mr_n71631072)
print v(xbgr.mr_n71631392)
print v(xbgr.mr_n71631504)
print v(xbgr.mr_n71631824)
print v(xbgr.mr_n71631936)
print v(xbgr.mr_n71632256)
print v(xbgr.mr_n71632368)
print v(xbgr.mr_n71632688)
print v(xbgr.mr_n71632800)
print v(xbgr.mr_n71633120)
print v(xbgr.mr_n71633232)
print v(xbgr.mr_n71633552)
print v(xbgr.mr_n71633664)
print v(xbgr.mr_n71633984)
print v(xbgr.mr_n71634096)
print v(xbgr.mr_n71634416)
print v(xbgr.mr_n71634528)
print v(xbgr.mr_n71634848)
print v(xbgr.mr_n71634960)
print v(xbgr.mr_n71635280)
print v(xbgr.mr_n71635392)
print v(xbgr.mr_n71635712)
print v(xbgr.mr_n71635824)
print v(xbgr.mr_n71636144)
print v(xbgr.mr_n71636256)
print v(xbgr.mr_n71636576)
print v(xbgr.mr_n71636688)
print v(xbgr.mr_n71637008)
print v(xbgr.mr_n71637120)
print v(xbgr.mr_n71637440)
print v(xbgr.mr_n71637552)
print v(xbgr.mr_n71637872)
print v(xbgr.mr_n71637984)
print v(xbgr.mr_n71638304)
print v(xbgr.mr_n71638416)
print v(xbgr.mr_n71638736)
print v(xbgr.mr_n71638848)
print v(xbgr.mr_n71639168)
print v(xbgr.mr_n71639280)
print v(xbgr.mr_n71639600)
print v(xbgr.mr_n71639712)
print v(xbgr.mr_n71640032)
print v(xbgr.mr_n71640144)
print v(xbgr.mr_n71640464)
print v(xbgr.mr_n71640576)
print v(xbgr.mr_n71640896)
print v(xbgr.mr_n71641008)
print v(xbgr.mr_n71641328)
print v(xbgr.mr_n71641440)
print v(xbgr.mr_n71641760)
print v(xbgr.mr_n71641872)
print v(xbgr.mr_n71642192)
print v(xbgr.mr_n71642304)
print v(xbgr.mr_n71642624)
print v(xbgr.mr_n71642736)
print v(xbgr.mr_n71643056)
print v(xbgr.mr_n71643168)
print v(xbgr.mr_n71643488)
print v(xbgr.mr_n71643600)
print v(xbgr.mr_n71643920)
print v(xbgr.mr_n71644032)
print v(xbgr.mr_n71644352)
print v(xbgr.mr_n71644464)
print v(xbgr.mr_n71644784)
print v(xbgr.mr_n71644896)
print v(xbgr.mr_n71645216)
print v(xbgr.mr_n71645328)
print v(xbgr.mr_n71645648)
print v(xbgr.mr_n71645760)
print v(xbgr.mr_n71646080)
print v(xbgr.mr_n71646192)
print v(xbgr.mr_n71646512)
print v(xbgr.mr_n71646624)
print v(xbgr.mr_n71646944)
print v(xbgr.mr_n71647056)
print v(xbgr.mr_n71647376)
print v(xbgr.mr_n71647488)
print v(xbgr.mr_n71647808)
print v(xbgr.mr_n71647920)
print v(xbgr.mr_n71648240)
print v(xbgr.mr_n71648352)
print v(xbgr.mr_n71648672)
print v(xbgr.mr_n71648784)
print v(xbgr.mr_n71649104)
print v(xbgr.mr_n71649216)
print v(xbgr.mr_n71649536)
print v(xbgr.mr_n71649648)
print v(xbgr.mr_n71649968)
print v(xbgr.mr_n71650080)
print v(xbgr.mr_n71650400)
print v(xbgr.mr_n71650512)
print v(xbgr.mr_n71650832)
print v(xbgr.mr_n71650944)
print v(xbgr.mr_n71651264)
print v(xbgr.mr_n71651376)
print v(xbgr.mr_n71651696)
print v(xbgr.mr_n71651808)
print v(xbgr.mr_n71652128)
print v(xbgr.mr_n71652240)
print v(xbgr.mr_n71652560)
print v(xbgr.mr_n71652672)
print v(xbgr.mr_n71652992)
print v(xbgr.mr_n71653104)
print v(xbgr.mr_n71653424)
print v(xbgr.mr_n71653536)
print v(xbgr.mr_n71653856)
print v(xbgr.mr_n71653968)
print v(xbgr.mr_n71654288)
print v(xbgr.mr_n71654400)
print v(xbgr.mr_n71654720)
print v(xbgr.mr_n71654832)
print v(xbgr.mr_n71655152)
print v(xbgr.mr_n71655264)
print v(xbgr.mr_n71655584)
print v(xbgr.mr_n71655696)
print v(xbgr.mr_n71656016)
print v(xbgr.mr_n71656128)
print v(xbgr.mr_n71656448)
print v(xbgr.mr_n71656560)
print v(xbgr.mr_n71656880)
print v(xbgr.mr_n71656992)
print v(xbgr.mr_n71657312)
print v(xbgr.mr_n71657424)
print v(xbgr.mr_n71657744)
print v(xbgr.mr_n71657856)
print v(xbgr.mr_n71658176)
print v(xbgr.mr_n71658288)
print v(xbgr.mr_n71658608)
print v(xbgr.mr_n71658720)
print v(xbgr.mr_n71659040)
print v(xbgr.mr_n71659152)
print v(xbgr.mr_n71659472)
print v(xbgr.mr_n71659584)
print v(xbgr.mr_n71659904)
print v(xbgr.mr_n71660016)
print v(xbgr.mr_n71660336)
print v(xbgr.mr_n71660448)
print v(xbgr.mr_n71660768)
print v(xbgr.mr_n71660880)
print v(xbgr.mr_n71661200)
print v(xbgr.mr_n71661312)
print v(xbgr.mr_n71661632)
print v(xbgr.mr_n71661744)
print v(xbgr.mr_n71662064)
print v(xbgr.mr_n71662176)
print v(xbgr.mr_n71662496)
print v(xbgr.mr_n71662608)
print v(xbgr.mr_n71662928)
print v(xbgr.mr_n71663040)
print v(xbgr.mr_n71663360)
print v(xbgr.mr_n71663472)
print v(xbgr.mr_n71663792)
print v(xbgr.mr_n71663904)
print v(xbgr.mr_n71664224)
print v(xbgr.mr_n71664336)
print v(xbgr.mr_n71664656)
print v(xbgr.mr_n71664768)
print v(xbgr.mr_n71665088)
print v(xbgr.mr_n71665200)
print v(xbgr.mr_n71665520)
print v(xbgr.mr_n71665632)
print v(xbgr.mr_n71665952)
print v(xbgr.mr_n71666064)
print v(xbgr.mr_n71666384)
print v(xbgr.mr_n71666496)
print v(xbgr.mr_n71666816)
print v(xbgr.mr_n71666928)
print v(xbgr.mr_n71667248)
print v(xbgr.mr_n71667360)
print v(xbgr.mr_n71667680)
print v(xbgr.mr_n71667792)
print v(xbgr.mr_n71668112)
print v(xbgr.mr_n71668224)
print v(xbgr.mr_n71668544)
print v(xbgr.mr_n71668656)
print v(xbgr.mr_n71668976)
print v(xbgr.mr_n71669088)
print v(xbgr.mr_n71669408)
print v(xbgr.mr_n71669520)
print v(xbgr.mr_n71669840)
print v(xbgr.mr_n71669952)
print v(xbgr.mr_n71670272)
print v(xbgr.mr_n71670384)
print v(xbgr.mr_n71670704)
print v(xbgr.mr_n71670816)
print v(xbgr.mr_n71671136)
print v(xbgr.mr_n71671248)
print v(xbgr.mr_n71671568)
print v(xbgr.mr_n71671680)
print v(xbgr.mr_n71672000)
print v(xbgr.mr_n71672112)
print v(xbgr.mr_n71672432)
print v(xbgr.mr_n71672544)
print v(xbgr.mr_n71672864)
print v(xbgr.mr_n71672976)
print v(xbgr.mr_n71673296)
print v(xbgr.mr_n71673408)
print v(xbgr.mr_n71673728)
print v(xbgr.mr_n71673840)
print v(xbgr.mr_n71674160)
print v(xbgr.mr_n71674272)
print v(xbgr.mr_n71674592)
print v(xbgr.mr_n71674704)
print v(xbgr.mr_n71675024)
print v(xbgr.mr_n71675136)
print v(xbgr.mr_n71675456)
print v(xbgr.mr_n71675568)
print v(xbgr.mr_n71675888)
print v(xbgr.mr_n71676000)
print v(xbgr.mr_n71676320)
print v(xbgr.mr_n71676432)
print v(xbgr.mr_n71676752)
print v(xbgr.mr_n71676864)
print v(xbgr.mr_n71677184)
print v(xbgr.mr_n71677296)
print v(xbgr.mr_n71677616)
print v(xbgr.mr_n71677728)
print v(xbgr.mr_n71678048)
print v(xbgr.mr_n71678160)
print v(xbgr.mr_n71678480)
print v(xbgr.mr_n71678592)
print v(xbgr.mr_n71678912)
print v(xbgr.mr_n71679024)
print v(xbgr.mr_n71679344)
print v(xbgr.mr_n71679456)
print v(xbgr.mr_n71679776)
print v(xbgr.mr_n71679888)
print v(xbgr.mr_n71680208)
print v(xbgr.mr_n71680320)
print v(xbgr.mr_n71680640)
print v(xbgr.mr_n71680752)
print v(xbgr.mr_n71681072)
print v(xbgr.mr_n71681184)
print v(xbgr.mr_n71681504)
print v(xbgr.mr_n71681616)
print v(xbgr.mr_n71681936)
print v(xbgr.mr_n71682048)
print v(xbgr.mr_n71682368)
print v(xbgr.mr_n71682480)
print v(xbgr.mr_n71682800)
print v(xbgr.mr_n71682912)
print v(xbgr.mr_n71683232)
print v(xbgr.mr_n71683344)
print v(xbgr.mr_n71683664)
print v(xbgr.mr_n71683776)
print v(xbgr.mr_n71684096)
print v(xbgr.mr_n71684208)
print v(xbgr.mr_n71684528)
print v(xbgr.mr_n71684640)
print v(xbgr.mr_n71684960)
print v(xbgr.mr_n71685072)
print v(xbgr.mr_n71685392)
print v(xbgr.mr_n71685504)
print v(xbgr.mr_n71685824)
print v(xbgr.mr_n71685936)
print v(xbgr.mr_n71686256)
print v(xbgr.mr_n71686368)
print v(xbgr.mr_n71686688)
print v(xbgr.mr_n71686800)
print v(xbgr.mr_n71687120)
print v(xbgr.mr_n71687232)
print v(xbgr.mr_n71687552)
print v(xbgr.mr_n71687664)
print v(xbgr.mr_n71687984)
print v(xbgr.mr_n71688096)
print v(xbgr.mr_n71688416)
print v(xbgr.mr_n71688528)
print v(xbgr.mr_n71688848)
print v(xbgr.mr_n71688960)
print v(xbgr.mr_n71689280)
print v(xbgr.mr_n71689392)
print v(xbgr.mr_n71689712)
print v(xbgr.mr_n71689824)
print v(xbgr.mr_n71690144)
print v(xbgr.mr_n71690256)
print v(xbgr.mr_n71690576)
print v(xbgr.mr_n71690688)
print v(xbgr.mr_n71691008)
print v(xbgr.mr_n71691120)
print v(xbgr.mr_n71691440)
print v(xbgr.mr_n71691552)
print v(xbgr.mr_n71691872)
print v(xbgr.mr_n71691984)
print v(xbgr.mr_n71692304)
print v(xbgr.mr_n71692416)
print v(xbgr.mr_n71692736)
print v(xbgr.mr_n71692848)
print v(xbgr.mr_n71693168)
print v(xbgr.mr_n71693280)
print v(xbgr.mr_n71693600)
print v(xbgr.mr_n71693712)
print v(xbgr.mr_n71694032)
print v(xbgr.mr_n71694144)
print v(xbgr.mr_n71694464)
print v(xbgr.mr_n71694576)
print v(xbgr.mr_n71694896)
print v(xbgr.mr_n71695008)
print v(xbgr.mr_n71695328)
print v(xbgr.mr_n71695440)
print v(xbgr.mr_n71695760)
print v(xbgr.mr_n71695872)
print v(xbgr.mr_n71696192)
print v(xbgr.mr_n71696304)
print v(xbgr.mr_n71696624)
print v(xbgr.mr_n71696736)
print v(xbgr.mr_n71697056)
print v(xbgr.mr_n71697168)
print v(xbgr.mr_n71697488)
print v(xbgr.mr_n71697600)
print v(xbgr.mr_n71697920)
print v(xbgr.mr_n71698032)
print v(xbgr.mr_n71698352)
print v(xbgr.mr_n71698464)
print v(xbgr.mr_n71698784)
print v(xbgr.mr_n71698896)
print v(xbgr.mr_n71699216)
print v(xbgr.mr_n71699328)
print v(xbgr.mr_n71699648)
print v(xbgr.mr_n71699760)
print v(xbgr.mr_n71700080)
print v(xbgr.mr_n71700192)
print v(xbgr.mr_n71700512)
print v(xbgr.mr_n71700624)
print v(xbgr.mr_n71700944)
print v(xbgr.mr_n71701056)
print v(xbgr.mr_n71701376)
print v(xbgr.mr_n71701488)
print v(xbgr.mr_n71701808)
print v(xbgr.mr_n71701920)
print v(xbgr.mr_n71702240)
print v(xbgr.mr_n71702352)
print v(xbgr.mr_n71702672)
print v(xbgr.mr_n71702784)
print v(xbgr.mr_n71703104)
print v(xbgr.mr_n71703216)
print v(xbgr.mr_n71703536)
print v(xbgr.mr_n71703648)
print v(xbgr.mr_n71703968)
print v(xbgr.mr_n71704080)
print v(xbgr.mr_n71704400)
print v(xbgr.mr_n71704512)
print v(xbgr.mr_n71704832)
print v(xbgr.mr_n71704944)
print v(xbgr.mr_n71705264)
print v(xbgr.mr_n71705376)
print v(xbgr.mr_n71705696)
print v(xbgr.mr_n71705808)
print v(xbgr.mr_n71706128)
print v(xbgr.mr_n71706240)
print v(xbgr.mr_n71706560)
print v(xbgr.mr_n71706672)
print v(xbgr.mr_n71706992)
print v(xbgr.mr_n71707104)
print v(xbgr.mr_n71707424)
print v(xbgr.mr_n71707536)
print v(xbgr.mr_n71707856)
print v(xbgr.mr_n71707968)
print v(xbgr.mr_n71708288)
print v(xbgr.mr_n71708400)
print v(xbgr.mr_n71708720)
print v(xbgr.mr_n71708832)
print v(xbgr.mr_n71709152)
print v(xbgr.mr_n71709264)
print v(xbgr.mr_n71709584)
print v(xbgr.mr_n71709696)
print v(xbgr.mr_n71710016)
print v(xbgr.mr_n71710128)
print v(xbgr.mr_n71710448)
print v(xbgr.mr_n71710560)
print v(xbgr.mr_n71710880)
print v(xbgr.mr_n71710992)
print v(xbgr.mr_n71711312)
print v(xbgr.mr_n71711424)
print v(xbgr.mr_n71711744)
print v(xbgr.mr_n71711856)
print v(xbgr.mr_n71712176)
print v(xbgr.mr_n71712288)
print v(xbgr.mr_n71712608)
print v(xbgr.mr_n71712720)
print v(xbgr.mr_n71713040)
print v(xbgr.mr_n71713152)
print v(xbgr.mr_n71713472)
print v(xbgr.mr_n71713584)
print v(xbgr.mr_n71713904)
print v(xbgr.mr_n71714016)
print v(xbgr.mr_n71714336)
print v(xbgr.mr_n71714448)
print v(xbgr.mr_n71714768)
print v(xbgr.mr_n71714880)
print v(xbgr.mr_n71715200)
print v(xbgr.mr_n71715312)
print v(xbgr.mr_n71715632)
print v(xbgr.mr_n71715744)
print v(xbgr.mr_n71716064)
print v(xbgr.mr_n71716176)
print v(xbgr.mr_n71716496)
print v(xbgr.mr_n71716608)
print v(xbgr.mr_n71716928)
print v(xbgr.mr_n71717040)
print v(xbgr.mr_n71717360)
print v(xbgr.mr_n71717472)
print v(xbgr.mr_n71717792)
print v(xbgr.mr_n71717904)
print v(xbgr.mr_n71718224)
print v(xbgr.mr_n71718336)
print v(xbgr.mr_n71718656)
print v(xbgr.mr_n71718768)
print v(xbgr.mr_n71719088)
print v(xbgr.mr_n71719200)
print v(xbgr.mr_n71719520)
print v(xbgr.mr_n71719632)
print v(xbgr.mr_n71719952)
print v(xbgr.mr_n71720064)
print v(xbgr.mr_n71720384)
print v(xbgr.mr_n71720496)
print v(xbgr.mr_n71720816)
print v(xbgr.mr_n71720928)
print v(xbgr.mr_n71721248)
print v(xbgr.mr_n71721360)
print v(xbgr.mr_n71721680)
print v(xbgr.mr_n71721792)
print v(xbgr.mr_n71722112)
print v(xbgr.mr_n71722224)
print v(xbgr.mr_n71722544)
print v(xbgr.mr_n71722656)
print v(xbgr.mr_n71722976)
print v(xbgr.mr_n71723088)
print v(xbgr.mr_n71723408)
print v(xbgr.mr_n71723520)
print v(xbgr.mr_n71723840)
print v(xbgr.mr_n71723952)
print v(xbgr.mr_n71724272)
print v(xbgr.mr_n71724384)
print v(xbgr.mr_n71724704)
print v(xbgr.mr_n71724816)
print v(xbgr.mr_n71725136)
print v(xbgr.mr_n71725248)
print v(xbgr.mr_n71725568)
print v(xbgr.mr_n71725680)
print v(xbgr.mr_n71726000)
print v(xbgr.mr_n71726112)
print v(xbgr.mr_n71726432)
print v(xbgr.mr_n71726544)
print v(xbgr.mr_n71726864)
print v(xbgr.mr_n71726976)
print v(xbgr.mr_n71727296)
print v(xbgr.mr_n71727408)
print v(xbgr.mr_n71727728)
print v(xbgr.mr_n71727840)
print v(xbgr.mr_n71728160)
print v(xbgr.mr_n71728272)
print v(xbgr.mr_n71728592)
print v(xbgr.mr_n71728704)
print v(xbgr.mr_n71729024)
print v(xbgr.mr_n71729136)
print v(xbgr.mr_n71729456)
print v(xbgr.mr_n71729568)
print v(xbgr.mr_n71729888)
print v(xbgr.mr_n71730000)
print v(xbgr.mr_n71730320)
print v(xbgr.mr_n71730432)
print v(xbgr.mr_n71730752)
print v(xbgr.mr_n71730864)
print v(xbgr.mr_n71731184)
print v(xbgr.mr_n71731296)
print v(xbgr.mr_n71731616)
print v(xbgr.mr_n71731728)
print v(xbgr.mr_n71732048)
print v(xbgr.mr_n71732160)
print v(xbgr.mr_n71732480)
print v(xbgr.mr_n71732592)
print v(xbgr.mr_n71732912)
print v(xbgr.mr_n71733024)
print v(xbgr.mr_n71733344)
print v(xbgr.mr_n71733456)
print v(xbgr.mr_n71733776)
print v(xbgr.mr_n71733888)
print v(xbgr.mr_n71734208)
print v(xbgr.mr_n71734320)
print v(xbgr.mr_n71734640)
print v(xbgr.mr_n71734752)
print v(xbgr.mr_n71735072)
print v(xbgr.mr_n71735184)
print v(xbgr.mr_n71735504)
print v(xbgr.mr_n71735616)
print v(xbgr.mr_n71735936)
print v(xbgr.mr_n71736048)
print v(xbgr.mr_n71736368)
print v(xbgr.mr_n71736480)
print v(xbgr.mr_n71736800)
print v(xbgr.mr_n71736912)
print v(xbgr.mr_n71737232)
print v(xbgr.mr_n71737344)
print v(xbgr.mr_n71737664)
print v(xbgr.mr_n71737776)
print v(xbgr.mr_n71738096)
print v(xbgr.mr_n71738208)
print v(xbgr.mr_n71738528)
print v(xbgr.mr_n71738640)
print v(xbgr.mr_n71738960)
print v(xbgr.mr_n71739072)
print v(xbgr.mr_n71739392)
print v(xbgr.mr_n71739504)
print v(xbgr.mr_n71739824)
print v(xbgr.mr_n71739936)
print v(xbgr.mr_n71740256)
print v(xbgr.mr_n71740368)
print v(xbgr.mr_n71740688)
print v(xbgr.mr_n71740800)
print v(xbgr.mr_n71741120)
print v(xbgr.mr_n71741232)
print v(xbgr.mr_n71741552)
print v(xbgr.mr_n71741664)
print v(xbgr.mr_n71741984)
print v(xbgr.mr_n71742096)
print v(xbgr.mr_n71742416)
print v(xbgr.mr_n71742528)
print v(xbgr.mr_n71742848)
print v(xbgr.mr_n71742960)
print v(xbgr.mr_n71743280)
print v(xbgr.mr_n71743392)
print v(xbgr.mr_n71743712)
print v(xbgr.mr_n71743824)
print v(xbgr.mr_n71744144)
print v(xbgr.mr_n71744256)
print v(xbgr.mr_n71744576)
print v(xbgr.mr_n71744688)
print v(xbgr.mr_n71745008)
print v(xbgr.mr_n71745120)
print v(xbgr.mr_n71745440)
print v(xbgr.mr_n71745552)
print v(xbgr.mr_n71745872)
print v(xbgr.mr_n71745984)
print v(xbgr.mr_n71746304)
print v(xbgr.mr_n71746416)
print v(xbgr.mr_n71746736)
print v(xbgr.mr_n71746848)
print v(xbgr.mr_n71747168)
print v(xbgr.mr_n71747280)
print v(xbgr.mr_n71747600)
print v(xbgr.mr_n71747712)
print v(xbgr.mr_n71748032)
print v(xbgr.mr_n71748144)
print v(xbgr.mr_n71748464)
print v(xbgr.mr_n71748576)
print v(xbgr.mr_n71748896)
print v(xbgr.mr_n71749008)
print v(xbgr.mr_n71749328)
print v(xbgr.mr_n71749440)
print v(xbgr.mr_n71749760)
print v(xbgr.mr_n71749872)
print v(xbgr.mr_n71750192)
print v(xbgr.mr_n71750304)
print v(xbgr.mr_n71750624)
print v(xbgr.mr_n71750736)
print v(xbgr.mr_n71751056)
print v(xbgr.mr_n71751168)
print v(xbgr.mr_n71751488)
print v(xbgr.mr_n71751600)
print v(xbgr.mr_n71751920)
print v(xbgr.mr_n71752032)
print v(xbgr.mr_n71752352)
print v(xbgr.mr_n71752464)
print v(xbgr.mr_n71752784)
print v(xbgr.mr_n71752896)
print v(xbgr.mr_n71753216)
print v(xbgr.mr_n71753328)
print v(xbgr.mr_n71753648)
print v(xbgr.mr_n71753760)
print v(xbgr.mr_n71754080)
print v(xbgr.mr_n71754192)
print v(xbgr.mr_n71754512)
print v(xbgr.mr_n71754624)
print v(xbgr.mr_n71754944)
print v(xbgr.mr_n71755056)
print v(xbgr.mr_n71755376)
print v(xbgr.mr_n71755488)
print v(xbgr.mr_n71755808)
print v(xbgr.mr_n71755920)
print v(xbgr.mr_n71756240)
print v(xbgr.mr_n71756352)
print v(xbgr.mr_n71756672)
print v(xbgr.mr_n71756784)
print v(xbgr.mr_n71757104)
print v(xbgr.mr_n71757216)
print v(xbgr.mr_n71757536)
print v(xbgr.mr_n71757648)
print v(xbgr.mr_n71757968)
print v(xbgr.mr_n71758080)
print v(xbgr.mr_n71758400)
print v(xbgr.mr_n71758512)
print v(xbgr.mr_n71758832)
print v(xbgr.mr_n71758944)
print v(xbgr.mr_n71759264)
print v(xbgr.mr_n71759376)
print v(xbgr.mr_n71759696)
print v(xbgr.mr_n71759808)
print v(xbgr.mr_n71760128)
print v(xbgr.mr_n71760240)
print v(xbgr.mr_n71760560)
print v(xbgr.mr_n71760672)
print v(xbgr.mr_n71760992)
print v(xbgr.mr_n71761104)
print v(xbgr.mr_n71761424)
print v(xbgr.mr_n71761536)
print v(xbgr.mr_n71761856)
print v(xbgr.mr_n71761968)
print v(xbgr.mr_n71762288)
print v(xbgr.mr_n71762400)
print v(xbgr.mr_n71762720)
print v(xbgr.mr_n71762832)
print v(xbgr.mr_n71763152)
print v(xbgr.mr_n71763264)
print v(xbgr.mr_n71763584)
print v(xbgr.mr_n71763696)
print v(xbgr.mr_n71764016)
print v(xbgr.mr_n71764128)
print v(xbgr.mr_n71764448)
print v(xbgr.mr_n71764560)
print v(xbgr.mr_n71764880)
print v(xbgr.mr_n71764992)
print v(xbgr.mr_n71765312)
print v(xbgr.mr_n71765424)
print v(xbgr.mr_n71765744)
print v(xbgr.mr_n71765856)
print v(xbgr.mr_n71766176)
print v(xbgr.mr_n71766288)
print v(xbgr.mr_n71766608)
print v(xbgr.mr_n71766720)
print v(xbgr.mr_n71767040)
print v(xbgr.mr_n71767152)
print v(xbgr.mr_n71767472)
print v(xbgr.mr_n71767584)
print v(xbgr.mr_n71767904)
print v(xbgr.mr_n71768016)
print v(xbgr.mr_n71768336)
print v(xbgr.mr_n71768448)
print v(xbgr.mr_n71768768)
print v(xbgr.mr_n71768880)
print v(xbgr.mr_n71769200)
print v(xbgr.mr_n71769312)
print v(xbgr.mr_n71769632)
print v(xbgr.mr_n71769744)
print v(xbgr.mr_n71770064)
print v(xbgr.mr_n71770176)
print v(xbgr.mr_n71770496)
print v(xbgr.mr_n71770608)
print v(xbgr.mr_n71770928)
print v(xbgr.mr_n71771040)
print v(xbgr.mr_n71771360)
print v(xbgr.mr_n71771472)
print v(xbgr.mr_n71771792)
print v(xbgr.mr_n71771904)
print v(xbgr.mr_n71772224)
print v(xbgr.mr_n71772336)
print v(xbgr.mr_n71772656)
print v(xbgr.mr_n71772768)
print v(xbgr.mr_n71773088)
print v(xbgr.mr_n71773200)
print v(xbgr.mr_n71773520)
print v(xbgr.mr_n71773632)
print v(xbgr.mr_n71773952)
print v(xbgr.mr_n71774064)
print v(xbgr.mr_n71774384)
print v(xbgr.mr_n71774496)
print v(xbgr.mr_n71774816)
print v(xbgr.mr_n71774928)
print v(xbgr.mr_n71775248)
print v(xbgr.mr_n71775360)
print v(xbgr.mr_n71775680)
print v(xbgr.mr_n71775792)
print v(xbgr.mr_n71776112)
print v(xbgr.mr_n71776224)
print v(xbgr.mr_n71776544)
print v(xbgr.mr_n71776656)
print v(xbgr.mr_n71776976)
print v(xbgr.mr_n71777088)
print v(xbgr.mr_n71777408)
print v(xbgr.mr_n71777520)
print v(xbgr.mr_n71777840)
print v(xbgr.mr_n71777952)
print v(xbgr.mr_n71778272)
print v(xbgr.mr_n71778384)
print v(xbgr.mr_n71778704)
print v(xbgr.mr_n71778816)
print v(xbgr.mr_n71779136)
print v(xbgr.mr_n71779248)
print v(xbgr.mr_n71779568)
print v(xbgr.mr_n71779680)
print v(xbgr.mr_n71780000)
print v(xbgr.mr_n71780112)
print v(xbgr.mr_n71780432)
print v(xbgr.mr_n71780544)
print v(xbgr.mr_n71780864)
print v(xbgr.mr_n71780976)
print v(xbgr.mr_n71781296)
print v(xbgr.mr_n71781408)
print v(xbgr.mr_n71781728)
print v(xbgr.mr_n71781840)
print v(xbgr.mr_n71782160)
print v(xbgr.mr_n71782272)
print v(xbgr.mr_n71782592)
print v(xbgr.mr_n71782704)
print v(xbgr.mr_n71783024)
print v(xbgr.mr_n71783136)
print v(xbgr.mr_n71783456)
print v(xbgr.mr_n71783568)
print v(xbgr.mr_n71783888)
print v(xbgr.mr_n71784000)
print v(xbgr.mr_n71784320)
print v(xbgr.mr_n71784432)
print v(xbgr.mr_n71784752)
print v(xbgr.mr_n71784864)
print v(xbgr.mr_n71785184)
print v(xbgr.mr_n71785296)
print v(xbgr.mr_n71785616)
print v(xbgr.mr_n71785728)
print v(xbgr.mr_n71786048)
print v(xbgr.mr_n71786160)
print v(xbgr.mr_n71786480)
print v(xbgr.mr_n71786592)
print v(xbgr.mr_n71786912)
print v(xbgr.mr_n71787024)
print v(xbgr.mr_n71787344)
print v(xbgr.mr_n71787456)
print v(xbgr.mr_n71787776)
print v(xbgr.mr_n71787888)
print v(xbgr.mr_n71788208)
print v(xbgr.mr_n71788320)
print v(xbgr.mr_n71788640)
print v(xbgr.mr_n71788752)
print v(xbgr.mr_n71789072)
print v(xbgr.mr_n71789184)
print v(xbgr.mr_n71789504)
print v(xbgr.mr_n71789616)
print v(xbgr.mr_n71789936)
print v(xbgr.mr_n71790048)
print v(xbgr.mr_n71790368)
print v(xbgr.mr_n71790480)
print v(xbgr.mr_n71790800)
print v(xbgr.mr_n71790912)
print v(xbgr.mr_n71791232)
print v(xbgr.mr_n71791344)
print v(xbgr.mr_n71791664)
print v(xbgr.mr_n71791776)
print v(xbgr.mr_n71792096)
print v(xbgr.mr_n71792208)
print v(xbgr.mr_n71792528)
print v(xbgr.mr_n71792640)
print v(xbgr.mr_n71792960)
print v(xbgr.mr_n71793072)
print v(xbgr.mr_n71793392)
print v(xbgr.mr_n71793504)
print v(xbgr.mr_n71793824)
print v(xbgr.mr_n71793936)
print v(xbgr.mr_n71794256)
print v(xbgr.mr_n71794368)
print v(xbgr.mr_n71794688)
print v(xbgr.mr_n71794800)
print v(xbgr.mr_n71795120)
print v(xbgr.mr_n71795232)
print v(xbgr.mr_n71795552)
print v(xbgr.mr_n71795664)
print v(xbgr.mr_n71795984)
print v(xbgr.mr_n71796096)
print v(xbgr.mr_n71796416)
print v(xbgr.mr_n71796528)
print v(xbgr.mr_n71796848)
print v(xbgr.mr_n71796960)
print v(xbgr.mr_n71797280)
print v(xbgr.mr_n71797392)
print v(xbgr.mr_n71797712)
print v(xbgr.mr_n71797824)
print v(xbgr.mr_n71798144)
print v(xbgr.mr_n71798256)
print v(xbgr.mr_n71798576)
print v(xbgr.mr_n71798688)
print v(xbgr.mr_n71799008)
print v(xbgr.mr_n71799120)
print v(xbgr.mr_n71799440)
print v(xbgr.mr_n71799552)
print v(xbgr.mr_n71799872)
print v(xbgr.mr_n71799984)
print v(xbgr.mr_n71800304)
print v(xbgr.mr_n71800416)
print v(xbgr.mr_n71800736)
print v(xbgr.mr_n71800848)
print v(xbgr.mr_n71801168)
print v(xbgr.mr_n71801280)
print v(xbgr.mr_n71801600)
print v(xbgr.mr_n71801712)
print v(xbgr.mr_n71802032)
print v(xbgr.mr_n71802144)
print v(xbgr.mr_n71802464)
print v(xbgr.mr_n71802576)
print v(xbgr.mr_n71802896)
print v(xbgr.mr_n71803008)
print v(xbgr.mr_n71803328)
print v(xbgr.mr_n71803440)
print v(xbgr.mr_n71803760)
print v(xbgr.mr_n71803872)
print v(xbgr.mr_n71804192)
print v(xbgr.mr_n71804304)
print v(xbgr.mr_n71804624)
print v(xbgr.mr_n71804736)
print v(xbgr.mr_n71805056)
print v(xbgr.mr_n71805168)
print v(xbgr.mr_n71805488)
print v(xbgr.mr_n71805600)
print v(xbgr.mr_n71805920)
print v(xbgr.mr_n71806032)
print v(xbgr.mr_n71806352)
print v(xbgr.mr_n71806464)
print v(xbgr.mr_n71806784)
print v(xbgr.mr_n71806896)
print v(xbgr.mr_n71807216)
print v(xbgr.mr_n71807328)
print v(xbgr.mr_n71807648)
print v(xbgr.mr_n71807760)
print v(xbgr.mr_n71808080)
print v(xbgr.mr_n71808192)
print v(xbgr.mr_n71808512)
print v(xbgr.mr_n71808624)
print v(xbgr.mr_n71808944)
print v(xbgr.mr_n71809056)
print v(xbgr.mr_n71809376)
print v(xbgr.mr_n71809488)
print v(xbgr.mr_n71809808)
print v(xbgr.mr_n71809920)
print v(xbgr.mr_n71810240)
print v(xbgr.mr_n71810352)
print v(xbgr.mr_n71810672)
print v(xbgr.mr_n71810784)
print v(xbgr.mr_n71811104)
print v(xbgr.mr_n71811216)
print v(xbgr.mr_n71811536)
print v(xbgr.mr_n71811648)
print v(xbgr.mr_n71811968)
print v(xbgr.mr_n71812080)
print v(xbgr.mr_n71812400)
print v(xbgr.mr_n71812512)
print v(xbgr.mr_n71812832)
print v(xbgr.mr_n71812944)
print v(xbgr.mr_n71813264)
print v(xbgr.mr_n71813376)
print v(xbgr.mr_n71813696)
print v(xbgr.mr_n71813808)
print v(xbgr.mr_n71814128)
print v(xbgr.mr_n71814240)
print v(xbgr.mr_n71814560)
print v(xbgr.mr_n71814672)
print v(xbgr.mr_n71814992)
print v(xbgr.mr_n71815104)
print v(xbgr.mr_n71815424)
print v(xbgr.mr_n71815536)
print v(xbgr.mr_n71815856)
print v(xbgr.mr_n71815968)
print v(xbgr.mr_n71816288)
print v(xbgr.mr_n71816400)
print v(xbgr.mr_n71816720)
print v(xbgr.mr_n71816832)
print v(xbgr.mr_n71817152)
print v(xbgr.mr_n71817264)
print v(xbgr.mr_n71817584)
print v(xbgr.mr_n71817696)
print v(xbgr.mr_n71818016)
print v(xbgr.mr_n71818128)
print v(xbgr.mr_n71818448)
print v(xbgr.mr_n71818560)
print v(xbgr.mr_n71818880)
print v(xbgr.mr_n71818992)
print v(xbgr.mr_n71819312)
print v(xbgr.mr_n71819424)
print v(xbgr.mr_n71819744)
print v(xbgr.mr_n71819856)
print v(xbgr.mr_n71820176)
print v(xbgr.mr_n71820288)
print v(xbgr.mr_n71820608)
print v(xbgr.mr_n71820720)
print v(xbgr.mr_n71821040)
print v(xbgr.mr_n71821152)
print v(xbgr.mr_n71821472)
print v(xbgr.mr_n71821584)
print v(xbgr.mr_n71821904)
print v(xbgr.mr_n71822016)
print v(xbgr.mr_n71822336)
print v(xbgr.mr_n71822448)
print v(xbgr.mr_n71822768)
print v(xbgr.mr_n71822880)
print v(xbgr.mr_n71823200)
print v(xbgr.mr_n71823312)
print v(xbgr.mr_n71823632)
print v(xbgr.mr_n71823744)
print v(xbgr.mr_n71824064)
print v(xbgr.mr_n71824176)
print v(xbgr.mr_n71824496)
print v(xbgr.mr_n71824608)
print v(xbgr.mr_n71824928)
print v(xbgr.mr_n71825040)
print v(xbgr.mr_n71825360)
print v(xbgr.mr_n71825472)
print v(xbgr.mr_n71825792)
print v(xbgr.mr_n71825904)
print v(xbgr.mr_n71826224)
print v(xbgr.mr_n71826336)
print v(xbgr.mr_n71826768)
print v(xbgr.mr_n71827088)
print v(xbgr.mr_n71827200)
print v(xbgr.mr_n71827632)
print v(xbgr.mr_n71827952)
print v(xbgr.mr_n71828064)
print v(xbgr.mr_n71828496)
print v(xbgr.mr_n71828816)
print v(xbgr.mr_n71829680)
print v(xbgr.mr_n71830544)
print v(xbgr.mr_n71831408)
print v(xbgr.mr_n71832272)
print v(xbgr.mr_n71833136)
print v(xbgr.mr_n71834000)
print v(xbgr.mr_n71834112)
print v(xbgr.mr_n71834432)
print v(xbgr.mr_n71834544)
print v(xbgr.mr_n71834864)
print v(xbgr.mr_n71834976)
print v(xbgr.mr_n71835296)
print v(xbgr.mr_n71835408)
print v(xbgr.mr_n71835728)
print v(xbgr.mr_n71836592)
print v(xbgr.mr_n71837456)
print v(xbgr.mr_n71838320)
print v(xbgr.mr_n71838432)
print v(xbgr.mr_n71838752)
print v(xbgr.mr_n71838864)
print v(xbgr.mr_n71839184)
print v(xbgr.mr_n71839296)
print v(xbgr.mr_n71839728)
print v(xbgr.mr_n71840160)
print v(xbgr.mr_n71840592)
print v(xbgr.mr_n71840912)
print v(xbgr.mr_n71841024)
print v(xbgr.mr_n71841344)
print v(xbgr.mr_n71841456)
print v(xbgr.mr_n71841776)
print v(xbgr.mr_n71841888)
print v(xbgr.mr_n71842208)
print v(xbgr.mr_n71842320)
print v(xbgr.mr_n71842640)
print v(xbgr.mr_n71842752)
print v(xbgr.mr_n71843072)
print v(xbgr.mr_n71843184)
print v(xbgr.mr_n71843504)
print v(xbgr.mr_n71843616)
print v(xbgr.mr_n71843936)
print v(xbgr.mr_n71844048)
print v(xbgr.mr_n71844368)
print v(xbgr.mr_n71844480)
print v(xbgr.mr_n71844800)
print v(xbgr.mr_n71844912)
print v(xbgr.mr_n71845232)
print v(xbgr.mr_n71845344)
print v(xbgr.mr_n71845664)
print v(xbgr.mr_n71845776)
print v(xbgr.mr_n71846096)
print v(xbgr.mr_n71846208)
print v(xbgr.mr_n71846528)
print v(xbgr.mr_n71846640)
print v(xbgr.mr_n71846960)
print v(xbgr.mr_n71847072)
print v(xbgr.mr_n71847392)
print v(xbgr.mr_n71847504)
print v(xbgr.mr_n71847824)
print v(xbgr.mr_n71847936)
print v(xbgr.mr_n71848256)
print v(xbgr.mr_n71848368)
print v(xbgr.mr_n71848688)
print v(xbgr.mr_n71848800)
print v(xbgr.mr_n71849120)
print v(xbgr.mr_n71849232)
print v(xbgr.mr_n71849552)
print v(xbgr.mr_n71849664)
print v(xbgr.mr_n71849984)
print v(xbgr.mr_n71850096)
print v(xbgr.mr_n71850416)
print v(xbgr.mr_n71850528)
print v(xbgr.mr_n71850848)
print v(xbgr.mr_n71850960)
print v(xbgr.mr_n71851280)
print v(xbgr.mr_n71851392)
print v(xbgr.mr_n71851712)
print v(xbgr.mr_n71851824)
print v(xbgr.mr_n71852144)
print v(xbgr.mr_n71852256)
print v(xbgr.mr_n71852576)
print v(xbgr.mr_n71852688)
print v(xbgr.mr_n71853008)
print v(xbgr.mr_n71853120)
print v(xbgr.mr_n71853440)
print v(xbgr.mr_n71853552)
print v(xbgr.mr_n71853872)
print v(xbgr.mr_n71853984)
print v(xbgr.mr_n71854416)
print v(xbgr.mr_n71854736)
print v(xbgr.mr_n71854848)
print v(xbgr.mr_n71855280)
print v(xbgr.mr_n71855600)
print v(xbgr.mr_n71856464)
print v(xbgr.mr_n71857328)
print v(xbgr.mr_n71858192)
print v(xbgr.mr_n71859056)
print v(xbgr.mr_n71859168)
print v(xbgr.mr_n71859488)
print v(xbgr.mr_n71859600)
print v(xbgr.mr_n71859920)
print v(xbgr.mr_n71860032)
print v(xbgr.mr_n71860352)
print v(xbgr.mr_n71860464)
print v(xbgr.mr_n71860784)
print v(xbgr.mr_n71861648)
print v(xbgr.mr_n71862512)
print v(xbgr.mr_n71862624)
print v(xbgr.mr_n71862944)
print v(xbgr.mr_n71863056)
print v(xbgr.mr_n71863376)
print v(xbgr.mr_n71863488)
print v(xbgr.mr_n71863808)
print v(xbgr.mr_n71863920)
print v(xbgr.mr_n71864240)
print v(xbgr.mr_n71864352)
print v(xbgr.mr_n71864784)
print v(xbgr.mr_n71865104)
print v(xbgr.mr_n71865216)
print v(xbgr.mr_n71865648)
print v(xbgr.mr_n71865968)
print v(xbgr.mr_n71866832)
print v(xbgr.mr_n71867696)
print v(xbgr.mr_n71868560)
print v(xbgr.mr_n71869424)
print v(xbgr.mr_n71869536)
print v(xbgr.mr_n71869856)
print v(xbgr.mr_n71869968)
print v(xbgr.mr_n71870288)
print v(xbgr.mr_n71870400)
print v(xbgr.mr_n71870720)
print v(xbgr.mr_n71870832)
print v(xbgr.mr_n71871152)
print v(xbgr.mr_n71872016)
print v(xbgr.mr_n71872880)
print v(xbgr.mr_n71872992)
print v(xbgr.mr_n71873424)
print v(xbgr.mr_n71873744)
print v(xbgr.mr_n71873856)
print v(xbgr.mr_n71874176)
print v(xbgr.mr_n71874288)
print v(xbgr.mr_n71874608)
print v(xbgr.mr_n71874720)
print v(xbgr.mr_n71875040)
print v(xbgr.mr_n71875152)
print v(xbgr.mr_n71875472)
print v(xbgr.mr_n71875584)
print v(xbgr.mr_n71876016)
print v(xbgr.mr_n71876336)
print v(xbgr.mr_n71877200)
print v(xbgr.mr_n71877312)
print v(xbgr.mr_n71877744)
print v(xbgr.mr_n71878064)
print v(xbgr.mr_n71878176)
print v(xbgr.mr_n71878608)
print v(xbgr.mr_n71878928)
print v(xbgr.mr_n71879040)
print v(xbgr.mr_n71879360)
print v(xbgr.mr_n71879472)
print v(xbgr.mr_n71879792)
print v(xbgr.mr_n71879904)
print v(xbgr.mr_n71880224)
print v(xbgr.mr_n71880336)
print v(xbgr.mr_n71880656)
print v(xbgr.mr_n71881520)
print v(xbgr.mr_n71882384)
print v(xbgr.mr_n71882496)
print v(xbgr.mr_n71882816)
print v(xbgr.mr_n71882928)
print v(xbgr.mr_n71883248)
print v(xbgr.mr_n71883360)
print v(xbgr.mr_n71883680)
print v(xbgr.mr_n71883792)
print v(xbgr.mr_n71884112)
print v(xbgr.mr_n71884976)
print v(xbgr.mr_n71885840)
print v(xbgr.mr_n71885952)
print v(xbgr.mr_n71886272)
print v(xbgr.mr_n71886384)
print v(xbgr.mr_n71886704)
print v(xbgr.mr_n71887568)
print v(xbgr.mr_n71887680)
print v(xbgr.mr_n71888000)
print v(xbgr.mr_n71888112)
print v(xbgr.mr_n71888432)
print v(xbgr.mr_n71888544)
print v(xbgr.mr_n71888864)
print v(xbgr.mr_n71888976)
print v(xbgr.mr_n71889296)
print v(xbgr.mr_n71889408)
print v(xbgr.mr_n71889728)
print v(xbgr.mr_n71889840)
print v(xbgr.mr_n71890160)
print v(xbgr.mr_n71891024)
print v(xbgr.mr_n71891824)
print v(xbgr.mr_n71891936)
print v(xbgr.mr_n71892256)
print v(xbgr.mr_n71892368)
print v(xbgr.mr_n71892688)
print v(xbgr.mr_n71892800)
print v(xbgr.mr_n71893120)
print v(xbgr.mr_n71893232)
print v(xbgr.mr_n71893552)
print v(xbgr.mr_n71893664)
print v(xbgr.mr_n71893984)
print v(xbgr.mr_n71894096)
print v(xbgr.mr_n71894416)
print v(xbgr.mr_n71894528)
print v(xbgr.mr_n71894848)
print v(xbgr.mr_n71894960)
print v(xbgr.mr_n71895280)
print v(xbgr.mr_n71895392)
print v(xbgr.mr_n71895712)
print v(xbgr.mr_n71895824)
print v(xbgr.mr_n71896144)
print v(xbgr.mr_n71896256)
print v(xbgr.mr_n71896576)
print v(xbgr.mr_n71896688)
print v(xbgr.mr_n71897008)
print v(xbgr.mr_n71897120)
print v(xbgr.mr_n71897440)
print v(xbgr.mr_n71897552)
print v(xbgr.mr_n71897872)
print v(xbgr.mr_n71897984)
print v(xbgr.mr_n71898304)
print v(xbgr.mr_n71898416)
print v(xbgr.mr_n71898736)
print v(xbgr.mr_n71898848)
print v(xbgr.mr_n71899168)
print v(xbgr.mr_n71899280)
print v(xbgr.mr_n71899600)
print v(xbgr.mr_n71899712)
print v(xbgr.mr_n71900032)
print v(xbgr.mr_n71900144)
print v(xbgr.mr_n71900464)
print v(xbgr.mr_n71900576)
print v(xbgr.mr_n71900896)
print v(xbgr.mr_n71901008)
print v(xbgr.mr_n71901328)
print v(xbgr.mr_n71901440)
print v(xbgr.mr_n71901760)
print v(xbgr.mr_n71901872)
print v(xbgr.mr_n71902192)
print v(xbgr.mr_n71902304)
print v(xbgr.mr_n71902624)
print v(xbgr.mr_n71902736)
print v(xbgr.mr_n71903056)
print v(xbgr.mr_n71903168)
print v(xbgr.mr_n71903488)
print v(xbgr.mr_n71903600)
print v(xbgr.mr_n71903920)
print v(xbgr.mr_n71904032)
print v(xbgr.mr_n71904352)
print v(xbgr.mr_n71904464)
print v(xbgr.mr_n71904784)
print v(xbgr.mr_n71904896)
print v(xbgr.mr_n71905216)
print v(xbgr.mr_n71905328)
print v(xbgr.mr_n71905648)
print v(xbgr.mr_n71905760)
print v(xbgr.mr_n71906080)
print v(xbgr.mr_n71906192)
print v(xbgr.mr_n71906512)
print v(xbgr.mr_n71906624)
print v(xbgr.mr_n71906944)
print v(xbgr.mr_n71907056)
print v(xbgr.mr_n71907376)
print v(xbgr.mr_n71907488)
print v(xbgr.mr_n71907808)
print v(xbgr.mr_n71907920)
print v(xbgr.mr_n71908240)
print v(xbgr.mr_n71908352)
print v(xbgr.mr_n71908672)
print v(xbgr.mr_n71908784)
print v(xbgr.mr_n71909104)
print v(xbgr.mr_n71909216)
print v(xbgr.mr_n71909536)
print v(xbgr.mr_n71909648)
print v(xbgr.mr_n71909968)
print v(xbgr.mr_n71910080)
print v(xbgr.mr_n71910400)
print v(xbgr.mr_n71910512)
print v(xbgr.mr_n71910832)
print v(xbgr.mr_n71910944)
print v(xbgr.mr_n71911264)
print v(xbgr.mr_n71911376)
print v(xbgr.mr_n71911696)
print v(xbgr.mr_n71911808)
print v(xbgr.mr_n71912128)
print v(xbgr.mr_n71912240)
print v(xbgr.mr_n71912560)
print v(xbgr.mr_n71912672)
print v(xbgr.mr_n71912992)
print v(xbgr.mr_n71913104)
print v(xbgr.mr_n71913424)
print v(xbgr.mr_n71913536)
print v(xbgr.mr_n71913856)
print v(xbgr.mr_n71913968)
print v(xbgr.mr_n71914288)
print v(xbgr.mr_n71914400)
print v(xbgr.mr_n71914720)
print v(xbgr.mr_n71914832)
print v(xbgr.mr_n71915152)
print v(xbgr.mr_n71915264)
print v(xbgr.mr_n71915584)
print v(xbgr.mr_n71915696)
print v(xbgr.mr_n71916016)
print v(xbgr.mr_n71916128)
print v(xbgr.mr_n71916448)
print v(xbgr.mr_n71916560)
print v(xbgr.mr_n71916880)
print v(xbgr.mr_n71916992)
print v(xbgr.mr_n71917312)
print v(xbgr.mr_n71917424)
print v(xbgr.mr_n71917744)
print v(xbgr.mr_n71917856)
print v(xbgr.mr_n71918176)
print v(xbgr.mr_n71918288)
print v(xbgr.mr_n71918608)
print v(xbgr.mr_n71918720)
print v(xbgr.mr_n71919040)
print v(xbgr.mr_n71919152)
print v(xbgr.mr_n71919472)
print v(xbgr.mr_n71919584)
print v(xbgr.mr_n71919904)
print v(xbgr.mr_n71920016)
print v(xbgr.mr_n71920336)
print v(xbgr.mr_n71920448)
print v(xbgr.mr_n71920768)
print v(xbgr.mr_n71920880)
print v(xbgr.mr_n71921200)
print v(xbgr.mr_n71921312)
print v(xbgr.mr_n71921632)
print v(xbgr.mr_n71921744)
print v(xbgr.mr_n71922064)
print v(xbgr.mr_n71922176)
print v(xbgr.mr_n71922496)
print v(xbgr.mr_n71922608)
print v(xbgr.mr_n71922928)
print v(xbgr.mr_n71923040)
print v(xbgr.mr_n71923360)
print v(xbgr.mr_n71923472)
print v(xbgr.mr_n71923792)
print v(xbgr.mr_n71923904)
print v(xbgr.mr_n71924224)
print v(xbgr.mr_n71924336)
print v(xbgr.mr_n71924656)
print v(xbgr.mr_n71924768)
print v(xbgr.mr_n71925088)
print v(xbgr.mr_n71925200)
print v(xbgr.mr_n71925520)
print v(xbgr.mr_n71925632)
print v(xbgr.mr_n71925952)
print v(xbgr.mr_n71926064)
print v(xbgr.mr_n71926384)
print v(xbgr.mr_n71926496)
print v(xbgr.mr_n71926816)
print v(xbgr.mr_n71926928)
print v(xbgr.mr_n71927248)
print v(xbgr.mr_n71927360)
print v(xbgr.mr_n71927680)
print v(xbgr.mr_n71927792)
print v(xbgr.mr_n71928112)
print v(xbgr.mr_n71928224)
print v(xbgr.mr_n71928544)
print v(xbgr.mr_n71928656)
print v(xbgr.mr_n71928976)
print v(xbgr.mr_n71929088)
print v(xbgr.mr_n71929408)
print v(xbgr.mr_n71929520)
print v(xbgr.mr_n71929840)
print v(xbgr.mr_n71929952)
print v(xbgr.mr_n71930272)
print v(xbgr.mr_n71930384)
print v(xbgr.mr_n71930704)
print v(xbgr.mr_n71930816)
print v(xbgr.mr_n71931136)
print v(xbgr.mr_n71931248)
print v(xbgr.mr_n71931568)
print v(xbgr.mr_n71931680)
print v(xbgr.mr_n71932000)
print v(xbgr.mr_n71932112)
print v(xbgr.mr_n71932432)
print v(xbgr.mr_n71932544)
print v(xbgr.mr_n71932864)
print v(xbgr.mr_n71932976)
print v(xbgr.mr_n71933296)
print v(xbgr.mr_n71933408)
print v(xbgr.mr_n71933728)
print v(xbgr.mr_n71933840)
print v(xbgr.mr_n71934160)
print v(xbgr.mr_n71934272)
print v(xbgr.mr_n71934592)
print v(xbgr.mr_n71934704)
print v(xbgr.mr_n71935024)
print v(xbgr.mr_n71935136)
print v(xbgr.mr_n71935456)
print v(xbgr.mr_n71935568)
print v(xbgr.mr_n71935888)
print v(xbgr.mr_n71936000)
print v(xbgr.mr_n71936320)
print v(xbgr.mr_n71936432)
print v(xbgr.mr_n71936752)
print v(xbgr.mr_n71936864)
print v(xbgr.mr_n71937184)
print v(xbgr.mr_n71937296)
print v(xbgr.mr_n71937616)
print v(xbgr.mr_n71937728)
print v(xbgr.mr_n71938048)
print v(xbgr.mr_n71938160)
print v(xbgr.mr_n71938480)
print v(xbgr.mr_n71938592)
print v(xbgr.mr_n71938912)
print v(xbgr.mr_n71939024)
print v(xbgr.mr_n71939344)
print v(xbgr.mr_n71939456)
print v(xbgr.mr_n71939776)
print v(xbgr.mr_n71939888)
print v(xbgr.mr_n71940208)
print v(xbgr.mr_n71940320)
print v(xbgr.mr_n71940640)
print v(xbgr.mr_n71940752)
print v(xbgr.mr_n71941072)
print v(xbgr.mr_n71941184)
print v(xbgr.mr_n71941504)
print v(xbgr.mr_n71941616)
print v(xbgr.mr_n71941936)
print v(xbgr.mr_n71942048)
print v(xbgr.mr_n71942368)
print v(xbgr.mr_n71942480)
print v(xbgr.mr_n71942800)
print v(xbgr.mr_n71942912)
print v(xbgr.mr_n71943232)
print v(xbgr.mr_n71943344)
print v(xbgr.mr_n71943664)
print v(xbgr.mr_n71943776)
print v(xbgr.mr_n71944096)
print v(xbgr.mr_n71944208)
print v(xbgr.mr_n71944528)
print v(xbgr.mr_n71944640)
print v(xbgr.mr_n71944960)
print v(xbgr.mr_n71945072)
print v(xbgr.mr_n71945392)
print v(xbgr.mr_n71945504)
print v(xbgr.mr_n71945824)
print v(xbgr.mr_n71945936)
print v(xbgr.mr_n71946256)
print v(xbgr.mr_n71946368)
print v(xbgr.mr_n71946688)
print v(xbgr.mr_n71946800)
print v(xbgr.mr_n71947120)
print v(xbgr.mr_n71947232)
print v(xbgr.mr_n71947552)
print v(xbgr.mr_n71947664)
print v(xbgr.mr_n71947984)
print v(xbgr.mr_n71948096)
print v(xbgr.mr_n71948416)
print v(xbgr.mr_n71948528)
print v(xbgr.mr_n71948848)
print v(xbgr.mr_n71948960)
print v(xbgr.mr_n71949280)
print v(xbgr.mr_n71949392)
print v(xbgr.mr_n71949712)
print v(xbgr.mr_n71949824)
print v(xbgr.mr_n71950144)
print v(xbgr.mr_n71950256)
print v(xbgr.mr_n71950576)
print v(xbgr.mr_n71950688)
print v(xbgr.mr_n71951008)
print v(xbgr.mr_n71951120)
print v(xbgr.mr_n71951440)
print v(xbgr.mr_n71951552)
print v(xbgr.mr_n71951872)
print v(xbgr.mr_n71951984)
print v(xbgr.mr_n71952304)
print v(xbgr.mr_n71952416)
print v(xbgr.mr_n71952736)
print v(xbgr.mr_n71952848)
print v(xbgr.mr_n71953168)
print v(xbgr.mr_n71953280)
print v(xbgr.mr_n71953600)
print v(xbgr.mr_n71953712)
print v(xbgr.mr_n71954032)
print v(xbgr.mr_n71954144)
print v(xbgr.mr_n71954464)
print v(xbgr.mr_n71954576)
print v(xbgr.mr_n71954896)
print v(xbgr.mr_n71955008)
print v(xbgr.mr_n71955328)
print v(xbgr.mr_n71955440)
print v(xbgr.mr_n71955760)
print v(xbgr.mr_n71955872)
print v(xbgr.mr_n71956192)
print v(xbgr.mr_n71956304)
print v(xbgr.mr_n71956624)
print v(xbgr.mr_n71956736)
print v(xbgr.mr_n71957056)
print v(xbgr.mr_n71957168)
print v(xbgr.mr_n71957488)
print v(xbgr.mr_n71957600)
print v(xbgr.mr_n71957920)
print v(xbgr.mr_n71958032)
print v(xbgr.mr_n71958352)
print v(xbgr.mr_n71958464)
print v(xbgr.mr_n71958784)
print v(xbgr.mr_n71958896)
print v(xbgr.mr_n71959216)
print v(xbgr.mr_n71959328)
print v(xbgr.mr_n71959648)
print v(xbgr.mr_n71959760)
print v(xbgr.mr_n71960080)
print v(xbgr.mr_n71960192)
print v(xbgr.mr_n71960512)
print v(xbgr.mr_n71960624)
print v(xbgr.mr_n71960944)
print v(xbgr.mr_n71961056)
print v(xbgr.mr_n71961376)
print v(xbgr.mr_n71961488)
print v(xbgr.mr_n71961808)
print v(xbgr.mr_n71961920)
print v(xbgr.mr_n71962240)
print v(xbgr.mr_n71962352)
print v(xbgr.mr_n71962672)
print v(xbgr.mr_n71962784)
print v(xbgr.mr_n71963104)
print v(xbgr.mr_n71963216)
print v(xbgr.mr_n71963536)
print v(xbgr.mr_n71963648)
print v(xbgr.mr_n71963968)
print v(xbgr.mr_n71964080)
print v(xbgr.mr_n71964400)
print v(xbgr.mr_n71964512)
print v(xbgr.mr_n71964832)
print v(xbgr.mr_n71964944)
print v(xbgr.mr_n71965264)
print v(xbgr.mr_n71965376)
print v(xbgr.mr_n71965696)
print v(xbgr.mr_n71965808)
print v(xbgr.mr_n71966128)
print v(xbgr.mr_n71966240)
print v(xbgr.mr_n71966560)
print v(xbgr.mr_n71966672)
print v(xbgr.mr_n71966992)
print v(xbgr.mr_n71967104)
print v(xbgr.mr_n71967424)
print v(xbgr.mr_n71967536)
print v(xbgr.mr_n71967856)
print v(xbgr.mr_n71967968)
print v(xbgr.mr_n71968288)
print v(xbgr.mr_n71968400)
print v(xbgr.mr_n71968720)
print v(xbgr.mr_n71968832)
print v(xbgr.mr_n71969152)
print v(xbgr.mr_n71969264)
print v(xbgr.mr_n71969584)
print v(xbgr.mr_n71969696)
print v(xbgr.mr_n71970016)
print v(xbgr.mr_n71970128)
print v(xbgr.mr_n71970448)
print v(xbgr.mr_n71970560)
print v(xbgr.mr_n71970880)
print v(xbgr.mr_n71970992)
print v(xbgr.mr_n71971312)
print v(xbgr.mr_n71971424)
print v(xbgr.mr_n71971744)
print v(xbgr.mr_n71971856)
print v(xbgr.mr_n71972176)
print v(xbgr.mr_n71972288)
print v(xbgr.mr_n71972608)
print v(xbgr.mr_n71972720)
print v(xbgr.mr_n71973040)
print v(xbgr.mr_n71973152)
print v(xbgr.mr_n71973472)
print v(xbgr.mr_n71973584)
print v(xbgr.mr_n71973904)
print v(xbgr.mr_n71974016)
print v(xbgr.mr_n71974336)
print v(xbgr.mr_n71974448)
print v(xbgr.mr_n71974768)
print v(xbgr.mr_n71974880)
print v(xbgr.mr_n71975200)
print v(xbgr.mr_n71975312)
print v(xbgr.mr_n71975632)
print v(xbgr.mr_n71975744)
print v(xbgr.mr_n71976064)
print v(xbgr.mr_n71976176)
print v(xbgr.mr_n71976496)
print v(xbgr.mr_n71976608)
print v(xbgr.mr_n71976928)
print v(xbgr.mr_n71977040)
print v(xbgr.mr_n71977360)
print v(xbgr.mr_n71977472)
print v(xbgr.mr_n71977792)
print v(xbgr.mr_n71977904)
print v(xbgr.mr_n71978224)
print v(xbgr.mr_n71978336)
print v(xbgr.mr_n71978656)
print v(xbgr.mr_n71978768)
print v(xbgr.mr_n71979088)
print v(xbgr.mr_n71979200)
print v(xbgr.mr_n71979520)
print v(xbgr.mr_n71979632)
print v(xbgr.mr_n71979952)
print v(xbgr.mr_n71980064)
print v(xbgr.mr_n71980384)
print v(xbgr.mr_n71980496)
print v(xbgr.mr_n71980816)
print v(xbgr.mr_n71980928)
print v(xbgr.mr_n71981248)
print v(xbgr.mr_n71981360)
print v(xbgr.mr_n71981680)
print v(xbgr.mr_n71981792)
print v(xbgr.mr_n71982112)
print v(xbgr.mr_n71982224)
print v(xbgr.mr_n71982544)
print v(xbgr.mr_n71982656)
print v(xbgr.mr_n71982976)
print v(xbgr.mr_n71983088)
print v(xbgr.mr_n71983408)
print v(xbgr.mr_n71983520)
print v(xbgr.mr_n71983840)
print v(xbgr.mr_n71983952)
print v(xbgr.mr_n71984272)
print v(xbgr.mr_n71984384)
print v(xbgr.mr_n71984704)
print v(xbgr.mr_n71984816)
print v(xbgr.mr_n71985136)
print v(xbgr.mr_n71985248)
print v(xbgr.mr_n71985568)
print v(xbgr.mr_n71985680)
print v(xbgr.mr_n71986000)
print v(xbgr.mr_n71986112)
print v(xbgr.mr_n71986432)
print v(xbgr.mr_n71986544)
print v(xbgr.mr_n71986864)
print v(xbgr.mr_n71986976)
print v(xbgr.mr_n71987296)
print v(xbgr.mr_n71987408)
print v(xbgr.mr_n71987728)
print v(xbgr.mr_n71987840)
print v(xbgr.mr_n71988160)
print v(xbgr.mr_n71988272)
print v(xbgr.mr_n71988592)
print v(xbgr.mr_n71988704)
print v(xbgr.mr_n71989024)
print v(xbgr.mr_n71989136)
print v(xbgr.mr_n71989456)
print v(xbgr.mr_n71989568)
print v(xbgr.mr_n71989888)
print v(xbgr.mr_n71990000)
print v(xbgr.mr_n71990320)
print v(xbgr.mr_n71990432)
print v(xbgr.mr_n71990752)
print v(xbgr.mr_n71990864)
print v(xbgr.mr_n71991184)
print v(xbgr.mr_n71991296)
print v(xbgr.mr_n71991616)
print v(xbgr.mr_n71991728)
print v(xbgr.mr_n71992048)
print v(xbgr.mr_n71992160)
print v(xbgr.mr_n71992480)
print v(xbgr.mr_n71992592)
print v(xbgr.mr_n71992912)
print v(xbgr.mr_n71993024)
print v(xbgr.mr_n71993344)
print v(xbgr.mr_n71993456)
print v(xbgr.mr_n71993776)
print v(xbgr.mr_n71993888)
print v(xbgr.mr_n71994208)
print v(xbgr.mr_n71994320)
print v(xbgr.mr_n71994640)
print v(xbgr.mr_n71994752)
print v(xbgr.mr_n71995072)
print v(xbgr.mr_n71995184)
print v(xbgr.mr_n71995504)
print v(xbgr.mr_n71995616)
print v(xbgr.mr_n71995936)
print v(xbgr.mr_n71996048)
print v(xbgr.mr_n71996368)
print v(xbgr.mr_n71996480)
print v(xbgr.mr_n71996800)
print v(xbgr.mr_n71996912)
print v(xbgr.mr_n71997232)
print v(xbgr.mr_n71997344)
print v(xbgr.mr_n71997664)
print v(xbgr.mr_n71997776)
print v(xbgr.mr_n71998096)
print v(xbgr.mr_n71998208)
print v(xbgr.mr_n71998528)
print v(xbgr.mr_n71998640)
print v(xbgr.mr_n71998960)
print v(xbgr.mr_n71999072)
print v(xbgr.mr_n71999392)
print v(xbgr.mr_n71999504)
print v(xbgr.mr_n71999824)
print v(xbgr.mr_n71999936)
print v(xbgr.mr_n72000256)
print v(xbgr.mr_n72000368)
print v(xbgr.mr_n72000688)
print v(xbgr.mr_n72000800)
print v(xbgr.mr_n72001120)
print v(xbgr.mr_n72001232)
print v(xbgr.mr_n72001552)
print v(xbgr.mr_n72001664)
print v(xbgr.mr_n72001984)
print v(xbgr.mr_n72002096)
print v(xbgr.mr_n72002416)
print v(xbgr.mr_n72002528)
print v(xbgr.mr_n72002848)
print v(xbgr.mr_n72002960)
print v(xbgr.mr_n72003280)
print v(xbgr.mr_n72003392)
print v(xbgr.mr_n72003712)
print v(xbgr.mr_n72003824)
print v(xbgr.mr_n72004144)
print v(xbgr.mr_n72004256)
print v(xbgr.mr_n72004576)
print v(xbgr.mr_n72004688)
print v(xbgr.mr_n72005008)
print v(xbgr.mr_n72005120)
print v(xbgr.mr_n72005440)
print v(xbgr.mr_n72005552)
print v(xbgr.mr_n72005872)
print v(xbgr.mr_n72005984)
print v(xbgr.mr_n72006304)
print v(xbgr.mr_n72006416)
print v(xbgr.mr_n72006736)
print v(xbgr.mr_n72006848)
print v(xbgr.mr_n72007168)
print v(xbgr.mr_n72007280)
print v(xbgr.mr_n72007600)
print v(xbgr.mr_n72007712)
print v(xbgr.mr_n72008032)
print v(xbgr.mr_n72008144)
print v(xbgr.mr_n72008464)
print v(xbgr.mr_n72008576)
print v(xbgr.mr_n72008896)
print v(xbgr.mr_n72009008)
print v(xbgr.mr_n72009328)
print v(xbgr.mr_n72009440)
print v(xbgr.mr_n72009760)
print v(xbgr.mr_n72009872)
print v(xbgr.mr_n72010192)
print v(xbgr.mr_n72010304)
print v(xbgr.mr_n72010624)
print v(xbgr.mr_n72010736)
print v(xbgr.mr_n72011056)
print v(xbgr.mr_n72011168)
print v(xbgr.mr_n72011488)
print v(xbgr.mr_n72011600)
print v(xbgr.mr_n72011920)
print v(xbgr.mr_n72012032)
print v(xbgr.mr_n72012352)
print v(xbgr.mr_n72012464)
print v(xbgr.mr_n72012784)
print v(xbgr.mr_n72012896)
print v(xbgr.mr_n72013216)
print v(xbgr.mr_n72013328)
print v(xbgr.mr_n72013648)
print v(xbgr.mr_n72013760)
print v(xbgr.mr_n72014080)
print v(xbgr.mr_n72014192)
print v(xbgr.mr_n72014512)
print v(xbgr.mr_n72014624)
print v(xbgr.mr_n72014944)
print v(xbgr.mr_n72015056)
print v(xbgr.mr_n72015376)
print v(xbgr.mr_n72015488)
print v(xbgr.mr_n72015808)
print v(xbgr.mr_n72015920)
print v(xbgr.mr_n72016240)
print v(xbgr.mr_n72016352)
print v(xbgr.mr_n72016672)
print v(xbgr.mr_n72016784)
print v(xbgr.mr_n72017104)
print v(xbgr.mr_n72017216)
print v(xbgr.mr_n72017536)
print v(xbgr.mr_n72017648)
print v(xbgr.mr_n72017968)
print v(xbgr.mr_n72018080)
print v(xbgr.mr_n72018400)
print v(xbgr.mr_n72018512)
print v(xbgr.mr_n72018832)
print v(xbgr.mr_n72018944)
print v(xbgr.mr_n72019264)
print v(xbgr.mr_n72019376)
print v(xbgr.mr_n72019696)
print v(xbgr.mr_n72019808)
print v(xbgr.mr_n72020128)
print v(xbgr.mr_n72020240)
print v(xbgr.mr_n72020560)
print v(xbgr.mr_n72020672)
print v(xbgr.mr_n72020992)
print v(xbgr.mr_n72021104)
print v(xbgr.mr_n72021424)
print v(xbgr.mr_n72021536)
print v(xbgr.mr_n72021856)
print v(xbgr.mr_n72021968)
print v(xbgr.mr_n72022288)
print v(xbgr.mr_n72022400)
print v(xbgr.mr_n72022720)
print v(xbgr.mr_n72022832)
print v(xbgr.mr_n72023152)
print v(xbgr.mr_n72023264)
print v(xbgr.mr_n72023584)
print v(xbgr.mr_n72023696)
print v(xbgr.mr_n72024016)
print v(xbgr.mr_n72024128)
print v(xbgr.mr_n72024448)
print v(xbgr.mr_n72024560)
print v(xbgr.mr_n72024880)
print v(xbgr.mr_n72024992)
print v(xbgr.mr_n72025312)
print v(xbgr.mr_n72025424)
print v(xbgr.mr_n72025744)
print v(xbgr.mr_n72025856)
print v(xbgr.mr_n72026176)
print v(xbgr.mr_n72026288)
print v(xbgr.mr_n72026608)
print v(xbgr.mr_n72026720)
print v(xbgr.mr_n72027040)
print v(xbgr.mr_n72027152)
print v(xbgr.mr_n72027472)
print v(xbgr.mr_n72027584)
print v(xbgr.mr_n72027904)
print v(xbgr.mr_n72028016)
print v(xbgr.mr_n72028336)
print v(xbgr.mr_n72028448)
print v(xbgr.mr_n72028768)
print v(xbgr.mr_n72028880)
print v(xbgr.mr_n72029200)
print v(xbgr.mr_n72029312)
print v(xbgr.mr_n72029632)
print v(xbgr.mr_n72029744)
print v(xbgr.mr_n72030064)
print v(xbgr.mr_n72030176)
print v(xbgr.mr_n72030496)
print v(xbgr.mr_n72030608)
print v(xbgr.mr_n72030928)
print v(xbgr.mr_n72031040)
print v(xbgr.mr_n72031360)
print v(xbgr.mr_n72031472)
print v(xbgr.mr_n72031792)
print v(xbgr.mr_n72031904)
print v(xbgr.mr_n72032224)
print v(xbgr.mr_n72032336)
print v(xbgr.mr_n72032656)
print v(xbgr.mr_n72032768)
print v(xbgr.mr_n72033088)
print v(xbgr.mr_n72033200)
print v(xbgr.mr_n72033520)
print v(xbgr.mr_n72033632)
print v(xbgr.mr_n72033952)
print v(xbgr.mr_n72034064)
print v(xbgr.mr_n72034384)
print v(xbgr.mr_n72034496)
print v(xbgr.mr_n72034816)
print v(xbgr.mr_n72034928)
print v(xbgr.mr_n72035248)
print v(xbgr.mr_n72035360)
print v(xbgr.mr_n72035680)
print v(xbgr.mr_n72035792)
print v(xbgr.mr_n72036112)
print v(xbgr.mr_n72036224)
print v(xbgr.mr_n72036544)
print v(xbgr.mr_n72036656)
print v(xbgr.mr_n72036976)
print v(xbgr.mr_n72037088)
print v(xbgr.mr_n72037408)
print v(xbgr.mr_n72037520)
print v(xbgr.mr_n72037840)
print v(xbgr.mr_n72037952)
print v(xbgr.mr_n72038272)
print v(xbgr.mr_n72038384)
print v(xbgr.mr_n72038704)
print v(xbgr.mr_n72038816)
print v(xbgr.mr_n72039136)
print v(xbgr.mr_n72039248)
print v(xbgr.mr_n72039568)
print v(xbgr.mr_n72039680)
print v(xbgr.mr_n72040000)
print v(xbgr.mr_n72040112)
print v(xbgr.mr_n72040432)
print v(xbgr.mr_n72040544)
print v(xbgr.mr_n72040864)
print v(xbgr.mr_n72040976)
print v(xbgr.mr_n72041296)
print v(xbgr.mr_n72041408)
print v(xbgr.mr_n72041728)
print v(xbgr.mr_n72041840)
print v(xbgr.mr_n72042160)
print v(xbgr.mr_n72042272)
print v(xbgr.mr_n72042592)
print v(xbgr.mr_n72042704)
print v(xbgr.mr_n72043024)
print v(xbgr.mr_n72043136)
print v(xbgr.mr_n72043456)
print v(xbgr.mr_n72043568)
print v(xbgr.mr_n72043888)
print v(xbgr.mr_n72044000)
print v(xbgr.mr_n72044320)
print v(xbgr.mr_n72044432)
print v(xbgr.mr_n72044752)
print v(xbgr.mr_n72044864)
print v(xbgr.mr_n72045184)
print v(xbgr.mr_n72045296)
print v(xbgr.mr_n72045616)
print v(xbgr.mr_n72045728)
print v(xbgr.mr_n72046048)
print v(xbgr.mr_n72046160)
print v(xbgr.mr_n72046480)
print v(xbgr.mr_n72046592)
print v(xbgr.mr_n72046912)
print v(xbgr.mr_n72047024)
print v(xbgr.mr_n72047344)
print v(xbgr.mr_n72047456)
print v(xbgr.mr_n72047776)
print v(xbgr.mr_n72047888)
print v(xbgr.mr_n72048208)
print v(xbgr.mr_n72048320)
print v(xbgr.mr_n72048640)
print v(xbgr.mr_n72048752)
print v(xbgr.mr_n72049072)
print v(xbgr.mr_n72049184)
print v(xbgr.mr_n72049504)
print v(xbgr.mr_n72049616)
print v(xbgr.mr_n72049936)
print v(xbgr.mr_n72050048)
print v(xbgr.mr_n72050368)
print v(xbgr.mr_n72050480)
print v(xbgr.mr_n72050800)
print v(xbgr.mr_n72050912)
print v(xbgr.mr_n72051232)
print v(xbgr.mr_n72051344)
print v(xbgr.mr_n72051664)
print v(xbgr.mr_n72051776)
print v(xbgr.mr_n72052096)
print v(xbgr.mr_n72052208)
print v(xbgr.mr_n72052528)
print v(xbgr.mr_n72052640)
print v(xbgr.mr_n72052960)
print v(xbgr.mr_n72053392)
print v(xbgr.mr_n72053504)
print v(xbgr.mr_n72053824)
print v(xbgr.mr_n72054256)
print v(xbgr.mr_n72054368)
print v(xbgr.mr_n72054688)
print v(xbgr.mr_n72054800)
print v(xbgr.mr_n72055120)
print v(xbgr.mr_n72055232)
print v(xbgr.mr_n72055552)
print v(xbgr.mr_n72055664)
print v(xbgr.mr_n72055984)
print v(xbgr.mr_n72056096)
print v(xbgr.mr_n72056416)
print v(xbgr.mr_n72056528)
print v(xbgr.mr_n72056848)
print v(xbgr.mr_n72056960)
print v(xbgr.mr_n72057280)
print v(xbgr.mr_n72057392)
print v(xbgr.mr_n72057712)
print v(xbgr.mr_n72057824)
print v(xbgr.mr_n72058144)
print v(xbgr.mr_n72058256)
print v(xbgr.mr_n72058576)
print v(xbgr.mr_n72058688)
print v(xbgr.mr_n72059008)
print v(xbgr.mr_n72059120)
print v(xbgr.mr_n72059440)
print v(xbgr.mr_n72059552)
print v(xbgr.mr_n72059872)
print v(xbgr.mr_n72059984)
print v(xbgr.mr_n72060304)
print v(xbgr.mr_n72060416)
print v(xbgr.mr_n72060736)
print v(xbgr.mr_n72060848)
print v(xbgr.mr_n72061168)
print v(xbgr.mr_n72061280)
print v(xbgr.mr_n72061600)
print v(xbgr.mr_n72061712)
print v(xbgr.mr_n72062032)
print v(xbgr.mr_n72062144)
print v(xbgr.mr_n72062464)
print v(xbgr.mr_n72062576)
print v(xbgr.mr_n72062896)
print v(xbgr.mr_n72063008)
print v(xbgr.mr_n72063328)
print v(xbgr.mr_n72063440)
print v(xbgr.mr_n72063760)
print v(xbgr.mr_n72064192)
print v(xbgr.mr_n72064304)
print v(xbgr.mr_n72064624)
print v(xbgr.mr_n72065056)
print v(xbgr.mr_n72065168)
print v(xbgr.mr_n72065488)
print v(xbgr.mr_n72065920)
print v(xbgr.mr_n72066032)
print v(xbgr.mr_n72066352)
print v(xbgr.mr_n72066784)
print v(xbgr.mr_n72066896)
print v(xbgr.mr_n72067216)
print v(xbgr.mr_n72067648)
print v(xbgr.mr_n72067760)
print v(xbgr.mr_n72068080)
print v(xbgr.mr_n72068192)
print v(xbgr.mr_n72068512)
print v(xbgr.mr_n72068624)
print v(xbgr.mr_n72068944)
print v(xbgr.mr_n72069056)
print v(xbgr.mr_n72069376)
print v(xbgr.mr_n72069488)
print v(xbgr.mr_n72069808)
print v(xbgr.mr_n72069920)
print v(xbgr.mr_n72070240)
print v(xbgr.mr_n72070352)
print v(xbgr.mr_n72070672)
print v(xbgr.mr_n72070784)
print v(xbgr.mr_n72071104)
print v(xbgr.mr_n72071216)
print v(xbgr.mr_n72071536)
print v(xbgr.mr_n72071648)
print v(xbgr.mr_n72071968)
print v(xbgr.mr_n72072080)
print v(xbgr.mr_n72072400)
print v(xbgr.mr_n72072512)
print v(xbgr.mr_n72072832)
print v(xbgr.mr_n72072944)
print v(xbgr.mr_n72073264)
print v(xbgr.mr_n72073376)
print v(xbgr.mr_n72073696)
print v(xbgr.mr_n72073808)
print v(xbgr.mr_n72074128)
print v(xbgr.mr_n72074240)
print v(xbgr.mr_n72074560)
print v(xbgr.mr_n72074672)
print v(xbgr.mr_n72074992)
print v(xbgr.mr_n72075104)
print v(xbgr.mr_n72075424)
print v(xbgr.mr_n72075536)
print v(xbgr.mr_n72075856)
print v(xbgr.mr_n72075968)
print v(xbgr.mr_n72076288)
print v(xbgr.mr_n72076400)
print v(xbgr.mr_n72076720)
print v(xbgr.mr_n72076832)
print v(xbgr.mr_n72077152)
print v(xbgr.mr_n72077264)
print v(xbgr.mr_n72077584)
print v(xbgr.mr_n72077696)
print v(xbgr.mr_n72078016)
print v(xbgr.mr_n72078128)
print v(xbgr.mr_n72078448)
print v(xbgr.mr_n72078560)
print v(xbgr.mr_n72078880)
print v(xbgr.mr_n72078992)
print v(xbgr.mr_n72079312)
print v(xbgr.mr_n72079424)
print v(xbgr.mr_n72079744)
print v(xbgr.mr_n72079856)
print v(xbgr.mr_n72080176)
print v(xbgr.mr_n72080288)
print v(xbgr.mr_n72080608)
print v(xbgr.mr_n72080720)
print v(xbgr.mr_n72081040)
print v(xbgr.mr_n72081152)
print v(xbgr.mr_n72081472)
print v(xbgr.mr_n72081584)
print v(xbgr.mr_n72081904)
print v(xbgr.mr_n72082016)
print v(xbgr.mr_n72082336)
print v(xbgr.mr_n72082448)
print v(xbgr.mr_n72082768)
print v(xbgr.mr_n72082880)
print v(xbgr.mr_n72083200)
print v(xbgr.mr_n72083312)
print v(xbgr.mr_n72083632)
print v(xbgr.mr_n72083744)
print v(xbgr.mr_n72084064)
print v(xbgr.mr_n72084176)
print v(xbgr.mr_n72084496)
print v(xbgr.mr_n72084608)
print v(xbgr.mr_n72084928)
print v(xbgr.mr_n72085040)
print v(xbgr.mr_n72085360)
print v(xbgr.mr_n72085472)
print v(xbgr.mr_n72085792)
print v(xbgr.mr_n72085904)
print v(xbgr.mr_n72086224)
print v(xbgr.mr_n72086336)
print v(xbgr.mr_n72086656)
print v(xbgr.mr_n72086768)
print v(xbgr.mr_n72087088)
print v(xbgr.mr_n72087200)
print v(xbgr.mr_n72087520)
print v(xbgr.mr_n72087952)
print v(xbgr.mr_n72088064)
print v(xbgr.mr_n72088384)
print v(xbgr.mr_n72088816)
print v(xbgr.mr_n72088928)
print v(xbgr.mr_n72089248)
print v(xbgr.mr_n72089680)
print v(xbgr.mr_n72089792)
print v(xbgr.mr_n72090112)
print v(xbgr.mr_n72090224)
print v(xbgr.mr_n72090544)
print v(xbgr.mr_n72090656)
print v(xbgr.mr_n72090976)
print v(xbgr.mr_n72091088)
print v(xbgr.mr_n72091408)
print v(xbgr.mr_n72091520)
print v(xbgr.mr_n72091840)
print v(xbgr.mr_n72091952)
print v(xbgr.mr_n72092272)
print v(xbgr.mr_n72092384)
print v(xbgr.mr_n72092704)
print v(xbgr.mr_n72092816)
print v(xbgr.mr_n72093136)
print v(xbgr.mr_n72093248)
print v(xbgr.mr_n72093568)
print v(xbgr.mr_n72093680)
print v(xbgr.mr_n72094000)
print v(xbgr.mr_n72094112)
print v(xbgr.mr_n72094432)
print v(xbgr.mr_n72094544)
print v(xbgr.mr_n72094864)
print v(xbgr.mr_n72094976)
print v(xbgr.mr_n72095296)
print v(xbgr.mr_n72095408)
print v(xbgr.mr_n72095728)
print v(xbgr.mr_n72095840)
print v(xbgr.mr_n72096160)
print v(xbgr.mr_n72096272)
print v(xbgr.mr_n72096592)
print v(xbgr.mr_n72096704)
print v(xbgr.mr_n72097024)
print v(xbgr.mr_n72097136)
print v(xbgr.mr_n72097456)
print v(xbgr.mr_n72097568)
print v(xbgr.mr_n72097888)
print v(xbgr.mr_n72098000)
print v(xbgr.mr_n72098320)
print v(xbgr.mr_n72098432)
print v(xbgr.mr_n72098752)
print v(xbgr.mr_n72098864)
print v(xbgr.mr_n72099184)
print v(xbgr.mr_n72099296)
print v(xbgr.mr_n72099616)
print v(xbgr.mr_n72099728)
print v(xbgr.mr_n72100048)
print v(xbgr.mr_n72100160)
print v(xbgr.mr_n72100480)
print v(xbgr.mr_n72100592)
print v(xbgr.mr_n72100912)
print v(xbgr.mr_n72101024)
print v(xbgr.mr_n72101344)
print v(xbgr.mr_n72101456)
print v(xbgr.mr_n72101776)
print v(xbgr.mr_n72101888)
print v(xbgr.mr_n72102208)
print v(xbgr.mr_n72102320)
print v(xbgr.mr_n72102640)
print v(xbgr.mr_n72102752)
print v(xbgr.mr_n72103072)
print v(xbgr.mr_n72103184)
print v(xbgr.mr_n72103504)
print v(xbgr.mr_n72103616)
print v(xbgr.mr_n72103936)
print v(xbgr.mr_n72104048)
print v(xbgr.mr_n72104368)
print v(xbgr.mr_n72104480)
print v(xbgr.mr_n72104800)
print v(xbgr.mr_n72104912)
print v(xbgr.mr_n72105232)
print v(xbgr.mr_n72105344)
print v(xbgr.mr_n72105664)
print v(xbgr.mr_n72105776)
print v(xbgr.mr_n72106096)
print v(xbgr.mr_n72106208)
print v(xbgr.mr_n72106528)
print v(xbgr.mr_n72106640)
print v(xbgr.mr_n72106960)
print v(xbgr.mr_n72107072)
print v(xbgr.mr_n72107392)
print v(xbgr.mr_n72107504)
print v(xbgr.mr_n72107824)
print v(xbgr.mr_n72107936)
print v(xbgr.mr_n72108256)
print v(xbgr.mr_n72108368)
print v(xbgr.mr_n72108688)
print v(xbgr.mr_n72108800)
print v(xbgr.mr_n72109120)
print v(xbgr.mr_n72109232)
print v(xbgr.mr_n72109552)
print v(xbgr.mr_n72109664)
print v(xbgr.mr_n72109984)
print v(xbgr.mr_n72110096)
print v(xbgr.mr_n72110416)
print v(xbgr.mr_n72110528)
print v(xbgr.mr_n72110848)
print v(xbgr.mr_n72110960)
print v(xbgr.mr_n72111280)
print v(xbgr.mr_n72111392)
print v(xbgr.mr_n72111712)
print v(xbgr.mr_n72111824)
print v(xbgr.mr_n72112144)
print v(xbgr.mr_n72112256)
print v(xbgr.mr_n72112576)
print v(xbgr.mr_n72112688)
print v(xbgr.mr_n72113008)
print v(xbgr.mr_n72113120)
print v(xbgr.mr_n72113440)
print v(xbgr.mr_n72113552)
print v(xbgr.mr_n72113872)
print v(xbgr.mr_n72113984)
print v(xbgr.mr_n72114304)
print v(xbgr.mr_n72114416)
print v(xbgr.mr_n72114736)
print v(xbgr.mr_n72114848)
print v(xbgr.mr_n72115168)
print v(xbgr.mr_n72115280)
print v(xbgr.mr_n72115600)
print v(xbgr.mr_n72115712)
print v(xbgr.mr_n72116032)
print v(xbgr.mr_n72116144)
print v(xbgr.mr_n72116464)
print v(xbgr.mr_n72116576)
print v(xbgr.mr_n72116896)
print v(xbgr.mr_n72117008)
print v(xbgr.mr_n72117328)
print v(xbgr.mr_n72117440)
print v(xbgr.mr_n72117760)
print v(xbgr.mr_n72117872)
print v(xbgr.mr_n72118192)
print v(xbgr.mr_n72118304)
print v(xbgr.mr_n72118624)
print v(xbgr.mr_n72118736)
print v(xbgr.mr_n72119056)
print v(xbgr.mr_n72119168)
print v(xbgr.mr_n72119488)
print v(xbgr.mr_n72119600)
print v(xbgr.mr_n72119920)
print v(xbgr.mr_n72120032)
print v(xbgr.mr_n72120352)
print v(xbgr.mr_n72120464)
print v(xbgr.mr_n72120784)
print v(xbgr.mr_n72120896)
print v(xbgr.mr_n72121216)
print v(xbgr.mr_n72121328)
print v(xbgr.mr_n72121648)
print v(xbgr.mr_n72121760)
print v(xbgr.mr_n72122080)
print v(xbgr.mr_n72122192)
print v(xbgr.mr_n72122512)
print v(xbgr.mr_n72122624)
print v(xbgr.mr_n72122944)
print v(xbgr.mr_n72123056)
print v(xbgr.mr_n72123376)
print v(xbgr.mr_n72123488)
print v(xbgr.mr_n72123808)
print v(xbgr.mr_n72123920)
print v(xbgr.mr_n72124240)
print v(xbgr.mr_n72124352)
print v(xbgr.mr_n72124672)
print v(xbgr.mr_n72124784)
print v(xbgr.mr_n72125104)
print v(xbgr.mr_n72125216)
print v(xbgr.mr_n72125536)
print v(xbgr.mr_n72125648)
print v(xbgr.mr_n72125968)
print v(xbgr.mr_n72126080)
print v(xbgr.mr_n72126400)
print v(xbgr.mr_n72126512)
print v(xbgr.mr_n72126832)
print v(xbgr.mr_n72126944)
print v(xbgr.mr_n72127264)
print v(xbgr.mr_n72127376)
print v(xbgr.mr_n72127696)
print v(xbgr.mr_n72127808)
print v(xbgr.mr_n72128128)
print v(xbgr.mr_n72128240)
print v(xbgr.mr_n72128560)
print v(xbgr.mr_n72128672)
print v(xbgr.mr_n72128992)
print v(xbgr.mr_n72129104)
print v(xbgr.mr_n72129424)
print v(xbgr.mr_n72129536)
print v(xbgr.mr_n72129856)
print v(xbgr.mr_n72129968)
print v(xbgr.mr_n72130288)
print v(xbgr.mr_n72130400)
print v(xbgr.mr_n72130720)
print v(xbgr.mr_n72130832)
print v(xbgr.mr_n72131152)
print v(xbgr.mr_n72131264)
print v(xbgr.mr_n72131584)
print v(xbgr.mr_n72131696)
print v(xbgr.mr_n72132016)
print v(xbgr.mr_n72132128)
print v(xbgr.mr_n72132448)
print v(xbgr.mr_n72132560)
print v(xbgr.mr_n72132880)
print v(xbgr.mr_n72132992)
print v(xbgr.mr_n72133312)
print v(xbgr.mr_n72133424)
print v(xbgr.mr_n72133744)
print v(xbgr.mr_n72133856)
print v(xbgr.mr_n72134176)
print v(xbgr.mr_n72134288)
print v(xbgr.mr_n72134608)
print v(xbgr.mr_n72134720)
print v(xbgr.mr_n72135040)
print v(xbgr.mr_n72135152)
print v(xbgr.mr_n72135472)
print v(xbgr.mr_n72135584)
print v(xbgr.mr_n72135904)
print v(xbgr.mr_n72136016)
print v(xbgr.mr_n72136336)
print v(xbgr.mr_n72136448)
print v(xbgr.mr_n72136768)
print v(xbgr.mr_n72136880)
print v(xbgr.mr_n72137200)
print v(xbgr.mr_n72137312)
print v(xbgr.mr_n72137632)
print v(xbgr.mr_n72137744)
print v(xbgr.mr_n72138064)
print v(xbgr.mr_n72138176)
print v(xbgr.mr_n72138496)
print v(xbgr.mr_n72138608)
print v(xbgr.mr_n72138928)
print v(xbgr.mr_n72139040)
print v(xbgr.mr_n72139360)
print v(xbgr.mr_n72139472)
print v(xbgr.mr_n72139792)
print v(xbgr.mr_n72139904)
print v(xbgr.mr_n72140224)
print v(xbgr.mr_n72140336)
print v(xbgr.mr_n72140656)
print v(xbgr.mr_n72140768)
print v(xbgr.mr_n72141088)
print v(xbgr.mr_n72141200)
print v(xbgr.mr_n72141520)
print v(xbgr.mr_n72141632)
print v(xbgr.mr_n72141952)
print v(xbgr.mr_n72142064)
print v(xbgr.mr_n72142384)
print v(xbgr.mr_n72142496)
print v(xbgr.mr_n72142816)
print v(xbgr.mr_n72142928)
print v(xbgr.mr_n72143248)
print v(xbgr.mr_n72143360)
print v(xbgr.mr_n72143680)
print v(xbgr.mr_n72143792)
print v(xbgr.mr_n72144112)
print v(xbgr.mr_n72144224)
print v(xbgr.mr_n72144544)
print v(xbgr.mr_n72144656)
print v(xbgr.mr_n72144976)
print v(xbgr.mr_n72145088)
print v(xbgr.mr_n72145408)
print v(xbgr.mr_n72145520)
print v(xbgr.mr_n72145840)
print v(xbgr.mr_n72145952)
print v(xbgr.mr_n72146272)
print v(xbgr.mr_n72146384)
print v(xbgr.mr_n72146704)
print v(xbgr.mr_n72146816)
print v(xbgr.mr_n72147136)
print v(xbgr.mr_n72147248)
print v(xbgr.mr_n72147568)
print v(xbgr.mr_n72147680)
print v(xbgr.mr_n72148000)
print v(xbgr.mr_n72148112)
print v(xbgr.mr_n72148432)
print v(xbgr.mr_n72148544)
print v(xbgr.mr_n72148864)
print v(xbgr.mr_n72148976)
print v(xbgr.mr_n72149296)
print v(xbgr.mr_n72149408)
print v(xbgr.mr_n72149728)
print v(xbgr.mr_n72149840)
print v(xbgr.mr_n72150160)
print v(xbgr.mr_n72150272)
print v(xbgr.mr_n72150592)
print v(xbgr.mr_n72150704)
print v(xbgr.mr_n72151024)
print v(xbgr.mr_n72151136)
print v(xbgr.mr_n72151456)
print v(xbgr.mr_n72151568)
print v(xbgr.mr_n72151888)
print v(xbgr.mr_n72152000)
print v(xbgr.mr_n72152320)
print v(xbgr.mr_n72152432)
print v(xbgr.mr_n72152752)
print v(xbgr.mr_n72152864)
print v(xbgr.mr_n72153184)
print v(xbgr.mr_n72153296)
print v(xbgr.mr_n72153616)
print v(xbgr.mr_n72153728)
print v(xbgr.mr_n72154048)
print v(xbgr.mr_n72154160)
print v(xbgr.mr_n72154480)
print v(xbgr.mr_n72154592)
print v(xbgr.mr_n72154912)
print v(xbgr.mr_n72155024)
print v(xbgr.mr_n72155344)
print v(xbgr.mr_n72155456)
print v(xbgr.mr_n72155776)
print v(xbgr.mr_n72155888)
print v(xbgr.mr_n72156208)
print v(xbgr.mr_n72156320)
print v(xbgr.mr_n72156640)
print v(xbgr.mr_n72156752)
print v(xbgr.mr_n72157072)
print v(xbgr.mr_n72157184)
print v(xbgr.mr_n72157504)
print v(xbgr.mr_n72157616)
print v(xbgr.mr_n72157936)
print v(xbgr.mr_n72158048)
print v(xbgr.mr_n72158368)
print v(xbgr.mr_n72158480)
print v(xbgr.mr_n72158800)
print v(xbgr.mr_n72158912)
print v(xbgr.mr_n72159232)
print v(xbgr.mr_n72159344)
print v(xbgr.mr_n72159664)
print v(xbgr.mr_n72159776)
print v(xbgr.mr_n72160096)
print v(xbgr.mr_n72160208)
print v(xbgr.mr_n72160528)
print v(xbgr.mr_n72160640)
print v(xbgr.mr_n72160960)
print v(xbgr.mr_n72161072)
print v(xbgr.mr_n72161392)
print v(xbgr.mr_n72161504)
print v(xbgr.mr_n72161824)
print v(xbgr.mr_n72161936)
print v(xbgr.mr_n72162256)
print v(xbgr.mr_n72162368)
print v(xbgr.mr_n72162688)
print v(xbgr.mr_n72162800)
print v(xbgr.mr_n72163120)
print v(xbgr.mr_n72163232)
print v(xbgr.mr_n72163552)
print v(xbgr.mr_n72163664)
print v(xbgr.mr_n72163984)
print v(xbgr.mr_n72164096)
print v(xbgr.mr_n72164416)
print v(xbgr.mr_n72164528)
print v(xbgr.mr_n72164848)
print v(xbgr.mr_n72164960)
print v(xbgr.mr_n72165280)
print v(xbgr.mr_n72165392)
print v(xbgr.mr_n72165712)
print v(xbgr.mr_n72165824)
print v(xbgr.mr_n72166144)
print v(xbgr.mr_n72166256)
print v(xbgr.mr_n72166576)
print v(xbgr.mr_n72166688)
print v(xbgr.mr_n72167008)
print v(xbgr.mr_n72167120)
print v(xbgr.mr_n72167440)
print v(xbgr.mr_n72167552)
print v(xbgr.mr_n72167872)
print v(xbgr.mr_n72167984)
print v(xbgr.mr_n72168304)
print v(xbgr.mr_n72168416)
print v(xbgr.mr_n72168736)
print v(xbgr.mr_n72168848)
print v(xbgr.mr_n72169168)
print v(xbgr.mr_n72169280)
print v(xbgr.mr_n72169600)
print v(xbgr.mr_n72169712)
print v(xbgr.mr_n72170032)
print v(xbgr.mr_n72170144)
print v(xbgr.mr_n72170464)
print v(xbgr.mr_n72170576)
print v(xbgr.mr_n72170896)
print v(xbgr.mr_n72171008)
print v(xbgr.mr_n72171328)
print v(xbgr.mr_n72171440)
print v(xbgr.mr_n72171760)
print v(xbgr.mr_n72171872)
print v(xbgr.mr_n72172192)
print v(xbgr.mr_n72172304)
print v(xbgr.mr_n72172624)
print v(xbgr.mr_n72172736)
print v(xbgr.mr_n72173056)
print v(xbgr.mr_n72173168)
print v(xbgr.mr_n72173488)
print v(xbgr.mr_n72173600)
print v(xbgr.mr_n72173920)
print v(xbgr.mr_n72174032)
print v(xbgr.mr_n72174352)
print v(xbgr.mr_n72174464)
print v(xbgr.mr_n72174784)
print v(xbgr.mr_n72174896)
print v(xbgr.mr_n72175216)
print v(xbgr.mr_n72175328)
print v(xbgr.mr_n72175648)
print v(xbgr.mr_n72175760)
print v(xbgr.mr_n72176080)
print v(xbgr.mr_n72176192)
print v(xbgr.mr_n72176512)
print v(xbgr.mr_n72176624)
print v(xbgr.mr_n72176944)
print v(xbgr.mr_n72177056)
print v(xbgr.mr_n72177376)
print v(xbgr.mr_n72177488)
print v(xbgr.mr_n72177808)
print v(xbgr.mr_n72177920)
print v(xbgr.mr_n72178240)
print v(xbgr.mr_n72178352)
print v(xbgr.mr_n72178672)
print v(xbgr.mr_n72178784)
print v(xbgr.mr_n72179104)
print v(xbgr.mr_n72179216)
print v(xbgr.mr_n72179536)
print v(xbgr.mr_n72179648)
print v(xbgr.mr_n72179968)
print v(xbgr.mr_n72180080)
print v(xbgr.mr_n72180400)
print v(xbgr.mr_n72180512)
print v(xbgr.mr_n72180832)
print v(xbgr.mr_n72180944)
print v(xbgr.mr_n72181264)
print v(xbgr.mr_n72181376)
print v(xbgr.mr_n72181696)
print v(xbgr.mr_n72181808)
print v(xbgr.mr_n72182128)
print v(xbgr.mr_n72182240)
print v(xbgr.mr_n72182560)
print v(xbgr.mr_n72182672)
print v(xbgr.mr_n72182992)
print v(xbgr.mr_n72183104)
print v(xbgr.mr_n72183424)
print v(xbgr.mr_n72183536)
print v(xbgr.mr_n72183856)
print v(xbgr.mr_n72183968)
print v(xbgr.mr_n72184288)
print v(xbgr.mr_n72184400)
print v(xbgr.mr_n72184720)
print v(xbgr.mr_n72184832)
print v(xbgr.mr_n72185152)
print v(xbgr.mr_n72185264)
print v(xbgr.mr_n72185584)
print v(xbgr.mr_n72185696)
print v(xbgr.mr_n72186016)
print v(xbgr.mr_n72186128)
print v(xbgr.mr_n72186448)
print v(xbgr.mr_n72186560)
print v(xbgr.mr_n72186880)
print v(xbgr.mr_n72186992)
print v(xbgr.mr_n72187312)
print v(xbgr.mr_n72187424)
print v(xbgr.mr_n72187744)
print v(xbgr.mr_n72187856)
print v(xbgr.mr_n72188176)
print v(xbgr.mr_n72188288)
print v(xbgr.mr_n72188608)
print v(xbgr.mr_n72188720)
print v(xbgr.mr_n72189040)
print v(xbgr.mr_n72189152)
print v(xbgr.mr_n72189472)
print v(xbgr.mr_n72189584)
print v(xbgr.mr_n72189904)
print v(xbgr.mr_n72190016)
print v(xbgr.mr_n72190336)
print v(xbgr.mr_n72190448)
print v(xbgr.mr_n72190768)
print v(xbgr.mr_n72190880)
print v(xbgr.mr_n72191200)
print v(xbgr.mr_n72191312)
print v(xbgr.mr_n72191632)
print v(xbgr.mr_n72191744)
print v(xbgr.mr_n72192064)
print v(xbgr.mr_n72192176)
print v(xbgr.mr_n72192496)
print v(xbgr.mr_n72192608)
print v(xbgr.mr_n72192928)
print v(xbgr.mr_n72193040)
print v(xbgr.mr_n72193360)
print v(xbgr.mr_n72193472)
print v(xbgr.mr_n72193792)
print v(xbgr.mr_n72193904)
print v(xbgr.mr_n72194224)
print v(xbgr.mr_n72194336)
print v(xbgr.mr_n72194656)
print v(xbgr.mr_n72194768)
print v(xbgr.mr_n72195088)
print v(xbgr.mr_n72195200)
print v(xbgr.mr_n72195520)
print v(xbgr.mr_n72195632)
print v(xbgr.mr_n72195952)
print v(xbgr.mr_n72196064)
print v(xbgr.mr_n72196384)
print v(xbgr.mr_n72196496)
print v(xbgr.mr_n72196816)
print v(xbgr.mr_n72196928)
print v(xbgr.mr_n72197248)
print v(xbgr.mr_n72197360)
print v(xbgr.mr_n72197680)
print v(xbgr.mr_n72197792)
print v(xbgr.mr_n72198112)
print v(xbgr.mr_n72198224)
print v(xbgr.mr_n72198544)
print v(xbgr.mr_n72198656)
print v(xbgr.mr_n72198976)
print v(xbgr.mr_n72199088)
print v(xbgr.mr_n72199408)
print v(xbgr.mr_n72199520)
print v(xbgr.mr_n72199840)
print v(xbgr.mr_n72199952)
print v(xbgr.mr_n72200272)
print v(xbgr.mr_n72200384)
print v(xbgr.mr_n72200704)
print v(xbgr.mr_n72200816)
print v(xbgr.mr_n72201136)
print v(xbgr.mr_n72201248)
print v(xbgr.mr_n72201568)
print v(xbgr.mr_n72201680)
print v(xbgr.mr_n72202000)
print v(xbgr.mr_n72202112)
print v(xbgr.mr_n72202432)
print v(xbgr.mr_n72202544)
print v(xbgr.mr_n72202864)
print v(xbgr.mr_n72202976)
print v(xbgr.mr_n72203296)
print v(xbgr.mr_n72203408)
print v(xbgr.mr_n72203728)
print v(xbgr.mr_n72203840)
print v(xbgr.mr_n72204160)
print v(xbgr.mr_n72204272)
print v(xbgr.mr_n72204592)
print v(xbgr.mr_n72204704)
print v(xbgr.mr_n72205024)
print v(xbgr.mr_n72205136)
print v(xbgr.mr_n72205456)
print v(xbgr.mr_n72205568)
print v(xbgr.mr_n72205888)
print v(xbgr.mr_n72206000)
print v(xbgr.mr_n72206320)
print v(xbgr.mr_n72206432)
print v(xbgr.mr_n72206752)
print v(xbgr.mr_n72206864)
print v(xbgr.mr_n72207184)
print v(xbgr.mr_n72207296)
print v(xbgr.mr_n72207616)
print v(xbgr.mr_n72207728)
print v(xbgr.mr_n72208048)
print v(xbgr.mr_n72208160)
print v(xbgr.mr_n72208480)
print v(xbgr.mr_n72208592)
print v(xbgr.mr_n72208912)
print v(xbgr.mr_n72209024)
print v(xbgr.mr_n72209344)
print v(xbgr.mr_n72209456)
print v(xbgr.mr_n72209776)
print v(xbgr.mr_n72209888)
print v(xbgr.mr_n72210208)
print v(xbgr.mr_n72210320)
print v(xbgr.mr_n72210640)
print v(xbgr.mr_n72210752)
print v(xbgr.mr_n72211072)
print v(xbgr.mr_n72211184)
print v(xbgr.mr_n72211504)
print v(xbgr.mr_n72211616)
print v(xbgr.mr_n72211936)
print v(xbgr.mr_n72212048)
print v(xbgr.mr_n72212368)
print v(xbgr.mr_n72212480)
print v(xbgr.mr_n72212800)
print v(xbgr.mr_n72212912)
print v(xbgr.mr_n72213232)
print v(xbgr.mr_n72213344)
print v(xbgr.mr_n72213664)
print v(xbgr.mr_n72213776)
print v(xbgr.mr_n72214096)
print v(xbgr.mr_n72214208)
print v(xbgr.mr_n72214528)
print v(xbgr.mr_n72214640)
print v(xbgr.mr_n72214960)
print v(xbgr.mr_n72215072)
print v(xbgr.mr_n72215392)
print v(xbgr.mr_n72215504)
print v(xbgr.mr_n72215824)
print v(xbgr.mr_n72215936)
print v(xbgr.mr_n72216256)
print v(xbgr.mr_n72216368)
print v(xbgr.mr_n72216688)
print v(xbgr.mr_n72216800)
print v(xbgr.mr_n72217120)
print v(xbgr.mr_n72217232)
print v(xbgr.mr_n72217552)
print v(xbgr.mr_n72217664)
print v(xbgr.mr_n72217984)
print v(xbgr.mr_n72218096)
print v(xbgr.mr_n72218416)
print v(xbgr.mr_n72218528)
print v(xbgr.mr_n72218848)
print v(xbgr.mr_n72218960)
print v(xbgr.mr_n72219280)
print v(xbgr.mr_n72219392)
print v(xbgr.mr_n72219712)
print v(xbgr.mr_n72219824)
print v(xbgr.mr_n72220144)
print v(xbgr.mr_n72220256)
print v(xbgr.mr_n72220576)
print v(xbgr.mr_n72220688)
print v(xbgr.mr_n72221008)
print v(xbgr.mr_n72221120)
print v(xbgr.mr_n72221440)
print v(xbgr.mr_n72221552)
print v(xbgr.mr_n72221872)
print v(xbgr.mr_n72221984)
print v(xbgr.mr_n72222304)
print v(xbgr.mr_n72222416)
print v(xbgr.mr_n72222736)
print v(xbgr.mr_n72222848)
print v(xbgr.mr_n72223168)
print v(xbgr.mr_n72223280)
print v(xbgr.mr_n72223600)
print v(xbgr.mr_n72223712)
print v(xbgr.mr_n72224032)
print v(xbgr.mr_n72224144)
print v(xbgr.mr_n72224464)
print v(xbgr.mr_n72224576)
print v(xbgr.mr_n72224896)
print v(xbgr.mr_n72225008)
print v(xbgr.mr_n72225328)
print v(xbgr.mr_n72225440)
print v(xbgr.mr_n72225760)
print v(xbgr.mr_n72225872)
print v(xbgr.mr_n72226192)
print v(xbgr.mr_n72226304)
print v(xbgr.mr_n72226624)
print v(xbgr.mr_n72226736)
print v(xbgr.mr_n72227056)
print v(xbgr.mr_n72227168)
print v(xbgr.mr_n72227488)
print v(xbgr.mr_n72227600)
print v(xbgr.mr_n72227920)
print v(xbgr.mr_n72228032)
print v(xbgr.mr_n72228352)
print v(xbgr.mr_n72228464)
print v(xbgr.mr_n72228784)
print v(xbgr.mr_n72228896)
print v(xbgr.mr_n72229216)
print v(xbgr.mr_n72229328)
print v(xbgr.mr_n72229648)
print v(xbgr.mr_n72229760)
print v(xbgr.mr_n72230080)
print v(xbgr.mr_n72230192)
print v(xbgr.mr_n72230512)
print v(xbgr.mr_n72230624)
print v(xbgr.mr_n72230944)
print v(xbgr.mr_n72231056)
print v(xbgr.mr_n72231376)
print v(xbgr.mr_n72231488)
print v(xbgr.mr_n72231808)
print v(xbgr.mr_n72231920)
print v(xbgr.mr_n72232240)
print v(xbgr.mr_n72232352)
print v(xbgr.mr_n72232672)
print v(xbgr.mr_n72232784)
print v(xbgr.mr_n72233104)
print v(xbgr.mr_n72233216)
print v(xbgr.mr_n72233536)
print v(xbgr.mr_n72233648)
print v(xbgr.mr_n72233968)
print v(xbgr.mr_n72234080)
print v(xbgr.mr_n72234400)
print v(xbgr.mr_n72234512)
print v(xbgr.mr_n72234832)
print v(xbgr.mr_n72234944)
print v(xbgr.mr_n72235264)
print v(xbgr.mr_n72235376)
print v(xbgr.mr_n72235696)
print v(xbgr.mr_n72235808)
print v(xbgr.mr_n72236128)
print v(xbgr.mr_n72236240)
print v(xbgr.mr_n72236560)
print v(xbgr.mr_n72236672)
print v(xbgr.mr_n72236992)
print v(xbgr.mr_n72237104)
print v(xbgr.mr_n72237424)
print v(xbgr.mr_n72237536)
print v(xbgr.mr_n72237856)
print v(xbgr.mr_n72237968)
print v(xbgr.mr_n72238288)
print v(xbgr.mr_n72238400)
print v(xbgr.mr_n72238720)
print v(xbgr.mr_n72238832)
print v(xbgr.mr_n72239152)
print v(xbgr.mr_n72239264)
print v(xbgr.mr_n72239584)
print v(xbgr.mr_n72239696)
print v(xbgr.mr_n72240016)
print v(xbgr.mr_n72240128)
print v(xbgr.mr_n72240448)
print v(xbgr.mr_n72240560)
print v(xbgr.mr_n72240880)
print v(xbgr.mr_n72240992)
print v(xbgr.mr_n72241312)
print v(xbgr.mr_n72241424)
print v(xbgr.mr_n72241744)
print v(xbgr.mr_n72241856)
print v(xbgr.mr_n72242176)
print v(xbgr.mr_n72242288)
print v(xbgr.mr_n72242608)
print v(xbgr.mr_n72242720)
print v(xbgr.mr_n72243040)
print v(xbgr.mr_n72243152)
print v(xbgr.mr_n72243472)
print v(xbgr.mr_n72243584)
print v(xbgr.mr_n72243904)
print v(xbgr.mr_n72244016)
print v(xbgr.mr_n72244336)
print v(xbgr.mr_n72244448)
print v(xbgr.mr_n72244768)
print v(xbgr.mr_n72244880)
print v(xbgr.mr_n72245200)
print v(xbgr.mr_n72245312)
print v(xbgr.mr_n72245632)
print v(xbgr.mr_n72245744)
print v(xbgr.mr_n72246064)
print v(xbgr.mr_n72246176)
print v(xbgr.mr_n72246496)
print v(xbgr.mr_n72246608)
print v(xbgr.mr_n72246928)
print v(xbgr.mr_n72247040)
print v(xbgr.mr_n72247360)
print v(xbgr.mr_n72247472)
print v(xbgr.mr_n72247792)
print v(xbgr.mr_n72247904)
print v(xbgr.mr_n72248224)
print v(xbgr.mr_n72248336)
print v(xbgr.mr_n72248656)
print v(xbgr.mr_n72248768)
print v(xbgr.mr_n72249088)
print v(xbgr.mr_n72249200)
print v(xbgr.mr_n72249520)
print v(xbgr.mr_n72249632)
print v(xbgr.mr_n72249952)
print v(xbgr.mr_n72250064)
print v(xbgr.mr_n72250384)
print v(xbgr.mr_n72250496)
print v(xbgr.mr_n72250816)
print v(xbgr.mr_n72250928)
print v(xbgr.mr_n72251248)
print v(xbgr.mr_n72251360)
print v(xbgr.mr_n72251680)
print v(xbgr.mr_n72251792)
print v(xbgr.mr_n72252112)
print v(xbgr.mr_n72252224)
print v(xbgr.mr_n72252544)
print v(xbgr.mr_n72252656)
print v(xbgr.mr_n72252976)
print v(xbgr.mr_n72253088)
print v(xbgr.mr_n72253408)
print v(xbgr.mr_n72253520)
print v(xbgr.mr_n72253840)
print v(xbgr.mr_n72253952)
print v(xbgr.mr_n72254272)
print v(xbgr.mr_n72254384)
print v(xbgr.mr_n72254704)
print v(xbgr.mr_n72254816)
print v(xbgr.mr_n72255248)
print v(xbgr.mr_n72255568)
print v(xbgr.mr_n72255680)
print v(xbgr.mr_n72256112)
print v(xbgr.mr_n72256432)
print v(xbgr.mr_n72256544)
print v(xbgr.mr_n72256976)
print v(xbgr.mr_n72257296)
print v(xbgr.mr_n72258160)
print v(xbgr.mr_n72259024)
print v(xbgr.mr_n72259136)
print v(xbgr.mr_n72259456)
print v(xbgr.mr_n72259568)
print v(xbgr.mr_n72259888)
print v(xbgr.mr_n72260000)
print v(xbgr.mr_n72260320)
print v(xbgr.mr_n72260432)
print v(xbgr.mr_n72260752)
print v(xbgr.mr_n72260864)
print v(xbgr.mr_n72261184)
print v(xbgr.mr_n72261296)
print v(xbgr.mr_n72261616)
print v(xbgr.mr_n72262480)
print v(xbgr.mr_n72263344)
print v(xbgr.mr_n72264208)
print v(xbgr.mr_n72264320)
print v(xbgr.mr_n72264640)
print v(xbgr.mr_n72264752)
print v(xbgr.mr_n72265072)
print v(xbgr.mr_n72265184)
print v(xbgr.mr_n72265504)
print v(xbgr.mr_n72265616)
print v(xbgr.mr_n72265936)
print v(xbgr.mr_n72266800)
print v(xbgr.mr_n72267664)
print v(xbgr.mr_n72267776)
print v(xbgr.mr_n72268096)
print v(xbgr.mr_n72268208)
print v(xbgr.mr_n72268528)
print v(xbgr.mr_n72268640)
print v(xbgr.mr_n72268960)
print v(xbgr.mr_n72269072)
print v(xbgr.mr_n72269392)
print v(xbgr.mr_n72269504)
print v(xbgr.mr_n72269824)
print v(xbgr.mr_n72269936)
print v(xbgr.mr_n72270256)
print v(xbgr.mr_n72271120)
print v(xbgr.mr_n72271232)
print v(xbgr.mr_n72271664)
print v(xbgr.mr_n72271984)
print v(xbgr.mr_n72272096)
print v(xbgr.mr_n72272528)
print v(xbgr.mr_n72272848)
print v(xbgr.mr_n72272960)
print v(xbgr.mr_n72273392)
print v(xbgr.mr_n72273712)
print v(xbgr.mr_n72274576)
print v(xbgr.mr_n72275440)
print v(xbgr.mr_n72276304)
print v(xbgr.mr_n72277168)
print v(xbgr.mr_n72278032)
print v(xbgr.mr_n72278896)
print v(xbgr.mr_n72279008)
print v(xbgr.mr_n72279328)
print v(xbgr.mr_n72279440)
print v(xbgr.mr_n72279760)
print v(xbgr.mr_n72279872)
print v(xbgr.mr_n72280192)
print v(xbgr.mr_n72280304)
print v(xbgr.mr_n72280624)
print v(xbgr.mr_n72281488)
print v(xbgr.mr_n72282352)
print v(xbgr.mr_n72283216)
print v(xbgr.mr_n72284080)
print v(xbgr.mr_n72284192)
print v(xbgr.mr_n72284624)
print v(xbgr.mr_n72284944)
print v(xbgr.mr_n72285056)
print v(xbgr.mr_n72285488)
print v(xbgr.mr_n72285808)
print v(xbgr.mr_n72285920)
print v(xbgr.mr_n72286352)
print v(xbgr.mr_n72286672)
print v(xbgr.mr_n72287536)
print v(xbgr.mr_n72288400)
print v(xbgr.mr_n72289264)
print v(xbgr.mr_n72290128)
print v(xbgr.mr_n72290992)
print v(xbgr.mr_n72291856)
print v(xbgr.mr_n72291968)
print v(xbgr.mr_n72292288)
print v(xbgr.mr_n72292400)
print v(xbgr.mr_n72292720)
print v(xbgr.mr_n72292832)
print v(xbgr.mr_n72293152)
print v(xbgr.mr_n72293264)
print v(xbgr.mr_n72293584)
print v(xbgr.mr_n72294448)
print v(xbgr.mr_n72295312)
print v(xbgr.mr_n72296176)
print v(xbgr.mr_n72296288)
print v(xbgr.mr_n72296608)
print v(xbgr.mr_n72296720)
print v(xbgr.mr_n72297040)
print v(xbgr.mr_n72297152)
print v(xbgr.mr_n72297584)
print v(xbgr.mr_n72298016)
print v(xbgr.mr_n72298448)
print v(xbgr.mr_n72298768)
print v(xbgr.mr_n72298880)
print v(xbgr.mr_n72299200)
print v(xbgr.mr_n72299312)
print v(xbgr.mr_n72299632)
print v(xbgr.mr_n72299744)
print v(xbgr.mr_n72300064)
print v(xbgr.mr_n72300176)
print v(xbgr.mr_n72300496)
print v(xbgr.mr_n72300608)
print v(xbgr.mr_n72300928)
print v(xbgr.mr_n72301040)
print v(xbgr.mr_n72301360)
print v(xbgr.mr_n72301472)
print v(xbgr.mr_n72301904)
print v(xbgr.mr_n72302224)
print v(xbgr.mr_n72302656)
print v(xbgr.mr_n72302768)
print v(xbgr.mr_n72303088)
print v(xbgr.mr_n72303200)
print v(xbgr.mr_n72303520)
print v(xbgr.mr_n72303632)
print v(xbgr.mr_n72303952)
print v(xbgr.mr_n72304064)
print v(xbgr.mr_n72304384)
print v(xbgr.mr_n72304496)
print v(xbgr.mr_n72304816)
print v(xbgr.mr_n72304928)
print v(xbgr.mr_n72305248)
print v(xbgr.mr_n72305360)
print v(xbgr.mr_n72305792)
print v(xbgr.mr_n72306112)
print v(xbgr.mr_n72306224)
print v(xbgr.mr_n72306656)
print v(xbgr.mr_n72306976)
print v(xbgr.mr_n72307088)
print v(xbgr.mr_n72307408)
print v(xbgr.mr_n72307520)
print v(xbgr.mr_n72307840)
print v(xbgr.mr_n72307952)
print v(xbgr.mr_n72308384)
print v(xbgr.mr_n72308816)
print v(xbgr.mr_n72309136)
print v(xbgr.mr_n72309248)
print v(xbgr.mr_n72309568)
print v(xbgr.mr_n72309680)
print v(xbgr.mr_n72310000)
print v(xbgr.mr_n72310112)
print v(xbgr.mr_n72310432)
print v(xbgr.mr_n72310544)
print v(xbgr.mr_n72310864)
print v(xbgr.mr_n72310976)
print v(xbgr.mr_n72311296)
print v(xbgr.mr_n72311408)
print v(xbgr.mr_n72311728)
print v(xbgr.mr_n72311840)
print v(xbgr.mr_n72312160)
print v(xbgr.mr_n72312272)
print v(xbgr.mr_n72312592)
print v(xbgr.mr_n72312704)
print v(xbgr.mr_n72313024)
print v(xbgr.mr_n72313136)
print v(xbgr.mr_n72313456)
print v(xbgr.mr_n72313568)
print v(xbgr.mr_n72313888)
print v(xbgr.mr_n72314752)
print v(xbgr.mr_n72315616)
print v(xbgr.mr_n72315728)
print v(xbgr.mr_n72316160)
print v(xbgr.mr_n72316480)
print v(xbgr.mr_n72316592)
print v(xbgr.mr_n72317344)
print v(xbgr.mr_n72317776)
print v(xbgr.mr_n72317888)
print v(xbgr.mr_n72318208)
print v(xbgr.mr_n72318320)
print v(xbgr.mr_n72318640)
print v(xbgr.mr_n72318752)
print v(xbgr.mr_n72319072)
print v(xbgr.mr_n72319184)
print v(xbgr.mr_n72319504)
print v(xbgr.mr_n72320368)
print v(xbgr.mr_n72320800)
print v(xbgr.mr_n72320912)
print v(xbgr.mr_n72321232)
print v(xbgr.mr_n72321344)
print v(xbgr.mr_n72321664)
print v(xbgr.mr_n72322528)
print v(xbgr.mr_n72323824)
print v(xbgr.mr_n72324688)
print v(xbgr.mr_n72325552)
print v(xbgr.mr_n72325664)
print v(xbgr.mr_n72326416)
print v(xbgr.mr_n72326528)
print v(xbgr.mr_n72326960)
print v(xbgr.mr_n72327392)
print v(xbgr.mr_n72328144)
print v(xbgr.mr_n72329008)
print v(xbgr.mr_n72329872)
print v(xbgr.mr_n72329984)
print v(xbgr.mr_n72330304)
print v(xbgr.mr_n72330416)
print v(xbgr.mr_n72330848)
print v(xbgr.mr_n72331168)
print v(xbgr.mr_n72331280)
print v(xbgr.mr_n72331712)
print v(xbgr.mr_n72332032)
print v(xbgr.mr_n72332144)
print v(xbgr.mr_n72332464)
print v(xbgr.mr_n72332576)
print v(xbgr.mr_n72332896)
print v(xbgr.mr_n72333760)
print v(xbgr.mr_n72333872)
print v(xbgr.mr_n72334304)
print v(xbgr.mr_n72334624)
print v(xbgr.mr_n72335600)
print v(xbgr.mr_n72335920)
print v(xbgr.mr_n72336032)
print v(xbgr.mr_n72336464)
print v(xbgr.mr_n72336784)
print v(xbgr.mr_n72337216)
print v(xbgr.mr_n72337328)
print v(xbgr.mr_n72337648)
print v(xbgr.mr_n72337760)
print v(xbgr.mr_n72338080)
print v(xbgr.mr_n72338512)
print v(xbgr.mr_n72338624)
print v(xbgr.mr_n72338944)
print v(xbgr.mr_n72339056)
print v(xbgr.mr_n72339376)
print v(xbgr.mr_n72339488)
print v(xbgr.mr_n72339808)
print v(xbgr.mr_n72339920)
print v(xbgr.mr_n72340240)
print v(xbgr.mr_n72340352)
print v(xbgr.mr_n72340784)
print v(xbgr.mr_n72341104)
print v(xbgr.mr_n72341216)
print v(xbgr.mr_n72341536)
print v(xbgr.mr_n72341648)
print v(xbgr.mr_n72341968)
print v(xbgr.mr_n72342512)
print v(xbgr.mr_n72343264)
print v(xbgr.mr_n72344560)
print v(xbgr.mr_n72344672)
print v(xbgr.mr_n72344992)
print v(xbgr.mr_n72345104)
print v(xbgr.mr_n72345424)
print v(xbgr.mr_n72346288)
print v(xbgr.mr_n72347152)
print v(xbgr.mr_n72348016)
print v(xbgr.mr_n72348128)
print v(xbgr.mr_n72348448)
print v(xbgr.mr_n72348560)
print v(xbgr.mr_n72348880)
print v(xbgr.mr_n72348992)
print v(xbgr.mr_n72349312)
print v(xbgr.mr_n72349424)
print v(xbgr.mr_n72349744)
print v(xbgr.mr_n72349856)
print v(xbgr.mr_n72350176)
print v(xbgr.mr_n72351040)
print v(xbgr.mr_n72351904)
print v(xbgr.mr_n72352768)
print v(xbgr.mr_n72352880)
print v(xbgr.mr_n72353200)
print v(xbgr.mr_n72353312)
print v(xbgr.mr_n72353632)
print v(xbgr.mr_n72353744)
print v(xbgr.mr_n72354064)
print v(xbgr.mr_n72354176)
print v(xbgr.mr_n72354608)
print v(xbgr.mr_n72354928)
print v(xbgr.mr_n72355040)
print v(xbgr.mr_n72355360)
print v(xbgr.mr_n72355472)
print v(xbgr.mr_n72355792)
print v(xbgr.mr_n72355904)
print v(xbgr.mr_n72356224)
print v(xbgr.mr_n72356336)
print v(xbgr.mr_n72357088)
print v(xbgr.mr_n72357632)
print v(xbgr.mr_n72358064)
print v(xbgr.mr_n72358496)
print v(xbgr.mr_n72358928)
print v(xbgr.mr_n72359248)
print v(xbgr.mr_n72359360)
print v(xbgr.mr_n72360112)
print v(xbgr.mr_n72360976)
print v(xbgr.mr_n72361840)
print v(xbgr.mr_n72362704)
print v(xbgr.mr_n72363568)
print v(xbgr.mr_n72364432)
print v(xbgr.mr_n72365296)
print v(xbgr.mr_n72365408)
print v(xbgr.mr_n72365728)
print v(xbgr.mr_n72365840)
print v(xbgr.mr_n72366272)
print v(xbgr.mr_n72366592)
print v(xbgr.mr_n72366704)
print v(xbgr.mr_n72367136)
print v(xbgr.mr_n72367456)
print v(xbgr.mr_n72367568)
print v(xbgr.mr_n72367888)
print v(xbgr.mr_n72368000)
print v(xbgr.mr_n72368320)
print v(xbgr.mr_n72368432)
print v(xbgr.mr_n72368752)
print v(xbgr.mr_n72368864)
print v(xbgr.mr_n72369184)
print v(xbgr.mr_n72369296)
print v(xbgr.mr_n72369616)
print v(xbgr.mr_n72369728)
print v(xbgr.mr_n72370048)
print v(xbgr.mr_n72370912)
print v(xbgr.mr_n72371344)
print v(xbgr.mr_n72372320)
print v(xbgr.mr_n72372752)
print v(xbgr.mr_n72373184)
print v(xbgr.mr_n72373616)
print v(xbgr.mr_n72373936)
print v(xbgr.mr_n72374800)
print v(xbgr.mr_n72375664)
print v(xbgr.mr_n72376528)
print v(xbgr.mr_n72377392)
print v(xbgr.mr_n72378256)
print v(xbgr.mr_n72379120)
print v(xbgr.mr_n72380416)
print v(xbgr.mr_n72380848)
print v(xbgr.mr_n72382144)
print v(xbgr.mr_n72382256)
print v(xbgr.mr_n72382576)
print v(xbgr.mr_n72382688)
print v(xbgr.mr_n72383008)
print v(xbgr.mr_n72383120)
print v(xbgr.mr_n72383552)
print v(xbgr.mr_n72383984)
print v(xbgr.mr_n72384304)
print v(xbgr.mr_n72384416)
print v(xbgr.mr_n72384736)
print v(xbgr.mr_n72384848)
print v(xbgr.mr_n72385168)
print v(xbgr.mr_n72385280)
print v(xbgr.mr_n72385600)
print v(xbgr.mr_n72385712)
print v(xbgr.mr_n72386144)
print v(xbgr.mr_n72386464)
print v(xbgr.mr_n72387328)
print v(xbgr.mr_n72387440)
print v(xbgr.mr_n72387760)
print v(xbgr.mr_n72387872)
print v(xbgr.mr_n72388192)
print v(xbgr.mr_n72388304)
print v(xbgr.mr_n72388624)
print v(xbgr.mr_n72388736)
print v(xbgr.mr_n72389056)
print v(xbgr.mr_n72389920)
print v(xbgr.mr_n72390352)
print v(xbgr.mr_n72391648)
print v(xbgr.mr_n72391760)
print v(xbgr.mr_n72392080)
print v(xbgr.mr_n72392192)
print v(xbgr.mr_n72392512)
print v(xbgr.mr_n72392624)
print v(xbgr.mr_n72392944)
print v(xbgr.mr_n72393808)
print v(xbgr.mr_n72393920)
print v(xbgr.mr_n72394352)
print v(xbgr.mr_n72394672)
print v(xbgr.mr_n72394784)
print v(xbgr.mr_n72395104)
print v(xbgr.mr_n72395216)
print v(xbgr.mr_n72395536)
print v(xbgr.mr_n72395648)
print v(xbgr.mr_n72395968)
print v(xbgr.mr_n72396080)
print v(xbgr.mr_n72396512)
print v(xbgr.mr_n72396832)
print v(xbgr.mr_n72397696)
print v(xbgr.mr_n72397808)
print v(xbgr.mr_n72398128)
print v(xbgr.mr_n72398992)
print v(xbgr.mr_n72399104)
print v(xbgr.mr_n72399424)
print v(xbgr.mr_n72399536)
print v(xbgr.mr_n72399856)
print v(xbgr.mr_n72400400)
print v(xbgr.mr_n72400832)
print v(xbgr.mr_n72401152)
print v(xbgr.mr_n72401584)
print v(xbgr.mr_n72401696)
print v(xbgr.mr_n72402016)
print v(xbgr.mr_n72402128)
print v(xbgr.mr_n72402448)
print v(xbgr.mr_n72402560)
print v(xbgr.mr_n72402880)
print v(xbgr.mr_n72402992)
print v(xbgr.mr_n72403312)
print v(xbgr.mr_n72403424)
print v(xbgr.mr_n72404176)
print v(xbgr.mr_n72404288)
print v(xbgr.mr_n72404608)
print v(xbgr.mr_n72404720)
print v(xbgr.mr_n72405040)
print v(xbgr.mr_n72406336)
print v(xbgr.mr_n72406448)
print v(xbgr.mr_n72406768)
print v(xbgr.mr_n72406880)
print v(xbgr.mr_n72407200)
print v(xbgr.mr_n72408176)
print v(xbgr.mr_n72408496)
print v(xbgr.mr_n72409360)
print v(xbgr.mr_n72409792)
print v(xbgr.mr_n72409904)
print v(xbgr.mr_n72410224)
print v(xbgr.mr_n72410336)
print v(xbgr.mr_n72410656)
print v(xbgr.mr_n72410768)
print v(xbgr.mr_n72411088)
print v(xbgr.mr_n72411952)
print v(xbgr.mr_n72413248)
print v(xbgr.mr_n72414112)
print v(xbgr.mr_n72415088)
print v(xbgr.mr_n72415408)
print v(xbgr.mr_n72415520)
print v(xbgr.mr_n72415952)
print v(xbgr.mr_n72416272)
print v(xbgr.mr_n72416384)
print v(xbgr.mr_n72416704)
print v(xbgr.mr_n72416816)
print v(xbgr.mr_n72417136)
print v(xbgr.mr_n72417248)
print v(xbgr.mr_n72417568)
print v(xbgr.mr_n72417680)
print v(xbgr.mr_n72418000)
print v(xbgr.mr_n72418112)
print v(xbgr.mr_n72418432)
print v(xbgr.mr_n72418544)
print v(xbgr.mr_n72418864)
print v(xbgr.mr_n72418976)
print v(xbgr.mr_n72419296)
print v(xbgr.mr_n72419408)
print v(xbgr.mr_n72419840)
print v(xbgr.mr_n72420160)
print v(xbgr.mr_n72420272)
print v(xbgr.mr_n72420704)
print v(xbgr.mr_n72421024)
print v(xbgr.mr_n72421888)
print v(xbgr.mr_n72422752)
print v(xbgr.mr_n72423616)
print v(xbgr.mr_n72423728)
print v(xbgr.mr_n72424048)
print v(xbgr.mr_n72424160)
print v(xbgr.mr_n72424480)
print v(xbgr.mr_n72424592)
print v(xbgr.mr_n72424912)
print v(xbgr.mr_n72425024)
print v(xbgr.mr_n72425456)
print v(xbgr.mr_n72425888)
print v(xbgr.mr_n72426320)
print v(xbgr.mr_n72426752)
print v(xbgr.mr_n72427072)
print v(xbgr.mr_n72427184)
print v(xbgr.mr_n72427504)
print v(xbgr.mr_n72427616)
print v(xbgr.mr_n72427936)
print v(xbgr.mr_n72428048)
print v(xbgr.mr_n72428368)
print v(xbgr.mr_n72428480)
print v(xbgr.mr_n72428800)
print v(xbgr.mr_n72428912)
print v(xbgr.mr_n72429232)
print v(xbgr.mr_n72429344)
print v(xbgr.mr_n72429664)
print v(xbgr.mr_n72429776)
print v(xbgr.mr_n72430208)
print v(xbgr.mr_n72430528)
print v(xbgr.mr_n72430640)
print v(xbgr.mr_n72430960)
print v(xbgr.mr_n72431824)
print v(xbgr.mr_n72432560)
print v(xbgr.mr_n72433424)
print v(xbgr.mr_n72434288)
print v(xbgr.mr_n72435152)
print v(xbgr.mr_n72436016)
print v(xbgr.mr_n72436128)
print v(xbgr.mr_n72436560)
print v(xbgr.mr_n72436880)
print v(xbgr.mr_n72436992)
print v(xbgr.mr_n72437424)
print v(xbgr.mr_n72437744)
print v(xbgr.mr_n72437856)
print v(xbgr.mr_n72438176)
print v(xbgr.mr_n72438288)
print v(xbgr.mr_n72438608)
print v(xbgr.mr_n72438720)
print v(xbgr.mr_n72439152)
print v(xbgr.mr_n72439472)
print v(xbgr.mr_n72440336)
print v(xbgr.mr_n72440448)
print v(xbgr.mr_n72440768)
print v(xbgr.mr_n72440880)
print v(xbgr.mr_n72441200)
print v(xbgr.mr_n72441312)
print v(xbgr.mr_n72441632)
print v(xbgr.mr_n72441744)
print v(xbgr.mr_n72442064)
print v(xbgr.mr_n72442176)
print v(xbgr.mr_n72442496)
print v(xbgr.mr_n72442608)
print v(xbgr.mr_n72442928)
print v(xbgr.mr_n72443040)
print v(xbgr.mr_n72443360)
print v(xbgr.mr_n72443792)
print v(xbgr.mr_n72443904)
print v(xbgr.mr_n72444224)
print v(xbgr.mr_n72444336)
print v(xbgr.mr_n72444656)
print v(xbgr.mr_n72444768)
print v(xbgr.mr_n72445088)
print v(xbgr.mr_n72445200)
print v(xbgr.mr_n72445520)
print v(xbgr.mr_n72446816)
print v(xbgr.mr_n72447680)
print v(xbgr.mr_n72448224)
print v(xbgr.mr_n72448656)
print v(xbgr.mr_n72448976)
print v(xbgr.mr_n72449088)
print v(xbgr.mr_n72449408)
print v(xbgr.mr_n72449520)
print v(xbgr.mr_n72449840)
print v(xbgr.mr_n72449952)
print v(xbgr.mr_n72450272)
print v(xbgr.mr_n72450384)
print v(xbgr.mr_n72450704)
print v(xbgr.mr_n72450816)
print v(xbgr.mr_n72451136)
print v(xbgr.mr_n72451248)
print v(xbgr.mr_n72451568)
print v(xbgr.mr_n72451680)
print v(xbgr.mr_n72452000)
print v(xbgr.mr_n72452112)
print v(xbgr.mr_n72452432)
print v(xbgr.mr_n72452544)
print v(xbgr.mr_n72452864)
print v(xbgr.mr_n72453728)
print v(xbgr.mr_n72454592)
print v(xbgr.mr_n72454704)
print v(xbgr.mr_n72455136)
print v(xbgr.mr_n72455888)
print v(xbgr.mr_n72456752)
print v(xbgr.mr_n72457616)
print v(xbgr.mr_n72458592)
print v(xbgr.mr_n72459024)
print v(xbgr.mr_n72459344)
print v(xbgr.mr_n72459456)
print v(xbgr.mr_n72459776)
print v(xbgr.mr_n72459888)
print v(xbgr.mr_n72460208)
print v(xbgr.mr_n72461072)
print v(xbgr.mr_n72461936)
print v(xbgr.mr_n72462048)
print v(xbgr.mr_n72462368)
print v(xbgr.mr_n72462480)
print v(xbgr.mr_n72462800)
print v(xbgr.mr_n72462912)
print v(xbgr.mr_n72463232)
print v(xbgr.mr_n72463344)
print v(xbgr.mr_n72463664)
print v(xbgr.mr_n72463776)
print v(xbgr.mr_n72464096)
print v(xbgr.mr_n72464208)
print v(xbgr.mr_n72464528)
print v(xbgr.mr_n72464640)
print v(xbgr.mr_n72464960)
print v(xbgr.mr_n72465072)
print v(xbgr.mr_n72465392)
print v(xbgr.mr_n72465504)
print v(xbgr.mr_n72465936)
print v(xbgr.mr_n72466256)
print v(xbgr.mr_n72466688)
print v(xbgr.mr_n72466800)
print v(xbgr.mr_n72467552)
print v(xbgr.mr_n72467664)
print v(xbgr.mr_n72468096)
print v(xbgr.mr_n72468848)
print v(xbgr.mr_n72468960)
print v(xbgr.mr_n72469280)
print v(xbgr.mr_n72469392)
print v(xbgr.mr_n72469824)
print v(xbgr.mr_n72470256)
print v(xbgr.mr_n72470688)
print v(xbgr.mr_n72471008)
print v(xbgr.mr_n72471120)
print v(xbgr.mr_n72471440)
print v(xbgr.mr_n72471552)
print v(xbgr.mr_n72471984)
print v(xbgr.mr_n72472304)
print v(xbgr.mr_n72473168)
print v(xbgr.mr_n72473280)
print v(xbgr.mr_n72473600)
print v(xbgr.mr_n72473712)
print v(xbgr.mr_n72474032)
print v(xbgr.mr_n72474144)
print v(xbgr.mr_n72474464)
print v(xbgr.mr_n72474576)
print v(xbgr.mr_n72474896)
print v(xbgr.mr_n72475008)
print v(xbgr.mr_n72475328)
print v(xbgr.mr_n72475440)
print v(xbgr.mr_n72475760)
print v(xbgr.mr_n72476624)
print v(xbgr.mr_n72477488)
print v(xbgr.mr_n72477600)
print v(xbgr.mr_n72477920)
print v(xbgr.mr_n72478032)
print v(xbgr.mr_n72478352)
print v(xbgr.mr_n72478464)
print v(xbgr.mr_n72478784)
print v(xbgr.mr_n72478896)
print v(xbgr.mr_n72479216)
print v(xbgr.mr_n72480080)
print v(xbgr.mr_n72480944)
print v(xbgr.mr_n72481808)
print v(xbgr.mr_n72482672)
print v(xbgr.mr_n72484080)
print v(xbgr.mr_n72484400)
print v(xbgr.mr_n72485264)
print v(xbgr.mr_n72486128)
print v(xbgr.mr_n72486240)
print v(xbgr.mr_n72486672)
print v(xbgr.mr_n72486992)
print v(xbgr.mr_n72487104)
print v(xbgr.mr_n72487536)
print v(xbgr.mr_n72487856)
print v(xbgr.mr_n72488720)
print v(xbgr.mr_n72489584)
print v(xbgr.mr_n72490448)
print v(xbgr.mr_n72491312)
print v(xbgr.mr_n72491424)
print v(xbgr.mr_n72491744)
print v(xbgr.mr_n72491856)
print v(xbgr.mr_n72492176)
print v(xbgr.mr_n72492288)
print v(xbgr.mr_n72492608)
print v(xbgr.mr_n72492720)
print v(xbgr.mr_n72493040)
print v(xbgr.mr_n72493904)
print v(xbgr.mr_n72494768)
print v(xbgr.mr_n72494880)
print v(xbgr.mr_n72495200)
print v(xbgr.mr_n72495312)
print v(xbgr.mr_n72495744)
print v(xbgr.mr_n72496176)
print v(xbgr.mr_n72496496)
print v(xbgr.mr_n72496608)
print v(xbgr.mr_n72496928)
print v(xbgr.mr_n72497040)
print v(xbgr.mr_n72497360)
print v(xbgr.mr_n72497472)
print v(xbgr.mr_n72497792)
print v(xbgr.mr_n72497904)
print v(xbgr.mr_n72498224)
print v(xbgr.mr_n72498336)
print v(xbgr.mr_n72498768)
print v(xbgr.mr_n72499088)
print v(xbgr.mr_n72499200)
print v(xbgr.mr_n72499632)
print v(xbgr.mr_n72499952)
print v(xbgr.mr_n72500816)
print v(xbgr.mr_n72501680)
print v(xbgr.mr_n72502544)
print v(xbgr.mr_n72503408)
print v(xbgr.mr_n72503520)
print v(xbgr.mr_n72503840)
print v(xbgr.mr_n72503952)
print v(xbgr.mr_n72504272)
print v(xbgr.mr_n72504384)
print v(xbgr.mr_n72504704)
print v(xbgr.mr_n72504816)
print v(xbgr.mr_n72505136)
print v(xbgr.mr_n72506000)
print v(xbgr.mr_n72506864)
print v(xbgr.mr_n72506976)
print v(xbgr.mr_n72507296)
print v(xbgr.mr_n72507408)
print v(xbgr.mr_n72507840)
print v(xbgr.mr_n72508272)
print v(xbgr.mr_n72508592)
print v(xbgr.mr_n72508704)
print v(xbgr.mr_n72509024)
print v(xbgr.mr_n72509136)
print v(xbgr.mr_n72509456)
print v(xbgr.mr_n72509568)
print v(xbgr.mr_n72509888)
print v(xbgr.mr_n72510000)
print v(xbgr.mr_n72510320)
print v(xbgr.mr_n72510432)
print v(xbgr.mr_n72510864)
print v(xbgr.mr_n72511184)
print v(xbgr.mr_n72511296)
print v(xbgr.mr_n72511728)
print v(xbgr.mr_n72512048)
print v(xbgr.mr_n72512160)
print v(xbgr.mr_n72512592)
print v(xbgr.mr_n72512912)
print v(xbgr.mr_n72513024)
print v(xbgr.mr_n72513456)
print v(xbgr.mr_n72513776)
print v(xbgr.mr_n72514640)
print v(xbgr.mr_n72515504)
print v(xbgr.mr_n72516368)
print v(xbgr.mr_n72517232)
print v(xbgr.mr_n72518096)
print v(xbgr.mr_n72518960)
print v(xbgr.mr_n72519072)
print v(xbgr.mr_n72519392)
print v(xbgr.mr_n72519504)
print v(xbgr.mr_n72519824)
print v(xbgr.mr_n72519936)
print v(xbgr.mr_n72520256)
print v(xbgr.mr_n72520368)
print v(xbgr.mr_n72520688)
print v(xbgr.mr_n72520800)
print v(xbgr.mr_n72521120)
print v(xbgr.mr_n72521232)
print v(xbgr.mr_n72521552)
print v(xbgr.mr_n72521664)
print v(xbgr.mr_n72521984)
print v(xbgr.mr_n72522096)
print v(xbgr.mr_n72522416)
print v(xbgr.mr_n72522528)
print v(xbgr.mr_n72522848)
print v(xbgr.mr_n72522960)
print v(xbgr.mr_n72523392)
print v(xbgr.mr_n72523824)
print v(xbgr.mr_n72524144)
print v(xbgr.mr_n72525008)
print v(xbgr.mr_n72525872)
print v(xbgr.mr_n72525984)
print v(xbgr.mr_n72526304)
print v(xbgr.mr_n72526416)
print v(xbgr.mr_n72526736)
print v(xbgr.mr_n72526848)
print v(xbgr.mr_n72527168)
print v(xbgr.mr_n72527280)
print v(xbgr.mr_n72527600)
print v(xbgr.mr_n72527712)
print v(xbgr.mr_n72528032)
print v(xbgr.mr_n72528144)
print v(xbgr.mr_n72528464)
print v(xbgr.mr_n72528576)
print v(xbgr.mr_n72528896)
print v(xbgr.mr_n72529008)
print v(xbgr.mr_n72529440)
print v(xbgr.mr_n72529872)
print v(xbgr.mr_n72530192)
print v(xbgr.mr_n72530304)
print v(xbgr.mr_n72530624)
print v(xbgr.mr_n72530736)
print v(xbgr.mr_n72531056)
print v(xbgr.mr_n72531168)
print v(xbgr.mr_n72531488)
print v(xbgr.mr_n72531600)
print v(xbgr.mr_n72531920)
print v(xbgr.mr_n72532032)
print v(xbgr.mr_n72532352)
print v(xbgr.mr_n72532464)
print v(xbgr.mr_n72532784)
print v(xbgr.mr_n72533648)
print v(xbgr.mr_n72534512)
print v(xbgr.mr_n72535376)
print v(xbgr.mr_n72536240)
print v(xbgr.mr_n72536352)
print v(xbgr.mr_n72536784)
print v(xbgr.mr_n72537104)
print v(xbgr.mr_n72537216)
print v(xbgr.mr_n72537536)
print v(xbgr.mr_n72537648)
print v(xbgr.mr_n72537968)
print v(xbgr.mr_n72538080)
print v(xbgr.mr_n72538400)
print v(xbgr.mr_n72538512)
print v(xbgr.mr_n72538832)
print v(xbgr.mr_n72538944)
print v(xbgr.mr_n72539264)
print v(xbgr.mr_n72539376)
print v(xbgr.mr_n72539696)
print v(xbgr.mr_n72539808)
print v(xbgr.mr_n72540240)
print v(xbgr.mr_n72540560)
print v(xbgr.mr_n72541424)
print v(xbgr.mr_n72541536)
print v(xbgr.mr_n72541856)
print v(xbgr.mr_n72541968)
print v(xbgr.mr_n72542288)
print v(xbgr.mr_n72542400)
print v(xbgr.mr_n72542720)
print v(xbgr.mr_n72542832)
print v(xbgr.mr_n72543152)
print v(xbgr.mr_n72543264)
print v(xbgr.mr_n72543696)
print v(xbgr.mr_n72544016)
print v(xbgr.mr_n72544128)
print v(xbgr.mr_n72544560)
print v(xbgr.mr_n72544880)
print v(xbgr.mr_n72545744)
print v(xbgr.mr_n72546608)
print v(xbgr.mr_n72547472)
print v(xbgr.mr_n72548336)
print v(xbgr.mr_n72548448)
print v(xbgr.mr_n72548768)
print v(xbgr.mr_n72548880)
print v(xbgr.mr_n72549200)
print v(xbgr.mr_n72549312)
print v(xbgr.mr_n72549632)
print v(xbgr.mr_n72549744)
print v(xbgr.mr_n72550064)
print v(xbgr.mr_n72550176)
print v(xbgr.mr_n72550496)
print v(xbgr.mr_n72550608)
print v(xbgr.mr_n72550928)
print v(xbgr.mr_n72551792)
print v(xbgr.mr_n72552656)
print v(xbgr.mr_n72552768)
print v(xbgr.mr_n72553088)
print v(xbgr.mr_n72553200)
print v(xbgr.mr_n72553632)
print v(xbgr.mr_n72554064)
print v(xbgr.mr_n72554384)
print v(xbgr.mr_n72554496)
print v(xbgr.mr_n72554816)
print v(xbgr.mr_n72554928)
print v(xbgr.mr_n72555248)
print v(xbgr.mr_n72555360)
print v(xbgr.mr_n72555680)
print v(xbgr.mr_n72555792)
print v(xbgr.mr_n72556112)
print v(xbgr.mr_n72556976)
print v(xbgr.mr_n72557840)
print v(xbgr.mr_n72558704)
print v(xbgr.mr_n72559568)
print v(xbgr.mr_n72560432)
print v(xbgr.mr_n72560544)
print v(xbgr.mr_n72560864)
print v(xbgr.mr_n72560976)
print v(xbgr.mr_n72561296)
print v(xbgr.mr_n72561408)
print v(xbgr.mr_n72561728)
print v(xbgr.mr_n72561840)
print v(xbgr.mr_n72562160)
print v(xbgr.mr_n72562272)
print v(xbgr.mr_n72562704)
print v(xbgr.mr_n72563024)
print v(xbgr.mr_n72563136)
print v(xbgr.mr_n72563568)
print v(xbgr.mr_n72563888)
print v(xbgr.mr_n72564000)
print v(xbgr.mr_n72564432)
print v(xbgr.mr_n72564752)
print v(xbgr.mr_n72564864)
print v(xbgr.mr_n72565296)
print v(xbgr.mr_n72565616)
print v(xbgr.mr_n72566480)
print v(xbgr.mr_n72566592)
print v(xbgr.mr_n72566912)
print v(xbgr.mr_n72567024)
print v(xbgr.mr_n72567344)
print v(xbgr.mr_n72567456)
print v(xbgr.mr_n72567776)
print v(xbgr.mr_n72567888)
print v(xbgr.mr_n72568208)
print v(xbgr.mr_n72569072)
print v(xbgr.mr_n72569936)
print v(xbgr.mr_n72570800)
print v(xbgr.mr_n72571664)
print v(xbgr.mr_n72572528)
print v(xbgr.mr_n72572640)
print v(xbgr.mr_n72572960)
print v(xbgr.mr_n72573072)
print v(xbgr.mr_n72573392)
print v(xbgr.mr_n72573504)
print v(xbgr.mr_n72573824)
print v(xbgr.mr_n72573936)
print v(xbgr.mr_n72574368)
print v(xbgr.mr_n72574800)
print v(xbgr.mr_n72575120)
print v(xbgr.mr_n72575232)
print v(xbgr.mr_n72575552)
print v(xbgr.mr_n72575664)
print v(xbgr.mr_n72575984)
print v(xbgr.mr_n72576848)
print v(xbgr.mr_n72576960)
print v(xbgr.mr_n72577280)
print v(xbgr.mr_n72577392)
print v(xbgr.mr_n72577712)
print v(xbgr.mr_n72578576)
print v(xbgr.mr_n72579440)
print v(xbgr.mr_n72579552)
print v(xbgr.mr_n72579872)
print v(xbgr.mr_n72579984)
print v(xbgr.mr_n72580304)
print v(xbgr.mr_n72581168)
print v(xbgr.mr_n72582032)
print v(xbgr.mr_n72582896)
print v(xbgr.mr_n72583008)
print v(xbgr.mr_n72583328)
print v(xbgr.mr_n72583440)
print v(xbgr.mr_n72583760)
print v(xbgr.mr_n72583872)
print v(xbgr.mr_n72584192)
print v(xbgr.mr_n72584304)
print v(xbgr.mr_n72584624)
print v(xbgr.mr_n72584736)
print v(xbgr.mr_n72585056)
print v(xbgr.mr_n72585168)
print v(xbgr.mr_n72585488)
print v(xbgr.mr_n72585600)
print v(xbgr.mr_n72585920)
print v(xbgr.mr_n72586032)
print v(xbgr.mr_n72586352)
print v(xbgr.mr_n72586464)
print v(xbgr.mr_n72586784)
print v(xbgr.mr_n72586896)
print v(xbgr.mr_n72587216)
print v(xbgr.mr_n72587328)
print v(xbgr.mr_n72587648)
print v(xbgr.mr_n72587760)
print v(xbgr.mr_n72588192)
print v(xbgr.mr_n72588512)
print v(xbgr.mr_n72588624)
print v(xbgr.mr_n72589056)
print v(xbgr.mr_n72589376)
print v(xbgr.mr_n72589488)
print v(xbgr.mr_n72589920)
print v(xbgr.mr_n72590240)
print v(xbgr.mr_n72591104)
print v(xbgr.mr_n72591968)
print v(xbgr.mr_n72592832)
print v(xbgr.mr_n72592944)
print v(xbgr.mr_n72593264)
print v(xbgr.mr_n72593376)
print v(xbgr.mr_n72593696)
print v(xbgr.mr_n72594560)
print v(xbgr.mr_n72595424)
print v(xbgr.mr_n72596288)
print v(xbgr.mr_n72596400)
print v(xbgr.mr_n72596720)
print v(xbgr.mr_n72596832)
print v(xbgr.mr_n72597152)
print v(xbgr.mr_n72597264)
print v(xbgr.mr_n72597584)
print v(xbgr.mr_n72597696)
print v(xbgr.mr_n72598016)
print v(xbgr.mr_n72598128)
print v(xbgr.mr_n72598448)
print v(xbgr.mr_n72598560)
print v(xbgr.mr_n72598880)
print v(xbgr.mr_n72598992)
print v(xbgr.mr_n72599312)
print v(xbgr.mr_n72599424)
print v(xbgr.mr_n72599744)
print v(xbgr.mr_n72599856)
print v(xbgr.mr_n72600176)
print v(xbgr.mr_n72600288)
print v(xbgr.mr_n72600608)
print v(xbgr.mr_n72600720)
print v(xbgr.mr_n72601040)
print v(xbgr.mr_n72601152)
print v(xbgr.mr_n72601472)
print v(xbgr.mr_n72601584)
print v(xbgr.mr_n72602016)
print v(xbgr.mr_n72602336)
print v(xbgr.mr_n72603200)
print v(xbgr.mr_n72604064)
print v(xbgr.mr_n72604928)
print v(xbgr.mr_n72605040)
print v(xbgr.mr_n72605472)
print v(xbgr.mr_n72605792)
print v(xbgr.mr_n72605904)
print v(xbgr.mr_n72606336)
print v(xbgr.mr_n72606656)
print v(xbgr.mr_n72606768)
print v(xbgr.mr_n72607088)
print v(xbgr.mr_n72607200)
print v(xbgr.mr_n72607520)
print v(xbgr.mr_n72607632)
print v(xbgr.mr_n72608064)
print v(xbgr.mr_n72608496)
print v(xbgr.mr_n72608928)
print v(xbgr.mr_n72609248)
print v(xbgr.mr_n72610112)
print v(xbgr.mr_n72610976)
print v(xbgr.mr_n72611840)
print v(xbgr.mr_n72612704)
print v(xbgr.mr_n72613568)
print v(xbgr.mr_n72614432)
print v(xbgr.mr_n72614544)
print v(xbgr.mr_n72614864)
print v(xbgr.mr_n72614976)
print v(xbgr.mr_n72615296)
print v(xbgr.mr_n72615408)
print v(xbgr.mr_n72615728)
print v(xbgr.mr_n72615840)
print v(xbgr.mr_n72616160)
print v(xbgr.mr_n72616272)
print v(xbgr.mr_n72616592)
print v(xbgr.mr_n72616704)
print v(xbgr.mr_n72617024)
print v(xbgr.mr_n72617888)
print v(xbgr.mr_n72618752)
print v(xbgr.mr_n72619728)
print v(xbgr.mr_n72620160)
print v(xbgr.mr_n72620592)
print v(xbgr.mr_n72620912)
print v(xbgr.mr_n72621024)
print v(xbgr.mr_n72621344)
print v(xbgr.mr_n72621456)
print v(xbgr.mr_n72621776)
print v(xbgr.mr_n72621888)
print v(xbgr.mr_n72622320)
print v(xbgr.mr_n72622640)
print v(xbgr.mr_n72622752)
print v(xbgr.mr_n72623072)
print v(xbgr.mr_n72623184)
print v(xbgr.mr_n72623616)
print v(xbgr.mr_n72623936)
print v(xbgr.mr_n72624048)
print v(xbgr.mr_n72624480)
print v(xbgr.mr_n72624800)
print v(xbgr.mr_n72624912)
print v(xbgr.mr_n72625344)
print v(xbgr.mr_n72625664)
print v(xbgr.mr_n72626528)
print v(xbgr.mr_n72627392)
print v(xbgr.mr_n72627504)
print v(xbgr.mr_n72627824)
print v(xbgr.mr_n72627936)
print v(xbgr.mr_n72628256)
print v(xbgr.mr_n72628368)
print v(xbgr.mr_n72628688)
print v(xbgr.mr_n72628800)
print v(xbgr.mr_n72629232)
print v(xbgr.mr_n72629552)
print v(xbgr.mr_n72630416)
print v(xbgr.mr_n72630528)
print v(xbgr.mr_n72630848)
print v(xbgr.mr_n72630960)
print v(xbgr.mr_n72631280)
print v(xbgr.mr_n72631392)
print v(xbgr.mr_n72631712)
print v(xbgr.mr_n72632576)
print v(xbgr.mr_n72633008)
print v(xbgr.mr_n72633872)
print v(xbgr.mr_n72633984)
print v(xbgr.mr_n72634304)
print v(xbgr.mr_n72634416)
print v(xbgr.mr_n72634736)
print v(xbgr.mr_n72634848)
print v(xbgr.mr_n72635168)
print v(xbgr.mr_n72635280)
print v(xbgr.mr_n72635600)
print v(xbgr.mr_n72635712)
print v(xbgr.mr_n72636144)
print v(xbgr.mr_n72636896)
print v(xbgr.mr_n72637760)
print v(xbgr.mr_n72638192)
print v(xbgr.mr_n72638304)
print v(xbgr.mr_n72638624)
print v(xbgr.mr_n72639056)
print v(xbgr.mr_n72639920)
print v(xbgr.mr_n72640784)
print v(xbgr.mr_n72641648)
print v(xbgr.mr_n72642512)
print v(xbgr.mr_n72643808)
print v(xbgr.mr_n72644672)
print v(xbgr.mr_n72645648)
print v(xbgr.mr_n72645968)
print v(xbgr.mr_n72646080)
print v(xbgr.mr_n72646512)
print v(xbgr.mr_n72646832)
print v(xbgr.mr_n72647696)
print v(xbgr.mr_n72647808)
print v(xbgr.mr_n72648128)
print v(xbgr.mr_n72648240)
print v(xbgr.mr_n72648672)
print v(xbgr.mr_n72648992)
print v(xbgr.mr_n72649104)
print v(xbgr.mr_n72649424)
print v(xbgr.mr_n72649536)
print v(xbgr.mr_n72649856)
print v(xbgr.mr_n72649968)
print v(xbgr.mr_n72650288)
print v(xbgr.mr_n72650400)
print v(xbgr.mr_n72650832)
print v(xbgr.mr_n72651152)
print v(xbgr.mr_n72651264)
print v(xbgr.mr_n72651584)
print v(xbgr.mr_n72651696)
print v(xbgr.mr_n72652016)
print v(xbgr.mr_n72652880)
print v(xbgr.mr_n72652992)
print v(xbgr.mr_n72653744)
print v(xbgr.mr_n72653856)
print v(xbgr.mr_n72654176)
print v(xbgr.mr_n72654288)
print v(xbgr.mr_n72654608)
print v(xbgr.mr_n72654720)
print v(xbgr.mr_n72655040)
print v(xbgr.mr_n72655152)
print v(xbgr.mr_n72655472)
print v(xbgr.mr_n72655584)
print v(xbgr.mr_n72655904)
print v(xbgr.mr_n72656016)
print v(xbgr.mr_n72656336)
print v(xbgr.mr_n72656448)
print v(xbgr.mr_n72656768)
print v(xbgr.mr_n72656880)
print v(xbgr.mr_n72657200)
print v(xbgr.mr_n72657312)
print v(xbgr.mr_n72657632)
print v(xbgr.mr_n72657744)
print v(xbgr.mr_n72658064)
print v(xbgr.mr_n72658176)
print v(xbgr.mr_n72658496)
print v(xbgr.mr_n72658608)
print v(xbgr.mr_n72658928)
print v(xbgr.mr_n72659040)
print v(xbgr.mr_n72659472)
print v(xbgr.mr_n72659792)
print v(xbgr.mr_n72659904)
print v(xbgr.mr_n72660336)
print v(xbgr.mr_n72660656)
print v(xbgr.mr_n72660768)
print v(xbgr.mr_n72661200)
print v(xbgr.mr_n72661520)
print v(xbgr.mr_n72662384)
print v(xbgr.mr_n72663248)
print v(xbgr.mr_n72664112)
print v(xbgr.mr_n72664976)
print v(xbgr.mr_n72665840)
print v(xbgr.mr_n72666704)
print v(xbgr.mr_n72666816)
print v(xbgr.mr_n72667136)
print v(xbgr.mr_n72667248)
print v(xbgr.mr_n72667568)
print v(xbgr.mr_n72667680)
print v(xbgr.mr_n72668000)
print v(xbgr.mr_n72668112)
print v(xbgr.mr_n72668432)
print v(xbgr.mr_n72669296)
print v(xbgr.mr_n72670160)
print v(xbgr.mr_n72671024)
print v(xbgr.mr_n72671136)
print v(xbgr.mr_n72671456)
print v(xbgr.mr_n72671568)
print v(xbgr.mr_n72671888)
print v(xbgr.mr_n72672000)
print v(xbgr.mr_n72672432)
print v(xbgr.mr_n72672864)
print v(xbgr.mr_n72673296)
print v(xbgr.mr_n72673616)
print v(xbgr.mr_n72673728)
print v(xbgr.mr_n72674048)
print v(xbgr.mr_n72674160)
print v(xbgr.mr_n72674480)
print v(xbgr.mr_n72674592)
print v(xbgr.mr_n72674912)
print v(xbgr.mr_n72675024)
print v(xbgr.mr_n72675344)
print v(xbgr.mr_n72675456)
print v(xbgr.mr_n72675776)
print v(xbgr.mr_n72675888)
print v(xbgr.mr_n72676208)
print v(xbgr.mr_n72676320)
print v(xbgr.mr_n72676752)
print v(xbgr.mr_n72677072)
print v(xbgr.mr_n72677184)
print v(xbgr.mr_n72677616)
print v(xbgr.mr_n72677936)
print v(xbgr.mr_n72678048)
print v(xbgr.mr_n72678480)
print v(xbgr.mr_n72678800)
print v(xbgr.mr_n72679664)
print v(xbgr.mr_n72680528)
print v(xbgr.mr_n72681392)
print v(xbgr.mr_n72682256)
print v(xbgr.mr_n72683120)
print v(xbgr.mr_n72683984)
print v(xbgr.mr_n72684096)
print v(xbgr.mr_n72684416)
print v(xbgr.mr_n72684528)
print v(xbgr.mr_n72684848)
print v(xbgr.mr_n72684960)
print v(xbgr.mr_n72685280)
print v(xbgr.mr_n72685392)
print v(xbgr.mr_n72685712)
print v(xbgr.mr_n72686576)
print v(xbgr.mr_n72687440)
print v(xbgr.mr_n72688304)
print v(xbgr.mr_n72688416)
print v(xbgr.mr_n72688736)
print v(xbgr.mr_n72688848)
print v(xbgr.mr_n72689168)
print v(xbgr.mr_n72689280)
print v(xbgr.mr_n72689712)
print v(xbgr.mr_n72690032)
print v(xbgr.mr_n72690144)
print v(xbgr.mr_n72690576)
print v(xbgr.mr_n72690896)
print v(xbgr.mr_n72691008)
print v(xbgr.mr_n72691440)
print v(xbgr.mr_n72691760)
print v(xbgr.mr_n72691872)
print v(xbgr.mr_n72692192)
print v(xbgr.mr_n72692304)
print v(xbgr.mr_n72692624)
print v(xbgr.mr_n72692736)
print v(xbgr.mr_n72693168)
print v(xbgr.mr_n72693488)
print v(xbgr.mr_n72694352)
print v(xbgr.mr_n72695216)
print v(xbgr.mr_n72696080)
print v(xbgr.mr_n72696192)
print v(xbgr.mr_n72696512)
print v(xbgr.mr_n72696624)
print v(xbgr.mr_n72696944)
print v(xbgr.mr_n72697808)
print v(xbgr.mr_n72698672)
print v(xbgr.mr_n72699536)
print v(xbgr.mr_n72700400)
print v(xbgr.mr_n72700512)
print v(xbgr.mr_n72700832)
print v(xbgr.mr_n72700944)
print v(xbgr.mr_n72701264)
print v(xbgr.mr_n72702128)
print v(xbgr.mr_n72702672)
print v(xbgr.mr_n72702992)
print v(xbgr.mr_n72703104)
print v(xbgr.mr_n72703424)
print v(xbgr.mr_n72703536)
print v(xbgr.mr_n72703856)
print v(xbgr.mr_n72703968)
print v(xbgr.mr_n72704288)
print v(xbgr.mr_n72704400)
print v(xbgr.mr_n72704832)
print v(xbgr.mr_n72705584)
print v(xbgr.mr_n72706448)
print v(xbgr.mr_n72707312)
print v(xbgr.mr_n72708176)
print v(xbgr.mr_n72708288)
print v(xbgr.mr_n72708608)
print v(xbgr.mr_n72708720)
print v(xbgr.mr_n72709040)
print v(xbgr.mr_n72709152)
print v(xbgr.mr_n72709472)
print v(xbgr.mr_n72709584)
print v(xbgr.mr_n72709904)
print v(xbgr.mr_n72710016)
print v(xbgr.mr_n72710336)
print v(xbgr.mr_n72710448)
print v(xbgr.mr_n72710768)
print v(xbgr.mr_n72710880)
print v(xbgr.mr_n72711312)
print v(xbgr.mr_n72711632)
print v(xbgr.mr_n72711744)
print v(xbgr.mr_n72712064)
print v(xbgr.mr_n72712176)
print v(xbgr.mr_n72712496)
print v(xbgr.mr_n72712608)
print v(xbgr.mr_n72712928)
print v(xbgr.mr_n72713040)
print v(xbgr.mr_n72713360)
print v(xbgr.mr_n72713472)
print v(xbgr.mr_n72713904)
print v(xbgr.mr_n72714224)
print v(xbgr.mr_n72715088)
print v(xbgr.mr_n72715200)
print v(xbgr.mr_n72715520)
print v(xbgr.mr_n72715632)
print v(xbgr.mr_n72716064)
print v(xbgr.mr_n72716496)
print v(xbgr.mr_n72716816)
print v(xbgr.mr_n72716928)
print v(xbgr.mr_n72717248)
print v(xbgr.mr_n72717360)
print v(xbgr.mr_n72717680)
print v(xbgr.mr_n72717792)
print v(xbgr.mr_n72718112)
print v(xbgr.mr_n72718224)
print v(xbgr.mr_n72718544)
print v(xbgr.mr_n72718656)
print v(xbgr.mr_n72719088)
print v(xbgr.mr_n72719408)
print v(xbgr.mr_n72719520)
print v(xbgr.mr_n72719952)
print v(xbgr.mr_n72720272)
print v(xbgr.mr_n72721136)
print v(xbgr.mr_n72722000)
print v(xbgr.mr_n72722864)
print v(xbgr.mr_n72723728)
print v(xbgr.mr_n72723840)
print v(xbgr.mr_n72724160)
print v(xbgr.mr_n72724272)
print v(xbgr.mr_n72724592)
print v(xbgr.mr_n72724704)
print v(xbgr.mr_n72725024)
print v(xbgr.mr_n72725136)
print v(xbgr.mr_n72725456)
print v(xbgr.mr_n72726320)
print v(xbgr.mr_n72727184)
print v(xbgr.mr_n72727296)
print v(xbgr.mr_n72727616)
print v(xbgr.mr_n72727728)
print v(xbgr.mr_n72728160)
print v(xbgr.mr_n72728592)
print v(xbgr.mr_n72728912)
print v(xbgr.mr_n72729024)
print v(xbgr.mr_n72729344)
print v(xbgr.mr_n72729456)
print v(xbgr.mr_n72729776)
print v(xbgr.mr_n72729888)
print v(xbgr.mr_n72730208)
print v(xbgr.mr_n72730320)
print v(xbgr.mr_n72730640)
print v(xbgr.mr_n72731504)
print v(xbgr.mr_n72732368)
print v(xbgr.mr_n72733232)
print v(xbgr.mr_n72734096)
print v(xbgr.mr_n72734960)
print v(xbgr.mr_n72735072)
print v(xbgr.mr_n72735504)
print v(xbgr.mr_n72735824)
print v(xbgr.mr_n72735936)
print v(xbgr.mr_n72736368)
print v(xbgr.mr_n72736688)
print v(xbgr.mr_n72736800)
print v(xbgr.mr_n72737232)
print v(xbgr.mr_n72737552)
print v(xbgr.mr_n72737664)
print v(xbgr.mr_n72737984)
print v(xbgr.mr_n72738096)
print v(xbgr.mr_n72738416)
print v(xbgr.mr_n72738528)
print v(xbgr.mr_n72738848)
print v(xbgr.mr_n72738960)
print v(xbgr.mr_n72739280)
print v(xbgr.mr_n72739392)
print v(xbgr.mr_n72739712)
print v(xbgr.mr_n72739824)
print v(xbgr.mr_n72740144)
print v(xbgr.mr_n72740256)
print v(xbgr.mr_n72740576)
print v(xbgr.mr_n72740688)
print v(xbgr.mr_n72741008)
print v(xbgr.mr_n72741120)
print v(xbgr.mr_n72741440)
print v(xbgr.mr_n72741552)
print v(xbgr.mr_n72741872)
print v(xbgr.mr_n72741984)
print v(xbgr.mr_n72742304)
print v(xbgr.mr_n72742416)
print v(xbgr.mr_n72742736)
print v(xbgr.mr_n72743600)
print v(xbgr.mr_n72744464)
print v(xbgr.mr_n72745328)
print v(xbgr.mr_n72745440)
print v(xbgr.mr_n72745872)
print v(xbgr.mr_n72746192)
print v(xbgr.mr_n72746304)
print v(xbgr.mr_n72746624)
print v(xbgr.mr_n72746736)
print v(xbgr.mr_n72747056)
print v(xbgr.mr_n72747168)
print v(xbgr.mr_n72747488)
print v(xbgr.mr_n72747600)
print v(xbgr.mr_n72748032)
print v(xbgr.mr_n72748464)
print v(xbgr.mr_n72748896)
print v(xbgr.mr_n72749328)
print v(xbgr.mr_n72749648)
print v(xbgr.mr_n72749760)
print v(xbgr.mr_n72750192)
print v(xbgr.mr_n72750512)
print v(xbgr.mr_n72751376)
print v(xbgr.mr_n72751488)
print v(xbgr.mr_n72751808)
print v(xbgr.mr_n72751920)
print v(xbgr.mr_n72752240)
print v(xbgr.mr_n72752352)
print v(xbgr.mr_n72752672)
print v(xbgr.mr_n72753648)
print v(xbgr.mr_n72754080)
print v(xbgr.mr_n72754512)
print v(xbgr.mr_n72754832)
print v(xbgr.mr_n72755696)
print v(xbgr.mr_n72755808)
print v(xbgr.mr_n72756128)
print v(xbgr.mr_n72756240)
print v(xbgr.mr_n72756560)
print v(xbgr.mr_n72756672)
print v(xbgr.mr_n72756992)
print v(xbgr.mr_n72757104)
print v(xbgr.mr_n72757424)
print v(xbgr.mr_n72757536)
print v(xbgr.mr_n72757856)
print v(xbgr.mr_n72757968)
print v(xbgr.mr_n72758288)
print v(xbgr.mr_n72758400)
print v(xbgr.mr_n72758720)
print v(xbgr.mr_n72758832)
print v(xbgr.mr_n72759152)
print v(xbgr.mr_n72760016)
print v(xbgr.mr_n72760880)
print v(xbgr.mr_n72761744)
print v(xbgr.mr_n72762608)
print v(xbgr.mr_n72763472)
print v(xbgr.mr_n72764336)
print v(xbgr.mr_n72765200)
print v(xbgr.mr_n72766064)
print v(xbgr.mr_n72766928)
print v(xbgr.mr_n72767792)
print v(xbgr.mr_n72768656)
print v(xbgr.mr_n72769520)
print v(xbgr.mr_n72769632)
print v(xbgr.mr_n72769952)
print v(xbgr.mr_n72770064)
print v(xbgr.mr_n72770384)
print v(xbgr.mr_n72770496)
print v(xbgr.mr_n72770816)
print v(xbgr.mr_n72770928)
print v(xbgr.mr_n72771248)
print v(xbgr.mr_n72771360)
print v(xbgr.mr_n72771792)
print v(xbgr.mr_n72772112)
print v(xbgr.mr_n72772224)
print v(xbgr.mr_n72772656)
print v(xbgr.mr_n72772976)
print v(xbgr.mr_n72773840)
print v(xbgr.mr_n72774704)
print v(xbgr.mr_n72775568)
print v(xbgr.mr_n72776432)
print v(xbgr.mr_n72776544)
print v(xbgr.mr_n72776864)
print v(xbgr.mr_n72776976)
print v(xbgr.mr_n72777296)
print v(xbgr.mr_n72777408)
print v(xbgr.mr_n72777728)
print v(xbgr.mr_n72777840)
print v(xbgr.mr_n72778160)
print v(xbgr.mr_n72778272)
print v(xbgr.mr_n72778592)
print v(xbgr.mr_n72778704)
print v(xbgr.mr_n72779024)
print v(xbgr.mr_n72779136)
print v(xbgr.mr_n72779456)
print v(xbgr.mr_n72780320)
print v(xbgr.mr_n72781184)
print v(xbgr.mr_n72781296)
print v(xbgr.mr_n72781616)
print v(xbgr.mr_n72781728)
print v(xbgr.mr_n72782160)
print v(xbgr.mr_n72782592)
print v(xbgr.mr_n72782912)
print v(xbgr.mr_n72783024)
print v(xbgr.mr_n72783344)
print v(xbgr.mr_n72783456)
print v(xbgr.mr_n72783776)
print v(xbgr.mr_n72783888)
print v(xbgr.mr_n72784208)
print v(xbgr.mr_n72784320)
print v(xbgr.mr_n72784640)
print v(xbgr.mr_n72784752)
print v(xbgr.mr_n72785184)
print v(xbgr.mr_n72785504)
print v(xbgr.mr_n72785616)
print v(xbgr.mr_n72786048)
print v(xbgr.mr_n72786368)
print v(xbgr.mr_n72786480)
print v(xbgr.mr_n72786800)
print v(xbgr.mr_n72787664)
print v(xbgr.mr_n72788528)
print v(xbgr.mr_n72789392)
print v(xbgr.mr_n72790256)
print v(xbgr.mr_n72790368)
print v(xbgr.mr_n72790688)
print v(xbgr.mr_n72790800)
print v(xbgr.mr_n72791120)
print v(xbgr.mr_n72791232)
print v(xbgr.mr_n72791552)
print v(xbgr.mr_n72791664)
print v(xbgr.mr_n72791984)
print v(xbgr.mr_n72792096)
print v(xbgr.mr_n72792416)
print v(xbgr.mr_n72792528)
print v(xbgr.mr_n72792848)
print v(xbgr.mr_n72793712)
print v(xbgr.mr_n72794576)
print v(xbgr.mr_n72794688)
print v(xbgr.mr_n72795120)
print v(xbgr.mr_n72795440)
print v(xbgr.mr_n72795552)
print v(xbgr.mr_n72795872)
print v(xbgr.mr_n72795984)
print v(xbgr.mr_n72796304)
print v(xbgr.mr_n72796416)
print v(xbgr.mr_n72796736)
print v(xbgr.mr_n72796848)
print v(xbgr.mr_n72797168)
print v(xbgr.mr_n72797280)
print v(xbgr.mr_n72797600)
print v(xbgr.mr_n72797712)
print v(xbgr.mr_n72798144)
print v(xbgr.mr_n72798576)
print v(xbgr.mr_n72799008)
print v(xbgr.mr_n72799440)
print v(xbgr.mr_n72799760)
print v(xbgr.mr_n72800192)
print v(xbgr.mr_n72800304)
print v(xbgr.mr_n72800624)
print v(xbgr.mr_n72800736)
print v(xbgr.mr_n72801056)
print v(xbgr.mr_n72801168)
print v(xbgr.mr_n72801488)
print v(xbgr.mr_n72801600)
print v(xbgr.mr_n72801920)
print v(xbgr.mr_n72802032)
print v(xbgr.mr_n72802352)
print v(xbgr.mr_n72802464)
print v(xbgr.mr_n72803216)
print v(xbgr.mr_n72803328)
print v(xbgr.mr_n72803760)
print v(xbgr.mr_n72804080)
print v(xbgr.mr_n72804512)
print v(xbgr.mr_n72804624)
print v(xbgr.mr_n72805056)
print v(xbgr.mr_n72805376)
print v(xbgr.mr_n72805488)
print v(xbgr.mr_n72805920)
print v(xbgr.mr_n72806240)
print v(xbgr.mr_n72806352)
print v(xbgr.mr_n72806784)
print v(xbgr.mr_n72807536)
print v(xbgr.mr_n72808400)
print v(xbgr.mr_n72809264)
print v(xbgr.mr_n72810128)
print v(xbgr.mr_n72810992)
print v(xbgr.mr_n72811856)
print v(xbgr.mr_n72811968)
print v(xbgr.mr_n72812288)
print v(xbgr.mr_n72812400)
print v(xbgr.mr_n72812720)
print v(xbgr.mr_n72812832)
print v(xbgr.mr_n72813152)
print v(xbgr.mr_n72813264)
print v(xbgr.mr_n72813584)
print v(xbgr.mr_n72814448)
print v(xbgr.mr_n72815312)
print v(xbgr.mr_n72816176)
print v(xbgr.mr_n72816288)
print v(xbgr.mr_n72816608)
print v(xbgr.mr_n72816720)
print v(xbgr.mr_n72817040)
print v(xbgr.mr_n72817152)
print v(xbgr.mr_n72817472)
print v(xbgr.mr_n72817584)
print v(xbgr.mr_n72817904)
print v(xbgr.mr_n72818016)
print v(xbgr.mr_n72818336)
print v(xbgr.mr_n72818448)
print v(xbgr.mr_n72818768)
print v(xbgr.mr_n72818880)
print v(xbgr.mr_n72819200)
print v(xbgr.mr_n72819312)
print v(xbgr.mr_n72819632)
print v(xbgr.mr_n72820496)
print v(xbgr.mr_n72820928)
print v(xbgr.mr_n72821792)
print v(xbgr.mr_n72822224)
print v(xbgr.mr_n72823088)
print v(xbgr.mr_n72823952)
print v(xbgr.mr_n72825248)
print v(xbgr.mr_n72826544)
print v(xbgr.mr_n72826656)
print v(xbgr.mr_n72826976)
print v(xbgr.mr_n72827088)
print v(xbgr.mr_n72827520)
print v(xbgr.mr_n72827840)
print v(xbgr.mr_n72827952)
print v(xbgr.mr_n72828384)
print v(xbgr.mr_n72828704)
print v(xbgr.mr_n72828816)
print v(xbgr.mr_n72829136)
print v(xbgr.mr_n72829248)
print v(xbgr.mr_n72829568)
print v(xbgr.mr_n72829680)
print v(xbgr.mr_n72830112)
print v(xbgr.mr_n72830432)
print v(xbgr.mr_n72830544)
print v(xbgr.mr_n72830976)
print v(xbgr.mr_n72831296)
print v(xbgr.mr_n72831408)
print v(xbgr.mr_n72831840)
print v(xbgr.mr_n72832160)
print v(xbgr.mr_n72832272)
print v(xbgr.mr_n72832592)
print v(xbgr.mr_n72833024)
print v(xbgr.mr_n72833136)
print v(xbgr.mr_n72833456)
print v(xbgr.mr_n72833568)
print v(xbgr.mr_n72833888)
print v(xbgr.mr_n72834000)
print v(xbgr.mr_n72834320)
print v(xbgr.mr_n72834432)
print v(xbgr.mr_n72835184)
print v(xbgr.mr_n72836048)
print v(xbgr.mr_n72836912)
print v(xbgr.mr_n72837024)
print v(xbgr.mr_n72837344)
print v(xbgr.mr_n72837456)
print v(xbgr.mr_n72837776)
print v(xbgr.mr_n72837888)
print v(xbgr.mr_n72838208)
print v(xbgr.mr_n72838320)
print v(xbgr.mr_n72839072)
print v(xbgr.mr_n72839504)
print v(xbgr.mr_n72840368)
print v(xbgr.mr_n72841664)
print v(xbgr.mr_n72842096)
print v(xbgr.mr_n72842960)
print v(xbgr.mr_n72843072)
print v(xbgr.mr_n72843392)
print v(xbgr.mr_n72843504)
print v(xbgr.mr_n72843824)
print v(xbgr.mr_n72844688)
print v(xbgr.mr_n72845120)
print v(xbgr.mr_n72845232)
print v(xbgr.mr_n72845552)
print v(xbgr.mr_n72846416)
print v(xbgr.mr_n72847280)
print v(xbgr.mr_n72848144)
print v(xbgr.mr_n72849008)
print v(xbgr.mr_n72849120)
print v(xbgr.mr_n72849440)
print v(xbgr.mr_n72849552)
print v(xbgr.mr_n72849872)
print v(xbgr.mr_n72849984)
print v(xbgr.mr_n72850304)
print v(xbgr.mr_n72850416)
print v(xbgr.mr_n72851168)
print v(xbgr.mr_n72852032)
print v(xbgr.mr_n72852896)
print v(xbgr.mr_n72853008)
print v(xbgr.mr_n72853440)
print v(xbgr.mr_n72853872)
print v(xbgr.mr_n72854304)
print v(xbgr.mr_n72854624)
print v(xbgr.mr_n72854736)
print v(xbgr.mr_n72855056)
print v(xbgr.mr_n72855168)
print v(xbgr.mr_n72855488)
print v(xbgr.mr_n72855600)
print v(xbgr.mr_n72855920)
print v(xbgr.mr_n72856032)
print v(xbgr.mr_n72856352)
print v(xbgr.mr_n72856464)
print v(xbgr.mr_n72856784)
print v(xbgr.mr_n72856896)
print v(xbgr.mr_n72857216)
print v(xbgr.mr_n72857328)
print v(xbgr.mr_n72857648)
print v(xbgr.mr_n72857760)
print v(xbgr.mr_n72858944)
print v(xbgr.mr_n72859488)
print v(xbgr.mr_n72859920)
print v(xbgr.mr_n72860352)
print v(xbgr.mr_n72861104)
print v(xbgr.mr_n72861216)
print v(xbgr.mr_n72861536)
print v(xbgr.mr_n72861648)
print v(xbgr.mr_n72861968)
print v(xbgr.mr_n72862080)
print v(xbgr.mr_n72862400)
print v(xbgr.mr_n72862512)
print v(xbgr.mr_n72862832)
print v(xbgr.mr_n72862944)
print v(xbgr.mr_n72863264)
print v(xbgr.mr_n72863376)
print v(xbgr.mr_n72863808)
print v(xbgr.mr_n72864128)
print v(xbgr.mr_n72864240)
print v(xbgr.mr_n72864560)
print v(xbgr.mr_n72864672)
print v(xbgr.mr_n72865104)
print v(xbgr.mr_n72865424)
print v(xbgr.mr_n72865536)
print v(xbgr.mr_n72865856)
print v(xbgr.mr_n72865968)
print v(xbgr.mr_n72866288)
print v(xbgr.mr_n72866400)
print v(xbgr.mr_n72866720)
print v(xbgr.mr_n72866832)
print v(xbgr.mr_n72867152)
print v(xbgr.mr_n72867264)
print v(xbgr.mr_n72867584)
print v(xbgr.mr_n72867696)
print v(xbgr.mr_n72868016)
print v(xbgr.mr_n72868880)
print v(xbgr.mr_n72869424)
print v(xbgr.mr_n72869744)
print v(xbgr.mr_n72869856)
print v(xbgr.mr_n72870288)
print v(xbgr.mr_n72870608)
print v(xbgr.mr_n72870720)
print v(xbgr.mr_n72871472)
print v(xbgr.mr_n72872336)
print v(xbgr.mr_n72872448)
print v(xbgr.mr_n72872768)
print v(xbgr.mr_n72872880)
print v(xbgr.mr_n72873200)
print v(xbgr.mr_n72873312)
print v(xbgr.mr_n72873632)
print v(xbgr.mr_n72874064)
print v(xbgr.mr_n72874928)
print v(xbgr.mr_n72876224)
print v(xbgr.mr_n72877200)
print v(xbgr.mr_n72877520)
print v(xbgr.mr_n72877632)
print v(xbgr.mr_n72877952)
print v(xbgr.mr_n72878064)
print v(xbgr.mr_n72878384)
print v(xbgr.mr_n72879248)
print v(xbgr.mr_n72879360)
print v(xbgr.mr_n72879680)
print v(xbgr.mr_n72879792)
print v(xbgr.mr_n72880112)
print v(xbgr.mr_n72880224)
print v(xbgr.mr_n72880544)
print v(xbgr.mr_n72880656)
print v(xbgr.mr_n72880976)
print v(xbgr.mr_n72881088)
print v(xbgr.mr_n72881408)
print v(xbgr.mr_n72881952)
print v(xbgr.mr_n72882272)
print v(xbgr.mr_n72883568)
print v(xbgr.mr_n72884432)
print v(xbgr.mr_n72884976)
print v(xbgr.mr_n72885408)
print v(xbgr.mr_n72886160)
print v(xbgr.mr_n72886272)
print v(xbgr.mr_n72886592)
print v(xbgr.mr_n72886704)
print v(xbgr.mr_n72887024)
print v(xbgr.mr_n72887136)
print v(xbgr.mr_n72887456)
print v(xbgr.mr_n72887568)
print v(xbgr.mr_n72887888)
print v(xbgr.mr_n72888000)
print v(xbgr.mr_n72888320)
print v(xbgr.mr_n72888432)
print v(xbgr.mr_n72888864)
print v(xbgr.mr_n72889184)
print v(xbgr.mr_n72889296)
print v(xbgr.mr_n72889616)
print v(xbgr.mr_n72889728)
print v(xbgr.mr_n72890048)
print v(xbgr.mr_n72890160)
print v(xbgr.mr_n72890480)
print v(xbgr.mr_n72890592)
print v(xbgr.mr_n72890912)
print v(xbgr.mr_n72891024)
print v(xbgr.mr_n72891344)
print v(xbgr.mr_n72891456)
print v(xbgr.mr_n72891776)
print v(xbgr.mr_n72891888)
print v(xbgr.mr_n72892208)
print v(xbgr.mr_n72892320)
print v(xbgr.mr_n72892752)
print v(xbgr.mr_n72893184)
print v(xbgr.mr_n72893616)
print v(xbgr.mr_n72893936)
print v(xbgr.mr_n72894048)
print v(xbgr.mr_n72894368)
print v(xbgr.mr_n72894480)
print v(xbgr.mr_n72894800)
print v(xbgr.mr_n72894912)
print v(xbgr.mr_n72895232)
print v(xbgr.mr_n72895344)
print v(xbgr.mr_n72895664)
print v(xbgr.mr_n72895776)
print v(xbgr.mr_n72896208)
print v(xbgr.mr_n72896528)
print v(xbgr.mr_n72897392)
print v(xbgr.mr_n72898256)
print v(xbgr.mr_n72898368)
print v(xbgr.mr_n72898688)
print v(xbgr.mr_n72898800)
print v(xbgr.mr_n72899120)
print v(xbgr.mr_n72899232)
print v(xbgr.mr_n72899552)
print v(xbgr.mr_n72899664)
print v(xbgr.mr_n72899984)
print v(xbgr.mr_n72900960)
print v(xbgr.mr_n72901280)
print v(xbgr.mr_n72901392)
print v(xbgr.mr_n72901712)
print v(xbgr.mr_n72901824)
print v(xbgr.mr_n72902144)
print v(xbgr.mr_n72902256)
print v(xbgr.mr_n72902576)
print v(xbgr.mr_n72902688)
print v(xbgr.mr_n72903008)
print v(xbgr.mr_n72903120)
print v(xbgr.mr_n72903440)
print v(xbgr.mr_n72904304)
print v(xbgr.mr_n72905168)
print v(xbgr.mr_n72906032)
print v(xbgr.mr_n72906896)
print v(xbgr.mr_n72907008)
print v(xbgr.mr_n72907328)
print v(xbgr.mr_n72907440)
print v(xbgr.mr_n72907760)
print v(xbgr.mr_n72908736)
print v(xbgr.mr_n72909168)
print v(xbgr.mr_n72909488)
print v(xbgr.mr_n72910352)
print v(xbgr.mr_n72911216)
print v(xbgr.mr_n72912080)
print v(xbgr.mr_n72912944)
print v(xbgr.mr_n72913056)
print v(xbgr.mr_n72913488)
print v(xbgr.mr_n72913808)
print v(xbgr.mr_n72913920)
print v(xbgr.mr_n72914240)
print v(xbgr.mr_n72914352)
print v(xbgr.mr_n72914672)
print v(xbgr.mr_n72914784)
print v(xbgr.mr_n72915216)
print v(xbgr.mr_n72915536)
print v(xbgr.mr_n72915648)
print v(xbgr.mr_n72916080)
print v(xbgr.mr_n72916400)
print v(xbgr.mr_n72916512)
print v(xbgr.mr_n72916832)
print v(xbgr.mr_n72916944)
print v(xbgr.mr_n72917264)
print v(xbgr.mr_n72917376)
print v(xbgr.mr_n72917696)
print v(xbgr.mr_n72917808)
print v(xbgr.mr_n72918128)
print v(xbgr.mr_n72918240)
print v(xbgr.mr_n72918560)
print v(xbgr.mr_n72918672)
print v(xbgr.mr_n72919104)
print v(xbgr.mr_n72919424)
print v(xbgr.mr_n72920288)
print v(xbgr.mr_n72920832)
print v(xbgr.mr_n72921152)
print v(xbgr.mr_n72921264)
print v(xbgr.mr_n72921584)
print v(xbgr.mr_n72921696)
print v(xbgr.mr_n72922016)
print v(xbgr.mr_n72922128)
print v(xbgr.mr_n72922448)
print v(xbgr.mr_n72922560)
print v(xbgr.mr_n72922880)
print v(xbgr.mr_n72922992)
print v(xbgr.mr_n72923312)
print v(xbgr.mr_n72923424)
print v(xbgr.mr_n72923856)
print v(xbgr.mr_n72924176)
print v(xbgr.mr_n72925040)
print v(xbgr.mr_n72925472)
print v(xbgr.mr_n72926336)
print v(xbgr.mr_n72927200)
print v(xbgr.mr_n72928608)
print v(xbgr.mr_n72929472)
print v(xbgr.mr_n72929904)
print v(xbgr.mr_n72930224)
print v(xbgr.mr_n72931088)
print v(xbgr.mr_n72931200)
print v(xbgr.mr_n72931520)
print v(xbgr.mr_n72931632)
print v(xbgr.mr_n72931952)
print v(xbgr.mr_n72932064)
print v(xbgr.mr_n72932384)
print v(xbgr.mr_n72932496)
print v(xbgr.mr_n72932816)
print v(xbgr.mr_n72932928)
print v(xbgr.mr_n72933248)
print v(xbgr.mr_n72933360)
print v(xbgr.mr_n72933680)
print v(xbgr.mr_n72933792)
print v(xbgr.mr_n72934112)
print v(xbgr.mr_n72934976)
print v(xbgr.mr_n72935952)
print v(xbgr.mr_n72936384)
print v(xbgr.mr_n72936816)
print v(xbgr.mr_n72937136)
print v(xbgr.mr_n72937248)
print v(xbgr.mr_n72937568)
print v(xbgr.mr_n72937680)
print v(xbgr.mr_n72938000)
print v(xbgr.mr_n72938864)
print v(xbgr.mr_n72939728)
print v(xbgr.mr_n72940592)
print v(xbgr.mr_n72940704)
print v(xbgr.mr_n72941024)
print v(xbgr.mr_n72941136)
print v(xbgr.mr_n72941456)
print v(xbgr.mr_n72942320)
print v(xbgr.mr_n72943184)
print v(xbgr.mr_n72944048)
print v(xbgr.mr_n72944160)
print v(xbgr.mr_n72944480)
print v(xbgr.mr_n72944592)
print v(xbgr.mr_n72944912)
print v(xbgr.mr_n72945024)
print v(xbgr.mr_n72945344)
print v(xbgr.mr_n72945456)
print v(xbgr.mr_n72945776)
print v(xbgr.mr_n72946640)
print v(xbgr.mr_n72947504)
print v(xbgr.mr_n72947616)
print v(xbgr.mr_n72947936)
print v(xbgr.mr_n72948048)
print v(xbgr.mr_n72948368)
print v(xbgr.mr_n72948480)
print v(xbgr.mr_n72948800)
print v(xbgr.mr_n72948912)
print v(xbgr.mr_n72949232)
print v(xbgr.mr_n72949344)
print v(xbgr.mr_n72949776)
print v(xbgr.mr_n72950096)
print v(xbgr.mr_n72950208)
print v(xbgr.mr_n72950528)
print v(xbgr.mr_n72950640)
print v(xbgr.mr_n72950960)
print v(xbgr.mr_n72951072)
print v(xbgr.mr_n72951392)
print v(xbgr.mr_n72951504)
print v(xbgr.mr_n72951824)
print v(xbgr.mr_n72952688)
print v(xbgr.mr_n72952800)
print v(xbgr.mr_n72953232)
print v(xbgr.mr_n72953552)
print v(xbgr.mr_n72953664)
print v(xbgr.mr_n72953984)
print v(xbgr.mr_n72954096)
print v(xbgr.mr_n72954416)
print v(xbgr.mr_n72954528)
print v(xbgr.mr_n72954848)
print v(xbgr.mr_n72954960)
print v(xbgr.mr_n72955280)
print v(xbgr.mr_n72955392)
print v(xbgr.mr_n72955712)
print v(xbgr.mr_n72955824)
print v(xbgr.mr_n72956144)
print v(xbgr.mr_n72956576)
print v(xbgr.mr_n72956688)
print v(xbgr.mr_n72957008)
print v(xbgr.mr_n72957552)
print v(xbgr.mr_n72957872)
print v(xbgr.mr_n72957984)
print v(xbgr.mr_n72958416)
print v(xbgr.mr_n72958848)
print v(xbgr.mr_n72959280)
print v(xbgr.mr_n72959712)
print v(xbgr.mr_n72960144)
print v(xbgr.mr_n72960464)
print v(xbgr.mr_n72960576)
print v(xbgr.mr_n72961008)
print v(xbgr.mr_n72961328)
print v(xbgr.mr_n72961440)
print v(xbgr.mr_n72961872)
print v(xbgr.mr_n72962192)
print v(xbgr.mr_n72963056)
print v(xbgr.mr_n72964352)
print v(xbgr.mr_n72964896)
print v(xbgr.mr_n72965216)
print v(xbgr.mr_n72965760)
print v(xbgr.mr_n72966080)
print v(xbgr.mr_n72966192)
print v(xbgr.mr_n72966944)
print v(xbgr.mr_n72967376)
print v(xbgr.mr_n72968240)
print v(xbgr.mr_n72969104)
print v(xbgr.mr_n72970400)
print v(xbgr.mr_n72971264)
print v(xbgr.mr_n72971696)
print v(xbgr.mr_n72971808)
print v(xbgr.mr_n72972560)
print v(xbgr.mr_n72972672)
print v(xbgr.mr_n72972992)
print v(xbgr.mr_n72973104)
print v(xbgr.mr_n72973424)
print v(xbgr.mr_n72973536)
print v(xbgr.mr_n72974288)
print v(xbgr.mr_n72975584)
print v(xbgr.mr_n72976448)
print v(xbgr.mr_n72977312)
print v(xbgr.mr_n72977744)
print v(xbgr.mr_n72977856)
print v(xbgr.mr_n72978176)
print v(xbgr.mr_n72978288)
print v(xbgr.mr_n72978608)
print v(xbgr.mr_n72978720)
print v(xbgr.mr_n72979040)
print v(xbgr.mr_n72979152)
print v(xbgr.mr_n72979904)
print v(xbgr.mr_n72980016)
print v(xbgr.mr_n72980336)
print v(xbgr.mr_n72980448)
print v(xbgr.mr_n72980768)
print v(xbgr.mr_n72980880)
print v(xbgr.mr_n72981200)
print v(xbgr.mr_n72982064)
print v(xbgr.mr_n72982176)
print v(xbgr.mr_n72982496)
print v(xbgr.mr_n72982608)
print v(xbgr.mr_n72983040)
print v(xbgr.mr_n72983360)
print v(xbgr.mr_n72983472)
print v(xbgr.mr_n72983792)
print v(xbgr.mr_n72983904)
print v(xbgr.mr_n72984224)
print v(xbgr.mr_n72984336)
print v(xbgr.mr_n72984768)
print v(xbgr.mr_n72985200)
print v(xbgr.mr_n72985520)
print v(xbgr.mr_n72985632)
print v(xbgr.mr_n72985952)
print v(xbgr.mr_n72986064)
print v(xbgr.mr_n72986384)
print v(xbgr.mr_n72986496)
print v(xbgr.mr_n72986928)
print v(xbgr.mr_n72987248)
print v(xbgr.mr_n72987360)
print v(xbgr.mr_n72987792)
print v(xbgr.mr_n72988112)
print v(xbgr.mr_n72988224)
print v(xbgr.mr_n72988544)
print v(xbgr.mr_n72988656)
print v(xbgr.mr_n72988976)
print v(xbgr.mr_n72989088)
print v(xbgr.mr_n72989408)
print v(xbgr.mr_n72989520)
print v(xbgr.mr_n72989840)
print v(xbgr.mr_n72990704)
print v(xbgr.mr_n72991568)
print v(xbgr.mr_n72991680)
print v(xbgr.mr_n72992000)
print v(xbgr.mr_n72992544)
print v(xbgr.mr_n72992864)
print v(xbgr.mr_n72993296)
print v(xbgr.mr_n72994592)
print v(xbgr.mr_n72995888)
print v(xbgr.mr_n72996000)
print v(xbgr.mr_n72996320)
print v(xbgr.mr_n72996432)
print v(xbgr.mr_n72996752)
print v(xbgr.mr_n72996864)
print v(xbgr.mr_n72997184)
print v(xbgr.mr_n72997296)
print v(xbgr.mr_n72997616)
print v(xbgr.mr_n72997728)
print v(xbgr.mr_n72998048)
print v(xbgr.mr_n72998160)
print v(xbgr.mr_n72998480)
print v(xbgr.mr_n72998592)
print v(xbgr.mr_n72999024)
print v(xbgr.mr_n72999344)
print v(xbgr.mr_n73000208)
print v(xbgr.mr_n73000320)
print v(xbgr.mr_n73000640)
print v(xbgr.mr_n73000752)
print v(xbgr.mr_n73001072)
print v(xbgr.mr_n73001184)
print v(xbgr.mr_n73001504)
print v(xbgr.mr_n73001616)
print v(xbgr.mr_n73001936)
print v(xbgr.mr_n73002800)
print v(xbgr.mr_n73003664)
print v(xbgr.mr_n73004528)
print v(xbgr.mr_n73005392)
print v(xbgr.mr_n73006256)
print v(xbgr.mr_n73006368)
print v(xbgr.mr_n73006688)
print v(xbgr.mr_n73006800)
print v(xbgr.mr_n73007120)
print v(xbgr.mr_n73007232)
print v(xbgr.mr_n73007552)
print v(xbgr.mr_n73007664)
print v(xbgr.mr_n73007984)
print v(xbgr.mr_n73008096)
print v(xbgr.mr_n73008416)
print v(xbgr.mr_n73008528)
print v(xbgr.mr_n73008848)
print v(xbgr.mr_n73008960)
print v(xbgr.mr_n73009280)
print v(xbgr.mr_n73009392)
print v(xbgr.mr_n73009712)
print v(xbgr.mr_n73009824)
print v(xbgr.mr_n73010144)
print v(xbgr.mr_n73010256)
print v(xbgr.mr_n73010688)
print v(xbgr.mr_n73011008)
print v(xbgr.mr_n73011120)
print v(xbgr.mr_n73011440)
print v(xbgr.mr_n73011552)
print v(xbgr.mr_n73011984)
print v(xbgr.mr_n73012304)
print v(xbgr.mr_n73012416)
print v(xbgr.mr_n73012848)
print v(xbgr.mr_n73013168)
print v(xbgr.mr_n73013280)
print v(xbgr.mr_n73013712)
print v(xbgr.mr_n73014144)
print v(xbgr.mr_n73014464)
print v(xbgr.mr_n73014576)
print v(xbgr.mr_n73015008)
print v(xbgr.mr_n73015328)
print v(xbgr.mr_n73015440)
print v(xbgr.mr_n73015760)
print v(xbgr.mr_n73015872)
print v(xbgr.mr_n73016192)
print v(xbgr.mr_n73016304)
print v(xbgr.mr_n73016624)
print v(xbgr.mr_n73016736)
print v(xbgr.mr_n73017056)
print v(xbgr.mr_n73017168)
print v(xbgr.mr_n73017488)
print v(xbgr.mr_n73017600)
print v(xbgr.mr_n73017920)
print v(xbgr.mr_n73018032)
print v(xbgr.mr_n73018352)
print v(xbgr.mr_n73018464)
print v(xbgr.mr_n73018784)
print v(xbgr.mr_n73019648)
print v(xbgr.mr_n73019760)
print v(xbgr.mr_n73020080)
print v(xbgr.mr_n73020192)
print v(xbgr.mr_n73020512)
print v(xbgr.mr_n73021376)
print v(xbgr.mr_n73022240)
print v(xbgr.mr_n73023104)
print v(xbgr.mr_n73023968)
print v(xbgr.mr_n73024832)
print v(xbgr.mr_n73024944)
print v(xbgr.mr_n73025264)
print v(xbgr.mr_n73025376)
print v(xbgr.mr_n73025696)
print v(xbgr.mr_n73025808)
print v(xbgr.mr_n73026128)
print v(xbgr.mr_n73026992)
print v(xbgr.mr_n73027856)
print v(xbgr.mr_n73028720)
print v(xbgr.mr_n73029584)
print v(xbgr.mr_n73030448)
print v(xbgr.mr_n73031312)
print v(xbgr.mr_n73032176)
print v(xbgr.mr_n73032288)
print v(xbgr.mr_n73032608)
print v(xbgr.mr_n73032720)
print v(xbgr.mr_n73033152)
print v(xbgr.mr_n73033472)
print v(xbgr.mr_n73034336)
print v(xbgr.mr_n73034880)
print v(xbgr.mr_n73035312)
print v(xbgr.mr_n73035744)
print v(xbgr.mr_n73036496)
print v(xbgr.mr_n73037360)
print v(xbgr.mr_n73038224)
print v(xbgr.mr_n73038336)
print v(xbgr.mr_n73038656)
print v(xbgr.mr_n73038768)
print v(xbgr.mr_n73039200)
print v(xbgr.mr_n73039632)
print v(xbgr.mr_n73039952)
print v(xbgr.mr_n73040816)
print v(xbgr.mr_n73040928)
print v(xbgr.mr_n73041360)
print v(xbgr.mr_n73041680)
print v(xbgr.mr_n73041792)
print v(xbgr.mr_n73042224)
print v(xbgr.mr_n73042544)
print v(xbgr.mr_n73043408)
print v(xbgr.mr_n73043520)
print v(xbgr.mr_n73043840)
print v(xbgr.mr_n73044704)
print v(xbgr.mr_n73045568)
print v(xbgr.mr_n73045680)
print v(xbgr.mr_n73046000)
print v(xbgr.mr_n73046112)
print v(xbgr.mr_n73046432)
print v(xbgr.mr_n73047296)
print v(xbgr.mr_n73047728)
print v(xbgr.mr_n73047840)
print v(xbgr.mr_n73048272)
print v(xbgr.mr_n73048592)
print v(xbgr.mr_n73048704)
print v(xbgr.mr_n73049136)
print v(xbgr.mr_n73049888)
print v(xbgr.mr_n73050000)
print v(xbgr.mr_n73050320)
print v(xbgr.mr_n73050432)
print v(xbgr.mr_n73050752)
print v(xbgr.mr_n73050864)
print v(xbgr.mr_n73051184)
print v(xbgr.mr_n73051616)
print v(xbgr.mr_n73051728)
print v(xbgr.mr_n73052480)
print v(xbgr.mr_n73052912)
print v(xbgr.mr_n73053024)
print v(xbgr.mr_n73053888)
print v(xbgr.mr_n73054208)
print v(xbgr.mr_n73054320)
print v(xbgr.mr_n73054640)
print v(xbgr.mr_n73055504)
print v(xbgr.mr_n73056368)
print v(xbgr.mr_n73057232)
print v(xbgr.mr_n73058096)
print v(xbgr.mr_n73058208)
print v(xbgr.mr_n73058528)
print v(xbgr.mr_n73058640)
print v(xbgr.mr_n73058960)
print v(xbgr.mr_n73059072)
print v(xbgr.mr_n73059392)
print v(xbgr.mr_n73059504)
print v(xbgr.mr_n73059824)
print v(xbgr.mr_n73059936)
print v(xbgr.mr_n73060256)
print v(xbgr.mr_n73060368)
print v(xbgr.mr_n73060688)
print v(xbgr.mr_n73060800)
print v(xbgr.mr_n73061120)
print v(xbgr.mr_n73061232)
print v(xbgr.mr_n73061552)
print v(xbgr.mr_n73061664)
print v(xbgr.mr_n73061984)
print v(xbgr.mr_n73062096)
print v(xbgr.mr_n73062528)
print v(xbgr.mr_n73062960)
print v(xbgr.mr_n73063392)
print v(xbgr.mr_n73063712)
print v(xbgr.mr_n73063824)
print v(xbgr.mr_n73064144)
print v(xbgr.mr_n73065008)
print v(xbgr.mr_n73065120)
print v(xbgr.mr_n73065440)
print v(xbgr.mr_n73065552)
print v(xbgr.mr_n73065872)
print v(xbgr.mr_n73065984)
print v(xbgr.mr_n73066416)
print v(xbgr.mr_n73066736)
print v(xbgr.mr_n73066848)
print v(xbgr.mr_n73067168)
print v(xbgr.mr_n73067280)
print v(xbgr.mr_n73067712)
print v(xbgr.mr_n73068032)
print v(xbgr.mr_n73068464)
print v(xbgr.mr_n73068576)
print v(xbgr.mr_n73068896)
print v(xbgr.mr_n73069008)
print v(xbgr.mr_n73069328)
print v(xbgr.mr_n73069440)
print v(xbgr.mr_n73069760)
print v(xbgr.mr_n73069872)
print v(xbgr.mr_n73070304)
print v(xbgr.mr_n73070624)
print v(xbgr.mr_n73070736)
print v(xbgr.mr_n73071056)
print v(xbgr.mr_n73071168)
print v(xbgr.mr_n73071488)
print v(xbgr.mr_n73071600)
print v(xbgr.mr_n73071920)
print v(xbgr.mr_n73072032)
print v(xbgr.mr_n73072352)
print v(xbgr.mr_n73072464)
print v(xbgr.mr_n73072784)
print v(xbgr.mr_n73072896)
print v(xbgr.mr_n73073216)
print v(xbgr.mr_n73073328)
print v(xbgr.mr_n73074080)
print v(xbgr.mr_n73074512)
print v(xbgr.mr_n73075376)
print v(xbgr.mr_n73075488)
print v(xbgr.mr_n73075808)
print v(xbgr.mr_n73076352)
print v(xbgr.mr_n73076784)
print v(xbgr.mr_n73077216)
print v(xbgr.mr_n73077536)
print v(xbgr.mr_n73077968)
print v(xbgr.mr_n73078832)
print v(xbgr.mr_n73080992)
print v(xbgr.mr_n73081856)
print v(xbgr.mr_n73081968)
print v(xbgr.mr_n73082288)
print v(xbgr.mr_n73083152)
print v(xbgr.mr_n73084016)
print v(xbgr.mr_n73084128)
print v(xbgr.mr_n73084448)
print v(xbgr.mr_n73084560)
print v(xbgr.mr_n73084880)
print v(xbgr.mr_n73084992)
print v(xbgr.mr_n73085312)
print v(xbgr.mr_n73085424)
print v(xbgr.mr_n73085744)
print v(xbgr.mr_n73086608)
print v(xbgr.mr_n73087472)
print v(xbgr.mr_n73087584)
print v(xbgr.mr_n73087904)
print v(xbgr.mr_n73088016)
print v(xbgr.mr_n73088336)
print v(xbgr.mr_n73088448)
print v(xbgr.mr_n73088768)
print v(xbgr.mr_n73088880)
print v(xbgr.mr_n73089200)
print v(xbgr.mr_n73089312)
print v(xbgr.mr_n73089632)
print v(xbgr.mr_n73089744)
print v(xbgr.mr_n73090064)
print v(xbgr.mr_n73090176)
print v(xbgr.mr_n73090608)
print v(xbgr.mr_n73090928)
print v(xbgr.mr_n73091040)
print v(xbgr.mr_n73091472)
print v(xbgr.mr_n73091792)
print v(xbgr.mr_n73092336)
print v(xbgr.mr_n73093200)
print v(xbgr.mr_n73093520)
print v(xbgr.mr_n73093632)
print v(xbgr.mr_n73094816)
print v(xbgr.mr_n73094928)
print v(xbgr.mr_n73095248)
print v(xbgr.mr_n73095360)
print v(xbgr.mr_n73095680)
print v(xbgr.mr_n73095792)
print v(xbgr.mr_n73096112)
print v(xbgr.mr_n73096224)
print v(xbgr.mr_n73096544)
print v(xbgr.mr_n73097408)
print v(xbgr.mr_n73098272)
print v(xbgr.mr_n73098384)
print v(xbgr.mr_n73098816)
print v(xbgr.mr_n73099248)
print v(xbgr.mr_n73099680)
print v(xbgr.mr_n73100000)
print v(xbgr.mr_n73100112)
print v(xbgr.mr_n73100432)
print v(xbgr.mr_n73100544)
print v(xbgr.mr_n73100864)
print v(xbgr.mr_n73100976)
print v(xbgr.mr_n73101296)
print v(xbgr.mr_n73101408)
print v(xbgr.mr_n73101728)
print v(xbgr.mr_n73101840)
print v(xbgr.mr_n73102160)
print v(xbgr.mr_n73102272)
print v(xbgr.mr_n73102592)
print v(xbgr.mr_n73103456)
print v(xbgr.mr_n73103568)
print v(xbgr.mr_n73103888)
print v(xbgr.mr_n73104000)
print v(xbgr.mr_n73104320)
print v(xbgr.mr_n73104432)
print v(xbgr.mr_n73104752)
print v(xbgr.mr_n73104864)
print v(xbgr.mr_n73105184)
print v(xbgr.mr_n73105728)
print v(xbgr.mr_n73106480)
print v(xbgr.mr_n73107344)
print v(xbgr.mr_n73108208)
print v(xbgr.mr_n73109072)
print v(xbgr.mr_n73109936)
print v(xbgr.mr_n73110800)
print v(xbgr.mr_n73110912)
print v(xbgr.mr_n73111232)
print v(xbgr.mr_n73111344)
print v(xbgr.mr_n73111664)
print v(xbgr.mr_n73111776)
print v(xbgr.mr_n73112096)
print v(xbgr.mr_n73112208)
print v(xbgr.mr_n73112528)
print v(xbgr.mr_n73112640)
print v(xbgr.mr_n73112960)
print v(xbgr.mr_n73113072)
print v(xbgr.mr_n73113392)
print v(xbgr.mr_n73114256)
print v(xbgr.mr_n73115120)
print v(xbgr.mr_n73115984)
print v(xbgr.mr_n73116848)
print v(xbgr.mr_n73117712)
print v(xbgr.mr_n73118576)
print v(xbgr.mr_n73119440)
print v(xbgr.mr_n73119552)
print v(xbgr.mr_n73119872)
print v(xbgr.mr_n73119984)
print v(xbgr.mr_n73120304)
print v(xbgr.mr_n73120416)
print v(xbgr.mr_n73120736)
print v(xbgr.mr_n73120848)
print v(xbgr.mr_n73121168)
print v(xbgr.mr_n73121280)
print v(xbgr.mr_n73121600)
print v(xbgr.mr_n73121712)
print v(xbgr.mr_n73122032)
print v(xbgr.mr_n73122144)
print v(xbgr.mr_n73122576)
print v(xbgr.mr_n73122896)
print v(xbgr.mr_n73123008)
print v(xbgr.mr_n73123440)
print v(xbgr.mr_n73123760)
print v(xbgr.mr_n73123872)
print v(xbgr.mr_n73124304)
print v(xbgr.mr_n73124624)
print v(xbgr.mr_n73125488)
print v(xbgr.mr_n73126352)
print v(xbgr.mr_n73127216)
print v(xbgr.mr_n73128080)
print v(xbgr.mr_n73128944)
print v(xbgr.mr_n73129808)
print v(xbgr.mr_n73129920)
print v(xbgr.mr_n73130240)
print v(xbgr.mr_n73130352)
print v(xbgr.mr_n73130672)
print v(xbgr.mr_n73130784)
print v(xbgr.mr_n73131104)
print v(xbgr.mr_n73131216)
print v(xbgr.mr_n73131536)
print v(xbgr.mr_n73132400)
print v(xbgr.mr_n73133264)
print v(xbgr.mr_n73134128)
print v(xbgr.mr_n73134240)
print v(xbgr.mr_n73134672)
print v(xbgr.mr_n73134992)
print v(xbgr.mr_n73135104)
print v(xbgr.mr_n73135424)
print v(xbgr.mr_n73135536)
print v(xbgr.mr_n73135856)
print v(xbgr.mr_n73135968)
print v(xbgr.mr_n73136288)
print v(xbgr.mr_n73136400)
print v(xbgr.mr_n73136720)
print v(xbgr.mr_n73136832)
print v(xbgr.mr_n73137264)
print v(xbgr.mr_n73137584)
print v(xbgr.mr_n73137696)
print v(xbgr.mr_n73138128)
print v(xbgr.mr_n73138448)
print v(xbgr.mr_n73138560)
print v(xbgr.mr_n73138880)
print v(xbgr.mr_n73138992)
print v(xbgr.mr_n73139424)
print v(xbgr.mr_n73139856)
print v(xbgr.mr_n73140176)
print v(xbgr.mr_n73140288)
print v(xbgr.mr_n73140720)
print v(xbgr.mr_n73141040)
print v(xbgr.mr_n73141152)
print v(xbgr.mr_n73141584)
print v(xbgr.mr_n73141904)
print v(xbgr.mr_n73142768)
print v(xbgr.mr_n73143632)
print v(xbgr.mr_n73144496)
print v(xbgr.mr_n73145360)
print v(xbgr.mr_n73145472)
print v(xbgr.mr_n73145792)
print v(xbgr.mr_n73145904)
print v(xbgr.mr_n73146224)
print v(xbgr.mr_n73146336)
print v(xbgr.mr_n73146656)
print v(xbgr.mr_n73146768)
print v(xbgr.mr_n73147088)
print v(xbgr.mr_n73147952)
print v(xbgr.mr_n73148816)
print v(xbgr.mr_n73149680)
print v(xbgr.mr_n73150544)
print v(xbgr.mr_n73151408)
print v(xbgr.mr_n73152272)
print v(xbgr.mr_n73153136)
print v(xbgr.mr_n73154000)
print v(xbgr.mr_n73154112)
print v(xbgr.mr_n73154432)
print v(xbgr.mr_n73154544)
print v(xbgr.mr_n73154864)
print v(xbgr.mr_n73154976)
print v(xbgr.mr_n73155296)
print v(xbgr.mr_n73155408)
print v(xbgr.mr_n73155728)
print v(xbgr.mr_n73155840)
print v(xbgr.mr_n73156160)
print v(xbgr.mr_n73156272)
print v(xbgr.mr_n73156592)
print v(xbgr.mr_n73156704)
print v(xbgr.mr_n73157024)
print v(xbgr.mr_n73157136)
print v(xbgr.mr_n73157456)
print v(xbgr.mr_n73157568)
print v(xbgr.mr_n73157888)
print v(xbgr.mr_n73158000)
print v(xbgr.mr_n73158432)
print v(xbgr.mr_n73158752)
print v(xbgr.mr_n73158864)
print v(xbgr.mr_n73159184)
print v(xbgr.mr_n73159296)
print v(xbgr.mr_n73159616)
print v(xbgr.mr_n73159728)
print v(xbgr.mr_n73160048)
print v(xbgr.mr_n73160160)
print v(xbgr.mr_n73160480)
print v(xbgr.mr_n73160592)
print v(xbgr.mr_n73161024)
print v(xbgr.mr_n73161344)
print v(xbgr.mr_n73161456)
print v(xbgr.mr_n73161888)
print v(xbgr.mr_n73162208)
print v(xbgr.mr_n73162320)
print v(xbgr.mr_n73162640)
print v(xbgr.mr_n73163504)
print v(xbgr.mr_n73164368)
print v(xbgr.mr_n73164912)
print v(xbgr.mr_n73165664)
print v(xbgr.mr_n73166096)
print v(xbgr.mr_n73166208)
print v(xbgr.mr_n73166960)
print v(xbgr.mr_n73167072)
print v(xbgr.mr_n73167504)
print v(xbgr.mr_n73167936)
print v(xbgr.mr_n73168256)
print v(xbgr.mr_n73169120)
print v(xbgr.mr_n73169552)
print v(xbgr.mr_n73170416)
print v(xbgr.mr_n73170528)
print v(xbgr.mr_n73171280)
print v(xbgr.mr_n73172576)
print v(xbgr.mr_n73173440)
print v(xbgr.mr_n73173552)
print v(xbgr.mr_n73173872)
print v(xbgr.mr_n73173984)
print v(xbgr.mr_n73174304)
print v(xbgr.mr_n73174416)
print v(xbgr.mr_n73174736)
print v(xbgr.mr_n73174848)
print v(xbgr.mr_n73175168)
print v(xbgr.mr_n73176032)
print v(xbgr.mr_n73176896)
print v(xbgr.mr_n73177760)
print v(xbgr.mr_n73177872)
print v(xbgr.mr_n73178192)
print v(xbgr.mr_n73178304)
print v(xbgr.mr_n73178624)
print v(xbgr.mr_n73179488)
print v(xbgr.mr_n73179600)
print v(xbgr.mr_n73179920)
print v(xbgr.mr_n73180032)
print v(xbgr.mr_n73180352)
print v(xbgr.mr_n73180464)
print v(xbgr.mr_n73180784)
print v(xbgr.mr_n73180896)
print v(xbgr.mr_n73181216)
print v(xbgr.mr_n73182080)
print v(xbgr.mr_n73182944)
print v(xbgr.mr_n73183056)
print v(xbgr.mr_n73183376)
print v(xbgr.mr_n73183488)
print v(xbgr.mr_n73183808)
print v(xbgr.mr_n73183920)
print v(xbgr.mr_n73184240)
print v(xbgr.mr_n73184352)
print v(xbgr.mr_n73184672)
print v(xbgr.mr_n73184784)
print v(xbgr.mr_n73185104)
print v(xbgr.mr_n73185216)
print v(xbgr.mr_n73185968)
print v(xbgr.mr_n73186832)
print v(xbgr.mr_n73187696)
print v(xbgr.mr_n73187808)
print v(xbgr.mr_n73188128)
print v(xbgr.mr_n73188240)
print v(xbgr.mr_n73188560)
print v(xbgr.mr_n73188672)
print v(xbgr.mr_n73188992)
print v(xbgr.mr_n73189104)
print v(xbgr.mr_n73189536)
print v(xbgr.mr_n73189856)
print v(xbgr.mr_n73189968)
print v(xbgr.mr_n73190720)
print v(xbgr.mr_n73191584)
print v(xbgr.mr_n73192448)
print v(xbgr.mr_n73193312)
print v(xbgr.mr_n73193424)
print v(xbgr.mr_n73193744)
print v(xbgr.mr_n73193856)
print v(xbgr.mr_n73194176)
print v(xbgr.mr_n73194288)
print v(xbgr.mr_n73194608)
print v(xbgr.mr_n73194720)
print v(xbgr.mr_n73195040)
print v(xbgr.mr_n73195904)
print v(xbgr.mr_n73197200)
print v(xbgr.mr_n73197312)
print v(xbgr.mr_n73197632)
print v(xbgr.mr_n73197744)
print v(xbgr.mr_n73198176)
print v(xbgr.mr_n73198496)
print v(xbgr.mr_n73198608)
print v(xbgr.mr_n73199040)
print v(xbgr.mr_n73199360)
print v(xbgr.mr_n73199792)
print v(xbgr.mr_n73200656)
print v(xbgr.mr_n73201520)
print v(xbgr.mr_n73201632)
print v(xbgr.mr_n73201952)
print v(xbgr.mr_n73202064)
print v(xbgr.mr_n73202496)
print v(xbgr.mr_n73202816)
print v(xbgr.mr_n73202928)
print v(xbgr.mr_n73203248)
print v(xbgr.mr_n73203360)
print v(xbgr.mr_n73203680)
print v(xbgr.mr_n73203792)
print v(xbgr.mr_n73204112)
print v(xbgr.mr_n73204224)
print v(xbgr.mr_n73204656)
print v(xbgr.mr_n73205088)
print v(xbgr.mr_n73205520)
print v(xbgr.mr_n73205952)
print v(xbgr.mr_n73206272)
print v(xbgr.mr_n73206384)
print v(xbgr.mr_n73206816)
print v(xbgr.mr_n73207136)
print v(xbgr.mr_n73208000)
print v(xbgr.mr_n73208864)
print v(xbgr.mr_n73209296)
print v(xbgr.mr_n73210160)
print v(xbgr.mr_n73210592)
print v(xbgr.mr_n73210704)
print v(xbgr.mr_n73211456)
print v(xbgr.mr_n73212320)
print v(xbgr.mr_n73213184)
print v(xbgr.mr_n73213296)
print v(xbgr.mr_n73213728)
print v(xbgr.mr_n73214048)
print v(xbgr.mr_n73214912)
print v(xbgr.mr_n73215024)
print v(xbgr.mr_n73215344)
print v(xbgr.mr_n73215456)
print v(xbgr.mr_n73215776)
print v(xbgr.mr_n73215888)
print v(xbgr.mr_n73216208)
print v(xbgr.mr_n73216320)
print v(xbgr.mr_n73216640)
print v(xbgr.mr_n73216752)
print v(xbgr.mr_n73217072)
print v(xbgr.mr_n73217184)
print v(xbgr.mr_n73217504)
print v(xbgr.mr_n73217616)
print v(xbgr.mr_n73217936)
print v(xbgr.mr_n73218048)
print v(xbgr.mr_n73218368)
print v(xbgr.mr_n73218480)
print v(xbgr.mr_n73218800)
print v(xbgr.mr_n73218912)
print v(xbgr.mr_n73219664)
print v(xbgr.mr_n73220960)
print v(xbgr.mr_n73221824)
print v(xbgr.mr_n73223120)
print v(xbgr.mr_n73223232)
print v(xbgr.mr_n73223552)
print v(xbgr.mr_n73223664)
print v(xbgr.mr_n73223984)
print v(xbgr.mr_n73224096)
print v(xbgr.mr_n73224416)
print v(xbgr.mr_n73224528)
print v(xbgr.mr_n73225280)
print v(xbgr.mr_n73226144)
print v(xbgr.mr_n73227008)
print v(xbgr.mr_n73227872)
print v(xbgr.mr_n73227984)
print v(xbgr.mr_n73228304)
print v(xbgr.mr_n73228416)
print v(xbgr.mr_n73228736)
print v(xbgr.mr_n73228848)
print v(xbgr.mr_n73229168)
print v(xbgr.mr_n73229280)
print v(xbgr.mr_n73229600)
print v(xbgr.mr_n73229712)
print v(xbgr.mr_n73230032)
print v(xbgr.mr_n73230576)
print v(xbgr.mr_n73231328)
print v(xbgr.mr_n73232192)
print v(xbgr.mr_n73232304)
print v(xbgr.mr_n73232624)
print v(xbgr.mr_n73232736)
print v(xbgr.mr_n73233168)
print v(xbgr.mr_n73233488)
print v(xbgr.mr_n73233600)
print v(xbgr.mr_n73233920)
print v(xbgr.mr_n73234032)
print v(xbgr.mr_n73234352)
print v(xbgr.mr_n73234464)
print v(xbgr.mr_n73234784)
print v(xbgr.mr_n73234896)
print v(xbgr.mr_n73235216)
print v(xbgr.mr_n73235648)
print v(xbgr.mr_n73235760)
print v(xbgr.mr_n73236080)
print v(xbgr.mr_n73236192)
print v(xbgr.mr_n73236944)
print v(xbgr.mr_n73237056)
print v(xbgr.mr_n73237376)
print v(xbgr.mr_n73237488)
print v(xbgr.mr_n73238240)
print v(xbgr.mr_n73239104)
print v(xbgr.mr_n73239216)
print v(xbgr.mr_n73239536)
print v(xbgr.mr_n73240400)
print v(xbgr.mr_n73240944)
print v(xbgr.mr_n73241264)
print v(xbgr.mr_n73241808)
print v(xbgr.mr_n73242240)
print v(xbgr.mr_n73242560)
print v(xbgr.mr_n73242672)
print v(xbgr.mr_n73243424)
print v(xbgr.mr_n73243536)
print v(xbgr.mr_n73243856)
print v(xbgr.mr_n73243968)
print v(xbgr.mr_n73244288)
print v(xbgr.mr_n73245152)
print v(xbgr.mr_n73245584)
print v(xbgr.mr_n73245696)
print v(xbgr.mr_n73246016)
print v(xbgr.mr_n73246128)
print v(xbgr.mr_n73246448)
print v(xbgr.mr_n73246560)
print v(xbgr.mr_n73246880)
print v(xbgr.mr_n73246992)
print v(xbgr.mr_n73247312)
print v(xbgr.mr_n73247424)
print v(xbgr.mr_n73248608)
print v(xbgr.mr_n73248720)
print v(xbgr.mr_n73249040)
print v(xbgr.mr_n73249152)
print v(xbgr.mr_n73249472)
print v(xbgr.mr_n73249584)
print v(xbgr.mr_n73249904)
print v(xbgr.mr_n73250336)
print v(xbgr.mr_n73382720)
print v(xbgr.mr_n73382832)
print v(xbgr.mr_n73383152)
print v(xbgr.mr_n73383264)
print v(xbgr.mr_n73383584)
print v(xbgr.mr_n73383696)
print v(xbgr.mr_n73384016)
print v(xbgr.mr_n73384128)
print v(xbgr.mr_n73384448)
print v(xbgr.mr_n73384560)
print v(xbgr.mr_n73384880)
print v(xbgr.mr_n73384992)
print v(xbgr.mr_n73385312)
print v(xbgr.mr_n73385424)
print v(xbgr.mr_n73385744)
print v(xbgr.mr_n73385856)
print v(xbgr.mr_n73386176)
print v(xbgr.mr_n73386288)
print v(xbgr.mr_n73386608)
print v(xbgr.mr_n73386720)
print v(xbgr.mr_n73387040)
print v(xbgr.mr_n73387152)
print v(xbgr.mr_n73387472)
print v(xbgr.mr_n73387584)
print v(xbgr.mr_n73387904)
print v(xbgr.mr_n73388016)
print v(xbgr.mr_n73388336)
print v(xbgr.mr_n73388448)
print v(xbgr.mr_n73388768)
print v(xbgr.mr_n73388880)
print v(xbgr.mr_n73389200)
print v(xbgr.mr_n73389312)
print v(xbgr.mr_n73389632)
print v(xbgr.mr_n73389744)
print v(xbgr.mr_n73390064)
print v(xbgr.mr_n73390176)
print v(xbgr.mr_n73390496)
print v(xbgr.mr_n73390608)
print v(xbgr.mr_n73390928)
print v(xbgr.mr_n73391040)
print v(xbgr.mr_n73391360)
print v(xbgr.mr_n73391472)
print v(xbgr.mr_n73391792)
print v(xbgr.mr_n73391904)
print v(xbgr.mr_n73392224)
print v(xbgr.mr_n73392336)
print v(xbgr.mr_n73392656)
print v(xbgr.mr_n73392768)
print v(xbgr.mr_n73393088)
print v(xbgr.mr_n73393200)
print v(xbgr.mr_n73393520)
print v(xbgr.mr_n73393632)
print v(xbgr.mr_n73393952)
print v(xbgr.mr_n73394064)
print v(xbgr.mr_n73394384)
print v(xbgr.mr_n73394496)
print v(xbgr.mr_n73394816)
print v(xbgr.mr_n73394928)
print v(xbgr.mr_n73395248)
print v(xbgr.mr_n73395360)
print v(xbgr.mr_n73395680)
print v(xbgr.mr_n73395792)
print v(xbgr.mr_n73396112)
print v(xbgr.mr_n73396224)
print v(xbgr.mr_n73396544)
print v(xbgr.mr_n73396656)
print v(xbgr.mr_n73396976)
print v(xbgr.mr_n73397088)
print v(xbgr.mr_n73397408)
print v(xbgr.mr_n73397520)
print v(xbgr.mr_n73397840)
print v(xbgr.mr_n73397952)
print v(xbgr.mr_n73398272)
print v(xbgr.mr_n73398384)
print v(xbgr.mr_n73398704)
print v(xbgr.mr_n73398816)
print v(xbgr.mr_n73399136)
print v(xbgr.mr_n73399248)
print v(xbgr.mr_n73399568)
print v(xbgr.mr_n73399680)
print v(xbgr.mr_n73400000)
print v(xbgr.mr_n73400112)
print v(xbgr.mr_n73400432)
print v(xbgr.mr_n73400544)
print v(xbgr.mr_n73400864)
print v(xbgr.mr_n73400976)
print v(xbgr.mr_n73401296)
print v(xbgr.mr_n73401408)
print v(xbgr.mr_n73401728)
print v(xbgr.mr_n73401840)
print v(xbgr.mr_n73402160)
print v(xbgr.mr_n73402272)
print v(xbgr.mr_n73402592)
print v(xbgr.mr_n73402704)
print v(xbgr.mr_n73403024)
print v(xbgr.mr_n73403136)
print v(xbgr.mr_n73403456)
print v(xbgr.mr_n73403568)
print v(xbgr.mr_n73403888)
print v(xbgr.mr_n73404000)
print v(xbgr.mr_n73404320)
print v(xbgr.mr_n73404432)
print v(xbgr.mr_n73404752)
print v(xbgr.mr_n73404864)
print v(xbgr.mr_n73405184)
print v(xbgr.mr_n73405296)
print v(xbgr.mr_n73405616)
print v(xbgr.mr_n73405728)
print v(xbgr.mr_n73406048)
print v(xbgr.mr_n73406160)
print v(xbgr.mr_n73406480)
print v(xbgr.mr_n73406592)
print v(xbgr.mr_n73406912)
print v(xbgr.mr_n73407024)
print v(xbgr.mr_n73407344)
print v(xbgr.mr_n73407456)
print v(xbgr.mr_n73407776)
print v(xbgr.mr_n73407888)
print v(xbgr.mr_n73408208)
print v(xbgr.mr_n73408320)
print v(xbgr.mr_n73408640)
print v(xbgr.mr_n73408752)
print v(xbgr.mr_n73409072)
print v(xbgr.mr_n73409184)
print v(xbgr.mr_n73409504)
print v(xbgr.mr_n73409616)
print v(xbgr.mr_n73409936)
print v(xbgr.mr_n73410048)
print v(xbgr.mr_n73410368)
print v(xbgr.mr_n73410480)
print v(xbgr.mr_n73410800)
print v(xbgr.mr_n73410912)
print v(xbgr.mr_n73411232)
print v(xbgr.mr_n73411344)
print v(xbgr.mr_n73411664)
print v(xbgr.mr_n73411776)
print v(xbgr.mr_n73412096)
print v(xbgr.mr_n73412208)
print v(xbgr.mr_n73412528)
print v(xbgr.mr_n73412640)
print v(xbgr.mr_n73412960)
print v(xbgr.mr_n73413072)
print v(xbgr.mr_n73413392)
print v(xbgr.mr_n73413504)
print v(xbgr.mr_n73413824)
print v(xbgr.mr_n73413936)
print v(xbgr.mr_n73414256)
print v(xbgr.mr_n73414368)
print v(xbgr.mr_n73414688)
print v(xbgr.mr_n73414800)
print v(xbgr.mr_n73415120)
print v(xbgr.mr_n73415232)
print v(xbgr.mr_n73415552)
print v(xbgr.mr_n73415664)
print v(xbgr.mr_n73415984)
print v(xbgr.mr_n73416096)
print v(xbgr.mr_n73416416)
print v(xbgr.mr_n73416528)
print v(xbgr.mr_n73416848)
print v(xbgr.mr_n73416960)
print v(xbgr.mr_n73417280)
print v(xbgr.mr_n73417392)
print v(xbgr.mr_n73417712)
print v(xbgr.mr_n73417824)
print v(xbgr.mr_n73418144)
print v(xbgr.mr_n73418256)
print v(xbgr.mr_n73418576)
print v(xbgr.mr_n73418688)
print v(xbgr.mr_n73419008)
print v(xbgr.mr_n73419120)
print v(xbgr.mr_n73419440)
print v(xbgr.mr_n73419552)
print v(xbgr.mr_n73419872)
print v(xbgr.mr_n73419984)
print v(xbgr.mr_n73420304)
print v(xbgr.mr_n73420416)
print v(xbgr.mr_n73420736)
print v(xbgr.mr_n73420848)
print v(xbgr.mr_n73421168)
print v(xbgr.mr_n73421280)
print v(xbgr.mr_n73421600)
print v(xbgr.mr_n73421712)
print v(xbgr.mr_n73422032)
print v(xbgr.mr_n73422144)
print v(xbgr.mr_n73422464)
print v(xbgr.mr_n73422576)
print v(xbgr.mr_n73422896)
print v(xbgr.mr_n73423008)
print v(xbgr.mr_n73423328)
print v(xbgr.mr_n73423440)
print v(xbgr.mr_n73423760)
print v(xbgr.mr_n73423872)
print v(xbgr.mr_n73424192)
print v(xbgr.mr_n73424304)
print v(xbgr.mr_n73424624)
print v(xbgr.mr_n73424736)
print v(xbgr.mr_n73425056)
print v(xbgr.mr_n73425168)
print v(xbgr.mr_n73425488)
print v(xbgr.mr_n73425600)
print v(xbgr.mr_n73425920)
print v(xbgr.mr_n73426032)
print v(xbgr.mr_n73426352)
print v(xbgr.mr_n73426464)
print v(xbgr.mr_n73426784)
print v(xbgr.mr_n73426896)
print v(xbgr.mr_n73427216)
print v(xbgr.mr_n73427328)
print v(xbgr.mr_n73427648)
print v(xbgr.mr_n73427760)
print v(xbgr.mr_n73428080)
print v(xbgr.mr_n73428192)
print v(xbgr.mr_n73428512)
print v(xbgr.mr_n73428624)
print v(xbgr.mr_n73428944)
print v(xbgr.mr_n73429056)
print v(xbgr.mr_n73429376)
print v(xbgr.mr_n73429488)
print v(xbgr.mr_n73429808)
print v(xbgr.mr_n73429920)
print v(xbgr.mr_n73430240)
print v(xbgr.mr_n73430352)
print v(xbgr.mr_n73430672)
print v(xbgr.mr_n73430784)
print v(xbgr.mr_n73431104)
print v(xbgr.mr_n73431216)
print v(xbgr.mr_n73431536)
print v(xbgr.mr_n73431648)
print v(xbgr.mr_n73431968)
print v(xbgr.mr_n73432080)
print v(xbgr.mr_n73432400)
print v(xbgr.mr_n73432512)
print v(xbgr.mr_n73432832)
print v(xbgr.mr_n73432944)
print v(xbgr.mr_n73433264)
print v(xbgr.mr_n73433376)
print v(xbgr.mr_n73433696)
print v(xbgr.mr_n73433808)
print v(xbgr.mr_n73434128)
print v(xbgr.mr_n73434240)
print v(xbgr.mr_n73434560)
print v(xbgr.mr_n73434672)
print v(xbgr.mr_n73434992)
print v(xbgr.mr_n73435104)
print v(xbgr.mr_n73435424)
print v(xbgr.mr_n73435536)
print v(xbgr.mr_n73435856)
print v(xbgr.mr_n73435968)
print v(xbgr.mr_n73436288)
print v(xbgr.mr_n73436400)
print v(xbgr.mr_n73436720)
print v(xbgr.mr_n73436832)
print v(xbgr.mr_n73437152)
print v(xbgr.mr_n73437264)
print v(xbgr.mr_n73437584)
print v(xbgr.mr_n73437696)
print v(xbgr.mr_n73438016)
print v(xbgr.mr_n73438128)
print v(xbgr.mr_n73438448)
print v(xbgr.mr_n73438560)
print v(xbgr.mr_n73438880)
print v(xbgr.mr_n73438992)
print v(xbgr.mr_n73439312)
print v(xbgr.mr_n73439424)
print v(xbgr.mr_n73439744)
print v(xbgr.mr_n73439856)
print v(xbgr.mr_n73440176)
print v(xbgr.mr_n73440288)
print v(xbgr.mr_n73440608)
print v(xbgr.mr_n73440720)
print v(xbgr.mr_n73441040)
print v(xbgr.mr_n73441152)
print v(xbgr.mr_n73441472)
print v(xbgr.mr_n73441584)
print v(xbgr.mr_n73441904)
print v(xbgr.mr_n73442016)
print v(xbgr.mr_n73442336)
print v(xbgr.mr_n73442448)
print v(xbgr.mr_n73442768)
print v(xbgr.mr_n73442880)
print v(xbgr.mr_n73443200)
print v(xbgr.mr_n73443312)
print v(xbgr.mr_n73443632)
print v(xbgr.mr_n73443744)
print v(xbgr.mr_n73444064)
print v(xbgr.mr_n73444176)
print v(xbgr.mr_n73444496)
print v(xbgr.mr_n73444608)
print v(xbgr.mr_n73444928)
print v(xbgr.mr_n73445040)
print v(xbgr.mr_n73445360)
print v(xbgr.mr_n73445472)
print v(xbgr.mr_n73445792)
print v(xbgr.mr_n73445904)
print v(xbgr.mr_n73446224)
print v(xbgr.mr_n73446336)
print v(xbgr.mr_n73446656)
print v(xbgr.mr_n73446768)
print v(xbgr.mr_n73447088)
print v(xbgr.mr_n73447200)
print v(xbgr.mr_n73447520)
print v(xbgr.mr_n73447632)
print v(xbgr.mr_n73447952)
print v(xbgr.mr_n73448064)
print v(xbgr.mr_n73448384)
print v(xbgr.mr_n73448496)
print v(xbgr.mr_n73448816)
print v(xbgr.mr_n73448928)
print v(xbgr.mr_n73449248)
print v(xbgr.mr_n73449360)
print v(xbgr.mr_n73449680)
print v(xbgr.mr_n73449792)
print v(xbgr.mr_n73450112)
print v(xbgr.mr_n73450224)
print v(xbgr.mr_n73450544)
print v(xbgr.mr_n73450656)
print v(xbgr.mr_n73450976)
print v(xbgr.mr_n73451088)
print v(xbgr.mr_n73451408)
print v(xbgr.mr_n73451520)
print v(xbgr.mr_n73451840)
print v(xbgr.mr_n73451952)
print v(xbgr.mr_n73452272)
print v(xbgr.mr_n73452384)
print v(xbgr.mr_n73452704)
print v(xbgr.mr_n73452816)
print v(xbgr.mr_n73453136)
print v(xbgr.mr_n73453248)
print v(xbgr.mr_n73453568)
print v(xbgr.mr_n73453680)
print v(xbgr.mr_n73454000)
print v(xbgr.mr_n73454112)
print v(xbgr.mr_n73454432)
print v(xbgr.mr_n73454544)
print v(xbgr.mr_n73454864)
print v(xbgr.mr_n73454976)
print v(xbgr.mr_n73455296)
print v(xbgr.mr_n73455408)
print v(xbgr.mr_n73455728)
print v(xbgr.mr_n73455840)
print v(xbgr.mr_n73456160)
print v(xbgr.mr_n73456272)
print v(xbgr.mr_n73456592)
print v(xbgr.mr_n73456704)
print v(xbgr.mr_n73457024)
print v(xbgr.mr_n73457136)
print v(xbgr.mr_n73457456)
print v(xbgr.mr_n73457568)
print v(xbgr.mr_n73457888)
print v(xbgr.mr_n73458000)
print v(xbgr.mr_n73458320)
print v(xbgr.mr_n73458432)
print v(xbgr.mr_n73458752)
print v(xbgr.mr_n73458864)
print v(xbgr.mr_n73459184)
print v(xbgr.mr_n73459296)
print v(xbgr.mr_n73459616)
print v(xbgr.mr_n73459728)
print v(xbgr.mr_n73460048)
print v(xbgr.mr_n73460160)
print v(xbgr.mr_n73460480)
print v(xbgr.mr_n73460592)
print v(xbgr.mr_n73460912)
print v(xbgr.mr_n73461024)
print v(xbgr.mr_n73461344)
print v(xbgr.mr_n73461456)
print v(xbgr.mr_n73461776)
print v(xbgr.mr_n73461888)
print v(xbgr.mr_n73462208)
print v(xbgr.mr_n73462320)
print v(xbgr.mr_n73462640)
print v(xbgr.mr_n73462752)
print v(xbgr.mr_n73463072)
print v(xbgr.mr_n73463184)
print v(xbgr.mr_n73463504)
print v(xbgr.mr_n73463616)
print v(xbgr.mr_n73463936)
print v(xbgr.mr_n73464048)
print v(xbgr.mr_n73464368)
print v(xbgr.mr_n73464480)
print v(xbgr.mr_n73464800)
print v(xbgr.mr_n73464912)
print v(xbgr.mr_n73465232)
print v(xbgr.mr_n73465344)
print v(xbgr.mr_n73465648)
print v(xbgr.mr_n73465760)
print v(xbgr.mr_n73466080)
print v(xbgr.mr_n73466192)
print v(xbgr.mr_n73466512)
print v(xbgr.mr_n73466624)
print v(xbgr.mr_n73466944)
print v(xbgr.mr_n73467056)
print v(xbgr.mr_n73467376)
print v(xbgr.mr_n73467488)
print v(xbgr.mr_n73467808)
print v(xbgr.mr_n73467920)
print v(xbgr.mr_n73468240)
print v(xbgr.mr_n73468352)
print v(xbgr.mr_n73468672)
print v(xbgr.mr_n73468784)
print v(xbgr.mr_n73469104)
print v(xbgr.mr_n73469216)
print v(xbgr.mr_n73469536)
print v(xbgr.mr_n73469648)
print v(xbgr.mr_n73469968)
print v(xbgr.mr_n73470080)
print v(xbgr.mr_n73470400)
print v(xbgr.mr_n73470512)
print v(xbgr.mr_n73470832)
print v(xbgr.mr_n73470944)
print v(xbgr.mr_n73471264)
print v(xbgr.mr_n73471376)
print v(xbgr.mr_n73471696)
print v(xbgr.mr_n73471808)
print v(xbgr.mr_n73472128)
print v(xbgr.mr_n73472240)
print v(xbgr.mr_n73472560)
print v(xbgr.mr_n73472672)
print v(xbgr.mr_n73472992)
print v(xbgr.mr_n73473104)
print v(xbgr.mr_n73473424)
print v(xbgr.mr_n73473536)
print v(xbgr.mr_n73473856)
print v(xbgr.mr_n73473968)
print v(xbgr.mr_n73474288)
print v(xbgr.mr_n73474400)
print v(xbgr.mr_n73474720)
print v(xbgr.mr_n73474832)
print v(xbgr.mr_n73475152)
print v(xbgr.mr_n73475264)
print v(xbgr.mr_n73475584)
print v(xbgr.mr_n73475696)
print v(xbgr.mr_n73476016)
print v(xbgr.mr_n73476128)
print v(xbgr.mr_n73476448)
print v(xbgr.mr_n73476560)
print v(xbgr.mr_n73476880)
print v(xbgr.mr_n73476992)
print v(xbgr.mr_n73477312)
print v(xbgr.mr_n73477424)
print v(xbgr.mr_n73477744)
print v(xbgr.mr_n73477856)
print v(xbgr.mr_n73478176)
print v(xbgr.mr_n73478288)
print v(xbgr.mr_n73478608)
print v(xbgr.mr_n73478720)
print v(xbgr.mr_n73479040)
print v(xbgr.mr_n73479152)
print v(xbgr.mr_n73479472)
print v(xbgr.mr_n73479584)
print v(xbgr.mr_n73479904)
print v(xbgr.mr_n73480016)
print v(xbgr.mr_n73480336)
print v(xbgr.mr_n73480448)
print v(xbgr.mr_n73480768)
print v(xbgr.mr_n73480880)
print v(xbgr.mr_n73481200)
print v(xbgr.mr_n73481312)
print v(xbgr.mr_n73481632)
print v(xbgr.mr_n73481744)
print v(xbgr.mr_n73482064)
print v(xbgr.mr_n73482176)
print v(xbgr.mr_n73482496)
print v(xbgr.mr_n73482608)
print v(xbgr.mr_n73482928)
print v(xbgr.mr_n73483040)
print v(xbgr.mr_n73483360)
print v(xbgr.mr_n73483472)
print v(xbgr.mr_n73483792)
print v(xbgr.mr_n73483904)
print v(xbgr.mr_n73484224)
print v(xbgr.mr_n73484336)
print v(xbgr.mr_n73484656)
print v(xbgr.mr_n73484768)
print v(xbgr.mr_n73485088)
print v(xbgr.mr_n73485200)
print v(xbgr.mr_n73485520)
print v(xbgr.mr_n73485632)
print v(xbgr.mr_n73485952)
print v(xbgr.mr_n73486064)
print v(xbgr.mr_n73486384)
print v(xbgr.mr_n73486496)
print v(xbgr.mr_n73486816)
print v(xbgr.mr_n73486928)
print v(xbgr.mr_n73487248)
print v(xbgr.mr_n73487360)
print v(xbgr.mr_n73487680)
print v(xbgr.mr_n73487792)
print v(xbgr.mr_n73488112)
print v(xbgr.mr_n73488224)
print v(xbgr.mr_n73488544)
print v(xbgr.mr_n73488656)
print v(xbgr.mr_n73488976)
print v(xbgr.mr_n73489088)
print v(xbgr.mr_n73489408)
print v(xbgr.mr_n73489520)
print v(xbgr.mr_n73489840)
print v(xbgr.mr_n73489952)
print v(xbgr.mr_n73490272)
print v(xbgr.mr_n73490384)
print v(xbgr.mr_n73490704)
print v(xbgr.mr_n73490816)
print v(xbgr.mr_n73491136)
print v(xbgr.mr_n73491248)
print v(xbgr.mr_n73491568)
print v(xbgr.mr_n73491680)
print v(xbgr.mr_n73492000)
print v(xbgr.mr_n73492112)
print v(xbgr.mr_n73492432)
print v(xbgr.mr_n73492544)
print v(xbgr.mr_n73492864)
print v(xbgr.mr_n73492976)
print v(xbgr.mr_n73493296)
print v(xbgr.mr_n73493408)
print v(xbgr.mr_n73493728)
print v(xbgr.mr_n73493840)
print v(xbgr.mr_n73494160)
print v(xbgr.mr_n73494272)
print v(xbgr.mr_n73494592)
print v(xbgr.mr_n73494704)
print v(xbgr.mr_n73495024)
print v(xbgr.mr_n73495136)
print v(xbgr.mr_n73495456)
print v(xbgr.mr_n73495568)
print v(xbgr.mr_n73495888)
print v(xbgr.mr_n73496000)
print v(xbgr.mr_n73496320)
print v(xbgr.mr_n73496432)
print v(xbgr.mr_n73496752)
print v(xbgr.mr_n73496864)
print v(xbgr.mr_n73497184)
print v(xbgr.mr_n73497296)
print v(xbgr.mr_n73497616)
print v(xbgr.mr_n73497728)
print v(xbgr.mr_n73498048)
print v(xbgr.mr_n73498160)
print v(xbgr.mr_n73498480)
print v(xbgr.mr_n73498592)
print v(xbgr.mr_n73498912)
print v(xbgr.mr_n73499024)
print v(xbgr.mr_n73499344)
print v(xbgr.mr_n73499456)
print v(xbgr.mr_n73499776)
print v(xbgr.mr_n73499888)
print v(xbgr.mr_n73500208)
print v(xbgr.mr_n73500320)
print v(xbgr.mr_n73500640)
print v(xbgr.mr_n73500752)
print v(xbgr.mr_n73501072)
print v(xbgr.mr_n73501184)
print v(xbgr.mr_n73501504)
print v(xbgr.mr_n73501616)
print v(xbgr.mr_n73501936)
print v(xbgr.mr_n73502048)
print v(xbgr.mr_n73502368)
print v(xbgr.mr_n73502480)
print v(xbgr.mr_n73502800)
print v(xbgr.mr_n73502912)
print v(xbgr.mr_n73503232)
print v(xbgr.mr_n73503344)
print v(xbgr.mr_n73503664)
print v(xbgr.mr_n73503776)
print v(xbgr.mr_n73504096)
print v(xbgr.mr_n73504208)
print v(xbgr.mr_n73504528)
print v(xbgr.mr_n73504640)
print v(xbgr.mr_n73504960)
print v(xbgr.mr_n73505072)
print v(xbgr.mr_n73505392)
print v(xbgr.mr_n73505504)
print v(xbgr.mr_n73505824)
print v(xbgr.mr_n73505936)
print v(xbgr.mr_n73506256)
print v(xbgr.mr_n73506368)
print v(xbgr.mr_n73506688)
print v(xbgr.mr_n73506800)
print v(xbgr.mr_n73507120)
print v(xbgr.mr_n73507232)
print v(xbgr.mr_n73507552)
print v(xbgr.mr_n73507664)
print v(xbgr.mr_n73507984)
print v(xbgr.mr_n73508096)
print v(xbgr.mr_n73508416)
print v(xbgr.mr_n73508528)
print v(xbgr.mr_n73508848)
print v(xbgr.mr_n73508960)
print v(xbgr.mr_n73509280)
print v(xbgr.mr_n73509392)
print v(xbgr.mr_n73509712)
print v(xbgr.mr_n73509824)
print v(xbgr.mr_n73510144)
print v(xbgr.mr_n73510256)
print v(xbgr.mr_n73510576)
print v(xbgr.mr_n73510688)
print v(xbgr.mr_n73511008)
print v(xbgr.mr_n73511120)
print v(xbgr.mr_n73511440)
print v(xbgr.mr_n73511552)
print v(xbgr.mr_n73511872)
print v(xbgr.mr_n73511984)
print v(xbgr.mr_n73512304)
print v(xbgr.mr_n73512416)
print v(xbgr.mr_n73512736)
print v(xbgr.mr_n73512848)
print v(xbgr.mr_n73513168)
print v(xbgr.mr_n73513280)
print v(xbgr.mr_n73513600)
print v(xbgr.mr_n73513808)
print v(xbgr.mr_n73514048)
print v(xbgr.mr_n73514912)
print v(xbgr.mr_n73515024)
print v(xbgr.mr_n73515344)
print v(xbgr.mr_n73515456)
print v(xbgr.mr_n73515776)
print v(xbgr.mr_n73515888)
print v(xbgr.mr_n73516208)
print v(xbgr.mr_n73516320)
print v(xbgr.mr_n73516640)
print v(xbgr.mr_n73516752)
print v(xbgr.mr_n73517072)
print v(xbgr.mr_n73517184)
print v(xbgr.mr_n73517504)
print v(xbgr.mr_n73518368)
print v(xbgr.mr_n73519232)
print v(xbgr.mr_n73520096)
print v(xbgr.mr_n73520208)
print v(xbgr.mr_n73520960)
print v(xbgr.mr_n73521072)
print v(xbgr.mr_n73521392)
print v(xbgr.mr_n73522256)
print v(xbgr.mr_n73523120)
print v(xbgr.mr_n73523984)
print v(xbgr.mr_n73524848)
print v(xbgr.mr_n73525392)
print v(xbgr.mr_n73526144)
print v(xbgr.mr_n73526688)
print v(xbgr.mr_n73527120)
print v(xbgr.mr_n73527872)
print v(xbgr.mr_n73527984)
print v(xbgr.mr_n73528304)
print v(xbgr.mr_n73528416)
print v(xbgr.mr_n73528736)
print v(xbgr.mr_n73529600)
print v(xbgr.mr_n73530464)
print v(xbgr.mr_n73531328)
print v(xbgr.mr_n73531440)
print v(xbgr.mr_n73531760)
print v(xbgr.mr_n73531872)
print v(xbgr.mr_n73532304)
print v(xbgr.mr_n73532624)
print v(xbgr.mr_n73532736)
print v(xbgr.mr_n73533056)
print v(xbgr.mr_n73533920)
print v(xbgr.mr_n73534032)
print v(xbgr.mr_n73534464)
print v(xbgr.mr_n73534784)
print v(xbgr.mr_n73534896)
print v(xbgr.mr_n73535216)
print v(xbgr.mr_n73535328)
print v(xbgr.mr_n73535648)
print v(xbgr.mr_n73535760)
print v(xbgr.mr_n73536080)
print v(xbgr.mr_n73536192)
print v(xbgr.mr_n73536512)
print v(xbgr.mr_n73537488)
print v(xbgr.mr_n73537808)
print v(xbgr.mr_n73537920)
print v(xbgr.mr_n73538240)
print v(xbgr.mr_n73538352)
print v(xbgr.mr_n73538672)
print v(xbgr.mr_n73538784)
print v(xbgr.mr_n73539104)
print v(xbgr.mr_n73539216)
print v(xbgr.mr_n73539536)
print v(xbgr.mr_n73539968)
print v(xbgr.mr_n73540944)
print v(xbgr.mr_n73541264)
print v(xbgr.mr_n73542128)
print v(xbgr.mr_n73542992)
print v(xbgr.mr_n73543104)
print v(xbgr.mr_n73543856)
print v(xbgr.mr_n73544720)
print v(xbgr.mr_n73544832)
print v(xbgr.mr_n73545152)
print v(xbgr.mr_n73546016)
print v(xbgr.mr_n73546128)
print v(xbgr.mr_n73546448)
print v(xbgr.mr_n73546560)
print v(xbgr.mr_n73546880)
print v(xbgr.mr_n73547744)
print v(xbgr.mr_n73547856)
print v(xbgr.mr_n73548176)
print v(xbgr.mr_n73548288)
print v(xbgr.mr_n73548608)
print v(xbgr.mr_n73548720)
print v(xbgr.mr_n73549040)
print v(xbgr.mr_n73549152)
print v(xbgr.mr_n73549472)
print v(xbgr.mr_n73550448)
print v(xbgr.mr_n73550880)
print v(xbgr.mr_n73551200)
print v(xbgr.mr_n73552064)
print v(xbgr.mr_n73552928)
print v(xbgr.mr_n73553040)
print v(xbgr.mr_n73553360)
print v(xbgr.mr_n73553472)
print v(xbgr.mr_n73553792)
print v(xbgr.mr_n73553904)
print v(xbgr.mr_n73554224)
print v(xbgr.mr_n73554336)
print v(xbgr.mr_n73554768)
print v(xbgr.mr_n73555200)
print v(xbgr.mr_n73555520)
print v(xbgr.mr_n73555632)
print v(xbgr.mr_n73555952)
print v(xbgr.mr_n73556064)
print v(xbgr.mr_n73556384)
print v(xbgr.mr_n73556496)
print v(xbgr.mr_n73556816)
print v(xbgr.mr_n73556928)
print v(xbgr.mr_n73557248)
print v(xbgr.mr_n73558112)
print v(xbgr.mr_n73558976)
print v(xbgr.mr_n73559088)
print v(xbgr.mr_n73559408)
print v(xbgr.mr_n73560272)
print v(xbgr.mr_n73561136)
print v(xbgr.mr_n73561248)
print v(xbgr.mr_n73561568)
print v(xbgr.mr_n73561680)
print v(xbgr.mr_n73562112)
print v(xbgr.mr_n73562432)
print v(xbgr.mr_n73562544)
print v(xbgr.mr_n73562976)
print v(xbgr.mr_n73563296)
print v(xbgr.mr_n73563728)
print v(xbgr.mr_n73563840)
print v(xbgr.mr_n73564160)
print v(xbgr.mr_n73564272)
print v(xbgr.mr_n73564592)
print v(xbgr.mr_n73565024)
print v(xbgr.mr_n73565136)
print v(xbgr.mr_n73565888)
print v(xbgr.mr_n73566000)
print v(xbgr.mr_n73566320)
print v(xbgr.mr_n73566432)
print v(xbgr.mr_n73566752)
print v(xbgr.mr_n73567184)
print v(xbgr.mr_n73567296)
print v(xbgr.mr_n73567616)
print v(xbgr.mr_n73568048)
print v(xbgr.mr_n73568912)
print v(xbgr.mr_n73570640)
print v(xbgr.mr_n73570752)
print v(xbgr.mr_n73571072)
print v(xbgr.mr_n73571184)
print v(xbgr.mr_n73571504)
print v(xbgr.mr_n73571616)
print v(xbgr.mr_n73572048)
print v(xbgr.mr_n73572480)
print v(xbgr.mr_n73572800)
print v(xbgr.mr_n73572912)
print v(xbgr.mr_n73573232)
print v(xbgr.mr_n73574640)
print v(xbgr.mr_n73574960)
print v(xbgr.mr_n73575936)
print v(xbgr.mr_n73576256)
print v(xbgr.mr_n73576368)
print v(xbgr.mr_n73576688)
print v(xbgr.mr_n73576800)
print v(xbgr.mr_n73577232)
print v(xbgr.mr_n73577552)
print v(xbgr.mr_n73577664)
print v(xbgr.mr_n73578096)
print v(xbgr.mr_n73578416)
print v(xbgr.mr_n73578528)
print v(xbgr.mr_n73578848)
print v(xbgr.mr_n73578960)
print v(xbgr.mr_n73579280)
print v(xbgr.mr_n73580144)
print v(xbgr.mr_n73580576)
print v(xbgr.mr_n73581440)
print v(xbgr.mr_n73581552)
print v(xbgr.mr_n73581872)
print v(xbgr.mr_n73581984)
print v(xbgr.mr_n73582304)
print v(xbgr.mr_n73582416)
print v(xbgr.mr_n73583168)
print v(xbgr.mr_n73583600)
print v(xbgr.mr_n73583712)
print v(xbgr.mr_n73584032)
print v(xbgr.mr_n73584464)
print v(xbgr.mr_n73584576)
print v(xbgr.mr_n73584896)
print v(xbgr.mr_n73585008)
print v(xbgr.mr_n73585328)
print v(xbgr.mr_n73585440)
print v(xbgr.mr_n73585760)
print v(xbgr.mr_n73585872)
print v(xbgr.mr_n73586192)
print v(xbgr.mr_n73586304)
print v(xbgr.mr_n73586624)
print v(xbgr.mr_n73588032)
print v(xbgr.mr_n73588352)
print v(xbgr.mr_n73588464)
print v(xbgr.mr_n73588896)
print v(xbgr.mr_n73589216)
print v(xbgr.mr_n73589328)
print v(xbgr.mr_n73589648)
print v(xbgr.mr_n73590080)
print v(xbgr.mr_n73590944)
print v(xbgr.mr_n73591808)
print v(xbgr.mr_n73592672)
print v(xbgr.mr_n73593536)
print v(xbgr.mr_n73594400)
print v(xbgr.mr_n73595696)
print v(xbgr.mr_n73596128)
print v(xbgr.mr_n73596240)
print v(xbgr.mr_n73596560)
print v(xbgr.mr_n73596992)
print v(xbgr.mr_n73597104)
print v(xbgr.mr_n73597424)
print v(xbgr.mr_n73598288)
print v(xbgr.mr_n73598400)
print v(xbgr.mr_n73598720)
print v(xbgr.mr_n73598832)
print v(xbgr.mr_n73599152)
print v(xbgr.mr_n73600016)
print v(xbgr.mr_n73600128)
print v(xbgr.mr_n73600992)
print v(xbgr.mr_n73601424)
print v(xbgr.mr_n73601856)
print v(xbgr.mr_n73602608)
print v(xbgr.mr_n73602720)
print v(xbgr.mr_n73603152)
print v(xbgr.mr_n73603904)
print v(xbgr.mr_n73604336)
print v(xbgr.mr_n73604448)
print v(xbgr.mr_n73604880)
print v(xbgr.mr_n73605632)
print v(xbgr.mr_n73605744)
print v(xbgr.mr_n73606064)
print v(xbgr.mr_n73606176)
print v(xbgr.mr_n73606496)
print v(xbgr.mr_n73606608)
print v(xbgr.mr_n73606928)
print v(xbgr.mr_n73607040)
print v(xbgr.mr_n73607360)
print v(xbgr.mr_n73607472)
print v(xbgr.mr_n73607792)
print v(xbgr.mr_n73607904)
print v(xbgr.mr_n73608224)
print v(xbgr.mr_n73608336)
print v(xbgr.mr_n73608656)
print v(xbgr.mr_n73608768)
print v(xbgr.mr_n73609088)
print v(xbgr.mr_n73609200)
print v(xbgr.mr_n73609520)
print v(xbgr.mr_n73609632)
print v(xbgr.mr_n73609952)
print v(xbgr.mr_n73610064)
print v(xbgr.mr_n73610384)
print v(xbgr.mr_n73610496)
print v(xbgr.mr_n73610816)
print v(xbgr.mr_n73610928)
print v(xbgr.mr_n73611248)
print v(xbgr.mr_n73611360)
print v(xbgr.mr_n73611792)
print v(xbgr.mr_n73612112)
print v(xbgr.mr_n73612224)
print v(xbgr.mr_n73612656)
print v(xbgr.mr_n73612976)
print v(xbgr.mr_n73613088)
print v(xbgr.mr_n73613840)
print v(xbgr.mr_n73614272)
print v(xbgr.mr_n73615136)
print v(xbgr.mr_n73616000)
print v(xbgr.mr_n73616864)
print v(xbgr.mr_n73616976)
print v(xbgr.mr_n73617296)
print v(xbgr.mr_n73617408)
print v(xbgr.mr_n73617728)
print v(xbgr.mr_n73617840)
print v(xbgr.mr_n73618160)
print v(xbgr.mr_n73618272)
print v(xbgr.mr_n73619024)
print v(xbgr.mr_n73619888)
print v(xbgr.mr_n73620752)
print v(xbgr.mr_n73621616)
print v(xbgr.mr_n73622912)
print v(xbgr.mr_n73623024)
print v(xbgr.mr_n73623344)
print v(xbgr.mr_n73623456)
print v(xbgr.mr_n73623776)
print v(xbgr.mr_n73623888)
print v(xbgr.mr_n73624320)
print v(xbgr.mr_n73624752)
print v(xbgr.mr_n73625184)
print v(xbgr.mr_n73625504)
print v(xbgr.mr_n73625616)
print v(xbgr.mr_n73626048)
print v(xbgr.mr_n73626368)
print v(xbgr.mr_n73626480)
print v(xbgr.mr_n73626800)
print v(xbgr.mr_n73626912)
print v(xbgr.mr_n73627232)
print v(xbgr.mr_n73627344)
print v(xbgr.mr_n73627664)
print v(xbgr.mr_n73627776)
print v(xbgr.mr_n73628096)
print v(xbgr.mr_n73628208)
print v(xbgr.mr_n73628640)
print v(xbgr.mr_n73628960)
print v(xbgr.mr_n73629072)
print v(xbgr.mr_n73629504)
print v(xbgr.mr_n73629824)
print v(xbgr.mr_n73630256)
print v(xbgr.mr_n73630368)
print v(xbgr.mr_n73630800)
print v(xbgr.mr_n73631120)
print v(xbgr.mr_n73631232)
print v(xbgr.mr_n73631664)
print v(xbgr.mr_n73631984)
print v(xbgr.mr_n73632096)
print v(xbgr.mr_n73632528)
print v(xbgr.mr_n73632848)
print v(xbgr.mr_n73632960)
print v(xbgr.mr_n73633280)
print v(xbgr.mr_n73633392)
print v(xbgr.mr_n73633712)
print v(xbgr.mr_n73634576)
print v(xbgr.mr_n73635440)
print v(xbgr.mr_n73636304)
print v(xbgr.mr_n73637168)
print v(xbgr.mr_n73638032)
print v(xbgr.mr_n73638896)
print v(xbgr.mr_n73639008)
print v(xbgr.mr_n73639760)
print v(xbgr.mr_n73640624)
print v(xbgr.mr_n73641488)
print v(xbgr.mr_n73642352)
print v(xbgr.mr_n73643216)
print v(xbgr.mr_n73644080)
print v(xbgr.mr_n73644192)
print v(xbgr.mr_n73644512)
print v(xbgr.mr_n73644624)
print v(xbgr.mr_n73644944)
print v(xbgr.mr_n73645056)
print v(xbgr.mr_n73645376)
print v(xbgr.mr_n73645488)
print v(xbgr.mr_n73645808)
print v(xbgr.mr_n73646672)
print v(xbgr.mr_n73647536)
print v(xbgr.mr_n73648400)
print v(xbgr.mr_n73648512)
print v(xbgr.mr_n73648832)
print v(xbgr.mr_n73648944)
print v(xbgr.mr_n73649264)
print v(xbgr.mr_n73649376)
print v(xbgr.mr_n73649696)
print v(xbgr.mr_n73650560)
print v(xbgr.mr_n73651424)
print v(xbgr.mr_n73652288)
print v(xbgr.mr_n73652400)
print v(xbgr.mr_n73652720)
print v(xbgr.mr_n73652832)
print v(xbgr.mr_n73653152)
print v(xbgr.mr_n73653264)
print v(xbgr.mr_n73653696)
print v(xbgr.mr_n73654128)
print v(xbgr.mr_n73654560)
print v(xbgr.mr_n73654880)
print v(xbgr.mr_n73654992)
print v(xbgr.mr_n73655312)
print v(xbgr.mr_n73655424)
print v(xbgr.mr_n73655744)
print v(xbgr.mr_n73655856)
print v(xbgr.mr_n73656176)
print v(xbgr.mr_n73656288)
print v(xbgr.mr_n73656608)
print v(xbgr.mr_n73656720)
print v(xbgr.mr_n73657040)
print v(xbgr.mr_n73657152)
print v(xbgr.mr_n73657472)
print v(xbgr.mr_n73657584)
print v(xbgr.mr_n73657904)
print v(xbgr.mr_n73658016)
print v(xbgr.mr_n73658336)
print v(xbgr.mr_n73658448)
print v(xbgr.mr_n73658880)
print v(xbgr.mr_n73659200)
print v(xbgr.mr_n73659312)
print v(xbgr.mr_n73659632)
print v(xbgr.mr_n73660064)
print v(xbgr.mr_n73660176)
print v(xbgr.mr_n73660496)
print v(xbgr.mr_n73660608)
print v(xbgr.mr_n73660928)
print v(xbgr.mr_n73661040)
print v(xbgr.mr_n73661360)
print v(xbgr.mr_n73661472)
print v(xbgr.mr_n73662224)
print v(xbgr.mr_n73662336)
print v(xbgr.mr_n73663088)
print v(xbgr.mr_n73663952)
print v(xbgr.mr_n73664064)
print v(xbgr.mr_n73664384)
print v(xbgr.mr_n73664496)
print v(xbgr.mr_n73664816)
print v(xbgr.mr_n73664928)
print v(xbgr.mr_n73665248)
print v(xbgr.mr_n73665360)
print v(xbgr.mr_n73665792)
print v(xbgr.mr_n73666224)
print v(xbgr.mr_n73666544)
print v(xbgr.mr_n73666656)
print v(xbgr.mr_n73666976)
print v(xbgr.mr_n73667088)
print v(xbgr.mr_n73667408)
print v(xbgr.mr_n73668272)
print v(xbgr.mr_n73669568)
print v(xbgr.mr_n73670432)
print v(xbgr.mr_n73670544)
print v(xbgr.mr_n73670864)
print v(xbgr.mr_n73670976)
print v(xbgr.mr_n73671296)
print v(xbgr.mr_n73671408)
print v(xbgr.mr_n73671728)
print v(xbgr.mr_n73671840)
print v(xbgr.mr_n73672272)
print v(xbgr.mr_n73672592)
print v(xbgr.mr_n73672704)
print v(xbgr.mr_n73673024)
print v(xbgr.mr_n73673136)
print v(xbgr.mr_n73673456)
print v(xbgr.mr_n73673568)
print v(xbgr.mr_n73674000)
print v(xbgr.mr_n73674320)
print v(xbgr.mr_n73674432)
print v(xbgr.mr_n73674752)
print v(xbgr.mr_n73674864)
print v(xbgr.mr_n73675184)
print v(xbgr.mr_n73676048)
print v(xbgr.mr_n73676912)
print v(xbgr.mr_n73677776)
print v(xbgr.mr_n73678640)
print v(xbgr.mr_n73678752)
print v(xbgr.mr_n73679072)
print v(xbgr.mr_n73679184)
print v(xbgr.mr_n73679616)
print v(xbgr.mr_n73680048)
print v(xbgr.mr_n73680368)
print v(xbgr.mr_n73680480)
print v(xbgr.mr_n73680800)
print v(xbgr.mr_n73681664)
print v(xbgr.mr_n73682528)
print v(xbgr.mr_n73682640)
print v(xbgr.mr_n73682960)
print v(xbgr.mr_n73683072)
print v(xbgr.mr_n73683392)
print v(xbgr.mr_n73683504)
print v(xbgr.mr_n73683824)
print v(xbgr.mr_n73683936)
print v(xbgr.mr_n73684256)
print v(xbgr.mr_n73684368)
print v(xbgr.mr_n73684800)
print v(xbgr.mr_n73685120)
print v(xbgr.mr_n73685232)
print v(xbgr.mr_n73685984)
print v(xbgr.mr_n73686848)
print v(xbgr.mr_n73686960)
print v(xbgr.mr_n73687280)
print v(xbgr.mr_n73687392)
print v(xbgr.mr_n73687824)
print v(xbgr.mr_n73688144)
print v(xbgr.mr_n73688256)
print v(xbgr.mr_n73688576)
print v(xbgr.mr_n73688688)
print v(xbgr.mr_n73689008)
print v(xbgr.mr_n73689120)
print v(xbgr.mr_n73689440)
print v(xbgr.mr_n73689552)
print v(xbgr.mr_n73689872)
print v(xbgr.mr_n73689984)
print v(xbgr.mr_n73690304)
print v(xbgr.mr_n73691168)
print v(xbgr.mr_n73692144)
print v(xbgr.mr_n73692464)
print v(xbgr.mr_n73693328)
print v(xbgr.mr_n73694192)
print v(xbgr.mr_n73695056)
print v(xbgr.mr_n73695488)
print v(xbgr.mr_n73695920)
print v(xbgr.mr_n73696032)
print v(xbgr.mr_n73696352)
print v(xbgr.mr_n73696464)
print v(xbgr.mr_n73696784)
print v(xbgr.mr_n73696896)
print v(xbgr.mr_n73697216)
print v(xbgr.mr_n73697328)
print v(xbgr.mr_n73697648)
print v(xbgr.mr_n73697760)
print v(xbgr.mr_n73698080)
print v(xbgr.mr_n73698192)
print v(xbgr.mr_n73698512)
print v(xbgr.mr_n73699376)
print v(xbgr.mr_n73700240)
print v(xbgr.mr_n73700352)
print v(xbgr.mr_n73700672)
print v(xbgr.mr_n73700784)
print v(xbgr.mr_n73701104)
print v(xbgr.mr_n73701216)
print v(xbgr.mr_n73701536)
print v(xbgr.mr_n73701648)
print v(xbgr.mr_n73703264)
print v(xbgr.mr_n73704128)
print v(xbgr.mr_n73704240)
print v(xbgr.mr_n73704560)
print v(xbgr.mr_n73704672)
print v(xbgr.mr_n73704992)
print v(xbgr.mr_n73705424)
print v(xbgr.mr_n73705536)
print v(xbgr.mr_n73705856)
print v(xbgr.mr_n73705968)
print v(xbgr.mr_n73706288)
print v(xbgr.mr_n73706400)
print v(xbgr.mr_n73706832)
print v(xbgr.mr_n73707152)
print v(xbgr.mr_n73707264)
print v(xbgr.mr_n73707696)
print v(xbgr.mr_n73708448)
print v(xbgr.mr_n73709312)
print v(xbgr.mr_n73710608)
print v(xbgr.mr_n73710720)
print v(xbgr.mr_n73711152)
print v(xbgr.mr_n73711472)
print v(xbgr.mr_n73712336)
print v(xbgr.mr_n73713200)
print v(xbgr.mr_n73713632)
print v(xbgr.mr_n73714928)
print v(xbgr.mr_n73715792)
print v(xbgr.mr_n73716224)
print v(xbgr.mr_n73717088)
print v(xbgr.mr_n73718384)
print v(xbgr.mr_n73718496)
print v(xbgr.mr_n73718816)
print v(xbgr.mr_n73718928)
print v(xbgr.mr_n73719248)
print v(xbgr.mr_n73719360)
print v(xbgr.mr_n73719680)
print v(xbgr.mr_n73719792)
print v(xbgr.mr_n73720112)
print v(xbgr.mr_n73720224)
print v(xbgr.mr_n73720544)
print v(xbgr.mr_n73720656)
print v(xbgr.mr_n73720976)
print v(xbgr.mr_n73721088)
print v(xbgr.mr_n73721840)
print v(xbgr.mr_n73721952)
print v(xbgr.mr_n73722384)
print v(xbgr.mr_n73722704)
print v(xbgr.mr_n73722816)
print v(xbgr.mr_n73723136)
print v(xbgr.mr_n73723248)
print v(xbgr.mr_n73723568)
print v(xbgr.mr_n73723680)
print v(xbgr.mr_n73724000)
print v(xbgr.mr_n73724112)
print v(xbgr.mr_n73724432)
print v(xbgr.mr_n73724544)
print v(xbgr.mr_n73724976)
print v(xbgr.mr_n73725296)
print v(xbgr.mr_n73725840)
print v(xbgr.mr_n73726160)
print v(xbgr.mr_n73726272)
print v(xbgr.mr_n73726704)
print v(xbgr.mr_n73727024)
print v(xbgr.mr_n73727136)
print v(xbgr.mr_n73727568)
print v(xbgr.mr_n73727888)
print v(xbgr.mr_n73728000)
print v(xbgr.mr_n73728320)
print v(xbgr.mr_n73728432)
print v(xbgr.mr_n73728752)
print v(xbgr.mr_n73728864)
print v(xbgr.mr_n73729184)
print v(xbgr.mr_n73729296)
print v(xbgr.mr_n73729616)
print v(xbgr.mr_n73729728)
print v(xbgr.mr_n73730048)
print v(xbgr.mr_n73730160)
print v(xbgr.mr_n73730480)
print v(xbgr.mr_n73730592)
print v(xbgr.mr_n73730912)
print v(xbgr.mr_n73731024)
print v(xbgr.mr_n73731344)
print v(xbgr.mr_n73732208)
print v(xbgr.mr_n73732320)
print v(xbgr.mr_n73732640)
print v(xbgr.mr_n73732752)
print v(xbgr.mr_n73733072)
print v(xbgr.mr_n73733184)
print v(xbgr.mr_n73733504)
print v(xbgr.mr_n73733616)
print v(xbgr.mr_n73733936)
print v(xbgr.mr_n73734800)
print v(xbgr.mr_n73735664)
print v(xbgr.mr_n73736528)
print v(xbgr.mr_n73737072)
print v(xbgr.mr_n73737504)
print v(xbgr.mr_n73737824)
print v(xbgr.mr_n73737936)
print v(xbgr.mr_n73738256)
print v(xbgr.mr_n73738368)
print v(xbgr.mr_n73738688)
print v(xbgr.mr_n73738800)
print v(xbgr.mr_n73739120)
print v(xbgr.mr_n73739232)
print v(xbgr.mr_n73739552)
print v(xbgr.mr_n73740848)
print v(xbgr.mr_n73741712)
print v(xbgr.mr_n73742688)
print v(xbgr.mr_n73743120)
print v(xbgr.mr_n73743440)
print v(xbgr.mr_n73743872)
print v(xbgr.mr_n73744736)
print v(xbgr.mr_n73745600)
print v(xbgr.mr_n73745712)
print v(xbgr.mr_n73746032)
print v(xbgr.mr_n73746144)
print v(xbgr.mr_n73746464)
print v(xbgr.mr_n73746576)
print v(xbgr.mr_n73746896)
print v(xbgr.mr_n73747008)
print v(xbgr.mr_n73748192)
print v(xbgr.mr_n73748304)
print v(xbgr.mr_n73748624)
print v(xbgr.mr_n73748736)
print v(xbgr.mr_n73749056)
print v(xbgr.mr_n73749168)
print v(xbgr.mr_n73749600)
print v(xbgr.mr_n73749920)
print v(xbgr.mr_n73750352)
print v(xbgr.mr_n73750464)
print v(xbgr.mr_n73750896)
print v(xbgr.mr_n73751216)
print v(xbgr.mr_n73752080)
print v(xbgr.mr_n73752192)
print v(xbgr.mr_n73752624)
print v(xbgr.mr_n73752944)
print v(xbgr.mr_n73753056)
print v(xbgr.mr_n73753808)
print v(xbgr.mr_n73754352)
print v(xbgr.mr_n73754672)
print v(xbgr.mr_n73754784)
print v(xbgr.mr_n73755104)
print v(xbgr.mr_n73755216)
print v(xbgr.mr_n73755536)
print v(xbgr.mr_n73755648)
print v(xbgr.mr_n73755968)
print v(xbgr.mr_n73756400)
print v(xbgr.mr_n73756512)
print v(xbgr.mr_n73756832)
print v(xbgr.mr_n73756944)
print v(xbgr.mr_n73757264)
print v(xbgr.mr_n73757376)
print v(xbgr.mr_n73758128)
print v(xbgr.mr_n73758240)
print v(xbgr.mr_n73758672)
print v(xbgr.mr_n73758992)
print v(xbgr.mr_n73759104)
print v(xbgr.mr_n73759424)
print v(xbgr.mr_n73759536)
print v(xbgr.mr_n73759856)
print v(xbgr.mr_n73759968)
print v(xbgr.mr_n73760288)
print v(xbgr.mr_n73761152)
print v(xbgr.mr_n73761584)
print v(xbgr.mr_n73762016)
print v(xbgr.mr_n73762128)
print v(xbgr.mr_n73762448)
print v(xbgr.mr_n73762560)
print v(xbgr.mr_n73763312)
print v(xbgr.mr_n73763424)
print v(xbgr.mr_n73763744)
print v(xbgr.mr_n73763856)
print v(xbgr.mr_n73764608)
print v(xbgr.mr_n73765472)
print v(xbgr.mr_n73765584)
print v(xbgr.mr_n73765904)
print v(xbgr.mr_n73766768)
print v(xbgr.mr_n73766880)
print v(xbgr.mr_n73767200)
print v(xbgr.mr_n73767312)
print v(xbgr.mr_n73767632)
print v(xbgr.mr_n73767744)
print v(xbgr.mr_n73768064)
print v(xbgr.mr_n73768176)
print v(xbgr.mr_n73768496)
print v(xbgr.mr_n73768608)
print v(xbgr.mr_n73768928)
print v(xbgr.mr_n73769040)
print v(xbgr.mr_n73769360)
print v(xbgr.mr_n73769472)
print v(xbgr.mr_n73769904)
print v(xbgr.mr_n73770336)
print v(xbgr.mr_n73770656)
print v(xbgr.mr_n73771088)
print v(xbgr.mr_n73771200)
print v(xbgr.mr_n73772384)
print v(xbgr.mr_n73774112)
print v(xbgr.mr_n73774224)
print v(xbgr.mr_n73774656)
print v(xbgr.mr_n73774976)
print v(xbgr.mr_n73775088)
print v(xbgr.mr_n73775408)
print v(xbgr.mr_n73775520)
print v(xbgr.mr_n73775952)
print v(xbgr.mr_n73776272)
print v(xbgr.mr_n73776384)
print v(xbgr.mr_n73776704)
print v(xbgr.mr_n73777136)
print v(xbgr.mr_n73777248)
print v(xbgr.mr_n73778000)
print v(xbgr.mr_n73778112)
print v(xbgr.mr_n73778432)
print v(xbgr.mr_n73778544)
print v(xbgr.mr_n73778864)
print v(xbgr.mr_n73778976)
print v(xbgr.mr_n73779296)
print v(xbgr.mr_n73779408)
print v(xbgr.mr_n73779728)
print v(xbgr.mr_n73779840)
print v(xbgr.mr_n73780160)
print v(xbgr.mr_n73781024)
print v(xbgr.mr_n73781888)
print v(xbgr.mr_n73782752)
print v(xbgr.mr_n73782864)
print v(xbgr.mr_n73783184)
print v(xbgr.mr_n73783616)
print v(xbgr.mr_n73783728)
print v(xbgr.mr_n73784048)
print v(xbgr.mr_n73784160)
print v(xbgr.mr_n73784480)
print v(xbgr.mr_n73784592)
print v(xbgr.mr_n73784912)
print v(xbgr.mr_n73785776)
print v(xbgr.mr_n73786752)
print v(xbgr.mr_n73787072)
print v(xbgr.mr_n73787184)
print v(xbgr.mr_n73787504)
print v(xbgr.mr_n73787616)
print v(xbgr.mr_n73787936)
print v(xbgr.mr_n73788048)
print v(xbgr.mr_n73788368)
print v(xbgr.mr_n73788480)
print v(xbgr.mr_n73788800)
print v(xbgr.mr_n73789344)
print v(xbgr.mr_n73789776)
print v(xbgr.mr_n73790208)
print v(xbgr.mr_n73791392)
print v(xbgr.mr_n73791504)
print v(xbgr.mr_n73791824)
print v(xbgr.mr_n73791936)
print v(xbgr.mr_n73792256)
print v(xbgr.mr_n73793120)
print v(xbgr.mr_n73793232)
print v(xbgr.mr_n73793552)
print v(xbgr.mr_n73793664)
print v(xbgr.mr_n73793984)
print v(xbgr.mr_n73794416)
print v(xbgr.mr_n73795280)
print v(xbgr.mr_n73796576)
print v(xbgr.mr_n73796688)
print v(xbgr.mr_n73797008)
print v(xbgr.mr_n73797120)
print v(xbgr.mr_n73797440)
print v(xbgr.mr_n73797872)
print v(xbgr.mr_n73798736)
print v(xbgr.mr_n73799168)
print v(xbgr.mr_n73799280)
print v(xbgr.mr_n73799600)
print v(xbgr.mr_n73799712)
print v(xbgr.mr_n73800032)
print v(xbgr.mr_n73800144)
print v(xbgr.mr_n73800464)
print v(xbgr.mr_n73800576)
print v(xbgr.mr_n73801328)
print v(xbgr.mr_n73801440)
print v(xbgr.mr_n73802192)
print v(xbgr.mr_n73803168)
print v(xbgr.mr_n73803488)
print v(xbgr.mr_n73803600)
print v(xbgr.mr_n73803920)
print v(xbgr.mr_n73804032)
print v(xbgr.mr_n73804352)
print v(xbgr.mr_n73804784)
print v(xbgr.mr_n73805648)
print v(xbgr.mr_n73805760)
print v(xbgr.mr_n73806080)
print v(xbgr.mr_n73806192)
print v(xbgr.mr_n73806512)
print v(xbgr.mr_n73806624)
print v(xbgr.mr_n73806944)
print v(xbgr.mr_n73807056)
print v(xbgr.mr_n73807376)
print v(xbgr.mr_n73807488)
print v(xbgr.mr_n73807920)
print v(xbgr.mr_n73808672)
print v(xbgr.mr_n73809648)
print v(xbgr.mr_n73810080)
print v(xbgr.mr_n73810400)
print v(xbgr.mr_n73810832)
print v(xbgr.mr_n73811808)
print v(xbgr.mr_n73812240)
print v(xbgr.mr_n73812560)
print v(xbgr.mr_n73812992)
print v(xbgr.mr_n73813104)
print v(xbgr.mr_n73813424)
print v(xbgr.mr_n73813536)
print v(xbgr.mr_n73813856)
print v(xbgr.mr_n73813968)
print v(xbgr.mr_n73814288)
print v(xbgr.mr_n73814400)
print v(xbgr.mr_n73815152)
print v(xbgr.mr_n73816016)
print v(xbgr.mr_n73817312)
print v(xbgr.mr_n73817424)
print v(xbgr.mr_n73817744)
print v(xbgr.mr_n73817856)
print v(xbgr.mr_n73818176)
print v(xbgr.mr_n73818288)
print v(xbgr.mr_n73818608)
print v(xbgr.mr_n73818720)
print v(xbgr.mr_n73819040)
print v(xbgr.mr_n73819152)
print v(xbgr.mr_n73819472)
print v(xbgr.mr_n73819904)
print v(xbgr.mr_n73820016)
print v(xbgr.mr_n73820336)
print v(xbgr.mr_n73820448)
print v(xbgr.mr_n73820768)
print v(xbgr.mr_n73820880)
print v(xbgr.mr_n73821200)
print v(xbgr.mr_n73821312)
print v(xbgr.mr_n73821632)
print v(xbgr.mr_n73821744)
print v(xbgr.mr_n73822064)
print v(xbgr.mr_n73822176)
print v(xbgr.mr_n73822496)
print v(xbgr.mr_n73822608)
print v(xbgr.mr_n73822928)
print v(xbgr.mr_n73823040)
print v(xbgr.mr_n73823360)
print v(xbgr.mr_n73823472)
print v(xbgr.mr_n73823904)
print v(xbgr.mr_n73824224)
print v(xbgr.mr_n73824336)
print v(xbgr.mr_n73824768)
print v(xbgr.mr_n73825200)
print v(xbgr.mr_n73825520)
print v(xbgr.mr_n73825632)
print v(xbgr.mr_n73825952)
print v(xbgr.mr_n73826064)
print v(xbgr.mr_n73826384)
print v(xbgr.mr_n73826496)
print v(xbgr.mr_n73826816)
print v(xbgr.mr_n73826928)
print v(xbgr.mr_n73827680)
print v(xbgr.mr_n73827792)
print v(xbgr.mr_n73828224)
print v(xbgr.mr_n73828544)
print v(xbgr.mr_n73829088)
print v(xbgr.mr_n73829408)
print v(xbgr.mr_n73830272)
print v(xbgr.mr_n73830384)
print v(xbgr.mr_n73830704)
print v(xbgr.mr_n73831136)
print v(xbgr.mr_n73831568)
print v(xbgr.mr_n73832000)
print v(xbgr.mr_n73832112)
print v(xbgr.mr_n73832864)
print v(xbgr.mr_n73832976)
print v(xbgr.mr_n73833296)
print v(xbgr.mr_n73833408)
print v(xbgr.mr_n73833728)
print v(xbgr.mr_n73834160)
print v(xbgr.mr_n73834272)
print v(xbgr.mr_n73834592)
print v(xbgr.mr_n73834704)
print v(xbgr.mr_n73835024)
print v(xbgr.mr_n73835136)
print v(xbgr.mr_n73835456)
print v(xbgr.mr_n73835888)
print v(xbgr.mr_n73836752)
print v(xbgr.mr_n73837616)
print v(xbgr.mr_n73838912)
print v(xbgr.mr_n73839776)
print v(xbgr.mr_n73840640)
print v(xbgr.mr_n73841504)
print v(xbgr.mr_n73841616)
print v(xbgr.mr_n73841936)
print v(xbgr.mr_n73842800)
print v(xbgr.mr_n73843664)
print v(xbgr.mr_n73844528)
print v(xbgr.mr_n73844640)
print v(xbgr.mr_n73844960)
print v(xbgr.mr_n73845072)
print v(xbgr.mr_n73845392)
print v(xbgr.mr_n73845504)
print v(xbgr.mr_n73845824)
print v(xbgr.mr_n73845936)
print v(xbgr.mr_n73846256)
print v(xbgr.mr_n73846368)
print v(xbgr.mr_n73846688)
print v(xbgr.mr_n73846800)
print v(xbgr.mr_n73848416)
print v(xbgr.mr_n73849392)
print v(xbgr.mr_n73849824)
print v(xbgr.mr_n73850256)
print v(xbgr.mr_n73850576)
print v(xbgr.mr_n73850688)
print v(xbgr.mr_n73851008)
print v(xbgr.mr_n73851120)
print v(xbgr.mr_n73851440)
print v(xbgr.mr_n73851552)
print v(xbgr.mr_n73851872)
print v(xbgr.mr_n73851984)
print v(xbgr.mr_n73852304)
print v(xbgr.mr_n73852416)
print v(xbgr.mr_n73852736)
print v(xbgr.mr_n73852848)
print v(xbgr.mr_n73853168)
print v(xbgr.mr_n73853280)
print v(xbgr.mr_n73853712)
print v(xbgr.mr_n73854032)
print v(xbgr.mr_n73854144)
print v(xbgr.mr_n73854576)
print v(xbgr.mr_n73855008)
print v(xbgr.mr_n73856192)
print v(xbgr.mr_n73856304)
print v(xbgr.mr_n73856624)
print v(xbgr.mr_n73856736)
print v(xbgr.mr_n73857056)
print v(xbgr.mr_n73857168)
print v(xbgr.mr_n73857488)
print v(xbgr.mr_n73857600)
print v(xbgr.mr_n73857920)
print v(xbgr.mr_n73858032)
print v(xbgr.mr_n73858352)
print v(xbgr.mr_n73858784)
print v(xbgr.mr_n73858896)
print v(xbgr.mr_n73859216)
print v(xbgr.mr_n73859328)
print v(xbgr.mr_n73859648)
print v(xbgr.mr_n73859760)
print v(xbgr.mr_n73860080)
print v(xbgr.mr_n73860192)
print v(xbgr.mr_n73860624)
print v(xbgr.mr_n73860944)
print v(xbgr.mr_n73861376)
print v(xbgr.mr_n73862240)
print v(xbgr.mr_n73862352)
print v(xbgr.mr_n73862672)
print v(xbgr.mr_n73863104)
print v(xbgr.mr_n73863536)
print v(xbgr.mr_n73864080)
print v(xbgr.mr_n73864400)
print v(xbgr.mr_n73865264)
print v(xbgr.mr_n73865376)
print v(xbgr.mr_n73865696)
print v(xbgr.mr_n73865808)
print v(xbgr.mr_n73866240)
print v(xbgr.mr_n73866992)
print v(xbgr.mr_n73867424)
print v(xbgr.mr_n73867856)
print v(xbgr.mr_n73868288)
print v(xbgr.mr_n73868400)
print v(xbgr.mr_n73869584)
print v(xbgr.mr_n73870448)
print v(xbgr.mr_n73871424)
print v(xbgr.mr_n73871744)
print v(xbgr.mr_n73871856)
print v(xbgr.mr_n73872288)
print v(xbgr.mr_n73872608)
print v(xbgr.mr_n73872720)
print v(xbgr.mr_n73873040)
print v(xbgr.mr_n73873152)
print v(xbgr.mr_n73873472)
print v(xbgr.mr_n73873584)
print v(xbgr.mr_n73873904)
print v(xbgr.mr_n73874016)
print v(xbgr.mr_n73874336)
print v(xbgr.mr_n73874448)
print v(xbgr.mr_n73874768)
print v(xbgr.mr_n73874880)
print v(xbgr.mr_n73875312)
print v(xbgr.mr_n73875744)
print v(xbgr.mr_n73876176)
print v(xbgr.mr_n73876928)
print v(xbgr.mr_n73877360)
print v(xbgr.mr_n73878224)
print v(xbgr.mr_n73879088)
print v(xbgr.mr_n73880816)
print v(xbgr.mr_n73881680)
print v(xbgr.mr_n73881792)
print v(xbgr.mr_n73882544)
print v(xbgr.mr_n73882656)
print v(xbgr.mr_n73882976)
print v(xbgr.mr_n73883088)
print v(xbgr.mr_n73883408)
print v(xbgr.mr_n73883520)
print v(xbgr.mr_n73885568)
print v(xbgr.mr_n73885680)
print v(xbgr.mr_n73886000)
print v(xbgr.mr_n73886112)
print v(xbgr.mr_n73886432)
print v(xbgr.mr_n73886544)
print v(xbgr.mr_n73886864)
print v(xbgr.mr_n73886976)
print v(xbgr.mr_n73887296)
print v(xbgr.mr_n73887408)
print v(xbgr.mr_n73887728)
print v(xbgr.mr_n73887840)
print v(xbgr.mr_n73888160)
print v(xbgr.mr_n73888272)
print v(xbgr.mr_n73888704)
print v(xbgr.mr_n73889024)
print v(xbgr.mr_n73889136)
print v(xbgr.mr_n73889568)
print v(xbgr.mr_n73889888)
print v(xbgr.mr_n73890000)
print v(xbgr.mr_n73890432)
print v(xbgr.mr_n73890752)
print v(xbgr.mr_n73890864)
print v(xbgr.mr_n73891184)
print v(xbgr.mr_n73891296)
print v(xbgr.mr_n73891616)
print v(xbgr.mr_n73891728)
print v(xbgr.mr_n73892048)
print v(xbgr.mr_n73892160)
print v(xbgr.mr_n73892480)
print v(xbgr.mr_n73892592)
print v(xbgr.mr_n73892912)
print v(xbgr.mr_n73893024)
print v(xbgr.mr_n73893344)
print v(xbgr.mr_n73893456)
print v(xbgr.mr_n73893776)
print v(xbgr.mr_n73893888)
print v(xbgr.mr_n73894208)
print v(xbgr.mr_n73894320)
print v(xbgr.mr_n73894640)
print v(xbgr.mr_n73894752)
print v(xbgr.mr_n73895072)
print v(xbgr.mr_n73895184)
print v(xbgr.mr_n73895504)
print v(xbgr.mr_n73895616)
print v(xbgr.mr_n73895936)
print v(xbgr.mr_n73896048)
print v(xbgr.mr_n73896368)
print v(xbgr.mr_n73896480)
print v(xbgr.mr_n73896800)
print v(xbgr.mr_n73896912)
print v(xbgr.mr_n73897232)
print v(xbgr.mr_n73897344)
print v(xbgr.mr_n73897664)
print v(xbgr.mr_n73897776)
print v(xbgr.mr_n73898096)
print v(xbgr.mr_n73898208)
print v(xbgr.mr_n73898640)
print v(xbgr.mr_n73898960)
print v(xbgr.mr_n73899072)
print v(xbgr.mr_n73899504)
print v(xbgr.mr_n73899824)
print v(xbgr.mr_n73899936)
print v(xbgr.mr_n73900368)
print v(xbgr.mr_n73900688)
print v(xbgr.mr_n73901552)
print v(xbgr.mr_n73902416)
print v(xbgr.mr_n73903280)
print v(xbgr.mr_n73904144)
print v(xbgr.mr_n73905008)
print v(xbgr.mr_n73905872)
print v(xbgr.mr_n73905984)
print v(xbgr.mr_n73906304)
print v(xbgr.mr_n73906416)
print v(xbgr.mr_n73906736)
print v(xbgr.mr_n73906848)
print v(xbgr.mr_n73907168)
print v(xbgr.mr_n73907280)
print v(xbgr.mr_n73907600)
print v(xbgr.mr_n73907712)
print v(xbgr.mr_n73908032)
print v(xbgr.mr_n73908144)
print v(xbgr.mr_n73908464)
print v(xbgr.mr_n73909328)
print v(xbgr.mr_n73910192)
print v(xbgr.mr_n73911056)
print v(xbgr.mr_n73911168)
print v(xbgr.mr_n73911488)
print v(xbgr.mr_n73911600)
print v(xbgr.mr_n73911920)
print v(xbgr.mr_n73912032)
print v(xbgr.mr_n73912464)
print v(xbgr.mr_n73912896)
print v(xbgr.mr_n73913328)
print v(xbgr.mr_n73913648)
print v(xbgr.mr_n73913760)
print v(xbgr.mr_n73914192)
print v(xbgr.mr_n73914512)
print v(xbgr.mr_n73914624)
print v(xbgr.mr_n73914944)
print v(xbgr.mr_n73915056)
print v(xbgr.mr_n73915376)
print v(xbgr.mr_n73915488)
print v(xbgr.mr_n73915808)
print v(xbgr.mr_n73915920)
print v(xbgr.mr_n73916240)
print v(xbgr.mr_n73916352)
print v(xbgr.mr_n73916672)
print v(xbgr.mr_n73916784)
print v(xbgr.mr_n73917216)
print v(xbgr.mr_n73917648)
print v(xbgr.mr_n73917968)
print v(xbgr.mr_n73918080)
print v(xbgr.mr_n73918512)
print v(xbgr.mr_n73918832)
print v(xbgr.mr_n73918944)
print v(xbgr.mr_n73919376)
print v(xbgr.mr_n73919696)
print v(xbgr.mr_n73919808)
print v(xbgr.mr_n73920240)
print v(xbgr.mr_n73920560)
print v(xbgr.mr_n73921424)
print v(xbgr.mr_n73922288)
print v(xbgr.mr_n73923152)
print v(xbgr.mr_n73924016)
print v(xbgr.mr_n73924880)
print v(xbgr.mr_n73924992)
print v(xbgr.mr_n73925312)
print v(xbgr.mr_n73925424)
print v(xbgr.mr_n73925744)
print v(xbgr.mr_n73925856)
print v(xbgr.mr_n73926176)
print v(xbgr.mr_n73926288)
print v(xbgr.mr_n73926608)
print v(xbgr.mr_n73927472)
print v(xbgr.mr_n73928336)
print v(xbgr.mr_n73929200)
print v(xbgr.mr_n73929312)
print v(xbgr.mr_n73929632)
print v(xbgr.mr_n73929744)
print v(xbgr.mr_n73930064)
print v(xbgr.mr_n73930176)
print v(xbgr.mr_n73930496)
print v(xbgr.mr_n73930608)
print v(xbgr.mr_n73930928)
print v(xbgr.mr_n73931040)
print v(xbgr.mr_n73931360)
print v(xbgr.mr_n73931472)
print v(xbgr.mr_n73931792)
print v(xbgr.mr_n73932656)
print v(xbgr.mr_n73933520)
print v(xbgr.mr_n73934384)
print v(xbgr.mr_n73935248)
print v(xbgr.mr_n73936112)
print v(xbgr.mr_n73936976)
print v(xbgr.mr_n73937840)
print v(xbgr.mr_n73938704)
print v(xbgr.mr_n73939568)
print v(xbgr.mr_n73939680)
print v(xbgr.mr_n73940000)
print v(xbgr.mr_n73940112)
print v(xbgr.mr_n73940432)
print v(xbgr.mr_n73940544)
print v(xbgr.mr_n73940864)
print v(xbgr.mr_n73940976)
print v(xbgr.mr_n73941296)
print v(xbgr.mr_n73941408)
print v(xbgr.mr_n73941728)
print v(xbgr.mr_n73941840)
print v(xbgr.mr_n73942160)
print v(xbgr.mr_n73942272)
print v(xbgr.mr_n73942592)
print v(xbgr.mr_n73942704)
print v(xbgr.mr_n73943024)
print v(xbgr.mr_n73943136)
print v(xbgr.mr_n73943456)
print v(xbgr.mr_n73943568)
print v(xbgr.mr_n73943888)
print v(xbgr.mr_n73944752)
print v(xbgr.mr_n73944864)
print v(xbgr.mr_n73945184)
print v(xbgr.mr_n73945296)
print v(xbgr.mr_n73945616)
print v(xbgr.mr_n73945728)
print v(xbgr.mr_n73946048)
print v(xbgr.mr_n73946160)
print v(xbgr.mr_n73946480)
print v(xbgr.mr_n73946592)
print v(xbgr.mr_n73946912)
print v(xbgr.mr_n73947024)
print v(xbgr.mr_n73947344)
print v(xbgr.mr_n73947456)
print v(xbgr.mr_n73947776)
print v(xbgr.mr_n73947888)
print v(xbgr.mr_n73948208)
print v(xbgr.mr_n73948320)
print v(xbgr.mr_n73948640)
print v(xbgr.mr_n73948752)
print v(xbgr.mr_n73949072)
print v(xbgr.mr_n73949184)
print v(xbgr.mr_n73949616)
print v(xbgr.mr_n73949936)
print v(xbgr.mr_n73950048)
print v(xbgr.mr_n73950480)
print v(xbgr.mr_n73950800)
print v(xbgr.mr_n73950912)
print v(xbgr.mr_n73951344)
print v(xbgr.mr_n73951664)
print v(xbgr.mr_n73951776)
print v(xbgr.mr_n73952208)
print v(xbgr.mr_n73952528)
print v(xbgr.mr_n73952640)
print v(xbgr.mr_n73952960)
print v(xbgr.mr_n73953072)
print v(xbgr.mr_n73953504)
print v(xbgr.mr_n73953936)
print v(xbgr.mr_n73954256)
print v(xbgr.mr_n73954368)
print v(xbgr.mr_n73954688)
print v(xbgr.mr_n73954800)
print v(xbgr.mr_n73955120)
print v(xbgr.mr_n73955232)
print v(xbgr.mr_n73955552)
print v(xbgr.mr_n73955664)
print v(xbgr.mr_n73955984)
print v(xbgr.mr_n73956096)
print v(xbgr.mr_n73956528)
print v(xbgr.mr_n73956848)
print v(xbgr.mr_n73956960)
print v(xbgr.mr_n73957392)
print v(xbgr.mr_n73957712)
print v(xbgr.mr_n73958576)
print v(xbgr.mr_n73959440)
print v(xbgr.mr_n73960304)
print v(xbgr.mr_n73961168)
print v(xbgr.mr_n73961280)
print v(xbgr.mr_n73961600)
print v(xbgr.mr_n73961712)
print v(xbgr.mr_n73962032)
print v(xbgr.mr_n73962144)
print v(xbgr.mr_n73962464)
print v(xbgr.mr_n73962576)
print v(xbgr.mr_n73962896)
print v(xbgr.mr_n73963760)
print v(xbgr.mr_n73964624)
print v(xbgr.mr_n73964736)
print v(xbgr.mr_n73965056)
print v(xbgr.mr_n73965168)
print v(xbgr.mr_n73965600)
print v(xbgr.mr_n73966032)
print v(xbgr.mr_n73966352)
print v(xbgr.mr_n73966464)
print v(xbgr.mr_n73966784)
print v(xbgr.mr_n73966896)
print v(xbgr.mr_n73967216)
print v(xbgr.mr_n73967328)
print v(xbgr.mr_n73967648)
print v(xbgr.mr_n73967760)
print v(xbgr.mr_n73968080)
print v(xbgr.mr_n73968192)
print v(xbgr.mr_n73968624)
print v(xbgr.mr_n73968944)
print v(xbgr.mr_n73969056)
print v(xbgr.mr_n73969488)
print v(xbgr.mr_n73969808)
print v(xbgr.mr_n73969920)
print v(xbgr.mr_n73970240)
print v(xbgr.mr_n73970352)
print v(xbgr.mr_n73970672)
print v(xbgr.mr_n73970784)
print v(xbgr.mr_n73971104)
print v(xbgr.mr_n73971216)
print v(xbgr.mr_n73971536)
print v(xbgr.mr_n73971648)
print v(xbgr.mr_n73971968)
print v(xbgr.mr_n73972080)
print v(xbgr.mr_n73972400)
print v(xbgr.mr_n73972512)
print v(xbgr.mr_n73972832)
print v(xbgr.mr_n73972944)
print v(xbgr.mr_n73973264)
print v(xbgr.mr_n73973376)
print v(xbgr.mr_n73973696)
print v(xbgr.mr_n73973808)
print v(xbgr.mr_n73974128)
print v(xbgr.mr_n73974992)
print v(xbgr.mr_n73975856)
print v(xbgr.mr_n73976720)
print v(xbgr.mr_n73977584)
print v(xbgr.mr_n73977696)
print v(xbgr.mr_n73978016)
print v(xbgr.mr_n73978128)
print v(xbgr.mr_n73978448)
print v(xbgr.mr_n73978560)
print v(xbgr.mr_n73978880)
print v(xbgr.mr_n73978992)
print v(xbgr.mr_n73979424)
print v(xbgr.mr_n73979856)
print v(xbgr.mr_n73980288)
print v(xbgr.mr_n73980720)
print v(xbgr.mr_n73981040)
print v(xbgr.mr_n73981152)
print v(xbgr.mr_n73981472)
print v(xbgr.mr_n73981584)
print v(xbgr.mr_n73981904)
print v(xbgr.mr_n73982016)
print v(xbgr.mr_n73982336)
print v(xbgr.mr_n73982448)
print v(xbgr.mr_n73982768)
print v(xbgr.mr_n73983632)
print v(xbgr.mr_n73984496)
print v(xbgr.mr_n73984608)
print v(xbgr.mr_n73985040)
print v(xbgr.mr_n73985360)
print v(xbgr.mr_n73986224)
print v(xbgr.mr_n73986336)
print v(xbgr.mr_n73986656)
print v(xbgr.mr_n73986768)
print v(xbgr.mr_n73987088)
print v(xbgr.mr_n73987200)
print v(xbgr.mr_n73987520)
print v(xbgr.mr_n73987632)
print v(xbgr.mr_n73987952)
print v(xbgr.mr_n73988816)
print v(xbgr.mr_n73988928)
print v(xbgr.mr_n73989360)
print v(xbgr.mr_n73989680)
print v(xbgr.mr_n73989792)
print v(xbgr.mr_n73990112)
print v(xbgr.mr_n73990224)
print v(xbgr.mr_n73990544)
print v(xbgr.mr_n73990656)
print v(xbgr.mr_n73990976)
print v(xbgr.mr_n73991088)
print v(xbgr.mr_n73991408)
print v(xbgr.mr_n73992272)
print v(xbgr.mr_n73992704)
print v(xbgr.mr_n73992816)
print v(xbgr.mr_n73993136)
print v(xbgr.mr_n73993248)
print v(xbgr.mr_n73993568)
print v(xbgr.mr_n73994000)
print v(xbgr.mr_n73994864)
print v(xbgr.mr_n73995728)
print v(xbgr.mr_n73995840)
print v(xbgr.mr_n73996592)
print v(xbgr.mr_n73996704)
print v(xbgr.mr_n73997024)
print v(xbgr.mr_n73997136)
print v(xbgr.mr_n73997456)
print v(xbgr.mr_n73998320)
print v(xbgr.mr_n73999184)
print v(xbgr.mr_n73999296)
print v(xbgr.mr_n73999616)
print v(xbgr.mr_n73999728)
print v(xbgr.mr_n74000048)
print v(xbgr.mr_n74000912)
print v(xbgr.mr_n74001024)
print v(xbgr.mr_n74001344)
print v(xbgr.mr_n74001456)
print v(xbgr.mr_n74001776)
print v(xbgr.mr_n74001888)
print v(xbgr.mr_n74002208)
print v(xbgr.mr_n74002320)
print v(xbgr.mr_n74002640)
print v(xbgr.mr_n74002752)
print v(xbgr.mr_n74003504)
print v(xbgr.mr_n74004368)
print v(xbgr.mr_n74005232)
print v(xbgr.mr_n74005344)
print v(xbgr.mr_n74005664)
print v(xbgr.mr_n74005776)
print v(xbgr.mr_n74006096)
print v(xbgr.mr_n74006208)
print v(xbgr.mr_n74006528)
print v(xbgr.mr_n74006640)
print v(xbgr.mr_n74006960)
print v(xbgr.mr_n74007072)
print v(xbgr.mr_n74007392)
print v(xbgr.mr_n74007504)
print v(xbgr.mr_n74007824)
print v(xbgr.mr_n74007936)
print v(xbgr.mr_n74008368)
print v(xbgr.mr_n74008688)
print v(xbgr.mr_n74008800)
print v(xbgr.mr_n74009120)
print v(xbgr.mr_n74009232)
print v(xbgr.mr_n74009552)
print v(xbgr.mr_n74010416)
print v(xbgr.mr_n74011280)
print v(xbgr.mr_n74012144)
print v(xbgr.mr_n74013008)
print v(xbgr.mr_n74013440)
print v(xbgr.mr_n74013552)
print v(xbgr.mr_n74013872)
print v(xbgr.mr_n74013984)
print v(xbgr.mr_n74014304)
print v(xbgr.mr_n74014416)
print v(xbgr.mr_n74014848)
print v(xbgr.mr_n74015600)
print v(xbgr.mr_n74015712)
print v(xbgr.mr_n74016032)
print v(xbgr.mr_n74016144)
print v(xbgr.mr_n74016464)
print v(xbgr.mr_n74017328)
print v(xbgr.mr_n74018192)
print v(xbgr.mr_n74018304)
print v(xbgr.mr_n74018624)
print v(xbgr.mr_n74018736)
print v(xbgr.mr_n74019056)
print v(xbgr.mr_n74019920)
print v(xbgr.mr_n74020784)
print v(xbgr.mr_n74021648)
print v(xbgr.mr_n74021760)
print v(xbgr.mr_n74022080)
print v(xbgr.mr_n74022192)
print v(xbgr.mr_n74022512)
print v(xbgr.mr_n74023376)
print v(xbgr.mr_n74024240)
print v(xbgr.mr_n74024352)
print v(xbgr.mr_n74024672)
print v(xbgr.mr_n74024784)
print v(xbgr.mr_n74025104)
print v(xbgr.mr_n74025216)
print v(xbgr.mr_n74025536)
print v(xbgr.mr_n74025648)
print v(xbgr.mr_n74025968)
print v(xbgr.mr_n74026080)
print v(xbgr.mr_n74026400)
print v(xbgr.mr_n74026512)
print v(xbgr.mr_n74026832)
print v(xbgr.mr_n74026944)
print v(xbgr.mr_n74027264)
print v(xbgr.mr_n74027376)
print v(xbgr.mr_n74027696)
print v(xbgr.mr_n74027808)
print v(xbgr.mr_n74028128)
print v(xbgr.mr_n74028240)
print v(xbgr.mr_n74028560)
print v(xbgr.mr_n74028672)
print v(xbgr.mr_n74028992)
print v(xbgr.mr_n74029104)
print v(xbgr.mr_n74029424)
print v(xbgr.mr_n74029536)
print v(xbgr.mr_n74029856)
print v(xbgr.mr_n74029968)
print v(xbgr.mr_n74030288)
print v(xbgr.mr_n74030400)
print v(xbgr.mr_n74030720)
print v(xbgr.mr_n74030832)
print v(xbgr.mr_n74031152)
print v(xbgr.mr_n74031264)
print v(xbgr.mr_n74031584)
print v(xbgr.mr_n74031696)
print v(xbgr.mr_n74032016)
print v(xbgr.mr_n74032128)
print v(xbgr.mr_n74032448)
print v(xbgr.mr_n74032560)
print v(xbgr.mr_n74032880)
print v(xbgr.mr_n74032992)
print v(xbgr.mr_n74033312)
print v(xbgr.mr_n74033424)
print v(xbgr.mr_n74033744)
print v(xbgr.mr_n74033856)
print v(xbgr.mr_n74034176)
print v(xbgr.mr_n74034288)
print v(xbgr.mr_n74034608)
print v(xbgr.mr_n74034720)
print v(xbgr.mr_n74035040)
print v(xbgr.mr_n74035152)
print v(xbgr.mr_n74035584)
print v(xbgr.mr_n74036016)
print v(xbgr.mr_n74036448)
print v(xbgr.mr_n74036880)
print v(xbgr.mr_n74037312)
print v(xbgr.mr_n74037744)
print v(xbgr.mr_n74038176)
print v(xbgr.mr_n74038608)
print v(xbgr.mr_n74039040)
print v(xbgr.mr_n74039472)
print v(xbgr.mr_n74039904)
print v(xbgr.mr_n74040336)
print v(xbgr.mr_n74040768)
print v(xbgr.mr_n74041200)
print v(xbgr.mr_n74041632)
print v(xbgr.mr_n74042064)
print v(xbgr.mr_n74042496)
print v(xbgr.mr_n74042928)
print v(xbgr.mr_n74043360)
print v(xbgr.mr_n74043792)
print v(xbgr.mr_n74044224)
print v(xbgr.mr_n74044656)
print v(xbgr.mr_n74045088)
print v(xbgr.mr_n74045520)
print v(xbgr.mr_n74045952)
print v(xbgr.mr_n74046384)
print v(xbgr.mr_n74046704)
print v(xbgr.mr_n74046816)
print v(xbgr.mr_n74047136)
print v(xbgr.mr_n74047248)
print v(xbgr.mr_n74047568)
print v(xbgr.mr_n74047680)
print v(xbgr.mr_n74048000)
print v(xbgr.mr_n74048112)
print v(xbgr.mr_n74048432)
print v(xbgr.mr_n74048544)
print v(xbgr.mr_n74048864)
print v(xbgr.mr_n74048976)
print v(xbgr.mr_n74049296)
print v(xbgr.mr_n74049408)
print v(xbgr.mr_n74049728)
print v(xbgr.mr_n74049840)
print v(xbgr.mr_n74050160)
print v(xbgr.mr_n74050272)
print v(xbgr.mr_n74050592)
print v(xbgr.mr_n74050704)
print v(xbgr.mr_n74051024)
print v(xbgr.mr_n74051136)
print v(xbgr.mr_n74051456)
print v(xbgr.mr_n74051568)
print v(xbgr.mr_n74051888)
print v(xbgr.mr_n74052000)
print v(xbgr.mr_n74052320)
print v(xbgr.mr_n74052432)
print v(xbgr.mr_n74052752)
print v(xbgr.mr_n74052864)
print v(xbgr.mr_n74053184)
print v(xbgr.mr_n74053296)
print v(xbgr.mr_n74053616)
print v(xbgr.mr_n74053728)
print v(xbgr.mr_n74054048)
print v(xbgr.mr_n74054160)
print v(xbgr.mr_n74054480)
print v(xbgr.mr_n74054592)
print v(xbgr.mr_n74054912)
print v(xbgr.mr_n74055024)
print v(xbgr.mr_n74055344)
print v(xbgr.mr_n74055456)
print v(xbgr.mr_n74055776)
print v(xbgr.mr_n74055888)
print v(xbgr.mr_n74056208)
print v(xbgr.mr_n74056320)
print v(xbgr.mr_n74056640)
print v(xbgr.mr_n74056752)
print v(xbgr.mr_n74057184)
print v(xbgr.mr_n74057616)
print v(xbgr.mr_n74058048)
print v(xbgr.mr_n74058480)
print v(xbgr.mr_n74058800)
print v(xbgr.mr_n74058912)
print v(xbgr.mr_n74059232)
print v(xbgr.mr_n74059344)
print v(xbgr.mr_n74059776)
print v(xbgr.mr_n74060208)
print v(xbgr.mr_n74060640)
print v(xbgr.mr_n74061072)
print v(xbgr.mr_n74061504)
print v(xbgr.mr_n74061936)
print v(xbgr.mr_n74062368)
print v(xbgr.mr_n74062800)
print v(xbgr.mr_n74063232)
print v(xbgr.mr_n74063664)
print v(xbgr.mr_n74064096)
print v(xbgr.mr_n74064528)
print v(xbgr.mr_n74064960)
print v(xbgr.mr_n74065392)
print v(xbgr.mr_n74065824)
print v(xbgr.mr_n74066256)
print v(xbgr.mr_n74066688)
print v(xbgr.mr_n74067120)
print v(xbgr.mr_n74067552)
print v(xbgr.mr_n74067984)
print v(xbgr.mr_n74068416)
print v(xbgr.mr_n74068848)
print v(xbgr.mr_n74069168)
print v(xbgr.mr_n74069280)
print v(xbgr.mr_n74069712)
print v(xbgr.mr_n74070032)
print v(xbgr.mr_n74070144)
print v(xbgr.mr_n74070576)
print v(xbgr.mr_n74070896)
print v(xbgr.mr_n74071008)
print v(xbgr.mr_n74071440)
print v(xbgr.mr_n74071760)
print v(xbgr.mr_n74071872)
print v(xbgr.mr_n74072304)
print v(xbgr.mr_n74072624)
print v(xbgr.mr_n74072736)
print v(xbgr.mr_n74073168)
print v(xbgr.mr_n74073488)
print v(xbgr.mr_n74073600)
print v(xbgr.mr_n74073920)
print v(xbgr.mr_n74074032)
print v(xbgr.mr_n74074352)
print v(xbgr.mr_n74074464)
print v(xbgr.mr_n74074896)
print v(xbgr.mr_n74075328)
print v(xbgr.mr_n74075760)
print v(xbgr.mr_n74076080)
print v(xbgr.mr_n74076192)
print v(xbgr.mr_n74076512)
print v(xbgr.mr_n74076624)
print v(xbgr.mr_n74076944)
print v(xbgr.mr_n74077056)
print v(xbgr.mr_n74077376)
print v(xbgr.mr_n74077488)
print v(xbgr.mr_n74077808)
print v(xbgr.mr_n74077920)
print v(xbgr.mr_n74078240)
print v(xbgr.mr_n74078352)
print v(xbgr.mr_n74078672)
print v(xbgr.mr_n74078784)
print v(xbgr.mr_n74079216)
print v(xbgr.mr_n74079536)
print v(xbgr.mr_n74079648)
print v(xbgr.mr_n74080080)
print v(xbgr.mr_n74080400)
print v(xbgr.mr_n74080512)
print v(xbgr.mr_n74080944)
print v(xbgr.mr_n74081264)
print v(xbgr.mr_n74082128)
print v(xbgr.mr_n74082992)
print v(xbgr.mr_n74083856)
print v(xbgr.mr_n74084720)
print v(xbgr.mr_n74085584)
print v(xbgr.mr_n74086448)
print v(xbgr.mr_n74086560)
print v(xbgr.mr_n74086880)
print v(xbgr.mr_n74086992)
print v(xbgr.mr_n74087312)
print v(xbgr.mr_n74087424)
print v(xbgr.mr_n74087744)
print v(xbgr.mr_n74087856)
print v(xbgr.mr_n74088176)
print v(xbgr.mr_n74089040)
print v(xbgr.mr_n74089904)
print v(xbgr.mr_n74090768)
print v(xbgr.mr_n74090880)
print v(xbgr.mr_n74091200)
print v(xbgr.mr_n74091312)
print v(xbgr.mr_n74091632)
print v(xbgr.mr_n74091744)
print v(xbgr.mr_n74092176)
print v(xbgr.mr_n74092608)
print v(xbgr.mr_n74093040)
print v(xbgr.mr_n74093360)
print v(xbgr.mr_n74093472)
print v(xbgr.mr_n74093792)
print v(xbgr.mr_n74093904)
print v(xbgr.mr_n74094224)
print v(xbgr.mr_n74094336)
print v(xbgr.mr_n74094656)
print v(xbgr.mr_n74094768)
print v(xbgr.mr_n74095088)
print v(xbgr.mr_n74095200)
print v(xbgr.mr_n74095520)
print v(xbgr.mr_n74095632)
print v(xbgr.mr_n74095952)
print v(xbgr.mr_n74096064)
print v(xbgr.mr_n74096384)
print v(xbgr.mr_n74096496)
print v(xbgr.mr_n74096816)
print v(xbgr.mr_n74096928)
print v(xbgr.mr_n74097360)
print v(xbgr.mr_n74097680)
print v(xbgr.mr_n74097792)
print v(xbgr.mr_n74098224)
print v(xbgr.mr_n74098544)
print v(xbgr.mr_n74098656)
print v(xbgr.mr_n74098976)
print v(xbgr.mr_n74099088)
print v(xbgr.mr_n74099408)
print v(xbgr.mr_n74100272)
print v(xbgr.mr_n74101136)
print v(xbgr.mr_n74101248)
print v(xbgr.mr_n74101568)
print v(xbgr.mr_n74101680)
print v(xbgr.mr_n74102000)
print v(xbgr.mr_n74102864)
print v(xbgr.mr_n74103408)
print v(xbgr.mr_n74103840)
print v(xbgr.mr_n74104592)
print v(xbgr.mr_n74105456)
print v(xbgr.mr_n74105568)
print v(xbgr.mr_n74105888)
print v(xbgr.mr_n74106000)
print v(xbgr.mr_n74106320)
print v(xbgr.mr_n74106432)
print v(xbgr.mr_n74106752)
print v(xbgr.mr_n74106864)
print v(xbgr.mr_n74107184)
print v(xbgr.mr_n74107296)
print v(xbgr.mr_n74107616)
print v(xbgr.mr_n74107728)
print v(xbgr.mr_n74108048)
print v(xbgr.mr_n74108160)
print v(xbgr.mr_n74108480)
print v(xbgr.mr_n74108592)
print v(xbgr.mr_n74108912)
print v(xbgr.mr_n74109776)
print v(xbgr.mr_n74109888)
print v(xbgr.mr_n74110208)
print v(xbgr.mr_n74110320)
print v(xbgr.mr_n74110640)
print v(xbgr.mr_n74111504)
print v(xbgr.mr_n74112368)
print v(xbgr.mr_n74112480)
print v(xbgr.mr_n74112800)
print v(xbgr.mr_n74112912)
print v(xbgr.mr_n74113232)
print v(xbgr.mr_n74113344)
print v(xbgr.mr_n74113776)
print v(xbgr.mr_n74114096)
print v(xbgr.mr_n74114528)
print v(xbgr.mr_n74115824)
print v(xbgr.mr_n74115936)
print v(xbgr.mr_n74116256)
print v(xbgr.mr_n74116368)
print v(xbgr.mr_n74116688)
print v(xbgr.mr_n74116800)
print v(xbgr.mr_n74117120)
print v(xbgr.mr_n74117232)
print v(xbgr.mr_n74117552)
print v(xbgr.mr_n74117664)
print v(xbgr.mr_n74118096)
print v(xbgr.mr_n74118416)
print v(xbgr.mr_n74118528)
print v(xbgr.mr_n74118848)
print v(xbgr.mr_n74118960)
print v(xbgr.mr_n74119280)
print v(xbgr.mr_n74119392)
print v(xbgr.mr_n74119712)
print v(xbgr.mr_n74119824)
print v(xbgr.mr_n74120144)
print v(xbgr.mr_n74121008)
print v(xbgr.mr_n74121872)
print v(xbgr.mr_n74122736)
print v(xbgr.mr_n74123600)
print v(xbgr.mr_n74123712)
print v(xbgr.mr_n74124032)
print v(xbgr.mr_n74124144)
print v(xbgr.mr_n74124464)
print v(xbgr.mr_n74124576)
print v(xbgr.mr_n74124896)
print v(xbgr.mr_n74125008)
print v(xbgr.mr_n74125328)
print v(xbgr.mr_n74126192)
print v(xbgr.mr_n74127056)
print v(xbgr.mr_n74127920)
print v(xbgr.mr_n74128784)
print v(xbgr.mr_n74129216)
print v(xbgr.mr_n74129328)
print v(xbgr.mr_n74129648)
print v(xbgr.mr_n74129760)
print v(xbgr.mr_n74130080)
print v(xbgr.mr_n74130192)
print v(xbgr.mr_n74130512)
print v(xbgr.mr_n74130624)
print v(xbgr.mr_n74130944)
print v(xbgr.mr_n74131056)
print v(xbgr.mr_n74131376)
print v(xbgr.mr_n74131488)
print v(xbgr.mr_n74131808)
print v(xbgr.mr_n74131920)
print v(xbgr.mr_n74132240)
print v(xbgr.mr_n74132352)
print v(xbgr.mr_n74132784)
print v(xbgr.mr_n74133104)
print v(xbgr.mr_n74133216)
print v(xbgr.mr_n74133648)
print v(xbgr.mr_n74133968)
print v(xbgr.mr_n74134080)
print v(xbgr.mr_n74134512)
print v(xbgr.mr_n74134832)
print v(xbgr.mr_n74134944)
print v(xbgr.mr_n74135264)
print v(xbgr.mr_n74135376)
print v(xbgr.mr_n74135696)
print v(xbgr.mr_n74136560)
print v(xbgr.mr_n74137424)
print v(xbgr.mr_n74138288)
print v(xbgr.mr_n74139152)
print v(xbgr.mr_n74140016)
print v(xbgr.mr_n74140880)
print v(xbgr.mr_n74141744)
print v(xbgr.mr_n74142608)
print v(xbgr.mr_n74143472)
print v(xbgr.mr_n74143584)
print v(xbgr.mr_n74143904)
print v(xbgr.mr_n74144016)
print v(xbgr.mr_n74144336)
print v(xbgr.mr_n74145200)
print v(xbgr.mr_n74145312)
print v(xbgr.mr_n74145632)
print v(xbgr.mr_n74145744)
print v(xbgr.mr_n74146064)
print v(xbgr.mr_n74146176)
print v(xbgr.mr_n74146496)
print v(xbgr.mr_n74146608)
print v(xbgr.mr_n74146928)
print v(xbgr.mr_n74147040)
print v(xbgr.mr_n74147360)
print v(xbgr.mr_n74147472)
print v(xbgr.mr_n74147792)
print v(xbgr.mr_n74147904)
print v(xbgr.mr_n74148224)
print v(xbgr.mr_n74148336)
print v(xbgr.mr_n74148656)
print v(xbgr.mr_n74149520)
print v(xbgr.mr_n74150384)
print v(xbgr.mr_n74151248)
print v(xbgr.mr_n74151360)
print v(xbgr.mr_n74151680)
print v(xbgr.mr_n74152976)
print v(xbgr.mr_n74153840)
print v(xbgr.mr_n74154704)
print v(xbgr.mr_n74155568)
print v(xbgr.mr_n74155680)
print v(xbgr.mr_n74156000)
print v(xbgr.mr_n74156112)
print v(xbgr.mr_n74156544)
print v(xbgr.mr_n74156864)
print v(xbgr.mr_n74156976)
print v(xbgr.mr_n74157408)
print v(xbgr.mr_n74157728)
print v(xbgr.mr_n74157840)
print v(xbgr.mr_n74158272)
print v(xbgr.mr_n74158592)
print v(xbgr.mr_n74158704)
print v(xbgr.mr_n74159136)
print v(xbgr.mr_n74159456)
print v(xbgr.mr_n74159568)
print v(xbgr.mr_n74160000)
print v(xbgr.mr_n74160320)
print v(xbgr.mr_n74160432)
print v(xbgr.mr_n74160752)
print v(xbgr.mr_n74160864)
print v(xbgr.mr_n74161184)
print v(xbgr.mr_n74161296)
print v(xbgr.mr_n74161728)
print v(xbgr.mr_n74162048)
print v(xbgr.mr_n74162160)
print v(xbgr.mr_n74162480)
print v(xbgr.mr_n74162592)
print v(xbgr.mr_n74162912)
print v(xbgr.mr_n74163024)
print v(xbgr.mr_n74163344)
print v(xbgr.mr_n74163456)
print v(xbgr.mr_n74163776)
print v(xbgr.mr_n74163888)
print v(xbgr.mr_n74164208)
print v(xbgr.mr_n74164320)
print v(xbgr.mr_n74164640)
print v(xbgr.mr_n74164752)
print v(xbgr.mr_n74165072)
print v(xbgr.mr_n74165184)
print v(xbgr.mr_n74165616)
print v(xbgr.mr_n74165936)
print v(xbgr.mr_n74166912)
print v(xbgr.mr_n74167344)
print v(xbgr.mr_n74167664)
print v(xbgr.mr_n74168528)
print v(xbgr.mr_n74168640)
print v(xbgr.mr_n74168960)
print v(xbgr.mr_n74169072)
print v(xbgr.mr_n74169392)
print v(xbgr.mr_n74169504)
print v(xbgr.mr_n74169824)
print v(xbgr.mr_n74169936)
print v(xbgr.mr_n74170256)
print v(xbgr.mr_n74171120)
print v(xbgr.mr_n74171552)
print v(xbgr.mr_n74172416)
print v(xbgr.mr_n74173280)
print v(xbgr.mr_n74173392)
print v(xbgr.mr_n74173712)
print v(xbgr.mr_n74173824)
print v(xbgr.mr_n74174144)
print v(xbgr.mr_n74174256)
print v(xbgr.mr_n74174576)
print v(xbgr.mr_n74174688)
print v(xbgr.mr_n74175440)
print v(xbgr.mr_n74175552)
print v(xbgr.mr_n74175872)
print v(xbgr.mr_n74175984)
print v(xbgr.mr_n74176304)
print v(xbgr.mr_n74176416)
print v(xbgr.mr_n74176736)
print v(xbgr.mr_n74176848)
print v(xbgr.mr_n74177168)
print v(xbgr.mr_n74177712)
print v(xbgr.mr_n74178032)
print v(xbgr.mr_n74178144)
print v(xbgr.mr_n74178576)
print v(xbgr.mr_n74178896)
print v(xbgr.mr_n74179008)
print v(xbgr.mr_n74180192)
print v(xbgr.mr_n74180624)
print v(xbgr.mr_n74180736)
print v(xbgr.mr_n74181056)
print v(xbgr.mr_n74181168)
print v(xbgr.mr_n74181488)
print v(xbgr.mr_n74181600)
print v(xbgr.mr_n74181920)
print v(xbgr.mr_n74182032)
print v(xbgr.mr_n74182352)
print v(xbgr.mr_n74182464)
print v(xbgr.mr_n74182784)
print v(xbgr.mr_n74182896)
print v(xbgr.mr_n74183648)
print v(xbgr.mr_n74184512)
print v(xbgr.mr_n74184624)
print v(xbgr.mr_n74184944)
print v(xbgr.mr_n74185056)
print v(xbgr.mr_n74185376)
print v(xbgr.mr_n74185488)
print v(xbgr.mr_n74185808)
print v(xbgr.mr_n74185920)
print v(xbgr.mr_n74186240)
print v(xbgr.mr_n74186352)
print v(xbgr.mr_n74186672)
print v(xbgr.mr_n74186784)
print v(xbgr.mr_n74187104)
print v(xbgr.mr_n74187216)
print v(xbgr.mr_n74187536)
print v(xbgr.mr_n74187648)
print v(xbgr.mr_n74187968)
print v(xbgr.mr_n74188832)
print v(xbgr.mr_n74189696)
print v(xbgr.mr_n74190560)
print v(xbgr.mr_n74190672)
print v(xbgr.mr_n74191104)
print v(xbgr.mr_n74191536)
print v(xbgr.mr_n74191856)
print v(xbgr.mr_n74192288)
print v(xbgr.mr_n74192400)
print v(xbgr.mr_n74192720)
print v(xbgr.mr_n74192832)
print v(xbgr.mr_n74193584)
print v(xbgr.mr_n74194992)
print v(xbgr.mr_n74195312)
print v(xbgr.mr_n74195424)
print v(xbgr.mr_n74195744)
print v(xbgr.mr_n74195856)
print v(xbgr.mr_n74196176)
print v(xbgr.mr_n74196288)
print v(xbgr.mr_n74196720)
print v(xbgr.mr_n74197040)
print v(xbgr.mr_n74197152)
print v(xbgr.mr_n74197584)
print v(xbgr.mr_n74197904)
print v(xbgr.mr_n74198336)
print v(xbgr.mr_n74198768)
print v(xbgr.mr_n74198880)
print v(xbgr.mr_n74199200)
print v(xbgr.mr_n74199312)
print v(xbgr.mr_n74199632)
print v(xbgr.mr_n74199744)
print v(xbgr.mr_n74200496)
print v(xbgr.mr_n74201360)
print v(xbgr.mr_n74201472)
print v(xbgr.mr_n74201904)
print v(xbgr.mr_n74202224)
print v(xbgr.mr_n74203088)
print v(xbgr.mr_n74203952)
print v(xbgr.mr_n74205248)
print v(xbgr.mr_n74205680)
print v(xbgr.mr_n74205792)
print v(xbgr.mr_n74206112)
print v(xbgr.mr_n74206224)
print v(xbgr.mr_n74206544)
print v(xbgr.mr_n74206656)
print v(xbgr.mr_n74206976)
print v(xbgr.mr_n74207088)
print v(xbgr.mr_n74207408)
print v(xbgr.mr_n74207520)
print v(xbgr.mr_n74207840)
print v(xbgr.mr_n74207952)
print v(xbgr.mr_n74208272)
print v(xbgr.mr_n74208384)
print v(xbgr.mr_n74208704)
print v(xbgr.mr_n74208816)
print v(xbgr.mr_n74209568)
print v(xbgr.mr_n74210432)
print v(xbgr.mr_n74211296)
print v(xbgr.mr_n74211408)
print v(xbgr.mr_n74211728)
print v(xbgr.mr_n74211840)
print v(xbgr.mr_n74212160)
print v(xbgr.mr_n74212272)
print v(xbgr.mr_n74212592)
print v(xbgr.mr_n74213456)
print v(xbgr.mr_n74214320)
print v(xbgr.mr_n74215184)
print v(xbgr.mr_n74216048)
print v(xbgr.mr_n74216912)
print v(xbgr.mr_n74217776)
print v(xbgr.mr_n74217888)
print v(xbgr.mr_n74218208)
print v(xbgr.mr_n74219072)
print v(xbgr.mr_n74219184)
print v(xbgr.mr_n74219504)
print v(xbgr.mr_n74219616)
print v(xbgr.mr_n74219936)
print v(xbgr.mr_n74220800)
print v(xbgr.mr_n74221232)
print v(xbgr.mr_n74221344)
print v(xbgr.mr_n74222096)
print v(xbgr.mr_n74222208)
print v(xbgr.mr_n74222528)
print v(xbgr.mr_n74222640)
print v(xbgr.mr_n74222960)
print v(xbgr.mr_n74223072)
print v(xbgr.mr_n74223392)
print v(xbgr.mr_n74223504)
print v(xbgr.mr_n74223824)
print v(xbgr.mr_n74223936)
print v(xbgr.mr_n74224256)
print v(xbgr.mr_n74224368)
print v(xbgr.mr_n74224688)
print v(xbgr.mr_n74224800)
print v(xbgr.mr_n74225120)
print v(xbgr.mr_n74225232)
print v(xbgr.mr_n74225552)
print v(xbgr.mr_n74225664)
print v(xbgr.mr_n74225984)
print v(xbgr.mr_n74226528)
print v(xbgr.mr_n74227280)
print v(xbgr.mr_n74228144)
print v(xbgr.mr_n74229008)
print v(xbgr.mr_n74229120)
print v(xbgr.mr_n74229552)
print v(xbgr.mr_n74229872)
print v(xbgr.mr_n74230736)
print v(xbgr.mr_n74231600)
print v(xbgr.mr_n74232464)
print v(xbgr.mr_n74233328)
print v(xbgr.mr_n74234192)
print v(xbgr.mr_n74235056)
print v(xbgr.mr_n74235168)
print v(xbgr.mr_n74235488)
print v(xbgr.mr_n74235600)
print v(xbgr.mr_n74235920)
print v(xbgr.mr_n74236784)
print v(xbgr.mr_n74237648)
print v(xbgr.mr_n74237760)
print v(xbgr.mr_n74238080)
print v(xbgr.mr_n74238192)
print v(xbgr.mr_n74238512)
print v(xbgr.mr_n74238624)
print v(xbgr.mr_n74238944)
print v(xbgr.mr_n74239056)
print v(xbgr.mr_n74239376)
print v(xbgr.mr_n74239488)
print v(xbgr.mr_n74239808)
print v(xbgr.mr_n74239920)
print v(xbgr.mr_n74240240)
print v(xbgr.mr_n74240352)
print v(xbgr.mr_n74240672)
print v(xbgr.mr_n74241536)
print v(xbgr.mr_n74241648)
print v(xbgr.mr_n74241968)
print v(xbgr.mr_n74242080)
print v(xbgr.mr_n74242400)
print v(xbgr.mr_n74242512)
print v(xbgr.mr_n74242832)
print v(xbgr.mr_n74242944)
print v(xbgr.mr_n74243264)
print v(xbgr.mr_n74243376)
print v(xbgr.mr_n74243696)
print v(xbgr.mr_n74243808)
print v(xbgr.mr_n74244128)
print v(xbgr.mr_n74244240)
print v(xbgr.mr_n74244560)
print v(xbgr.mr_n74244672)
print v(xbgr.mr_n74245104)
print v(xbgr.mr_n74245536)
print v(xbgr.mr_n74245968)
print v(xbgr.mr_n74246288)
print v(xbgr.mr_n74246400)
print v(xbgr.mr_n74246720)
print v(xbgr.mr_n74246832)
print v(xbgr.mr_n74247152)
print v(xbgr.mr_n74247264)
print v(xbgr.mr_n74247584)
print v(xbgr.mr_n74247696)
print v(xbgr.mr_n74248016)
print v(xbgr.mr_n74248128)
print v(xbgr.mr_n74248448)
print v(xbgr.mr_n74248560)
print v(xbgr.mr_n74248880)
print v(xbgr.mr_n74248992)
print v(xbgr.mr_n74249312)
print v(xbgr.mr_n74249424)
print v(xbgr.mr_n74249744)
print v(xbgr.mr_n74249856)
print v(xbgr.mr_n74250176)
print v(xbgr.mr_n74250288)
print v(xbgr.mr_n74250608)
print v(xbgr.mr_n74250720)
print v(xbgr.mr_n74251040)
print v(xbgr.mr_n74251152)
print v(xbgr.mr_n74251472)
print v(xbgr.mr_n74251584)
print v(xbgr.mr_n74251904)
print v(xbgr.mr_n74252016)
print v(xbgr.mr_n74252336)
print v(xbgr.mr_n74252448)
print v(xbgr.mr_n74252768)
print v(xbgr.mr_n74252880)
print v(xbgr.mr_n74253312)
print v(xbgr.mr_n74253632)
print v(xbgr.mr_n74253744)
print v(xbgr.mr_n74254176)
print v(xbgr.mr_n74254608)
print v(xbgr.mr_n74254928)
print v(xbgr.mr_n74255040)
print v(xbgr.mr_n74255360)
print v(xbgr.mr_n74255472)
print v(xbgr.mr_n74255792)
print v(xbgr.mr_n74255904)
print v(xbgr.mr_n74256224)
print v(xbgr.mr_n74256336)
print v(xbgr.mr_n74256768)
print v(xbgr.mr_n74257200)
print v(xbgr.mr_n74257632)
print v(xbgr.mr_n74258064)
print v(xbgr.mr_n74258496)
print v(xbgr.mr_n74258928)
print v(xbgr.mr_n74259360)
print v(xbgr.mr_n74259792)
print v(xbgr.mr_n74260112)
print v(xbgr.mr_n74260224)
print v(xbgr.mr_n74260544)
print v(xbgr.mr_n74260656)
print v(xbgr.mr_n74260976)
print v(xbgr.mr_n74261088)
print v(xbgr.mr_n74261408)
print v(xbgr.mr_n74261520)
print v(xbgr.mr_n74261840)
print v(xbgr.mr_n74261952)
print v(xbgr.mr_n74262272)
print v(xbgr.mr_n74262384)
print v(xbgr.mr_n74262704)
print v(xbgr.mr_n74262816)
print v(xbgr.mr_n74263136)
print v(xbgr.mr_n74263248)
print v(xbgr.mr_n74263568)
print v(xbgr.mr_n74263680)
print v(xbgr.mr_n74264000)
print v(xbgr.mr_n74264112)
print v(xbgr.mr_n74264432)
print v(xbgr.mr_n74264544)
print v(xbgr.mr_n74264864)
print v(xbgr.mr_n74264976)
print v(xbgr.mr_n74265296)
print v(xbgr.mr_n74265408)
print v(xbgr.mr_n74265728)
print v(xbgr.mr_n74265840)
print v(xbgr.mr_n74266160)
print v(xbgr.mr_n74266272)
print v(xbgr.mr_n74266592)
print v(xbgr.mr_n74266704)
print v(xbgr.mr_n74267024)
print v(xbgr.mr_n74267136)
print v(xbgr.mr_n74267456)
print v(xbgr.mr_n74267568)
print v(xbgr.mr_n74267888)
print v(xbgr.mr_n74268000)
print v(xbgr.mr_n74268320)
print v(xbgr.mr_n74268432)
print v(xbgr.mr_n74268752)
print v(xbgr.mr_n74268864)
print v(xbgr.mr_n74269184)
print v(xbgr.mr_n74269296)
print v(xbgr.mr_n74269616)
print v(xbgr.mr_n74269728)
print v(xbgr.mr_n74270048)
print v(xbgr.mr_n74270160)
print v(xbgr.mr_n74270592)
print v(xbgr.mr_n74271024)
print v(xbgr.mr_n74271344)
print v(xbgr.mr_n74271456)
print v(xbgr.mr_n74271776)
print v(xbgr.mr_n74271888)
print v(xbgr.mr_n74272320)
print v(xbgr.mr_n74272752)
print v(xbgr.mr_n74273184)
print v(xbgr.mr_n74273616)
print v(xbgr.mr_n74274048)
print v(xbgr.mr_n74274480)
print v(xbgr.mr_n74274912)
print v(xbgr.mr_n74275344)
print v(xbgr.mr_n74275776)
print v(xbgr.mr_n74276208)
print v(xbgr.mr_n74276640)
print v(xbgr.mr_n74277072)
print v(xbgr.mr_n74277504)
print v(xbgr.mr_n74277936)
print v(xbgr.mr_n74278368)
print v(xbgr.mr_n74278800)
print v(xbgr.mr_n74279232)
print v(xbgr.mr_n74279664)
print v(xbgr.mr_n74280096)
print v(xbgr.mr_n74280528)
print v(xbgr.mr_n74280960)
print v(xbgr.mr_n74281392)
print v(xbgr.mr_n74281824)
print v(xbgr.mr_n74282256)
print v(xbgr.mr_n74282576)
print v(xbgr.mr_n74282688)
print v(xbgr.mr_n74283008)
print v(xbgr.mr_n74283120)
print v(xbgr.mr_n74283440)
print v(xbgr.mr_n74283552)
print v(xbgr.mr_n74283872)
print v(xbgr.mr_n74283984)
print v(xbgr.mr_n74284304)
print v(xbgr.mr_n74284416)
print v(xbgr.mr_n74284736)
print v(xbgr.mr_n74284848)
print v(xbgr.mr_n74285168)
print v(xbgr.mr_n74285280)
print v(xbgr.mr_n74285600)
print v(xbgr.mr_n74285712)
print v(xbgr.mr_n74286032)
print v(xbgr.mr_n74286144)
print v(xbgr.mr_n74286464)
print v(xbgr.mr_n74286576)
print v(xbgr.mr_n74286896)
print v(xbgr.mr_n74287008)
print v(xbgr.mr_n74287328)
print v(xbgr.mr_n74287440)
print v(xbgr.mr_n74287760)
print v(xbgr.mr_n74287872)
print v(xbgr.mr_n74288304)
print v(xbgr.mr_n74288736)
print v(xbgr.mr_n74289168)
print v(xbgr.mr_n74289600)
print v(xbgr.mr_n74290032)
print v(xbgr.mr_n74290464)
print v(xbgr.mr_n74290896)
print v(xbgr.mr_n74291328)
print v(xbgr.mr_n74291760)
print v(xbgr.mr_n74292192)
print v(xbgr.mr_n74292624)
print v(xbgr.mr_n74293056)
print v(xbgr.mr_n74293488)
print v(xbgr.mr_n74293808)
print v(xbgr.mr_n74293920)
print v(xbgr.mr_n74294240)
print v(xbgr.mr_n74294352)
print v(xbgr.mr_n74294672)
print v(xbgr.mr_n74294784)
print v(xbgr.mr_n74295104)
print v(xbgr.mr_n74295216)
print v(xbgr.mr_n74295536)
print v(xbgr.mr_n74295648)
print v(xbgr.mr_n74295968)
print v(xbgr.mr_n74296080)
print v(xbgr.mr_n74296400)
print v(xbgr.mr_n74296512)
print v(xbgr.mr_n74296832)
print v(xbgr.mr_n74296944)
print v(xbgr.mr_n74297264)
print v(xbgr.mr_n74297376)
print v(xbgr.mr_n74297696)
print v(xbgr.mr_n74297808)
print v(xbgr.mr_n74298128)
print v(xbgr.mr_n74298240)
print v(xbgr.mr_n74298560)
print v(xbgr.mr_n74298672)
print v(xbgr.mr_n74298992)
print v(xbgr.mr_n74299104)
print v(xbgr.mr_n74299536)
print v(xbgr.mr_n74299968)
print v(xbgr.mr_n74300400)
print v(xbgr.mr_n74300832)
print v(xbgr.mr_n74301264)
print v(xbgr.mr_n74301696)
print v(xbgr.mr_n74302128)
print v(xbgr.mr_n74302560)
print v(xbgr.mr_n74302992)
print v(xbgr.mr_n74303424)
print v(xbgr.mr_n74303856)
print v(xbgr.mr_n74304288)
print v(xbgr.mr_n74304720)
print v(xbgr.mr_n74305040)
print v(xbgr.mr_n74305152)
print v(xbgr.mr_n74305472)
print v(xbgr.mr_n74305584)
print v(xbgr.mr_n74305904)
print v(xbgr.mr_n74306016)
print v(xbgr.mr_n74306336)
print v(xbgr.mr_n74306448)
print v(xbgr.mr_n74306768)
print v(xbgr.mr_n74306880)
print v(xbgr.mr_n74307200)
print v(xbgr.mr_n74307312)
print v(xbgr.mr_n74307632)
print v(xbgr.mr_n74307744)
print v(xbgr.mr_n74308064)
print v(xbgr.mr_n74308176)
print v(xbgr.mr_n74308496)
print v(xbgr.mr_n74308608)
print v(xbgr.mr_n74308928)
print v(xbgr.mr_n74309040)
print v(xbgr.mr_n74309360)
print v(xbgr.mr_n74309472)
print v(xbgr.mr_n74309792)
print v(xbgr.mr_n74309904)
print v(xbgr.mr_n74310224)
print v(xbgr.mr_n74310336)
print v(xbgr.mr_n74310768)
print v(xbgr.mr_n74311200)
print v(xbgr.mr_n74311632)
print v(xbgr.mr_n74312064)
print v(xbgr.mr_n74312496)
print v(xbgr.mr_n74312928)
print v(xbgr.mr_n74313360)
print v(xbgr.mr_n74313792)
print v(xbgr.mr_n74314224)
print v(xbgr.mr_n74314656)
print v(xbgr.mr_n74315088)
print v(xbgr.mr_n74315520)
print v(xbgr.mr_n74315952)
print v(xbgr.mr_n74316272)
print v(xbgr.mr_n74316384)
print v(xbgr.mr_n74316704)
print v(xbgr.mr_n74316816)
print v(xbgr.mr_n74317136)
print v(xbgr.mr_n74317248)
print v(xbgr.mr_n74317568)
print v(xbgr.mr_n74317680)
print v(xbgr.mr_n74318000)
print v(xbgr.mr_n74318112)
print v(xbgr.mr_n74318432)
print v(xbgr.mr_n74318544)
print v(xbgr.mr_n74318864)
print v(xbgr.mr_n74318976)
print v(xbgr.mr_n74319408)
print v(xbgr.mr_n74319840)
print v(xbgr.mr_n74320272)
print v(xbgr.mr_n74320704)
print v(xbgr.mr_n74321024)
print v(xbgr.mr_n74321136)
print v(xbgr.mr_n74321456)
print v(xbgr.mr_n74321568)
print v(xbgr.mr_n74321888)
print v(xbgr.mr_n74322000)
print v(xbgr.mr_n74322320)
print v(xbgr.mr_n74322432)
print v(xbgr.mr_n74322752)
print v(xbgr.mr_n74322864)
print v(xbgr.mr_n74323184)
print v(xbgr.mr_n74323296)
print v(xbgr.mr_n74323728)
print v(xbgr.mr_n74324160)
print v(xbgr.mr_n74324592)
print v(xbgr.mr_n74325024)
print v(xbgr.mr_n74325456)
print v(xbgr.mr_n74325888)
print v(xbgr.mr_n74326320)
print v(xbgr.mr_n74326752)
print v(xbgr.mr_n74327184)
print v(xbgr.mr_n74327504)
print v(xbgr.mr_n74327616)
print v(xbgr.mr_n74327936)
print v(xbgr.mr_n74328048)
print v(xbgr.mr_n74328368)
print v(xbgr.mr_n74328480)
print v(xbgr.mr_n74328800)
print v(xbgr.mr_n74328912)
print v(xbgr.mr_n74329232)
print v(xbgr.mr_n74329344)
print v(xbgr.mr_n74329664)
print v(xbgr.mr_n74329776)
print v(xbgr.mr_n74330096)
print v(xbgr.mr_n74330208)
print v(xbgr.mr_n74330528)
print v(xbgr.mr_n74330640)
print v(xbgr.mr_n74330960)
print v(xbgr.mr_n74331072)
print v(xbgr.mr_n74331392)
print v(xbgr.mr_n74331504)
print v(xbgr.mr_n74331824)
print v(xbgr.mr_n74331936)
print v(xbgr.mr_n74332256)
print v(xbgr.mr_n74332368)
print v(xbgr.mr_n74332688)
print v(xbgr.mr_n74332800)
print v(xbgr.mr_n74333120)
print v(xbgr.mr_n74333232)
print v(xbgr.mr_n74333664)
print v(xbgr.mr_n74334096)
print v(xbgr.mr_n74334528)
print v(xbgr.mr_n74334960)
print v(xbgr.mr_n74335280)
print v(xbgr.mr_n74335392)
print v(xbgr.mr_n74335712)
print v(xbgr.mr_n74335824)
print v(xbgr.mr_n74336256)
print v(xbgr.mr_n74336688)
print v(xbgr.mr_n74337120)
print v(xbgr.mr_n74337552)
print v(xbgr.mr_n74337984)
print v(xbgr.mr_n74338416)
print v(xbgr.mr_n74338848)
print v(xbgr.mr_n74339280)
print v(xbgr.mr_n74339600)
print v(xbgr.mr_n74339712)
print v(xbgr.mr_n74340032)
print v(xbgr.mr_n74340144)
print v(xbgr.mr_n74340464)
print v(xbgr.mr_n74340576)
print v(xbgr.mr_n74340896)
print v(xbgr.mr_n74341008)
print v(xbgr.mr_n74341328)
print v(xbgr.mr_n74341440)
print v(xbgr.mr_n74341760)
print v(xbgr.mr_n74341872)
print v(xbgr.mr_n74342192)
print v(xbgr.mr_n74342304)
print v(xbgr.mr_n74342624)
print v(xbgr.mr_n74342736)
print v(xbgr.mr_n74343056)
print v(xbgr.mr_n74343168)
print v(xbgr.mr_n74343488)
print v(xbgr.mr_n74343600)
print v(xbgr.mr_n74343920)
print v(xbgr.mr_n74344032)
print v(xbgr.mr_n74344352)
print v(xbgr.mr_n74344464)
print v(xbgr.mr_n74344896)
print v(xbgr.mr_n74345328)
print v(xbgr.mr_n74345760)
print v(xbgr.mr_n74346192)
print v(xbgr.mr_n74346624)
print v(xbgr.mr_n74347056)
print v(xbgr.mr_n74347376)
print v(xbgr.mr_n74347488)
print v(xbgr.mr_n74347808)
print v(xbgr.mr_n74347920)
print v(xbgr.mr_n74348240)
print v(xbgr.mr_n74348352)
print v(xbgr.mr_n74348672)
print v(xbgr.mr_n74348784)
print v(xbgr.mr_n74349104)
print v(xbgr.mr_n74349216)
print v(xbgr.mr_n74349536)
print v(xbgr.mr_n74349648)
print v(xbgr.mr_n74349968)
print v(xbgr.mr_n74350080)
print v(xbgr.mr_n74350400)
print v(xbgr.mr_n74350512)
print v(xbgr.mr_n74350832)
print v(xbgr.mr_n74350944)
print v(xbgr.mr_n74351264)
print v(xbgr.mr_n74351376)
print v(xbgr.mr_n74351696)
print v(xbgr.mr_n74351808)
print v(xbgr.mr_n74352128)
print v(xbgr.mr_n74352240)
print v(xbgr.mr_n74352560)
print v(xbgr.mr_n74352672)
print v(xbgr.mr_n74352992)
print v(xbgr.mr_n74353104)
print v(xbgr.mr_n74353424)
print v(xbgr.mr_n74353536)
print v(xbgr.mr_n74353856)
print v(xbgr.mr_n74353968)
print v(xbgr.mr_n74354288)
print v(xbgr.mr_n74354400)
print v(xbgr.mr_n74354720)
print v(xbgr.mr_n74354832)
print v(xbgr.mr_n74355264)
print v(xbgr.mr_n74355696)
print v(xbgr.mr_n74356016)
print v(xbgr.mr_n74356128)
print v(xbgr.mr_n74356448)
print v(xbgr.mr_n74356560)
print v(xbgr.mr_n74356880)
print v(xbgr.mr_n74356992)
print v(xbgr.mr_n74357312)
print v(xbgr.mr_n74357424)
print v(xbgr.mr_n74357856)
print v(xbgr.mr_n74358288)
print v(xbgr.mr_n74358720)
print v(xbgr.mr_n74359152)
print v(xbgr.mr_n74359584)
print v(xbgr.mr_n74360016)
print v(xbgr.mr_n74360448)
print v(xbgr.mr_n74360880)
print v(xbgr.mr_n74361312)
print v(xbgr.mr_n74361744)
print v(xbgr.mr_n74362176)
print v(xbgr.mr_n74362608)
print v(xbgr.mr_n74363040)
print v(xbgr.mr_n74363472)
print v(xbgr.mr_n74363904)
print v(xbgr.mr_n74364336)
print v(xbgr.mr_n74364656)
print v(xbgr.mr_n74364768)
print v(xbgr.mr_n74365088)
print v(xbgr.mr_n74365200)
print v(xbgr.mr_n74365520)
print v(xbgr.mr_n74365632)
print v(xbgr.mr_n74365952)
print v(xbgr.mr_n74366064)
print v(xbgr.mr_n74366384)
print v(xbgr.mr_n74366496)
print v(xbgr.mr_n74366816)
print v(xbgr.mr_n74366928)
print v(xbgr.mr_n74367248)
print v(xbgr.mr_n74367360)
print v(xbgr.mr_n74367680)
print v(xbgr.mr_n74367792)
print v(xbgr.mr_n74368112)
print v(xbgr.mr_n74368224)
print v(xbgr.mr_n74368544)
print v(xbgr.mr_n74368656)
print v(xbgr.mr_n74369088)
print v(xbgr.mr_n74369520)
print v(xbgr.mr_n74369952)
print v(xbgr.mr_n74370384)
print v(xbgr.mr_n74370816)
print v(xbgr.mr_n74371248)
print v(xbgr.mr_n74371680)
print v(xbgr.mr_n74372112)
print v(xbgr.mr_n74372432)
print v(xbgr.mr_n74372544)
print v(xbgr.mr_n74372864)
print v(xbgr.mr_n74372976)
print v(xbgr.mr_n74373296)
print v(xbgr.mr_n74373408)
print v(xbgr.mr_n74373728)
print v(xbgr.mr_n74373840)
print v(xbgr.mr_n74374160)
print v(xbgr.mr_n74374272)
print v(xbgr.mr_n74374592)
print v(xbgr.mr_n74374704)
print v(xbgr.mr_n74375024)
print v(xbgr.mr_n74375136)
print v(xbgr.mr_n74375456)
print v(xbgr.mr_n74375568)
print v(xbgr.mr_n74375888)
print v(xbgr.mr_n74376000)
print v(xbgr.mr_n74376320)
print v(xbgr.mr_n74376432)
print v(xbgr.mr_n74376752)
print v(xbgr.mr_n74376864)
print v(xbgr.mr_n74377184)
print v(xbgr.mr_n74377296)
print v(xbgr.mr_n74377616)
print v(xbgr.mr_n74377728)
print v(xbgr.mr_n74378048)
print v(xbgr.mr_n74378160)
print v(xbgr.mr_n74378592)
print v(xbgr.mr_n74379024)
print v(xbgr.mr_n74379456)
print v(xbgr.mr_n74379888)
print v(xbgr.mr_n74380320)
print v(xbgr.mr_n74380752)
print v(xbgr.mr_n74381184)
print v(xbgr.mr_n74381616)
print v(xbgr.mr_n74382048)
print v(xbgr.mr_n74382480)
print v(xbgr.mr_n74382912)
print v(xbgr.mr_n74383344)
print v(xbgr.mr_n74383776)
print v(xbgr.mr_n74384208)
print v(xbgr.mr_n74384528)
print v(xbgr.mr_n74384640)
print v(xbgr.mr_n74384960)
print v(xbgr.mr_n74385072)
print v(xbgr.mr_n74385392)
print v(xbgr.mr_n74385504)
print v(xbgr.mr_n74385824)
print v(xbgr.mr_n74385936)
print v(xbgr.mr_n74386256)
print v(xbgr.mr_n74386368)
print v(xbgr.mr_n74386688)
print v(xbgr.mr_n74386800)
print v(xbgr.mr_n74387120)
print v(xbgr.mr_n74387232)
print v(xbgr.mr_n74387552)
print v(xbgr.mr_n74387664)
print v(xbgr.mr_n74387984)
print v(xbgr.mr_n74388096)
print v(xbgr.mr_n74388416)
print v(xbgr.mr_n74388528)
print v(xbgr.mr_n74388848)
print v(xbgr.mr_n74388960)
print v(xbgr.mr_n74389280)
print v(xbgr.mr_n74389392)
print v(xbgr.mr_n74389712)
print v(xbgr.mr_n74389824)
print v(xbgr.mr_n74390144)
print v(xbgr.mr_n74390256)
print v(xbgr.mr_n74390576)
print v(xbgr.mr_n74390688)
print v(xbgr.mr_n74391008)
print v(xbgr.mr_n74391120)
print v(xbgr.mr_n74391440)
print v(xbgr.mr_n74391552)
print v(xbgr.mr_n74391872)
print v(xbgr.mr_n74391984)
print v(xbgr.mr_n74392304)
print v(xbgr.mr_n74392416)
print v(xbgr.mr_n74392736)
print v(xbgr.mr_n74392848)
print v(xbgr.mr_n74393168)
print v(xbgr.mr_n74393280)
print v(xbgr.mr_n74393600)
print v(xbgr.mr_n74393712)
print v(xbgr.mr_n74394032)
print v(xbgr.mr_n74394144)
print v(xbgr.mr_n74394464)
print v(xbgr.mr_n74394576)
print v(xbgr.mr_n74395008)
print v(xbgr.mr_n74395440)
print v(xbgr.mr_n74395872)
print v(xbgr.mr_n74396304)
print v(xbgr.mr_n74396736)
print v(xbgr.mr_n74397168)
print v(xbgr.mr_n74397600)
print v(xbgr.mr_n74398032)
print v(xbgr.mr_n74398464)
print v(xbgr.mr_n74398896)
print v(xbgr.mr_n74399328)
print v(xbgr.mr_n74399760)
print v(xbgr.mr_n74400192)
print v(xbgr.mr_n74400624)
print v(xbgr.mr_n74401056)
print v(xbgr.mr_n74401488)
print v(xbgr.mr_n74401808)
print v(xbgr.mr_n74401920)
print v(xbgr.mr_n74402240)
print v(xbgr.mr_n74402352)
print v(xbgr.mr_n74402784)
print v(xbgr.mr_n74403216)
print v(xbgr.mr_n74403648)
print v(xbgr.mr_n74404080)
print v(xbgr.mr_n74404512)
print v(xbgr.mr_n74404944)
print v(xbgr.mr_n74405376)
print v(xbgr.mr_n74405808)
print v(xbgr.mr_n74406240)
print v(xbgr.mr_n74406672)
print v(xbgr.mr_n74406992)
print v(xbgr.mr_n74407104)
print v(xbgr.mr_n74407424)
print v(xbgr.mr_n74407536)
print v(xbgr.mr_n74407856)
print v(xbgr.mr_n74407968)
print v(xbgr.mr_n74408288)
print v(xbgr.mr_n74408400)
print v(xbgr.mr_n74408720)
print v(xbgr.mr_n74408832)
print v(xbgr.mr_n74409152)
print v(xbgr.mr_n74409264)
print v(xbgr.mr_n74409584)
print v(xbgr.mr_n74409696)
print v(xbgr.mr_n74410016)
print v(xbgr.mr_n74410128)
print v(xbgr.mr_n74410448)
print v(xbgr.mr_n74410560)
print v(xbgr.mr_n74410880)
print v(xbgr.mr_n74410992)
print v(xbgr.mr_n74411312)
print v(xbgr.mr_n74411424)
print v(xbgr.mr_n74411744)
print v(xbgr.mr_n74411856)
print v(xbgr.mr_n74412176)
print v(xbgr.mr_n74412288)
print v(xbgr.mr_n74412720)
print v(xbgr.mr_n74413152)
print v(xbgr.mr_n74413584)
print v(xbgr.mr_n74414016)
print v(xbgr.mr_n74414448)
print v(xbgr.mr_n74414880)
print v(xbgr.mr_n74415312)
print v(xbgr.mr_n74415744)
print v(xbgr.mr_n74416176)
print v(xbgr.mr_n74416608)
print v(xbgr.mr_n74417040)
print v(xbgr.mr_n74417472)
print v(xbgr.mr_n74417904)
print v(xbgr.mr_n74418224)
print v(xbgr.mr_n74418336)
print v(xbgr.mr_n74418656)
print v(xbgr.mr_n74418768)
print v(xbgr.mr_n74419088)
print v(xbgr.mr_n74419200)
print v(xbgr.mr_n74419520)
print v(xbgr.mr_n74419632)
print v(xbgr.mr_n74419952)
print v(xbgr.mr_n74420064)
print v(xbgr.mr_n74420384)
print v(xbgr.mr_n74420496)
print v(xbgr.mr_n74420816)
print v(xbgr.mr_n74420928)
print v(xbgr.mr_n74421248)
print v(xbgr.mr_n74421360)
print v(xbgr.mr_n74421680)
print v(xbgr.mr_n74421792)
print v(xbgr.mr_n74422112)
print v(xbgr.mr_n74422224)
print v(xbgr.mr_n74422544)
print v(xbgr.mr_n74422656)
print v(xbgr.mr_n74422976)
print v(xbgr.mr_n74423088)
print v(xbgr.mr_n74423408)
print v(xbgr.mr_n74423520)
print v(xbgr.mr_n74423952)
print v(xbgr.mr_n74424384)
print v(xbgr.mr_n74424816)
print v(xbgr.mr_n74425248)
print v(xbgr.mr_n74425680)
print v(xbgr.mr_n74426112)
print v(xbgr.mr_n74426544)
print v(xbgr.mr_n74426976)
print v(xbgr.mr_n74427408)
print v(xbgr.mr_n74427840)
print v(xbgr.mr_n74428272)
print v(xbgr.mr_n74428704)
print v(xbgr.mr_n74429136)
print v(xbgr.mr_n74429456)
print v(xbgr.mr_n74429568)
print v(xbgr.mr_n74429888)
print v(xbgr.mr_n74430000)
print v(xbgr.mr_n74430320)
print v(xbgr.mr_n74430432)
print v(xbgr.mr_n74430752)
print v(xbgr.mr_n74430864)
print v(xbgr.mr_n74431184)
print v(xbgr.mr_n74431296)
print v(xbgr.mr_n74431616)
print v(xbgr.mr_n74431728)
print v(xbgr.mr_n74432048)
print v(xbgr.mr_n74432160)
print v(xbgr.mr_n74432480)
print v(xbgr.mr_n74432592)
print v(xbgr.mr_n74432912)
print v(xbgr.mr_n74433024)
print v(xbgr.mr_n74433344)
print v(xbgr.mr_n74433456)
print v(xbgr.mr_n74433776)
print v(xbgr.mr_n74433888)
print v(xbgr.mr_n74434208)
print v(xbgr.mr_n74434320)
print v(xbgr.mr_n74434640)
print v(xbgr.mr_n74434752)
print v(xbgr.mr_n74435184)
print v(xbgr.mr_n74435616)
print v(xbgr.mr_n74436048)
print v(xbgr.mr_n74436480)
print v(xbgr.mr_n74436912)
print v(xbgr.mr_n74437344)
print v(xbgr.mr_n74437776)
print v(xbgr.mr_n74438208)
print v(xbgr.mr_n74438640)
print v(xbgr.mr_n74439072)
print v(xbgr.mr_n74439504)
print v(xbgr.mr_n74439936)
print v(xbgr.mr_n74440368)
print v(xbgr.mr_n74440688)
print v(xbgr.mr_n74440800)
print v(xbgr.mr_n74441120)
print v(xbgr.mr_n74441232)
print v(xbgr.mr_n74441552)
print v(xbgr.mr_n74441664)
print v(xbgr.mr_n74441984)
print v(xbgr.mr_n74442096)
print v(xbgr.mr_n74442416)
print v(xbgr.mr_n74442528)
print v(xbgr.mr_n74442848)
print v(xbgr.mr_n74442960)
print v(xbgr.mr_n74443280)
print v(xbgr.mr_n74443392)
print v(xbgr.mr_n74443712)
print v(xbgr.mr_n74443824)
print v(xbgr.mr_n74444144)
print v(xbgr.mr_n74444256)
print v(xbgr.mr_n74444576)
print v(xbgr.mr_n74444688)
print v(xbgr.mr_n74445008)
print v(xbgr.mr_n74445120)
print v(xbgr.mr_n74445440)
print v(xbgr.mr_n74445552)
print v(xbgr.mr_n74445872)
print v(xbgr.mr_n74445984)
print v(xbgr.mr_n74446416)
print v(xbgr.mr_n74446848)
print v(xbgr.mr_n74447280)
print v(xbgr.mr_n74447712)
print v(xbgr.mr_n74448144)
print v(xbgr.mr_n74448576)
print v(xbgr.mr_n74449008)
print v(xbgr.mr_n74449440)
print v(xbgr.mr_n74449872)
print v(xbgr.mr_n74450304)
print v(xbgr.mr_n74450736)
print v(xbgr.mr_n74451168)
print v(xbgr.mr_n74451600)
print v(xbgr.mr_n74451920)
print v(xbgr.mr_n74452032)
print v(xbgr.mr_n74452352)
print v(xbgr.mr_n74452464)
print v(xbgr.mr_n74452784)
print v(xbgr.mr_n74452896)
print v(xbgr.mr_n74453216)
print v(xbgr.mr_n74453328)
print v(xbgr.mr_n74453648)
print v(xbgr.mr_n74453760)
print v(xbgr.mr_n74454192)
print v(xbgr.mr_n74454624)
print v(xbgr.mr_n74455056)
print v(xbgr.mr_n74455488)
print v(xbgr.mr_n74455920)
print v(xbgr.mr_n74456240)
print v(xbgr.mr_n74456352)
print v(xbgr.mr_n74456672)
print v(xbgr.mr_n74456784)
print v(xbgr.mr_n74457104)
print v(xbgr.mr_n74457216)
print v(xbgr.mr_n74457536)
print v(xbgr.mr_n74457648)
print v(xbgr.mr_n74457968)
print v(xbgr.mr_n74458080)
print v(xbgr.mr_n74458400)
print v(xbgr.mr_n74458512)
print v(xbgr.mr_n74458832)
print v(xbgr.mr_n74458944)
print v(xbgr.mr_n74459264)
print v(xbgr.mr_n74459376)
print v(xbgr.mr_n74459808)
print v(xbgr.mr_n74460240)
print v(xbgr.mr_n74460672)
print v(xbgr.mr_n74461104)
print v(xbgr.mr_n74461536)
print v(xbgr.mr_n74461968)
print v(xbgr.mr_n74462400)
print v(xbgr.mr_n74462832)
print v(xbgr.mr_n74463152)
print v(xbgr.mr_n74463264)
print v(xbgr.mr_n74463584)
print v(xbgr.mr_n74463696)
print v(xbgr.mr_n74464016)
print v(xbgr.mr_n74464128)
print v(xbgr.mr_n74464448)
print v(xbgr.mr_n74464560)
print v(xbgr.mr_n74464880)
print v(xbgr.mr_n74464992)
print v(xbgr.mr_n74465312)
print v(xbgr.mr_n74465424)
print v(xbgr.mr_n74465744)
print v(xbgr.mr_n74465856)
print v(xbgr.mr_n74466176)
print v(xbgr.mr_n74466288)
print v(xbgr.mr_n74466720)
print v(xbgr.mr_n74467152)
print v(xbgr.mr_n74467584)
print v(xbgr.mr_n74468016)
print v(xbgr.mr_n74468448)
print v(xbgr.mr_n74468768)
print v(xbgr.mr_n74468880)
print v(xbgr.mr_n74469200)
print v(xbgr.mr_n74469312)
print v(xbgr.mr_n74469632)
print v(xbgr.mr_n74469744)
print v(xbgr.mr_n74470064)
print v(xbgr.mr_n74470176)
print v(xbgr.mr_n74470496)
print v(xbgr.mr_n74470608)
print v(xbgr.mr_n74471040)
print v(xbgr.mr_n74471472)
print v(xbgr.mr_n74471904)
print v(xbgr.mr_n74472336)
print v(xbgr.mr_n74472768)
print v(xbgr.mr_n74473200)
print v(xbgr.mr_n74473632)
print v(xbgr.mr_n74474064)
print v(xbgr.mr_n74474384)
print v(xbgr.mr_n74474496)
print v(xbgr.mr_n74474816)
print v(xbgr.mr_n74474928)
print v(xbgr.mr_n74475248)
print v(xbgr.mr_n74475360)
print v(xbgr.mr_n74475680)
print v(xbgr.mr_n74475792)
print v(xbgr.mr_n74476112)
print v(xbgr.mr_n74476224)
print v(xbgr.mr_n74476544)
print v(xbgr.mr_n74476656)
print v(xbgr.mr_n74476976)
print v(xbgr.mr_n74477088)
print v(xbgr.mr_n74477520)
print v(xbgr.mr_n74477952)
print v(xbgr.mr_n74478384)
print v(xbgr.mr_n74478816)
print v(xbgr.mr_n74479136)
print v(xbgr.mr_n74479248)
print v(xbgr.mr_n74479680)
print v(xbgr.mr_n74480112)
print v(xbgr.mr_n74480432)
print v(xbgr.mr_n74480544)
print v(xbgr.mr_n74480864)
print v(xbgr.mr_n74480976)
print v(xbgr.mr_n74481296)
print v(xbgr.mr_n74481408)
print v(xbgr.mr_n74481728)
print v(xbgr.mr_n74481840)
print v(xbgr.mr_n74482160)
print v(xbgr.mr_n74482272)
print v(xbgr.mr_n74482704)
print v(xbgr.mr_n74483136)
print v(xbgr.mr_n74483568)
print v(xbgr.mr_n74484000)
print v(xbgr.mr_n74484432)
print v(xbgr.mr_n74484864)
print v(xbgr.mr_n74485296)
print v(xbgr.mr_n74485616)
print v(xbgr.mr_n74485728)
print v(xbgr.mr_n74486048)
print v(xbgr.mr_n74486160)
print v(xbgr.mr_n74486480)
print v(xbgr.mr_n74486592)
print v(xbgr.mr_n74486912)
print v(xbgr.mr_n74487024)
print v(xbgr.mr_n74487344)
print v(xbgr.mr_n74487456)
print v(xbgr.mr_n74487776)
print v(xbgr.mr_n74487888)
print v(xbgr.mr_n74488208)
print v(xbgr.mr_n74488320)
print v(xbgr.mr_n74488640)
print v(xbgr.mr_n74488752)
print v(xbgr.mr_n74489072)
print v(xbgr.mr_n74489184)
print v(xbgr.mr_n74489504)
print v(xbgr.mr_n74489616)
print v(xbgr.mr_n74489936)
print v(xbgr.mr_n74490048)
print v(xbgr.mr_n74490368)
print v(xbgr.mr_n74490480)
print v(xbgr.mr_n74490800)
print v(xbgr.mr_n74490912)
print v(xbgr.mr_n74491344)
print v(xbgr.mr_n74491776)
print v(xbgr.mr_n74492208)
print v(xbgr.mr_n74492640)
print v(xbgr.mr_n74493072)
print v(xbgr.mr_n74493504)
print v(xbgr.mr_n74493936)
print v(xbgr.mr_n74494368)
print v(xbgr.mr_n74494800)
print v(xbgr.mr_n74495232)
print v(xbgr.mr_n74495664)
print v(xbgr.mr_n74496096)
print v(xbgr.mr_n74496528)
print v(xbgr.mr_n74496848)
print v(xbgr.mr_n74496960)
print v(xbgr.mr_n74497280)
print v(xbgr.mr_n74497392)
print v(xbgr.mr_n74497712)
print v(xbgr.mr_n74497824)
print v(xbgr.mr_n74498144)
print v(xbgr.mr_n74498256)
print v(xbgr.mr_n74498576)
print v(xbgr.mr_n74498688)
print v(xbgr.mr_n74499008)
print v(xbgr.mr_n74499120)
print v(xbgr.mr_n74499440)
print v(xbgr.mr_n74499552)
print v(xbgr.mr_n74499872)
print v(xbgr.mr_n74499984)
print v(xbgr.mr_n74500304)
print v(xbgr.mr_n74500416)
print v(xbgr.mr_n74500736)
print v(xbgr.mr_n74500848)
print v(xbgr.mr_n74501168)
print v(xbgr.mr_n74501280)
print v(xbgr.mr_n74501600)
print v(xbgr.mr_n74501712)
print v(xbgr.mr_n74502032)
print v(xbgr.mr_n74502144)
print v(xbgr.mr_n74502464)
print v(xbgr.mr_n74502576)
print v(xbgr.mr_n74502896)
print v(xbgr.mr_n74503008)
print v(xbgr.mr_n74503328)
print v(xbgr.mr_n74503440)
print v(xbgr.mr_n74503872)
print v(xbgr.mr_n74504304)
print v(xbgr.mr_n74504736)
print v(xbgr.mr_n74505168)
print v(xbgr.mr_n74505600)
print v(xbgr.mr_n74506032)
print v(xbgr.mr_n74506352)
print v(xbgr.mr_n74506464)
print v(xbgr.mr_n74506784)
print v(xbgr.mr_n74506896)
print v(xbgr.mr_n74507216)
print v(xbgr.mr_n74507328)
print v(xbgr.mr_n74507648)
print v(xbgr.mr_n74507760)
print v(xbgr.mr_n74508080)
print v(xbgr.mr_n74508192)
print v(xbgr.mr_n74508512)
print v(xbgr.mr_n74508624)
print v(xbgr.mr_n74508944)
print v(xbgr.mr_n74509056)
print v(xbgr.mr_n74509376)
print v(xbgr.mr_n74509488)
print v(xbgr.mr_n74509808)
print v(xbgr.mr_n74509920)
print v(xbgr.mr_n74510240)
print v(xbgr.mr_n74510352)
print v(xbgr.mr_n74510784)
print v(xbgr.mr_n74511216)
print v(xbgr.mr_n74511648)
print v(xbgr.mr_n74512080)
print v(xbgr.mr_n74512512)
print v(xbgr.mr_n74512944)
print v(xbgr.mr_n74513376)
print v(xbgr.mr_n74513808)
print v(xbgr.mr_n74514240)
print v(xbgr.mr_n74514672)
print v(xbgr.mr_n74515104)
print v(xbgr.mr_n74515536)
print v(xbgr.mr_n74515968)
print v(xbgr.mr_n74516400)
print v(xbgr.mr_n74516832)
print v(xbgr.mr_n74517264)
print v(xbgr.mr_n74517696)
print v(xbgr.mr_n74518128)
print v(xbgr.mr_n74518560)
print v(xbgr.mr_n74518992)
print v(xbgr.mr_n74519312)
print v(xbgr.mr_n74519424)
print v(xbgr.mr_n74519744)
print v(xbgr.mr_n74519856)
print v(xbgr.mr_n74520176)
print v(xbgr.mr_n74520288)
print v(xbgr.mr_n74520608)
print v(xbgr.mr_n74520720)
print v(xbgr.mr_n74521040)
print v(xbgr.mr_n74521152)
print v(xbgr.mr_n74521472)
print v(xbgr.mr_n74521584)
print v(xbgr.mr_n74521904)
print v(xbgr.mr_n74522016)
print v(xbgr.mr_n74522336)
print v(xbgr.mr_n74522448)
print v(xbgr.mr_n74522768)
print v(xbgr.mr_n74522880)
print v(xbgr.mr_n74523200)
print v(xbgr.mr_n74523312)
print v(xbgr.mr_n74523632)
print v(xbgr.mr_n74523744)
print v(xbgr.mr_n74524064)
print v(xbgr.mr_n74524176)
print v(xbgr.mr_n74524496)
print v(xbgr.mr_n74524608)
print v(xbgr.mr_n74524928)
print v(xbgr.mr_n74525040)
print v(xbgr.mr_n74525472)
print v(xbgr.mr_n74525904)
print v(xbgr.mr_n74526336)
print v(xbgr.mr_n74526768)
print v(xbgr.mr_n74527088)
print v(xbgr.mr_n74527200)
print v(xbgr.mr_n74527520)
print v(xbgr.mr_n74527632)
print v(xbgr.mr_n74527952)
print v(xbgr.mr_n74528064)
print v(xbgr.mr_n74528384)
print v(xbgr.mr_n74528496)
print v(xbgr.mr_n74528816)
print v(xbgr.mr_n74528928)
print v(xbgr.mr_n74529248)
print v(xbgr.mr_n74529360)
print v(xbgr.mr_n74529792)
print v(xbgr.mr_n74530224)
print v(xbgr.mr_n74530656)
print v(xbgr.mr_n74531088)
print v(xbgr.mr_n74531520)
print v(xbgr.mr_n74531952)
print v(xbgr.mr_n74532384)
print v(xbgr.mr_n74532816)
print v(xbgr.mr_n74533248)
print v(xbgr.mr_n74533680)
print v(xbgr.mr_n74534000)
print v(xbgr.mr_n74534112)
print v(xbgr.mr_n74534432)
print v(xbgr.mr_n74534544)
print v(xbgr.mr_n74534976)
print v(xbgr.mr_n74535408)
print v(xbgr.mr_n74535728)
print v(xbgr.mr_n74535840)
print v(xbgr.mr_n74536160)
print v(xbgr.mr_n74536272)
print v(xbgr.mr_n74536592)
print v(xbgr.mr_n74536704)
print v(xbgr.mr_n74537024)
print v(xbgr.mr_n74537136)
print v(xbgr.mr_n74537568)
print v(xbgr.mr_n74538000)
print v(xbgr.mr_n74538432)
print v(xbgr.mr_n74538864)
print v(xbgr.mr_n74539296)
print v(xbgr.mr_n74539728)
print v(xbgr.mr_n74540160)
print v(xbgr.mr_n74540592)
print v(xbgr.mr_n74541024)
print v(xbgr.mr_n74541456)
print v(xbgr.mr_n74541776)
print v(xbgr.mr_n74541888)
print v(xbgr.mr_n74542208)
print v(xbgr.mr_n74542320)
print v(xbgr.mr_n74542640)
print v(xbgr.mr_n74542752)
print v(xbgr.mr_n74543072)
print v(xbgr.mr_n74543184)
print v(xbgr.mr_n74543504)
print v(xbgr.mr_n74543616)
print v(xbgr.mr_n74543936)
print v(xbgr.mr_n74544048)
print v(xbgr.mr_n74544368)
print v(xbgr.mr_n74544480)
print v(xbgr.mr_n74544800)
print v(xbgr.mr_n74544912)
print v(xbgr.mr_n74545232)
print v(xbgr.mr_n74545344)
print v(xbgr.mr_n74545664)
print v(xbgr.mr_n74545776)
print v(xbgr.mr_n74546096)
print v(xbgr.mr_n74546208)
print v(xbgr.mr_n74546528)
print v(xbgr.mr_n74546640)
print v(xbgr.mr_n74546960)
print v(xbgr.mr_n74547072)
print v(xbgr.mr_n74547392)
print v(xbgr.mr_n74547504)
print v(xbgr.mr_n74547824)
print v(xbgr.mr_n74547936)
print v(xbgr.mr_n74548256)
print v(xbgr.mr_n74548368)
print v(xbgr.mr_n74548688)
print v(xbgr.mr_n74548800)
print v(xbgr.mr_n74549120)
print v(xbgr.mr_n74549232)
print v(xbgr.mr_n74549552)
print v(xbgr.mr_n74549664)
print v(xbgr.mr_n74549984)
print v(xbgr.mr_n74550096)
print v(xbgr.mr_n74550416)
print v(xbgr.mr_n74550528)
print v(xbgr.mr_n74550848)
print v(xbgr.mr_n74551280)
print v(xbgr.mr_n74551392)
print v(xbgr.mr_n74551712)
print v(xbgr.mr_n74552144)
print v(xbgr.mr_n74552256)
print v(xbgr.mr_n74552576)
print v(xbgr.mr_n74553008)
print v(xbgr.mr_n74553120)
print v(xbgr.mr_n74553440)
print v(xbgr.mr_n74553872)
print v(xbgr.mr_n74553984)
print v(xbgr.mr_n74554304)
print v(xbgr.mr_n74554736)
print v(xbgr.mr_n74554848)
print v(xbgr.mr_n74555168)
print v(xbgr.mr_n74555280)
print v(xbgr.mr_n74555600)
print v(xbgr.mr_n74555712)
print v(xbgr.mr_n74556032)
print v(xbgr.mr_n74556144)
print v(xbgr.mr_n74556464)
print v(xbgr.mr_n74556576)
print v(xbgr.mr_n74556896)
print v(xbgr.mr_n74557008)
print v(xbgr.mr_n74557328)
print v(xbgr.mr_n74557440)
print v(xbgr.mr_n74557760)
print v(xbgr.mr_n74557872)
print v(xbgr.mr_n74558192)
print v(xbgr.mr_n74558304)
print v(xbgr.mr_n74558624)
print v(xbgr.mr_n74558736)
print v(xbgr.mr_n74559056)
print v(xbgr.mr_n74559168)
print v(xbgr.mr_n74559488)
print v(xbgr.mr_n74559600)
print v(xbgr.mr_n74559920)
print v(xbgr.mr_n74560032)
print v(xbgr.mr_n74560352)
print v(xbgr.mr_n74560464)
print v(xbgr.mr_n74560784)
print v(xbgr.mr_n74560896)
print v(xbgr.mr_n74561216)
print v(xbgr.mr_n74561328)
print v(xbgr.mr_n74561648)
print v(xbgr.mr_n74561760)
print v(xbgr.mr_n74562080)
print v(xbgr.mr_n74562192)
print v(xbgr.mr_n74562512)
print v(xbgr.mr_n74562624)
print v(xbgr.mr_n74562944)
print v(xbgr.mr_n74563056)
print v(xbgr.mr_n74563376)
print v(xbgr.mr_n74563488)
print v(xbgr.mr_n74563808)
print v(xbgr.mr_n74563920)
print v(xbgr.mr_n74564240)
print v(xbgr.mr_n74564352)
print v(xbgr.mr_n74564672)
print v(xbgr.mr_n74564784)
print v(xbgr.mr_n74565104)
print v(xbgr.mr_n74565216)
print v(xbgr.mr_n74565536)
print v(xbgr.mr_n74565648)
print v(xbgr.mr_n74565968)
print v(xbgr.mr_n74566080)
print v(xbgr.mr_n74566400)
print v(xbgr.mr_n74566512)
print v(xbgr.mr_n74566832)
print v(xbgr.mr_n74566944)
print v(xbgr.mr_n74567264)
print v(xbgr.mr_n74567376)
print v(xbgr.mr_n74567696)
print v(xbgr.mr_n74567808)
print v(xbgr.mr_n74568128)
print v(xbgr.mr_n74568240)
print v(xbgr.mr_n74568560)
print v(xbgr.mr_n74568672)
print v(xbgr.mr_n74568992)
print v(xbgr.mr_n74569104)
print v(xbgr.mr_n74569424)
print v(xbgr.mr_n74569536)
print v(xbgr.mr_n74569856)
print v(xbgr.mr_n74569968)
print v(xbgr.mr_n74570288)
print v(xbgr.mr_n74570400)
print v(xbgr.mr_n74570720)
print v(xbgr.mr_n74570832)
print v(xbgr.mr_n74571152)
print v(xbgr.mr_n74571264)
print v(xbgr.mr_n74571584)
print v(xbgr.mr_n74571696)
print v(xbgr.mr_n74572016)
print v(xbgr.mr_n74572128)
print v(xbgr.mr_n74572448)
print v(xbgr.mr_n74572560)
print v(xbgr.mr_n74572880)
print v(xbgr.mr_n74572992)
print v(xbgr.mr_n74573312)
print v(xbgr.mr_n74573424)
print v(xbgr.mr_n74573744)
print v(xbgr.mr_n74573856)
print v(xbgr.mr_n74574176)
print v(xbgr.mr_n74574288)
print v(xbgr.mr_n74574608)
print v(xbgr.mr_n74574720)
print v(xbgr.mr_n74575040)
print v(xbgr.mr_n74575152)
print v(xbgr.mr_n74575472)
print v(xbgr.mr_n74575584)
print v(xbgr.mr_n74575904)
print v(xbgr.mr_n74576016)
print v(xbgr.mr_n74576336)
print v(xbgr.mr_n74576448)
print v(xbgr.mr_n74576768)
print v(xbgr.mr_n74576880)
print v(xbgr.mr_n74577200)
print v(xbgr.mr_n74577312)
print v(xbgr.mr_n74577632)
print v(xbgr.mr_n74577744)
print v(xbgr.mr_n74578064)
print v(xbgr.mr_n74578176)
print v(xbgr.mr_n74578496)
print v(xbgr.mr_n74578608)
print v(xbgr.mr_n74578928)
print v(xbgr.mr_n74579040)
print v(xbgr.mr_n74579360)
print v(xbgr.mr_n74579472)
print v(xbgr.mr_n74579792)
print v(xbgr.mr_n74579904)
print v(xbgr.mr_n74580224)
print v(xbgr.mr_n74580336)
print v(xbgr.mr_n74580656)
print v(xbgr.mr_n74580768)
print v(xbgr.mr_n74581088)
print v(xbgr.mr_n74581200)
print v(xbgr.mr_n74581520)
print v(xbgr.mr_n74581632)
print v(xbgr.mr_n74581952)
print v(xbgr.mr_n74582064)
print v(xbgr.mr_n74582384)
print v(xbgr.mr_n74582496)
print v(xbgr.mr_n74582816)
print v(xbgr.mr_n74582928)
print v(xbgr.mr_n74583248)
print v(xbgr.mr_n74583360)
print v(xbgr.mr_n74583680)
print v(xbgr.mr_n74583792)
print v(xbgr.mr_n74584112)
print v(xbgr.mr_n74584224)
print v(xbgr.mr_n74584544)
print v(xbgr.mr_n74584656)
print v(xbgr.mr_n74584976)
print v(xbgr.mr_n74585088)
print v(xbgr.mr_n74585408)
print v(xbgr.mr_n74585520)
print v(xbgr.mr_n74585840)
print v(xbgr.mr_n74586272)
print v(xbgr.mr_n74586384)
print v(xbgr.mr_n74586704)
print v(xbgr.mr_n74587136)
print v(xbgr.mr_n74587248)
print v(xbgr.mr_n74587568)
print v(xbgr.mr_n74588000)
print v(xbgr.mr_n74588112)
print v(xbgr.mr_n74588432)
print v(xbgr.mr_n74588864)
print v(xbgr.mr_n74588976)
print v(xbgr.mr_n74589296)
print v(xbgr.mr_n74589408)
print v(xbgr.mr_n74589728)
print v(xbgr.mr_n74589840)
print v(xbgr.mr_n74590160)
print v(xbgr.mr_n74590272)
print v(xbgr.mr_n74590592)
print v(xbgr.mr_n74591024)
print v(xbgr.mr_n74591136)
print v(xbgr.mr_n74591456)
print v(xbgr.mr_n74591888)
print v(xbgr.mr_n74592000)
print v(xbgr.mr_n74592320)
print v(xbgr.mr_n74592752)
print v(xbgr.mr_n74592864)
print v(xbgr.mr_n74593184)
print v(xbgr.mr_n74593616)
print v(xbgr.mr_n74593728)
print v(xbgr.mr_n74594048)
print v(xbgr.mr_n74594160)
print v(xbgr.mr_n74594480)
print v(xbgr.mr_n74594592)
print v(xbgr.mr_n74594912)
print v(xbgr.mr_n74595024)
print v(xbgr.mr_n74595344)
print v(xbgr.mr_n74595456)
print v(xbgr.mr_n74595776)
print v(xbgr.mr_n74595888)
print v(xbgr.mr_n74596208)
print v(xbgr.mr_n74596320)
print v(xbgr.mr_n74596640)
print v(xbgr.mr_n74596752)
print v(xbgr.mr_n74597072)
print v(xbgr.mr_n74597184)
print v(xbgr.mr_n74597504)
print v(xbgr.mr_n74597616)
print v(xbgr.mr_n74597936)
print v(xbgr.mr_n74598048)
print v(xbgr.mr_n74598368)
print v(xbgr.mr_n74598480)
print v(xbgr.mr_n74598800)
print v(xbgr.mr_n74598912)
print v(xbgr.mr_n74599232)
print v(xbgr.mr_n74599344)
print v(xbgr.mr_n74599664)
print v(xbgr.mr_n74599776)
print v(xbgr.mr_n74600096)
print v(xbgr.mr_n74600208)
print v(xbgr.mr_n74600528)
print v(xbgr.mr_n74600640)
print v(xbgr.mr_n74600960)
print v(xbgr.mr_n74601072)
print v(xbgr.mr_n74601392)
print v(xbgr.mr_n74601504)
print v(xbgr.mr_n74601824)
print v(xbgr.mr_n74601936)
print v(xbgr.mr_n74602256)
print v(xbgr.mr_n74602368)
print v(xbgr.mr_n74602688)
print v(xbgr.mr_n74602800)
print v(xbgr.mr_n74603120)
print v(xbgr.mr_n74603232)
print v(xbgr.mr_n74603552)
print v(xbgr.mr_n74603664)
print v(xbgr.mr_n74603984)
print v(xbgr.mr_n74604096)
print v(xbgr.mr_n74604416)
print v(xbgr.mr_n74604528)
print v(xbgr.mr_n74604848)
print v(xbgr.mr_n74604960)
print v(xbgr.mr_n74605280)
print v(xbgr.mr_n74605392)
print v(xbgr.mr_n74605824)
print v(xbgr.mr_n74606256)
print v(xbgr.mr_n74606688)
print v(xbgr.mr_n74607120)
print v(xbgr.mr_n74607552)
print v(xbgr.mr_n74607984)
print v(xbgr.mr_n74608416)
print v(xbgr.mr_n74608848)
print v(xbgr.mr_n74609280)
print v(xbgr.mr_n74609712)
print v(xbgr.mr_n74610144)
print v(xbgr.mr_n74610576)
print v(xbgr.mr_n74611008)
print v(xbgr.mr_n74611440)
print v(xbgr.mr_n74611872)
print v(xbgr.mr_n74612304)
print v(xbgr.mr_n74612736)
print v(xbgr.mr_n74613168)
print v(xbgr.mr_n74613600)
print v(xbgr.mr_n74614032)
print v(xbgr.mr_n74614464)
print v(xbgr.mr_n74614896)
print v(xbgr.mr_n74615328)
print v(xbgr.mr_n74615760)
print v(xbgr.mr_n74616192)
print v(xbgr.mr_n74616624)
print v(xbgr.mr_n74616944)
print v(xbgr.mr_n74617056)
print v(xbgr.mr_n74617376)
print v(xbgr.mr_n74617488)
print v(xbgr.mr_n74617808)
print v(xbgr.mr_n74617920)
print v(xbgr.mr_n74618240)
print v(xbgr.mr_n74618352)
print v(xbgr.mr_n74618672)
print v(xbgr.mr_n74618784)
print v(xbgr.mr_n74619104)
print v(xbgr.mr_n74619216)
print v(xbgr.mr_n74619536)
print v(xbgr.mr_n74619648)
print v(xbgr.mr_n74619968)
print v(xbgr.mr_n74620080)
print v(xbgr.mr_n74620400)
print v(xbgr.mr_n74620512)
print v(xbgr.mr_n74620832)
print v(xbgr.mr_n74620944)
print v(xbgr.mr_n74621264)
print v(xbgr.mr_n74621376)
print v(xbgr.mr_n74621696)
print v(xbgr.mr_n74621808)
print v(xbgr.mr_n74622128)
print v(xbgr.mr_n74622240)
print v(xbgr.mr_n74622560)
print v(xbgr.mr_n74622672)
print v(xbgr.mr_n74622992)
print v(xbgr.mr_n74623104)
print v(xbgr.mr_n74623424)
print v(xbgr.mr_n74623536)
print v(xbgr.mr_n74623856)
print v(xbgr.mr_n74623968)
print v(xbgr.mr_n74624288)
print v(xbgr.mr_n74624400)
print v(xbgr.mr_n74624720)
print v(xbgr.mr_n74624832)
print v(xbgr.mr_n74625152)
print v(xbgr.mr_n74625264)
print v(xbgr.mr_n74625696)
print v(xbgr.mr_n74626128)
print v(xbgr.mr_n74626560)
print v(xbgr.mr_n74626992)
print v(xbgr.mr_n74627424)
print v(xbgr.mr_n74627856)
print v(xbgr.mr_n74628288)
print v(xbgr.mr_n74628720)
print v(xbgr.mr_n74629152)
print v(xbgr.mr_n74629584)
print v(xbgr.mr_n74630016)
print v(xbgr.mr_n74630448)
print v(xbgr.mr_n74630768)
print v(xbgr.mr_n74630880)
print v(xbgr.mr_n74631200)
print v(xbgr.mr_n74631312)
print v(xbgr.mr_n74631744)
print v(xbgr.mr_n74632176)
print v(xbgr.mr_n74632608)
print v(xbgr.mr_n74633040)
print v(xbgr.mr_n74633472)
print v(xbgr.mr_n74633904)
print v(xbgr.mr_n74634336)
print v(xbgr.mr_n74634768)
print v(xbgr.mr_n74635200)
print v(xbgr.mr_n74635632)
print v(xbgr.mr_n74635952)
print v(xbgr.mr_n74636064)
print v(xbgr.mr_n74636384)
print v(xbgr.mr_n74636496)
print v(xbgr.mr_n74636816)
print v(xbgr.mr_n74636928)
print v(xbgr.mr_n74637248)
print v(xbgr.mr_n74637360)
print v(xbgr.mr_n74637680)
print v(xbgr.mr_n74637792)
print v(xbgr.mr_n74638112)
print v(xbgr.mr_n74638224)
print v(xbgr.mr_n74638544)
print v(xbgr.mr_n74638656)
print v(xbgr.mr_n74638976)
print v(xbgr.mr_n74639088)
print v(xbgr.mr_n74639408)
print v(xbgr.mr_n74639520)
print v(xbgr.mr_n74639840)
print v(xbgr.mr_n74639952)
print v(xbgr.mr_n74640272)
print v(xbgr.mr_n74640384)
print v(xbgr.mr_n74640704)
print v(xbgr.mr_n74640816)
print v(xbgr.mr_n74641136)
print v(xbgr.mr_n74641248)
print v(xbgr.mr_n74641568)
print v(xbgr.mr_n74641680)
print v(xbgr.mr_n74642000)
print v(xbgr.mr_n74642112)
print v(xbgr.mr_n74642432)
print v(xbgr.mr_n74642544)
print v(xbgr.mr_n74642864)
print v(xbgr.mr_n74642976)
print v(xbgr.mr_n74643296)
print v(xbgr.mr_n74643408)
print v(xbgr.mr_n74643728)
print v(xbgr.mr_n74643840)
print v(xbgr.mr_n74644160)
print v(xbgr.mr_n74644272)
print v(xbgr.mr_n74644592)
print v(xbgr.mr_n74644704)
print v(xbgr.mr_n74645024)
print v(xbgr.mr_n74645136)
print v(xbgr.mr_n74645456)
print v(xbgr.mr_n74645568)
print v(xbgr.mr_n74645888)
print v(xbgr.mr_n74646000)
print v(xbgr.mr_n74646320)
print v(xbgr.mr_n74646432)
print v(xbgr.mr_n74646752)
print v(xbgr.mr_n74646864)
print v(xbgr.mr_n74647184)
print v(xbgr.mr_n74647616)
print v(xbgr.mr_n74647728)
print v(xbgr.mr_n74648048)
print v(xbgr.mr_n74648480)
print v(xbgr.mr_n74648592)
print v(xbgr.mr_n74648912)
print v(xbgr.mr_n74649344)
print v(xbgr.mr_n74649456)
print v(xbgr.mr_n74649776)
print v(xbgr.mr_n74650208)
print v(xbgr.mr_n74650320)
print v(xbgr.mr_n74650640)
print v(xbgr.mr_n74651072)
print v(xbgr.mr_n74651184)
print v(xbgr.mr_n74651504)
print v(xbgr.mr_n74651616)
print v(xbgr.mr_n74651936)
print v(xbgr.mr_n74652048)
print v(xbgr.mr_n74652368)
print v(xbgr.mr_n74652480)
print v(xbgr.mr_n74652800)
print v(xbgr.mr_n74652912)
print v(xbgr.mr_n74653232)
print v(xbgr.mr_n74653344)
print v(xbgr.mr_n74653664)
print v(xbgr.mr_n74653776)
print v(xbgr.mr_n74654096)
print v(xbgr.mr_n74654208)
print v(xbgr.mr_n74654528)
print v(xbgr.mr_n74654640)
print v(xbgr.mr_n74654960)
print v(xbgr.mr_n74655072)
print v(xbgr.mr_n74655392)
print v(xbgr.mr_n74655504)
print v(xbgr.mr_n74655824)
print v(xbgr.mr_n74655936)
print v(xbgr.mr_n74656256)
print v(xbgr.mr_n74656368)
print v(xbgr.mr_n74656688)
print v(xbgr.mr_n74656800)
print v(xbgr.mr_n74657120)
print v(xbgr.mr_n74657232)
print v(xbgr.mr_n74657552)
print v(xbgr.mr_n74657664)
print v(xbgr.mr_n74657984)
print v(xbgr.mr_n74658096)
print v(xbgr.mr_n74658416)
print v(xbgr.mr_n74658528)
print v(xbgr.mr_n74658848)
print v(xbgr.mr_n74658960)
print v(xbgr.mr_n74659280)
print v(xbgr.mr_n74659392)
print v(xbgr.mr_n74659712)
print v(xbgr.mr_n74659824)
print v(xbgr.mr_n74660144)
print v(xbgr.mr_n74660256)
print v(xbgr.mr_n74660576)
print v(xbgr.mr_n74660688)
print v(xbgr.mr_n74661008)
print v(xbgr.mr_n74661120)
print v(xbgr.mr_n74661440)
print v(xbgr.mr_n74661552)
print v(xbgr.mr_n74661872)
print v(xbgr.mr_n74661984)
print v(xbgr.mr_n74662304)
print v(xbgr.mr_n74662416)
print v(xbgr.mr_n74662736)
print v(xbgr.mr_n74662848)
print v(xbgr.mr_n74663168)
print v(xbgr.mr_n74663280)
print v(xbgr.mr_n74663600)
print v(xbgr.mr_n74663712)
print v(xbgr.mr_n74664032)
print v(xbgr.mr_n74664144)
print v(xbgr.mr_n74664464)
print v(xbgr.mr_n74664576)
print v(xbgr.mr_n74664896)
print v(xbgr.mr_n74665008)
print v(xbgr.mr_n74665328)
print v(xbgr.mr_n74665440)
print v(xbgr.mr_n74665760)
print v(xbgr.mr_n74665872)
print v(xbgr.mr_n74666192)
print v(xbgr.mr_n74666304)
print v(xbgr.mr_n74666624)
print v(xbgr.mr_n74666736)
print v(xbgr.mr_n74667056)
print v(xbgr.mr_n74667168)
print v(xbgr.mr_n74667488)
print v(xbgr.mr_n74667600)
print v(xbgr.mr_n74667920)
print v(xbgr.mr_n74668032)
print v(xbgr.mr_n74668352)
print v(xbgr.mr_n74668464)
print v(xbgr.mr_n74668784)
print v(xbgr.mr_n74668896)
print v(xbgr.mr_n74669216)
print v(xbgr.mr_n74669328)
print v(xbgr.mr_n74669648)
print v(xbgr.mr_n74670080)
print v(xbgr.mr_n74670192)
print v(xbgr.mr_n74670512)
print v(xbgr.mr_n74670624)
print v(xbgr.mr_n74670944)
print v(xbgr.mr_n74671056)
print v(xbgr.mr_n74671376)
print v(xbgr.mr_n74671808)
print v(xbgr.mr_n74671920)
print v(xbgr.mr_n74672240)
print v(xbgr.mr_n74672672)
print v(xbgr.mr_n74672784)
print v(xbgr.mr_n74673104)
print v(xbgr.mr_n74673216)
print v(xbgr.mr_n74673536)
print v(xbgr.mr_n74673648)
print v(xbgr.mr_n74673968)
print v(xbgr.mr_n74674080)
print v(xbgr.mr_n74674400)
print v(xbgr.mr_n74674512)
print v(xbgr.mr_n74674832)
print v(xbgr.mr_n74674944)
print v(xbgr.mr_n74675264)
print v(xbgr.mr_n74675376)
print v(xbgr.mr_n74675696)
print v(xbgr.mr_n74675808)
print v(xbgr.mr_n74676128)
print v(xbgr.mr_n74676240)
print v(xbgr.mr_n74676560)
print v(xbgr.mr_n74676672)
print v(xbgr.mr_n74676992)
print v(xbgr.mr_n74677104)
print v(xbgr.mr_n74677424)
print v(xbgr.mr_n74677536)
print v(xbgr.mr_n74677856)
print v(xbgr.mr_n74677968)
print v(xbgr.mr_n74678288)
print v(xbgr.mr_n74678720)
print v(xbgr.mr_n74678832)
print v(xbgr.mr_n74679152)
print v(xbgr.mr_n74679264)
print v(xbgr.mr_n74679584)
print v(xbgr.mr_n74679696)
print v(xbgr.mr_n74680016)
print v(xbgr.mr_n74680128)
print v(xbgr.mr_n74680448)
print v(xbgr.mr_n74680560)
print v(xbgr.mr_n74680880)
print v(xbgr.mr_n74680992)
print v(xbgr.mr_n74681312)
print v(xbgr.mr_n74681424)
print v(xbgr.mr_n74681744)
print v(xbgr.mr_n74681856)
print v(xbgr.mr_n74682176)
print v(xbgr.mr_n74682288)
print v(xbgr.mr_n74682608)
print v(xbgr.mr_n74682720)
print v(xbgr.mr_n74683040)
print v(xbgr.mr_n74683152)
print v(xbgr.mr_n74683472)
print v(xbgr.mr_n74683584)
print v(xbgr.mr_n74683904)
print v(xbgr.mr_n74684016)
print v(xbgr.mr_n74684336)
print v(xbgr.mr_n74684448)
print v(xbgr.mr_n74684768)
print v(xbgr.mr_n74684880)
print v(xbgr.mr_n74685200)
print v(xbgr.mr_n74685312)
print v(xbgr.mr_n74685632)
print v(xbgr.mr_n74685744)
print v(xbgr.mr_n74686064)
print v(xbgr.mr_n74686176)
print v(xbgr.mr_n74686496)
print v(xbgr.mr_n74686608)
print v(xbgr.mr_n74686928)
print v(xbgr.mr_n74687040)
print v(xbgr.mr_n74687360)
print v(xbgr.mr_n74687472)
print v(xbgr.mr_n74687792)
print v(xbgr.mr_n74687904)
print v(xbgr.mr_n74688224)
print v(xbgr.mr_n74688336)
print v(xbgr.mr_n74688656)
print v(xbgr.mr_n74688768)
print v(xbgr.mr_n74689088)
print v(xbgr.mr_n74689200)
print v(xbgr.mr_n74689520)
print v(xbgr.mr_n74689632)
print v(xbgr.mr_n74689952)
print v(xbgr.mr_n74690064)
print v(xbgr.mr_n74690384)
print v(xbgr.mr_n74690496)
print v(xbgr.mr_n74690816)
print v(xbgr.mr_n74690928)
print v(xbgr.mr_n74691248)
print v(xbgr.mr_n74691360)
print v(xbgr.mr_n74691680)
print v(xbgr.mr_n74691792)
print v(xbgr.mr_n74692112)
print v(xbgr.mr_n74692224)
print v(xbgr.mr_n74692544)
print v(xbgr.mr_n74692656)
print v(xbgr.mr_n74692976)
print v(xbgr.mr_n74693088)
print v(xbgr.mr_n74693408)
print v(xbgr.mr_n74693520)
print v(xbgr.mr_n74693840)
print v(xbgr.mr_n74693952)
print v(xbgr.mr_n74694272)
print v(xbgr.mr_n74694384)
print v(xbgr.mr_n74694704)
print v(xbgr.mr_n74694816)
print v(xbgr.mr_n74695136)
print v(xbgr.mr_n74695248)
print v(xbgr.mr_n74695568)
print v(xbgr.mr_n74695680)
print v(xbgr.mr_n74696000)
print v(xbgr.mr_n74696112)
print v(xbgr.mr_n74696432)
print v(xbgr.mr_n74696544)
print v(xbgr.mr_n74696864)
print v(xbgr.mr_n74696976)
print v(xbgr.mr_n74697296)
print v(xbgr.mr_n74697408)
print v(xbgr.mr_n74697728)
print v(xbgr.mr_n74697840)
print v(xbgr.mr_n74698160)
print v(xbgr.mr_n74698272)
print v(xbgr.mr_n74698592)
print v(xbgr.mr_n74698704)
print v(xbgr.mr_n74699024)
print v(xbgr.mr_n74699136)
print v(xbgr.mr_n74699456)
print v(xbgr.mr_n74699568)
print v(xbgr.mr_n74699888)
print v(xbgr.mr_n74700000)
print v(xbgr.mr_n74700432)
print v(xbgr.mr_n74700864)
print v(xbgr.mr_n74701296)
print v(xbgr.mr_n74701728)
print v(xbgr.mr_n74702160)
print v(xbgr.mr_n74702592)
print v(xbgr.mr_n74703024)
print v(xbgr.mr_n74703456)
print v(xbgr.mr_n74703776)
print v(xbgr.mr_n74703888)
print v(xbgr.mr_n74704208)
print v(xbgr.mr_n74704320)
print v(xbgr.mr_n74704640)
print v(xbgr.mr_n74704752)
print v(xbgr.mr_n74705072)
print v(xbgr.mr_n74705184)
print v(xbgr.mr_n74705504)
print v(xbgr.mr_n74705616)
print v(xbgr.mr_n74705936)
print v(xbgr.mr_n74706048)
print v(xbgr.mr_n74706368)
print v(xbgr.mr_n74706480)
print v(xbgr.mr_n74706800)
print v(xbgr.mr_n74706912)
print v(xbgr.mr_n74707344)
print v(xbgr.mr_n74707776)
print v(xbgr.mr_n74708208)
print v(xbgr.mr_n74708640)
print v(xbgr.mr_n74709072)
print v(xbgr.mr_n74709504)
print v(xbgr.mr_n74709824)
print v(xbgr.mr_n74709936)
print v(xbgr.mr_n74710368)
print v(xbgr.mr_n74710800)
print v(xbgr.mr_n74711232)
print v(xbgr.mr_n74711664)
print v(xbgr.mr_n74712096)
print v(xbgr.mr_n74712528)
print v(xbgr.mr_n74712960)
print v(xbgr.mr_n74713392)
print v(xbgr.mr_n74713824)
print v(xbgr.mr_n74714256)
print v(xbgr.mr_n74714688)
print v(xbgr.mr_n74715120)
print v(xbgr.mr_n74715440)
print v(xbgr.mr_n74715552)
print v(xbgr.mr_n74715872)
print v(xbgr.mr_n74715984)
print v(xbgr.mr_n74716304)
print v(xbgr.mr_n74716416)
print v(xbgr.mr_n74716736)
print v(xbgr.mr_n74716848)
print v(xbgr.mr_n74717168)
print v(xbgr.mr_n74717280)
print v(xbgr.mr_n74717600)
print v(xbgr.mr_n74717712)
print v(xbgr.mr_n74718032)
print v(xbgr.mr_n74718144)
print v(xbgr.mr_n74718464)
print v(xbgr.mr_n74718576)
print v(xbgr.mr_n74718896)
print v(xbgr.mr_n74719008)
print v(xbgr.mr_n74719328)
print v(xbgr.mr_n74719440)
print v(xbgr.mr_n74719760)
print v(xbgr.mr_n74719872)
print v(xbgr.mr_n74720192)
print v(xbgr.mr_n74720304)
print v(xbgr.mr_n74720624)
print v(xbgr.mr_n74720736)
print v(xbgr.mr_n74721056)
print v(xbgr.mr_n74721168)
print v(xbgr.mr_n74721488)
print v(xbgr.mr_n74721600)
print v(xbgr.mr_n74721920)
print v(xbgr.mr_n74722032)
print v(xbgr.mr_n74722352)
print v(xbgr.mr_n74722464)
print v(xbgr.mr_n74722784)
print v(xbgr.mr_n74722896)
print v(xbgr.mr_n74723216)
print v(xbgr.mr_n74723328)
print v(xbgr.mr_n74723648)
print v(xbgr.mr_n74723760)
print v(xbgr.mr_n74724080)
print v(xbgr.mr_n74724192)
print v(xbgr.mr_n74724624)
print v(xbgr.mr_n74725056)
print v(xbgr.mr_n74725488)
print v(xbgr.mr_n74725920)
print v(xbgr.mr_n74726352)
print v(xbgr.mr_n74726784)
print v(xbgr.mr_n74727216)
print v(xbgr.mr_n74727648)
print v(xbgr.mr_n74728080)
print v(xbgr.mr_n74728512)
print v(xbgr.mr_n74728944)
print v(xbgr.mr_n74729376)
print v(xbgr.mr_n74729808)
print v(xbgr.mr_n74730240)
print v(xbgr.mr_n74730672)
print v(xbgr.mr_n74731104)
print v(xbgr.mr_n74731536)
print v(xbgr.mr_n74731968)
print v(xbgr.mr_n74732400)
print v(xbgr.mr_n74732720)
print v(xbgr.mr_n74732832)
print v(xbgr.mr_n74733152)
print v(xbgr.mr_n74733264)
print v(xbgr.mr_n74733584)
print v(xbgr.mr_n74733696)
print v(xbgr.mr_n74734016)
print v(xbgr.mr_n74734128)
print v(xbgr.mr_n74734448)
print v(xbgr.mr_n74734560)
print v(xbgr.mr_n74734992)
print v(xbgr.mr_n74735424)
print v(xbgr.mr_n74735856)
print v(xbgr.mr_n74736288)
print v(xbgr.mr_n74736720)
print v(xbgr.mr_n74737152)
print v(xbgr.mr_n74737584)
print v(xbgr.mr_n74737904)
print v(xbgr.mr_n74738016)
print v(xbgr.mr_n74738336)
print v(xbgr.mr_n74738448)
print v(xbgr.mr_n74738768)
print v(xbgr.mr_n74738880)
print v(xbgr.mr_n74739200)
print v(xbgr.mr_n74739312)
print v(xbgr.mr_n74739632)
print v(xbgr.mr_n74739744)
print v(xbgr.mr_n74740064)
print v(xbgr.mr_n74740176)
print v(xbgr.mr_n74740496)
print v(xbgr.mr_n74740608)
print v(xbgr.mr_n74740928)
print v(xbgr.mr_n74741040)
print v(xbgr.mr_n74741360)
print v(xbgr.mr_n74741472)
print v(xbgr.mr_n74741792)
print v(xbgr.mr_n74741904)
print v(xbgr.mr_n74742224)
print v(xbgr.mr_n74742336)
print v(xbgr.mr_n74742656)
print v(xbgr.mr_n74742768)
print v(xbgr.mr_n74743088)
print v(xbgr.mr_n74743200)
print v(xbgr.mr_n74743632)
print v(xbgr.mr_n74744064)
print v(xbgr.mr_n74744496)
print v(xbgr.mr_n74744928)
print v(xbgr.mr_n74745360)
print v(xbgr.mr_n74745792)
print v(xbgr.mr_n74746224)
print v(xbgr.mr_n74746656)
print v(xbgr.mr_n74747088)
print v(xbgr.mr_n74747520)
print v(xbgr.mr_n74747952)
print v(xbgr.mr_n74748384)
print v(xbgr.mr_n74748816)
print v(xbgr.mr_n74749136)
print v(xbgr.mr_n74749248)
print v(xbgr.mr_n74749568)
print v(xbgr.mr_n74749680)
print v(xbgr.mr_n74750000)
print v(xbgr.mr_n74750112)
print v(xbgr.mr_n74750432)
print v(xbgr.mr_n74750544)
print v(xbgr.mr_n74750864)
print v(xbgr.mr_n74750976)
print v(xbgr.mr_n74751296)
print v(xbgr.mr_n74751408)
print v(xbgr.mr_n74751728)
print v(xbgr.mr_n74751840)
print v(xbgr.mr_n74752160)
print v(xbgr.mr_n74752272)
print v(xbgr.mr_n74752592)
print v(xbgr.mr_n74752704)
print v(xbgr.mr_n74753024)
print v(xbgr.mr_n74753136)
print v(xbgr.mr_n74753456)
print v(xbgr.mr_n74753568)
print v(xbgr.mr_n74753888)
print v(xbgr.mr_n74754000)
print v(xbgr.mr_n74754432)
print v(xbgr.mr_n74754864)
print v(xbgr.mr_n74755296)
print v(xbgr.mr_n74755728)
print v(xbgr.mr_n74756160)
print v(xbgr.mr_n74756592)
print v(xbgr.mr_n74757024)
print v(xbgr.mr_n74757456)
print v(xbgr.mr_n74757888)
print v(xbgr.mr_n74758320)
print v(xbgr.mr_n74758752)
print v(xbgr.mr_n74759184)
print v(xbgr.mr_n74759504)
print v(xbgr.mr_n74759616)
print v(xbgr.mr_n74760048)
print v(xbgr.mr_n74760368)
print v(xbgr.mr_n74760480)
print v(xbgr.mr_n74760800)
print v(xbgr.mr_n74760912)
print v(xbgr.mr_n74761232)
print v(xbgr.mr_n74761344)
print v(xbgr.mr_n74761664)
print v(xbgr.mr_n74761776)
print v(xbgr.mr_n74762096)
print v(xbgr.mr_n74762208)
print v(xbgr.mr_n74762640)
print v(xbgr.mr_n74763072)
print v(xbgr.mr_n74763392)
print v(xbgr.mr_n74763504)
print v(xbgr.mr_n74763824)
print v(xbgr.mr_n74763936)
print v(xbgr.mr_n74764256)
print v(xbgr.mr_n74764368)
print v(xbgr.mr_n74764688)
print v(xbgr.mr_n74764800)
print v(xbgr.mr_n74765120)
print v(xbgr.mr_n74765232)
print v(xbgr.mr_n74765552)
print v(xbgr.mr_n74765664)
print v(xbgr.mr_n74765984)
print v(xbgr.mr_n74766096)
print v(xbgr.mr_n74766416)
print v(xbgr.mr_n74766528)
print v(xbgr.mr_n74766960)
print v(xbgr.mr_n74767392)
print v(xbgr.mr_n74767824)
print v(xbgr.mr_n74768256)
print v(xbgr.mr_n74768688)
print v(xbgr.mr_n74769120)
print v(xbgr.mr_n74769552)
print v(xbgr.mr_n74769984)
print v(xbgr.mr_n74770416)
print v(xbgr.mr_n74770848)
print v(xbgr.mr_n74771280)
print v(xbgr.mr_n74771600)
print v(xbgr.mr_n74771712)
print v(xbgr.mr_n74772032)
print v(xbgr.mr_n74772144)
print v(xbgr.mr_n74772464)
print v(xbgr.mr_n74772576)
print v(xbgr.mr_n74773008)
print v(xbgr.mr_n74773440)
print v(xbgr.mr_n74773760)
print v(xbgr.mr_n74773872)
print v(xbgr.mr_n74774192)
print v(xbgr.mr_n74774304)
print v(xbgr.mr_n74774624)
print v(xbgr.mr_n74774736)
print v(xbgr.mr_n74775056)
print v(xbgr.mr_n74775168)
print v(xbgr.mr_n74775600)
print v(xbgr.mr_n74775920)
print v(xbgr.mr_n74776032)
print v(xbgr.mr_n74776352)
print v(xbgr.mr_n74776464)
print v(xbgr.mr_n74776784)
print v(xbgr.mr_n74776896)
print v(xbgr.mr_n74777216)
print v(xbgr.mr_n74777328)
print v(xbgr.mr_n74777648)
print v(xbgr.mr_n74777760)
print v(xbgr.mr_n74778080)
print v(xbgr.mr_n74778192)
print v(xbgr.mr_n74778624)
print v(xbgr.mr_n74779056)
print v(xbgr.mr_n74779488)
print v(xbgr.mr_n74779920)
print v(xbgr.mr_n74780352)
print v(xbgr.mr_n74780784)
print v(xbgr.mr_n74781216)
print v(xbgr.mr_n74781648)
print v(xbgr.mr_n74782080)
print v(xbgr.mr_n74782512)
print v(xbgr.mr_n74782832)
print v(xbgr.mr_n74782944)
print v(xbgr.mr_n74783264)
print v(xbgr.mr_n74783376)
print v(xbgr.mr_n74783696)
print v(xbgr.mr_n74783808)
print v(xbgr.mr_n74784128)
print v(xbgr.mr_n74784240)
print v(xbgr.mr_n74784560)
print v(xbgr.mr_n74784672)
print v(xbgr.mr_n74784992)
print v(xbgr.mr_n74785104)
print v(xbgr.mr_n74785424)
print v(xbgr.mr_n74785536)
print v(xbgr.mr_n74785856)
print v(xbgr.mr_n74785968)
print v(xbgr.mr_n74786288)
print v(xbgr.mr_n74786400)
print v(xbgr.mr_n74786720)
print v(xbgr.mr_n74786832)
print v(xbgr.mr_n74787152)
print v(xbgr.mr_n74787264)
print v(xbgr.mr_n74787584)
print v(xbgr.mr_n74787696)
print v(xbgr.mr_n74788016)
print v(xbgr.mr_n74788128)
print v(xbgr.mr_n74788560)
print v(xbgr.mr_n74788992)
print v(xbgr.mr_n74789424)
print v(xbgr.mr_n74789856)
print v(xbgr.mr_n74790288)
print v(xbgr.mr_n74790720)
print v(xbgr.mr_n74791152)
print v(xbgr.mr_n74791584)
print v(xbgr.mr_n74792016)
print v(xbgr.mr_n74792448)
print v(xbgr.mr_n74792880)
print v(xbgr.mr_n74793312)
print v(xbgr.mr_n74793744)
print v(xbgr.mr_n74794064)
print v(xbgr.mr_n74794176)
print v(xbgr.mr_n74794496)
print v(xbgr.mr_n74794608)
print v(xbgr.mr_n74794928)
print v(xbgr.mr_n74795040)
print v(xbgr.mr_n74795360)
print v(xbgr.mr_n74795472)
print v(xbgr.mr_n74795792)
print v(xbgr.mr_n74795904)
print v(xbgr.mr_n74796224)
print v(xbgr.mr_n74796336)
print v(xbgr.mr_n74796656)
print v(xbgr.mr_n74796768)
print v(xbgr.mr_n74797088)
print v(xbgr.mr_n74797200)
print v(xbgr.mr_n74797520)
print v(xbgr.mr_n74797632)
print v(xbgr.mr_n74797952)
print v(xbgr.mr_n74798064)
print v(xbgr.mr_n74798384)
print v(xbgr.mr_n74798496)
print v(xbgr.mr_n74798816)
print v(xbgr.mr_n74798928)
print v(xbgr.mr_n74799248)
print v(xbgr.mr_n74799360)
print v(xbgr.mr_n74799792)
print v(xbgr.mr_n74800224)
print v(xbgr.mr_n74800656)
print v(xbgr.mr_n74801088)
print v(xbgr.mr_n74801520)
print v(xbgr.mr_n74801952)
print v(xbgr.mr_n74802384)
print v(xbgr.mr_n74802816)
print v(xbgr.mr_n74803248)
print v(xbgr.mr_n74803680)
print v(xbgr.mr_n74804112)
print v(xbgr.mr_n74804544)
print v(xbgr.mr_n74804976)
print v(xbgr.mr_n74805296)
print v(xbgr.mr_n74805408)
print v(xbgr.mr_n74805728)
print v(xbgr.mr_n74805840)
print v(xbgr.mr_n74806160)
print v(xbgr.mr_n74806272)
print v(xbgr.mr_n74806592)
print v(xbgr.mr_n74806704)
print v(xbgr.mr_n74807024)
print v(xbgr.mr_n74807136)
print v(xbgr.mr_n74807456)
print v(xbgr.mr_n74807568)
print v(xbgr.mr_n74807888)
print v(xbgr.mr_n74808000)
print v(xbgr.mr_n74808320)
print v(xbgr.mr_n74808432)
print v(xbgr.mr_n74808752)
print v(xbgr.mr_n74808864)
print v(xbgr.mr_n74809184)
print v(xbgr.mr_n74809296)
print v(xbgr.mr_n74809616)
print v(xbgr.mr_n74809728)
print v(xbgr.mr_n74810048)
print v(xbgr.mr_n74810160)
print v(xbgr.mr_n74810480)
print v(xbgr.mr_n74810592)
print v(xbgr.mr_n74811024)
print v(xbgr.mr_n74811456)
print v(xbgr.mr_n74811888)
print v(xbgr.mr_n74812320)
print v(xbgr.mr_n74812752)
print v(xbgr.mr_n74813184)
print v(xbgr.mr_n74813616)
print v(xbgr.mr_n74814048)
print v(xbgr.mr_n74814480)
print v(xbgr.mr_n74814912)
print v(xbgr.mr_n74815344)
print v(xbgr.mr_n74815776)
print v(xbgr.mr_n74816208)
print v(xbgr.mr_n74816528)
print v(xbgr.mr_n74816640)
print v(xbgr.mr_n74816960)
print v(xbgr.mr_n74817072)
print v(xbgr.mr_n74817504)
print v(xbgr.mr_n74817824)
print v(xbgr.mr_n74817936)
print v(xbgr.mr_n74818256)
print v(xbgr.mr_n74818368)
print v(xbgr.mr_n74818688)
print v(xbgr.mr_n74818800)
print v(xbgr.mr_n74819120)
print v(xbgr.mr_n74819232)
print v(xbgr.mr_n74819664)
print v(xbgr.mr_n74820096)
print v(xbgr.mr_n74820528)
print v(xbgr.mr_n74820960)
print v(xbgr.mr_n74821280)
print v(xbgr.mr_n74821392)
print v(xbgr.mr_n74821712)
print v(xbgr.mr_n74821824)
print v(xbgr.mr_n74822256)
print v(xbgr.mr_n74822688)
print v(xbgr.mr_n74823008)
print v(xbgr.mr_n74823120)
print v(xbgr.mr_n74823440)
print v(xbgr.mr_n74823552)
print v(xbgr.mr_n74823872)
print v(xbgr.mr_n74823984)
print v(xbgr.mr_n74824304)
print v(xbgr.mr_n74824416)
print v(xbgr.mr_n74824736)
print v(xbgr.mr_n74824848)
print v(xbgr.mr_n74825280)
print v(xbgr.mr_n74825712)
print v(xbgr.mr_n74826144)
print v(xbgr.mr_n74826576)
print v(xbgr.mr_n74827008)
print v(xbgr.mr_n74827440)
print v(xbgr.mr_n74827760)
print v(xbgr.mr_n74827872)
print v(xbgr.mr_n74828192)
print v(xbgr.mr_n74828304)
print v(xbgr.mr_n74828624)
print v(xbgr.mr_n74828736)
print v(xbgr.mr_n74829056)
print v(xbgr.mr_n74829168)
print v(xbgr.mr_n74829488)
print v(xbgr.mr_n74829600)
print v(xbgr.mr_n74829920)
print v(xbgr.mr_n74830032)
print v(xbgr.mr_n74830352)
print v(xbgr.mr_n74830464)
print v(xbgr.mr_n74830784)
print v(xbgr.mr_n74830896)
print v(xbgr.mr_n74831216)
print v(xbgr.mr_n74831328)
print v(xbgr.mr_n74831648)
print v(xbgr.mr_n74831760)
print v(xbgr.mr_n74832080)
print v(xbgr.mr_n74832192)
print v(xbgr.mr_n74832512)
print v(xbgr.mr_n74832624)
print v(xbgr.mr_n74833056)
print v(xbgr.mr_n74833488)
print v(xbgr.mr_n74833920)
print v(xbgr.mr_n74834352)
print v(xbgr.mr_n74834784)
print v(xbgr.mr_n74835216)
print v(xbgr.mr_n74835648)
print v(xbgr.mr_n74836080)
print v(xbgr.mr_n74836400)
print v(xbgr.mr_n74836512)
print v(xbgr.mr_n74836832)
print v(xbgr.mr_n74836944)
print v(xbgr.mr_n74837264)
print v(xbgr.mr_n74837376)
print v(xbgr.mr_n74837696)
print v(xbgr.mr_n74837808)
print v(xbgr.mr_n74838128)
print v(xbgr.mr_n74838240)
print v(xbgr.mr_n74838560)
print v(xbgr.mr_n74838672)
print v(xbgr.mr_n74838992)
print v(xbgr.mr_n74839104)
print v(xbgr.mr_n74839424)
print v(xbgr.mr_n74839536)
print v(xbgr.mr_n74839968)
print v(xbgr.mr_n74840400)
print v(xbgr.mr_n74840720)
print v(xbgr.mr_n74840832)
print v(xbgr.mr_n74841152)
print v(xbgr.mr_n74841264)
print v(xbgr.mr_n74841584)
print v(xbgr.mr_n74841696)
print v(xbgr.mr_n74842016)
print v(xbgr.mr_n74842128)
print v(xbgr.mr_n74842448)
print v(xbgr.mr_n74842560)
print v(xbgr.mr_n74842880)
print v(xbgr.mr_n74842992)
print v(xbgr.mr_n74843424)
print v(xbgr.mr_n74843856)
print v(xbgr.mr_n74844288)
print v(xbgr.mr_n74844720)
print v(xbgr.mr_n74845152)
print v(xbgr.mr_n74845584)
print v(xbgr.mr_n74846016)
print v(xbgr.mr_n74846448)
print v(xbgr.mr_n74846880)
print v(xbgr.mr_n74847312)
print v(xbgr.mr_n74847744)
print v(xbgr.mr_n74848176)
print v(xbgr.mr_n74848608)
print v(xbgr.mr_n74849040)
print v(xbgr.mr_n74849472)
print v(xbgr.mr_n74849904)
print v(xbgr.mr_n74850224)
print v(xbgr.mr_n74850336)
print v(xbgr.mr_n74850656)
print v(xbgr.mr_n74850768)
print v(xbgr.mr_n74851088)
print v(xbgr.mr_n74851200)
print v(xbgr.mr_n74851520)
print v(xbgr.mr_n74851632)
print v(xbgr.mr_n74851952)
print v(xbgr.mr_n74852064)
print v(xbgr.mr_n74852384)
print v(xbgr.mr_n74852496)
print v(xbgr.mr_n74852816)
print v(xbgr.mr_n74852928)
print v(xbgr.mr_n74853248)
print v(xbgr.mr_n74853360)
print v(xbgr.mr_n74853680)
print v(xbgr.mr_n74853792)
print v(xbgr.mr_n74854112)
print v(xbgr.mr_n74854224)
print v(xbgr.mr_n74854544)
print v(xbgr.mr_n74854656)
print v(xbgr.mr_n74854976)
print v(xbgr.mr_n74855088)
print v(xbgr.mr_n74855408)
print v(xbgr.mr_n74855520)
print v(xbgr.mr_n74855840)
print v(xbgr.mr_n74855952)
print v(xbgr.mr_n74856272)
print v(xbgr.mr_n74856384)
print v(xbgr.mr_n74856704)
print v(xbgr.mr_n74856816)
print v(xbgr.mr_n74857136)
print v(xbgr.mr_n74857248)
print v(xbgr.mr_n74857568)
print v(xbgr.mr_n74857680)
print v(xbgr.mr_n74858000)
print v(xbgr.mr_n74858112)
print v(xbgr.mr_n74858432)
print v(xbgr.mr_n74858544)
print v(xbgr.mr_n74858976)
print v(xbgr.mr_n74859408)
print v(xbgr.mr_n74859840)
print v(xbgr.mr_n74860272)
print v(xbgr.mr_n74860704)
print v(xbgr.mr_n74861136)
print v(xbgr.mr_n74861456)
print v(xbgr.mr_n74861568)
print v(xbgr.mr_n74861888)
print v(xbgr.mr_n74862000)
print v(xbgr.mr_n74862320)
print v(xbgr.mr_n74862432)
print v(xbgr.mr_n74862752)
print v(xbgr.mr_n74862864)
print v(xbgr.mr_n74863184)
print v(xbgr.mr_n74863296)
print v(xbgr.mr_n74863616)
print v(xbgr.mr_n74863728)
print v(xbgr.mr_n74864160)
print v(xbgr.mr_n74864592)
print v(xbgr.mr_n74865024)
print v(xbgr.mr_n74865456)
print v(xbgr.mr_n74865888)
print v(xbgr.mr_n74866320)
print v(xbgr.mr_n74866752)
print v(xbgr.mr_n74867184)
print v(xbgr.mr_n74867616)
print v(xbgr.mr_n74868048)
print v(xbgr.mr_n74868480)
print v(xbgr.mr_n74868912)
print v(xbgr.mr_n74869344)
print v(xbgr.mr_n74869776)
print v(xbgr.mr_n74870208)
print v(xbgr.mr_n74870640)
print v(xbgr.mr_n74871072)
print v(xbgr.mr_n74871504)
print v(xbgr.mr_n74871936)
print v(xbgr.mr_n74872368)
print v(xbgr.mr_n74872688)
print v(xbgr.mr_n74872800)
print v(xbgr.mr_n74873120)
print v(xbgr.mr_n74873232)
print v(xbgr.mr_n74873552)
print v(xbgr.mr_n74873664)
print v(xbgr.mr_n74873984)
print v(xbgr.mr_n74874096)
print v(xbgr.mr_n74874416)
print v(xbgr.mr_n74874528)
print v(xbgr.mr_n74874848)
print v(xbgr.mr_n74874960)
print v(xbgr.mr_n74875280)
print v(xbgr.mr_n74875392)
print v(xbgr.mr_n74875712)
print v(xbgr.mr_n74875824)
print v(xbgr.mr_n74876144)
print v(xbgr.mr_n74876256)
print v(xbgr.mr_n74876576)
print v(xbgr.mr_n74876688)
print v(xbgr.mr_n74877008)
print v(xbgr.mr_n74877120)
print v(xbgr.mr_n74877440)
print v(xbgr.mr_n74877552)
print v(xbgr.mr_n74877872)
print v(xbgr.mr_n74877984)
print v(xbgr.mr_n74878304)
print v(xbgr.mr_n74878416)
print v(xbgr.mr_n74878736)
print v(xbgr.mr_n74878848)
print v(xbgr.mr_n74879168)
print v(xbgr.mr_n74879280)
print v(xbgr.mr_n74879600)
print v(xbgr.mr_n74879712)
print v(xbgr.mr_n74880032)
print v(xbgr.mr_n74880144)
print v(xbgr.mr_n74880464)
print v(xbgr.mr_n74880576)
print v(xbgr.mr_n74880896)
print v(xbgr.mr_n74881008)
print v(xbgr.mr_n74881328)
print v(xbgr.mr_n74881440)
print v(xbgr.mr_n74881760)
print v(xbgr.mr_n74881872)
print v(xbgr.mr_n74882192)
print v(xbgr.mr_n74882304)
print v(xbgr.mr_n74882624)
print v(xbgr.mr_n74882736)
print v(xbgr.mr_n74883056)
print v(xbgr.mr_n74883168)
print v(xbgr.mr_n74883488)
print v(xbgr.mr_n74883600)
print v(xbgr.mr_n74883920)
print v(xbgr.mr_n74884032)
print v(xbgr.mr_n74884352)
print v(xbgr.mr_n74884464)
print v(xbgr.mr_n74884784)
print v(xbgr.mr_n74884896)
print v(xbgr.mr_n74885216)
print v(xbgr.mr_n74885328)
print v(xbgr.mr_n74885648)
print v(xbgr.mr_n74885760)
print v(xbgr.mr_n74886080)
print v(xbgr.mr_n74886192)
print v(xbgr.mr_n74886624)
print v(xbgr.mr_n74887056)
print v(xbgr.mr_n74887376)
print v(xbgr.mr_n74887488)
print v(xbgr.mr_n74887808)
print v(xbgr.mr_n74887920)
print v(xbgr.mr_n74888240)
print v(xbgr.mr_n74888352)
print v(xbgr.mr_n74888672)
print v(xbgr.mr_n74888784)
print v(xbgr.mr_n74889104)
print v(xbgr.mr_n74889216)
print v(xbgr.mr_n74889536)
print v(xbgr.mr_n74889648)
print v(xbgr.mr_n74889968)
print v(xbgr.mr_n74890080)
print v(xbgr.mr_n74890400)
print v(xbgr.mr_n74890512)
print v(xbgr.mr_n74890832)
print v(xbgr.mr_n74890944)
print v(xbgr.mr_n74891264)
print v(xbgr.mr_n74891376)
print v(xbgr.mr_n74891808)
print v(xbgr.mr_n74892240)
print v(xbgr.mr_n74892672)
print v(xbgr.mr_n74892992)
print v(xbgr.mr_n74893104)
print v(xbgr.mr_n74893424)
print v(xbgr.mr_n74893536)
print v(xbgr.mr_n74893968)
print v(xbgr.mr_n74894400)
print v(xbgr.mr_n74894832)
print v(xbgr.mr_n74895264)
print v(xbgr.mr_n74895696)
print v(xbgr.mr_n74896128)
print v(xbgr.mr_n74896560)
print v(xbgr.mr_n74896992)
print v(xbgr.mr_n74897424)
print v(xbgr.mr_n74897856)
print v(xbgr.mr_n74898288)
print v(xbgr.mr_n74898608)
print v(xbgr.mr_n74898720)
print v(xbgr.mr_n74899040)
print v(xbgr.mr_n74899152)
print v(xbgr.mr_n74899472)
print v(xbgr.mr_n74899584)
print v(xbgr.mr_n74899904)
print v(xbgr.mr_n74900016)
print v(xbgr.mr_n74900336)
print v(xbgr.mr_n74900448)
print v(xbgr.mr_n74900768)
print v(xbgr.mr_n74900880)
print v(xbgr.mr_n74901200)
print v(xbgr.mr_n74901312)
print v(xbgr.mr_n74901632)
print v(xbgr.mr_n74901744)
print v(xbgr.mr_n74902176)
print v(xbgr.mr_n74902608)
print v(xbgr.mr_n74903040)
print v(xbgr.mr_n74903472)
print v(xbgr.mr_n74903904)
print v(xbgr.mr_n74904336)
print v(xbgr.mr_n74904768)
print v(xbgr.mr_n74905200)
print v(xbgr.mr_n74905632)
print v(xbgr.mr_n74906064)
print v(xbgr.mr_n74906496)
print v(xbgr.mr_n74906928)
print v(xbgr.mr_n74907360)
print v(xbgr.mr_n74907792)
print v(xbgr.mr_n74908224)
print v(xbgr.mr_n74908656)
print v(xbgr.mr_n74909088)
print v(xbgr.mr_n74909520)
print v(xbgr.mr_n74909952)
print v(xbgr.mr_n74910384)
print v(xbgr.mr_n74910704)
print v(xbgr.mr_n74910816)
print v(xbgr.mr_n74911136)
print v(xbgr.mr_n74911248)
print v(xbgr.mr_n74911568)
print v(xbgr.mr_n74911680)
print v(xbgr.mr_n74912000)
print v(xbgr.mr_n74912112)
print v(xbgr.mr_n74912432)
print v(xbgr.mr_n74912544)
print v(xbgr.mr_n74912864)
print v(xbgr.mr_n74912976)
print v(xbgr.mr_n74913296)
print v(xbgr.mr_n74913408)
print v(xbgr.mr_n74913728)
print v(xbgr.mr_n74913840)
print v(xbgr.mr_n74914160)
print v(xbgr.mr_n74914272)
print v(xbgr.mr_n74914592)
print v(xbgr.mr_n74914704)
print v(xbgr.mr_n74915024)
print v(xbgr.mr_n74915136)
print v(xbgr.mr_n74915456)
print v(xbgr.mr_n74915568)
print v(xbgr.mr_n74915888)
print v(xbgr.mr_n74916000)
print v(xbgr.mr_n74916432)
print v(xbgr.mr_n74916864)
print v(xbgr.mr_n74917296)
print v(xbgr.mr_n74917728)
print v(xbgr.mr_n74918160)
print v(xbgr.mr_n74918592)
print v(xbgr.mr_n74919024)
print v(xbgr.mr_n74919456)
print v(xbgr.mr_n74919888)
print v(xbgr.mr_n74920320)
print v(xbgr.mr_n74920752)
print v(xbgr.mr_n74921184)
print v(xbgr.mr_n74921616)
print v(xbgr.mr_n74921936)
print v(xbgr.mr_n74922048)
print v(xbgr.mr_n74922368)
print v(xbgr.mr_n74922480)
print v(xbgr.mr_n74922800)
print v(xbgr.mr_n74922912)
print v(xbgr.mr_n74923232)
print v(xbgr.mr_n74923344)
print v(xbgr.mr_n74923664)
print v(xbgr.mr_n74923776)
print v(xbgr.mr_n74924096)
print v(xbgr.mr_n74924208)
print v(xbgr.mr_n74924528)
print v(xbgr.mr_n74924640)
print v(xbgr.mr_n74924960)
print v(xbgr.mr_n74925072)
print v(xbgr.mr_n74925392)
print v(xbgr.mr_n74925504)
print v(xbgr.mr_n74925824)
print v(xbgr.mr_n74925936)
print v(xbgr.mr_n74926256)
print v(xbgr.mr_n74926368)
print v(xbgr.mr_n74926688)
print v(xbgr.mr_n74926800)
print v(xbgr.mr_n74927232)
print v(xbgr.mr_n74927552)
print v(xbgr.mr_n74927664)
print v(xbgr.mr_n74928096)
print v(xbgr.mr_n74928528)
print v(xbgr.mr_n74928960)
print v(xbgr.mr_n74929392)
print v(xbgr.mr_n74929824)
print v(xbgr.mr_n74930256)
print v(xbgr.mr_n74930688)
print v(xbgr.mr_n74931120)
print v(xbgr.mr_n74931552)
print v(xbgr.mr_n74931984)
print v(xbgr.mr_n74932416)
print v(xbgr.mr_n74932848)
print v(xbgr.mr_n74933168)
print v(xbgr.mr_n74933280)
print v(xbgr.mr_n74933600)
print v(xbgr.mr_n74933712)
print v(xbgr.mr_n74934032)
print v(xbgr.mr_n74934144)
print v(xbgr.mr_n74934464)
print v(xbgr.mr_n74934576)
print v(xbgr.mr_n74934896)
print v(xbgr.mr_n74935008)
print v(xbgr.mr_n74935328)
print v(xbgr.mr_n74935440)
print v(xbgr.mr_n74935760)
print v(xbgr.mr_n74935872)
print v(xbgr.mr_n74936192)
print v(xbgr.mr_n74936304)
print v(xbgr.mr_n74936624)
print v(xbgr.mr_n74936736)
print v(xbgr.mr_n74937056)
print v(xbgr.mr_n74937168)
print v(xbgr.mr_n74937488)
print v(xbgr.mr_n74937600)
print v(xbgr.mr_n74938032)
print v(xbgr.mr_n74938464)
print v(xbgr.mr_n74938896)
print v(xbgr.mr_n74939216)
print v(xbgr.mr_n74939328)
print v(xbgr.mr_n74939648)
print v(xbgr.mr_n74939760)
print v(xbgr.mr_n74940192)
print v(xbgr.mr_n74940624)
print v(xbgr.mr_n74941056)
print v(xbgr.mr_n74941488)
print v(xbgr.mr_n74941920)
print v(xbgr.mr_n74942352)
print v(xbgr.mr_n74942784)
print v(xbgr.mr_n74943216)
print v(xbgr.mr_n74943648)
print v(xbgr.mr_n74944080)
print v(xbgr.mr_n74944400)
print v(xbgr.mr_n74944512)
print v(xbgr.mr_n74944832)
print v(xbgr.mr_n74944944)
print v(xbgr.mr_n74945264)
print v(xbgr.mr_n74945376)
print v(xbgr.mr_n74945696)
print v(xbgr.mr_n74945808)
print v(xbgr.mr_n74946128)
print v(xbgr.mr_n74946240)
print v(xbgr.mr_n74946560)
print v(xbgr.mr_n74946672)
print v(xbgr.mr_n74946992)
print v(xbgr.mr_n74947104)
print v(xbgr.mr_n74947424)
print v(xbgr.mr_n74947536)
print v(xbgr.mr_n74947856)
print v(xbgr.mr_n74947968)
print v(xbgr.mr_n74948288)
print v(xbgr.mr_n74948400)
print v(xbgr.mr_n74948720)
print v(xbgr.mr_n74948832)
print v(xbgr.mr_n74949152)
print v(xbgr.mr_n74949264)
print v(xbgr.mr_n74949696)
print v(xbgr.mr_n74950128)
print v(xbgr.mr_n74950560)
print v(xbgr.mr_n74950992)
print v(xbgr.mr_n74951424)
print v(xbgr.mr_n74951856)
print v(xbgr.mr_n74952288)
print v(xbgr.mr_n74952608)
print v(xbgr.mr_n74952720)
print v(xbgr.mr_n74953152)
print v(xbgr.mr_n74953584)
print v(xbgr.mr_n74954016)
print v(xbgr.mr_n74954448)
print v(xbgr.mr_n74954880)
print v(xbgr.mr_n74955312)
print v(xbgr.mr_n74955632)
print v(xbgr.mr_n74955744)
print v(xbgr.mr_n74956064)
print v(xbgr.mr_n74956176)
print v(xbgr.mr_n74956496)
print v(xbgr.mr_n74956608)
print v(xbgr.mr_n74956928)
print v(xbgr.mr_n74957040)
print v(xbgr.mr_n74957360)
print v(xbgr.mr_n74957472)
print v(xbgr.mr_n74957792)
print v(xbgr.mr_n74957904)
print v(xbgr.mr_n74958224)
print v(xbgr.mr_n74958336)
print v(xbgr.mr_n74958656)
print v(xbgr.mr_n74958768)
print v(xbgr.mr_n74959088)
print v(xbgr.mr_n74959200)
print v(xbgr.mr_n74959520)
print v(xbgr.mr_n74959632)
print v(xbgr.mr_n74959952)
print v(xbgr.mr_n74960064)
print v(xbgr.mr_n74960384)
print v(xbgr.mr_n74960496)
print v(xbgr.mr_n74960816)
print v(xbgr.mr_n74960928)
print v(xbgr.mr_n74961248)
print v(xbgr.mr_n74961360)
print v(xbgr.mr_n74961680)
print v(xbgr.mr_n74961792)
print v(xbgr.mr_n74962112)
print v(xbgr.mr_n74962224)
print v(xbgr.mr_n74962544)
print v(xbgr.mr_n74962656)
print v(xbgr.mr_n74962976)
print v(xbgr.mr_n74963088)
print v(xbgr.mr_n74963408)
print v(xbgr.mr_n74963520)
print v(xbgr.mr_n74963840)
print v(xbgr.mr_n74963952)
print v(xbgr.mr_n74964272)
print v(xbgr.mr_n74964384)
print v(xbgr.mr_n74964704)
print v(xbgr.mr_n74964816)
print v(xbgr.mr_n74965136)
print v(xbgr.mr_n74965248)
print v(xbgr.mr_n74965568)
print v(xbgr.mr_n74965680)
print v(xbgr.mr_n74966112)
print v(xbgr.mr_n74966544)
print v(xbgr.mr_n74966976)
print v(xbgr.mr_n74967296)
print v(xbgr.mr_n74967408)
print v(xbgr.mr_n74967728)
print v(xbgr.mr_n74967840)
print v(xbgr.mr_n74968272)
print v(xbgr.mr_n74968704)
print v(xbgr.mr_n74969136)
print v(xbgr.mr_n74969568)
print v(xbgr.mr_n74970000)
print v(xbgr.mr_n74970432)
print v(xbgr.mr_n74970864)
print v(xbgr.mr_n74971296)
print v(xbgr.mr_n74971728)
print v(xbgr.mr_n74972160)
print v(xbgr.mr_n74972592)
print v(xbgr.mr_n74973024)
print v(xbgr.mr_n74973456)
print v(xbgr.mr_n74973888)
print v(xbgr.mr_n74974320)
print v(xbgr.mr_n74974752)
print v(xbgr.mr_n74975184)
print v(xbgr.mr_n74975616)
print v(xbgr.mr_n74976048)
print v(xbgr.mr_n74976480)
print v(xbgr.mr_n74976912)
print v(xbgr.mr_n74977344)
print v(xbgr.mr_n74977776)
print v(xbgr.mr_n74978096)
print v(xbgr.mr_n74978208)
print v(xbgr.mr_n74978528)
print v(xbgr.mr_n74978640)
print v(xbgr.mr_n74978960)
print v(xbgr.mr_n74979072)
print v(xbgr.mr_n74979392)
print v(xbgr.mr_n74979504)
print v(xbgr.mr_n74979824)
print v(xbgr.mr_n74979936)
print v(xbgr.mr_n74980256)
print v(xbgr.mr_n74980368)
print v(xbgr.mr_n74980688)
print v(xbgr.mr_n74980800)
print v(xbgr.mr_n74981120)
print v(xbgr.mr_n74981232)
print v(xbgr.mr_n74981552)
print v(xbgr.mr_n74981664)
print v(xbgr.mr_n74981984)
print v(xbgr.mr_n74982096)
print v(xbgr.mr_n74982416)
print v(xbgr.mr_n74982528)
print v(xbgr.mr_n74982848)
print v(xbgr.mr_n74982960)
print v(xbgr.mr_n74983280)
print v(xbgr.mr_n74983392)
print v(xbgr.mr_n74983712)
print v(xbgr.mr_n74983824)
print v(xbgr.mr_n74984256)
print v(xbgr.mr_n74984688)
print v(xbgr.mr_n74985008)
print v(xbgr.mr_n74985120)
print v(xbgr.mr_n74985440)
print v(xbgr.mr_n74985552)
print v(xbgr.mr_n74985872)
print v(xbgr.mr_n74985984)
print v(xbgr.mr_n74986304)
print v(xbgr.mr_n74986416)
print v(xbgr.mr_n74986848)
print v(xbgr.mr_n74987280)
print v(xbgr.mr_n74987600)
print v(xbgr.mr_n74987712)
print v(xbgr.mr_n74988032)
print v(xbgr.mr_n74988144)
print v(xbgr.mr_n74988464)
print v(xbgr.mr_n74988576)
print v(xbgr.mr_n74988896)
print v(xbgr.mr_n74989008)
print v(xbgr.mr_n74989328)
print v(xbgr.mr_n74989440)
print v(xbgr.mr_n74989760)
print v(xbgr.mr_n74989872)
print v(xbgr.mr_n74990192)
print v(xbgr.mr_n74990304)
print v(xbgr.mr_n74990624)
print v(xbgr.mr_n74990736)
print v(xbgr.mr_n74991168)
print v(xbgr.mr_n74991600)
print v(xbgr.mr_n74992032)
print v(xbgr.mr_n74992464)
print v(xbgr.mr_n74992896)
print v(xbgr.mr_n74993328)
print v(xbgr.mr_n74993760)
print v(xbgr.mr_n74994192)
print v(xbgr.mr_n74994624)
print v(xbgr.mr_n74995056)
print v(xbgr.mr_n74995376)
print v(xbgr.mr_n74995488)
print v(xbgr.mr_n74995808)
print v(xbgr.mr_n74995920)
print v(xbgr.mr_n74996240)
print v(xbgr.mr_n74996352)
print v(xbgr.mr_n74996672)
print v(xbgr.mr_n74996784)
print v(xbgr.mr_n75001840)
print v(xbgr.mr_n75001952)
print v(xbgr.mr_n75002288)
print v(xbgr.mr_n75002400)
print v(xbgr.mr_n75002720)
print v(xbgr.mr_n75002832)
print v(xbgr.mr_n75003200)
print v(xbgr.mr_n75003312)
print v(xbgr.mr_n75003632)
print v(xbgr.mr_n75003744)
print v(xbgr.mr_n75004064)
print v(xbgr.mr_n75004176)
print v(xbgr.mr_n75004416)
print v(xbgr.mr_n75004528)
print v(xbgr.mr_n75004848)
print v(xbgr.mr_n75004960)
print v(xbgr.mr_n75005280)
print v(xbgr.mr_n75005392)
print v(xbgr.mr_n75005712)
print v(xbgr.mr_n75005824)
print v(xbgr.mr_n75006144)
print v(xbgr.mr_n75006256)
print v(xbgr.mr_n75006576)
print v(xbgr.mr_n75006688)
print v(xbgr.mr_n75007008)
print v(xbgr.mr_n75007120)
print v(xbgr.mr_n75007440)
print v(xbgr.mr_n75007552)
print v(xbgr.mr_n75007872)
print v(xbgr.mr_n75007984)
print v(xbgr.mr_n75008304)
print v(xbgr.mr_n75008416)
print v(xbgr.mr_n75008736)
print v(xbgr.mr_n75008848)
print v(xbgr.mr_n75009168)
print v(xbgr.mr_n75009280)
print v(xbgr.mr_n75009600)
print v(xbgr.mr_n75009712)
print v(xbgr.mr_n75010032)
print v(xbgr.mr_n75010144)
print v(xbgr.mr_n75010464)
print v(xbgr.mr_n75010576)
print v(xbgr.mr_n75010896)
print v(xbgr.mr_n75011008)
print v(xbgr.mr_n75011328)
print v(xbgr.mr_n75011440)
print v(xbgr.mr_n75011760)
print v(xbgr.mr_n75011872)
print v(xbgr.mr_n75012192)
print v(xbgr.mr_n75012304)
print v(xbgr.mr_n75012624)
print v(xbgr.mr_n75012736)
print v(xbgr.mr_n75013056)
print v(xbgr.mr_n75013168)
print v(xbgr.mr_n75013488)
print v(xbgr.mr_n75013600)
print v(xbgr.mr_n75013920)
print v(xbgr.mr_n75014032)
print v(xbgr.mr_n75014352)
print v(xbgr.mr_n75014464)
print v(xbgr.mr_n75014784)
print v(xbgr.mr_n75014896)
print v(xbgr.mr_n75015216)
print v(xbgr.mr_n75015328)
print v(xbgr.mr_n75015648)
print v(xbgr.mr_n75015760)
print v(xbgr.mr_n75016080)
print v(xbgr.mr_n75016192)
print v(xbgr.mr_n75016512)
print v(xbgr.mr_n75016624)
print v(xbgr.mr_n75016944)
print v(xbgr.mr_n75017056)
print v(xbgr.mr_n75017376)
print v(xbgr.mr_n75017488)
print v(xbgr.mr_n75017808)
print v(xbgr.mr_n75017920)
print v(xbgr.mr_n75018240)
print v(xbgr.mr_n75018352)
print v(xbgr.mr_n75018672)
print v(xbgr.mr_n75018784)
print v(xbgr.mr_n75019104)
print v(xbgr.mr_n75019216)
print v(xbgr.mr_n75019536)
print v(xbgr.mr_n75019648)
print v(xbgr.mr_n75019968)
print v(xbgr.mr_n75020080)
print v(xbgr.mr_n75020400)
print v(xbgr.mr_n75020512)
print v(xbgr.mr_n75020832)
print v(xbgr.mr_n75020944)
print v(xbgr.mr_n75021264)
print v(xbgr.mr_n75021376)
print v(xbgr.mr_n75021696)
print v(xbgr.mr_n75021808)
print v(xbgr.mr_n75022128)
print v(xbgr.mr_n75022240)
print v(xbgr.mr_n75022560)
print v(xbgr.mr_n75022672)
print v(xbgr.mr_n75022992)
print v(xbgr.mr_n75023104)
print v(xbgr.mr_n75023424)
print v(xbgr.mr_n75023536)
print v(xbgr.mr_n75023856)
print v(xbgr.mr_n75023968)
print v(xbgr.mr_n75024288)
print v(xbgr.mr_n75024400)
print v(xbgr.mr_n75024720)
print v(xbgr.mr_n75024832)
print v(xbgr.mr_n75025152)
print v(xbgr.mr_n75025264)
print v(xbgr.mr_n75025584)
print v(xbgr.mr_n75025696)
print v(xbgr.mr_n75026016)
print v(xbgr.mr_n75026128)
print v(xbgr.mr_n75026448)
print v(xbgr.mr_n75026560)
print v(xbgr.mr_n75026880)
print v(xbgr.mr_n75026992)
print v(xbgr.mr_n75027312)
print v(xbgr.mr_n75027424)
print v(xbgr.mr_n75027744)
print v(xbgr.mr_n75027856)
print v(xbgr.mr_n75028176)
print v(xbgr.mr_n75028288)
print v(xbgr.mr_n75028608)
print v(xbgr.mr_n75028720)
print v(xbgr.mr_n75029040)
print v(xbgr.mr_n75029152)
print v(xbgr.mr_n75029472)
print v(xbgr.mr_n75029584)
print v(xbgr.mr_n75029904)
print v(xbgr.mr_n75030016)
print v(xbgr.mr_n75030336)
print v(xbgr.mr_n75030448)
print v(xbgr.mr_n75030768)
print v(xbgr.mr_n75030880)
print v(xbgr.mr_n75031200)
print v(xbgr.mr_n75031312)
print v(xbgr.mr_n75031632)
print v(xbgr.mr_n75031744)
print v(xbgr.mr_n75031968)
print v(xbgr.mr_n75032080)
print v(xbgr.mr_n75032336)
print v(xbgr.mr_n75032448)
print v(xbgr.mr_n75032704)
print v(xbgr.mr_n75032816)
print v(xbgr.mr_n75033072)
print v(xbgr.mr_n75033184)
print v(xbgr.mr_n75033440)
print v(xbgr.mr_n75033552)
print v(xbgr.mr_n75033808)
print v(xbgr.mr_n75033920)
print v(xbgr.mr_n75034176)
print v(xbgr.mr_n75034288)
print v(xbgr.mr_n75034544)
print v(xbgr.mr_n75034656)
print v(xbgr.mr_n75034912)
print v(xbgr.mr_n75035024)
print v(xbgr.mr_n75035280)
print v(xbgr.mr_n75035392)
print v(xbgr.mr_n75035712)
print v(xbgr.mr_n75035824)
print v(xbgr.mr_n75036144)
print v(xbgr.mr_n75036256)
print v(xbgr.mr_n75036576)
print v(xbgr.mr_n75036688)
print v(xbgr.mr_n75037008)
print v(xbgr.mr_n75037120)
print v(xbgr.mr_n75037440)
print v(xbgr.mr_n75037552)
print v(xbgr.mr_n75037872)
print v(xbgr.mr_n75037984)
print v(xbgr.mr_n75038304)
print v(xbgr.mr_n75038416)
print v(xbgr.mr_n75038736)
print v(xbgr.mr_n75038848)
print v(xbgr.mr_n75039168)
print v(xbgr.mr_n75039280)
print v(xbgr.mr_n75039600)
print v(xbgr.mr_n75039712)
print v(xbgr.mr_n75040032)
print v(xbgr.mr_n75040144)
print v(xbgr.mr_n75040464)
print v(xbgr.mr_n75040576)
print v(xbgr.mr_n75040896)
print v(xbgr.mr_n75041008)
print v(xbgr.mr_n75041328)
print v(xbgr.mr_n75041440)
print v(xbgr.mr_n75041760)
print v(xbgr.mr_n75041872)
print v(xbgr.mr_n75042192)
print v(xbgr.mr_n75042304)
print v(xbgr.mr_n75042624)
print v(xbgr.mr_n75042736)
print v(xbgr.mr_n75043056)
print v(xbgr.mr_n75043168)
print v(xbgr.mr_n75043488)
print v(xbgr.mr_n75043600)
print v(xbgr.mr_n75043920)
print v(xbgr.mr_n75044032)
print v(xbgr.mr_n75044352)
print v(xbgr.mr_n75044464)
print v(xbgr.mr_n75044784)
print v(xbgr.mr_n75044896)
print v(xbgr.mr_n75045216)
print v(xbgr.mr_n75045328)
print v(xbgr.mr_n75045648)
print v(xbgr.mr_n75045760)
print v(xbgr.mr_n75046080)
print v(xbgr.mr_n75046192)
print v(xbgr.mr_n75046512)
print v(xbgr.mr_n75046624)
print v(xbgr.mr_n75046944)
print v(xbgr.mr_n75047056)
print v(xbgr.mr_n75047376)
print v(xbgr.mr_n75047488)
print v(xbgr.mr_n75047808)
print v(xbgr.mr_n75047920)
print v(xbgr.mr_n75048240)
print v(xbgr.mr_n75048352)
print v(xbgr.mr_n75048672)
print v(xbgr.mr_n75048784)
print v(xbgr.mr_n75049104)
print v(xbgr.mr_n75049216)
print v(xbgr.mr_n75049536)
print v(xbgr.mr_n75049648)
print v(xbgr.mr_n75049968)
print v(xbgr.mr_n75050080)
print v(xbgr.mr_n75050400)
print v(xbgr.mr_n75050512)
print v(xbgr.mr_n75050832)
print v(xbgr.mr_n75050944)
print v(xbgr.mr_n75051264)
print v(xbgr.mr_n75051376)
print v(xbgr.mr_n75051696)
print v(xbgr.mr_n75051808)
print v(xbgr.mr_n75052128)
print v(xbgr.mr_n75052240)
print v(xbgr.mr_n75052560)
print v(xbgr.mr_n75052672)
print v(xbgr.mr_n75052992)
print v(xbgr.mr_n75053104)
print v(xbgr.mr_n75053424)
print v(xbgr.mr_n75053536)
print v(xbgr.mr_n75053856)
print v(xbgr.mr_n75053968)
print v(xbgr.mr_n75054288)
print v(xbgr.mr_n75054400)
print v(xbgr.mr_n75054720)
print v(xbgr.mr_n75054832)
print v(xbgr.mr_n75055152)
print v(xbgr.mr_n75055264)
print v(xbgr.mr_n75055584)
print v(xbgr.mr_n75055696)
print v(xbgr.mr_n75056016)
print v(xbgr.mr_n75056128)
print v(xbgr.mr_n75056448)
print v(xbgr.mr_n75056560)
print v(xbgr.mr_n75056880)
print v(xbgr.mr_n75056992)
print v(xbgr.mr_n75057312)
print v(xbgr.mr_n75057424)
print v(xbgr.mr_n75057744)
print v(xbgr.mr_n75057856)
print v(xbgr.mr_n75058176)
print v(xbgr.mr_n75058288)
print v(xbgr.mr_n75058608)
print v(xbgr.mr_n75058720)
print v(xbgr.mr_n75059040)
print v(xbgr.mr_n75059152)
print v(xbgr.mr_n75059472)
print v(xbgr.mr_n75059584)
print v(xbgr.mr_n75059904)
print v(xbgr.mr_n75060016)
print v(xbgr.mr_n75060336)
print v(xbgr.mr_n75060448)
print v(xbgr.mr_n75060768)
print v(xbgr.mr_n75060880)
print v(xbgr.mr_n75061200)
print v(xbgr.mr_n75061312)
print v(xbgr.mr_n75061632)
print v(xbgr.mr_n75061744)
print v(xbgr.mr_n75062064)
print v(xbgr.mr_n75062176)
print v(xbgr.mr_n75062496)
print v(xbgr.mr_n75062608)
print v(xbgr.mr_n75062928)
print v(xbgr.mr_n75063040)
print v(xbgr.mr_n75063248)
print v(xbgr.mr_n75063360)
print v(xbgr.mr_n75063680)
print v(xbgr.mr_n75063792)
print v(xbgr.mr_n75064112)
print v(xbgr.mr_n75064224)
print v(xbgr.mr_n75064544)
print v(xbgr.mr_n75064656)
print v(xbgr.mr_n75064976)
print v(xbgr.mr_n75065088)
print v(xbgr.mr_n75065408)
print v(xbgr.mr_n75065520)
print v(xbgr.mr_n75065840)
print v(xbgr.mr_n75065952)
print v(xbgr.mr_n75066272)
print v(xbgr.mr_n75066384)
print v(xbgr.mr_n75066704)
print v(xbgr.mr_n75066816)
print v(xbgr.mr_n75067136)
print v(xbgr.mr_n75067248)
print v(xbgr.mr_n75067568)
print v(xbgr.mr_n75067680)
print v(xbgr.mr_n75068000)
print v(xbgr.mr_n75068112)
print v(xbgr.mr_n75068432)
print v(xbgr.mr_n75068544)
print v(xbgr.mr_n75068864)
print v(xbgr.mr_n75068976)
print v(xbgr.mr_n75069296)
print v(xbgr.mr_n75069408)
print v(xbgr.mr_n75069728)
print v(xbgr.mr_n75069840)
print v(xbgr.mr_n75070160)
print v(xbgr.mr_n75070272)
print v(xbgr.mr_n75070592)
print v(xbgr.mr_n75070704)
print v(xbgr.mr_n75071024)
print v(xbgr.mr_n75071136)
print v(xbgr.mr_n75071456)
print v(xbgr.mr_n75071568)
print v(xbgr.mr_n75071888)
print v(xbgr.mr_n75072000)
print v(xbgr.mr_n75072320)
print v(xbgr.mr_n75072432)
print v(xbgr.mr_n75072752)
print v(xbgr.mr_n75072864)
print v(xbgr.mr_n75073184)
print v(xbgr.mr_n75073296)
print v(xbgr.mr_n75073616)
print v(xbgr.mr_n75073728)
print v(xbgr.mr_n75074048)
print v(xbgr.mr_n75074160)
print v(xbgr.mr_n75074480)
print v(xbgr.mr_n75074592)
print v(xbgr.mr_n75074912)
print v(xbgr.mr_n75075024)
print v(xbgr.mr_n75075344)
print v(xbgr.mr_n75075456)
print v(xbgr.mr_n75075776)
print v(xbgr.mr_n75075888)
print v(xbgr.mr_n75076208)
print v(xbgr.mr_n75076320)
print v(xbgr.mr_n75076640)
print v(xbgr.mr_n75076752)
print v(xbgr.mr_n75077072)
print v(xbgr.mr_n75077184)
print v(xbgr.mr_n75077504)
print v(xbgr.mr_n75077616)
print v(xbgr.mr_n75077936)
print v(xbgr.mr_n75078048)
print v(xbgr.mr_n75078368)
print v(xbgr.mr_n75078480)
print v(xbgr.mr_n75078800)
print v(xbgr.mr_n75078912)
print v(xbgr.mr_n75079232)
print v(xbgr.mr_n75079344)
print v(xbgr.mr_n75079664)
print v(xbgr.mr_n75079776)
print v(xbgr.mr_n75080096)
print v(xbgr.mr_n75080208)
print v(xbgr.mr_n75080528)
print v(xbgr.mr_n75080640)
print v(xbgr.mr_n75080960)
print v(xbgr.mr_n75081072)
print v(xbgr.mr_n75081392)
print v(xbgr.mr_n75081504)
print v(xbgr.mr_n75081824)
print v(xbgr.mr_n75081936)
print v(xbgr.mr_n75082256)
print v(xbgr.mr_n75082368)
print v(xbgr.mr_n75082688)
print v(xbgr.mr_n75082800)
print v(xbgr.mr_n75083120)
print v(xbgr.mr_n75083232)
print v(xbgr.mr_n75083552)
print v(xbgr.mr_n75083664)
print v(xbgr.mr_n75083984)
print v(xbgr.mr_n75084096)
print v(xbgr.mr_n75084416)
print v(xbgr.mr_n75084528)
print v(xbgr.mr_n75084848)
print v(xbgr.mr_n75084960)
print v(xbgr.mr_n75085280)
print v(xbgr.mr_n75085392)
print v(xbgr.mr_n75085712)
print v(xbgr.mr_n75085824)
print v(xbgr.mr_n75086144)
print v(xbgr.mr_n75086256)
print v(xbgr.mr_n75086576)
print v(xbgr.mr_n75086688)
print v(xbgr.mr_n75087008)
print v(xbgr.mr_n75087120)
print v(xbgr.mr_n75087440)
print v(xbgr.mr_n75087552)
print v(xbgr.mr_n75087872)
print v(xbgr.mr_n75087984)
print v(xbgr.mr_n75088304)
print v(xbgr.mr_n75088416)
print v(xbgr.mr_n75088736)
print v(xbgr.mr_n75088848)
print v(xbgr.mr_n75089168)
print v(xbgr.mr_n75089280)
print v(xbgr.mr_n75089600)
print v(xbgr.mr_n75089712)
print v(xbgr.mr_n75090032)
print v(xbgr.mr_n75090144)
print v(xbgr.mr_n75090464)
print v(xbgr.mr_n75090576)
print v(xbgr.mr_n75090896)
print v(xbgr.mr_n75091008)
print v(xbgr.mr_n75091328)
print v(xbgr.mr_n75091440)
print v(xbgr.mr_n75091760)
print v(xbgr.mr_n75091872)
print v(xbgr.mr_n75092192)
print v(xbgr.mr_n75092304)
print v(xbgr.mr_n75092624)
print v(xbgr.mr_n75092736)
print v(xbgr.mr_n75093056)
print v(xbgr.mr_n75093168)
print v(xbgr.mr_n75093488)
print v(xbgr.mr_n75093600)
print v(xbgr.mr_n75093920)
print v(xbgr.mr_n75094032)
print v(xbgr.mr_n75094352)
print v(xbgr.mr_n75094464)
print v(xbgr.mr_n75094784)
print v(xbgr.mr_n75094896)
print v(xbgr.mr_n75095216)
print v(xbgr.mr_n75095328)
print v(xbgr.mr_n75095648)
print v(xbgr.mr_n75095760)
print v(xbgr.mr_n75096080)
print v(xbgr.mr_n75096192)
print v(xbgr.mr_n75096512)
print v(xbgr.mr_n75096624)
print v(xbgr.mr_n75096944)
print v(xbgr.mr_n75097056)
print v(xbgr.mr_n75097376)
print v(xbgr.mr_n75097488)
print v(xbgr.mr_n75097808)
print v(xbgr.mr_n75097920)
print v(xbgr.mr_n75098240)
print v(xbgr.mr_n75098352)
print v(xbgr.mr_n75098672)
print v(xbgr.mr_n75098784)
print v(xbgr.mr_n75099104)
print v(xbgr.mr_n75099216)
print v(xbgr.mr_n75099536)
print v(xbgr.mr_n75099648)
print v(xbgr.mr_n75099968)
print v(xbgr.mr_n75100080)
print v(xbgr.mr_n75100400)
print v(xbgr.mr_n75100512)
print v(xbgr.mr_n75100832)
print v(xbgr.mr_n75100944)
print v(xbgr.mr_n75101264)
print v(xbgr.mr_n75101376)
print v(xbgr.mr_n75101696)
print v(xbgr.mr_n75101808)
print v(xbgr.mr_n75102128)
print v(xbgr.mr_n75102240)
print v(xbgr.mr_n75102560)
print v(xbgr.mr_n75102672)
print v(xbgr.mr_n75102992)
print v(xbgr.mr_n75103104)
print v(xbgr.mr_n75103424)
print v(xbgr.mr_n75103536)
print v(xbgr.mr_n75103856)
print v(xbgr.mr_n75103968)
print v(xbgr.mr_n75104288)
print v(xbgr.mr_n75104400)
print v(xbgr.mr_n75104720)
print v(xbgr.mr_n75104832)
print v(xbgr.mr_n75105152)
print v(xbgr.mr_n75105264)
print v(xbgr.mr_n75105584)
print v(xbgr.mr_n75105696)
print v(xbgr.mr_n75106016)
print v(xbgr.mr_n75106128)
print v(xbgr.mr_n75106448)
print v(xbgr.mr_n75106560)
print v(xbgr.mr_n75106880)
print v(xbgr.mr_n75106992)
print v(xbgr.mr_n75107312)
print v(xbgr.mr_n75107424)
print v(xbgr.mr_n75107744)
print v(xbgr.mr_n75107856)
print v(xbgr.mr_n75108176)
print v(xbgr.mr_n75108288)
print v(xbgr.mr_n75108608)
print v(xbgr.mr_n75108720)
print v(xbgr.mr_n75109040)
print v(xbgr.mr_n75109152)
print v(xbgr.mr_n75109472)
print v(xbgr.mr_n75109584)
print v(xbgr.mr_n75109904)
print v(xbgr.mr_n75110016)
print v(xbgr.mr_n75110336)
print v(xbgr.mr_n75110448)
print v(xbgr.mr_n75110768)
print v(xbgr.mr_n75110880)
print v(xbgr.mr_n75111200)
print v(xbgr.mr_n75111312)
print v(xbgr.mr_n75111632)
print v(xbgr.mr_n75111744)
print v(xbgr.mr_n75112064)
print v(xbgr.mr_n75112176)
print v(xbgr.mr_n75112496)
print v(xbgr.mr_n75112608)
print v(xbgr.mr_n75112928)
print v(xbgr.mr_n75113040)
print v(xbgr.mr_n75113360)
print v(xbgr.mr_n75113472)
print v(xbgr.mr_n75113792)
print v(xbgr.mr_n75113904)
print v(xbgr.mr_n75114224)
print v(xbgr.mr_n75114336)
print v(xbgr.mr_n75114656)
print v(xbgr.mr_n75114768)
print v(xbgr.mr_n75115088)
print v(xbgr.mr_n75115200)
print v(xbgr.mr_n75115520)
print v(xbgr.mr_n75115632)
print v(xbgr.mr_n75115952)
print v(xbgr.mr_n75116064)
print v(xbgr.mr_n75116384)
print v(xbgr.mr_n75116496)
print v(xbgr.mr_n75116816)
print v(xbgr.mr_n75116928)
print v(xbgr.mr_n75117248)
print v(xbgr.mr_n75117360)
print v(xbgr.mr_n75117680)
print v(xbgr.mr_n75117792)
print v(xbgr.mr_n75118112)
print v(xbgr.mr_n75118224)
print v(xbgr.mr_n75118544)
print v(xbgr.mr_n75118656)
print v(xbgr.mr_n75118976)
print v(xbgr.mr_n75119088)
print v(xbgr.mr_n75119408)
print v(xbgr.mr_n75119520)
print v(xbgr.mr_n75119840)
print v(xbgr.mr_n75119952)
print v(xbgr.mr_n75120272)
print v(xbgr.mr_n75120384)
print v(xbgr.mr_n75120704)
print v(xbgr.mr_n75120816)
print v(xbgr.mr_n75121136)
print v(xbgr.mr_n75121248)
print v(xbgr.mr_n75121568)
print v(xbgr.mr_n75121680)
print v(xbgr.mr_n75122000)
print v(xbgr.mr_n75122112)
print v(xbgr.mr_n75122432)
print v(xbgr.mr_n75122544)
print v(xbgr.mr_n75122864)
print v(xbgr.mr_n75122976)
print v(xbgr.mr_n75123296)
print v(xbgr.mr_n75123408)
print v(xbgr.mr_n75123728)
print v(xbgr.mr_n75123840)
print v(xbgr.mr_n75124160)
print v(xbgr.mr_n75124272)
print v(xbgr.mr_n75124800)
print v(xbgr.mr_n75124912)
print v(xbgr.mr_n75125232)
print v(xbgr.mr_n75125344)
print v(xbgr.mr_n75125664)
print v(xbgr.mr_n75125776)
print v(xbgr.mr_n75126096)
print v(xbgr.mr_n75126208)
print v(xbgr.mr_n75126528)
print v(xbgr.mr_n75126640)
print v(xbgr.mr_n75126960)
print v(xbgr.mr_n75127072)
print v(xbgr.mr_n75127392)
print v(xbgr.mr_n75127504)
print v(xbgr.mr_n75127824)
print v(xbgr.mr_n75127936)
print v(xbgr.mr_n75128256)
print v(xbgr.mr_n75128368)
print v(xbgr.mr_n75128688)
print v(xbgr.mr_n75128800)
print v(xbgr.mr_n75129120)
print v(xbgr.mr_n75129232)
print v(xbgr.mr_n75129552)
print v(xbgr.mr_n75129664)
print v(xbgr.mr_n75129984)
print v(xbgr.mr_n75130096)
print v(xbgr.mr_n75130416)
print v(xbgr.mr_n75130528)
print v(xbgr.mr_n75130848)
print v(xbgr.mr_n75130960)
print v(xbgr.mr_n75131280)
print v(xbgr.mr_n75131392)
print v(xbgr.mr_n75131712)
print v(xbgr.mr_n75131824)
print v(xbgr.mr_n75132144)
print v(xbgr.mr_n75132256)
print v(xbgr.mr_n75132576)
print v(xbgr.mr_n75132688)
print v(xbgr.mr_n75133008)
print v(xbgr.mr_n75133120)
print v(xbgr.mr_n75133440)
print v(xbgr.mr_n75133552)
print v(xbgr.mr_n75133872)
print v(xbgr.mr_n75133984)
print v(xbgr.mr_n75134304)
print v(xbgr.mr_n75134416)
print v(xbgr.mr_n75134736)
print v(xbgr.mr_n75134848)
print v(xbgr.mr_n75135168)
print v(xbgr.mr_n75135280)
print v(xbgr.mr_n75135600)
print v(xbgr.mr_n75135712)
print v(xbgr.mr_n75136032)
print v(xbgr.mr_n75136144)
print v(xbgr.mr_n75136464)
print v(xbgr.mr_n75136576)
print v(xbgr.mr_n75136896)
print v(xbgr.mr_n75137008)
print v(xbgr.mr_n75137328)
print v(xbgr.mr_n75137440)
print v(xbgr.mr_n75137760)
print v(xbgr.mr_n75137872)
print v(xbgr.mr_n75138192)
print v(xbgr.mr_n75138304)
print v(xbgr.mr_n75138624)
print v(xbgr.mr_n75138736)
print v(xbgr.mr_n75139056)
print v(xbgr.mr_n75139168)
print v(xbgr.mr_n75139488)
print v(xbgr.mr_n75139600)
print v(xbgr.mr_n75139920)
print v(xbgr.mr_n75140032)
print v(xbgr.mr_n75140352)
print v(xbgr.mr_n75140464)
print v(xbgr.mr_n75140784)
print v(xbgr.mr_n75140896)
print v(xbgr.mr_n75141216)
print v(xbgr.mr_n75141328)
print v(xbgr.mr_n75141648)
print v(xbgr.mr_n75141760)
print v(xbgr.mr_n75142080)
print v(xbgr.mr_n75142192)
print v(xbgr.mr_n75142512)
print v(xbgr.mr_n75142624)
print v(xbgr.mr_n75142944)
print v(xbgr.mr_n75143056)
print v(xbgr.mr_n75143376)
print v(xbgr.mr_n75143488)
print v(xbgr.mr_n75143808)
print v(xbgr.mr_n75143920)
print v(xbgr.mr_n75144240)
print v(xbgr.mr_n75144352)
print v(xbgr.mr_n75144672)
print v(xbgr.mr_n75144784)
print v(xbgr.mr_n75145104)
print v(xbgr.mr_n75145216)
print v(xbgr.mr_n75145536)
print v(xbgr.mr_n75145648)
print v(xbgr.mr_n75145968)
print v(xbgr.mr_n75146080)
print v(xbgr.mr_n75146400)
print v(xbgr.mr_n75146512)
print v(xbgr.mr_n75146832)
print v(xbgr.mr_n75146944)
print v(xbgr.mr_n75147264)
print v(xbgr.mr_n75147376)
print v(xbgr.mr_n75147696)
print v(xbgr.mr_n75147808)
print v(xbgr.mr_n75148128)
print v(xbgr.mr_n75148240)
print v(xbgr.mr_n75148560)
print v(xbgr.mr_n75148672)
print v(xbgr.mr_n75148992)
print v(xbgr.mr_n75149104)
print v(xbgr.mr_n75149424)
print v(xbgr.mr_n75149536)
print v(xbgr.mr_n75149856)
print v(xbgr.mr_n75149968)
print v(xbgr.mr_n75150288)
print v(xbgr.mr_n75150400)
print v(xbgr.mr_n75150720)
print v(xbgr.mr_n75150832)
print v(xbgr.mr_n75151152)
print v(xbgr.mr_n75151264)
print v(xbgr.mr_n75151584)
print v(xbgr.mr_n75151696)
print v(xbgr.mr_n75152016)
print v(xbgr.mr_n75152128)
print v(xbgr.mr_n75152448)
print v(xbgr.mr_n75152560)
print v(xbgr.mr_n75152880)
print v(xbgr.mr_n75152992)
print v(xbgr.mr_n75153312)
print v(xbgr.mr_n75153424)
print v(xbgr.mr_n75153744)
print v(xbgr.mr_n75153856)
print v(xbgr.mr_n75154176)
print v(xbgr.mr_n75154288)
print v(xbgr.mr_n75154608)
print v(xbgr.mr_n75154720)
print v(xbgr.mr_n75155040)
print v(xbgr.mr_n75155152)
print v(xbgr.mr_n75155472)
print v(xbgr.mr_n75155584)
print v(xbgr.mr_n75155904)
print v(xbgr.mr_n75156016)
print v(xbgr.mr_n75156336)
print v(xbgr.mr_n75156448)
print v(xbgr.mr_n75156768)
print v(xbgr.mr_n75156880)
print v(xbgr.mr_n75157200)
print v(xbgr.mr_n75157312)
print v(xbgr.mr_n75157632)
print v(xbgr.mr_n75157744)
print v(xbgr.mr_n75158064)
print v(xbgr.mr_n75158176)
print v(xbgr.mr_n75158496)
print v(xbgr.mr_n75158608)
print v(xbgr.mr_n75158928)
print v(xbgr.mr_n75159040)
print v(xbgr.mr_n75159360)
print v(xbgr.mr_n75159472)
print v(xbgr.mr_n75159792)
print v(xbgr.mr_n75159904)
print v(xbgr.mr_n75160224)
print v(xbgr.mr_n75160336)
print v(xbgr.mr_n75160656)
print v(xbgr.mr_n75160768)
print v(xbgr.mr_n75161088)
print v(xbgr.mr_n75161200)
print v(xbgr.mr_n75161520)
print v(xbgr.mr_n75161632)
print v(xbgr.mr_n75161952)
print v(xbgr.mr_n75162064)
print v(xbgr.mr_n75162384)
print v(xbgr.mr_n75162496)
print v(xbgr.mr_n75162816)
print v(xbgr.mr_n75162928)
print v(xbgr.mr_n75163248)
print v(xbgr.mr_n75163360)
print v(xbgr.mr_n75163680)
print v(xbgr.mr_n75163792)
print v(xbgr.mr_n75164112)
print v(xbgr.mr_n75164224)
print v(xbgr.mr_n75426704)
print v(xbgr.mr_n75426944)
print v(xbgr.mr_n75427056)
print v(xbgr.mr_n75427376)
print v(xbgr.mr_n75427488)
print v(xbgr.mr_n75427808)
print v(xbgr.mr_n75427920)
print v(xbgr.mr_n75428240)
print v(xbgr.mr_n75428352)
print v(xbgr.mr_n75428672)
print v(xbgr.mr_n75428784)
print v(xbgr.mr_n75429104)
print v(xbgr.mr_n75429216)
print v(xbgr.mr_n75429536)
print v(xbgr.mr_n75429648)
print v(xbgr.mr_n75429968)
print v(xbgr.mr_n75430080)
print v(xbgr.mr_n75430400)
print v(xbgr.mr_n75430512)
print v(xbgr.mr_n75430832)
print v(xbgr.mr_n75430944)
print v(xbgr.mr_n75431264)
print v(xbgr.mr_n75431376)
print v(xbgr.mr_n75431696)
print v(xbgr.mr_n75431808)
print v(xbgr.mr_n75432128)
print v(xbgr.mr_n75432240)
print v(xbgr.mr_n75432560)
print v(xbgr.mr_n75432672)
print v(xbgr.mr_n75432992)
print v(xbgr.mr_n75433104)
print v(xbgr.mr_n75433424)
print v(xbgr.mr_n75433536)
print v(xbgr.mr_n75433856)
print v(xbgr.mr_n75433968)
print v(xbgr.mr_n75434288)
print v(xbgr.mr_n75434400)
print v(xbgr.mr_n75434720)
print v(xbgr.mr_n75434832)
print v(xbgr.mr_n75435152)
print v(xbgr.mr_n75435264)
print v(xbgr.mr_n75435584)
print v(xbgr.mr_n75435696)
print v(xbgr.mr_n75436016)
print v(xbgr.mr_n75436128)
print v(xbgr.mr_n75436448)
print v(xbgr.mr_n75436560)
print v(xbgr.mr_n75436880)
print v(xbgr.mr_n75436992)
print v(xbgr.mr_n75437312)
print v(xbgr.mr_n75437424)
print v(xbgr.mr_n75437744)
print v(xbgr.mr_n75437856)
print v(xbgr.mr_n75438176)
print v(xbgr.mr_n75438288)
print v(xbgr.mr_n75438608)
print v(xbgr.mr_n75438720)
print v(xbgr.mr_n75439040)
print v(xbgr.mr_n75439152)
print v(xbgr.mr_n75439472)
print v(xbgr.mr_n75439584)
print v(xbgr.mr_n75439904)
print v(xbgr.mr_n75440016)
print v(xbgr.mr_n75440336)
print v(xbgr.mr_n75440448)
print v(xbgr.mr_n75440768)
print v(xbgr.mr_n75440880)
print v(xbgr.mr_n75441200)
print v(xbgr.mr_n75441312)
print v(xbgr.mr_n75441632)
print v(xbgr.mr_n75441744)
print v(xbgr.mr_n75442064)
print v(xbgr.mr_n75442176)
print v(xbgr.mr_n75442496)
print v(xbgr.mr_n75442608)
print v(xbgr.mr_n75442928)
print v(xbgr.mr_n75443040)
print v(xbgr.mr_n75443360)
print v(xbgr.mr_n75443472)
print v(xbgr.mr_n75443792)
print v(xbgr.mr_n75443904)
print v(xbgr.mr_n75444224)
print v(xbgr.mr_n75444336)
print v(xbgr.mr_n75444656)
print v(xbgr.mr_n75444768)
print v(xbgr.mr_n75445088)
print v(xbgr.mr_n75445200)
print v(xbgr.mr_n75445520)
print v(xbgr.mr_n75445632)
print v(xbgr.mr_n75445952)
print v(xbgr.mr_n75446064)
print v(xbgr.mr_n75446384)
print v(xbgr.mr_n75446496)
print v(xbgr.mr_n75446816)
print v(xbgr.mr_n75446928)
print v(xbgr.mr_n75447248)
print v(xbgr.mr_n75447360)
print v(xbgr.mr_n75447680)
print v(xbgr.mr_n75447792)
print v(xbgr.mr_n75448112)
print v(xbgr.mr_n75448224)
print v(xbgr.mr_n75448544)
print v(xbgr.mr_n75448656)
print v(xbgr.mr_n75448976)
print v(xbgr.mr_n75449088)
print v(xbgr.mr_n75449408)
print v(xbgr.mr_n75449520)
print v(xbgr.mr_n75449840)
print v(xbgr.mr_n75449952)
print v(xbgr.mr_n75450272)
print v(xbgr.mr_n75450384)
print v(xbgr.mr_n75450704)
print v(xbgr.mr_n75450816)
print v(xbgr.mr_n75451136)
print v(xbgr.mr_n75451248)
print v(xbgr.mr_n75451568)
print v(xbgr.mr_n75451680)
print v(xbgr.mr_n75452000)
print v(xbgr.mr_n75452112)
print v(xbgr.mr_n75452432)
print v(xbgr.mr_n75452544)
print v(xbgr.mr_n75452864)
print v(xbgr.mr_n75452976)
print v(xbgr.mr_n75453296)
print v(xbgr.mr_n75453408)
print v(xbgr.mr_n75453728)
print v(xbgr.mr_n75453840)
print v(xbgr.mr_n75454160)
print v(xbgr.mr_n75454272)
print v(xbgr.mr_n75454592)
print v(xbgr.mr_n75454704)
print v(xbgr.mr_n75455024)
print v(xbgr.mr_n75455136)
print v(xbgr.mr_n75455456)
print v(xbgr.mr_n75455568)
print v(xbgr.mr_n75455888)
print v(xbgr.mr_n75456000)
print v(xbgr.mr_n75456320)
print v(xbgr.mr_n75456432)
print v(xbgr.mr_n75456752)
print v(xbgr.mr_n75456864)
print v(xbgr.mr_n75457184)
print v(xbgr.mr_n75457296)
print v(xbgr.mr_n75457616)
print v(xbgr.mr_n75457728)
print v(xbgr.mr_n75458048)
print v(xbgr.mr_n75458160)
print v(xbgr.mr_n75458480)
print v(xbgr.mr_n75458592)
print v(xbgr.mr_n75458912)
print v(xbgr.mr_n75459024)
print v(xbgr.mr_n75459344)
print v(xbgr.mr_n75459456)
print v(xbgr.mr_n75459776)
print v(xbgr.mr_n75459888)
print v(xbgr.mr_n75460208)
print v(xbgr.mr_n75460320)
print v(xbgr.mr_n75460640)
print v(xbgr.mr_n75460752)
print v(xbgr.mr_n75461072)
print v(xbgr.mr_n75461184)
print v(xbgr.mr_n75461504)
print v(xbgr.mr_n75461616)
print v(xbgr.mr_n75461936)
print v(xbgr.mr_n75462048)
print v(xbgr.mr_n75462368)
print v(xbgr.mr_n75462480)
print v(xbgr.mr_n75462800)
print v(xbgr.mr_n75462912)
print v(xbgr.mr_n75463232)
print v(xbgr.mr_n75463344)
print v(xbgr.mr_n75463664)
print v(xbgr.mr_n75463776)
print v(xbgr.mr_n75464096)
print v(xbgr.mr_n75464208)
print v(xbgr.mr_n75464528)
print v(xbgr.mr_n75464640)
print v(xbgr.mr_n75464960)
print v(xbgr.mr_n75465072)
print v(xbgr.mr_n75465392)
print v(xbgr.mr_n75465504)
print v(xbgr.mr_n75465824)
print v(xbgr.mr_n75465936)
print v(xbgr.mr_n75466256)
print v(xbgr.mr_n75466368)
print v(xbgr.mr_n75466688)
print v(xbgr.mr_n75466800)
print v(xbgr.mr_n75467120)
print v(xbgr.mr_n75467232)
print v(xbgr.mr_n75467552)
print v(xbgr.mr_n75467664)
print v(xbgr.mr_n75467984)
print v(xbgr.mr_n75468096)
print v(xbgr.mr_n75468416)
print v(xbgr.mr_n75468528)
print v(xbgr.mr_n75468848)
print v(xbgr.mr_n75468960)
print v(xbgr.mr_n75469280)
print v(xbgr.mr_n75469392)
print v(xbgr.mr_n75469712)
print v(xbgr.mr_n75469824)
print v(xbgr.mr_n75470144)
print v(xbgr.mr_n75470256)
print v(xbgr.mr_n75470576)
print v(xbgr.mr_n75470688)
print v(xbgr.mr_n75471008)
print v(xbgr.mr_n75471120)
print v(xbgr.mr_n75471440)
print v(xbgr.mr_n75471552)
print v(xbgr.mr_n75471872)
print v(xbgr.mr_n75471984)
print v(xbgr.mr_n75472304)
print v(xbgr.mr_n75472416)
print v(xbgr.mr_n75472736)
print v(xbgr.mr_n75472848)
print v(xbgr.mr_n75473168)
print v(xbgr.mr_n75473280)
print v(xbgr.mr_n75473600)
print v(xbgr.mr_n75473712)
print v(xbgr.mr_n75474032)
print v(xbgr.mr_n75474144)
print v(xbgr.mr_n75474464)
print v(xbgr.mr_n75474576)
print v(xbgr.mr_n75474896)
print v(xbgr.mr_n75475008)
print v(xbgr.mr_n75475328)
print v(xbgr.mr_n75475440)
print v(xbgr.mr_n75475760)
print v(xbgr.mr_n75475872)
print v(xbgr.mr_n75476192)
print v(xbgr.mr_n75476304)
print v(xbgr.mr_n75476624)
print v(xbgr.mr_n75476736)
print v(xbgr.mr_n75477056)
print v(xbgr.mr_n75477168)
print v(xbgr.mr_n75477488)
print v(xbgr.mr_n75477600)
print v(xbgr.mr_n75477920)
print v(xbgr.mr_n75478032)
print v(xbgr.mr_n75478352)
print v(xbgr.mr_n75478464)
print v(xbgr.mr_n75478784)
print v(xbgr.mr_n75478896)
print v(xbgr.mr_n75479216)
print v(xbgr.mr_n75479328)
print v(xbgr.mr_n75479648)
print v(xbgr.mr_n75479760)
print v(xbgr.mr_n75480080)
print v(xbgr.mr_n75480192)
print v(xbgr.mr_n75480512)
print v(xbgr.mr_n75480624)
print v(xbgr.mr_n75480944)
print v(xbgr.mr_n75481056)
print v(xbgr.mr_n75481376)
print v(xbgr.mr_n75481488)
print v(xbgr.mr_n75481808)
print v(xbgr.mr_n75481920)
print v(xbgr.mr_n75482240)
print v(xbgr.mr_n75482352)
print v(xbgr.mr_n75482672)
print v(xbgr.mr_n75482784)
print v(xbgr.mr_n75483104)
print v(xbgr.mr_n75483216)
print v(xbgr.mr_n75483536)
print v(xbgr.mr_n75483648)
print v(xbgr.mr_n75483968)
print v(xbgr.mr_n75484080)
print v(xbgr.mr_n75484400)
print v(xbgr.mr_n75484512)
print v(xbgr.mr_n75484832)
print v(xbgr.mr_n75484944)
print v(xbgr.mr_n75485264)
print v(xbgr.mr_n75485376)
print v(xbgr.mr_n75485696)
print v(xbgr.mr_n75485808)
print v(xbgr.mr_n75486128)
print v(xbgr.mr_n75486240)
print v(xbgr.mr_n75486560)
print v(xbgr.mr_n75486672)
print v(xbgr.mr_n75486992)
print v(xbgr.mr_n75487104)
print v(xbgr.mr_n75487424)
print v(xbgr.mr_n75487536)
print v(xbgr.mr_n75487856)
print v(xbgr.mr_n75487968)
print v(xbgr.mr_n75488288)
print v(xbgr.mr_n75488400)
print v(xbgr.mr_n75488720)
print v(xbgr.mr_n75488832)
print v(xbgr.mr_n75489152)
print v(xbgr.mr_n75489264)
print v(xbgr.mr_n75489584)
print v(xbgr.mr_n75489696)
print v(xbgr.mr_n75490016)
print v(xbgr.mr_n75490128)
print v(xbgr.mr_n75490448)
print v(xbgr.mr_n75490560)
print v(xbgr.mr_n75490880)
print v(xbgr.mr_n75490992)
print v(xbgr.mr_n75491312)
print v(xbgr.mr_n75491424)
print v(xbgr.mr_n75491744)
print v(xbgr.mr_n75491856)
print v(xbgr.mr_n75492176)
print v(xbgr.mr_n75492288)
print v(xbgr.mr_n75492608)
print v(xbgr.mr_n75492720)
print v(xbgr.mr_n75493040)
print v(xbgr.mr_n75493152)
print v(xbgr.mr_n75493472)
print v(xbgr.mr_n75493584)
print v(xbgr.mr_n75493904)
print v(xbgr.mr_n75494016)
print v(xbgr.mr_n75494336)
print v(xbgr.mr_n75494448)
print v(xbgr.mr_n75494768)
print v(xbgr.mr_n75494880)
print v(xbgr.mr_n75495200)
print v(xbgr.mr_n75495312)
print v(xbgr.mr_n75495632)
print v(xbgr.mr_n75495744)
print v(xbgr.mr_n75496064)
print v(xbgr.mr_n75496176)
print v(xbgr.mr_n75496496)
print v(xbgr.mr_n75496608)
print v(xbgr.mr_n75496928)
print v(xbgr.mr_n75497040)
print v(xbgr.mr_n75497360)
print v(xbgr.mr_n75497472)
print v(xbgr.mr_n75497792)
print v(xbgr.mr_n75497904)
print v(xbgr.mr_n75498224)
print v(xbgr.mr_n75498336)
print v(xbgr.mr_n75498656)
print v(xbgr.mr_n75498768)
print v(xbgr.mr_n75499088)
print v(xbgr.mr_n75499200)
print v(xbgr.mr_n75499520)
print v(xbgr.mr_n75499632)
print v(xbgr.mr_n75499952)
print v(xbgr.mr_n75500064)
print v(xbgr.mr_n75500384)
print v(xbgr.mr_n75500496)
print v(xbgr.mr_n75500816)
print v(xbgr.mr_n75500928)
print v(xbgr.mr_n75501248)
print v(xbgr.mr_n75501360)
print v(xbgr.mr_n75501680)
print v(xbgr.mr_n75501792)
print v(xbgr.mr_n75502112)
print v(xbgr.mr_n75502224)
print v(xbgr.mr_n75502544)
print v(xbgr.mr_n75502656)
print v(xbgr.mr_n75502976)
print v(xbgr.mr_n75503088)
print v(xbgr.mr_n75503408)
print v(xbgr.mr_n75503520)
print v(xbgr.mr_n75503840)
print v(xbgr.mr_n75503952)
print v(xbgr.mr_n75504272)
print v(xbgr.mr_n75504384)
print v(xbgr.mr_n75504704)
print v(xbgr.mr_n75504816)
print v(xbgr.mr_n75505136)
print v(xbgr.mr_n75505248)
print v(xbgr.mr_n75505568)
print v(xbgr.mr_n75505680)
print v(xbgr.mr_n75506000)
print v(xbgr.mr_n75506112)
print v(xbgr.mr_n75506432)
print v(xbgr.mr_n75506544)
print v(xbgr.mr_n75506864)
print v(xbgr.mr_n75506976)
print v(xbgr.mr_n75507296)
print v(xbgr.mr_n75507408)
print v(xbgr.mr_n75507728)
print v(xbgr.mr_n75507840)
print v(xbgr.mr_n75508160)
print v(xbgr.mr_n75508272)
print v(xbgr.mr_n75508592)
print v(xbgr.mr_n75508704)
print v(xbgr.mr_n75509024)
print v(xbgr.mr_n75509136)
print v(xbgr.mr_n75509456)
print v(xbgr.mr_n75509568)
print v(xbgr.mr_n75509888)
print v(xbgr.mr_n75510000)
print v(xbgr.mr_n75510320)
print v(xbgr.mr_n75510432)
print v(xbgr.mr_n75510752)
print v(xbgr.mr_n75510864)
print v(xbgr.mr_n75511184)
print v(xbgr.mr_n75511296)
print v(xbgr.mr_n75511616)
print v(xbgr.mr_n75511728)
print v(xbgr.mr_n75512048)
print v(xbgr.mr_n75512160)
print v(xbgr.mr_n75512480)
print v(xbgr.mr_n75512592)
print v(xbgr.mr_n75512912)
print v(xbgr.mr_n75513024)
print v(xbgr.mr_n75513344)
print v(xbgr.mr_n75513456)
print v(xbgr.mr_n75513776)
print v(xbgr.mr_n75513888)
print v(xbgr.mr_n75514208)
print v(xbgr.mr_n75514320)
print v(xbgr.mr_n75514640)
print v(xbgr.mr_n75514752)
print v(xbgr.mr_n75515072)
print v(xbgr.mr_n75515184)
print v(xbgr.mr_n75515504)
print v(xbgr.mr_n75515616)
print v(xbgr.mr_n75515936)
print v(xbgr.mr_n75516048)
print v(xbgr.mr_n75516368)
print v(xbgr.mr_n75516480)
print v(xbgr.mr_n75516800)
print v(xbgr.mr_n75516912)
print v(xbgr.mr_n75517232)
print v(xbgr.mr_n75517344)
print v(xbgr.mr_n75517664)
print v(xbgr.mr_n75517776)
print v(xbgr.mr_n75518096)
print v(xbgr.mr_n75518208)
print v(xbgr.mr_n75518528)
print v(xbgr.mr_n75518640)
print v(xbgr.mr_n75518960)
print v(xbgr.mr_n75519072)
print v(xbgr.mr_n75519392)
print v(xbgr.mr_n75519504)
print v(xbgr.mr_n75519824)
print v(xbgr.mr_n75519936)
print v(xbgr.mr_n75520256)
print v(xbgr.mr_n75520368)
print v(xbgr.mr_n75520688)
print v(xbgr.mr_n75520800)
print v(xbgr.mr_n75521120)
print v(xbgr.mr_n75521232)
print v(xbgr.mr_n75521552)
print v(xbgr.mr_n75521664)
print v(xbgr.mr_n75521984)
print v(xbgr.mr_n75522096)
print v(xbgr.mr_n75522416)
print v(xbgr.mr_n75522528)
print v(xbgr.mr_n75522848)
print v(xbgr.mr_n75522960)
print v(xbgr.mr_n75523280)
print v(xbgr.mr_n75523392)
print v(xbgr.mr_n75523712)
print v(xbgr.mr_n75523824)
print v(xbgr.mr_n75524144)
print v(xbgr.mr_n75524256)
print v(xbgr.mr_n75524576)
print v(xbgr.mr_n75524688)
print v(xbgr.mr_n75525008)
print v(xbgr.mr_n75525120)
print v(xbgr.mr_n75525440)
print v(xbgr.mr_n75525552)
print v(xbgr.mr_n75525872)
print v(xbgr.mr_n75525984)
print v(xbgr.mr_n75526304)
print v(xbgr.mr_n75526416)
print v(xbgr.mr_n75526736)
print v(xbgr.mr_n75526848)
print v(xbgr.mr_n75527168)
print v(xbgr.mr_n75527280)
print v(xbgr.mr_n75527600)
print v(xbgr.mr_n75527712)
print v(xbgr.mr_n75528032)
print v(xbgr.mr_n75528144)
print v(xbgr.mr_n75528464)
print v(xbgr.mr_n75528576)
print v(xbgr.mr_n75528896)
print v(xbgr.mr_n75529008)
print v(xbgr.mr_n75529328)
print v(xbgr.mr_n75529440)
print v(xbgr.mr_n75529760)
print v(xbgr.mr_n75529872)
print v(xbgr.mr_n75530192)
print v(xbgr.mr_n75530304)
print v(xbgr.mr_n75530624)
print v(xbgr.mr_n75530736)
print v(xbgr.mr_n75531056)
print v(xbgr.mr_n75531168)
print v(xbgr.mr_n75531488)
print v(xbgr.mr_n75531600)
print v(xbgr.mr_n75531920)
print v(xbgr.mr_n75532032)
print v(xbgr.mr_n75532352)
print v(xbgr.mr_n75532464)
print v(xbgr.mr_n75532784)
print v(xbgr.mr_n75532896)
print v(xbgr.mr_n75533216)
print v(xbgr.mr_n75533328)
print v(xbgr.mr_n75533648)
print v(xbgr.mr_n75533760)
print v(xbgr.mr_n75534080)
print v(xbgr.mr_n75534192)
print v(xbgr.mr_n75534512)
print v(xbgr.mr_n75534624)
print v(xbgr.mr_n75534944)
print v(xbgr.mr_n75535056)
print v(xbgr.mr_n75535376)
print v(xbgr.mr_n75535488)
print v(xbgr.mr_n75535808)
print v(xbgr.mr_n75535920)
print v(xbgr.mr_n75536240)
print v(xbgr.mr_n75536352)
print v(xbgr.mr_n75536672)
print v(xbgr.mr_n75536784)
print v(xbgr.mr_n75537104)
print v(xbgr.mr_n75537216)
print v(xbgr.mr_n75537536)
print v(xbgr.mr_n75537648)
print v(xbgr.mr_n75537968)
print v(xbgr.mr_n75538080)
print v(xbgr.mr_n75538400)
print v(xbgr.mr_n75538512)
print v(xbgr.mr_n75538832)
print v(xbgr.mr_n75538944)
print v(xbgr.mr_n75539264)
print v(xbgr.mr_n75539376)
print v(xbgr.mr_n75539696)
print v(xbgr.mr_n75539808)
print v(xbgr.mr_n75540128)
print v(xbgr.mr_n75540240)
print v(xbgr.mr_n75540560)
print v(xbgr.mr_n75540672)
print v(xbgr.mr_n75540992)
print v(xbgr.mr_n75541104)
print v(xbgr.mr_n75541424)
print v(xbgr.mr_n75541536)
print v(xbgr.mr_n75541856)
print v(xbgr.mr_n75541968)
print v(xbgr.mr_n75542288)
print v(xbgr.mr_n75542400)
print v(xbgr.mr_n75542720)
print v(xbgr.mr_n75542832)
print v(xbgr.mr_n75543152)
print v(xbgr.mr_n75543264)
print v(xbgr.mr_n75543584)
print v(xbgr.mr_n75543696)
print v(xbgr.mr_n75544016)
print v(xbgr.mr_n75544128)
print v(xbgr.mr_n75544448)
print v(xbgr.mr_n75544560)
print v(xbgr.mr_n75544880)
print v(xbgr.mr_n75544992)
print v(xbgr.mr_n75545312)
print v(xbgr.mr_n75545424)
print v(xbgr.mr_n75545744)
print v(xbgr.mr_n75545856)
print v(xbgr.mr_n75546176)
print v(xbgr.mr_n75546288)
print v(xbgr.mr_n75546608)
print v(xbgr.mr_n75546720)
print v(xbgr.mr_n75547040)
print v(xbgr.mr_n75547152)
print v(xbgr.mr_n75547472)
print v(xbgr.mr_n75547584)
print v(xbgr.mr_n75547904)
print v(xbgr.mr_n75548016)
print v(xbgr.mr_n75548336)
print v(xbgr.mr_n75548448)
print v(xbgr.mr_n75548768)
print v(xbgr.mr_n75548880)
print v(xbgr.mr_n75549200)
print v(xbgr.mr_n75549312)
print v(xbgr.mr_n75549632)
print v(xbgr.mr_n75549744)
print v(xbgr.mr_n75550064)
print v(xbgr.mr_n75550176)
print v(xbgr.mr_n75550496)
print v(xbgr.mr_n75550608)
print v(xbgr.mr_n75550928)
print v(xbgr.mr_n75551040)
print v(xbgr.mr_n75551360)
print v(xbgr.mr_n75551472)
print v(xbgr.mr_n75551792)
print v(xbgr.mr_n75551904)
print v(xbgr.mr_n75552224)
print v(xbgr.mr_n75552336)
print v(xbgr.mr_n75552656)
print v(xbgr.mr_n75552768)
print v(xbgr.mr_n75553088)
print v(xbgr.mr_n75553200)
print v(xbgr.mr_n75553520)
print v(xbgr.mr_n75553632)
print v(xbgr.mr_n75553952)
print v(xbgr.mr_n75554064)
print v(xbgr.mr_n75554384)
print v(xbgr.mr_n75554496)
print v(xbgr.mr_n75554816)
print v(xbgr.mr_n75554928)
print v(xbgr.mr_n75555248)
print v(xbgr.mr_n75555360)
print v(xbgr.mr_n75555680)
print v(xbgr.mr_n75555792)
print v(xbgr.mr_n75556112)
print v(xbgr.mr_n75556224)
print v(xbgr.mr_n75556544)
print v(xbgr.mr_n75556656)
print v(xbgr.mr_n75556976)
print v(xbgr.mr_n75557088)
print v(xbgr.mr_n75557408)
print v(xbgr.mr_n75557520)
print v(xbgr.mr_n75557840)
print v(xbgr.mr_n75557952)
print v(xbgr.mr_n75558272)
print v(xbgr.mr_n75558384)
print v(xbgr.mr_n75558704)
print v(xbgr.mr_n75558816)
print v(xbgr.mr_n75559136)
print v(xbgr.mr_n75559248)
print v(xbgr.mr_n75559568)
print v(xbgr.mr_n75559680)
print v(xbgr.mr_n75560000)
print v(xbgr.mr_n75560112)
print v(xbgr.mr_n75560432)
print v(xbgr.mr_n75560544)
print v(xbgr.mr_n75560864)
print v(xbgr.mr_n75560976)
print v(xbgr.mr_n75561296)
print v(xbgr.mr_n75561408)
print v(xbgr.mr_n75561728)
print v(xbgr.mr_n75561840)
print v(xbgr.mr_n75562160)
print v(xbgr.mr_n75562272)
print v(xbgr.mr_n75562592)
print v(xbgr.mr_n75562704)
print v(xbgr.mr_n75563024)
print v(xbgr.mr_n75563136)
print v(xbgr.mr_n75563456)
print v(xbgr.mr_n75563568)
print v(xbgr.mr_n75563888)
print v(xbgr.mr_n75564000)
print v(xbgr.mr_n75564320)
print v(xbgr.mr_n75564432)
print v(xbgr.mr_n75564752)
print v(xbgr.mr_n75564864)
print v(xbgr.mr_n75565184)
print v(xbgr.mr_n75565296)
print v(xbgr.mr_n75565616)
print v(xbgr.mr_n75565728)
print v(xbgr.mr_n75566048)
print v(xbgr.mr_n75566160)
print v(xbgr.mr_n75566480)
print v(xbgr.mr_n75566592)
print v(xbgr.mr_n75566912)
print v(xbgr.mr_n75567024)
print v(xbgr.mr_n75567344)
print v(xbgr.mr_n75567456)
print v(xbgr.mr_n75567776)
print v(xbgr.mr_n75567888)
print v(xbgr.mr_n75568208)
print v(xbgr.mr_n75568320)
print v(xbgr.mr_n75568640)
print v(xbgr.mr_n75568752)
print v(xbgr.mr_n75569072)
print v(xbgr.mr_n75569184)
print v(xbgr.mr_n75569504)
print v(xbgr.mr_n75569616)
print v(xbgr.mr_n75569936)
print v(xbgr.mr_n75570048)
print v(xbgr.mr_n75570368)
print v(xbgr.mr_n75570480)
print v(xbgr.mr_n75570800)
print v(xbgr.mr_n75570912)
print v(xbgr.mr_n75571232)
print v(xbgr.mr_n75571344)
print v(xbgr.mr_n75571664)
print v(xbgr.mr_n75571776)
print v(xbgr.mr_n75572096)
print v(xbgr.mr_n75572208)
print v(xbgr.mr_n75572528)
print v(xbgr.mr_n75572640)
print v(xbgr.mr_n75572960)
print v(xbgr.mr_n75573072)
print v(xbgr.mr_n75573392)
print v(xbgr.mr_n75573504)
print v(xbgr.mr_n75573824)
print v(xbgr.mr_n75573936)
print v(xbgr.mr_n75574256)
print v(xbgr.mr_n75574368)
print v(xbgr.mr_n75574688)
print v(xbgr.mr_n75574800)
print v(xbgr.mr_n75575120)
print v(xbgr.mr_n75575232)
print v(xbgr.mr_n75575552)
print v(xbgr.mr_n75575664)
print v(xbgr.mr_n75575984)
print v(xbgr.mr_n75576096)
print v(xbgr.mr_n75576416)
print v(xbgr.mr_n75576528)
print v(xbgr.mr_n75576848)
print v(xbgr.mr_n75576960)
print v(xbgr.mr_n75577280)
print v(xbgr.mr_n75577392)
print v(xbgr.mr_n75577712)
print v(xbgr.mr_n75577824)
print v(xbgr.mr_n75578144)
print v(xbgr.mr_n75578256)
print v(xbgr.mr_n75578576)
print v(xbgr.mr_n75578688)
print v(xbgr.mr_n75579008)
print v(xbgr.mr_n75579120)
print v(xbgr.mr_n75579440)
print v(xbgr.mr_n75579552)
print v(xbgr.mr_n75579872)
print v(xbgr.mr_n75579984)
print v(xbgr.mr_n75580304)
print v(xbgr.mr_n75580416)
print v(xbgr.mr_n75580736)
print v(xbgr.mr_n75580848)
print v(xbgr.mr_n75581168)
print v(xbgr.mr_n75581280)
print v(xbgr.mr_n75581600)
print v(xbgr.mr_n75581712)
print v(xbgr.mr_n75582032)
print v(xbgr.mr_n75582144)
print v(xbgr.mr_n75582464)
print v(xbgr.mr_n75582576)
print v(xbgr.mr_n75582896)
print v(xbgr.mr_n75583008)
print v(xbgr.mr_n75583328)
print v(xbgr.mr_n75583440)
print v(xbgr.mr_n75583760)
print v(xbgr.mr_n75583872)
print v(xbgr.mr_n75584192)
print v(xbgr.mr_n75584304)
print v(xbgr.mr_n75584624)
print v(xbgr.mr_n75584736)
print v(xbgr.mr_n75585056)
print v(xbgr.mr_n75585168)
print v(xbgr.mr_n75585488)
print v(xbgr.mr_n75585600)
print v(xbgr.mr_n75585920)
print v(xbgr.mr_n75586032)
print v(xbgr.mr_n75586352)
print v(xbgr.mr_n75586464)
print v(xbgr.mr_n75586784)
print v(xbgr.mr_n75586896)
print v(xbgr.mr_n75587216)
print v(xbgr.mr_n75587328)
print v(xbgr.mr_n75587648)
print v(xbgr.mr_n75587760)
print v(xbgr.mr_n75588080)
print v(xbgr.mr_n75588192)
print v(xbgr.mr_n75588512)
print v(xbgr.mr_n75588624)
print v(xbgr.mr_n75588944)
print v(xbgr.mr_n75589056)
print v(xbgr.mr_n75589376)
print v(xbgr.mr_n75589488)
print v(xbgr.mr_n75589808)
print v(xbgr.mr_n75589920)
print v(xbgr.mr_n75590240)
print v(xbgr.mr_n75590352)
print v(xbgr.mr_n75590672)
print v(xbgr.mr_n75590784)
print v(xbgr.mr_n75591104)
print v(xbgr.mr_n75591216)
print v(xbgr.mr_n75591536)
print v(xbgr.mr_n75591648)
print v(xbgr.mr_n75591968)
print v(xbgr.mr_n75592080)
print v(xbgr.mr_n75592400)
print v(xbgr.mr_n75592512)
print v(xbgr.mr_n75592832)
print v(xbgr.mr_n75592944)
print v(xbgr.mr_n75593264)
print v(xbgr.mr_n75593376)
print v(xbgr.mr_n75593696)
print v(xbgr.mr_n75593808)
print v(xbgr.mr_n75594128)
print v(xbgr.mr_n75594240)
print v(xbgr.mr_n75594560)
print v(xbgr.mr_n75594672)
print v(xbgr.mr_n75594992)
print v(xbgr.mr_n75595104)
print v(xbgr.mr_n75595424)
print v(xbgr.mr_n75595536)
print v(xbgr.mr_n75595856)
print v(xbgr.mr_n75595968)
print v(xbgr.mr_n75596288)
print v(xbgr.mr_n75596400)
print v(xbgr.mr_n75596720)
print v(xbgr.mr_n75596832)
print v(xbgr.mr_n75597152)
print v(xbgr.mr_n75597264)
print v(xbgr.mr_n75597584)
print v(xbgr.mr_n75597696)
print v(xbgr.mr_n75598016)
print v(xbgr.mr_n75598128)
print v(xbgr.mr_n75598448)
print v(xbgr.mr_n75598560)
print v(xbgr.mr_n75598880)
print v(xbgr.mr_n75598992)
print v(xbgr.mr_n75599312)
print v(xbgr.mr_n75599424)
print v(xbgr.mr_n75599744)
print v(xbgr.mr_n75599856)
print v(xbgr.mr_n75600176)
print v(xbgr.mr_n75600288)
print v(xbgr.mr_n75600608)
print v(xbgr.mr_n75600720)
print v(xbgr.mr_n75601040)
print v(xbgr.mr_n75601152)
print v(xbgr.mr_n75601472)
print v(xbgr.mr_n75601584)
print v(xbgr.mr_n75601904)
print v(xbgr.mr_n75602016)
print v(xbgr.mr_n75602336)
print v(xbgr.mr_n75602448)
print v(xbgr.mr_n75602768)
print v(xbgr.mr_n75602880)
print v(xbgr.mr_n75603200)
print v(xbgr.mr_n75603312)
print v(xbgr.mr_n75603632)
print v(xbgr.mr_n75603744)
print v(xbgr.mr_n75604064)
print v(xbgr.mr_n75604176)
print v(xbgr.mr_n75604496)
print v(xbgr.mr_n75604608)
print v(xbgr.mr_n75604928)
print v(xbgr.mr_n75605040)
print v(xbgr.mr_n75605360)
print v(xbgr.mr_n75605472)
print v(xbgr.mr_n75605792)
print v(xbgr.mr_n75605904)
print v(xbgr.mr_n75606224)
print v(xbgr.mr_n75606336)
print v(xbgr.mr_n75606656)
print v(xbgr.mr_n75606768)
print v(xbgr.mr_n75607088)
print v(xbgr.mr_n75607200)
print v(xbgr.mr_n75607520)
print v(xbgr.mr_n75607632)
print v(xbgr.mr_n75607952)
print v(xbgr.mr_n75608064)
print v(xbgr.mr_n75608384)
print v(xbgr.mr_n75608496)
print v(xbgr.mr_n75608816)
print v(xbgr.mr_n75608928)
print v(xbgr.mr_n75609248)
print v(xbgr.mr_n75609360)
print v(xbgr.mr_n75609680)
print v(xbgr.mr_n75609792)
print v(xbgr.mr_n75610112)
print v(xbgr.mr_n75610224)
print v(xbgr.mr_n75610544)
print v(xbgr.mr_n75610656)
print v(xbgr.mr_n75610976)
print v(xbgr.mr_n75611088)
print v(xbgr.mr_n75611408)
print v(xbgr.mr_n75611520)
print v(xbgr.mr_n75611840)
print v(xbgr.mr_n75611952)
print v(xbgr.mr_n75612272)
print v(xbgr.mr_n75612384)
print v(xbgr.mr_n75612704)
print v(xbgr.mr_n75612816)
print v(xbgr.mr_n75613136)
print v(xbgr.mr_n75613248)
print v(xbgr.mr_n75613568)
print v(xbgr.mr_n75613680)
print v(xbgr.mr_n75614000)
print v(xbgr.mr_n75614112)
print v(xbgr.mr_n75614432)
print v(xbgr.mr_n75614544)
print v(xbgr.mr_n75614864)
print v(xbgr.mr_n75614976)
print v(xbgr.mr_n75615296)
print v(xbgr.mr_n75615408)
print v(xbgr.mr_n75615728)
print v(xbgr.mr_n75615840)
print v(xbgr.mr_n75616160)
print v(xbgr.mr_n75616272)
print v(xbgr.mr_n75616592)
print v(xbgr.mr_n75616704)
print v(xbgr.mr_n75617024)
print v(xbgr.mr_n75617136)
print v(xbgr.mr_n75617456)
print v(xbgr.mr_n75617568)
print v(xbgr.mr_n75617888)
print v(xbgr.mr_n75618000)
print v(xbgr.mr_n75618320)
print v(xbgr.mr_n75618432)
print v(xbgr.mr_n75618752)
print v(xbgr.mr_n75618864)
print v(xbgr.mr_n75619184)
print v(xbgr.mr_n75619296)
print v(xbgr.mr_n75619616)
print v(xbgr.mr_n75619728)
print v(xbgr.mr_n75620048)
print v(xbgr.mr_n75620160)
print v(xbgr.mr_n75620480)
print v(xbgr.mr_n75620592)
print v(xbgr.mr_n75620912)
print v(xbgr.mr_n75621024)
print v(xbgr.mr_n75621344)
print v(xbgr.mr_n75621456)
print v(xbgr.mr_n75621776)
print v(xbgr.mr_n75621888)
print v(xbgr.mr_n75622208)
print v(xbgr.mr_n75622320)
print v(xbgr.mr_n75622640)
print v(xbgr.mr_n75622752)
print v(xbgr.mr_n75623072)
print v(xbgr.mr_n75623184)
print v(xbgr.mr_n75623504)
print v(xbgr.mr_n75623616)
print v(xbgr.mr_n75623936)
print v(xbgr.mr_n75624048)
print v(xbgr.mr_n75624352)
print v(xbgr.mr_n75624464)
print v(xbgr.mr_n75624784)
print v(xbgr.mr_n75624896)
print v(xbgr.mr_n75625216)
print v(xbgr.mr_n75625328)
print v(xbgr.mr_n75625648)
print v(xbgr.mr_n75625760)
print v(xbgr.mr_n75626080)
print v(xbgr.mr_n75626192)
print v(xbgr.mr_n75626512)
print v(xbgr.mr_n75626624)
print v(xbgr.mr_n75626944)
print v(xbgr.mr_n75627056)
print v(xbgr.mr_n75627376)
print v(xbgr.mr_n75627488)
print v(xbgr.mr_n75627808)
print v(xbgr.mr_n75627920)
print v(xbgr.mr_n75628240)
print v(xbgr.mr_n75628352)
print v(xbgr.mr_n75628672)
print v(xbgr.mr_n75628784)
print v(xbgr.mr_n75629104)
print v(xbgr.mr_n75629216)
print v(xbgr.mr_n75629536)
print v(xbgr.mr_n75629648)
print v(xbgr.mr_n75629968)
print v(xbgr.mr_n75630080)
print v(xbgr.mr_n75630400)
print v(xbgr.mr_n75630512)
print v(xbgr.mr_n75630832)
print v(xbgr.mr_n75630944)
print v(xbgr.mr_n75631264)
print v(xbgr.mr_n75631376)
print v(xbgr.mr_n75631696)
print v(xbgr.mr_n75631808)
print v(xbgr.mr_n75632128)
print v(xbgr.mr_n75632240)
print v(xbgr.mr_n75632560)
print v(xbgr.mr_n75632672)
print v(xbgr.mr_n75632992)
print v(xbgr.mr_n75633104)
print v(xbgr.mr_n75633424)
print v(xbgr.mr_n75633536)
print v(xbgr.mr_n75633856)
print v(xbgr.mr_n75633968)
print v(xbgr.mr_n75634288)
print v(xbgr.mr_n75634400)
print v(xbgr.mr_n75634720)
print v(xbgr.mr_n75634832)
print v(xbgr.mr_n75635152)
print v(xbgr.mr_n75635264)
print v(xbgr.mr_n75635584)
print v(xbgr.mr_n75635696)
print v(xbgr.mr_n75636016)
print v(xbgr.mr_n75636128)
print v(xbgr.mr_n75636448)
print v(xbgr.mr_n75636560)
print v(xbgr.mr_n75636880)
print v(xbgr.mr_n75636992)
print v(xbgr.mr_n75637312)
print v(xbgr.mr_n75637424)
print v(xbgr.mr_n75637744)
print v(xbgr.mr_n75637856)
print v(xbgr.mr_n75638176)
print v(xbgr.mr_n75638288)
print v(xbgr.mr_n75638608)
print v(xbgr.mr_n75638720)
print v(xbgr.mr_n75639040)
print v(xbgr.mr_n75639152)
print v(xbgr.mr_n75639472)
print v(xbgr.mr_n75639584)
print v(xbgr.mr_n75639904)
print v(xbgr.mr_n75640016)
print v(xbgr.mr_n75640336)
print v(xbgr.mr_n75640448)
print v(xbgr.mr_n75640768)
print v(xbgr.mr_n75640880)
print v(xbgr.mr_n75641200)
print v(xbgr.mr_n75641312)
print v(xbgr.mr_n75641632)
print v(xbgr.mr_n75641744)
print v(xbgr.mr_n75642064)
print v(xbgr.mr_n75642176)
print v(xbgr.mr_n75642496)
print v(xbgr.mr_n75642608)
print v(xbgr.mr_n75642928)
print v(xbgr.mr_n75643040)
print v(xbgr.mr_n75643360)
print v(xbgr.mr_n75643472)
print v(xbgr.mr_n75643792)
print v(xbgr.mr_n75643904)
print v(xbgr.mr_n75644224)
print v(xbgr.mr_n75644336)
print v(xbgr.mr_n75644656)
print v(xbgr.mr_n75644768)
print v(xbgr.mr_n75645088)
print v(xbgr.mr_n75645200)
print v(xbgr.mr_n75645520)
print v(xbgr.mr_n75645632)
print v(xbgr.mr_n75645952)
print v(xbgr.mr_n75646064)
print v(xbgr.mr_n75646384)
print v(xbgr.mr_n75646496)
print v(xbgr.mr_n75646816)
print v(xbgr.mr_n75646928)
print v(xbgr.mr_n75647248)
print v(xbgr.mr_n75647360)
print v(xbgr.mr_n75647680)
print v(xbgr.mr_n75647792)
print v(xbgr.mr_n75648112)
print v(xbgr.mr_n75648224)
print v(xbgr.mr_n75648544)
print v(xbgr.mr_n75648656)
print v(xbgr.mr_n75648976)
print v(xbgr.mr_n75649088)
print v(xbgr.mr_n75649408)
print v(xbgr.mr_n75649520)
print v(xbgr.mr_n75649840)
print v(xbgr.mr_n75649952)
print v(xbgr.mr_n75650272)
print v(xbgr.mr_n75650384)
print v(xbgr.mr_n75650704)
print v(xbgr.mr_n75650816)
print v(xbgr.mr_n75651136)
print v(xbgr.mr_n75651248)
print v(xbgr.mr_n75651568)
print v(xbgr.mr_n75651680)
print v(xbgr.mr_n75652000)
print v(xbgr.mr_n75652112)
print v(xbgr.mr_n75652432)
print v(xbgr.mr_n75652544)
print v(xbgr.mr_n75652864)
print v(xbgr.mr_n75652976)
print v(xbgr.mr_n75653296)
print v(xbgr.mr_n75653408)
print v(xbgr.mr_n75653728)
print v(xbgr.mr_n75653840)
print v(xbgr.mr_n75654160)
print v(xbgr.mr_n75654272)
print v(xbgr.mr_n75654592)
print v(xbgr.mr_n75654704)
print v(xbgr.mr_n75655024)
print v(xbgr.mr_n75655136)
print v(xbgr.mr_n75655456)
print v(xbgr.mr_n75655568)
print v(xbgr.mr_n75655888)
print v(xbgr.mr_n75656000)
print v(xbgr.mr_n75656320)
print v(xbgr.mr_n75656432)
print v(xbgr.mr_n75656752)
print v(xbgr.mr_n75656864)
print v(xbgr.mr_n75657184)
print v(xbgr.mr_n75657296)
print v(xbgr.mr_n75657616)
print v(xbgr.mr_n75657728)
print v(xbgr.mr_n75658048)
print v(xbgr.mr_n75658160)
print v(xbgr.mr_n75658480)
print v(xbgr.mr_n75658592)
print v(xbgr.mr_n75658912)
print v(xbgr.mr_n75659024)
print v(xbgr.mr_n75659344)
print v(xbgr.mr_n75659456)
print v(xbgr.mr_n75659776)
print v(xbgr.mr_n75659888)
print v(xbgr.mr_n75660208)
print v(xbgr.mr_n75660320)
print v(xbgr.mr_n75660640)
print v(xbgr.mr_n75660752)
print v(xbgr.mr_n75661072)
print v(xbgr.mr_n75661184)
print v(xbgr.mr_n75661504)
print v(xbgr.mr_n75661616)
print v(xbgr.mr_n75661936)
print v(xbgr.mr_n75662048)
print v(xbgr.mr_n75662368)
print v(xbgr.mr_n75662480)
print v(xbgr.mr_n75662800)
print v(xbgr.mr_n75662912)
print v(xbgr.mr_n75663232)
print v(xbgr.mr_n75663344)
print v(xbgr.mr_n75663664)
print v(xbgr.mr_n75663776)
print v(xbgr.mr_n75664096)
print v(xbgr.mr_n75664208)
print v(xbgr.mr_n75664528)
print v(xbgr.mr_n75664640)
print v(xbgr.mr_n75664960)
print v(xbgr.mr_n75665072)
print v(xbgr.mr_n75665392)
print v(xbgr.mr_n75665504)
print v(xbgr.mr_n75665824)
print v(xbgr.mr_n75665936)
print v(xbgr.mr_n75666256)
print v(xbgr.mr_n75666368)
print v(xbgr.mr_n75666688)
print v(xbgr.mr_n75666800)
print v(xbgr.mr_n75667120)
print v(xbgr.mr_n75667232)
print v(xbgr.mr_n75667552)
print v(xbgr.mr_n75667664)
print v(xbgr.mr_n75667984)
print v(xbgr.mr_n75668096)
print v(xbgr.mr_n75668416)
print v(xbgr.mr_n75668528)
print v(xbgr.mr_n75668848)
print v(xbgr.mr_n75668960)
print v(xbgr.mr_n75669280)
print v(xbgr.mr_n75669392)
print v(xbgr.mr_n75669712)
print v(xbgr.mr_n75669824)
print v(xbgr.mr_n75670144)
print v(xbgr.mr_n75670256)
print v(xbgr.mr_n75670576)
print v(xbgr.mr_n75670688)
print v(xbgr.mr_n75671008)
print v(xbgr.mr_n75671120)
print v(xbgr.mr_n75671440)
print v(xbgr.mr_n75671552)
print v(xbgr.mr_n75671872)
print v(xbgr.mr_n75671984)
print v(xbgr.mr_n75672304)
print v(xbgr.mr_n75672416)
print v(xbgr.mr_n75672736)
print v(xbgr.mr_n75672848)
print v(xbgr.mr_n75673168)
print v(xbgr.mr_n75673280)
print v(xbgr.mr_n75673600)
print v(xbgr.mr_n75673712)
print v(xbgr.mr_n75674032)
print v(xbgr.mr_n75674144)
print v(xbgr.mr_n75674464)
print v(xbgr.mr_n75674576)
print v(xbgr.mr_n75674896)
print v(xbgr.mr_n75675008)
print v(xbgr.mr_n75675328)
print v(xbgr.mr_n75675440)
print v(xbgr.mr_n75675760)
print v(xbgr.mr_n75675872)
print v(xbgr.mr_n75676192)
print v(xbgr.mr_n75676304)
print v(xbgr.mr_n75676624)
print v(xbgr.mr_n75676736)
print v(xbgr.mr_n75677056)
print v(xbgr.mr_n75677168)
print v(xbgr.mr_n75677488)
print v(xbgr.mr_n75677600)
print v(xbgr.mr_n75677920)
print v(xbgr.mr_n75678032)
print v(xbgr.mr_n75678352)
print v(xbgr.mr_n75678464)
print v(xbgr.mr_n75678784)
print v(xbgr.mr_n75678896)
print v(xbgr.mr_n75679216)
print v(xbgr.mr_n75679328)
print v(xbgr.mr_n75679648)
print v(xbgr.mr_n75679760)
print v(xbgr.mr_n75680080)
print v(xbgr.mr_n75680192)
print v(xbgr.mr_n75680512)
print v(xbgr.mr_n75680624)
print v(xbgr.mr_n75680944)
print v(xbgr.mr_n75681056)
print v(xbgr.mr_n75681376)
print v(xbgr.mr_n75681488)
print v(xbgr.mr_n75681808)
print v(xbgr.mr_n75681920)
print v(xbgr.mr_n75682240)
print v(xbgr.mr_n75682352)
print v(xbgr.mr_n75682672)
print v(xbgr.mr_n75682784)
print v(xbgr.mr_n75683104)
print v(xbgr.mr_n75683216)
print v(xbgr.mr_n75683536)
print v(xbgr.mr_n75683648)
print v(xbgr.mr_n75683968)
print v(xbgr.mr_n75684080)
print v(xbgr.mr_n75684400)
print v(xbgr.mr_n75684512)
print v(xbgr.mr_n75684832)
print v(xbgr.mr_n75684944)
print v(xbgr.mr_n75685264)
print v(xbgr.mr_n75685376)
print v(xbgr.mr_n75685696)
print v(xbgr.mr_n75685808)
print v(xbgr.mr_n75686128)
print v(xbgr.mr_n75686240)
print v(xbgr.mr_n75686560)
print v(xbgr.mr_n75686672)
print v(xbgr.mr_n75686992)
print v(xbgr.mr_n75687104)
print v(xbgr.mr_n75687424)
print v(xbgr.mr_n75687536)
print v(xbgr.mr_n75687856)
print v(xbgr.mr_n75687968)
print v(xbgr.mr_n75688288)
print v(xbgr.mr_n75688400)
print v(xbgr.mr_n75688720)
print v(xbgr.mr_n75688832)
print v(xbgr.mr_n75689152)
print v(xbgr.mr_n75689264)
print v(xbgr.mr_n75689584)
print v(xbgr.mr_n75689696)
print v(xbgr.mr_n75690016)
print v(xbgr.mr_n75690128)
print v(xbgr.mr_n75690448)
print v(xbgr.mr_n75690560)
print v(xbgr.mr_n75690880)
print v(xbgr.mr_n75690992)
print v(xbgr.mr_n75691312)
print v(xbgr.mr_n75691424)
print v(xbgr.mr_n75691744)
print v(xbgr.mr_n75691856)
print v(xbgr.mr_n75692176)
print v(xbgr.mr_n75692288)
print v(xbgr.mr_n75692608)
print v(xbgr.mr_n75692720)
print v(xbgr.mr_n75693040)
print v(xbgr.mr_n75693152)
print v(xbgr.mr_n75693472)
print v(xbgr.mr_n75693584)
print v(xbgr.mr_n75693904)
print v(xbgr.mr_n75694016)
print v(xbgr.mr_n75694336)
print v(xbgr.mr_n75694448)
print v(xbgr.mr_n75694768)
print v(xbgr.mr_n75694880)
print v(xbgr.mr_n75695200)
print v(xbgr.mr_n75695312)
print v(xbgr.mr_n75695632)
print v(xbgr.mr_n75695744)
print v(xbgr.mr_n75696064)
print v(xbgr.mr_n75696176)
print v(xbgr.mr_n75696496)
print v(xbgr.mr_n75696608)
print v(xbgr.mr_n75696928)
print v(xbgr.mr_n75697040)
print v(xbgr.mr_n75697360)
print v(xbgr.mr_n75697472)
print v(xbgr.mr_n75697792)
print v(xbgr.mr_n75697904)
print v(xbgr.mr_n75698224)
print v(xbgr.mr_n75698336)
print v(xbgr.mr_n75698656)
print v(xbgr.mr_n75698768)
print v(xbgr.mr_n75699088)
print v(xbgr.mr_n75699200)
print v(xbgr.mr_n75699520)
print v(xbgr.mr_n75699632)
print v(xbgr.mr_n75699952)
print v(xbgr.mr_n75700064)
print v(xbgr.mr_n75700384)
print v(xbgr.mr_n75700496)
print v(xbgr.mr_n75700816)
print v(xbgr.mr_n75700928)
print v(xbgr.mr_n75701248)
print v(xbgr.mr_n75701360)
print v(xbgr.mr_n75701680)
print v(xbgr.mr_n75701792)
print v(xbgr.mr_n75702112)
print v(xbgr.mr_n75702224)
print v(xbgr.mr_n75702544)
print v(xbgr.mr_n75702656)
print v(xbgr.mr_n75702976)
print v(xbgr.mr_n75703088)
print v(xbgr.mr_n75703408)
print v(xbgr.mr_n75703520)
print v(xbgr.mr_n75703840)
print v(xbgr.mr_n75703952)
print v(xbgr.mr_n75704272)
print v(xbgr.mr_n75704384)
print v(xbgr.mr_n75704704)
print v(xbgr.mr_n75704816)
print v(xbgr.mr_n75705136)
print v(xbgr.mr_n75705248)
print v(xbgr.mr_n75705568)
print v(xbgr.mr_n75705680)
print v(xbgr.mr_n75706000)
print v(xbgr.mr_n75706112)
print v(xbgr.mr_n75706432)
print v(xbgr.mr_n75706544)
print v(xbgr.mr_n75706864)
print v(xbgr.mr_n75706976)
print v(xbgr.mr_n75707296)
print v(xbgr.mr_n75707408)
print v(xbgr.mr_n75707728)
print v(xbgr.mr_n75707840)
print v(xbgr.mr_n75708160)
print v(xbgr.mr_n75708272)
print v(xbgr.mr_n75708592)
print v(xbgr.mr_n75708704)
print v(xbgr.mr_n75709024)
print v(xbgr.mr_n75709136)
print v(xbgr.mr_n75709456)
print v(xbgr.mr_n75709568)
print v(xbgr.mr_n75709888)
print v(xbgr.mr_n75710000)
print v(xbgr.mr_n75710320)
print v(xbgr.mr_n75710432)
print v(xbgr.mr_n75710752)
print v(xbgr.mr_n75710864)
print v(xbgr.mr_n75711184)
print v(xbgr.mr_n75711296)
print v(xbgr.mr_n75711616)
print v(xbgr.mr_n75711728)
print v(xbgr.mr_n75712048)
print v(xbgr.mr_n75712160)
print v(xbgr.mr_n75712480)
print v(xbgr.mr_n75712592)
print v(xbgr.mr_n75712912)
print v(xbgr.mr_n75713024)
print v(xbgr.mr_n75713344)
print v(xbgr.mr_n75713456)
print v(xbgr.mr_n75713776)
print v(xbgr.mr_n75713888)
print v(xbgr.mr_n75714208)
print v(xbgr.mr_n75714320)
print v(xbgr.mr_n75714640)
print v(xbgr.mr_n75714752)
print v(xbgr.mr_n75715072)
print v(xbgr.mr_n75715184)
print v(xbgr.mr_n75715504)
print v(xbgr.mr_n75715616)
print v(xbgr.mr_n75715936)
print v(xbgr.mr_n75716048)
print v(xbgr.mr_n75716368)
print v(xbgr.mr_n75716480)
print v(xbgr.mr_n75716800)
print v(xbgr.mr_n75716912)
print v(xbgr.mr_n75717232)
print v(xbgr.mr_n75717344)
print v(xbgr.mr_n75717664)
print v(xbgr.mr_n75717776)
print v(xbgr.mr_n75718096)
print v(xbgr.mr_n75718208)
print v(xbgr.mr_n75718528)
print v(xbgr.mr_n75718640)
print v(xbgr.mr_n75718960)
print v(xbgr.mr_n75719072)
print v(xbgr.mr_n75719392)
print v(xbgr.mr_n75719504)
print v(xbgr.mr_n75719824)
print v(xbgr.mr_n75719936)
print v(xbgr.mr_n75720256)
print v(xbgr.mr_n75720368)
print v(xbgr.mr_n75720688)
print v(xbgr.mr_n75720800)
print v(xbgr.mr_n75721120)
print v(xbgr.mr_n75721232)
print v(xbgr.mr_n75721552)
print v(xbgr.mr_n75721664)
print v(xbgr.mr_n75721984)
print v(xbgr.mr_n75722096)
print v(xbgr.mr_n75722416)
print v(xbgr.mr_n75722528)
print v(xbgr.mr_n75722848)
print v(xbgr.mr_n75722960)
print v(xbgr.mr_n75723280)
print v(xbgr.mr_n75723392)
print v(xbgr.mr_n75723712)
print v(xbgr.mr_n75723824)
print v(xbgr.mr_n75724144)
print v(xbgr.mr_n75724256)
print v(xbgr.mr_n75724576)
print v(xbgr.mr_n75724688)
print v(xbgr.mr_n75725008)
print v(xbgr.mr_n75725120)
print v(xbgr.mr_n75725440)
print v(xbgr.mr_n75725552)
print v(xbgr.mr_n75725872)
print v(xbgr.mr_n75725984)
print v(xbgr.mr_n75726304)
print v(xbgr.mr_n75726416)
print v(xbgr.mr_n75726736)
print v(xbgr.mr_n75726848)
print v(xbgr.mr_n75727168)
print v(xbgr.mr_n75727280)
print v(xbgr.mr_n75727600)
print v(xbgr.mr_n75727712)
print v(xbgr.mr_n75728032)
print v(xbgr.mr_n75728144)
print v(xbgr.mr_n75728464)
print v(xbgr.mr_n75728576)
print v(xbgr.mr_n75728896)
print v(xbgr.mr_n75729008)
print v(xbgr.mr_n75729328)
print v(xbgr.mr_n75729440)
print v(xbgr.mr_n75729760)
print v(xbgr.mr_n75729872)
print v(xbgr.mr_n75730192)
print v(xbgr.mr_n75730304)
print v(xbgr.mr_n75730624)
print v(xbgr.mr_n75730736)
print v(xbgr.mr_n75731056)
print v(xbgr.mr_n75731168)
print v(xbgr.mr_n75731488)
print v(xbgr.mr_n75731600)
print v(xbgr.mr_n75731920)
print v(xbgr.mr_n75732032)
print v(xbgr.mr_n75732352)
print v(xbgr.mr_n75732464)
print v(xbgr.mr_n75732784)
print v(xbgr.mr_n75732896)
print v(xbgr.mr_n75733216)
print v(xbgr.mr_n75733328)
print v(xbgr.mr_n75733648)
print v(xbgr.mr_n75733760)
print v(xbgr.mr_n75734080)
print v(xbgr.mr_n75734192)
print v(xbgr.mr_n75734512)
print v(xbgr.mr_n75734624)
print v(xbgr.mr_n75734944)
print v(xbgr.mr_n75735056)
print v(xbgr.mr_n75735376)
print v(xbgr.mr_n75735488)
print v(xbgr.mr_n75735808)
print v(xbgr.mr_n75735920)
print v(xbgr.mr_n75736240)
print v(xbgr.mr_n75736352)
print v(xbgr.mr_n75736672)
print v(xbgr.mr_n75736784)
print v(xbgr.mr_n75737104)
print v(xbgr.mr_n75737216)
print v(xbgr.mr_n75737536)
print v(xbgr.mr_n75737648)
print v(xbgr.mr_n75737968)
print v(xbgr.mr_n75738080)
print v(xbgr.mr_n75738400)
print v(xbgr.mr_n75738512)
print v(xbgr.mr_n75738832)
print v(xbgr.mr_n75738944)
print v(xbgr.mr_n75739264)
print v(xbgr.mr_n75739376)
print v(xbgr.mr_n75739696)
print v(xbgr.mr_n75739808)
print v(xbgr.mr_n75740128)
print v(xbgr.mr_n75740240)
print v(xbgr.mr_n75740560)
print v(xbgr.mr_n75740672)
print v(xbgr.mr_n75740992)
print v(xbgr.mr_n75741104)
print v(xbgr.mr_n75741424)
print v(xbgr.mr_n75741536)
print v(xbgr.mr_n75741856)
print v(xbgr.mr_n75741968)
print v(xbgr.mr_n75742288)
print v(xbgr.mr_n75742400)
print v(xbgr.mr_n75742720)
print v(xbgr.mr_n75742832)
print v(xbgr.mr_n75743152)
print v(xbgr.mr_n75743264)
print v(xbgr.mr_n75743584)
print v(xbgr.mr_n75743696)
print v(xbgr.mr_n75744016)
print v(xbgr.mr_n75744128)
print v(xbgr.mr_n75744448)
print v(xbgr.mr_n75744560)
print v(xbgr.mr_n75744880)
print v(xbgr.mr_n75744992)
print v(xbgr.mr_n75745312)
print v(xbgr.mr_n75745424)
print v(xbgr.mr_n75745744)
print v(xbgr.mr_n75745856)
print v(xbgr.mr_n75746176)
print v(xbgr.mr_n75746288)
print v(xbgr.mr_n75746608)
print v(xbgr.mr_n75746720)
print v(xbgr.mr_n75747040)
print v(xbgr.mr_n75747152)
print v(xbgr.mr_n75747472)
print v(xbgr.mr_n75747584)
print v(xbgr.mr_n75747904)
print v(xbgr.mr_n75748016)
print v(xbgr.mr_n75748336)
print v(xbgr.mr_n75748448)
print v(xbgr.mr_n75748768)
print v(xbgr.mr_n75748880)
print v(xbgr.mr_n75749200)
print v(xbgr.mr_n75749312)
print v(xbgr.mr_n75749632)
print v(xbgr.mr_n75749744)
print v(xbgr.mr_n75750064)
print v(xbgr.mr_n75750176)
print v(xbgr.mr_n75750496)
print v(xbgr.mr_n75750608)
print v(xbgr.mr_n75750928)
print v(xbgr.mr_n75751040)
print v(xbgr.mr_n75751360)
print v(xbgr.mr_n75751472)
print v(xbgr.mr_n75751792)
print v(xbgr.mr_n75751904)
print v(xbgr.mr_n75752224)
print v(xbgr.mr_n75752336)
print v(xbgr.mr_n75752656)
print v(xbgr.mr_n75752768)
print v(xbgr.mr_n75753088)
print v(xbgr.mr_n75753200)
print v(xbgr.mr_n75753520)
print v(xbgr.mr_n75753632)
print v(xbgr.mr_n75753952)
print v(xbgr.mr_n75754064)
print v(xbgr.mr_n75754384)
print v(xbgr.mr_n75754496)
print v(xbgr.mr_n75754816)
print v(xbgr.mr_n75754928)
print v(xbgr.mr_n75755248)
print v(xbgr.mr_n75755360)
print v(xbgr.mr_n75755680)
print v(xbgr.mr_n75755792)
print v(xbgr.mr_n75756112)
print v(xbgr.mr_n75756224)
print v(xbgr.mr_n75756544)
print v(xbgr.mr_n75756656)
print v(xbgr.mr_n75756976)
print v(xbgr.mr_n75757088)
print v(xbgr.mr_n75757408)
print v(xbgr.mr_n75757520)
print v(xbgr.mr_n75757840)
print v(xbgr.mr_n75757952)
print v(xbgr.mr_n75758272)
print v(xbgr.mr_n75758384)
print v(xbgr.mr_n75758704)
print v(xbgr.mr_n75758816)
print v(xbgr.mr_n75759136)
print v(xbgr.mr_n75759248)
print v(xbgr.mr_n75759568)
print v(xbgr.mr_n75759680)
print v(xbgr.mr_n75760000)
print v(xbgr.mr_n75760112)
print v(xbgr.mr_n75760432)
print v(xbgr.mr_n75760544)
print v(xbgr.mr_n75760864)
print v(xbgr.mr_n75760976)
print v(xbgr.mr_n75761296)
print v(xbgr.mr_n75761408)
print v(xbgr.mr_n75761728)
print v(xbgr.mr_n75761840)
print v(xbgr.mr_n75762160)
print v(xbgr.mr_n75762272)
print v(xbgr.mr_n75762592)
print v(xbgr.mr_n75762704)
print v(xbgr.mr_n75763024)
print v(xbgr.mr_n75763136)
print v(xbgr.mr_n75763456)
print v(xbgr.mr_n75763568)
print v(xbgr.mr_n75763888)
print v(xbgr.mr_n75764000)
print v(xbgr.mr_n75764320)
print v(xbgr.mr_n75764432)
print v(xbgr.mr_n75764752)
print v(xbgr.mr_n75764864)
print v(xbgr.mr_n75765184)
print v(xbgr.mr_n75765296)
print v(xbgr.mr_n75765616)
print v(xbgr.mr_n75765728)
print v(xbgr.mr_n75766048)
print v(xbgr.mr_n75766160)
print v(xbgr.mr_n75766480)
print v(xbgr.mr_n75766592)
print v(xbgr.mr_n75766912)
print v(xbgr.mr_n75767024)
print v(xbgr.mr_n75767344)
print v(xbgr.mr_n75767456)
print v(xbgr.mr_n75767776)
print v(xbgr.mr_n75767888)
print v(xbgr.mr_n75768208)
print v(xbgr.mr_n75768320)
print v(xbgr.mr_n75768640)
print v(xbgr.mr_n75768752)
print v(xbgr.mr_n75769072)
print v(xbgr.mr_n75769184)
print v(xbgr.mr_n75769504)
print v(xbgr.mr_n75769616)
print v(xbgr.mr_n75769936)
print v(xbgr.mr_n75770048)
print v(xbgr.mr_n75770368)
print v(xbgr.mr_n75770480)
print v(xbgr.mr_n75770800)
print v(xbgr.mr_n75770912)
print v(xbgr.mr_n75771232)
print v(xbgr.mr_n75771344)
print v(xbgr.mr_n75771664)
print v(xbgr.mr_n75771776)
print v(xbgr.mr_n75772096)
print v(xbgr.mr_n75772208)
print v(xbgr.mr_n75772528)
print v(xbgr.mr_n75772640)
print v(xbgr.mr_n75772960)
print v(xbgr.mr_n75773072)
print v(xbgr.mr_n75773392)
print v(xbgr.mr_n75773504)
print v(xbgr.mr_n75773824)
print v(xbgr.mr_n75773936)
print v(xbgr.mr_n75774256)
print v(xbgr.mr_n75774368)
print v(xbgr.mr_n75774688)
print v(xbgr.mr_n75774800)
print v(xbgr.mr_n75775120)
print v(xbgr.mr_n75775232)
print v(xbgr.mr_n75775552)
print v(xbgr.mr_n75775664)
print v(xbgr.mr_n75775984)
print v(xbgr.mr_n75776096)
print v(xbgr.mr_n75776416)
print v(xbgr.mr_n75776528)
print v(xbgr.mr_n75776848)
print v(xbgr.mr_n75776960)
print v(xbgr.mr_n75777280)
print v(xbgr.mr_n75777392)
print v(xbgr.mr_n75777712)
print v(xbgr.mr_n75777824)
print v(xbgr.mr_n75778144)
print v(xbgr.mr_n75778256)
print v(xbgr.mr_n75778576)
print v(xbgr.mr_n75778688)
print v(xbgr.mr_n75779008)
print v(xbgr.mr_n75779120)
print v(xbgr.mr_n75779440)
print v(xbgr.mr_n75779552)
print v(xbgr.mr_n75779872)
print v(xbgr.mr_n75779984)
print v(xbgr.mr_n75780304)
print v(xbgr.mr_n75780416)
print v(xbgr.mr_n75780736)
print v(xbgr.mr_n75780848)
print v(xbgr.mr_n75781168)
print v(xbgr.mr_n75781280)
print v(xbgr.mr_n75781600)
print v(xbgr.mr_n75781712)
print v(xbgr.mr_n75782032)
print v(xbgr.mr_n75782144)
print v(xbgr.mr_n75782464)
print v(xbgr.mr_n75782576)
print v(xbgr.mr_n75782896)
print v(xbgr.mr_n75783008)
print v(xbgr.mr_n75783328)
print v(xbgr.mr_n75783440)
print v(xbgr.mr_n75783760)
print v(xbgr.mr_n75783872)
print v(xbgr.mr_n75784192)
print v(xbgr.mr_n75784304)
print v(xbgr.mr_n75784624)
print v(xbgr.mr_n75784736)
print v(xbgr.mr_n75785056)
print v(xbgr.mr_n75785168)
print v(xbgr.mr_n75785488)
print v(xbgr.mr_n75785600)
print v(xbgr.mr_n75785920)
print v(xbgr.mr_n75786032)
print v(xbgr.mr_n75786352)
print v(xbgr.mr_n75786464)
print v(xbgr.mr_n75786784)
print v(xbgr.mr_n75786896)
print v(xbgr.mr_n75787216)
print v(xbgr.mr_n75787328)
print v(xbgr.mr_n75787648)
print v(xbgr.mr_n75787760)
print v(xbgr.mr_n75788080)
print v(xbgr.mr_n75788192)
print v(xbgr.mr_n75788512)
print v(xbgr.mr_n75788624)
print v(xbgr.mr_n75788944)
print v(xbgr.mr_n75789056)
print v(xbgr.mr_n75789376)
print v(xbgr.mr_n75789488)
print v(xbgr.mr_n75789808)
print v(xbgr.mr_n75789920)
print v(xbgr.mr_n75790240)
print v(xbgr.mr_n75790352)
print v(xbgr.mr_n75790672)
print v(xbgr.mr_n75790784)
print v(xbgr.mr_n75791104)
print v(xbgr.mr_n75791216)
print v(xbgr.mr_n75791536)
print v(xbgr.mr_n75791648)
print v(xbgr.mr_n75791968)
print v(xbgr.mr_n75792080)
print v(xbgr.mr_n75792400)
print v(xbgr.mr_n75792512)
print v(xbgr.mr_n75792832)
print v(xbgr.mr_n75792944)
print v(xbgr.mr_n75793264)
print v(xbgr.mr_n75793376)
print v(xbgr.mr_n75793696)
print v(xbgr.mr_n75793808)
print v(xbgr.mr_n75794128)
print v(xbgr.mr_n75794240)
print v(xbgr.mr_n75794560)
print v(xbgr.mr_n75794672)
print v(xbgr.mr_n75794992)
print v(xbgr.mr_n75795104)
print v(xbgr.mr_n75795424)
print v(xbgr.mr_n75795536)
print v(xbgr.mr_n75795856)
print v(xbgr.mr_n75795968)
print v(xbgr.mr_n75796288)
print v(xbgr.mr_n75796400)
print v(xbgr.mr_n75796720)
print v(xbgr.mr_n75796832)
print v(xbgr.mr_n75797152)
print v(xbgr.mr_n75797264)
print v(xbgr.mr_n75797584)
print v(xbgr.mr_n75797696)
print v(xbgr.mr_n75798016)
print v(xbgr.mr_n75798128)
print v(xbgr.mr_n75798448)
print v(xbgr.mr_n75798560)
print v(xbgr.mr_n75798880)
print v(xbgr.mr_n75798992)
print v(xbgr.mr_n75799312)
print v(xbgr.mr_n75799424)
print v(xbgr.mr_n75799744)
print v(xbgr.mr_n75799856)
print v(xbgr.mr_n75800176)
print v(xbgr.mr_n75800288)
print v(xbgr.mr_n75800608)
print v(xbgr.mr_n75800720)
print v(xbgr.mr_n75801040)
print v(xbgr.mr_n75801152)
print v(xbgr.mr_n75801472)
print v(xbgr.mr_n75801584)
print v(xbgr.mr_n75801904)
print v(xbgr.mr_n75802016)
print v(xbgr.mr_n75802336)
print v(xbgr.mr_n75802448)
print v(xbgr.mr_n75802768)
print v(xbgr.mr_n75802880)
print v(xbgr.mr_n75803200)
print v(xbgr.mr_n75803312)
print v(xbgr.mr_n75803632)
print v(xbgr.mr_n75803744)
print v(xbgr.mr_n75804064)
print v(xbgr.mr_n75804176)
print v(xbgr.mr_n75804496)
print v(xbgr.mr_n75804608)
print v(xbgr.mr_n75804928)
print v(xbgr.mr_n75805040)
print v(xbgr.mr_n75805360)
print v(xbgr.mr_n75805472)
print v(xbgr.mr_n75805792)
print v(xbgr.mr_n75805904)
print v(xbgr.mr_n75806224)
print v(xbgr.mr_n75806336)
print v(xbgr.mr_n75806656)
print v(xbgr.mr_n75806768)
print v(xbgr.mr_n75807088)
print v(xbgr.mr_n75807200)
print v(xbgr.mr_n75807520)
print v(xbgr.mr_n75807632)
print v(xbgr.mr_n75807952)
print v(xbgr.mr_n75808064)
print v(xbgr.mr_n75808384)
print v(xbgr.mr_n75808496)
print v(xbgr.mr_n75808816)
print v(xbgr.mr_n75808928)
print v(xbgr.mr_n75809248)
print v(xbgr.mr_n75809360)
print v(xbgr.mr_n75809680)
print v(xbgr.mr_n75809792)
print v(xbgr.mr_n75810112)
print v(xbgr.mr_n75810224)
print v(xbgr.mr_n75810544)
print v(xbgr.mr_n75810656)
print v(xbgr.mr_n75810976)
print v(xbgr.mr_n75811088)
print v(xbgr.mr_n75811408)
print v(xbgr.mr_n75811520)
print v(xbgr.mr_n75811840)
print v(xbgr.mr_n75811952)
print v(xbgr.mr_n75812272)
print v(xbgr.mr_n75812384)
print v(xbgr.mr_n75812704)
print v(xbgr.mr_n75812816)
print v(xbgr.mr_n75813136)
print v(xbgr.mr_n75813248)
print v(xbgr.mr_n75813568)
print v(xbgr.mr_n75813680)
print v(xbgr.mr_n75814000)
print v(xbgr.mr_n75814112)
print v(xbgr.mr_n75814432)
print v(xbgr.mr_n75814544)
print v(xbgr.mr_n75814864)
print v(xbgr.mr_n75814976)
print v(xbgr.mr_n75815296)
print v(xbgr.mr_n75815408)
print v(xbgr.mr_n75815728)
print v(xbgr.mr_n75815840)
print v(xbgr.mr_n75816160)
print v(xbgr.mr_n75816272)
print v(xbgr.mr_n75816592)
print v(xbgr.mr_n75816704)
print v(xbgr.mr_n75817024)
print v(xbgr.mr_n75817136)
print v(xbgr.mr_n75817456)
print v(xbgr.mr_n75817568)
print v(xbgr.mr_n75817888)
print v(xbgr.mr_n75818000)
print v(xbgr.mr_n75818320)
print v(xbgr.mr_n75818432)
print v(xbgr.mr_n75818752)
print v(xbgr.mr_n75818864)
print v(xbgr.mr_n75819184)
print v(xbgr.mr_n75819296)
print v(xbgr.mr_n75819616)
print v(xbgr.mr_n75819728)
print v(xbgr.mr_n75820048)
print v(xbgr.mr_n75820160)
print v(xbgr.mr_n75820480)
print v(xbgr.mr_n75820592)
print v(xbgr.mr_n75820912)
print v(xbgr.mr_n75821024)
print v(xbgr.mr_n75821344)
print v(xbgr.mr_n75821456)
print v(xbgr.mr_n75821776)
print v(xbgr.mr_n75821888)
print v(xbgr.mr_n75822208)
print v(xbgr.mr_n75822320)
print v(xbgr.mr_n75822640)
print v(xbgr.mr_n75822752)
print v(xbgr.mr_n75823072)
print v(xbgr.mr_n75823184)
print v(xbgr.mr_n75823504)
print v(xbgr.mr_n75823616)
print v(xbgr.mr_n75823936)
print v(xbgr.mr_n75824048)
print v(xbgr.mr_n75824368)
print v(xbgr.mr_n75824480)
print v(xbgr.mr_n75824800)
print v(xbgr.mr_n75824912)
print v(xbgr.mr_n75825232)
print v(xbgr.mr_n75825344)
print v(xbgr.mr_n75825664)
print v(xbgr.mr_n75825776)
print v(xbgr.mr_n75826096)
print v(xbgr.mr_n75826208)
print v(xbgr.mr_n75826528)
print v(xbgr.mr_n75826640)
print v(xbgr.mr_n75826960)
print v(xbgr.mr_n75827072)
print v(xbgr.mr_n75827392)
print v(xbgr.mr_n75827504)
print v(xbgr.mr_n75827824)
print v(xbgr.mr_n75827936)
print v(xbgr.mr_n75828256)
print v(xbgr.mr_n75828368)
print v(xbgr.mr_n75828688)
print v(xbgr.mr_n75828800)
print v(xbgr.mr_n75829120)
print v(xbgr.mr_n75829232)
print v(xbgr.mr_n75829552)
print v(xbgr.mr_n75829664)
print v(xbgr.mr_n75829984)
print v(xbgr.mr_n75830096)
print v(xbgr.mr_n75830416)
print v(xbgr.mr_n75830528)
print v(xbgr.mr_n75830848)
print v(xbgr.mr_n75830960)
print v(xbgr.mr_n75831280)
print v(xbgr.mr_n75831392)
print v(xbgr.mr_n75831712)
print v(xbgr.mr_n75831824)
print v(xbgr.mr_n75832144)
print v(xbgr.mr_n75832256)
print v(xbgr.mr_n75832576)
print v(xbgr.mr_n75832688)
print v(xbgr.mr_n75833008)
print v(xbgr.mr_n75833120)
print v(xbgr.mr_n75833440)
print v(xbgr.mr_n75833552)
print v(xbgr.mr_n75833872)
print v(xbgr.mr_n75833984)
print v(xbgr.mr_n75834304)
print v(xbgr.mr_n75834416)
print v(xbgr.mr_n75834736)
print v(xbgr.mr_n75834848)
print v(xbgr.mr_n75835168)
print v(xbgr.mr_n75835280)
print v(xbgr.mr_n75835600)
print v(xbgr.mr_n75835712)
print v(xbgr.mr_n75836032)
print v(xbgr.mr_n75836144)
print v(xbgr.mr_n75836464)
print v(xbgr.mr_n75836576)
print v(xbgr.mr_n75836896)
print v(xbgr.mr_n75837008)
print v(xbgr.mr_n75837328)
print v(xbgr.mr_n75837440)
print v(xbgr.mr_n75837760)
print v(xbgr.mr_n75837872)
print v(xbgr.mr_n75838192)
print v(xbgr.mr_n75838304)
print v(xbgr.mr_n75838624)
print v(xbgr.mr_n75838736)
print v(xbgr.mr_n75839056)
print v(xbgr.mr_n75839168)
print v(xbgr.mr_n75839488)
print v(xbgr.mr_n75839600)
print v(xbgr.mr_n75839920)
print v(xbgr.mr_n75840032)
print v(xbgr.mr_n75840352)
print v(xbgr.mr_n75840464)
print v(xbgr.mr_n75840784)
print v(xbgr.mr_n75840896)
print v(xbgr.mr_n75841216)
print v(xbgr.mr_n75841328)
print v(xbgr.mr_n75841648)
print v(xbgr.mr_n75841760)
print v(xbgr.mr_n75842080)
print v(xbgr.mr_n75842192)
print v(xbgr.mr_n75842512)
print v(xbgr.mr_n75842624)
print v(xbgr.mr_n75842944)
print v(xbgr.mr_n75843056)
print v(xbgr.mr_n75843376)
print v(xbgr.mr_n75843488)
print v(xbgr.mr_n75843808)
print v(xbgr.mr_n75843920)
print v(xbgr.mr_n75844240)
print v(xbgr.mr_n75844352)
print v(xbgr.mr_n75844672)
print v(xbgr.mr_n75844784)
print v(xbgr.mr_n75845104)
print v(xbgr.mr_n75845216)
print v(xbgr.mr_n75845536)
print v(xbgr.mr_n75845648)
print v(xbgr.mr_n75845968)
print v(xbgr.mr_n75846080)
print v(xbgr.mr_n75846400)
print v(xbgr.mr_n75846512)
print v(xbgr.mr_n75846832)
print v(xbgr.mr_n75846944)
print v(xbgr.mr_n75847264)
print v(xbgr.mr_n75847376)
print v(xbgr.mr_n75847696)
print v(xbgr.mr_n75847808)
print v(xbgr.mr_n75848128)
print v(xbgr.mr_n75848240)
print v(xbgr.mr_n75848560)
print v(xbgr.mr_n75848672)
print v(xbgr.mr_n75848992)
print v(xbgr.mr_n75849104)
print v(xbgr.mr_n75849424)
print v(xbgr.mr_n75849536)
print v(xbgr.mr_n75849856)
print v(xbgr.mr_n75849968)
print v(xbgr.mr_n75850288)
print v(xbgr.mr_n75850400)
print v(xbgr.mr_n75850720)
print v(xbgr.mr_n75850832)
print v(xbgr.mr_n75851152)
print v(xbgr.mr_n75851264)
print v(xbgr.mr_n75851584)
print v(xbgr.mr_n75851696)
print v(xbgr.mr_n75852016)
print v(xbgr.mr_n75852128)
print v(xbgr.mr_n75852448)
print v(xbgr.mr_n75852560)
print v(xbgr.mr_n75852880)
print v(xbgr.mr_n75852992)
print v(xbgr.mr_n75853312)
print v(xbgr.mr_n75853424)
print v(xbgr.mr_n75853744)
print v(xbgr.mr_n75853856)
print v(xbgr.mr_n75854176)
print v(xbgr.mr_n75854288)
print v(xbgr.mr_n75854608)
print v(xbgr.mr_n75854720)
print v(xbgr.mr_n75855040)
print v(xbgr.mr_n75855152)
print v(xbgr.mr_n75855472)
print v(xbgr.mr_n75855584)
print v(xbgr.mr_n75855904)
print v(xbgr.mr_n75856016)
print v(xbgr.mr_n75856336)
print v(xbgr.mr_n75856448)
print v(xbgr.mr_n75856768)
print v(xbgr.mr_n75856880)
print v(xbgr.mr_n75857200)
print v(xbgr.mr_n75857312)
print v(xbgr.mr_n75857632)
print v(xbgr.mr_n75857744)
print v(xbgr.mr_n75858064)
print v(xbgr.mr_n75858176)
print v(xbgr.mr_n75858496)
print v(xbgr.mr_n75858608)
print v(xbgr.mr_n75858928)
print v(xbgr.mr_n75859040)
print v(xbgr.mr_n75859360)
print v(xbgr.mr_n75859472)
print v(xbgr.mr_n75859792)
print v(xbgr.mr_n75859904)
print v(xbgr.mr_n75860224)
print v(xbgr.mr_n75860336)
print v(xbgr.mr_n75860656)
print v(xbgr.mr_n75860768)
print v(xbgr.mr_n75861088)
print v(xbgr.mr_n75861200)
print v(xbgr.mr_n75861520)
print v(xbgr.mr_n75861632)
print v(xbgr.mr_n75861952)
print v(xbgr.mr_n75862064)
print v(xbgr.mr_n75862384)
print v(xbgr.mr_n75862496)
print v(xbgr.mr_n75862816)
print v(xbgr.mr_n75862928)
print v(xbgr.mr_n75863248)
print v(xbgr.mr_n75863360)
print v(xbgr.mr_n75863680)
print v(xbgr.mr_n75863792)
print v(xbgr.mr_n75864112)
print v(xbgr.mr_n75864224)
print v(xbgr.mr_n75864544)
print v(xbgr.mr_n75864656)
print v(xbgr.mr_n75864976)
print v(xbgr.mr_n75865088)
print v(xbgr.mr_n75865408)
print v(xbgr.mr_n75865520)
print v(xbgr.mr_n75865840)
print v(xbgr.mr_n75865952)
print v(xbgr.mr_n75866272)
print v(xbgr.mr_n75866384)
print v(xbgr.mr_n75866704)
print v(xbgr.mr_n75866816)
print v(xbgr.mr_n75867136)
print v(xbgr.mr_n75867248)
print v(xbgr.mr_n75867568)
print v(xbgr.mr_n75867680)
print v(xbgr.mr_n75868000)
print v(xbgr.mr_n75868112)
print v(xbgr.mr_n75868432)
print v(xbgr.mr_n75868544)
print v(xbgr.mr_n75868864)
print v(xbgr.mr_n75868976)
print v(xbgr.mr_n75869296)
print v(xbgr.mr_n75869408)
print v(xbgr.mr_n75869728)
print v(xbgr.mr_n75869840)
print v(xbgr.mr_n75870160)
print v(xbgr.mr_n75870272)
print v(xbgr.mr_n75870592)
print v(xbgr.mr_n75870704)
print v(xbgr.mr_n75871024)
print v(xbgr.mr_n75871136)
print v(xbgr.mr_n75871456)
print v(xbgr.mr_n75871568)
print v(xbgr.mr_n75871888)
print v(xbgr.mr_n75872000)
print v(xbgr.mr_n75872320)
print v(xbgr.mr_n75872432)
print v(xbgr.mr_n75872752)
print v(xbgr.mr_n75872864)
print v(xbgr.mr_n75873184)
print v(xbgr.mr_n75873296)
print v(xbgr.mr_n75873616)
print v(xbgr.mr_n75873728)
print v(xbgr.mr_n75874048)
print v(xbgr.mr_n75874160)
print v(xbgr.mr_n75874480)
print v(xbgr.mr_n75874592)
print v(xbgr.mr_n75874912)
print v(xbgr.mr_n75875024)
print v(xbgr.mr_n75875344)
print v(xbgr.mr_n75875456)
print v(xbgr.mr_n75875776)
print v(xbgr.mr_n75875888)
print v(xbgr.mr_n75876208)
print v(xbgr.mr_n75876320)
print v(xbgr.mr_n75876640)
print v(xbgr.mr_n75876752)
print v(xbgr.mr_n75877072)
print v(xbgr.mr_n75877184)
print v(xbgr.mr_n75877504)
print v(xbgr.mr_n75877616)
print v(xbgr.mr_n75877936)
print v(xbgr.mr_n75878048)
print v(xbgr.mr_n75878368)
print v(xbgr.mr_n75878480)
print v(xbgr.mr_n75878800)
print v(xbgr.mr_n75878912)
print v(xbgr.mr_n75879232)
print v(xbgr.mr_n75879344)
print v(xbgr.mr_n75879664)
print v(xbgr.mr_n75879776)
print v(xbgr.mr_n75880096)
print v(xbgr.mr_n75880208)
print v(xbgr.mr_n75880528)
print v(xbgr.mr_n75880640)
print v(xbgr.mr_n75880960)
print v(xbgr.mr_n75881072)
print v(xbgr.mr_n75881392)
print v(xbgr.mr_n75881504)
print v(xbgr.mr_n75881824)
print v(xbgr.mr_n75881936)
print v(xbgr.mr_n75882256)
print v(xbgr.mr_n75882368)
print v(xbgr.mr_n75882688)
print v(xbgr.mr_n75882800)
print v(xbgr.mr_n75883120)
print v(xbgr.mr_n75883232)
print v(xbgr.mr_n75883552)
print v(xbgr.mr_n75883664)
print v(xbgr.mr_n75883984)
print v(xbgr.mr_n75884096)
print v(xbgr.mr_n75884416)
print v(xbgr.mr_n75884528)
print v(xbgr.mr_n75884848)
print v(xbgr.mr_n75884960)
print v(xbgr.mr_n75885280)
print v(xbgr.mr_n75885392)
print v(xbgr.mr_n75885712)
print v(xbgr.mr_n75885824)
print v(xbgr.mr_n75886144)
print v(xbgr.mr_n75886256)
print v(xbgr.mr_n75886576)
print v(xbgr.mr_n75886688)
print v(xbgr.mr_n75887008)
print v(xbgr.mr_n75887120)
print v(xbgr.mr_n75887440)
print v(xbgr.mr_n75887552)
print v(xbgr.mr_n75887872)
print v(xbgr.mr_n75887984)
print v(xbgr.mr_n75888304)
print v(xbgr.mr_n75888416)
print v(xbgr.mr_n75888736)
print v(xbgr.mr_n75888848)
print v(xbgr.mr_n75889168)
print v(xbgr.mr_n75889280)
print v(xbgr.mr_n75889600)
print v(xbgr.mr_n75889712)
print v(xbgr.mr_n75890032)
print v(xbgr.mr_n75890144)
print v(xbgr.mr_n75890464)
print v(xbgr.mr_n75890576)
print v(xbgr.mr_n75890896)
print v(xbgr.mr_n75891008)
print v(xbgr.mr_n75891328)
print v(xbgr.mr_n75891440)
print v(xbgr.mr_n75891760)
print v(xbgr.mr_n75891872)
print v(xbgr.mr_n75892192)
print v(xbgr.mr_n75892304)
print v(xbgr.mr_n75892624)
print v(xbgr.mr_n75892736)
print v(xbgr.mr_n75893056)
print v(xbgr.mr_n75893168)
print v(xbgr.mr_n75893488)
print v(xbgr.mr_n75893600)
print v(xbgr.mr_n75893920)
print v(xbgr.mr_n75894032)
print v(xbgr.mr_n75894352)
print v(xbgr.mr_n75894464)
print v(xbgr.mr_n75894784)
print v(xbgr.mr_n75894896)
print v(xbgr.mr_n75895216)
print v(xbgr.mr_n75895328)
print v(xbgr.mr_n75895648)
print v(xbgr.mr_n75895760)
print v(xbgr.mr_n75896080)
print v(xbgr.mr_n75896192)
print v(xbgr.mr_n75896512)
print v(xbgr.mr_n75896624)
print v(xbgr.mr_n75896944)
print v(xbgr.mr_n75897056)
print v(xbgr.mr_n75897376)
print v(xbgr.mr_n75897488)
print v(xbgr.mr_n75897808)
print v(xbgr.mr_n75897920)
print v(xbgr.mr_n75898240)
print v(xbgr.mr_n75898352)
print v(xbgr.mr_n75898672)
print v(xbgr.mr_n75898784)
print v(xbgr.mr_n75899104)
print v(xbgr.mr_n75899216)
print v(xbgr.mr_n75899536)
print v(xbgr.mr_n75899648)
print v(xbgr.mr_n75899968)
print v(xbgr.mr_n75900080)
print v(xbgr.mr_n75900400)
print v(xbgr.mr_n75900512)
print v(xbgr.mr_n75900832)
print v(xbgr.mr_n75900944)
print v(xbgr.mr_n75901264)
print v(xbgr.mr_n75901376)
print v(xbgr.mr_n75901696)
print v(xbgr.mr_n75901808)
print v(xbgr.mr_n75902128)
print v(xbgr.mr_n75902240)
print v(xbgr.mr_n75902560)
print v(xbgr.mr_n75902672)
print v(xbgr.mr_n75902992)
print v(xbgr.mr_n75903104)
print v(xbgr.mr_n75903424)
print v(xbgr.mr_n75903536)
print v(xbgr.mr_n75903856)
print v(xbgr.mr_n75903968)
print v(xbgr.mr_n75904288)
print v(xbgr.mr_n75904400)
print v(xbgr.mr_n75904720)
print v(xbgr.mr_n75904832)
print v(xbgr.mr_n75905152)
print v(xbgr.mr_n75905264)
print v(xbgr.mr_n75905584)
print v(xbgr.mr_n75905696)
print v(xbgr.mr_n75906016)
print v(xbgr.mr_n75906128)
print v(xbgr.mr_n75906448)
print v(xbgr.mr_n75906560)
print v(xbgr.mr_n75906880)
print v(xbgr.mr_n75906992)
print v(xbgr.mr_n75907312)
print v(xbgr.mr_n75907424)
print v(xbgr.mr_n75907744)
print v(xbgr.mr_n75907856)
print v(xbgr.mr_n75908176)
print v(xbgr.mr_n75908288)
print v(xbgr.mr_n75908608)
print v(xbgr.mr_n75908720)
print v(xbgr.mr_n75909040)
print v(xbgr.mr_n75909152)
print v(xbgr.mr_n75909472)
print v(xbgr.mr_n75909584)
print v(xbgr.mr_n75909904)
print v(xbgr.mr_n75910016)
print v(xbgr.mr_n75910336)
print v(xbgr.mr_n75910448)
print v(xbgr.mr_n75910768)
print v(xbgr.mr_n75910880)
print v(xbgr.mr_n75911200)
print v(xbgr.mr_n75911312)
print v(xbgr.mr_n75911632)
print v(xbgr.mr_n75911744)
print v(xbgr.mr_n75912064)
print v(xbgr.mr_n75912176)
print v(xbgr.mr_n75912496)
print v(xbgr.mr_n75912608)
print v(xbgr.mr_n75912928)
print v(xbgr.mr_n75913040)
print v(xbgr.mr_n75913360)
print v(xbgr.mr_n75913472)
print v(xbgr.mr_n75913792)
print v(xbgr.mr_n75913904)
print v(xbgr.mr_n75914224)
print v(xbgr.mr_n75914336)
print v(xbgr.mr_n75914656)
print v(xbgr.mr_n75914768)
print v(xbgr.mr_n75915088)
print v(xbgr.mr_n75915200)
print v(xbgr.mr_n75915520)
print v(xbgr.mr_n75915632)
print v(xbgr.mr_n75915952)
print v(xbgr.mr_n75916064)
print v(xbgr.mr_n75916384)
print v(xbgr.mr_n75916496)
print v(xbgr.mr_n75916816)
print v(xbgr.mr_n75916928)
print v(xbgr.mr_n75917248)
print v(xbgr.mr_n75917360)
print v(xbgr.mr_n75917680)
print v(xbgr.mr_n75917792)
print v(xbgr.mr_n75918112)
print v(xbgr.mr_n75918224)
print v(xbgr.mr_n75918544)
print v(xbgr.mr_n75918656)
print v(xbgr.mr_n75918976)
print v(xbgr.mr_n75919088)
print v(xbgr.mr_n75919408)
print v(xbgr.mr_n75919520)
print v(xbgr.mr_n75919840)
print v(xbgr.mr_n75919952)
print v(xbgr.mr_n75920272)
print v(xbgr.mr_n75920384)
print v(xbgr.mr_n75920704)
print v(xbgr.mr_n75920816)
print v(xbgr.mr_n75921136)
print v(xbgr.mr_n75921248)
print v(xbgr.mr_n75921568)
print v(xbgr.mr_n75921680)
print v(xbgr.mr_n75922000)
print v(xbgr.mr_n75922112)
print v(xbgr.mr_n75922432)
print v(xbgr.mr_n75922544)
print v(xbgr.mr_n75922864)
print v(xbgr.mr_n75922976)
print v(xbgr.mr_n75923296)
print v(xbgr.mr_n75923408)
print v(xbgr.mr_n75923728)
print v(xbgr.mr_n75923840)
print v(xbgr.mr_n75924160)
print v(xbgr.mr_n75924272)
print v(xbgr.mr_n75924592)
print v(xbgr.mr_n75924704)
print v(xbgr.mr_n75925024)
print v(xbgr.mr_n75925136)
print v(xbgr.mr_n75925456)
print v(xbgr.mr_n75925568)
print v(xbgr.mr_n75925888)
print v(xbgr.mr_n75926000)
print v(xbgr.mr_n75926320)
print v(xbgr.mr_n75926432)
print v(xbgr.mr_n75926752)
print v(xbgr.mr_n75926864)
print v(xbgr.mr_n75927184)
print v(xbgr.mr_n75927296)
print v(xbgr.mr_n75927616)
print v(xbgr.mr_n75927728)
print v(xbgr.mr_n75928048)
print v(xbgr.mr_n75928160)
print v(xbgr.mr_n75928480)
print v(xbgr.mr_n75928592)
print v(xbgr.mr_n75928912)
print v(xbgr.mr_n75929024)
print v(xbgr.mr_n75929344)
print v(xbgr.mr_n75929456)
print v(xbgr.mr_n75929776)
print v(xbgr.mr_n75929888)
print v(xbgr.mr_n75930208)
print v(xbgr.mr_n75930320)
print v(xbgr.mr_n75930640)
print v(xbgr.mr_n75930752)
print v(xbgr.mr_n75931072)
print v(xbgr.mr_n75931184)
print v(xbgr.mr_n75931504)
print v(xbgr.mr_n75931616)
print v(xbgr.mr_n75931936)
print v(xbgr.mr_n75932048)
print v(xbgr.mr_n75932368)
print v(xbgr.mr_n75932480)
print v(xbgr.mr_n75932800)
print v(xbgr.mr_n75932912)
print v(xbgr.mr_n75933232)
print v(xbgr.mr_n75933344)
print v(xbgr.mr_n75933664)
print v(xbgr.mr_n75933776)
print v(xbgr.mr_n75934096)
print v(xbgr.mr_n75934208)
print v(xbgr.mr_n75934528)
print v(xbgr.mr_n75934640)
print v(xbgr.mr_n75934960)
print v(xbgr.mr_n75935072)
print v(xbgr.mr_n75935392)
print v(xbgr.mr_n75935504)
print v(xbgr.mr_n75935824)
print v(xbgr.mr_n75935936)
print v(xbgr.mr_n75936256)
print v(xbgr.mr_n75936368)
print v(xbgr.mr_n75936688)
print v(xbgr.mr_n75936800)
print v(xbgr.mr_n75937120)
print v(xbgr.mr_n75937232)
print v(xbgr.mr_n75937552)
print v(xbgr.mr_n75937664)
print v(xbgr.mr_n75937984)
print v(xbgr.mr_n75938096)
print v(xbgr.mr_n75938416)
print v(xbgr.mr_n75938528)
print v(xbgr.mr_n75938848)
print v(xbgr.mr_n75938960)
print v(xbgr.mr_n75939280)
print v(xbgr.mr_n75939392)
print v(xbgr.mr_n75939712)
print v(xbgr.mr_n75939824)
print v(xbgr.mr_n75940144)
print v(xbgr.mr_n75940256)
print v(xbgr.mr_n75940576)
print v(xbgr.mr_n75940688)
print v(xbgr.mr_n75941008)
print v(xbgr.mr_n75941120)
print v(xbgr.mr_n75941440)
print v(xbgr.mr_n75941552)
print v(xbgr.mr_n75941872)
print v(xbgr.mr_n75941984)
print v(xbgr.mr_n75942304)
print v(xbgr.mr_n75942416)
print v(xbgr.mr_n75942736)
print v(xbgr.mr_n75942848)
print v(xbgr.mr_n75943168)
print v(xbgr.mr_n75943280)
print v(xbgr.mr_n75943600)
print v(xbgr.mr_n75943712)
print v(xbgr.mr_n75944032)
print v(xbgr.mr_n75944144)
print v(xbgr.mr_n75944464)
print v(xbgr.mr_n75944576)
print v(xbgr.mr_n75944896)
print v(xbgr.mr_n75945008)
print v(xbgr.mr_n75945328)
print v(xbgr.mr_n75945440)
print v(xbgr.mr_n75945760)
print v(xbgr.mr_n75945872)
print v(xbgr.mr_n75946192)
print v(xbgr.mr_n75946304)
print v(xbgr.mr_n75946624)
print v(xbgr.mr_n75946736)
print v(xbgr.mr_n75947056)
print v(xbgr.mr_n75947168)
print v(xbgr.mr_n75947488)
print v(xbgr.mr_n75947600)
print v(xbgr.mr_n75947920)
print v(xbgr.mr_n75948032)
print v(xbgr.mr_n75948352)
print v(xbgr.mr_n75948464)
print v(xbgr.mr_n75948784)
print v(xbgr.mr_n75948896)
print v(xbgr.mr_n75949216)
print v(xbgr.mr_n75949328)
print v(xbgr.mr_n75949648)
print v(xbgr.mr_n75949760)
print v(xbgr.mr_n75950080)
print v(xbgr.mr_n75950192)
print v(xbgr.mr_n75950512)
print v(xbgr.mr_n75950624)
print v(xbgr.mr_n75950944)
print v(xbgr.mr_n75951056)
print v(xbgr.mr_n75951376)
print v(xbgr.mr_n75951488)
print v(xbgr.mr_n75951808)
print v(xbgr.mr_n75951920)
print v(xbgr.mr_n75952240)
print v(xbgr.mr_n75952352)
print v(xbgr.mr_n75952672)
print v(xbgr.mr_n75952784)
print v(xbgr.mr_n75953104)
print v(xbgr.mr_n75953216)
print v(xbgr.mr_n75953536)
print v(xbgr.mr_n75953648)
print v(xbgr.mr_n75953968)
print v(xbgr.mr_n75954080)
print v(xbgr.mr_n75954400)
print v(xbgr.mr_n75954512)
print v(xbgr.mr_n75954832)
print v(xbgr.mr_n75954944)
print v(xbgr.mr_n75955264)
print v(xbgr.mr_n75955376)
print v(xbgr.mr_n75955696)
print v(xbgr.mr_n75955808)
print v(xbgr.mr_n75956128)
print v(xbgr.mr_n75956240)
print v(xbgr.mr_n75956560)
print v(xbgr.mr_n75956672)
print v(xbgr.mr_n75956992)
print v(xbgr.mr_n75957104)
print v(xbgr.mr_n75957424)
print v(xbgr.mr_n75957536)
print v(xbgr.mr_n75957856)
print v(xbgr.mr_n75957968)
print v(xbgr.mr_n75958288)
print v(xbgr.mr_n75958400)
print v(xbgr.mr_n75958720)
print v(xbgr.mr_n75958832)
print v(xbgr.mr_n75959152)
print v(xbgr.mr_n75959264)
print v(xbgr.mr_n75959584)
print v(xbgr.mr_n75959696)
print v(xbgr.mr_n75960016)
print v(xbgr.mr_n75960128)
print v(xbgr.mr_n75960448)
print v(xbgr.mr_n75960560)
print v(xbgr.mr_n75960880)
print v(xbgr.mr_n75960992)
print v(xbgr.mr_n75961312)
print v(xbgr.mr_n75961424)
print v(xbgr.mr_n75961744)
print v(xbgr.mr_n75961856)
print v(xbgr.mr_n75962176)
print v(xbgr.mr_n75962288)
print v(xbgr.mr_n75962608)
print v(xbgr.mr_n75962720)
print v(xbgr.mr_n75963040)
print v(xbgr.mr_n75963152)
print v(xbgr.mr_n75963472)
print v(xbgr.mr_n75963584)
print v(xbgr.mr_n75963904)
print v(xbgr.mr_n75964016)
print v(xbgr.mr_n75964336)
print v(xbgr.mr_n75964448)
print v(xbgr.mr_n75964768)
print v(xbgr.mr_n75964880)
print v(xbgr.mr_n75965200)
print v(xbgr.mr_n75965312)
print v(xbgr.mr_n75965632)
print v(xbgr.mr_n75965744)
print v(xbgr.mr_n75966064)
print v(xbgr.mr_n75966176)
print v(xbgr.mr_n75966496)
print v(xbgr.mr_n75966608)
print v(xbgr.mr_n75966928)
print v(xbgr.mr_n75967040)
print v(xbgr.mr_n75967360)
print v(xbgr.mr_n75967472)
print v(xbgr.mr_n75967792)
print v(xbgr.mr_n75967904)
print v(xbgr.mr_n75968224)
print v(xbgr.mr_n75968336)
print v(xbgr.mr_n75968656)
print v(xbgr.mr_n75968768)
print v(xbgr.mr_n75969088)
print v(xbgr.mr_n75969200)
print v(xbgr.mr_n75969520)
print v(xbgr.mr_n75969632)
print v(xbgr.mr_n75969952)
print v(xbgr.mr_n75970064)
print v(xbgr.mr_n75970384)
print v(xbgr.mr_n75970496)
print v(xbgr.mr_n75970816)
print v(xbgr.mr_n75970928)
print v(xbgr.mr_n75971248)
print v(xbgr.mr_n75971360)
print v(xbgr.mr_n75971680)
print v(xbgr.mr_n75971792)
print v(xbgr.mr_n75972112)
print v(xbgr.mr_n75972224)
print v(xbgr.mr_n75972544)
print v(xbgr.mr_n75972656)
print v(xbgr.mr_n75972976)
print v(xbgr.mr_n75973088)
print v(xbgr.mr_n75973408)
print v(xbgr.mr_n75973520)
print v(xbgr.mr_n75973840)
print v(xbgr.mr_n75973952)
print v(xbgr.mr_n75974272)
print v(xbgr.mr_n75974384)
print v(xbgr.mr_n75974704)
print v(xbgr.mr_n75974816)
print v(xbgr.mr_n75975136)
print v(xbgr.mr_n75975248)
print v(xbgr.mr_n75975568)
print v(xbgr.mr_n75975680)
print v(xbgr.mr_n75976000)
print v(xbgr.mr_n75976112)
print v(xbgr.mr_n75976432)
print v(xbgr.mr_n75976544)
print v(xbgr.mr_n75976864)
print v(xbgr.mr_n75976976)
print v(xbgr.mr_n75977296)
print v(xbgr.mr_n75977408)
print v(xbgr.mr_n75977728)
print v(xbgr.mr_n75977840)
print v(xbgr.mr_n75978160)
print v(xbgr.mr_n75978272)
print v(xbgr.mr_n75978592)
print v(xbgr.mr_n75978704)
print v(xbgr.mr_n75979024)
print v(xbgr.mr_n75979136)
print v(xbgr.mr_n75979456)
print v(xbgr.mr_n75979568)
print v(xbgr.mr_n75979888)
print v(xbgr.mr_n75980000)
print v(xbgr.mr_n75980320)
print v(xbgr.mr_n75980432)
print v(xbgr.mr_n75980752)
print v(xbgr.mr_n75980864)
print v(xbgr.mr_n75981184)
print v(xbgr.mr_n75981296)
print v(xbgr.mr_n75981616)
print v(xbgr.mr_n75981728)
print v(xbgr.mr_n75982048)
print v(xbgr.mr_n75982160)
print v(xbgr.mr_n75982480)
print v(xbgr.mr_n75982592)
print v(xbgr.mr_n75982912)
print v(xbgr.mr_n75983024)
print v(xbgr.mr_n75983344)
print v(xbgr.mr_n75983456)
print v(xbgr.mr_n75983776)
print v(xbgr.mr_n75983888)
print v(xbgr.mr_n75984208)
print v(xbgr.mr_n75984320)
print v(xbgr.mr_n75984640)
print v(xbgr.mr_n75984752)
print v(xbgr.mr_n75985072)
print v(xbgr.mr_n75985184)
print v(xbgr.mr_n75985504)
print v(xbgr.mr_n75985616)
print v(xbgr.mr_n75985936)
print v(xbgr.mr_n75986048)
print v(xbgr.mr_n75986368)
print v(xbgr.mr_n75986480)
print v(xbgr.mr_n75986800)
print v(xbgr.mr_n75986912)
print v(xbgr.mr_n75987232)
print v(xbgr.mr_n75987344)
print v(xbgr.mr_n75987664)
print v(xbgr.mr_n75987776)
print v(xbgr.mr_n75988096)
print v(xbgr.mr_n75988208)
print v(xbgr.mr_n75988528)
print v(xbgr.mr_n75988640)
print v(xbgr.mr_n75988960)
print v(xbgr.mr_n75989072)
print v(xbgr.mr_n75989392)
print v(xbgr.mr_n75989504)
print v(xbgr.mr_n75989824)
print v(xbgr.mr_n75989936)
print v(xbgr.mr_n75990256)
print v(xbgr.mr_n75990368)
print v(xbgr.mr_n75990688)
print v(xbgr.mr_n75990800)
print v(xbgr.mr_n75991120)
print v(xbgr.mr_n75991232)
print v(xbgr.mr_n75991552)
print v(xbgr.mr_n75991664)
print v(xbgr.mr_n75991984)
print v(xbgr.mr_n75992096)
print v(xbgr.mr_n75992416)
print v(xbgr.mr_n75992528)
print v(xbgr.mr_n75992848)
print v(xbgr.mr_n75992960)
print v(xbgr.mr_n75993280)
print v(xbgr.mr_n75993392)
print v(xbgr.mr_n75993712)
print v(xbgr.mr_n75993824)
print v(xbgr.mr_n75994144)
print v(xbgr.mr_n75994256)
print v(xbgr.mr_n75994576)
print v(xbgr.mr_n75994688)
print v(xbgr.mr_n75995008)
print v(xbgr.mr_n75995120)
print v(xbgr.mr_n75995440)
print v(xbgr.mr_n75995552)
print v(xbgr.mr_n75995872)
print v(xbgr.mr_n75995984)
print v(xbgr.mr_n75996304)
print v(xbgr.mr_n75996416)
print v(xbgr.mr_n75996736)
print v(xbgr.mr_n75996848)
print v(xbgr.mr_n75997168)
print v(xbgr.mr_n75997280)
print v(xbgr.mr_n75997600)
print v(xbgr.mr_n75997712)
print v(xbgr.mr_n75998032)
print v(xbgr.mr_n75998144)
print v(xbgr.mr_n75998464)
print v(xbgr.mr_n75998576)
print v(xbgr.mr_n75998896)
print v(xbgr.mr_n75999008)
print v(xbgr.mr_n75999328)
print v(xbgr.mr_n75999440)
print v(xbgr.mr_n75999760)
print v(xbgr.mr_n75999872)
print v(xbgr.mr_n76000192)
print v(xbgr.mr_n76000304)
print v(xbgr.mr_n76000624)
print v(xbgr.mr_n76000736)
print v(xbgr.mr_n76001056)
print v(xbgr.mr_n76001168)
print v(xbgr.mr_n76001488)
print v(xbgr.mr_n76001600)
print v(xbgr.mr_n76002032)
print v(xbgr.mr_n76002352)
print v(xbgr.mr_n76002464)
print v(xbgr.mr_n76002784)
print v(xbgr.mr_n76002896)
print v(xbgr.mr_n76003216)
print v(xbgr.mr_n76003328)
print v(xbgr.mr_n76003648)
print v(xbgr.mr_n76003760)
print v(xbgr.mr_n76004080)
print v(xbgr.mr_n76004192)
print v(xbgr.mr_n76004512)
print v(xbgr.mr_n76004624)
print v(xbgr.mr_n76004944)
print v(xbgr.mr_n76005056)
print v(xbgr.mr_n76005376)
print v(xbgr.mr_n76005488)
print v(xbgr.mr_n76005808)
print v(xbgr.mr_n76005920)
print v(xbgr.mr_n76006240)
print v(xbgr.mr_n76006352)
print v(xbgr.mr_n76006672)
print v(xbgr.mr_n76006784)
print v(xbgr.mr_n76007104)
print v(xbgr.mr_n76007216)
print v(xbgr.mr_n76007536)
print v(xbgr.mr_n76007648)
print v(xbgr.mr_n76008080)
print v(xbgr.mr_n76008400)
print v(xbgr.mr_n76008512)
print v(xbgr.mr_n76008832)
print v(xbgr.mr_n76008944)
print v(xbgr.mr_n76009264)
print v(xbgr.mr_n76009376)
print v(xbgr.mr_n76009696)
print v(xbgr.mr_n76009808)
print v(xbgr.mr_n76010128)
print v(xbgr.mr_n76010240)
print v(xbgr.mr_n76010560)
print v(xbgr.mr_n76010672)
print v(xbgr.mr_n76010992)
print v(xbgr.mr_n76011104)
print v(xbgr.mr_n76011424)
print v(xbgr.mr_n76011536)
print v(xbgr.mr_n76011856)
print v(xbgr.mr_n76011968)
print v(xbgr.mr_n76012288)
print v(xbgr.mr_n76012400)
print v(xbgr.mr_n76012720)
print v(xbgr.mr_n76012832)
print v(xbgr.mr_n76013152)
print v(xbgr.mr_n76013264)
print v(xbgr.mr_n76013584)
print v(xbgr.mr_n76013696)
print v(xbgr.mr_n76014016)
print v(xbgr.mr_n76014128)
print v(xbgr.mr_n76014448)
print v(xbgr.mr_n76014560)
print v(xbgr.mr_n76014880)
print v(xbgr.mr_n76014992)
print v(xbgr.mr_n76015312)
print v(xbgr.mr_n76015424)
print v(xbgr.mr_n76015744)
print v(xbgr.mr_n76015856)
print v(xbgr.mr_n76016176)
print v(xbgr.mr_n76016288)
print v(xbgr.mr_n76016608)
print v(xbgr.mr_n76016720)
print v(xbgr.mr_n76017040)
print v(xbgr.mr_n76017152)
print v(xbgr.mr_n76017472)
print v(xbgr.mr_n76017584)
print v(xbgr.mr_n76017904)
print v(xbgr.mr_n76018016)
print v(xbgr.mr_n76018336)
print v(xbgr.mr_n76018448)
print v(xbgr.mr_n76018768)
print v(xbgr.mr_n76018880)
print v(xbgr.mr_n76019200)
print v(xbgr.mr_n76019312)
print v(xbgr.mr_n76019632)
print v(xbgr.mr_n76019744)
print v(xbgr.mr_n76020064)
print v(xbgr.mr_n76020176)
print v(xbgr.mr_n76020496)
print v(xbgr.mr_n76020608)
print v(xbgr.mr_n76020928)
print v(xbgr.mr_n76021040)
print v(xbgr.mr_n76021360)
print v(xbgr.mr_n76021472)
print v(xbgr.mr_n76021792)
print v(xbgr.mr_n76021904)
print v(xbgr.mr_n76022224)
print v(xbgr.mr_n76022336)
print v(xbgr.mr_n76022656)
print v(xbgr.mr_n76022768)
print v(xbgr.mr_n76023088)
print v(xbgr.mr_n76023200)
print v(xbgr.mr_n76023520)
print v(xbgr.mr_n76023632)
print v(xbgr.mr_n76023952)
print v(xbgr.mr_n76024064)
print v(xbgr.mr_n76024384)
print v(xbgr.mr_n76024496)
print v(xbgr.mr_n76024816)
print v(xbgr.mr_n76024928)
print v(xbgr.mr_n76025248)
print v(xbgr.mr_n76025360)
print v(xbgr.mr_n76025680)
print v(xbgr.mr_n76025792)
print v(xbgr.mr_n76026112)
print v(xbgr.mr_n76026224)
print v(xbgr.mr_n76026544)
print v(xbgr.mr_n76026656)
print v(xbgr.mr_n76026976)
print v(xbgr.mr_n76027088)
print v(xbgr.mr_n76027408)
print v(xbgr.mr_n76027520)
print v(xbgr.mr_n76027840)
print v(xbgr.mr_n76027952)
print v(xbgr.mr_n76028272)
print v(xbgr.mr_n76028384)
print v(xbgr.mr_n76028704)
print v(xbgr.mr_n76028816)
print v(xbgr.mr_n76029136)
print v(xbgr.mr_n76029248)
print v(xbgr.mr_n76029568)
print v(xbgr.mr_n76029680)
print v(xbgr.mr_n76030000)
print v(xbgr.mr_n76030112)
print v(xbgr.mr_n76030432)
print v(xbgr.mr_n76030544)
print v(xbgr.mr_n76030864)
print v(xbgr.mr_n76030976)
print v(xbgr.mr_n76031296)
print v(xbgr.mr_n76031408)
print v(xbgr.mr_n76031728)
print v(xbgr.mr_n76031840)
print v(xbgr.mr_n76032160)
print v(xbgr.mr_n76032272)
print v(xbgr.mr_n76032592)
print v(xbgr.mr_n76032704)
print v(xbgr.mr_n76033024)
print v(xbgr.mr_n76033136)
print v(xbgr.mr_n76033456)
print v(xbgr.mr_n76033568)
print v(xbgr.mr_n76033888)
print v(xbgr.mr_n76034000)
print v(xbgr.mr_n76034320)
print v(xbgr.mr_n76034432)
print v(xbgr.mr_n76034752)
print v(xbgr.mr_n76034864)
print v(xbgr.mr_n76035184)
print v(xbgr.mr_n76035296)
print v(xbgr.mr_n76035616)
print v(xbgr.mr_n76035728)
print v(xbgr.mr_n76036048)
print v(xbgr.mr_n76036160)
print v(xbgr.mr_n76036480)
print v(xbgr.mr_n76036592)
print v(xbgr.mr_n76036912)
print v(xbgr.mr_n76037024)
print v(xbgr.mr_n76037344)
print v(xbgr.mr_n76037456)
print v(xbgr.mr_n76037776)
print v(xbgr.mr_n76037888)
print v(xbgr.mr_n76038208)
print v(xbgr.mr_n76038320)
print v(xbgr.mr_n76038640)
print v(xbgr.mr_n76038752)
print v(xbgr.mr_n76039072)
print v(xbgr.mr_n76039184)
print v(xbgr.mr_n76039504)
print v(xbgr.mr_n76039616)
print v(xbgr.mr_n76039936)
print v(xbgr.mr_n76040048)
print v(xbgr.mr_n76040368)
print v(xbgr.mr_n76040480)
print v(xbgr.mr_n76040912)
print v(xbgr.mr_n76041232)
print v(xbgr.mr_n76041344)
print v(xbgr.mr_n76041664)
print v(xbgr.mr_n76041776)
print v(xbgr.mr_n76042096)
print v(xbgr.mr_n76042208)
print v(xbgr.mr_n76042640)
print v(xbgr.mr_n76042960)
print v(xbgr.mr_n76043072)
print v(xbgr.mr_n76043392)
print v(xbgr.mr_n76043504)
print v(xbgr.mr_n76043824)
print v(xbgr.mr_n76043936)
print v(xbgr.mr_n76044368)
print v(xbgr.mr_n76044688)
print v(xbgr.mr_n76044800)
print v(xbgr.mr_n76045120)
print v(xbgr.mr_n76045232)
print v(xbgr.mr_n76045552)
print v(xbgr.mr_n76045664)
print v(xbgr.mr_n76045984)
print v(xbgr.mr_n76046096)
print v(xbgr.mr_n76046416)
print v(xbgr.mr_n76046528)
print v(xbgr.mr_n76046848)
print v(xbgr.mr_n76046960)
print v(xbgr.mr_n76047280)
print v(xbgr.mr_n76047392)
print v(xbgr.mr_n76047712)
print v(xbgr.mr_n76047824)
print v(xbgr.mr_n76048144)
print v(xbgr.mr_n76048256)
print v(xbgr.mr_n76048576)
print v(xbgr.mr_n76048688)
print v(xbgr.mr_n76049008)
print v(xbgr.mr_n76049120)
print v(xbgr.mr_n76049440)
print v(xbgr.mr_n76049552)
print v(xbgr.mr_n76049872)
print v(xbgr.mr_n76049984)
print v(xbgr.mr_n76050304)
print v(xbgr.mr_n76050416)
print v(xbgr.mr_n76050736)
print v(xbgr.mr_n76050848)
print v(xbgr.mr_n76051168)
print v(xbgr.mr_n76051280)
print v(xbgr.mr_n76051600)
print v(xbgr.mr_n76051712)
print v(xbgr.mr_n76052032)
print v(xbgr.mr_n76052144)
print v(xbgr.mr_n76052464)
print v(xbgr.mr_n76052576)
print v(xbgr.mr_n76052896)
print v(xbgr.mr_n76053008)
print v(xbgr.mr_n76053328)
print v(xbgr.mr_n76053440)
print v(xbgr.mr_n76053760)
print v(xbgr.mr_n76053872)
print v(xbgr.mr_n76054192)
print v(xbgr.mr_n76054304)
print v(xbgr.mr_n76054624)
print v(xbgr.mr_n76054736)
print v(xbgr.mr_n76055056)
print v(xbgr.mr_n76055168)
print v(xbgr.mr_n76055488)
print v(xbgr.mr_n76055600)
print v(xbgr.mr_n76055920)
print v(xbgr.mr_n76056032)
print v(xbgr.mr_n76056352)
print v(xbgr.mr_n76056464)
print v(xbgr.mr_n76056784)
print v(xbgr.mr_n76056896)
print v(xbgr.mr_n76057216)
print v(xbgr.mr_n76057328)
print v(xbgr.mr_n76057648)
print v(xbgr.mr_n76057760)
print v(xbgr.mr_n76058080)
print v(xbgr.mr_n76058192)
print v(xbgr.mr_n76058512)
print v(xbgr.mr_n76058624)
print v(xbgr.mr_n76058944)
print v(xbgr.mr_n76059056)
print v(xbgr.mr_n76059376)
print v(xbgr.mr_n76059488)
print v(xbgr.mr_n76059808)
print v(xbgr.mr_n76059920)
print v(xbgr.mr_n76060240)
print v(xbgr.mr_n76060352)
print v(xbgr.mr_n76060672)
print v(xbgr.mr_n76060784)
print v(xbgr.mr_n76061104)
print v(xbgr.mr_n76061216)
print v(xbgr.mr_n76061536)
print v(xbgr.mr_n76061648)
print v(xbgr.mr_n76061968)
print v(xbgr.mr_n76062080)
print v(xbgr.mr_n76062400)
print v(xbgr.mr_n76062512)
print v(xbgr.mr_n76062832)
print v(xbgr.mr_n76062944)
print v(xbgr.mr_n76063264)
print v(xbgr.mr_n76063376)
print v(xbgr.mr_n76063696)
print v(xbgr.mr_n76063808)
print v(xbgr.mr_n76064128)
print v(xbgr.mr_n76064240)
print v(xbgr.mr_n76064672)
print v(xbgr.mr_n76065104)
print v(xbgr.mr_n76065536)
print v(xbgr.mr_n76065968)
print v(xbgr.mr_n76066400)
print v(xbgr.mr_n76066832)
print v(xbgr.mr_n76067264)
print v(xbgr.mr_n76067696)
print v(xbgr.mr_n76068128)
print v(xbgr.mr_n76068560)
print v(xbgr.mr_n76068992)
print v(xbgr.mr_n76069424)
print v(xbgr.mr_n76069856)
print v(xbgr.mr_n76070288)
print v(xbgr.mr_n76070720)
print v(xbgr.mr_n76071152)
print v(xbgr.mr_n76071584)
print v(xbgr.mr_n76072016)
print v(xbgr.mr_n76072448)
print v(xbgr.mr_n76072880)
print v(xbgr.mr_n76073312)
print v(xbgr.mr_n76073744)
print v(xbgr.mr_n76074176)
print v(xbgr.mr_n76074608)
print v(xbgr.mr_n76075040)
print v(xbgr.mr_n76075472)
print v(xbgr.mr_n76075904)
print v(xbgr.mr_n76076336)
print v(xbgr.mr_n76076768)
print v(xbgr.mr_n76077200)
print v(xbgr.mr_n76077632)
print v(xbgr.mr_n76078064)
print v(xbgr.mr_n76078496)
print v(xbgr.mr_n76078928)
print v(xbgr.mr_n76079360)
print v(xbgr.mr_n76079792)
print v(xbgr.mr_n76080224)
print v(xbgr.mr_n76080656)
print v(xbgr.mr_n76081088)
print v(xbgr.mr_n76081520)
print v(xbgr.mr_n76081952)
print v(xbgr.mr_n76082384)
print v(xbgr.mr_n76082816)
print v(xbgr.mr_n76083248)
print v(xbgr.mr_n76083680)
print v(xbgr.mr_n76084112)
print v(xbgr.mr_n76084544)
print v(xbgr.mr_n76084976)
print v(xbgr.mr_n76085408)
print v(xbgr.mr_n76085840)
print v(xbgr.mr_n76086272)
print v(xbgr.mr_n76086704)
print v(xbgr.mr_n76087136)
print v(xbgr.mr_n76087568)
print v(xbgr.mr_n76088000)
print v(xbgr.mr_n76088432)
print v(xbgr.mr_n76088864)
print v(xbgr.mr_n76089296)
print v(xbgr.mr_n76089728)
print v(xbgr.mr_n76090160)
print v(xbgr.mr_n76090592)
print v(xbgr.mr_n76091024)
print v(xbgr.mr_n76091456)
print v(xbgr.mr_n76091888)
print v(xbgr.mr_n76092320)
print v(xbgr.mr_n76092752)
print v(xbgr.mr_n76093184)
print v(xbgr.mr_n76093616)
print v(xbgr.mr_n76094048)
print v(xbgr.mr_n76094480)
print v(xbgr.mr_n76094912)
print v(xbgr.mr_n76095344)
print v(xbgr.mr_n76095776)
print v(xbgr.mr_n76096208)
print v(xbgr.mr_n76096640)
print v(xbgr.mr_n76097072)
print v(xbgr.mr_n76097504)
print v(xbgr.mr_n76097936)
print v(xbgr.mr_n76098368)
print v(xbgr.mr_n76098800)
print v(xbgr.mr_n76099120)
print v(xbgr.mr_n76099232)
print v(xbgr.mr_n76099664)
print v(xbgr.mr_n76099984)
print v(xbgr.mr_n76100096)
print v(xbgr.mr_n76100416)
print v(xbgr.mr_n76100528)
print v(xbgr.mr_n76100848)
print v(xbgr.mr_n76100960)
print v(xbgr.mr_n76101280)
print v(xbgr.mr_n76101392)
print v(xbgr.mr_n76101712)
print v(xbgr.mr_n76101824)
print v(xbgr.mr_n76102144)
print v(xbgr.mr_n76102256)
print v(xbgr.mr_n76102576)
print v(xbgr.mr_n76102688)
print v(xbgr.mr_n76103008)
print v(xbgr.mr_n76103120)
print v(xbgr.mr_n76103440)
print v(xbgr.mr_n76103552)
print v(xbgr.mr_n76103872)
print v(xbgr.mr_n76103984)
print v(xbgr.mr_n76104416)
print v(xbgr.mr_n76104848)
print v(xbgr.mr_n76105280)
print v(xbgr.mr_n76105712)
print v(xbgr.mr_n76106144)
print v(xbgr.mr_n76106576)
print v(xbgr.mr_n76107008)
print v(xbgr.mr_n76107440)
print v(xbgr.mr_n76107872)
print v(xbgr.mr_n76108304)
print v(xbgr.mr_n76108736)
print v(xbgr.mr_n76109168)
print v(xbgr.mr_n76109600)
print v(xbgr.mr_n76110032)
print v(xbgr.mr_n76110464)
print v(xbgr.mr_n76110896)
print v(xbgr.mr_n76111328)
print v(xbgr.mr_n76111760)
print v(xbgr.mr_n76112192)
print v(xbgr.mr_n76112624)
print v(xbgr.mr_n76113056)
print v(xbgr.mr_n76113488)
print v(xbgr.mr_n76113920)
print v(xbgr.mr_n76114352)
print v(xbgr.mr_n76114784)
print v(xbgr.mr_n76115216)
print v(xbgr.mr_n76115648)
print v(xbgr.mr_n76115920)
print v(xbgr.mr_n76116032)
print v(xbgr.mr_n76116352)
print v(xbgr.mr_n76116464)
print v(xbgr.mr_n76116784)
print v(xbgr.mr_n76116896)
print v(xbgr.mr_n76117216)
print v(xbgr.mr_n76117328)
print v(xbgr.mr_n76117648)
print v(xbgr.mr_n76117760)
print v(xbgr.mr_n76118080)
print v(xbgr.mr_n76118192)
print v(xbgr.mr_n76118512)
print v(xbgr.mr_n76118624)
print v(xbgr.mr_n76118944)
print v(xbgr.mr_n76119056)
print v(xbgr.mr_n76119376)
print v(xbgr.mr_n76119488)
print v(xbgr.mr_n76119808)
print v(xbgr.mr_n76119920)
print v(xbgr.mr_n76120240)
print v(xbgr.mr_n76120352)
print v(xbgr.mr_n76120672)
print v(xbgr.mr_n76120784)
print v(xbgr.mr_n76121104)
print v(xbgr.mr_n76121216)
print v(xbgr.mr_n76121536)
print v(xbgr.mr_n76121648)
print v(xbgr.mr_n76121968)
print v(xbgr.mr_n76122080)
print v(xbgr.mr_n76122400)
print v(xbgr.mr_n76122512)
print v(xbgr.mr_n76122832)
print v(xbgr.mr_n76122944)
print v(xbgr.mr_n76123264)
print v(xbgr.mr_n76123376)
print v(xbgr.mr_n76123696)
print v(xbgr.mr_n76123808)
print v(xbgr.mr_n76124128)
print v(xbgr.mr_n76124240)
print v(xbgr.mr_n76124560)
print v(xbgr.mr_n76124672)
print v(xbgr.mr_n76124992)
print v(xbgr.mr_n76125104)
print v(xbgr.mr_n76125424)
print v(xbgr.mr_n76125536)
print v(xbgr.mr_n76125856)
print v(xbgr.mr_n76125968)
print v(xbgr.mr_n76126288)
print v(xbgr.mr_n76126400)
print v(xbgr.mr_n76126720)
print v(xbgr.mr_n76126832)
print v(xbgr.mr_n76127152)
print v(xbgr.mr_n76127264)
print v(xbgr.mr_n76127584)
print v(xbgr.mr_n76127696)
print v(xbgr.mr_n76128016)
print v(xbgr.mr_n76128128)
print v(xbgr.mr_n76128448)
print v(xbgr.mr_n76128560)
print v(xbgr.mr_n76128880)
print v(xbgr.mr_n76128992)
print v(xbgr.mr_n76129312)
print v(xbgr.mr_n76129424)
print v(xbgr.mr_n76129744)
print v(xbgr.mr_n76129856)
print v(xbgr.mr_n76130176)
print v(xbgr.mr_n76130288)
print v(xbgr.mr_n76130608)
print v(xbgr.mr_n76130720)
print v(xbgr.mr_n76131040)
print v(xbgr.mr_n76131152)
print v(xbgr.mr_n76131472)
print v(xbgr.mr_n76131584)
print v(xbgr.mr_n76131904)
print v(xbgr.mr_n76132016)
print v(xbgr.mr_n76132336)
print v(xbgr.mr_n76132448)
print v(xbgr.mr_n76132768)
print v(xbgr.mr_n76132880)
print v(xbgr.mr_n76133200)
print v(xbgr.mr_n76133312)
print v(xbgr.mr_n76133632)
print v(xbgr.mr_n76133744)
print v(xbgr.mr_n76134064)
print v(xbgr.mr_n76134176)
print v(xbgr.mr_n76134496)
print v(xbgr.mr_n76134608)
print v(xbgr.mr_n76134928)
print v(xbgr.mr_n76135040)
print v(xbgr.mr_n76135360)
print v(xbgr.mr_n76135472)
print v(xbgr.mr_n76135792)
print v(xbgr.mr_n76135904)
print v(xbgr.mr_n76136224)
print v(xbgr.mr_n76136336)
print v(xbgr.mr_n76136656)
print v(xbgr.mr_n76136768)
print v(xbgr.mr_n76137088)
print v(xbgr.mr_n76137200)
print v(xbgr.mr_n76137520)
print v(xbgr.mr_n76137632)
print v(xbgr.mr_n76137952)
print v(xbgr.mr_n76138064)
print v(xbgr.mr_n76138384)
print v(xbgr.mr_n76138496)
print v(xbgr.mr_n76138816)
print v(xbgr.mr_n76138928)
print v(xbgr.mr_n76139248)
print v(xbgr.mr_n76139360)
print v(xbgr.mr_n76139680)
print v(xbgr.mr_n76139792)
print v(xbgr.mr_n76140112)
print v(xbgr.mr_n76140224)
print v(xbgr.mr_n76140544)
print v(xbgr.mr_n76140656)
print v(xbgr.mr_n76140976)
print v(xbgr.mr_n76141088)
print v(xbgr.mr_n76141408)
print v(xbgr.mr_n76141520)
print v(xbgr.mr_n76141840)
print v(xbgr.mr_n76141952)
print v(xbgr.mr_n76142272)
print v(xbgr.mr_n76142384)
print v(xbgr.mr_n76142704)
print v(xbgr.mr_n76142816)
print v(xbgr.mr_n76143136)
print v(xbgr.mr_n76143248)
print v(xbgr.mr_n76143568)
print v(xbgr.mr_n76143680)
print v(xbgr.mr_n76144000)
print v(xbgr.mr_n76144112)
print v(xbgr.mr_n76144432)
print v(xbgr.mr_n76144544)
print v(xbgr.mr_n76144864)
print v(xbgr.mr_n76144976)
print v(xbgr.mr_n76145296)
print v(xbgr.mr_n76145408)
print v(xbgr.mr_n76145728)
print v(xbgr.mr_n76145840)
print v(xbgr.mr_n76146160)
print v(xbgr.mr_n76146272)
print v(xbgr.mr_n76146592)
print v(xbgr.mr_n76146704)
print v(xbgr.mr_n76147024)
print v(xbgr.mr_n76147136)
print v(xbgr.mr_n76147456)
print v(xbgr.mr_n76147568)
print v(xbgr.mr_n76147888)
print v(xbgr.mr_n76148000)
print v(xbgr.mr_n76148320)
print v(xbgr.mr_n76148432)
print v(xbgr.mr_n76148752)
print v(xbgr.mr_n76148864)
print v(xbgr.mr_n76149184)
print v(xbgr.mr_n76149296)
print v(xbgr.mr_n76149616)
print v(xbgr.mr_n76149728)
print v(xbgr.mr_n76150048)
print v(xbgr.mr_n76150160)
print v(xbgr.mr_n76150480)
print v(xbgr.mr_n76150592)
print v(xbgr.mr_n76150912)
print v(xbgr.mr_n76151024)
print v(xbgr.mr_n76151344)
print v(xbgr.mr_n76151456)
print v(xbgr.mr_n76151776)
print v(xbgr.mr_n76151888)
print v(xbgr.mr_n76152208)
print v(xbgr.mr_n76152320)
print v(xbgr.mr_n76152640)
print v(xbgr.mr_n76152752)
print v(xbgr.mr_n76153072)
print v(xbgr.mr_n76153184)
print v(xbgr.mr_n76153504)
print v(xbgr.mr_n76153616)
print v(xbgr.mr_n76153936)
print v(xbgr.mr_n76154048)
print v(xbgr.mr_n76154368)
print v(xbgr.mr_n76154480)
print v(xbgr.mr_n76154800)
print v(xbgr.mr_n76154912)
print v(xbgr.mr_n76155232)
print v(xbgr.mr_n76155344)
print v(xbgr.mr_n76155664)
print v(xbgr.mr_n76155776)
print v(xbgr.mr_n76156096)
print v(xbgr.mr_n76156208)
print v(xbgr.mr_n76156528)
print v(xbgr.mr_n76156640)
print v(xbgr.mr_n76156960)
print v(xbgr.mr_n76157072)
print v(xbgr.mr_n76157392)
print v(xbgr.mr_n76157504)
print v(xbgr.mr_n76157824)
print v(xbgr.mr_n76157936)
print v(xbgr.mr_n76158256)
print v(xbgr.mr_n76158368)
print v(xbgr.mr_n76158688)
print v(xbgr.mr_n76158800)
print v(xbgr.mr_n76159120)
print v(xbgr.mr_n76159232)
print v(xbgr.mr_n76159552)
print v(xbgr.mr_n76159664)
print v(xbgr.mr_n76159984)
print v(xbgr.mr_n76160096)
print v(xbgr.mr_n76160416)
print v(xbgr.mr_n76160528)
print v(xbgr.mr_n76160848)
print v(xbgr.mr_n76160960)
print v(xbgr.mr_n76161280)
print v(xbgr.mr_n76161392)
print v(xbgr.mr_n76161712)
print v(xbgr.mr_n76161824)
print v(xbgr.mr_n76162144)
print v(xbgr.mr_n76162256)
print v(xbgr.mr_n76162576)
print v(xbgr.mr_n76162688)
print v(xbgr.mr_n76163008)
print v(xbgr.mr_n76163120)
print v(xbgr.mr_n76163440)
print v(xbgr.mr_n76163552)
print v(xbgr.mr_n76163872)
print v(xbgr.mr_n76163984)
print v(xbgr.mr_n76164304)
print v(xbgr.mr_n76164416)
print v(xbgr.mr_n76164736)
print v(xbgr.mr_n76164848)
print v(xbgr.mr_n76165168)
print v(xbgr.mr_n76165280)
print v(xbgr.mr_n76165600)
print v(xbgr.mr_n76165712)
print v(xbgr.mr_n76166032)
print v(xbgr.mr_n76166144)
print v(xbgr.mr_n76166464)
print v(xbgr.mr_n76166576)
print v(xbgr.mr_n76166896)
print v(xbgr.mr_n76167008)
print v(xbgr.mr_n76167328)
print v(xbgr.mr_n76167440)
print v(xbgr.mr_n76167760)
print v(xbgr.mr_n76167872)
print v(xbgr.mr_n76168192)
print v(xbgr.mr_n76168304)
print v(xbgr.mr_n76168624)
print v(xbgr.mr_n76168736)
print v(xbgr.mr_n76169056)
print v(xbgr.mr_n76169168)
print v(xbgr.mr_n76169488)
print v(xbgr.mr_n76169600)
print v(xbgr.mr_n76169920)
print v(xbgr.mr_n76170032)
print v(xbgr.mr_n76170352)
print v(xbgr.mr_n76170464)
print v(xbgr.mr_n76170784)
print v(xbgr.mr_n76170896)
print v(xbgr.mr_n76171216)
print v(xbgr.mr_n76171328)
print v(xbgr.mr_n76171648)
print v(xbgr.mr_n76171760)
print v(xbgr.mr_n76172080)
print v(xbgr.mr_n76172192)
print v(xbgr.mr_n76172512)
print v(xbgr.mr_n76172624)
print v(xbgr.mr_n76172944)
print v(xbgr.mr_n76173056)
print v(xbgr.mr_n76173376)
print v(xbgr.mr_n76173488)
print v(xbgr.mr_n76173808)
print v(xbgr.mr_n76173920)
print v(xbgr.mr_n76174240)
print v(xbgr.mr_n76174352)
print v(xbgr.mr_n76174672)
print v(xbgr.mr_n76174784)
print v(xbgr.mr_n76175104)
print v(xbgr.mr_n76175216)
print v(xbgr.mr_n76175536)
print v(xbgr.mr_n76175648)
print v(xbgr.mr_n76175968)
print v(xbgr.mr_n76176080)
print v(xbgr.mr_n76176400)
print v(xbgr.mr_n76176512)
print v(xbgr.mr_n76176832)
print v(xbgr.mr_n76176944)
print v(xbgr.mr_n76177264)
print v(xbgr.mr_n76177376)
print v(xbgr.mr_n76177696)
print v(xbgr.mr_n76177808)
print v(xbgr.mr_n76178128)
print v(xbgr.mr_n76178240)
print v(xbgr.mr_n76178560)
print v(xbgr.mr_n76178672)
print v(xbgr.mr_n76178992)
print v(xbgr.mr_n76179104)
print v(xbgr.mr_n76179424)
print v(xbgr.mr_n76179536)
print v(xbgr.mr_n76179856)
print v(xbgr.mr_n76179968)
print v(xbgr.mr_n76180288)
print v(xbgr.mr_n76180400)
print v(xbgr.mr_n76180720)
print v(xbgr.mr_n76180832)
print v(xbgr.mr_n76181152)
print v(xbgr.mr_n76181264)
print v(xbgr.mr_n76181584)
print v(xbgr.mr_n76181696)
print v(xbgr.mr_n76182016)
print v(xbgr.mr_n76182128)
print v(xbgr.mr_n76182448)
print v(xbgr.mr_n76182560)
print v(xbgr.mr_n76182880)
print v(xbgr.mr_n76182992)
print v(xbgr.mr_n76183312)
print v(xbgr.mr_n76183424)
print v(xbgr.mr_n76183744)
print v(xbgr.mr_n76183856)
print v(xbgr.mr_n76184176)
print v(xbgr.mr_n76184288)
print v(xbgr.mr_n76184608)
print v(xbgr.mr_n76184720)
print v(xbgr.mr_n76185040)
print v(xbgr.mr_n76185152)
print v(xbgr.mr_n76185472)
print v(xbgr.mr_n76185584)
print v(xbgr.mr_n76185904)
print v(xbgr.mr_n76186016)
print v(xbgr.mr_n76186336)
print v(xbgr.mr_n76186448)
print v(xbgr.mr_n76186768)
print v(xbgr.mr_n76186880)
print v(xbgr.mr_n76187200)
print v(xbgr.mr_n76187312)
print v(xbgr.mr_n76187632)
print v(xbgr.mr_n76187744)
print v(xbgr.mr_n76188064)
print v(xbgr.mr_n76188176)
print v(xbgr.mr_n76188496)
print v(xbgr.mr_n76188608)
print v(xbgr.mr_n76188928)
print v(xbgr.mr_n76189040)
print v(xbgr.mr_n76189360)
print v(xbgr.mr_n76189472)
print v(xbgr.mr_n76189792)
print v(xbgr.mr_n76189904)
print v(xbgr.mr_n76190224)
print v(xbgr.mr_n76190336)
print v(xbgr.mr_n76190656)
print v(xbgr.mr_n76190768)
print v(xbgr.mr_n76191088)
print v(xbgr.mr_n76191200)
print v(xbgr.mr_n76191520)
print v(xbgr.mr_n76191632)
print v(xbgr.mr_n76191952)
print v(xbgr.mr_n76192064)
print v(xbgr.mr_n76192384)
print v(xbgr.mr_n76192496)
print v(xbgr.mr_n76192816)
print v(xbgr.mr_n76192928)
print v(xbgr.mr_n76193248)
print v(xbgr.mr_n76193360)
print v(xbgr.mr_n76193680)
print v(xbgr.mr_n76193792)
print v(xbgr.mr_n76194112)
print v(xbgr.mr_n76194224)
print v(xbgr.mr_n76194544)
print v(xbgr.mr_n76194656)
print v(xbgr.mr_n76194976)
print v(xbgr.mr_n76195088)
print v(xbgr.mr_n76195408)
print v(xbgr.mr_n76195520)
print v(xbgr.mr_n76195840)
print v(xbgr.mr_n76195952)
print v(xbgr.mr_n76196272)
print v(xbgr.mr_n76196384)
print v(xbgr.mr_n76196704)
print v(xbgr.mr_n76196816)
print v(xbgr.mr_n76197136)
print v(xbgr.mr_n76197248)
print v(xbgr.mr_n76197568)
print v(xbgr.mr_n76197680)
print v(xbgr.mr_n76198000)
print v(xbgr.mr_n76198112)
print v(xbgr.mr_n76198432)
print v(xbgr.mr_n76198544)
print v(xbgr.mr_n76198864)
print v(xbgr.mr_n76198976)
print v(xbgr.mr_n76199296)
print v(xbgr.mr_n76199408)
print v(xbgr.mr_n76199728)
print v(xbgr.mr_n76199840)
print v(xbgr.mr_n76200160)
print v(xbgr.mr_n76200272)
print v(xbgr.mr_n76200704)
print v(xbgr.mr_n76201024)
print v(xbgr.mr_n76201136)
print v(xbgr.mr_n76201456)
print v(xbgr.mr_n76201568)
print v(xbgr.mr_n76201888)
print v(xbgr.mr_n76202000)
print v(xbgr.mr_n76202432)
print v(xbgr.mr_n76202752)
print v(xbgr.mr_n76202864)
print v(xbgr.mr_n76203184)
print v(xbgr.mr_n76203296)
print v(xbgr.mr_n76203616)
print v(xbgr.mr_n76203728)
print v(xbgr.mr_n76204160)
print v(xbgr.mr_n76204480)
print v(xbgr.mr_n76204592)
print v(xbgr.mr_n76204912)
print v(xbgr.mr_n76205024)
print v(xbgr.mr_n76205344)
print v(xbgr.mr_n76205456)
print v(xbgr.mr_n76205888)
print v(xbgr.mr_n76206208)
print v(xbgr.mr_n76206320)
print v(xbgr.mr_n76206640)
print v(xbgr.mr_n76206752)
print v(xbgr.mr_n76207072)
print v(xbgr.mr_n76207184)
print v(xbgr.mr_n76207616)
print v(xbgr.mr_n76207936)
print v(xbgr.mr_n76208048)
print v(xbgr.mr_n76208368)
print v(xbgr.mr_n76208480)
print v(xbgr.mr_n76208800)
print v(xbgr.mr_n76208912)
print v(xbgr.mr_n76209344)
print v(xbgr.mr_n76209664)
print v(xbgr.mr_n76209776)
print v(xbgr.mr_n76210096)
print v(xbgr.mr_n76210208)
print v(xbgr.mr_n76210528)
print v(xbgr.mr_n76210640)
print v(xbgr.mr_n76211072)
print v(xbgr.mr_n76211392)
print v(xbgr.mr_n76211504)
print v(xbgr.mr_n76211824)
print v(xbgr.mr_n76211936)
print v(xbgr.mr_n76212256)
print v(xbgr.mr_n76212368)
print v(xbgr.mr_n76212800)
print v(xbgr.mr_n76213120)
print v(xbgr.mr_n76213232)
print v(xbgr.mr_n76213552)
print v(xbgr.mr_n76213664)
print v(xbgr.mr_n76213984)
print v(xbgr.mr_n76214096)
print v(xbgr.mr_n76214416)
print v(xbgr.mr_n76214528)
print v(xbgr.mr_n76214848)
print v(xbgr.mr_n76214960)
print v(xbgr.mr_n76215280)
print v(xbgr.mr_n76215392)
print v(xbgr.mr_n76215712)
print v(xbgr.mr_n76215824)
print v(xbgr.mr_n76216144)
print v(xbgr.mr_n76216256)
print v(xbgr.mr_n76216576)
print v(xbgr.mr_n76216688)
print v(xbgr.mr_n76217008)
print v(xbgr.mr_n76217120)
print v(xbgr.mr_n76217440)
print v(xbgr.mr_n76217552)
print v(xbgr.mr_n76217872)
print v(xbgr.mr_n76217984)
print v(xbgr.mr_n76218304)
print v(xbgr.mr_n76218416)
print v(xbgr.mr_n76218736)
print v(xbgr.mr_n76218848)
print v(xbgr.mr_n76219168)
print v(xbgr.mr_n76219280)
print v(xbgr.mr_n76219600)
print v(xbgr.mr_n76219712)
print v(xbgr.mr_n76220032)
print v(xbgr.mr_n76220144)
print v(xbgr.mr_n76220464)
print v(xbgr.mr_n76220576)
print v(xbgr.mr_n76220896)
print v(xbgr.mr_n76221008)
print v(xbgr.mr_n76221328)
print v(xbgr.mr_n76221440)
print v(xbgr.mr_n76221760)
print v(xbgr.mr_n76221872)
print v(xbgr.mr_n76222192)
print v(xbgr.mr_n76222304)
print v(xbgr.mr_n76222624)
print v(xbgr.mr_n76222736)
print v(xbgr.mr_n76223056)
print v(xbgr.mr_n76223168)
print v(xbgr.mr_n76223488)
print v(xbgr.mr_n76223600)
print v(xbgr.mr_n76223920)
print v(xbgr.mr_n76224032)
print v(xbgr.mr_n76224352)
print v(xbgr.mr_n76224464)
print v(xbgr.mr_n76224784)
print v(xbgr.mr_n76224896)
print v(xbgr.mr_n76225216)
print v(xbgr.mr_n76225328)
print v(xbgr.mr_n76225648)
print v(xbgr.mr_n76225760)
print v(xbgr.mr_n76226080)
print v(xbgr.mr_n76226192)
print v(xbgr.mr_n76226512)
print v(xbgr.mr_n76226624)
print v(xbgr.mr_n76226944)
print v(xbgr.mr_n76227056)
print v(xbgr.mr_n76227376)
print v(xbgr.mr_n76227488)
print v(xbgr.mr_n76227808)
print v(xbgr.mr_n76227920)
print v(xbgr.mr_n76228240)
print v(xbgr.mr_n76228352)
print v(xbgr.mr_n76228672)
print v(xbgr.mr_n76228784)
print v(xbgr.mr_n76229104)
print v(xbgr.mr_n76229216)
print v(xbgr.mr_n76229536)
print v(xbgr.mr_n76229648)
print v(xbgr.mr_n76229968)
print v(xbgr.mr_n76230080)
print v(xbgr.mr_n76230400)
print v(xbgr.mr_n76230512)
print v(xbgr.mr_n76230832)
print v(xbgr.mr_n76230944)
print v(xbgr.mr_n76231264)
print v(xbgr.mr_n76231376)
print v(xbgr.mr_n76231696)
print v(xbgr.mr_n76231808)
print v(xbgr.mr_n76232128)
print v(xbgr.mr_n76232240)
print v(xbgr.mr_n76232560)
print v(xbgr.mr_n76232672)
print v(xbgr.mr_n76232992)
print v(xbgr.mr_n76233104)
print v(xbgr.mr_n76233424)
print v(xbgr.mr_n76233536)
print v(xbgr.mr_n76233856)
print v(xbgr.mr_n76233968)
print v(xbgr.mr_n76234288)
print v(xbgr.mr_n76234400)
print v(xbgr.mr_n76234720)
print v(xbgr.mr_n76234832)
print v(xbgr.mr_n76235152)
print v(xbgr.mr_n76235264)
print v(xbgr.mr_n76235584)
print v(xbgr.mr_n76235696)
print v(xbgr.mr_n76236016)
print v(xbgr.mr_n76236128)
print v(xbgr.mr_n76236448)
print v(xbgr.mr_n76236560)
print v(xbgr.mr_n76236880)
print v(xbgr.mr_n76236992)
print v(xbgr.mr_n76237312)
print v(xbgr.mr_n76237424)
print v(xbgr.mr_n76237744)
print v(xbgr.mr_n76237856)
print v(xbgr.mr_n76238176)
print v(xbgr.mr_n76238288)
print v(xbgr.mr_n76238608)
print v(xbgr.mr_n76238720)
print v(xbgr.mr_n76239040)
print v(xbgr.mr_n76239152)
print v(xbgr.mr_n76239472)
print v(xbgr.mr_n76239584)
print v(xbgr.mr_n76239904)
print v(xbgr.mr_n76240016)
print v(xbgr.mr_n76240336)
print v(xbgr.mr_n76240448)
print v(xbgr.mr_n76240768)
print v(xbgr.mr_n76240880)
print v(xbgr.mr_n76241200)
print v(xbgr.mr_n76241312)
print v(xbgr.mr_n76241632)
print v(xbgr.mr_n76241744)
print v(xbgr.mr_n76242064)
print v(xbgr.mr_n76242176)
print v(xbgr.mr_n76242496)
print v(xbgr.mr_n76242608)
print v(xbgr.mr_n76243040)
print v(xbgr.mr_n76243360)
print v(xbgr.mr_n76243472)
print v(xbgr.mr_n76243792)
print v(xbgr.mr_n76243904)
print v(xbgr.mr_n76244224)
print v(xbgr.mr_n76244336)
print v(xbgr.mr_n76244768)
print v(xbgr.mr_n76245088)
print v(xbgr.mr_n76245200)
print v(xbgr.mr_n76245520)
print v(xbgr.mr_n76245632)
print v(xbgr.mr_n76245952)
print v(xbgr.mr_n76246064)
print v(xbgr.mr_n76246496)
print v(xbgr.mr_n76246816)
print v(xbgr.mr_n76246928)
print v(xbgr.mr_n76247248)
print v(xbgr.mr_n76247360)
print v(xbgr.mr_n76247680)
print v(xbgr.mr_n76247792)
print v(xbgr.mr_n76248112)
print v(xbgr.mr_n76248224)
print v(xbgr.mr_n76248544)
print v(xbgr.mr_n76248656)
print v(xbgr.mr_n76248976)
print v(xbgr.mr_n76249088)
print v(xbgr.mr_n76249408)
print v(xbgr.mr_n76249520)
print v(xbgr.mr_n76249840)
print v(xbgr.mr_n76249952)
print v(xbgr.mr_n76250272)
print v(xbgr.mr_n76250384)
print v(xbgr.mr_n76250816)
print v(xbgr.mr_n76251136)
print v(xbgr.mr_n76251248)
print v(xbgr.mr_n76251680)
print v(xbgr.mr_n76252000)
print v(xbgr.mr_n76252112)
print v(xbgr.mr_n76252544)
print v(xbgr.mr_n76252864)
print v(xbgr.mr_n76252976)
print v(xbgr.mr_n76253296)
print v(xbgr.mr_n76253408)
print v(xbgr.mr_n76253728)
print v(xbgr.mr_n76253840)
print v(xbgr.mr_n76254272)
print v(xbgr.mr_n76254592)
print v(xbgr.mr_n76254704)
print v(xbgr.mr_n76255024)
print v(xbgr.mr_n76255136)
print v(xbgr.mr_n76255456)
print v(xbgr.mr_n76255568)
print v(xbgr.mr_n76255888)
print v(xbgr.mr_n76256000)
print v(xbgr.mr_n76256320)
print v(xbgr.mr_n76256432)
print v(xbgr.mr_n76256864)
print v(xbgr.mr_n76257184)
print v(xbgr.mr_n76257296)
print v(xbgr.mr_n76257616)
print v(xbgr.mr_n76257728)
print v(xbgr.mr_n76258048)
print v(xbgr.mr_n76258160)
print v(xbgr.mr_n76258480)
print v(xbgr.mr_n76258592)
print v(xbgr.mr_n76258912)
print v(xbgr.mr_n76259024)
print v(xbgr.mr_n76259344)
print v(xbgr.mr_n76259456)
print v(xbgr.mr_n76259776)
print v(xbgr.mr_n76259888)
print v(xbgr.mr_n76260208)
print v(xbgr.mr_n76260320)
print v(xbgr.mr_n76260640)
print v(xbgr.mr_n76260752)
print v(xbgr.mr_n76261072)
print v(xbgr.mr_n76261184)
print v(xbgr.mr_n76261504)
print v(xbgr.mr_n76261616)
print v(xbgr.mr_n76261936)
print v(xbgr.mr_n76262048)
print v(xbgr.mr_n76262368)
print v(xbgr.mr_n76262480)
print v(xbgr.mr_n76262800)
print v(xbgr.mr_n76262912)
print v(xbgr.mr_n76263232)
print v(xbgr.mr_n76263344)
print v(xbgr.mr_n76263664)
print v(xbgr.mr_n76263776)
print v(xbgr.mr_n76264096)
print v(xbgr.mr_n76264208)
print v(xbgr.mr_n76264528)
print v(xbgr.mr_n76264640)
print v(xbgr.mr_n76264960)
print v(xbgr.mr_n76265072)
print v(xbgr.mr_n76265392)
print v(xbgr.mr_n76265504)
print v(xbgr.mr_n76265824)
print v(xbgr.mr_n76265936)
print v(xbgr.mr_n76266256)
print v(xbgr.mr_n76266368)
print v(xbgr.mr_n76266688)
print v(xbgr.mr_n76266800)
print v(xbgr.mr_n76267120)
print v(xbgr.mr_n76267232)
print v(xbgr.mr_n76267552)
print v(xbgr.mr_n76267664)
print v(xbgr.mr_n76267984)
print v(xbgr.mr_n76268096)
print v(xbgr.mr_n76268416)
print v(xbgr.mr_n76268528)
print v(xbgr.mr_n76268848)
print v(xbgr.mr_n76268960)
print v(xbgr.mr_n76269280)
print v(xbgr.mr_n76269392)
print v(xbgr.mr_n76269712)
print v(xbgr.mr_n76269824)
print v(xbgr.mr_n76270144)
print v(xbgr.mr_n76270256)
print v(xbgr.mr_n76270576)
print v(xbgr.mr_n76270688)
print v(xbgr.mr_n76271008)
print v(xbgr.mr_n76271120)
print v(xbgr.mr_n76271440)
print v(xbgr.mr_n76271552)
print v(xbgr.mr_n76271872)
print v(xbgr.mr_n76271984)
print v(xbgr.mr_n76272304)
print v(xbgr.mr_n76272416)
print v(xbgr.mr_n76272736)
print v(xbgr.mr_n76272848)
print v(xbgr.mr_n76273168)
print v(xbgr.mr_n76273280)
print v(xbgr.mr_n76273600)
print v(xbgr.mr_n76273712)
print v(xbgr.mr_n76274032)
print v(xbgr.mr_n76274144)
print v(xbgr.mr_n76274464)
print v(xbgr.mr_n76274576)
print v(xbgr.mr_n76274896)
print v(xbgr.mr_n76275008)
print v(xbgr.mr_n76275328)
print v(xbgr.mr_n76275440)
print v(xbgr.mr_n76275760)
print v(xbgr.mr_n76275872)
print v(xbgr.mr_n76276192)
print v(xbgr.mr_n76276304)
print v(xbgr.mr_n76276624)
print v(xbgr.mr_n76276736)
print v(xbgr.mr_n76277056)
print v(xbgr.mr_n76277168)
print v(xbgr.mr_n76277488)
print v(xbgr.mr_n76277600)
print v(xbgr.mr_n76277920)
print v(xbgr.mr_n76278032)
print v(xbgr.mr_n76278352)
print v(xbgr.mr_n76278464)
print v(xbgr.mr_n76278784)
print v(xbgr.mr_n76278896)
print v(xbgr.mr_n76279216)
print v(xbgr.mr_n76279328)
print v(xbgr.mr_n76279648)
print v(xbgr.mr_n76279760)
print v(xbgr.mr_n76280080)
print v(xbgr.mr_n76280192)
print v(xbgr.mr_n76280512)
print v(xbgr.mr_n76280624)
print v(xbgr.mr_n76280944)
print v(xbgr.mr_n76281056)
print v(xbgr.mr_n76281376)
print v(xbgr.mr_n76281488)
print v(xbgr.mr_n76281808)
print v(xbgr.mr_n76281920)
print v(xbgr.mr_n76282240)
print v(xbgr.mr_n76282352)
print v(xbgr.mr_n76282672)
print v(xbgr.mr_n76282784)
print v(xbgr.mr_n76283104)
print v(xbgr.mr_n76283216)
print v(xbgr.mr_n76283536)
print v(xbgr.mr_n76283648)
print v(xbgr.mr_n76283968)
print v(xbgr.mr_n76284080)
print v(xbgr.mr_n76284400)
print v(xbgr.mr_n76284512)
print v(xbgr.mr_n76284832)
print v(xbgr.mr_n76284944)
print v(xbgr.mr_n76285264)
print v(xbgr.mr_n76285376)
print v(xbgr.mr_n76285696)
print v(xbgr.mr_n76285808)
print v(xbgr.mr_n76286128)
print v(xbgr.mr_n76286240)
print v(xbgr.mr_n76286560)
print v(xbgr.mr_n76286672)
print v(xbgr.mr_n76286992)
print v(xbgr.mr_n76287104)
print v(xbgr.mr_n76287424)
print v(xbgr.mr_n76287536)
print v(xbgr.mr_n76287856)
print v(xbgr.mr_n76287968)
print v(xbgr.mr_n76288288)
print v(xbgr.mr_n76288400)
print v(xbgr.mr_n76288720)
print v(xbgr.mr_n76288832)
print v(xbgr.mr_n76289152)
print v(xbgr.mr_n76289264)
print v(xbgr.mr_n76289584)
print v(xbgr.mr_n76289696)
print v(xbgr.mr_n76290016)
print v(xbgr.mr_n76290128)
print v(xbgr.mr_n76290448)
print v(xbgr.mr_n76290560)
print v(xbgr.mr_n76290880)
print v(xbgr.mr_n76290992)
print v(xbgr.mr_n76291312)
print v(xbgr.mr_n76291424)
print v(xbgr.mr_n76291744)
print v(xbgr.mr_n76291856)
print v(xbgr.mr_n76292176)
print v(xbgr.mr_n76292288)
print v(xbgr.mr_n76292608)
print v(xbgr.mr_n76292720)
print v(xbgr.mr_n76293040)
print v(xbgr.mr_n76293152)
print v(xbgr.mr_n76293472)
print v(xbgr.mr_n76293584)
print v(xbgr.mr_n76293904)
print v(xbgr.mr_n76294016)
print v(xbgr.mr_n76294336)
print v(xbgr.mr_n76294448)
print v(xbgr.mr_n76294768)
print v(xbgr.mr_n76294880)
print v(xbgr.mr_n76295200)
print v(xbgr.mr_n76295312)
print v(xbgr.mr_n76295632)
print v(xbgr.mr_n76295744)
print v(xbgr.mr_n76296064)
print v(xbgr.mr_n76296176)
print v(xbgr.mr_n76296496)
print v(xbgr.mr_n76296608)
print v(xbgr.mr_n76296928)
print v(xbgr.mr_n76297040)
print v(xbgr.mr_n76297360)
print v(xbgr.mr_n76297472)
print v(xbgr.mr_n76297792)
print v(xbgr.mr_n76297904)
print v(xbgr.mr_n76298224)
print v(xbgr.mr_n76298336)
print v(xbgr.mr_n76298656)
print v(xbgr.mr_n76298768)
print v(xbgr.mr_n76299088)
print v(xbgr.mr_n76299200)
print v(xbgr.mr_n76299520)
print v(xbgr.mr_n76299632)
print v(xbgr.mr_n76299952)
print v(xbgr.mr_n76300064)
print v(xbgr.mr_n76300384)
print v(xbgr.mr_n76300496)
print v(xbgr.mr_n76300816)
print v(xbgr.mr_n76300928)
print v(xbgr.mr_n76301248)
print v(xbgr.mr_n76301360)
print v(xbgr.mr_n76301680)
print v(xbgr.mr_n76301792)
print v(xbgr.mr_n76302112)
print v(xbgr.mr_n76302224)
print v(xbgr.mr_n76302544)
print v(xbgr.mr_n76302656)
print v(xbgr.mr_n76302976)
print v(xbgr.mr_n76303088)
print v(xbgr.mr_n76303408)
print v(xbgr.mr_n76303520)
print v(xbgr.mr_n76303840)
print v(xbgr.mr_n76303952)
print v(xbgr.mr_n76304272)
print v(xbgr.mr_n76304384)
print v(xbgr.mr_n76304704)
print v(xbgr.mr_n76304816)
print v(xbgr.mr_n76305136)
print v(xbgr.mr_n76305248)
print v(xbgr.mr_n76305568)
print v(xbgr.mr_n76305680)
print v(xbgr.mr_n76306000)
print v(xbgr.mr_n76306112)
print v(xbgr.mr_n76306432)
print v(xbgr.mr_n76306544)
print v(xbgr.mr_n76306864)
print v(xbgr.mr_n76306976)
print v(xbgr.mr_n76307296)
print v(xbgr.mr_n76307408)
print v(xbgr.mr_n76307728)
print v(xbgr.mr_n76307840)
print v(xbgr.mr_n76308160)
print v(xbgr.mr_n76308272)
print v(xbgr.mr_n76308592)
print v(xbgr.mr_n76308704)
print v(xbgr.mr_n76309024)
print v(xbgr.mr_n76309136)
print v(xbgr.mr_n76309456)
print v(xbgr.mr_n76309568)
print v(xbgr.mr_n76309888)
print v(xbgr.mr_n76310000)
print v(xbgr.mr_n76310320)
print v(xbgr.mr_n76310432)
print v(xbgr.mr_n76310752)
print v(xbgr.mr_n76310864)
print v(xbgr.mr_n76311184)
print v(xbgr.mr_n76311296)
print v(xbgr.mr_n76311616)
print v(xbgr.mr_n76311728)
print v(xbgr.mr_n76312048)
print v(xbgr.mr_n76312160)
print v(xbgr.mr_n76312480)
print v(xbgr.mr_n76312592)
print v(xbgr.mr_n76312912)
print v(xbgr.mr_n76313024)
print v(xbgr.mr_n76313344)
print v(xbgr.mr_n76313456)
print v(xbgr.mr_n76313776)
print v(xbgr.mr_n76313888)
print v(xbgr.mr_n76314208)
print v(xbgr.mr_n76314320)
print v(xbgr.mr_n76314640)
print v(xbgr.mr_n76314752)
print v(xbgr.mr_n76315072)
print v(xbgr.mr_n76315184)
print v(xbgr.mr_n76315504)
print v(xbgr.mr_n76315616)
print v(xbgr.mr_n76315936)
print v(xbgr.mr_n76316048)
print v(xbgr.mr_n76316368)
print v(xbgr.mr_n76316480)
print v(xbgr.mr_n76316800)
print v(xbgr.mr_n76316912)
print v(xbgr.mr_n76317232)
print v(xbgr.mr_n76317344)
print v(xbgr.mr_n76317664)
print v(xbgr.mr_n76317776)
print v(xbgr.mr_n76318096)
print v(xbgr.mr_n76318208)
print v(xbgr.mr_n76318528)
print v(xbgr.mr_n76318640)
print v(xbgr.mr_n76318960)
print v(xbgr.mr_n76319072)
print v(xbgr.mr_n76319392)
print v(xbgr.mr_n76319504)
print v(xbgr.mr_n76319824)
print v(xbgr.mr_n76319936)
print v(xbgr.mr_n76320256)
print v(xbgr.mr_n76320368)
print v(xbgr.mr_n76320688)
print v(xbgr.mr_n76320800)
print v(xbgr.mr_n76321120)
print v(xbgr.mr_n76321232)
print v(xbgr.mr_n76321552)
print v(xbgr.mr_n76321664)
print v(xbgr.mr_n76321984)
print v(xbgr.mr_n76322096)
print v(xbgr.mr_n76322416)
print v(xbgr.mr_n76322528)
print v(xbgr.mr_n76322848)
print v(xbgr.mr_n76322960)
print v(xbgr.mr_n76323280)
print v(xbgr.mr_n76323392)
print v(xbgr.mr_n76323712)
print v(xbgr.mr_n76323824)
print v(xbgr.mr_n76324144)
print v(xbgr.mr_n76324256)
print v(xbgr.mr_n76324576)
print v(xbgr.mr_n76324688)
print v(xbgr.mr_n76325008)
print v(xbgr.mr_n76325120)
print v(xbgr.mr_n76325440)
print v(xbgr.mr_n76325552)
print v(xbgr.mr_n76325872)
print v(xbgr.mr_n76325984)
print v(xbgr.mr_n76326304)
print v(xbgr.mr_n76326416)
print v(xbgr.mr_n76326736)
print v(xbgr.mr_n76326848)
print v(xbgr.mr_n76327168)
print v(xbgr.mr_n76327280)
print v(xbgr.mr_n76327600)
print v(xbgr.mr_n76327712)
print v(xbgr.mr_n76328032)
print v(xbgr.mr_n76328144)
print v(xbgr.mr_n76328464)
print v(xbgr.mr_n76328576)
print v(xbgr.mr_n76328896)
print v(xbgr.mr_n76329008)
print v(xbgr.mr_n76329328)
print v(xbgr.mr_n76329440)
print v(xbgr.mr_n76329760)
print v(xbgr.mr_n76329872)
print v(xbgr.mr_n76330192)
print v(xbgr.mr_n76330304)
print v(xbgr.mr_n76330624)
print v(xbgr.mr_n76330736)
print v(xbgr.mr_n76331056)
print v(xbgr.mr_n76331168)
print v(xbgr.mr_n76331488)
print v(xbgr.mr_n76331600)
print v(xbgr.mr_n76332032)
print v(xbgr.mr_n76332352)
print v(xbgr.mr_n76332464)
print v(xbgr.mr_n76332896)
print v(xbgr.mr_n76333216)
print v(xbgr.mr_n76333328)
print v(xbgr.mr_n76333760)
print v(xbgr.mr_n76334080)
print v(xbgr.mr_n76334944)
print v(xbgr.mr_n76335056)
print v(xbgr.mr_n76335488)
print v(xbgr.mr_n76335808)
print v(xbgr.mr_n76335920)
print v(xbgr.mr_n76336240)
print v(xbgr.mr_n76336352)
print v(xbgr.mr_n76336672)
print v(xbgr.mr_n76336784)
print v(xbgr.mr_n76337104)
print v(xbgr.mr_n76337216)
print v(xbgr.mr_n76337536)
print v(xbgr.mr_n76337648)
print v(xbgr.mr_n76337968)
print v(xbgr.mr_n76338080)
print v(xbgr.mr_n76338400)
print v(xbgr.mr_n76338512)
print v(xbgr.mr_n76338832)
print v(xbgr.mr_n76338944)
print v(xbgr.mr_n76339264)
print v(xbgr.mr_n76340128)
print v(xbgr.mr_n76340992)
print v(xbgr.mr_n76341104)
print v(xbgr.mr_n76341424)
print v(xbgr.mr_n76341536)
print v(xbgr.mr_n76341856)
print v(xbgr.mr_n76342720)
print v(xbgr.mr_n76342832)
print v(xbgr.mr_n76343152)
print v(xbgr.mr_n76343264)
print v(xbgr.mr_n76343584)
print v(xbgr.mr_n76343696)
print v(xbgr.mr_n76344016)
print v(xbgr.mr_n76344128)
print v(xbgr.mr_n76344448)
print v(xbgr.mr_n76344560)
print v(xbgr.mr_n76344880)
print v(xbgr.mr_n76344992)
print v(xbgr.mr_n76345312)
print v(xbgr.mr_n76345424)
print v(xbgr.mr_n76345744)
print v(xbgr.mr_n76345856)
print v(xbgr.mr_n76346176)
print v(xbgr.mr_n76346288)
print v(xbgr.mr_n76346608)
print v(xbgr.mr_n76346720)
print v(xbgr.mr_n76347040)
print v(xbgr.mr_n76347152)
print v(xbgr.mr_n76347472)
print v(xbgr.mr_n76347584)
print v(xbgr.mr_n76347904)
print v(xbgr.mr_n76348016)
print v(xbgr.mr_n76348336)
print v(xbgr.mr_n76348448)
print v(xbgr.mr_n76348768)
print v(xbgr.mr_n76348880)
print v(xbgr.mr_n76349200)
print v(xbgr.mr_n76349312)
print v(xbgr.mr_n76349632)
print v(xbgr.mr_n76349744)
print v(xbgr.mr_n76350064)
print v(xbgr.mr_n76350176)
print v(xbgr.mr_n76350496)
print v(xbgr.mr_n76350608)
print v(xbgr.mr_n76350928)
print v(xbgr.mr_n76351040)
print v(xbgr.mr_n76351360)
print v(xbgr.mr_n76351472)
print v(xbgr.mr_n76351792)
print v(xbgr.mr_n76351904)
print v(xbgr.mr_n76352224)
print v(xbgr.mr_n76352336)
print v(xbgr.mr_n76352656)
print v(xbgr.mr_n76352768)
print v(xbgr.mr_n76353088)
print v(xbgr.mr_n76353200)
print v(xbgr.mr_n76353632)
print v(xbgr.mr_n76353952)
print v(xbgr.mr_n76354064)
print v(xbgr.mr_n76354384)
print v(xbgr.mr_n76354496)
print v(xbgr.mr_n76354816)
print v(xbgr.mr_n76354928)
print v(xbgr.mr_n76355248)
print v(xbgr.mr_n76355360)
print v(xbgr.mr_n76355680)
print v(xbgr.mr_n76355792)
print v(xbgr.mr_n76356112)
print v(xbgr.mr_n76356224)
print v(xbgr.mr_n76356544)
print v(xbgr.mr_n76356656)
print v(xbgr.mr_n76356976)
print v(xbgr.mr_n76357088)
print v(xbgr.mr_n76357408)
print v(xbgr.mr_n76357520)
print v(xbgr.mr_n76357840)
print v(xbgr.mr_n76357952)
print v(xbgr.mr_n76358272)
print v(xbgr.mr_n76358384)
print v(xbgr.mr_n76358704)
print v(xbgr.mr_n76358816)
print v(xbgr.mr_n76359136)
print v(xbgr.mr_n76359248)
print v(xbgr.mr_n76359568)
print v(xbgr.mr_n76359680)
print v(xbgr.mr_n76360000)
print v(xbgr.mr_n76360864)
print v(xbgr.mr_n76360976)
print v(xbgr.mr_n76361296)
print v(xbgr.mr_n76361408)
print v(xbgr.mr_n76361728)
print v(xbgr.mr_n76361840)
print v(xbgr.mr_n76362160)
print v(xbgr.mr_n76362272)
print v(xbgr.mr_n76362592)
print v(xbgr.mr_n76362704)
print v(xbgr.mr_n76363024)
print v(xbgr.mr_n76363136)
print v(xbgr.mr_n76363456)
print v(xbgr.mr_n76363568)
print v(xbgr.mr_n76363888)
print v(xbgr.mr_n76364000)
print v(xbgr.mr_n76364320)
print v(xbgr.mr_n76364432)
print v(xbgr.mr_n76364752)
print v(xbgr.mr_n76364864)
print v(xbgr.mr_n76365184)
print v(xbgr.mr_n76365296)
print v(xbgr.mr_n76365616)
print v(xbgr.mr_n76365728)
print v(xbgr.mr_n76366048)
print v(xbgr.mr_n76366160)
print v(xbgr.mr_n76366480)
print v(xbgr.mr_n76366592)
print v(xbgr.mr_n76366912)
print v(xbgr.mr_n76367024)
print v(xbgr.mr_n76367344)
print v(xbgr.mr_n76367456)
print v(xbgr.mr_n76367776)
print v(xbgr.mr_n76367888)
print v(xbgr.mr_n76368208)
print v(xbgr.mr_n76368320)
print v(xbgr.mr_n76368640)
print v(xbgr.mr_n76368752)
print v(xbgr.mr_n76369072)
print v(xbgr.mr_n76369184)
print v(xbgr.mr_n76369504)
print v(xbgr.mr_n76369616)
print v(xbgr.mr_n76369936)
print v(xbgr.mr_n76370048)
print v(xbgr.mr_n76370368)
print v(xbgr.mr_n76370480)
print v(xbgr.mr_n76370800)
print v(xbgr.mr_n76370912)
print v(xbgr.mr_n76371232)
print v(xbgr.mr_n76371344)
print v(xbgr.mr_n76371664)
print v(xbgr.mr_n76371776)
print v(xbgr.mr_n76372096)
print v(xbgr.mr_n76372208)
print v(xbgr.mr_n76372528)
print v(xbgr.mr_n76372640)
print v(xbgr.mr_n76372960)
print v(xbgr.mr_n76373072)
print v(xbgr.mr_n76373392)
print v(xbgr.mr_n76373504)
print v(xbgr.mr_n76373824)
print v(xbgr.mr_n76373936)
print v(xbgr.mr_n76374256)
print v(xbgr.mr_n76374368)
print v(xbgr.mr_n76374688)
print v(xbgr.mr_n76374800)
print v(xbgr.mr_n76375120)
print v(xbgr.mr_n76375232)
print v(xbgr.mr_n76375552)
print v(xbgr.mr_n76375664)
print v(xbgr.mr_n76375984)
print v(xbgr.mr_n76376096)
print v(xbgr.mr_n76376416)
print v(xbgr.mr_n76376528)
print v(xbgr.mr_n76376848)
print v(xbgr.mr_n76376960)
print v(xbgr.mr_n76377280)
print v(xbgr.mr_n76377392)
print v(xbgr.mr_n76377712)
print v(xbgr.mr_n76377824)
print v(xbgr.mr_n76378144)
print v(xbgr.mr_n76378256)
print v(xbgr.mr_n76378576)
print v(xbgr.mr_n76378688)
print v(xbgr.mr_n76379008)
print v(xbgr.mr_n76379120)
print v(xbgr.mr_n76379440)
print v(xbgr.mr_n76379552)
print v(xbgr.mr_n76379872)
print v(xbgr.mr_n76379984)
print v(xbgr.mr_n76380304)
print v(xbgr.mr_n76380416)
print v(xbgr.mr_n76380736)
print v(xbgr.mr_n76380848)
print v(xbgr.mr_n76381168)
print v(xbgr.mr_n76381280)
print v(xbgr.mr_n76381600)
print v(xbgr.mr_n76381712)
print v(xbgr.mr_n76382032)
print v(xbgr.mr_n76382144)
print v(xbgr.mr_n76382464)
print v(xbgr.mr_n76382576)
print v(xbgr.mr_n76382896)
print v(xbgr.mr_n76383008)
print v(xbgr.mr_n76383328)
print v(xbgr.mr_n76383440)
print v(xbgr.mr_n76383760)
print v(xbgr.mr_n76383872)
print v(xbgr.mr_n76384192)
print v(xbgr.mr_n76384304)
print v(xbgr.mr_n76384624)
print v(xbgr.mr_n76384736)
print v(xbgr.mr_n76385056)
print v(xbgr.mr_n76385168)
print v(xbgr.mr_n76385488)
print v(xbgr.mr_n76385600)
print v(xbgr.mr_n76385920)
print v(xbgr.mr_n76386032)
print v(xbgr.mr_n76386352)
print v(xbgr.mr_n76386464)
print v(xbgr.mr_n76386784)
print v(xbgr.mr_n76386896)
print v(xbgr.mr_n76387216)
print v(xbgr.mr_n76387328)
print v(xbgr.mr_n76387648)
print v(xbgr.mr_n76387760)
print v(xbgr.mr_n76388080)
print v(xbgr.mr_n76388192)
print v(xbgr.mr_n76388512)
print v(xbgr.mr_n76388624)
print v(xbgr.mr_n76388944)
print v(xbgr.mr_n76389056)
print v(xbgr.mr_n76389376)
print v(xbgr.mr_n76389488)
print v(xbgr.mr_n76389808)
print v(xbgr.mr_n76389920)
print v(xbgr.mr_n76390240)
print v(xbgr.mr_n76390352)
print v(xbgr.mr_n76390672)
print v(xbgr.mr_n76390784)
print v(xbgr.mr_n76391104)
print v(xbgr.mr_n76391216)
print v(xbgr.mr_n76391536)
print v(xbgr.mr_n76391648)
print v(xbgr.mr_n76391968)
print v(xbgr.mr_n76392080)
print v(xbgr.mr_n76392400)
print v(xbgr.mr_n76392512)
print v(xbgr.mr_n76392832)
print v(xbgr.mr_n76392944)
print v(xbgr.mr_n76393264)
print v(xbgr.mr_n76393376)
print v(xbgr.mr_n76393696)
print v(xbgr.mr_n76393808)
print v(xbgr.mr_n76394128)
print v(xbgr.mr_n76394240)
print v(xbgr.mr_n76394560)
print v(xbgr.mr_n76394672)
print v(xbgr.mr_n76394992)
print v(xbgr.mr_n76395104)
print v(xbgr.mr_n76395424)
print v(xbgr.mr_n76395536)
print v(xbgr.mr_n76395856)
print v(xbgr.mr_n76395968)
print v(xbgr.mr_n76396288)
print v(xbgr.mr_n76396400)
print v(xbgr.mr_n76396720)
print v(xbgr.mr_n76396832)
print v(xbgr.mr_n76397152)
print v(xbgr.mr_n76397264)
print v(xbgr.mr_n76397584)
print v(xbgr.mr_n76397696)
print v(xbgr.mr_n76398016)
print v(xbgr.mr_n76398128)
print v(xbgr.mr_n76398448)
print v(xbgr.mr_n76398560)
print v(xbgr.mr_n76398880)
print v(xbgr.mr_n76398992)
print v(xbgr.mr_n76399312)
print v(xbgr.mr_n76399424)
print v(xbgr.mr_n76399744)
print v(xbgr.mr_n76399856)
print v(xbgr.mr_n76400176)
print v(xbgr.mr_n76400288)
print v(xbgr.mr_n76400608)
print v(xbgr.mr_n76400720)
print v(xbgr.mr_n76401040)
print v(xbgr.mr_n76401152)
print v(xbgr.mr_n76401472)
print v(xbgr.mr_n76401584)
print v(xbgr.mr_n76401904)
print v(xbgr.mr_n76402016)
print v(xbgr.mr_n76402336)
print v(xbgr.mr_n76402448)
print v(xbgr.mr_n76402768)
print v(xbgr.mr_n76402880)
print v(xbgr.mr_n76403200)
print v(xbgr.mr_n76403312)
print v(xbgr.mr_n76403632)
print v(xbgr.mr_n76403744)
print v(xbgr.mr_n76404064)
print v(xbgr.mr_n76404176)
print v(xbgr.mr_n76404496)
print v(xbgr.mr_n76404608)
print v(xbgr.mr_n76404928)
print v(xbgr.mr_n76405040)
print v(xbgr.mr_n76405360)
print v(xbgr.mr_n76405472)
print v(xbgr.mr_n76405792)
print v(xbgr.mr_n76405904)
print v(xbgr.mr_n76406224)
print v(xbgr.mr_n76406336)
print v(xbgr.mr_n76406656)
print v(xbgr.mr_n76406768)
print v(xbgr.mr_n76407088)
print v(xbgr.mr_n76407200)
print v(xbgr.mr_n76407520)
print v(xbgr.mr_n76407632)
print v(xbgr.mr_n76407952)
print v(xbgr.mr_n76408064)
print v(xbgr.mr_n76408384)
print v(xbgr.mr_n76408496)
print v(xbgr.mr_n76408816)
print v(xbgr.mr_n76408928)
print v(xbgr.mr_n76409248)
print v(xbgr.mr_n76409360)
print v(xbgr.mr_n76409680)
print v(xbgr.mr_n76409792)
print v(xbgr.mr_n76410112)
print v(xbgr.mr_n76410224)
print v(xbgr.mr_n76410544)
print v(xbgr.mr_n76410656)
print v(xbgr.mr_n76410976)
print v(xbgr.mr_n76411088)
print v(xbgr.mr_n76411408)
print v(xbgr.mr_n76411520)
print v(xbgr.mr_n76411840)
print v(xbgr.mr_n76411952)
print v(xbgr.mr_n76412272)
print v(xbgr.mr_n76412384)
print v(xbgr.mr_n76412704)
print v(xbgr.mr_n76412816)
print v(xbgr.mr_n76413136)
print v(xbgr.mr_n76413248)
print v(xbgr.mr_n76413568)
print v(xbgr.mr_n76413680)
print v(xbgr.mr_n76414000)
print v(xbgr.mr_n76414112)
print v(xbgr.mr_n76414432)
print v(xbgr.mr_n76414544)
print v(xbgr.mr_n76414864)
print v(xbgr.mr_n76414976)
print v(xbgr.mr_n76415296)
print v(xbgr.mr_n76415408)
print v(xbgr.mr_n76415728)
print v(xbgr.mr_n76415840)
print v(xbgr.mr_n76416160)
print v(xbgr.mr_n76416272)
print v(xbgr.mr_n76416592)
print v(xbgr.mr_n76416704)
print v(xbgr.mr_n76417024)
print v(xbgr.mr_n76417136)
print v(xbgr.mr_n76417456)
print v(xbgr.mr_n76417568)
print v(xbgr.mr_n76417888)
print v(xbgr.mr_n76418000)
print v(xbgr.mr_n76418320)
print v(xbgr.mr_n76418432)
print v(xbgr.mr_n76418752)
print v(xbgr.mr_n76418864)
print v(xbgr.mr_n76419184)
print v(xbgr.mr_n76419296)
print v(xbgr.mr_n76419616)
print v(xbgr.mr_n76419728)
print v(xbgr.mr_n76420048)
print v(xbgr.mr_n76420160)
print v(xbgr.mr_n76420480)
print v(xbgr.mr_n76420592)
print v(xbgr.mr_n76420912)
print v(xbgr.mr_n76421024)
print v(xbgr.mr_n76421344)
print v(xbgr.mr_n76421456)
print v(xbgr.mr_n76421776)
print v(xbgr.mr_n76421888)
print v(xbgr.mr_n76422208)
print v(xbgr.mr_n76422320)
print v(xbgr.mr_n76422640)
print v(xbgr.mr_n76422752)
print v(xbgr.mr_n76423072)
print v(xbgr.mr_n76423184)
print v(xbgr.mr_n76423504)
print v(xbgr.mr_n76423616)
print v(xbgr.mr_n76423936)
print v(xbgr.mr_n76424048)
print v(xbgr.mr_n76424368)
print v(xbgr.mr_n76424480)
print v(xbgr.mr_n76424800)
print v(xbgr.mr_n76424912)
print v(xbgr.mr_n76425232)
print v(xbgr.mr_n76425344)
print v(xbgr.mr_n76425664)
print v(xbgr.mr_n76425776)
print v(xbgr.mr_n76426096)
print v(xbgr.mr_n76426208)
print v(xbgr.mr_n76426528)
print v(xbgr.mr_n76426640)
print v(xbgr.mr_n76426960)
print v(xbgr.mr_n76427072)
print v(xbgr.mr_n76427392)
print v(xbgr.mr_n76427504)
print v(xbgr.mr_n76427824)
print v(xbgr.mr_n76427936)
print v(xbgr.mr_n76428256)
print v(xbgr.mr_n76428368)
print v(xbgr.mr_n76428688)
print v(xbgr.mr_n76428800)
print v(xbgr.mr_n76429120)
print v(xbgr.mr_n76429232)
print v(xbgr.mr_n76429552)
print v(xbgr.mr_n76429664)
print v(xbgr.mr_n76429984)
print v(xbgr.mr_n76430096)
print v(xbgr.mr_n76430416)
print v(xbgr.mr_n76430528)
print v(xbgr.mr_n76430848)
print v(xbgr.mr_n76430960)
print v(xbgr.mr_n76431280)
print v(xbgr.mr_n76431392)
print v(xbgr.mr_n76431712)
print v(xbgr.mr_n76431824)
print v(xbgr.mr_n76432144)
print v(xbgr.mr_n76432256)
print v(xbgr.mr_n76432576)
print v(xbgr.mr_n76432688)
print v(xbgr.mr_n76433008)
print v(xbgr.mr_n76433120)
print v(xbgr.mr_n76433440)
print v(xbgr.mr_n76433552)
print v(xbgr.mr_n76433872)
print v(xbgr.mr_n76433984)
print v(xbgr.mr_n76434304)
print v(xbgr.mr_n76434416)
print v(xbgr.mr_n76434736)
print v(xbgr.mr_n76434848)
print v(xbgr.mr_n76435168)
print v(xbgr.mr_n76435280)
print v(xbgr.mr_n76435600)
print v(xbgr.mr_n76435712)
print v(xbgr.mr_n76436032)
print v(xbgr.mr_n76436144)
print v(xbgr.mr_n76436464)
print v(xbgr.mr_n76436576)
print v(xbgr.mr_n76436896)
print v(xbgr.mr_n76437008)
print v(xbgr.mr_n76437328)
print v(xbgr.mr_n76437440)
print v(xbgr.mr_n76437760)
print v(xbgr.mr_n76437872)
print v(xbgr.mr_n76438192)
print v(xbgr.mr_n76438304)
print v(xbgr.mr_n76438624)
print v(xbgr.mr_n76438736)
print v(xbgr.mr_n76439056)
print v(xbgr.mr_n76439168)
print v(xbgr.mr_n76439488)
print v(xbgr.mr_n76439600)
print v(xbgr.mr_n76439920)
print v(xbgr.mr_n76440032)
print v(xbgr.mr_n76440352)
print v(xbgr.mr_n76440464)
print v(xbgr.mr_n76440784)
print v(xbgr.mr_n76440896)
print v(xbgr.mr_n76441216)
print v(xbgr.mr_n76441328)
print v(xbgr.mr_n76441648)
print v(xbgr.mr_n76441760)
print v(xbgr.mr_n76442080)
print v(xbgr.mr_n76442192)
print v(xbgr.mr_n76442512)
print v(xbgr.mr_n76442624)
print v(xbgr.mr_n76442944)
print v(xbgr.mr_n76443056)
print v(xbgr.mr_n76443376)
print v(xbgr.mr_n76443488)
print v(xbgr.mr_n76443808)
print v(xbgr.mr_n76443920)
print v(xbgr.mr_n76444240)
print v(xbgr.mr_n76444352)
print v(xbgr.mr_n76444672)
print v(xbgr.mr_n76444784)
print v(xbgr.mr_n76445104)
print v(xbgr.mr_n76445216)
print v(xbgr.mr_n76445536)
print v(xbgr.mr_n76445648)
print v(xbgr.mr_n76445968)
print v(xbgr.mr_n76446080)
print v(xbgr.mr_n76446400)
print v(xbgr.mr_n76446512)
print v(xbgr.mr_n76446832)
print v(xbgr.mr_n76446944)
print v(xbgr.mr_n76447264)
print v(xbgr.mr_n76447376)
print v(xbgr.mr_n76447696)
print v(xbgr.mr_n76447808)
print v(xbgr.mr_n76448128)
print v(xbgr.mr_n76448240)
print v(xbgr.mr_n76448560)
print v(xbgr.mr_n76448672)
print v(xbgr.mr_n76448992)
print v(xbgr.mr_n76449104)
print v(xbgr.mr_n76449424)
print v(xbgr.mr_n76449536)
print v(xbgr.mr_n76449856)
print v(xbgr.mr_n76449968)
print v(xbgr.mr_n76450288)
print v(xbgr.mr_n76450400)
print v(xbgr.mr_n76450720)
print v(xbgr.mr_n76450832)
print v(xbgr.mr_n76451152)
print v(xbgr.mr_n76451264)
print v(xbgr.mr_n76451584)
print v(xbgr.mr_n76451696)
print v(xbgr.mr_n76452016)
print v(xbgr.mr_n76452128)
print v(xbgr.mr_n76452448)
print v(xbgr.mr_n76452560)
print v(xbgr.mr_n76452880)
print v(xbgr.mr_n76452992)
print v(xbgr.mr_n76453312)
print v(xbgr.mr_n76453424)
print v(xbgr.mr_n76453744)
print v(xbgr.mr_n76453856)
print v(xbgr.mr_n76454176)
print v(xbgr.mr_n76454288)
print v(xbgr.mr_n76454608)
print v(xbgr.mr_n76454720)
print v(xbgr.mr_n76455040)
print v(xbgr.mr_n76455152)
print v(xbgr.mr_n76455472)
print v(xbgr.mr_n76455584)
print v(xbgr.mr_n76455904)
print v(xbgr.mr_n76456016)
print v(xbgr.mr_n76456336)
print v(xbgr.mr_n76456448)
print v(xbgr.mr_n76456768)
print v(xbgr.mr_n76456880)
print v(xbgr.mr_n76457200)
print v(xbgr.mr_n76457312)
print v(xbgr.mr_n76457632)
print v(xbgr.mr_n76457744)
print v(xbgr.mr_n76458064)
print v(xbgr.mr_n76458176)
print v(xbgr.mr_n76458496)
print v(xbgr.mr_n76458608)
print v(xbgr.mr_n76458928)
print v(xbgr.mr_n76459040)
print v(xbgr.mr_n76459360)
print v(xbgr.mr_n76459472)
print v(xbgr.mr_n76459792)
print v(xbgr.mr_n76459904)
print v(xbgr.mr_n76460224)
print v(xbgr.mr_n76460336)
print v(xbgr.mr_n76460656)
print v(xbgr.mr_n76460768)
print v(xbgr.mr_n76461088)
print v(xbgr.mr_n76461200)
print v(xbgr.mr_n76461520)
print v(xbgr.mr_n76461632)
print v(xbgr.mr_n76461952)
print v(xbgr.mr_n76462064)
print v(xbgr.mr_n76462384)
print v(xbgr.mr_n76462496)
print v(xbgr.mr_n76462816)
print v(xbgr.mr_n76462928)
print v(xbgr.mr_n76463248)
print v(xbgr.mr_n76463360)
print v(xbgr.mr_n76463680)
print v(xbgr.mr_n76463792)
print v(xbgr.mr_n76464112)
print v(xbgr.mr_n76464224)
print v(xbgr.mr_n76464544)
print v(xbgr.mr_n76464656)
print v(xbgr.mr_n76464976)
print v(xbgr.mr_n76465088)
print v(xbgr.mr_n76465408)
print v(xbgr.mr_n76465520)
print v(xbgr.mr_n76465840)
print v(xbgr.mr_n76465952)
print v(xbgr.mr_n76466272)
print v(xbgr.mr_n76466384)
print v(xbgr.mr_n76466704)
print v(xbgr.mr_n76466816)
print v(xbgr.mr_n76467136)
print v(xbgr.mr_n76467248)
print v(xbgr.mr_n76467568)
print v(xbgr.mr_n76467680)
print v(xbgr.mr_n76468000)
print v(xbgr.mr_n76468112)
print v(xbgr.mr_n76468432)
print v(xbgr.mr_n76468544)
print v(xbgr.mr_n76468864)
print v(xbgr.mr_n76468976)
print v(xbgr.mr_n76469296)
print v(xbgr.mr_n76469408)
print v(xbgr.mr_n76469728)
print v(xbgr.mr_n76469840)
print v(xbgr.mr_n76470160)
print v(xbgr.mr_n76470272)
print v(xbgr.mr_n76470592)
print v(xbgr.mr_n76470704)
print v(xbgr.mr_n76471024)
print v(xbgr.mr_n76471136)
print v(xbgr.mr_n76471456)
print v(xbgr.mr_n76471568)
print v(xbgr.mr_n76471888)
print v(xbgr.mr_n76472000)
print v(xbgr.mr_n76472320)
print v(xbgr.mr_n76472432)
print v(xbgr.mr_n76472752)
print v(xbgr.mr_n76472864)
print v(xbgr.mr_n76473184)
print v(xbgr.mr_n76473296)
print v(xbgr.mr_n76473616)
print v(xbgr.mr_n76473728)
print v(xbgr.mr_n76474048)
print v(xbgr.mr_n76474160)
print v(xbgr.mr_n76474480)
print v(xbgr.mr_n76474592)
print v(xbgr.mr_n76474912)
print v(xbgr.mr_n76475024)
print v(xbgr.mr_n76475344)
print v(xbgr.mr_n76475456)
print v(xbgr.mr_n76475776)
print v(xbgr.mr_n76475888)
print v(xbgr.mr_n76476208)
print v(xbgr.mr_n76476320)
print v(xbgr.mr_n76476640)
print v(xbgr.mr_n76476752)
print v(xbgr.mr_n76477072)
print v(xbgr.mr_n76477184)
print v(xbgr.mr_n76477504)
print v(xbgr.mr_n76477616)
print v(xbgr.mr_n76477936)
print v(xbgr.mr_n76478048)
print v(xbgr.mr_n76478368)
print v(xbgr.mr_n76478480)
print v(xbgr.mr_n76478800)
print v(xbgr.mr_n76478912)
print v(xbgr.mr_n76479232)
print v(xbgr.mr_n76479344)
print v(xbgr.mr_n76479664)
print v(xbgr.mr_n76479776)
print v(xbgr.mr_n76480096)
print v(xbgr.mr_n76480208)
print v(xbgr.mr_n76480528)
print v(xbgr.mr_n76480640)
print v(xbgr.mr_n76480960)
print v(xbgr.mr_n76481072)
print v(xbgr.mr_n76481392)
print v(xbgr.mr_n76481504)
print v(xbgr.mr_n76481824)
print v(xbgr.mr_n76481936)
print v(xbgr.mr_n76482256)
print v(xbgr.mr_n76482368)
print v(xbgr.mr_n76482688)
print v(xbgr.mr_n76482800)
print v(xbgr.mr_n76483120)
print v(xbgr.mr_n76483232)
print v(xbgr.mr_n76483552)
print v(xbgr.mr_n76483664)
print v(xbgr.mr_n76483984)
print v(xbgr.mr_n76484096)
print v(xbgr.mr_n76484416)
print v(xbgr.mr_n76484528)
print v(xbgr.mr_n76484848)
print v(xbgr.mr_n76484960)
print v(xbgr.mr_n76485280)
print v(xbgr.mr_n76485392)
print v(xbgr.mr_n76485712)
print v(xbgr.mr_n76485824)
print v(xbgr.mr_n76486144)
print v(xbgr.mr_n76486256)
print v(xbgr.mr_n76486576)
print v(xbgr.mr_n76486688)
print v(xbgr.mr_n76487008)
print v(xbgr.mr_n76487120)
print v(xbgr.mr_n76487440)
print v(xbgr.mr_n76487552)
print v(xbgr.mr_n76487872)
print v(xbgr.mr_n76487984)
print v(xbgr.mr_n76488304)
print v(xbgr.mr_n76488416)
print v(xbgr.mr_n76488736)
print v(xbgr.mr_n76488848)
print v(xbgr.mr_n76489168)
print v(xbgr.mr_n76489280)
print v(xbgr.mr_n76489600)
print v(xbgr.mr_n76489712)
print v(xbgr.mr_n76490032)
print v(xbgr.mr_n76490144)
print v(xbgr.mr_n76490464)
print v(xbgr.mr_n76490576)
print v(xbgr.mr_n76490896)
print v(xbgr.mr_n76491008)
print v(xbgr.mr_n76491328)
print v(xbgr.mr_n76491440)
print v(xbgr.mr_n76491760)
print v(xbgr.mr_n76491872)
print v(xbgr.mr_n76492192)
print v(xbgr.mr_n76492304)
print v(xbgr.mr_n76492624)
print v(xbgr.mr_n76492736)
print v(xbgr.mr_n76493056)
print v(xbgr.mr_n76493168)
print v(xbgr.mr_n76493488)
print v(xbgr.mr_n76493600)
print v(xbgr.mr_n76493920)
print v(xbgr.mr_n76494032)
print v(xbgr.mr_n76494352)
print v(xbgr.mr_n76494464)
print v(xbgr.mr_n76494784)
print v(xbgr.mr_n76494896)
print v(xbgr.mr_n76495216)
print v(xbgr.mr_n76495328)
print v(xbgr.mr_n76495648)
print v(xbgr.mr_n76495760)
print v(xbgr.mr_n76496080)
print v(xbgr.mr_n76496192)
print v(xbgr.mr_n76496512)
print v(xbgr.mr_n76496624)
print v(xbgr.mr_n76496944)
print v(xbgr.mr_n76497056)
print v(xbgr.mr_n76497376)
print v(xbgr.mr_n76497488)
print v(xbgr.mr_n76497808)
print v(xbgr.mr_n76497920)
print v(xbgr.mr_n76498240)
print v(xbgr.mr_n76498352)
print v(xbgr.mr_n76498672)
print v(xbgr.mr_n76498784)
print v(xbgr.mr_n76499104)
print v(xbgr.mr_n76499216)
print v(xbgr.mr_n76499536)
print v(xbgr.mr_n76499648)
print v(xbgr.mr_n76499968)
print v(xbgr.mr_n76500080)
print v(xbgr.mr_n76500400)
print v(xbgr.mr_n76500512)
print v(xbgr.mr_n76500832)
print v(xbgr.mr_n76500944)
print v(xbgr.mr_n76501264)
print v(xbgr.mr_n76501376)
print v(xbgr.mr_n76501696)
print v(xbgr.mr_n76501808)
print v(xbgr.mr_n76502128)
print v(xbgr.mr_n76502240)
print v(xbgr.mr_n76502560)
print v(xbgr.mr_n76502672)
print v(xbgr.mr_n76502992)
print v(xbgr.mr_n76503104)
print v(xbgr.mr_n76503424)
print v(xbgr.mr_n76503536)
print v(xbgr.mr_n76503856)
print v(xbgr.mr_n76503968)
print v(xbgr.mr_n76504288)
print v(xbgr.mr_n76504400)
print v(xbgr.mr_n76504720)
print v(xbgr.mr_n76504832)
print v(xbgr.mr_n76505152)
print v(xbgr.mr_n76505264)
print v(xbgr.mr_n76505584)
print v(xbgr.mr_n76505696)
print v(xbgr.mr_n76506016)
print v(xbgr.mr_n76506128)
print v(xbgr.mr_n76506448)
print v(xbgr.mr_n76506560)
print v(xbgr.mr_n76506880)
print v(xbgr.mr_n76506992)
print v(xbgr.mr_n76507312)
print v(xbgr.mr_n76507424)
print v(xbgr.mr_n76507744)
print v(xbgr.mr_n76507856)
print v(xbgr.mr_n76508176)
print v(xbgr.mr_n76508288)
print v(xbgr.mr_n76508608)
print v(xbgr.mr_n76508720)
print v(xbgr.mr_n76509040)
print v(xbgr.mr_n76509152)
print v(xbgr.mr_n76509472)
print v(xbgr.mr_n76509584)
print v(xbgr.mr_n76509904)
print v(xbgr.mr_n76510016)
print v(xbgr.mr_n76510336)
print v(xbgr.mr_n76510448)
print v(xbgr.mr_n76510768)
print v(xbgr.mr_n76510880)
print v(xbgr.mr_n76511200)
print v(xbgr.mr_n76511312)
print v(xbgr.mr_n76511632)
print v(xbgr.mr_n76511744)
print v(xbgr.mr_n76512064)
print v(xbgr.mr_n76512176)
print v(xbgr.mr_n76512496)
print v(xbgr.mr_n76512608)
print v(xbgr.mr_n76512928)
print v(xbgr.mr_n76513040)
print v(xbgr.mr_n76513360)
print v(xbgr.mr_n76513472)
print v(xbgr.mr_n76513792)
print v(xbgr.mr_n76513904)
print v(xbgr.mr_n76514224)
print v(xbgr.mr_n76514336)
print v(xbgr.mr_n76514656)
print v(xbgr.mr_n76514768)
print v(xbgr.mr_n76515088)
print v(xbgr.mr_n76515200)
print v(xbgr.mr_n76515520)
print v(xbgr.mr_n76515632)
print v(xbgr.mr_n76515952)
print v(xbgr.mr_n76516064)
print v(xbgr.mr_n76516384)
print v(xbgr.mr_n76516496)
print v(xbgr.mr_n76516816)
print v(xbgr.mr_n76516928)
print v(xbgr.mr_n76517248)
print v(xbgr.mr_n76517360)
print v(xbgr.mr_n76517680)
print v(xbgr.mr_n76517792)
print v(xbgr.mr_n76518112)
print v(xbgr.mr_n76518224)
print v(xbgr.mr_n76518544)
print v(xbgr.mr_n76518656)
print v(xbgr.mr_n76518976)
print v(xbgr.mr_n76519088)
print v(xbgr.mr_n76519408)
print v(xbgr.mr_n76519520)
print v(xbgr.mr_n76519840)
print v(xbgr.mr_n76519952)
print v(xbgr.mr_n76520272)
print v(xbgr.mr_n76520384)
print v(xbgr.mr_n76520704)
print v(xbgr.mr_n76520816)
print v(xbgr.mr_n76521136)
print v(xbgr.mr_n76521248)
print v(xbgr.mr_n76521568)
print v(xbgr.mr_n76521680)
print v(xbgr.mr_n76522000)
print v(xbgr.mr_n76522112)
print v(xbgr.mr_n76522432)
print v(xbgr.mr_n76522544)
print v(xbgr.mr_n76522864)
print v(xbgr.mr_n76522976)
print v(xbgr.mr_n76523296)
print v(xbgr.mr_n76523408)
print v(xbgr.mr_n76523728)
print v(xbgr.mr_n76523840)
print v(xbgr.mr_n76524160)
print v(xbgr.mr_n76524272)
print v(xbgr.mr_n76524592)
print v(xbgr.mr_n76524704)
print v(xbgr.mr_n76525024)
print v(xbgr.mr_n76525136)
print v(xbgr.mr_n76525456)
print v(xbgr.mr_n76525568)
print v(xbgr.mr_n76525888)
print v(xbgr.mr_n76526000)
print v(xbgr.mr_n76526320)
print v(xbgr.mr_n76526432)
print v(xbgr.mr_n76526752)
print v(xbgr.mr_n76526864)
print v(xbgr.mr_n76527184)
print v(xbgr.mr_n76527296)
print v(xbgr.mr_n76527616)
print v(xbgr.mr_n76527728)
print v(xbgr.mr_n76528048)
print v(xbgr.mr_n76528160)
print v(xbgr.mr_n76528480)
print v(xbgr.mr_n76528592)
print v(xbgr.mr_n76528912)
print v(xbgr.mr_n76529024)
print v(xbgr.mr_n76529344)
print v(xbgr.mr_n76529456)
print v(xbgr.mr_n76529776)
print v(xbgr.mr_n76529888)
print v(xbgr.mr_n76530208)
print v(xbgr.mr_n76530320)
print v(xbgr.mr_n76530640)
print v(xbgr.mr_n76530752)
print v(xbgr.mr_n76531072)
print v(xbgr.mr_n76531184)
print v(xbgr.mr_n76531504)
print v(xbgr.mr_n76531616)
print v(xbgr.mr_n76531936)
print v(xbgr.mr_n76532048)
print v(xbgr.mr_n76532480)
print v(xbgr.mr_n76532800)
print v(xbgr.mr_n76532912)
print v(xbgr.mr_n76533232)
print v(xbgr.mr_n76533344)
print v(xbgr.mr_n76533664)
print v(xbgr.mr_n76533776)
print v(xbgr.mr_n76534096)
print v(xbgr.mr_n76534208)
print v(xbgr.mr_n76534528)
print v(xbgr.mr_n76535392)
print v(xbgr.mr_n76535504)
print v(xbgr.mr_n76535824)
print v(xbgr.mr_n76535936)
print v(xbgr.mr_n76536256)
print v(xbgr.mr_n76536368)
print v(xbgr.mr_n76536688)
print v(xbgr.mr_n76536800)
print v(xbgr.mr_n76537120)
print v(xbgr.mr_n76537232)
print v(xbgr.mr_n76537552)
print v(xbgr.mr_n76537664)
print v(xbgr.mr_n76537984)
print v(xbgr.mr_n76538096)
print v(xbgr.mr_n76538416)
print v(xbgr.mr_n76538528)
print v(xbgr.mr_n76538848)
print v(xbgr.mr_n76538960)
print v(xbgr.mr_n76539280)
print v(xbgr.mr_n76539392)
print v(xbgr.mr_n76539712)
print v(xbgr.mr_n76539824)
print v(xbgr.mr_n76540256)
print v(xbgr.mr_n76540576)
print v(xbgr.mr_n76540688)
print v(xbgr.mr_n76541008)
print v(xbgr.mr_n76541120)
print v(xbgr.mr_n76541440)
print v(xbgr.mr_n76541552)
print v(xbgr.mr_n76541872)
print v(xbgr.mr_n76541984)
print v(xbgr.mr_n76542304)
print v(xbgr.mr_n76542416)
print v(xbgr.mr_n76542736)
print v(xbgr.mr_n76542848)
print v(xbgr.mr_n76543168)
print v(xbgr.mr_n76543280)
print v(xbgr.mr_n76543600)
print v(xbgr.mr_n76543712)
print v(xbgr.mr_n76544032)
print v(xbgr.mr_n76544144)
print v(xbgr.mr_n76544464)
print v(xbgr.mr_n76544576)
print v(xbgr.mr_n76544896)
print v(xbgr.mr_n76545008)
print v(xbgr.mr_n76545328)
print v(xbgr.mr_n76545440)
print v(xbgr.mr_n76545760)
print v(xbgr.mr_n76545872)
print v(xbgr.mr_n76546192)
print v(xbgr.mr_n76546304)
print v(xbgr.mr_n76546624)
print v(xbgr.mr_n76546736)
print v(xbgr.mr_n76547056)
print v(xbgr.mr_n76547168)
print v(xbgr.mr_n76547488)
print v(xbgr.mr_n76547600)
print v(xbgr.mr_n76547920)
print v(xbgr.mr_n76548032)
print v(xbgr.mr_n76548352)
print v(xbgr.mr_n76548464)
print v(xbgr.mr_n76548784)
print v(xbgr.mr_n76548896)
print v(xbgr.mr_n76549216)
print v(xbgr.mr_n76549328)
print v(xbgr.mr_n76549648)
print v(xbgr.mr_n76549760)
print v(xbgr.mr_n76550080)
print v(xbgr.mr_n76550192)
print v(xbgr.mr_n76550512)
print v(xbgr.mr_n76550624)
print v(xbgr.mr_n76550944)
print v(xbgr.mr_n76551056)
print v(xbgr.mr_n76551376)
print v(xbgr.mr_n76551488)
print v(xbgr.mr_n76551808)
print v(xbgr.mr_n76551920)
print v(xbgr.mr_n76552240)
print v(xbgr.mr_n76552352)
print v(xbgr.mr_n76552672)
print v(xbgr.mr_n76552784)
print v(xbgr.mr_n76553104)
print v(xbgr.mr_n76553216)
print v(xbgr.mr_n76553536)
print v(xbgr.mr_n76553648)
print v(xbgr.mr_n76553968)
print v(xbgr.mr_n76554080)
print v(xbgr.mr_n76554400)
print v(xbgr.mr_n76554512)
print v(xbgr.mr_n76554832)
print v(xbgr.mr_n76554944)
print v(xbgr.mr_n76555264)
print v(xbgr.mr_n76555376)
print v(xbgr.mr_n76555696)
print v(xbgr.mr_n76555808)
print v(xbgr.mr_n76556128)
print v(xbgr.mr_n76556240)
print v(xbgr.mr_n76556560)
print v(xbgr.mr_n76556672)
print v(xbgr.mr_n76556992)
print v(xbgr.mr_n76557856)
print v(xbgr.mr_n76557968)
print v(xbgr.mr_n76558288)
print v(xbgr.mr_n76558400)
print v(xbgr.mr_n76558720)
print v(xbgr.mr_n76558832)
print v(xbgr.mr_n76559152)
print v(xbgr.mr_n76559264)
print v(xbgr.mr_n76559584)
print v(xbgr.mr_n76559696)
print v(xbgr.mr_n76560016)
print v(xbgr.mr_n76560128)
print v(xbgr.mr_n76560448)
print v(xbgr.mr_n76560560)
print v(xbgr.mr_n76560880)
print v(xbgr.mr_n76560992)
print v(xbgr.mr_n76561312)
print v(xbgr.mr_n76561424)
print v(xbgr.mr_n76561744)
print v(xbgr.mr_n76561856)
print v(xbgr.mr_n76562176)
print v(xbgr.mr_n76562288)
print v(xbgr.mr_n76562608)
print v(xbgr.mr_n76562720)
print v(xbgr.mr_n76563040)
print v(xbgr.mr_n76563152)
print v(xbgr.mr_n76563472)
print v(xbgr.mr_n76563584)
print v(xbgr.mr_n76563904)
print v(xbgr.mr_n76564016)
print v(xbgr.mr_n76564336)
print v(xbgr.mr_n76564448)
print v(xbgr.mr_n76564768)
print v(xbgr.mr_n76564880)
print v(xbgr.mr_n76565200)
print v(xbgr.mr_n76565312)
print v(xbgr.mr_n76565632)
print v(xbgr.mr_n76565744)
print v(xbgr.mr_n76566064)
print v(xbgr.mr_n76566176)
print v(xbgr.mr_n76566496)
print v(xbgr.mr_n76566608)
print v(xbgr.mr_n76566928)
print v(xbgr.mr_n76567040)
print v(xbgr.mr_n76567360)
print v(xbgr.mr_n76567472)
print v(xbgr.mr_n76567792)
print v(xbgr.mr_n76567904)
print v(xbgr.mr_n76568224)
print v(xbgr.mr_n76568336)
print v(xbgr.mr_n76568656)
print v(xbgr.mr_n76568768)
print v(xbgr.mr_n76569088)
print v(xbgr.mr_n76569200)
print v(xbgr.mr_n76569520)
print v(xbgr.mr_n76569632)
print v(xbgr.mr_n76569952)
print v(xbgr.mr_n76570064)
print v(xbgr.mr_n76570384)
print v(xbgr.mr_n76570496)
print v(xbgr.mr_n76570816)
print v(xbgr.mr_n76570928)
print v(xbgr.mr_n76571248)
print v(xbgr.mr_n76571360)
print v(xbgr.mr_n76571680)
print v(xbgr.mr_n76571792)
print v(xbgr.mr_n76572112)
print v(xbgr.mr_n76572224)
print v(xbgr.mr_n76572544)
print v(xbgr.mr_n76572656)
print v(xbgr.mr_n76572976)
print v(xbgr.mr_n76573088)
print v(xbgr.mr_n76573408)
print v(xbgr.mr_n76573520)
print v(xbgr.mr_n76573840)
print v(xbgr.mr_n76573952)
print v(xbgr.mr_n76574272)
print v(xbgr.mr_n76574384)
print v(xbgr.mr_n76574704)
print v(xbgr.mr_n76574816)
print v(xbgr.mr_n76575136)
print v(xbgr.mr_n76575248)
print v(xbgr.mr_n76575568)
print v(xbgr.mr_n76575680)
print v(xbgr.mr_n76576000)
print v(xbgr.mr_n76576112)
print v(xbgr.mr_n76576432)
print v(xbgr.mr_n76576544)
print v(xbgr.mr_n76576864)
print v(xbgr.mr_n76576976)
print v(xbgr.mr_n76577296)
print v(xbgr.mr_n76577408)
print v(xbgr.mr_n76577728)
print v(xbgr.mr_n76577840)
print v(xbgr.mr_n76578160)
print v(xbgr.mr_n76578272)
print v(xbgr.mr_n76578592)
print v(xbgr.mr_n76578704)
print v(xbgr.mr_n76579024)
print v(xbgr.mr_n76579136)
print v(xbgr.mr_n76579456)
print v(xbgr.mr_n76579568)
print v(xbgr.mr_n76579888)
print v(xbgr.mr_n76580000)
print v(xbgr.mr_n76580320)
print v(xbgr.mr_n76580432)
print v(xbgr.mr_n76580752)
print v(xbgr.mr_n76580864)
print v(xbgr.mr_n76581184)
print v(xbgr.mr_n76581296)
print v(xbgr.mr_n76581616)
print v(xbgr.mr_n76581728)
print v(xbgr.mr_n76582048)
print v(xbgr.mr_n76582160)
print v(xbgr.mr_n76582480)
print v(xbgr.mr_n76582592)
print v(xbgr.mr_n76582912)
print v(xbgr.mr_n76583024)
print v(xbgr.mr_n76583344)
print v(xbgr.mr_n76583456)
print v(xbgr.mr_n76583776)
print v(xbgr.mr_n76583888)
print v(xbgr.mr_n76584208)
print v(xbgr.mr_n76584320)
print v(xbgr.mr_n76584640)
print v(xbgr.mr_n76584752)
print v(xbgr.mr_n76585072)
print v(xbgr.mr_n76585184)
print v(xbgr.mr_n76585504)
print v(xbgr.mr_n76585616)
print v(xbgr.mr_n76585936)
print v(xbgr.mr_n76586048)
print v(xbgr.mr_n76586368)
print v(xbgr.mr_n76586480)
print v(xbgr.mr_n76586800)
print v(xbgr.mr_n76586912)
print v(xbgr.mr_n76587232)
print v(xbgr.mr_n76587344)
print v(xbgr.mr_n76587664)
print v(xbgr.mr_n76587776)
print v(xbgr.mr_n76588096)
print v(xbgr.mr_n76588208)
print v(xbgr.mr_n76588528)
print v(xbgr.mr_n76588640)
print v(xbgr.mr_n76588960)
print v(xbgr.mr_n76589072)
print v(xbgr.mr_n76589392)
print v(xbgr.mr_n76589504)
print v(xbgr.mr_n76589824)
print v(xbgr.mr_n76589936)
print v(xbgr.mr_n76590256)
print v(xbgr.mr_n76590368)
print v(xbgr.mr_n76590688)
print v(xbgr.mr_n76590800)
print v(xbgr.mr_n76591120)
print v(xbgr.mr_n76591232)
print v(xbgr.mr_n76591552)
print v(xbgr.mr_n76591664)
print v(xbgr.mr_n76591984)
print v(xbgr.mr_n76592096)
print v(xbgr.mr_n76592416)
print v(xbgr.mr_n76592528)
print v(xbgr.mr_n76592848)
print v(xbgr.mr_n76592960)
print v(xbgr.mr_n76593280)
print v(xbgr.mr_n76593392)
print v(xbgr.mr_n76593712)
print v(xbgr.mr_n76593824)
print v(xbgr.mr_n76594144)
print v(xbgr.mr_n76594256)
print v(xbgr.mr_n76594576)
print v(xbgr.mr_n76594688)
print v(xbgr.mr_n76595008)
print v(xbgr.mr_n76595120)
print v(xbgr.mr_n76595440)
print v(xbgr.mr_n76595552)
print v(xbgr.mr_n76595872)
print v(xbgr.mr_n76595984)
print v(xbgr.mr_n76596304)
print v(xbgr.mr_n76596416)
print v(xbgr.mr_n76596736)
print v(xbgr.mr_n76596848)
print v(xbgr.mr_n76597168)
print v(xbgr.mr_n76597280)
print v(xbgr.mr_n76597600)
print v(xbgr.mr_n76597712)
print v(xbgr.mr_n76598032)
print v(xbgr.mr_n76598144)
print v(xbgr.mr_n76598464)
print v(xbgr.mr_n76598576)
print v(xbgr.mr_n76598896)
print v(xbgr.mr_n76599008)
print v(xbgr.mr_n76599328)
print v(xbgr.mr_n76599440)
print v(xbgr.mr_n76599760)
print v(xbgr.mr_n76599872)
print v(xbgr.mr_n76600192)
print v(xbgr.mr_n76600304)
print v(xbgr.mr_n76600624)
print v(xbgr.mr_n76600736)
print v(xbgr.mr_n76601056)
print v(xbgr.mr_n76601168)
print v(xbgr.mr_n76601488)
print v(xbgr.mr_n76601600)
print v(xbgr.mr_n76601920)
print v(xbgr.mr_n76602032)
print v(xbgr.mr_n76602352)
print v(xbgr.mr_n76602464)
print v(xbgr.mr_n76602784)
print v(xbgr.mr_n76602896)
print v(xbgr.mr_n76603216)
print v(xbgr.mr_n76603328)
print v(xbgr.mr_n76603648)
print v(xbgr.mr_n76603760)
print v(xbgr.mr_n76604080)
print v(xbgr.mr_n76604192)
print v(xbgr.mr_n76604512)
print v(xbgr.mr_n76604624)
print v(xbgr.mr_n76604944)
print v(xbgr.mr_n76605056)
print v(xbgr.mr_n76605376)
print v(xbgr.mr_n76605488)
print v(xbgr.mr_n76605808)
print v(xbgr.mr_n76605920)
print v(xbgr.mr_n76606240)
print v(xbgr.mr_n76606352)
print v(xbgr.mr_n76606672)
print v(xbgr.mr_n76606784)
print v(xbgr.mr_n76607104)
print v(xbgr.mr_n76607216)
print v(xbgr.mr_n76607536)
print v(xbgr.mr_n76607648)
print v(xbgr.mr_n76607968)
print v(xbgr.mr_n76608080)
print v(xbgr.mr_n76608400)
print v(xbgr.mr_n76608512)
print v(xbgr.mr_n76608832)
print v(xbgr.mr_n76608944)
print v(xbgr.mr_n76609264)
print v(xbgr.mr_n76609376)
print v(xbgr.mr_n76609696)
print v(xbgr.mr_n76609808)
print v(xbgr.mr_n76610128)
print v(xbgr.mr_n76610240)
print v(xbgr.mr_n76610560)
print v(xbgr.mr_n76610672)
print v(xbgr.mr_n76610992)
print v(xbgr.mr_n76611104)
print v(xbgr.mr_n76611424)
print v(xbgr.mr_n76611536)
print v(xbgr.mr_n76611856)
print v(xbgr.mr_n76611968)
print v(xbgr.mr_n76612288)
print v(xbgr.mr_n76612400)
print v(xbgr.mr_n76612720)
print v(xbgr.mr_n76612832)
print v(xbgr.mr_n76613152)
print v(xbgr.mr_n76613264)
print v(xbgr.mr_n76613584)
print v(xbgr.mr_n76613696)
print v(xbgr.mr_n76614016)
print v(xbgr.mr_n76614128)
print v(xbgr.mr_n76614448)
print v(xbgr.mr_n76614560)
print v(xbgr.mr_n76614880)
print v(xbgr.mr_n76614992)
print v(xbgr.mr_n76615312)
print v(xbgr.mr_n76615424)
print v(xbgr.mr_n76615744)
print v(xbgr.mr_n76615856)
print v(xbgr.mr_n76616176)
print v(xbgr.mr_n76616288)
print v(xbgr.mr_n76616608)
print v(xbgr.mr_n76616720)
print v(xbgr.mr_n76617040)
print v(xbgr.mr_n76617152)
print v(xbgr.mr_n76617472)
print v(xbgr.mr_n76617584)
print v(xbgr.mr_n76617904)
print v(xbgr.mr_n76618016)
print v(xbgr.mr_n76618336)
print v(xbgr.mr_n76618448)
print v(xbgr.mr_n76618768)
print v(xbgr.mr_n76618880)
print v(xbgr.mr_n76619200)
print v(xbgr.mr_n76619312)
print v(xbgr.mr_n76619632)
print v(xbgr.mr_n76619744)
print v(xbgr.mr_n76620064)
print v(xbgr.mr_n76620176)
print v(xbgr.mr_n76620496)
print v(xbgr.mr_n76620608)
print v(xbgr.mr_n76620928)
print v(xbgr.mr_n76621040)
print v(xbgr.mr_n76621360)
print v(xbgr.mr_n76621472)
print v(xbgr.mr_n76621792)
print v(xbgr.mr_n76621904)
print v(xbgr.mr_n76622224)
print v(xbgr.mr_n76622336)
print v(xbgr.mr_n76622656)
print v(xbgr.mr_n76622768)
print v(xbgr.mr_n76623088)
print v(xbgr.mr_n76623200)
print v(xbgr.mr_n76623520)
print v(xbgr.mr_n76623632)
print v(xbgr.mr_n76623952)
print v(xbgr.mr_n76624064)
print v(xbgr.mr_n76624384)
print v(xbgr.mr_n76624496)
print v(xbgr.mr_n76624816)
print v(xbgr.mr_n76624928)
print v(xbgr.mr_n76625248)
print v(xbgr.mr_n76625360)
print v(xbgr.mr_n76625680)
print v(xbgr.mr_n76625792)
print v(xbgr.mr_n76626112)
print v(xbgr.mr_n76626224)
print v(xbgr.mr_n76626544)
print v(xbgr.mr_n76626656)
print v(xbgr.mr_n76626976)
print v(xbgr.mr_n76627088)
print v(xbgr.mr_n76627408)
print v(xbgr.mr_n76627520)
print v(xbgr.mr_n76627840)
print v(xbgr.mr_n76627952)
print v(xbgr.mr_n76628272)
print v(xbgr.mr_n76628384)
print v(xbgr.mr_n76628704)
print v(xbgr.mr_n76628816)
print v(xbgr.mr_n76629136)
print v(xbgr.mr_n76629248)
print v(xbgr.mr_n76629568)
print v(xbgr.mr_n76629680)
print v(xbgr.mr_n76630000)
print v(xbgr.mr_n76630112)
print v(xbgr.mr_n76630432)
print v(xbgr.mr_n76630544)
print v(xbgr.mr_n76630864)
print v(xbgr.mr_n76630976)
print v(xbgr.mr_n76631296)
print v(xbgr.mr_n76631408)
print v(xbgr.mr_n76631728)
print v(xbgr.mr_n76631840)
print v(xbgr.mr_n76632160)
print v(xbgr.mr_n76632272)
print v(xbgr.mr_n76632592)
print v(xbgr.mr_n76632704)
print v(xbgr.mr_n76633024)
print v(xbgr.mr_n76633136)
print v(xbgr.mr_n76633456)
print v(xbgr.mr_n76633568)
print v(xbgr.mr_n76633888)
print v(xbgr.mr_n76634000)
print v(xbgr.mr_n76634320)
print v(xbgr.mr_n76634432)
print v(xbgr.mr_n76634752)
print v(xbgr.mr_n76634864)
print v(xbgr.mr_n76635184)
print v(xbgr.mr_n76635296)
print v(xbgr.mr_n76635616)
print v(xbgr.mr_n76635728)
print v(xbgr.mr_n76636048)
print v(xbgr.mr_n76636160)
print v(xbgr.mr_n76636480)
print v(xbgr.mr_n76636592)
print v(xbgr.mr_n76636912)
print v(xbgr.mr_n76637024)
print v(xbgr.mr_n76637344)
print v(xbgr.mr_n76637456)
print v(xbgr.mr_n76637776)
print v(xbgr.mr_n76637888)
print v(xbgr.mr_n76638208)
print v(xbgr.mr_n76638320)
print v(xbgr.mr_n76638640)
print v(xbgr.mr_n76638752)
print v(xbgr.mr_n76639072)
print v(xbgr.mr_n76639184)
print v(xbgr.mr_n76639504)
print v(xbgr.mr_n76639616)
print v(xbgr.mr_n76639936)
print v(xbgr.mr_n76640048)
print v(xbgr.mr_n76640368)
print v(xbgr.mr_n76640480)
print v(xbgr.mr_n76640800)
print v(xbgr.mr_n76640912)
print v(xbgr.mr_n76641232)
print v(xbgr.mr_n76641344)
print v(xbgr.mr_n76641664)
print v(xbgr.mr_n76641776)
print v(xbgr.mr_n76642096)
print v(xbgr.mr_n76642208)
print v(xbgr.mr_n76642528)
print v(xbgr.mr_n76642640)
print v(xbgr.mr_n76642960)
print v(xbgr.mr_n76643072)
print v(xbgr.mr_n76643392)
print v(xbgr.mr_n76643504)
print v(xbgr.mr_n76643824)
print v(xbgr.mr_n76643936)
print v(xbgr.mr_n76644256)
print v(xbgr.mr_n76644368)
print v(xbgr.mr_n76644688)
print v(xbgr.mr_n76644800)
print v(xbgr.mr_n76645120)
print v(xbgr.mr_n76645232)
print v(xbgr.mr_n76645552)
print v(xbgr.mr_n76645664)
print v(xbgr.mr_n76645984)
print v(xbgr.mr_n76646096)
print v(xbgr.mr_n76646416)
print v(xbgr.mr_n76646528)
print v(xbgr.mr_n76646848)
print v(xbgr.mr_n76646960)
print v(xbgr.mr_n76647280)
print v(xbgr.mr_n76647392)
print v(xbgr.mr_n76647712)
print v(xbgr.mr_n76647824)
print v(xbgr.mr_n76648144)
print v(xbgr.mr_n76648256)
print v(xbgr.mr_n76648576)
print v(xbgr.mr_n76648688)
print v(xbgr.mr_n76649008)
print v(xbgr.mr_n76649120)
print v(xbgr.mr_n76649440)
print v(xbgr.mr_n76649552)
print v(xbgr.mr_n76649872)
print v(xbgr.mr_n76649984)
print v(xbgr.mr_n76650304)
print v(xbgr.mr_n76650416)
print v(xbgr.mr_n76650736)
print v(xbgr.mr_n76650848)
print v(xbgr.mr_n76651168)
print v(xbgr.mr_n76651280)
print v(xbgr.mr_n76651600)
print v(xbgr.mr_n76651712)
print v(xbgr.mr_n76652032)
print v(xbgr.mr_n76652144)
print v(xbgr.mr_n76652464)
print v(xbgr.mr_n76652576)
print v(xbgr.mr_n76652896)
print v(xbgr.mr_n76653008)
print v(xbgr.mr_n76653328)
print v(xbgr.mr_n76653440)
print v(xbgr.mr_n76653760)
print v(xbgr.mr_n76653872)
print v(xbgr.mr_n76654192)
print v(xbgr.mr_n76654304)
print v(xbgr.mr_n76654624)
print v(xbgr.mr_n76654736)
print v(xbgr.mr_n76655056)
print v(xbgr.mr_n76655168)
print v(xbgr.mr_n76655488)
print v(xbgr.mr_n76655600)
print v(xbgr.mr_n76655920)
print v(xbgr.mr_n76656032)
print v(xbgr.mr_n76656352)
print v(xbgr.mr_n76656464)
print v(xbgr.mr_n76656784)
print v(xbgr.mr_n76656896)
print v(xbgr.mr_n76657216)
print v(xbgr.mr_n76657328)
print v(xbgr.mr_n76657648)
print v(xbgr.mr_n76657760)
print v(xbgr.mr_n76658080)
print v(xbgr.mr_n76658192)
print v(xbgr.mr_n76658512)
print v(xbgr.mr_n76658624)
print v(xbgr.mr_n76658944)
print v(xbgr.mr_n76659056)
print v(xbgr.mr_n76659376)
print v(xbgr.mr_n76659488)
print v(xbgr.mr_n76659808)
print v(xbgr.mr_n76659920)
print v(xbgr.mr_n76660240)
print v(xbgr.mr_n76660352)
print v(xbgr.mr_n76660672)
print v(xbgr.mr_n76660784)
print v(xbgr.mr_n76661104)
print v(xbgr.mr_n76661216)
print v(xbgr.mr_n76661536)
print v(xbgr.mr_n76661648)
print v(xbgr.mr_n76661968)
print v(xbgr.mr_n76662080)
print v(xbgr.mr_n76662400)
print v(xbgr.mr_n76662512)
print v(xbgr.mr_n76662832)
print v(xbgr.mr_n76662944)
print v(xbgr.mr_n76663264)
print v(xbgr.mr_n76663376)
print v(xbgr.mr_n76663696)
print v(xbgr.mr_n76663808)
print v(xbgr.mr_n76664128)
print v(xbgr.mr_n76664240)
print v(xbgr.mr_n76664560)
print v(xbgr.mr_n76664672)
print v(xbgr.mr_n76664992)
print v(xbgr.mr_n76665104)
print v(xbgr.mr_n76665424)
print v(xbgr.mr_n76665536)
print v(xbgr.mr_n76665856)
print v(xbgr.mr_n76665968)
print v(xbgr.mr_n76666288)
print v(xbgr.mr_n76666400)
print v(xbgr.mr_n76666720)
print v(xbgr.mr_n76666832)
print v(xbgr.mr_n76667152)
print v(xbgr.mr_n76667264)
print v(xbgr.mr_n76667584)
print v(xbgr.mr_n76667696)
print v(xbgr.mr_n76668016)
print v(xbgr.mr_n76668128)
print v(xbgr.mr_n76668448)
print v(xbgr.mr_n76668560)
print v(xbgr.mr_n76668880)
print v(xbgr.mr_n76668992)
print v(xbgr.mr_n76669312)
print v(xbgr.mr_n76669424)
print v(xbgr.mr_n76669744)
print v(xbgr.mr_n76669856)
print v(xbgr.mr_n76670176)
print v(xbgr.mr_n76670288)
print v(xbgr.mr_n76670608)
print v(xbgr.mr_n76670720)
print v(xbgr.mr_n76671040)
print v(xbgr.mr_n76671152)
print v(xbgr.mr_n76671472)
print v(xbgr.mr_n76671584)
print v(xbgr.mr_n76671904)
print v(xbgr.mr_n76672016)
print v(xbgr.mr_n76672336)
print v(xbgr.mr_n76672448)
print v(xbgr.mr_n76672768)
print v(xbgr.mr_n76672880)
print v(xbgr.mr_n76673200)
print v(xbgr.mr_n76673312)
print v(xbgr.mr_n76673632)
print v(xbgr.mr_n76673744)
print v(xbgr.mr_n76674064)
print v(xbgr.mr_n76674176)
print v(xbgr.mr_n76674496)
print v(xbgr.mr_n76674608)
print v(xbgr.mr_n76674928)
print v(xbgr.mr_n76675040)
print v(xbgr.mr_n76675360)
print v(xbgr.mr_n76675472)
print v(xbgr.mr_n76675792)
print v(xbgr.mr_n76675904)
print v(xbgr.mr_n76676224)
print v(xbgr.mr_n76676336)
print v(xbgr.mr_n76676656)
print v(xbgr.mr_n76676768)
print v(xbgr.mr_n76677088)
print v(xbgr.mr_n76677200)
print v(xbgr.mr_n76677520)
print v(xbgr.mr_n76677632)
print v(xbgr.mr_n76677952)
print v(xbgr.mr_n76678064)
print v(xbgr.mr_n76678384)
print v(xbgr.mr_n76678496)
print v(xbgr.mr_n76678816)
print v(xbgr.mr_n76678928)
print v(xbgr.mr_n76679248)
print v(xbgr.mr_n76679360)
print v(xbgr.mr_n76679680)
print v(xbgr.mr_n76679792)
print v(xbgr.mr_n76680112)
print v(xbgr.mr_n76680224)
print v(xbgr.mr_n76680544)
print v(xbgr.mr_n76680656)
print v(xbgr.mr_n76680976)
print v(xbgr.mr_n76681088)
print v(xbgr.mr_n76681408)
print v(xbgr.mr_n76681520)
print v(xbgr.mr_n76681840)
print v(xbgr.mr_n76681952)
print v(xbgr.mr_n76682272)
print v(xbgr.mr_n76682384)
print v(xbgr.mr_n76682704)
print v(xbgr.mr_n76682816)
print v(xbgr.mr_n76683136)
print v(xbgr.mr_n76683248)
print v(xbgr.mr_n76683568)
print v(xbgr.mr_n76683680)
print v(xbgr.mr_n76684000)
print v(xbgr.mr_n76684112)
print v(xbgr.mr_n76684544)
print v(xbgr.mr_n76684864)
print v(xbgr.mr_n76684976)
print v(xbgr.mr_n76685296)
print v(xbgr.mr_n76685408)
print v(xbgr.mr_n76685728)
print v(xbgr.mr_n76685840)
print v(xbgr.mr_n76686272)
print v(xbgr.mr_n76686592)
print v(xbgr.mr_n76686704)
print v(xbgr.mr_n76687024)
print v(xbgr.mr_n76687136)
print v(xbgr.mr_n76687456)
print v(xbgr.mr_n76687568)
print v(xbgr.mr_n76687888)
print v(xbgr.mr_n76688000)
print v(xbgr.mr_n76688320)
print v(xbgr.mr_n76688432)
print v(xbgr.mr_n76688752)
print v(xbgr.mr_n76688864)
print v(xbgr.mr_n76689184)
print v(xbgr.mr_n76689296)
print v(xbgr.mr_n76689616)
print v(xbgr.mr_n76689728)
print v(xbgr.mr_n76690048)
print v(xbgr.mr_n76690160)
print v(xbgr.mr_n76690480)
print v(xbgr.mr_n76690592)
print v(xbgr.mr_n76690912)
print v(xbgr.mr_n76691024)
print v(xbgr.mr_n76691344)
print v(xbgr.mr_n76691456)
print v(xbgr.mr_n76691776)
print v(xbgr.mr_n76691888)
print v(xbgr.mr_n76692208)
print v(xbgr.mr_n76692320)
print v(xbgr.mr_n76692640)
print v(xbgr.mr_n76692752)
print v(xbgr.mr_n76693184)
print v(xbgr.mr_n76693504)
print v(xbgr.mr_n76693616)
print v(xbgr.mr_n76693936)
print v(xbgr.mr_n76694048)
print v(xbgr.mr_n76694368)
print v(xbgr.mr_n76694480)
print v(xbgr.mr_n76694800)
print v(xbgr.mr_n76694912)
print v(xbgr.mr_n76695232)
print v(xbgr.mr_n76695344)
print v(xbgr.mr_n76695664)
print v(xbgr.mr_n76695776)
print v(xbgr.mr_n76696096)
print v(xbgr.mr_n76696208)
print v(xbgr.mr_n76696640)
print v(xbgr.mr_n76696960)
print v(xbgr.mr_n76697072)
print v(xbgr.mr_n76697392)
print v(xbgr.mr_n76697504)
print v(xbgr.mr_n76697824)
print v(xbgr.mr_n76697936)
print v(xbgr.mr_n76698256)
print v(xbgr.mr_n76698368)
print v(xbgr.mr_n76698688)
print v(xbgr.mr_n76698800)
print v(xbgr.mr_n76699120)
print v(xbgr.mr_n76699232)
print v(xbgr.mr_n76699552)
print v(xbgr.mr_n76699664)
print v(xbgr.mr_n76699984)
print v(xbgr.mr_n76700096)
print v(xbgr.mr_n76700416)
print v(xbgr.mr_n76700528)
print v(xbgr.mr_n76700848)
print v(xbgr.mr_n76700960)
print v(xbgr.mr_n76701280)
print v(xbgr.mr_n76701392)
print v(xbgr.mr_n76701712)
print v(xbgr.mr_n76701824)
print v(xbgr.mr_n76702144)
print v(xbgr.mr_n76702256)
print v(xbgr.mr_n76702688)
print v(xbgr.mr_n76703008)
print v(xbgr.mr_n76703120)
print v(xbgr.mr_n76703440)
print v(xbgr.mr_n76703552)
print v(xbgr.mr_n76703872)
print v(xbgr.mr_n76703984)
print v(xbgr.mr_n76704416)
print v(xbgr.mr_n76704736)
print v(xbgr.mr_n76704848)
print v(xbgr.mr_n76705168)
print v(xbgr.mr_n76705280)
print v(xbgr.mr_n76705600)
print v(xbgr.mr_n76705712)
print v(xbgr.mr_n76706032)
print v(xbgr.mr_n76706144)
print v(xbgr.mr_n76706464)
print v(xbgr.mr_n76706576)
print v(xbgr.mr_n76707008)
print v(xbgr.mr_n76707328)
print v(xbgr.mr_n76707440)
print v(xbgr.mr_n76707760)
print v(xbgr.mr_n76707872)
print v(xbgr.mr_n76708192)
print v(xbgr.mr_n76708304)
print v(xbgr.mr_n76708624)
print v(xbgr.mr_n76708736)
print v(xbgr.mr_n76709056)
print v(xbgr.mr_n76709168)
print v(xbgr.mr_n76709488)
print v(xbgr.mr_n76709600)
print v(xbgr.mr_n76709920)
print v(xbgr.mr_n76710032)
print v(xbgr.mr_n76710352)
print v(xbgr.mr_n76710464)
print v(xbgr.mr_n76710784)
print v(xbgr.mr_n76710896)
print v(xbgr.mr_n76711216)
print v(xbgr.mr_n76711328)
print v(xbgr.mr_n76711648)
print v(xbgr.mr_n76711760)
print v(xbgr.mr_n76712080)
print v(xbgr.mr_n76712192)
print v(xbgr.mr_n76712512)
print v(xbgr.mr_n76712624)
print v(xbgr.mr_n76713056)
print v(xbgr.mr_n76713376)
print v(xbgr.mr_n76713488)
print v(xbgr.mr_n76713808)
print v(xbgr.mr_n76713920)
print v(xbgr.mr_n76714240)
print v(xbgr.mr_n76714352)
print v(xbgr.mr_n76714784)
print v(xbgr.mr_n76715104)
print v(xbgr.mr_n76715216)
print v(xbgr.mr_n76715648)
print v(xbgr.mr_n76715968)
print v(xbgr.mr_n76716080)
print v(xbgr.mr_n76716400)
print v(xbgr.mr_n76716512)
print v(xbgr.mr_n76716832)
print v(xbgr.mr_n76716944)
print v(xbgr.mr_n76717376)
print v(xbgr.mr_n76717696)
print v(xbgr.mr_n76717808)
print v(xbgr.mr_n76718128)
print v(xbgr.mr_n76718240)
print v(xbgr.mr_n76718560)
print v(xbgr.mr_n76718672)
print v(xbgr.mr_n76718992)
print v(xbgr.mr_n76719104)
print v(xbgr.mr_n76719424)
print v(xbgr.mr_n76719536)
print v(xbgr.mr_n76719856)
print v(xbgr.mr_n76719968)
print v(xbgr.mr_n76720288)
print v(xbgr.mr_n76720400)
print v(xbgr.mr_n76720720)
print v(xbgr.mr_n76720832)
print v(xbgr.mr_n76721152)
print v(xbgr.mr_n76721264)
print v(xbgr.mr_n76721696)
print v(xbgr.mr_n76722016)
print v(xbgr.mr_n76722128)
print v(xbgr.mr_n76722448)
print v(xbgr.mr_n76722560)
print v(xbgr.mr_n76722880)
print v(xbgr.mr_n76722992)
print v(xbgr.mr_n76723312)
print v(xbgr.mr_n76723424)
print v(xbgr.mr_n76723744)
print v(xbgr.mr_n76723856)
print v(xbgr.mr_n76724176)
print v(xbgr.mr_n76724288)
print v(xbgr.mr_n76724608)
print v(xbgr.mr_n76724720)
print v(xbgr.mr_n76725040)
print v(xbgr.mr_n76725152)
print v(xbgr.mr_n76725472)
print v(xbgr.mr_n76725584)
print v(xbgr.mr_n76725904)
print v(xbgr.mr_n76726016)
print v(xbgr.mr_n76726336)
print v(xbgr.mr_n76726448)
print v(xbgr.mr_n76726768)
print v(xbgr.mr_n76726880)
print v(xbgr.mr_n76727200)
print v(xbgr.mr_n76727312)
print v(xbgr.mr_n76727632)
print v(xbgr.mr_n76727744)
print v(xbgr.mr_n76728064)
print v(xbgr.mr_n76728176)
print v(xbgr.mr_n76728496)
print v(xbgr.mr_n76728608)
print v(xbgr.mr_n76728928)
print v(xbgr.mr_n76729040)
print v(xbgr.mr_n76729360)
print v(xbgr.mr_n76729472)
print v(xbgr.mr_n76729792)
print v(xbgr.mr_n76729904)
print v(xbgr.mr_n76730224)
print v(xbgr.mr_n76730336)
print v(xbgr.mr_n76730656)
print v(xbgr.mr_n76730768)
print v(xbgr.mr_n76731088)
print v(xbgr.mr_n76731200)
print v(xbgr.mr_n76731520)
print v(xbgr.mr_n76731632)
print v(xbgr.mr_n76731952)
print v(xbgr.mr_n76732064)
print v(xbgr.mr_n76732384)
print v(xbgr.mr_n76732496)
print v(xbgr.mr_n76732816)
print v(xbgr.mr_n76732928)
print v(xbgr.mr_n76733248)
print v(xbgr.mr_n76733360)
print v(xbgr.mr_n76733680)
print v(xbgr.mr_n76733792)
print v(xbgr.mr_n76734112)
print v(xbgr.mr_n76734224)
print v(xbgr.mr_n76734544)
print v(xbgr.mr_n76734656)
print v(xbgr.mr_n76734976)
print v(xbgr.mr_n76735088)
print v(xbgr.mr_n76735408)
print v(xbgr.mr_n76735520)
print v(xbgr.mr_n76735840)
print v(xbgr.mr_n76735952)
print v(xbgr.mr_n76736272)
print v(xbgr.mr_n76736384)
print v(xbgr.mr_n76736704)
print v(xbgr.mr_n76736816)
print v(xbgr.mr_n76737136)
print v(xbgr.mr_n76737248)
print v(xbgr.mr_n76737568)
print v(xbgr.mr_n76737680)
print v(xbgr.mr_n76738000)
print v(xbgr.mr_n76738112)
print v(xbgr.mr_n76738432)
print v(xbgr.mr_n76738544)
print v(xbgr.mr_n76738864)
print v(xbgr.mr_n76738976)
print v(xbgr.mr_n76739296)
print v(xbgr.mr_n76739408)
print v(xbgr.mr_n76739728)
print v(xbgr.mr_n76739840)
print v(xbgr.mr_n76740160)
print v(xbgr.mr_n76740272)
print v(xbgr.mr_n76740592)
print v(xbgr.mr_n76740704)
print v(xbgr.mr_n76741024)
print v(xbgr.mr_n76741136)
print v(xbgr.mr_n76741456)
print v(xbgr.mr_n76741568)
print v(xbgr.mr_n76741888)
print v(xbgr.mr_n76742000)
print v(xbgr.mr_n76742320)
print v(xbgr.mr_n76742432)
print v(xbgr.mr_n76742752)
print v(xbgr.mr_n76742864)
print v(xbgr.mr_n76743184)
print v(xbgr.mr_n76743296)
print v(xbgr.mr_n76743616)
print v(xbgr.mr_n76743728)
print v(xbgr.mr_n76744048)
print v(xbgr.mr_n76744160)
print v(xbgr.mr_n76744480)
print v(xbgr.mr_n76744592)
print v(xbgr.mr_n76744912)
print v(xbgr.mr_n76745024)
print v(xbgr.mr_n76745344)
print v(xbgr.mr_n76745456)
print v(xbgr.mr_n76745776)
print v(xbgr.mr_n76745888)
print v(xbgr.mr_n76746208)
print v(xbgr.mr_n76746320)
print v(xbgr.mr_n76746640)
print v(xbgr.mr_n76746752)
print v(xbgr.mr_n76747072)
print v(xbgr.mr_n76747184)
print v(xbgr.mr_n76747504)
print v(xbgr.mr_n76747616)
print v(xbgr.mr_n76747936)
print v(xbgr.mr_n76748048)
print v(xbgr.mr_n76748368)
print v(xbgr.mr_n76748480)
print v(xbgr.mr_n76748800)
print v(xbgr.mr_n76748912)
print v(xbgr.mr_n76749232)
print v(xbgr.mr_n76749344)
print v(xbgr.mr_n76749664)
print v(xbgr.mr_n76749776)
print v(xbgr.mr_n76750096)
print v(xbgr.mr_n76750208)
print v(xbgr.mr_n76750528)
print v(xbgr.mr_n76750640)
print v(xbgr.mr_n76750960)
print v(xbgr.mr_n76751072)
print v(xbgr.mr_n76751392)
print v(xbgr.mr_n76751504)
print v(xbgr.mr_n76751824)
print v(xbgr.mr_n76751936)
print v(xbgr.mr_n76752256)
print v(xbgr.mr_n76752368)
print v(xbgr.mr_n76752688)
print v(xbgr.mr_n76752800)
print v(xbgr.mr_n76753120)
print v(xbgr.mr_n76753232)
print v(xbgr.mr_n76753552)
print v(xbgr.mr_n76753664)
print v(xbgr.mr_n76753984)
print v(xbgr.mr_n76754096)
print v(xbgr.mr_n76754416)
print v(xbgr.mr_n76754528)
print v(xbgr.mr_n76754848)
print v(xbgr.mr_n76754960)
print v(xbgr.mr_n76755280)
print v(xbgr.mr_n76755392)
print v(xbgr.mr_n76755712)
print v(xbgr.mr_n76755824)
print v(xbgr.mr_n76756144)
print v(xbgr.mr_n76756256)
print v(xbgr.mr_n76756576)
print v(xbgr.mr_n76756688)
print v(xbgr.mr_n76757008)
print v(xbgr.mr_n76757120)
print v(xbgr.mr_n76757440)
print v(xbgr.mr_n76757552)
print v(xbgr.mr_n76757872)
print v(xbgr.mr_n76757984)
print v(xbgr.mr_n76758304)
print v(xbgr.mr_n76758416)
print v(xbgr.mr_n76758736)
print v(xbgr.mr_n76758848)
print v(xbgr.mr_n76759168)
print v(xbgr.mr_n76759280)
print v(xbgr.mr_n76759600)
print v(xbgr.mr_n76759712)
print v(xbgr.mr_n76760032)
print v(xbgr.mr_n76760144)
print v(xbgr.mr_n76760464)
print v(xbgr.mr_n76760576)
print v(xbgr.mr_n76760896)
print v(xbgr.mr_n76761008)
print v(xbgr.mr_n76761328)
print v(xbgr.mr_n76761440)
print v(xbgr.mr_n76761760)
print v(xbgr.mr_n76761872)
print v(xbgr.mr_n76762192)
print v(xbgr.mr_n76762304)
print v(xbgr.mr_n76762624)
print v(xbgr.mr_n76762736)
print v(xbgr.mr_n76763056)
print v(xbgr.mr_n76763168)
print v(xbgr.mr_n76763488)
print v(xbgr.mr_n76763600)
print v(xbgr.mr_n76763920)
print v(xbgr.mr_n76764032)
print v(xbgr.mr_n76764352)
print v(xbgr.mr_n76764464)
print v(xbgr.mr_n76764784)
print v(xbgr.mr_n76764896)
print v(xbgr.mr_n76765216)
print v(xbgr.mr_n76765328)
print v(xbgr.mr_n76765648)
print v(xbgr.mr_n76765760)
print v(xbgr.mr_n76766080)
print v(xbgr.mr_n76766192)
print v(xbgr.mr_n76766512)
print v(xbgr.mr_n76766624)
print v(xbgr.mr_n76766944)
print v(xbgr.mr_n76767056)
print v(xbgr.mr_n76767376)
print v(xbgr.mr_n76767488)
print v(xbgr.mr_n76767808)
print v(xbgr.mr_n76767920)
print v(xbgr.mr_n76768240)
print v(xbgr.mr_n76768352)
print v(xbgr.mr_n76768672)
print v(xbgr.mr_n76768784)
print v(xbgr.mr_n76769104)
print v(xbgr.mr_n76769216)
print v(xbgr.mr_n76769536)
print v(xbgr.mr_n76769648)
print v(xbgr.mr_n76769968)
print v(xbgr.mr_n76770080)
print v(xbgr.mr_n76770400)
print v(xbgr.mr_n76770512)
print v(xbgr.mr_n76770832)
print v(xbgr.mr_n76770944)
print v(xbgr.mr_n76771264)
print v(xbgr.mr_n76771376)
print v(xbgr.mr_n76771696)
print v(xbgr.mr_n76771808)
print v(xbgr.mr_n76772128)
print v(xbgr.mr_n76772240)
print v(xbgr.mr_n76772560)
print v(xbgr.mr_n76772672)
print v(xbgr.mr_n76772992)
print v(xbgr.mr_n76773104)
print v(xbgr.mr_n76773424)
print v(xbgr.mr_n76773536)
print v(xbgr.mr_n76773856)
print v(xbgr.mr_n76773968)
print v(xbgr.mr_n76774288)
print v(xbgr.mr_n76774400)
print v(xbgr.mr_n76774720)
print v(xbgr.mr_n76774832)
print v(xbgr.mr_n76775152)
print v(xbgr.mr_n76775264)
print v(xbgr.mr_n76775584)
print v(xbgr.mr_n76775696)
print v(xbgr.mr_n76776016)
print v(xbgr.mr_n76776128)
print v(xbgr.mr_n76776448)
print v(xbgr.mr_n76776560)
print v(xbgr.mr_n76776880)
print v(xbgr.mr_n76776992)
print v(xbgr.mr_n76777312)
print v(xbgr.mr_n76777424)
print v(xbgr.mr_n76777744)
print v(xbgr.mr_n76777856)
print v(xbgr.mr_n76778176)
print v(xbgr.mr_n76778288)
print v(xbgr.mr_n76778608)
print v(xbgr.mr_n76778720)
print v(xbgr.mr_n76779040)
print v(xbgr.mr_n76779152)
print v(xbgr.mr_n76779472)
print v(xbgr.mr_n76779584)
print v(xbgr.mr_n76779904)
print v(xbgr.mr_n76780016)
print v(xbgr.mr_n76780336)
print v(xbgr.mr_n76780448)
print v(xbgr.mr_n76780768)
print v(xbgr.mr_n76780880)
print v(xbgr.mr_n76781200)
print v(xbgr.mr_n76781312)
print v(xbgr.mr_n76781632)
print v(xbgr.mr_n76781744)
print v(xbgr.mr_n76782064)
print v(xbgr.mr_n76782176)
print v(xbgr.mr_n76782496)
print v(xbgr.mr_n76782608)
print v(xbgr.mr_n76782928)
print v(xbgr.mr_n76783040)
print v(xbgr.mr_n76783360)
print v(xbgr.mr_n76783472)
print v(xbgr.mr_n76783792)
print v(xbgr.mr_n76783904)
print v(xbgr.mr_n76784224)
print v(xbgr.mr_n76784336)
print v(xbgr.mr_n76784656)
print v(xbgr.mr_n76784768)
print v(xbgr.mr_n76785088)
print v(xbgr.mr_n76785200)
print v(xbgr.mr_n76785520)
print v(xbgr.mr_n76785632)
print v(xbgr.mr_n76785952)
print v(xbgr.mr_n76786064)
print v(xbgr.mr_n76786384)
print v(xbgr.mr_n76786496)
print v(xbgr.mr_n76786816)
print v(xbgr.mr_n76786928)
print v(xbgr.mr_n76787248)
print v(xbgr.mr_n76787360)
print v(xbgr.mr_n76787680)
print v(xbgr.mr_n76787792)
print v(xbgr.mr_n76788112)
print v(xbgr.mr_n76788224)
print v(xbgr.mr_n76788544)
print v(xbgr.mr_n76788656)
print v(xbgr.mr_n76788976)
print v(xbgr.mr_n76789088)
print v(xbgr.mr_n76789408)
print v(xbgr.mr_n76789520)
print v(xbgr.mr_n76789840)
print v(xbgr.mr_n76789952)
print v(xbgr.mr_n76790272)
print v(xbgr.mr_n76790384)
print v(xbgr.mr_n76790704)
print v(xbgr.mr_n76790816)
print v(xbgr.mr_n76791136)
print v(xbgr.mr_n76791248)
print v(xbgr.mr_n76791568)
print v(xbgr.mr_n76791680)
print v(xbgr.mr_n76792000)
print v(xbgr.mr_n76792112)
print v(xbgr.mr_n76792432)
print v(xbgr.mr_n76792544)
print v(xbgr.mr_n76792864)
print v(xbgr.mr_n76792976)
print v(xbgr.mr_n76793296)
print v(xbgr.mr_n76793408)
print v(xbgr.mr_n76793728)
print v(xbgr.mr_n76793840)
print v(xbgr.mr_n76794160)
print v(xbgr.mr_n76794272)
print v(xbgr.mr_n76794592)
print v(xbgr.mr_n76794704)
print v(xbgr.mr_n76795024)
print v(xbgr.mr_n76795136)
print v(xbgr.mr_n76795456)
print v(xbgr.mr_n76795568)
print v(xbgr.mr_n76795888)
print v(xbgr.mr_n76796000)
print v(xbgr.mr_n76796320)
print v(xbgr.mr_n76796432)
print v(xbgr.mr_n76796752)
print v(xbgr.mr_n76796864)
print v(xbgr.mr_n76797184)
print v(xbgr.mr_n76797296)
print v(xbgr.mr_n76797616)
print v(xbgr.mr_n76797728)
print v(xbgr.mr_n76798048)
print v(xbgr.mr_n76798160)
print v(xbgr.mr_n76798480)
print v(xbgr.mr_n76798592)
print v(xbgr.mr_n76798912)
print v(xbgr.mr_n76799024)
print v(xbgr.mr_n76799344)
print v(xbgr.mr_n76799456)
print v(xbgr.mr_n76799776)
print v(xbgr.mr_n76799888)
print v(xbgr.mr_n76800208)
print v(xbgr.mr_n76800320)
print v(xbgr.mr_n76800640)
print v(xbgr.mr_n76800752)
print v(xbgr.mr_n76801072)
print v(xbgr.mr_n76801184)
print v(xbgr.mr_n76801504)
print v(xbgr.mr_n76801616)
print v(xbgr.mr_n76801936)
print v(xbgr.mr_n76802048)
print v(xbgr.mr_n76802368)
print v(xbgr.mr_n76802480)
print v(xbgr.mr_n76802800)
print v(xbgr.mr_n76802912)
print v(xbgr.mr_n76803232)
print v(xbgr.mr_n76803344)
print v(xbgr.mr_n76803664)
print v(xbgr.mr_n76803776)
print v(xbgr.mr_n76804096)
print v(xbgr.mr_n76804208)
print v(xbgr.mr_n76804528)
print v(xbgr.mr_n76804640)
print v(xbgr.mr_n76804960)
print v(xbgr.mr_n76805072)
print v(xbgr.mr_n76805392)
print v(xbgr.mr_n76805504)
print v(xbgr.mr_n76805824)
print v(xbgr.mr_n76805936)
print v(xbgr.mr_n76806256)
print v(xbgr.mr_n76806368)
print v(xbgr.mr_n76806688)
print v(xbgr.mr_n76806800)
print v(xbgr.mr_n76807120)
print v(xbgr.mr_n76807232)
print v(xbgr.mr_n76807552)
print v(xbgr.mr_n76807664)
print v(xbgr.mr_n76807984)
print v(xbgr.mr_n76808096)
print v(xbgr.mr_n76808416)
print v(xbgr.mr_n76808528)
print v(xbgr.mr_n76808848)
print v(xbgr.mr_n76808960)
print v(xbgr.mr_n76809280)
print v(xbgr.mr_n76809392)
print v(xbgr.mr_n76809712)
print v(xbgr.mr_n76809824)
print v(xbgr.mr_n76810144)
print v(xbgr.mr_n76810256)
print v(xbgr.mr_n76810576)
print v(xbgr.mr_n76810688)
print v(xbgr.mr_n76811008)
print v(xbgr.mr_n76811120)
print v(xbgr.mr_n76811440)
print v(xbgr.mr_n76811552)
print v(xbgr.mr_n76811872)
print v(xbgr.mr_n76811984)
print v(xbgr.mr_n76812304)
print v(xbgr.mr_n76812416)
print v(xbgr.mr_n76812736)
print v(xbgr.mr_n76812848)
print v(xbgr.mr_n76813168)
print v(xbgr.mr_n76813280)
print v(xbgr.mr_n76813600)
print v(xbgr.mr_n76813712)
print v(xbgr.mr_n76814032)
print v(xbgr.mr_n76814144)
print v(xbgr.mr_n76814464)
print v(xbgr.mr_n76814576)
print v(xbgr.mr_n76814896)
print v(xbgr.mr_n76815008)
print v(xbgr.mr_n76815328)
print v(xbgr.mr_n76815440)
print v(xbgr.mr_n76815760)
print v(xbgr.mr_n76815872)
print v(xbgr.mr_n76816192)
print v(xbgr.mr_n76816304)
print v(xbgr.mr_n76816624)
print v(xbgr.mr_n76816736)
print v(xbgr.mr_n76817056)
print v(xbgr.mr_n76817168)
print v(xbgr.mr_n76817488)
print v(xbgr.mr_n76817600)
print v(xbgr.mr_n76817920)
print v(xbgr.mr_n76818032)
print v(xbgr.mr_n76818352)
print v(xbgr.mr_n76818464)
print v(xbgr.mr_n76818784)
print v(xbgr.mr_n76818896)
print v(xbgr.mr_n76819216)
print v(xbgr.mr_n76819328)
print v(xbgr.mr_n76819648)
print v(xbgr.mr_n76819760)
print v(xbgr.mr_n76820080)
print v(xbgr.mr_n76820192)
print v(xbgr.mr_n76820512)
print v(xbgr.mr_n76820624)
print v(xbgr.mr_n76820944)
print v(xbgr.mr_n76821056)
print v(xbgr.mr_n76821376)
print v(xbgr.mr_n76821488)
print v(xbgr.mr_n76821808)
print v(xbgr.mr_n76821920)
print v(xbgr.mr_n76822240)
print v(xbgr.mr_n76822352)
print v(xbgr.mr_n76822672)
print v(xbgr.mr_n76822784)
print v(xbgr.mr_n76823104)
print v(xbgr.mr_n76823216)
print v(xbgr.mr_n76823536)
print v(xbgr.mr_n76823648)
print v(xbgr.mr_n76823968)
print v(xbgr.mr_n76824080)
print v(xbgr.mr_n76824400)
print v(xbgr.mr_n76824512)
print v(xbgr.mr_n76824832)
print v(xbgr.mr_n76824944)
print v(xbgr.mr_n76825264)
print v(xbgr.mr_n76825376)
print v(xbgr.mr_n76825696)
print v(xbgr.mr_n76825808)
print v(xbgr.mr_n76826240)
print v(xbgr.mr_n76826560)
print v(xbgr.mr_n76826672)
print v(xbgr.mr_n76826992)
print v(xbgr.mr_n76827104)
print v(xbgr.mr_n76827424)
print v(xbgr.mr_n76827536)
print v(xbgr.mr_n76827856)
print v(xbgr.mr_n76827968)
print v(xbgr.mr_n76828288)
print v(xbgr.mr_n76828400)
print v(xbgr.mr_n76828832)
print v(xbgr.mr_n76829152)
print v(xbgr.mr_n76829264)
print v(xbgr.mr_n76829584)
print v(xbgr.mr_n76829696)
print v(xbgr.mr_n76830016)
print v(xbgr.mr_n76830128)
print v(xbgr.mr_n76830448)
print v(xbgr.mr_n76830560)
print v(xbgr.mr_n76830880)
print v(xbgr.mr_n76830992)
print v(xbgr.mr_n76831424)
print v(xbgr.mr_n76831744)
print v(xbgr.mr_n76831856)
print v(xbgr.mr_n76832176)
print v(xbgr.mr_n76832288)
print v(xbgr.mr_n76832608)
print v(xbgr.mr_n76832720)
print v(xbgr.mr_n76833040)
print v(xbgr.mr_n76833152)
print v(xbgr.mr_n76833472)
print v(xbgr.mr_n76833584)
print v(xbgr.mr_n76833904)
print v(xbgr.mr_n76834016)
print v(xbgr.mr_n76834336)
print v(xbgr.mr_n76834448)
print v(xbgr.mr_n76834880)
print v(xbgr.mr_n76835200)
print v(xbgr.mr_n76835312)
print v(xbgr.mr_n76835744)
print v(xbgr.mr_n76836064)
print v(xbgr.mr_n76836176)
print v(xbgr.mr_n76836496)
print v(xbgr.mr_n76836608)
print v(xbgr.mr_n76836928)
print v(xbgr.mr_n76837040)
print v(xbgr.mr_n76837360)
print v(xbgr.mr_n76837472)
print v(xbgr.mr_n76837792)
print v(xbgr.mr_n76837904)
print v(xbgr.mr_n76838336)
print v(xbgr.mr_n76838656)
print v(xbgr.mr_n76838768)
print v(xbgr.mr_n76839200)
print v(xbgr.mr_n76839520)
print v(xbgr.mr_n76839632)
print v(xbgr.mr_n76839952)
print v(xbgr.mr_n76840064)
print v(xbgr.mr_n76840384)
print v(xbgr.mr_n76840496)
print v(xbgr.mr_n76840816)
print v(xbgr.mr_n76840928)
print v(xbgr.mr_n76841248)
print v(xbgr.mr_n76841360)
print v(xbgr.mr_n76841680)
print v(xbgr.mr_n76841792)
print v(xbgr.mr_n76842112)
print v(xbgr.mr_n76842224)
print v(xbgr.mr_n76842544)
print v(xbgr.mr_n76842656)
print v(xbgr.mr_n76842976)
print v(xbgr.mr_n76843088)
print v(xbgr.mr_n76843408)
print v(xbgr.mr_n76843520)
print v(xbgr.mr_n76843840)
print v(xbgr.mr_n76843952)
print v(xbgr.mr_n76844272)
print v(xbgr.mr_n76844384)
print v(xbgr.mr_n76844704)
print v(xbgr.mr_n76844816)
print v(xbgr.mr_n76845136)
print v(xbgr.mr_n76845248)
print v(xbgr.mr_n76845568)
print v(xbgr.mr_n76845680)
print v(xbgr.mr_n76846000)
print v(xbgr.mr_n76846112)
print v(xbgr.mr_n76846432)
print v(xbgr.mr_n76846544)
print v(xbgr.mr_n76846864)
print v(xbgr.mr_n76846976)
print v(xbgr.mr_n76847296)
print v(xbgr.mr_n76847408)
print v(xbgr.mr_n76847728)
print v(xbgr.mr_n76847840)
print v(xbgr.mr_n76848160)
print v(xbgr.mr_n76848272)
print v(xbgr.mr_n76848592)
print v(xbgr.mr_n76848704)
print v(xbgr.mr_n76849024)
print v(xbgr.mr_n76849136)
print v(xbgr.mr_n76849456)
print v(xbgr.mr_n76849568)
print v(xbgr.mr_n76849888)
print v(xbgr.mr_n76850000)
print v(xbgr.mr_n76850320)
print v(xbgr.mr_n76850432)
print v(xbgr.mr_n76850752)
print v(xbgr.mr_n76850864)
print v(xbgr.mr_n76851184)
print v(xbgr.mr_n76851296)
print v(xbgr.mr_n76851616)
print v(xbgr.mr_n76851728)
print v(xbgr.mr_n76852048)
print v(xbgr.mr_n76852160)
print v(xbgr.mr_n76852480)
print v(xbgr.mr_n76852592)
print v(xbgr.mr_n76852912)
print v(xbgr.mr_n76853024)
print v(xbgr.mr_n76853344)
print v(xbgr.mr_n76853456)
print v(xbgr.mr_n76853776)
print v(xbgr.mr_n76853888)
print v(xbgr.mr_n76854208)
print v(xbgr.mr_n76854320)
print v(xbgr.mr_n76854640)
print v(xbgr.mr_n76854752)
print v(xbgr.mr_n76855072)
print v(xbgr.mr_n76855184)
print v(xbgr.mr_n76855504)
print v(xbgr.mr_n76855616)
print v(xbgr.mr_n76855936)
print v(xbgr.mr_n76856048)
print v(xbgr.mr_n76856368)
print v(xbgr.mr_n76856480)
print v(xbgr.mr_n76856800)
print v(xbgr.mr_n76856912)
print v(xbgr.mr_n76857232)
print v(xbgr.mr_n76857344)
print v(xbgr.mr_n76857664)
print v(xbgr.mr_n76857776)
print v(xbgr.mr_n76858096)
print v(xbgr.mr_n76858208)
print v(xbgr.mr_n76858528)
print v(xbgr.mr_n76858640)
print v(xbgr.mr_n76858960)
print v(xbgr.mr_n76859072)
print v(xbgr.mr_n76859392)
print v(xbgr.mr_n76859504)
print v(xbgr.mr_n76859824)
print v(xbgr.mr_n76859936)
print v(xbgr.mr_n76860256)
print v(xbgr.mr_n76860368)
print v(xbgr.mr_n76860688)
print v(xbgr.mr_n76860800)
print v(xbgr.mr_n76861120)
print v(xbgr.mr_n76861232)
print v(xbgr.mr_n76861552)
print v(xbgr.mr_n76861664)
print v(xbgr.mr_n76861984)
print v(xbgr.mr_n76862096)
print v(xbgr.mr_n76862416)
print v(xbgr.mr_n76862528)
print v(xbgr.mr_n76862848)
print v(xbgr.mr_n76862960)
print v(xbgr.mr_n76863280)
print v(xbgr.mr_n76863392)
print v(xbgr.mr_n76863712)
print v(xbgr.mr_n76863824)
print v(xbgr.mr_n76864144)
print v(xbgr.mr_n76864256)
print v(xbgr.mr_n76864576)
print v(xbgr.mr_n76864688)
print v(xbgr.mr_n76865008)
print v(xbgr.mr_n76865120)
print v(xbgr.mr_n76865440)
print v(xbgr.mr_n76865552)
print v(xbgr.mr_n76865872)
print v(xbgr.mr_n76865984)
print v(xbgr.mr_n76866304)
print v(xbgr.mr_n76866416)
print v(xbgr.mr_n76866736)
print v(xbgr.mr_n76866848)
print v(xbgr.mr_n76867168)
print v(xbgr.mr_n76867280)
print v(xbgr.mr_n76867600)
print v(xbgr.mr_n76867712)
print v(xbgr.mr_n76868032)
print v(xbgr.mr_n76868144)
print v(xbgr.mr_n76868464)
print v(xbgr.mr_n76868576)
print v(xbgr.mr_n76868896)
print v(xbgr.mr_n76869008)
print v(xbgr.mr_n76869328)
print v(xbgr.mr_n76869440)
print v(xbgr.mr_n76869760)
print v(xbgr.mr_n76869872)
print v(xbgr.mr_n76870192)
print v(xbgr.mr_n76870304)
print v(xbgr.mr_n76870624)
print v(xbgr.mr_n76870736)
print v(xbgr.mr_n76871056)
print v(xbgr.mr_n76871168)
print v(xbgr.mr_n76871488)
print v(xbgr.mr_n76871600)
print v(xbgr.mr_n76871920)
print v(xbgr.mr_n76872032)
print v(xbgr.mr_n76872352)
print v(xbgr.mr_n76872464)
print v(xbgr.mr_n76872896)
print v(xbgr.mr_n76873216)
print v(xbgr.mr_n76873328)
print v(xbgr.mr_n76873648)
print v(xbgr.mr_n76873760)
print v(xbgr.mr_n76874080)
print v(xbgr.mr_n76874192)
print v(xbgr.mr_n76874624)
print v(xbgr.mr_n76874944)
print v(xbgr.mr_n76875056)
print v(xbgr.mr_n76875488)
print v(xbgr.mr_n76875808)
print v(xbgr.mr_n76875920)
print v(xbgr.mr_n76876240)
print v(xbgr.mr_n76876352)
print v(xbgr.mr_n76876672)
print v(xbgr.mr_n76876784)
print v(xbgr.mr_n76877104)
print v(xbgr.mr_n76877216)
print v(xbgr.mr_n76877536)
print v(xbgr.mr_n76877648)
print v(xbgr.mr_n76877968)
print v(xbgr.mr_n76878080)
print v(xbgr.mr_n76878400)
print v(xbgr.mr_n76878512)
print v(xbgr.mr_n76878832)
print v(xbgr.mr_n76878944)
print v(xbgr.mr_n76879264)
print v(xbgr.mr_n76879376)
print v(xbgr.mr_n76879696)
print v(xbgr.mr_n76879808)
print v(xbgr.mr_n76880128)
print v(xbgr.mr_n76880240)
print v(xbgr.mr_n76880560)
print v(xbgr.mr_n76880672)
print v(xbgr.mr_n76880992)
print v(xbgr.mr_n76881104)
print v(xbgr.mr_n76881424)
print v(xbgr.mr_n76881536)
print v(xbgr.mr_n76881856)
print v(xbgr.mr_n76881968)
print v(xbgr.mr_n76882288)
print v(xbgr.mr_n76882400)
print v(xbgr.mr_n76882720)
print v(xbgr.mr_n76882832)
print v(xbgr.mr_n76883152)
print v(xbgr.mr_n76883264)
print v(xbgr.mr_n76883584)
print v(xbgr.mr_n76883696)
print v(xbgr.mr_n76884016)
print v(xbgr.mr_n76884128)
print v(xbgr.mr_n76884448)
print v(xbgr.mr_n76884560)
print v(xbgr.mr_n76884880)
print v(xbgr.mr_n76884992)
print v(xbgr.mr_n76885312)
print v(xbgr.mr_n76885424)
print v(xbgr.mr_n76885744)
print v(xbgr.mr_n76885856)
print v(xbgr.mr_n76886176)
print v(xbgr.mr_n76886288)
print v(xbgr.mr_n76886608)
print v(xbgr.mr_n76886720)
print v(xbgr.mr_n76887040)
print v(xbgr.mr_n76887152)
print v(xbgr.mr_n76887584)
print v(xbgr.mr_n76887904)
print v(xbgr.mr_n76888016)
print v(xbgr.mr_n76888336)
print v(xbgr.mr_n76888448)
print v(xbgr.mr_n76888768)
print v(xbgr.mr_n76888880)
print v(xbgr.mr_n76889200)
print v(xbgr.mr_n76889312)
print v(xbgr.mr_n76889632)
print v(xbgr.mr_n76889744)
print v(xbgr.mr_n76890064)
print v(xbgr.mr_n76890176)
print v(xbgr.mr_n76890496)
print v(xbgr.mr_n76890608)
print v(xbgr.mr_n76890928)
print v(xbgr.mr_n76891040)
print v(xbgr.mr_n76891360)
print v(xbgr.mr_n76891472)
print v(xbgr.mr_n76891904)
print v(xbgr.mr_n76892224)
print v(xbgr.mr_n76892336)
print v(xbgr.mr_n76892656)
print v(xbgr.mr_n76892768)
print v(xbgr.mr_n76893088)
print v(xbgr.mr_n76893200)
print v(xbgr.mr_n76893632)
print v(xbgr.mr_n76893952)
print v(xbgr.mr_n76894064)
print v(xbgr.mr_n76894384)
print v(xbgr.mr_n76894496)
print v(xbgr.mr_n76894816)
print v(xbgr.mr_n76894928)
print v(xbgr.mr_n76895248)
print v(xbgr.mr_n76895360)
print v(xbgr.mr_n76895680)
print v(xbgr.mr_n76895792)
print v(xbgr.mr_n76896224)
print v(xbgr.mr_n76896544)
print v(xbgr.mr_n76896656)
print v(xbgr.mr_n76896976)
print v(xbgr.mr_n76897088)
print v(xbgr.mr_n76897408)
print v(xbgr.mr_n76897520)
print v(xbgr.mr_n76897840)
print v(xbgr.mr_n76897952)
print v(xbgr.mr_n76898272)
print v(xbgr.mr_n76898384)
print v(xbgr.mr_n76898704)
print v(xbgr.mr_n76898816)
print v(xbgr.mr_n76899136)
print v(xbgr.mr_n76899248)
print v(xbgr.mr_n76899568)
print v(xbgr.mr_n76899680)
print v(xbgr.mr_n76900000)
print v(xbgr.mr_n76900112)
print v(xbgr.mr_n76900432)
print v(xbgr.mr_n76900544)
print v(xbgr.mr_n76900864)
print v(xbgr.mr_n76900976)
print v(xbgr.mr_n76901296)
print v(xbgr.mr_n76901408)
print v(xbgr.mr_n76901728)
print v(xbgr.mr_n76901840)
print v(xbgr.mr_n76902160)
print v(xbgr.mr_n76902272)
print v(xbgr.mr_n76902592)
print v(xbgr.mr_n76902704)
print v(xbgr.mr_n76903024)
print v(xbgr.mr_n76903136)
print v(xbgr.mr_n76903456)
print v(xbgr.mr_n76903568)
print v(xbgr.mr_n76903888)
print v(xbgr.mr_n76904000)
print v(xbgr.mr_n76904320)
print v(xbgr.mr_n76904432)
print v(xbgr.mr_n76904752)
print v(xbgr.mr_n76904864)
print v(xbgr.mr_n76905184)
print v(xbgr.mr_n76905296)
print v(xbgr.mr_n76905616)
print v(xbgr.mr_n76905728)
print v(xbgr.mr_n76906048)
print v(xbgr.mr_n76906160)
print v(xbgr.mr_n76906480)
print v(xbgr.mr_n76906592)
print v(xbgr.mr_n76906912)
print v(xbgr.mr_n76907024)
print v(xbgr.mr_n76907344)
print v(xbgr.mr_n76907456)
print v(xbgr.mr_n76907776)
print v(xbgr.mr_n76907888)
print v(xbgr.mr_n76908208)
print v(xbgr.mr_n76908320)
print v(xbgr.mr_n76908640)
print v(xbgr.mr_n76908752)
print v(xbgr.mr_n76909072)
print v(xbgr.mr_n76909184)
print v(xbgr.mr_n76909504)
print v(xbgr.mr_n76909616)
print v(xbgr.mr_n76909936)
print v(xbgr.mr_n76910048)
print v(xbgr.mr_n76910368)
print v(xbgr.mr_n76910480)
print v(xbgr.mr_n76910800)
print v(xbgr.mr_n76910912)
print v(xbgr.mr_n76911232)
print v(xbgr.mr_n76911344)
print v(xbgr.mr_n76911664)
print v(xbgr.mr_n76911776)
print v(xbgr.mr_n76912096)
print v(xbgr.mr_n76912208)
print v(xbgr.mr_n76912528)
print v(xbgr.mr_n76912640)
print v(xbgr.mr_n76912960)
print v(xbgr.mr_n76913072)
print v(xbgr.mr_n76913392)
print v(xbgr.mr_n76913504)
print v(xbgr.mr_n76913824)
print v(xbgr.mr_n76913936)
print v(xbgr.mr_n76914256)
print v(xbgr.mr_n76914368)
print v(xbgr.mr_n76914688)
print v(xbgr.mr_n76914800)
print v(xbgr.mr_n76915120)
print v(xbgr.mr_n76915232)
print v(xbgr.mr_n76915552)
print v(xbgr.mr_n76915664)
print v(xbgr.mr_n76915984)
print v(xbgr.mr_n76916096)
print v(xbgr.mr_n76916416)
print v(xbgr.mr_n76916528)
print v(xbgr.mr_n76916848)
print v(xbgr.mr_n76916960)
print v(xbgr.mr_n76917280)
print v(xbgr.mr_n76917392)
print v(xbgr.mr_n76917712)
print v(xbgr.mr_n76917824)
print v(xbgr.mr_n76918144)
print v(xbgr.mr_n76918256)
print v(xbgr.mr_n76918576)
print v(xbgr.mr_n76918688)
print v(xbgr.mr_n76919008)
print v(xbgr.mr_n76919120)
print v(xbgr.mr_n76919440)
print v(xbgr.mr_n76919552)
print v(xbgr.mr_n76919872)
print v(xbgr.mr_n76919984)
print v(xbgr.mr_n76920304)
print v(xbgr.mr_n76920416)
print v(xbgr.mr_n76920736)
print v(xbgr.mr_n76920848)
print v(xbgr.mr_n76921168)
print v(xbgr.mr_n76921280)
print v(xbgr.mr_n76921600)
print v(xbgr.mr_n76921712)
print v(xbgr.mr_n76922032)
print v(xbgr.mr_n76922144)
print v(xbgr.mr_n76922464)
print v(xbgr.mr_n76922576)
print v(xbgr.mr_n76922896)
print v(xbgr.mr_n76923008)
print v(xbgr.mr_n76923328)
print v(xbgr.mr_n76923440)
print v(xbgr.mr_n76923760)
print v(xbgr.mr_n76923872)
print v(xbgr.mr_n76924192)
print v(xbgr.mr_n76924304)
print v(xbgr.mr_n76924624)
print v(xbgr.mr_n76924736)
print v(xbgr.mr_n76925056)
print v(xbgr.mr_n76925168)
print v(xbgr.mr_n76925488)
print v(xbgr.mr_n76925600)
print v(xbgr.mr_n76925920)
print v(xbgr.mr_n76926032)
print v(xbgr.mr_n76926464)
print v(xbgr.mr_n76926784)
print v(xbgr.mr_n76926896)
print v(xbgr.mr_n76927216)
print v(xbgr.mr_n76927328)
print v(xbgr.mr_n76927648)
print v(xbgr.mr_n76927760)
print v(xbgr.mr_n76928192)
print v(xbgr.mr_n76928512)
print v(xbgr.mr_n76928624)
print v(xbgr.mr_n76929056)
print v(xbgr.mr_n76929376)
print v(xbgr.mr_n76929488)
print v(xbgr.mr_n76929808)
print v(xbgr.mr_n76929920)
print v(xbgr.mr_n76930240)
print v(xbgr.mr_n76930352)
print v(xbgr.mr_n76930672)
print v(xbgr.mr_n76930784)
print v(xbgr.mr_n76931104)
print v(xbgr.mr_n76931216)
print v(xbgr.mr_n76931536)
print v(xbgr.mr_n76931648)
print v(xbgr.mr_n76931968)
print v(xbgr.mr_n76932080)
print v(xbgr.mr_n76932400)
print v(xbgr.mr_n76932512)
print v(xbgr.mr_n76932832)
print v(xbgr.mr_n76932944)
print v(xbgr.mr_n76933264)
print v(xbgr.mr_n76933376)
print v(xbgr.mr_n76933696)
print v(xbgr.mr_n76933808)
print v(xbgr.mr_n76934128)
print v(xbgr.mr_n76934240)
print v(xbgr.mr_n76934560)
print v(xbgr.mr_n76934672)
print v(xbgr.mr_n76934992)
print v(xbgr.mr_n76935104)
print v(xbgr.mr_n76935424)
print v(xbgr.mr_n76935536)
print v(xbgr.mr_n76935856)
print v(xbgr.mr_n76935968)
print v(xbgr.mr_n76936288)
print v(xbgr.mr_n76936400)
print v(xbgr.mr_n76936720)
print v(xbgr.mr_n76936832)
print v(xbgr.mr_n76937152)
print v(xbgr.mr_n76937264)
print v(xbgr.mr_n76937584)
print v(xbgr.mr_n76937696)
print v(xbgr.mr_n76938016)
print v(xbgr.mr_n76938128)
print v(xbgr.mr_n76938448)
print v(xbgr.mr_n76938560)
print v(xbgr.mr_n76938880)
print v(xbgr.mr_n76938992)
print v(xbgr.mr_n76939312)
print v(xbgr.mr_n76939424)
print v(xbgr.mr_n76939744)
print v(xbgr.mr_n76939856)
print v(xbgr.mr_n76940176)
print v(xbgr.mr_n76940288)
print v(xbgr.mr_n76940608)
print v(xbgr.mr_n76940720)
print v(xbgr.mr_n76941040)
print v(xbgr.mr_n76941152)
print v(xbgr.mr_n76941472)
print v(xbgr.mr_n76941584)
print v(xbgr.mr_n76941904)
print v(xbgr.mr_n76942016)
print v(xbgr.mr_n76942336)
print v(xbgr.mr_n76942448)
print v(xbgr.mr_n76942768)
print v(xbgr.mr_n76942880)
print v(xbgr.mr_n76943200)
print v(xbgr.mr_n76943312)
print v(xbgr.mr_n76943632)
print v(xbgr.mr_n76943744)
print v(xbgr.mr_n76944064)
print v(xbgr.mr_n76944176)
print v(xbgr.mr_n76944496)
print v(xbgr.mr_n76944608)
print v(xbgr.mr_n76944928)
print v(xbgr.mr_n76945040)
print v(xbgr.mr_n76945360)
print v(xbgr.mr_n76945472)
print v(xbgr.mr_n76945792)
print v(xbgr.mr_n76945904)
print v(xbgr.mr_n76946224)
print v(xbgr.mr_n76946336)
print v(xbgr.mr_n76946656)
print v(xbgr.mr_n76946768)
print v(xbgr.mr_n76947088)
print v(xbgr.mr_n76947200)
print v(xbgr.mr_n76947520)
print v(xbgr.mr_n76947632)
print v(xbgr.mr_n76947952)
print v(xbgr.mr_n76948064)
print v(xbgr.mr_n76948384)
print v(xbgr.mr_n76948496)
print v(xbgr.mr_n76948816)
print v(xbgr.mr_n76948928)
print v(xbgr.mr_n76949248)
print v(xbgr.mr_n76949360)
print v(xbgr.mr_n76949680)
print v(xbgr.mr_n76949792)
print v(xbgr.mr_n76950112)
print v(xbgr.mr_n76950224)
print v(xbgr.mr_n76950544)
print v(xbgr.mr_n76950656)
print v(xbgr.mr_n76950976)
print v(xbgr.mr_n76951088)
print v(xbgr.mr_n76951408)
print v(xbgr.mr_n76951520)
print v(xbgr.mr_n76951840)
print v(xbgr.mr_n76951952)
print v(xbgr.mr_n76952272)
print v(xbgr.mr_n76952384)
print v(xbgr.mr_n76952704)
print v(xbgr.mr_n76952816)
print v(xbgr.mr_n76953136)
print v(xbgr.mr_n76953248)
print v(xbgr.mr_n76953568)
print v(xbgr.mr_n76953680)
print v(xbgr.mr_n76954000)
print v(xbgr.mr_n76954112)
print v(xbgr.mr_n76954432)
print v(xbgr.mr_n76954544)
print v(xbgr.mr_n76954864)
print v(xbgr.mr_n76954976)
print v(xbgr.mr_n76955296)
print v(xbgr.mr_n76955408)
print v(xbgr.mr_n76955728)
print v(xbgr.mr_n76955840)
print v(xbgr.mr_n76956160)
print v(xbgr.mr_n76956272)
print v(xbgr.mr_n76956592)
print v(xbgr.mr_n76956704)
print v(xbgr.mr_n76957024)
print v(xbgr.mr_n76957136)
print v(xbgr.mr_n76957456)
print v(xbgr.mr_n76957568)
print v(xbgr.mr_n76957888)
print v(xbgr.mr_n76958000)
print v(xbgr.mr_n76958320)
print v(xbgr.mr_n76958432)
print v(xbgr.mr_n76958752)
print v(xbgr.mr_n76958864)
print v(xbgr.mr_n76959184)
print v(xbgr.mr_n76959296)
print v(xbgr.mr_n76959616)
print v(xbgr.mr_n76959728)
print v(xbgr.mr_n76960048)
print v(xbgr.mr_n76960160)
print v(xbgr.mr_n76960480)
print v(xbgr.mr_n76960592)
print v(xbgr.mr_n76960912)
print v(xbgr.mr_n76961024)
print v(xbgr.mr_n76961344)
print v(xbgr.mr_n76961456)
print v(xbgr.mr_n76961776)
print v(xbgr.mr_n76961888)
print v(xbgr.mr_n76962208)
print v(xbgr.mr_n76962320)
print v(xbgr.mr_n76962640)
print v(xbgr.mr_n76962752)
print v(xbgr.mr_n76963072)
print v(xbgr.mr_n76963184)
print v(xbgr.mr_n76963504)
print v(xbgr.mr_n76963616)
print v(xbgr.mr_n76963936)
print v(xbgr.mr_n76964048)
print v(xbgr.mr_n76964368)
print v(xbgr.mr_n76964480)
print v(xbgr.mr_n76964800)
print v(xbgr.mr_n76964912)
print v(xbgr.mr_n76965232)
print v(xbgr.mr_n76965344)
print v(xbgr.mr_n76965664)
print v(xbgr.mr_n76965776)
print v(xbgr.mr_n76966096)
print v(xbgr.mr_n76966208)
print v(xbgr.mr_n76966528)
print v(xbgr.mr_n76966640)
print v(xbgr.mr_n76966960)
print v(xbgr.mr_n76967072)
print v(xbgr.mr_n76967392)
print v(xbgr.mr_n76967504)
print v(xbgr.mr_n76967824)
print v(xbgr.mr_n76967936)
print v(xbgr.mr_n76968256)
print v(xbgr.mr_n76968368)
print v(xbgr.mr_n76968688)
print v(xbgr.mr_n76968800)
print v(xbgr.mr_n76969120)
print v(xbgr.mr_n76969232)
print v(xbgr.mr_n76969552)
print v(xbgr.mr_n76969664)
print v(xbgr.mr_n76969984)
print v(xbgr.mr_n76970096)
print v(xbgr.mr_n76970416)
print v(xbgr.mr_n76970528)
print v(xbgr.mr_n76970848)
print v(xbgr.mr_n76970960)
print v(xbgr.mr_n76971280)
print v(xbgr.mr_n76971392)
print v(xbgr.mr_n76971712)
print v(xbgr.mr_n76971824)
print v(xbgr.mr_n76972144)
print v(xbgr.mr_n76972256)
print v(xbgr.mr_n76972576)
print v(xbgr.mr_n76972688)
print v(xbgr.mr_n76973008)
print v(xbgr.mr_n76973120)
print v(xbgr.mr_n76973440)
print v(xbgr.mr_n76973552)
print v(xbgr.mr_n76973872)
print v(xbgr.mr_n76973984)
print v(xbgr.mr_n76974304)
print v(xbgr.mr_n76974416)
print v(xbgr.mr_n76974736)
print v(xbgr.mr_n76974848)
print v(xbgr.mr_n76975168)
print v(xbgr.mr_n76975280)
print v(xbgr.mr_n76975600)
print v(xbgr.mr_n76975712)
print v(xbgr.mr_n76976032)
print v(xbgr.mr_n76976144)
print v(xbgr.mr_n76976464)
print v(xbgr.mr_n76976576)
print v(xbgr.mr_n76976896)
print v(xbgr.mr_n76977008)
print v(xbgr.mr_n76977328)
print v(xbgr.mr_n76977440)
print v(xbgr.mr_n76977760)
print v(xbgr.mr_n76977872)
print v(xbgr.mr_n76978192)
print v(xbgr.mr_n76978304)
print v(xbgr.mr_n76978624)
print v(xbgr.mr_n76978736)
print v(xbgr.mr_n76979056)
print v(xbgr.mr_n76979168)
print v(xbgr.mr_n76979488)
print v(xbgr.mr_n76979600)
print v(xbgr.mr_n76979920)
print v(xbgr.mr_n76980032)
print v(xbgr.mr_n76980352)
print v(xbgr.mr_n76980464)
print v(xbgr.mr_n76980784)
print v(xbgr.mr_n76980896)
print v(xbgr.mr_n76981216)
print v(xbgr.mr_n76981328)
print v(xbgr.mr_n76981648)
print v(xbgr.mr_n76981760)
print v(xbgr.mr_n76982080)
print v(xbgr.mr_n76982192)
print v(xbgr.mr_n76982512)
print v(xbgr.mr_n76982624)
print v(xbgr.mr_n76982944)
print v(xbgr.mr_n76983056)
print v(xbgr.mr_n76983376)
print v(xbgr.mr_n76983488)
print v(xbgr.mr_n76983808)
print v(xbgr.mr_n76983920)
print v(xbgr.mr_n76984240)
print v(xbgr.mr_n76984352)
print v(xbgr.mr_n76984672)
print v(xbgr.mr_n76984784)
print v(xbgr.mr_n76985104)
print v(xbgr.mr_n76985216)
print v(xbgr.mr_n76985536)
print v(xbgr.mr_n76985648)
print v(xbgr.mr_n76985968)
print v(xbgr.mr_n76986080)
print v(xbgr.mr_n76986400)
print v(xbgr.mr_n76986512)
print v(xbgr.mr_n76986832)
print v(xbgr.mr_n76986944)
print v(xbgr.mr_n76987264)
print v(xbgr.mr_n76987376)
print v(xbgr.mr_n76987696)
print v(xbgr.mr_n76987808)
print v(xbgr.mr_n76988128)
print v(xbgr.mr_n76988240)
print v(xbgr.mr_n76988560)
print v(xbgr.mr_n76988672)
print v(xbgr.mr_n76988992)
print v(xbgr.mr_n76989104)
print v(xbgr.mr_n76989424)
print v(xbgr.mr_n76989536)
print v(xbgr.mr_n76989856)
print v(xbgr.mr_n76989968)
print v(xbgr.mr_n76990288)
print v(xbgr.mr_n76990400)
print v(xbgr.mr_n76990720)
print v(xbgr.mr_n76990832)
print v(xbgr.mr_n76991152)
print v(xbgr.mr_n76991264)
print v(xbgr.mr_n76991584)
print v(xbgr.mr_n76991696)
print v(xbgr.mr_n76992016)
print v(xbgr.mr_n76992128)
print v(xbgr.mr_n76992448)
print v(xbgr.mr_n76992560)
print v(xbgr.mr_n76992880)
print v(xbgr.mr_n76992992)
print v(xbgr.mr_n76993312)
print v(xbgr.mr_n76993424)
print v(xbgr.mr_n76993744)
print v(xbgr.mr_n76993856)
print v(xbgr.mr_n76994176)
print v(xbgr.mr_n76994288)
print v(xbgr.mr_n76994608)
print v(xbgr.mr_n76994720)
print v(xbgr.mr_n76995040)
print v(xbgr.mr_n76995152)
print v(xbgr.mr_n76995472)
print v(xbgr.mr_n76995584)
print v(xbgr.mr_n76995904)
print v(xbgr.mr_n76996016)
print v(xbgr.mr_n76996336)
print v(xbgr.mr_n76996448)
print v(xbgr.mr_n76996768)
print v(xbgr.mr_n76996880)
print v(xbgr.mr_n76997200)
print v(xbgr.mr_n76997312)
print v(xbgr.mr_n76997632)
print v(xbgr.mr_n76997744)
print v(xbgr.mr_n76998064)
print v(xbgr.mr_n76998176)
print v(xbgr.mr_n76998496)
print v(xbgr.mr_n76998608)
print v(xbgr.mr_n76998928)
print v(xbgr.mr_n76999040)
print v(xbgr.mr_n76999360)
print v(xbgr.mr_n76999472)
print v(xbgr.mr_n76999792)
print v(xbgr.mr_n76999904)
print v(xbgr.mr_n77000224)
print v(xbgr.mr_n77000336)
print v(xbgr.mr_n77000656)
print v(xbgr.mr_n77000768)
print v(xbgr.mr_n77001088)
print v(xbgr.mr_n77001200)
print v(xbgr.mr_n77001520)
print v(xbgr.mr_n77001632)
print v(xbgr.mr_n77001952)
print v(xbgr.mr_n77002064)
print v(xbgr.mr_n77002384)
print v(xbgr.mr_n77002496)
print v(xbgr.mr_n77002816)
print v(xbgr.mr_n77002928)
print v(xbgr.mr_n77003248)
print v(xbgr.mr_n77003360)
print v(xbgr.mr_n77003680)
print v(xbgr.mr_n77003792)
print v(xbgr.mr_n77004112)
print v(xbgr.mr_n77004224)
print v(xbgr.mr_n77004544)
print v(xbgr.mr_n77004656)
print v(xbgr.mr_n77004976)
print v(xbgr.mr_n77005088)
print v(xbgr.mr_n77005408)
print v(xbgr.mr_n77005520)
print v(xbgr.mr_n77005840)
print v(xbgr.mr_n77005952)
print v(xbgr.mr_n77006272)
print v(xbgr.mr_n77006384)
print v(xbgr.mr_n77006704)
print v(xbgr.mr_n77006816)
print v(xbgr.mr_n77007136)
print v(xbgr.mr_n77007248)
print v(xbgr.mr_n77007568)
print v(xbgr.mr_n77007680)
print v(xbgr.mr_n77008000)
print v(xbgr.mr_n77008112)
print v(xbgr.mr_n77008432)
print v(xbgr.mr_n77008544)
print v(xbgr.mr_n77008864)
print v(xbgr.mr_n77008976)
print v(xbgr.mr_n77009296)
print v(xbgr.mr_n77009408)
print v(xbgr.mr_n77009728)
print v(xbgr.mr_n77009840)
print v(xbgr.mr_n77010160)
print v(xbgr.mr_n77010272)
print v(xbgr.mr_n77010592)
print v(xbgr.mr_n77010704)
print v(xbgr.mr_n77011024)
print v(xbgr.mr_n77011136)
print v(xbgr.mr_n77011456)
print v(xbgr.mr_n77011568)
print v(xbgr.mr_n77011888)
print v(xbgr.mr_n77012000)
print v(xbgr.mr_n77012320)
print v(xbgr.mr_n77012432)
print v(xbgr.mr_n77012752)
print v(xbgr.mr_n77012864)
print v(xbgr.mr_n77013184)
print v(xbgr.mr_n77013296)
print v(xbgr.mr_n77013616)
print v(xbgr.mr_n77013728)
print v(xbgr.mr_n77014048)
print v(xbgr.mr_n77014160)
print v(xbgr.mr_n77014480)
print v(xbgr.mr_n77014592)
print v(xbgr.mr_n77014912)
print v(xbgr.mr_n77015024)
print v(xbgr.mr_n77015344)
print v(xbgr.mr_n77015456)
print v(xbgr.mr_n77015776)
print v(xbgr.mr_n77015888)
print v(xbgr.mr_n77016208)
print v(xbgr.mr_n77016320)
print v(xbgr.mr_n77016640)
print v(xbgr.mr_n77016752)
print v(xbgr.mr_n77017072)
print v(xbgr.mr_n77017184)
print v(xbgr.mr_n77017504)
print v(xbgr.mr_n77017616)
print v(xbgr.mr_n77017936)
print v(xbgr.mr_n77018048)
print v(xbgr.mr_n77018368)
print v(xbgr.mr_n77018480)
print v(xbgr.mr_n77018800)
print v(xbgr.mr_n77018912)
print v(xbgr.mr_n77019232)
print v(xbgr.mr_n77019344)
print v(xbgr.mr_n77085216)
print v(xbgr.mr_n77085328)
print v(xbgr.mr_n77085648)
print v(xbgr.mr_n77085760)
print v(xbgr.mr_n77086080)
print v(xbgr.mr_n77086192)
print v(xbgr.mr_n77086624)
print v(xbgr.mr_n77086944)
print v(xbgr.mr_n77087056)
print v(xbgr.mr_n77087376)
print v(xbgr.mr_n77087488)
print v(xbgr.mr_n77087920)
print v(xbgr.mr_n77088352)
print v(xbgr.mr_n77088672)
print v(xbgr.mr_n77088784)
print v(xbgr.mr_n77089104)
print v(xbgr.mr_n77089216)
print v(xbgr.mr_n77089536)
print v(xbgr.mr_n77089648)
print v(xbgr.mr_n77089968)
print v(xbgr.mr_n77090080)
print v(xbgr.mr_n77090400)
print v(xbgr.mr_n77090512)
print v(xbgr.mr_n77090832)
print v(xbgr.mr_n77090944)
print v(xbgr.mr_n77091264)
print v(xbgr.mr_n77091376)
print v(xbgr.mr_n77091696)
print v(xbgr.mr_n77091808)
print v(xbgr.mr_n77092128)
print v(xbgr.mr_n77092240)
print v(xbgr.mr_n77092560)
print v(xbgr.mr_n77092672)
print v(xbgr.mr_n77092992)
print v(xbgr.mr_n77093104)
print v(xbgr.mr_n77093424)
print v(xbgr.mr_n77093536)
print v(xbgr.mr_n77093968)
print v(xbgr.mr_n77094288)
print v(xbgr.mr_n77094400)
print v(xbgr.mr_n77094720)
print v(xbgr.mr_n77094832)
print v(xbgr.mr_n77095152)
print v(xbgr.mr_n77095264)
print v(xbgr.mr_n77095584)
print v(xbgr.mr_n77095696)
print v(xbgr.mr_n77096016)
print v(xbgr.mr_n77096128)
print v(xbgr.mr_n77096448)
print v(xbgr.mr_n77096560)
print v(xbgr.mr_n77096880)
print v(xbgr.mr_n77096992)
print v(xbgr.mr_n77097312)
print v(xbgr.mr_n77097424)
print v(xbgr.mr_n77097744)
print v(xbgr.mr_n77097856)
print v(xbgr.mr_n77098176)
print v(xbgr.mr_n77098288)
print v(xbgr.mr_n77098720)
print v(xbgr.mr_n77099152)
print v(xbgr.mr_n77099472)
print v(xbgr.mr_n77099584)
print v(xbgr.mr_n77099904)
print v(xbgr.mr_n77100016)
print v(xbgr.mr_n77100336)
print v(xbgr.mr_n77100448)
print v(xbgr.mr_n77100768)
print v(xbgr.mr_n77100880)
print v(xbgr.mr_n77101200)
print v(xbgr.mr_n77101312)
print v(xbgr.mr_n77101632)
print v(xbgr.mr_n77101744)
print v(xbgr.mr_n77102064)
print v(xbgr.mr_n77102176)
print v(xbgr.mr_n77102496)
print v(xbgr.mr_n77102608)
print v(xbgr.mr_n77102928)
print v(xbgr.mr_n77103040)
print v(xbgr.mr_n77103360)
print v(xbgr.mr_n77103472)
print v(xbgr.mr_n77103792)
print v(xbgr.mr_n77103904)
print v(xbgr.mr_n77104224)
print v(xbgr.mr_n77104336)
print v(xbgr.mr_n77104656)
print v(xbgr.mr_n77104768)
print v(xbgr.mr_n77105088)
print v(xbgr.mr_n77105200)
print v(xbgr.mr_n77105520)
print v(xbgr.mr_n77105632)
print v(xbgr.mr_n77105952)
print v(xbgr.mr_n77106064)
print v(xbgr.mr_n77106384)
print v(xbgr.mr_n77106496)
print v(xbgr.mr_n77106816)
print v(xbgr.mr_n77106928)
print v(xbgr.mr_n77107248)
print v(xbgr.mr_n77107360)
print v(xbgr.mr_n77107680)
print v(xbgr.mr_n77107792)
print v(xbgr.mr_n77108112)
print v(xbgr.mr_n77108224)
print v(xbgr.mr_n77108544)
print v(xbgr.mr_n77108656)
print v(xbgr.mr_n77108976)
print v(xbgr.mr_n77109088)
print v(xbgr.mr_n77109408)
print v(xbgr.mr_n77109520)
print v(xbgr.mr_n77109840)
print v(xbgr.mr_n77109952)
print v(xbgr.mr_n77110272)
print v(xbgr.mr_n77110384)
print v(xbgr.mr_n77110704)
print v(xbgr.mr_n77110816)
print v(xbgr.mr_n77111136)
print v(xbgr.mr_n77111248)
print v(xbgr.mr_n77111568)
print v(xbgr.mr_n77111680)
print v(xbgr.mr_n77112000)
print v(xbgr.mr_n77112112)
print v(xbgr.mr_n77112432)
print v(xbgr.mr_n77112544)
print v(xbgr.mr_n77112864)
print v(xbgr.mr_n77112976)
print v(xbgr.mr_n77113296)
print v(xbgr.mr_n77113408)
print v(xbgr.mr_n77113728)
print v(xbgr.mr_n77113840)
print v(xbgr.mr_n77114160)
print v(xbgr.mr_n77114272)
print v(xbgr.mr_n77114592)
print v(xbgr.mr_n77114704)
print v(xbgr.mr_n77115024)
print v(xbgr.mr_n77115136)
print v(xbgr.mr_n77115456)
print v(xbgr.mr_n77115568)
print v(xbgr.mr_n77115888)
print v(xbgr.mr_n77116000)
print v(xbgr.mr_n77116320)
print v(xbgr.mr_n77116432)
print v(xbgr.mr_n77116752)
print v(xbgr.mr_n77116864)
print v(xbgr.mr_n77117184)
print v(xbgr.mr_n77117296)
print v(xbgr.mr_n77117616)
print v(xbgr.mr_n77117728)
print v(xbgr.mr_n77118048)
print v(xbgr.mr_n77118160)
print v(xbgr.mr_n77118480)
print v(xbgr.mr_n77118592)
print v(xbgr.mr_n77118912)
print v(xbgr.mr_n77119024)
print v(xbgr.mr_n77119344)
print v(xbgr.mr_n77119456)
print v(xbgr.mr_n77119776)
print v(xbgr.mr_n77119888)
print v(xbgr.mr_n77120208)
print v(xbgr.mr_n77120320)
print v(xbgr.mr_n77120640)
print v(xbgr.mr_n77120752)
print v(xbgr.mr_n77121072)
print v(xbgr.mr_n77121184)
print v(xbgr.mr_n77121504)
print v(xbgr.mr_n77121616)
print v(xbgr.mr_n77121936)
print v(xbgr.mr_n77122048)
print v(xbgr.mr_n77122368)
print v(xbgr.mr_n77122480)
print v(xbgr.mr_n77122800)
print v(xbgr.mr_n77122912)
print v(xbgr.mr_n77123232)
print v(xbgr.mr_n77123344)
print v(xbgr.mr_n77123664)
print v(xbgr.mr_n77123776)
print v(xbgr.mr_n77124096)
print v(xbgr.mr_n77124208)
print v(xbgr.mr_n77124528)
print v(xbgr.mr_n77124640)
print v(xbgr.mr_n77124960)
print v(xbgr.mr_n77125072)
print v(xbgr.mr_n77125392)
print v(xbgr.mr_n77125504)
print v(xbgr.mr_n77125824)
print v(xbgr.mr_n77125936)
print v(xbgr.mr_n77126256)
print v(xbgr.mr_n77126368)
print v(xbgr.mr_n77126688)
print v(xbgr.mr_n77126800)
print v(xbgr.mr_n77127120)
print v(xbgr.mr_n77127232)
print v(xbgr.mr_n77127552)
print v(xbgr.mr_n77127664)
print v(xbgr.mr_n77127984)
print v(xbgr.mr_n77128096)
print v(xbgr.mr_n77128416)
print v(xbgr.mr_n77128528)
print v(xbgr.mr_n77128848)
print v(xbgr.mr_n77128960)
print v(xbgr.mr_n77129280)
print v(xbgr.mr_n77129392)
print v(xbgr.mr_n77129712)
print v(xbgr.mr_n77129824)
print v(xbgr.mr_n77130144)
print v(xbgr.mr_n77130256)
print v(xbgr.mr_n77130576)
print v(xbgr.mr_n77130688)
print v(xbgr.mr_n77131008)
print v(xbgr.mr_n77131120)
print v(xbgr.mr_n77131440)
print v(xbgr.mr_n77131552)
print v(xbgr.mr_n77131872)
print v(xbgr.mr_n77131984)
print v(xbgr.mr_n77132304)
print v(xbgr.mr_n77132416)
print v(xbgr.mr_n77132736)
print v(xbgr.mr_n77132848)
print v(xbgr.mr_n77133168)
print v(xbgr.mr_n77133280)
print v(xbgr.mr_n77133600)
print v(xbgr.mr_n77133712)
print v(xbgr.mr_n77134032)
print v(xbgr.mr_n77134144)
print v(xbgr.mr_n77134464)
print v(xbgr.mr_n77134576)
print v(xbgr.mr_n77134896)
print v(xbgr.mr_n77135008)
print v(xbgr.mr_n77135328)
print v(xbgr.mr_n77135440)
print v(xbgr.mr_n77135760)
print v(xbgr.mr_n77135872)
print v(xbgr.mr_n77136192)
print v(xbgr.mr_n77136304)
print v(xbgr.mr_n77136624)
print v(xbgr.mr_n77136736)
print v(xbgr.mr_n77137056)
print v(xbgr.mr_n77137168)
print v(xbgr.mr_n77137488)
print v(xbgr.mr_n77137600)
print v(xbgr.mr_n77137920)
print v(xbgr.mr_n77138032)
print v(xbgr.mr_n77138352)
print v(xbgr.mr_n77138464)
print v(xbgr.mr_n77138784)
print v(xbgr.mr_n77138896)
print v(xbgr.mr_n77139216)
print v(xbgr.mr_n77139328)
print v(xbgr.mr_n77139648)
print v(xbgr.mr_n77139760)
print v(xbgr.mr_n77140080)
print v(xbgr.mr_n77140192)
print v(xbgr.mr_n77140512)
print v(xbgr.mr_n77140624)
print v(xbgr.mr_n77140944)
print v(xbgr.mr_n77141056)
print v(xbgr.mr_n77141376)
print v(xbgr.mr_n77141488)
print v(xbgr.mr_n77141808)
print v(xbgr.mr_n77141920)
print v(xbgr.mr_n77142240)
print v(xbgr.mr_n77142352)
print v(xbgr.mr_n77142672)
print v(xbgr.mr_n77142784)
print v(xbgr.mr_n77143104)
print v(xbgr.mr_n77143216)
print v(xbgr.mr_n77143536)
print v(xbgr.mr_n77143648)
print v(xbgr.mr_n77143968)
print v(xbgr.mr_n77144080)
print v(xbgr.mr_n77144400)
print v(xbgr.mr_n77144512)
print v(xbgr.mr_n77144832)
print v(xbgr.mr_n77144944)
print v(xbgr.mr_n77145264)
print v(xbgr.mr_n77145376)
print v(xbgr.mr_n77145696)
print v(xbgr.mr_n77145808)
print v(xbgr.mr_n77146128)
print v(xbgr.mr_n77146240)
print v(xbgr.mr_n77146560)
print v(xbgr.mr_n77146672)
print v(xbgr.mr_n77146992)
print v(xbgr.mr_n77147104)
print v(xbgr.mr_n77147424)
print v(xbgr.mr_n77147536)
print v(xbgr.mr_n77147856)
print v(xbgr.mr_n77147968)
print v(xbgr.mr_n77148288)
print v(xbgr.mr_n77148400)
print v(xbgr.mr_n77148720)
print v(xbgr.mr_n77148832)
print v(xbgr.mr_n77149152)
print v(xbgr.mr_n77149264)
print v(xbgr.mr_n77149584)
print v(xbgr.mr_n77149696)
print v(xbgr.mr_n77150016)
print v(xbgr.mr_n77150128)
print v(xbgr.mr_n77150448)
print v(xbgr.mr_n77150560)
print v(xbgr.mr_n77150880)
print v(xbgr.mr_n77150992)
print v(xbgr.mr_n77151312)
print v(xbgr.mr_n77151424)
print v(xbgr.mr_n77151744)
print v(xbgr.mr_n77151856)
print v(xbgr.mr_n77152176)
print v(xbgr.mr_n77152288)
print v(xbgr.mr_n77152608)
print v(xbgr.mr_n77152720)
print v(xbgr.mr_n77153040)
print v(xbgr.mr_n77153152)
print v(xbgr.mr_n77153472)
print v(xbgr.mr_n77153584)
print v(xbgr.mr_n77153904)
print v(xbgr.mr_n77154016)
print v(xbgr.mr_n77154336)
print v(xbgr.mr_n77154448)
print v(xbgr.mr_n77154768)
print v(xbgr.mr_n77154880)
print v(xbgr.mr_n77155200)
print v(xbgr.mr_n77155312)
print v(xbgr.mr_n77155632)
print v(xbgr.mr_n77155744)
print v(xbgr.mr_n77156064)
print v(xbgr.mr_n77156176)
print v(xbgr.mr_n77156496)
print v(xbgr.mr_n77156608)
print v(xbgr.mr_n77156928)
print v(xbgr.mr_n77157040)
print v(xbgr.mr_n77157360)
print v(xbgr.mr_n77157472)
print v(xbgr.mr_n77157792)
print v(xbgr.mr_n77157904)
print v(xbgr.mr_n77158224)
print v(xbgr.mr_n77158336)
print v(xbgr.mr_n77158656)
print v(xbgr.mr_n77158768)
print v(xbgr.mr_n77159088)
print v(xbgr.mr_n77159200)
print v(xbgr.mr_n77159520)
print v(xbgr.mr_n77159632)
print v(xbgr.mr_n77159952)
print v(xbgr.mr_n77160064)
print v(xbgr.mr_n77160384)
print v(xbgr.mr_n77160496)
print v(xbgr.mr_n77160816)
print v(xbgr.mr_n77160928)
print v(xbgr.mr_n77161248)
print v(xbgr.mr_n77161360)
print v(xbgr.mr_n77161680)
print v(xbgr.mr_n77161792)
print v(xbgr.mr_n77162112)
print v(xbgr.mr_n77162224)
print v(xbgr.mr_n77162544)
print v(xbgr.mr_n77162656)
print v(xbgr.mr_n77162976)
print v(xbgr.mr_n77163088)
print v(xbgr.mr_n77163408)
print v(xbgr.mr_n77163520)
print v(xbgr.mr_n77163840)
print v(xbgr.mr_n77163952)
print v(xbgr.mr_n77164272)
print v(xbgr.mr_n77164384)
print v(xbgr.mr_n77164704)
print v(xbgr.mr_n77164816)
print v(xbgr.mr_n77165136)
print v(xbgr.mr_n77165248)
print v(xbgr.mr_n77165568)
print v(xbgr.mr_n77165680)
print v(xbgr.mr_n77166000)
print v(xbgr.mr_n77166112)
print v(xbgr.mr_n77166432)
print v(xbgr.mr_n77166544)
print v(xbgr.mr_n77166864)
print v(xbgr.mr_n77166976)
print v(xbgr.mr_n77167408)
print v(xbgr.mr_n77167728)
print v(xbgr.mr_n77167840)
print v(xbgr.mr_n77168160)
print v(xbgr.mr_n77168272)
print v(xbgr.mr_n77168592)
print v(xbgr.mr_n77168704)
print v(xbgr.mr_n77169024)
print v(xbgr.mr_n77169136)
print v(xbgr.mr_n77169456)
print v(xbgr.mr_n77170320)
print v(xbgr.mr_n77170432)
print v(xbgr.mr_n77170752)
print v(xbgr.mr_n77170864)
print v(xbgr.mr_n77171184)
print v(xbgr.mr_n77171296)
print v(xbgr.mr_n77171616)
print v(xbgr.mr_n77171728)
print v(xbgr.mr_n77172048)
print v(xbgr.mr_n77172160)
print v(xbgr.mr_n77172592)
print v(xbgr.mr_n77172912)
print v(xbgr.mr_n77173024)
print v(xbgr.mr_n77173344)
print v(xbgr.mr_n77173456)
print v(xbgr.mr_n77173776)
print v(xbgr.mr_n77173888)
print v(xbgr.mr_n77174208)
print v(xbgr.mr_n77174320)
print v(xbgr.mr_n77174640)
print v(xbgr.mr_n77174752)
print v(xbgr.mr_n77175184)
print v(xbgr.mr_n77175504)
print v(xbgr.mr_n77176368)
print v(xbgr.mr_n77176480)
print v(xbgr.mr_n77176912)
print v(xbgr.mr_n77177232)
print v(xbgr.mr_n77178096)
print v(xbgr.mr_n77178208)
print v(xbgr.mr_n77178640)
print v(xbgr.mr_n77178960)
print v(xbgr.mr_n77179072)
print v(xbgr.mr_n77179392)
print v(xbgr.mr_n77179504)
print v(xbgr.mr_n77179824)
print v(xbgr.mr_n77179936)
print v(xbgr.mr_n77180256)
print v(xbgr.mr_n77180368)
print v(xbgr.mr_n77180688)
print v(xbgr.mr_n77180800)
print v(xbgr.mr_n77181120)
print v(xbgr.mr_n77181232)
print v(xbgr.mr_n77181552)
print v(xbgr.mr_n77182416)
print v(xbgr.mr_n77182528)
print v(xbgr.mr_n77182848)
print v(xbgr.mr_n77182960)
print v(xbgr.mr_n77183280)
print v(xbgr.mr_n77184144)
print v(xbgr.mr_n77184256)
print v(xbgr.mr_n77184576)
print v(xbgr.mr_n77184688)
print v(xbgr.mr_n77185008)
print v(xbgr.mr_n77185120)
print v(xbgr.mr_n77185440)
print v(xbgr.mr_n77185552)
print v(xbgr.mr_n77185872)
print v(xbgr.mr_n77185984)
print v(xbgr.mr_n77186304)
print v(xbgr.mr_n77186416)
print v(xbgr.mr_n77186736)
print v(xbgr.mr_n77186848)
print v(xbgr.mr_n77187168)
print v(xbgr.mr_n77187280)
print v(xbgr.mr_n77187600)
print v(xbgr.mr_n77187712)
print v(xbgr.mr_n77188032)
print v(xbgr.mr_n77188144)
print v(xbgr.mr_n77188464)
print v(xbgr.mr_n77188576)
print v(xbgr.mr_n77188896)
print v(xbgr.mr_n77189008)
print v(xbgr.mr_n77189328)
print v(xbgr.mr_n77189440)
print v(xbgr.mr_n77189760)
print v(xbgr.mr_n77189872)
print v(xbgr.mr_n77190192)
print v(xbgr.mr_n77190304)
print v(xbgr.mr_n77190624)
print v(xbgr.mr_n77190736)
print v(xbgr.mr_n77191056)
print v(xbgr.mr_n77191168)
print v(xbgr.mr_n77191488)
print v(xbgr.mr_n77191600)
print v(xbgr.mr_n77191920)
print v(xbgr.mr_n77192032)
print v(xbgr.mr_n77192352)
print v(xbgr.mr_n77192464)
print v(xbgr.mr_n77192784)
print v(xbgr.mr_n77192896)
print v(xbgr.mr_n77193216)
print v(xbgr.mr_n77193328)
print v(xbgr.mr_n77193648)
print v(xbgr.mr_n77193760)
print v(xbgr.mr_n77194080)
print v(xbgr.mr_n77194192)
print v(xbgr.mr_n77194512)
print v(xbgr.mr_n77194624)
print v(xbgr.mr_n77194944)
print v(xbgr.mr_n77195056)
print v(xbgr.mr_n77195488)
print v(xbgr.mr_n77195920)
print v(xbgr.mr_n77196352)
print v(xbgr.mr_n77196784)
print v(xbgr.mr_n77197216)
print v(xbgr.mr_n77197648)
print v(xbgr.mr_n77198080)
print v(xbgr.mr_n77198512)
print v(xbgr.mr_n77198944)
print v(xbgr.mr_n77199376)
print v(xbgr.mr_n77199808)
print v(xbgr.mr_n77200240)
print v(xbgr.mr_n77200672)
print v(xbgr.mr_n77201104)
print v(xbgr.mr_n77201536)
print v(xbgr.mr_n77201968)
print v(xbgr.mr_n77202400)
print v(xbgr.mr_n77202832)
print v(xbgr.mr_n77203264)
print v(xbgr.mr_n77203696)
print v(xbgr.mr_n77204128)
print v(xbgr.mr_n77204560)
print v(xbgr.mr_n77204880)
print v(xbgr.mr_n77204992)
print v(xbgr.mr_n77205424)
print v(xbgr.mr_n77205856)
print v(xbgr.mr_n77206288)
print v(xbgr.mr_n77206720)
print v(xbgr.mr_n77207152)
print v(xbgr.mr_n77207584)
print v(xbgr.mr_n77208016)
print v(xbgr.mr_n77208448)
print v(xbgr.mr_n77208880)
print v(xbgr.mr_n77209312)
print v(xbgr.mr_n77209744)
print v(xbgr.mr_n77210176)
print v(xbgr.mr_n77210608)
print v(xbgr.mr_n77211040)
print v(xbgr.mr_n77211472)
print v(xbgr.mr_n77211904)
print v(xbgr.mr_n77212336)
print v(xbgr.mr_n77212768)
print v(xbgr.mr_n77213200)
print v(xbgr.mr_n77213632)
print v(xbgr.mr_n77214064)
print v(xbgr.mr_n77214496)
print v(xbgr.mr_n77214928)
print v(xbgr.mr_n77215360)
print v(xbgr.mr_n77215792)
print v(xbgr.mr_n77216224)
print v(xbgr.mr_n77216656)
print v(xbgr.mr_n77217088)
print v(xbgr.mr_n77217520)
print v(xbgr.mr_n77217952)
print v(xbgr.mr_n77218384)
print v(xbgr.mr_n77218816)
print v(xbgr.mr_n77219248)
print v(xbgr.mr_n77219680)
print v(xbgr.mr_n77220112)
print v(xbgr.mr_n77220544)
print v(xbgr.mr_n77220976)
print v(xbgr.mr_n77221408)
print v(xbgr.mr_n77221840)
print v(xbgr.mr_n77222272)
print v(xbgr.mr_n77222704)
print v(xbgr.mr_n77223136)
print v(xbgr.mr_n77223568)
print v(xbgr.mr_n77224000)
print v(xbgr.mr_n77224432)
print v(xbgr.mr_n77224864)
print v(xbgr.mr_n77225296)
print v(xbgr.mr_n77225728)
print v(xbgr.mr_n77226160)
print v(xbgr.mr_n77226592)
print v(xbgr.mr_n77227024)
print v(xbgr.mr_n77227456)
print v(xbgr.mr_n77227888)
print v(xbgr.mr_n77228320)
print v(xbgr.mr_n77228752)
print v(xbgr.mr_n77229184)
print v(xbgr.mr_n77229616)
print v(xbgr.mr_n77230048)
print v(xbgr.mr_n77230480)
print v(xbgr.mr_n77230912)
print v(xbgr.mr_n77231344)
print v(xbgr.mr_n77231776)
print v(xbgr.mr_n77232208)
print v(xbgr.mr_n77232528)
print v(xbgr.mr_n77232640)
print v(xbgr.mr_n77232960)
print v(xbgr.mr_n77233072)
print v(xbgr.mr_n77233392)
print v(xbgr.mr_n77233504)
print v(xbgr.mr_n77233824)
print v(xbgr.mr_n77233936)
print v(xbgr.mr_n77234256)
print v(xbgr.mr_n77234368)
print v(xbgr.mr_n77234688)
print v(xbgr.mr_n77234800)
print v(xbgr.mr_n77235120)
print v(xbgr.mr_n77235232)
print v(xbgr.mr_n77235552)
print v(xbgr.mr_n77235664)
print v(xbgr.mr_n77235984)
print v(xbgr.mr_n77236096)
print v(xbgr.mr_n77236416)
print v(xbgr.mr_n77236528)
print v(xbgr.mr_n77236848)
print v(xbgr.mr_n77236960)
print v(xbgr.mr_n77237280)
print v(xbgr.mr_n77237392)
print v(xbgr.mr_n77237712)
print v(xbgr.mr_n77238144)
print v(xbgr.mr_n77238256)
print v(xbgr.mr_n77238576)
print v(xbgr.mr_n77238688)
print v(xbgr.mr_n77239008)
print v(xbgr.mr_n77239120)
print v(xbgr.mr_n77239440)
print v(xbgr.mr_n77239552)
print v(xbgr.mr_n77239872)
print v(xbgr.mr_n77239984)
print v(xbgr.mr_n77240304)
print v(xbgr.mr_n77240416)
print v(xbgr.mr_n77240736)
print v(xbgr.mr_n77240848)
print v(xbgr.mr_n77241168)
print v(xbgr.mr_n77241280)
print v(xbgr.mr_n77241600)
print v(xbgr.mr_n77241712)
print v(xbgr.mr_n77242032)
print v(xbgr.mr_n77242144)
print v(xbgr.mr_n77242464)
print v(xbgr.mr_n77242576)
print v(xbgr.mr_n77243008)
print v(xbgr.mr_n77243440)
print v(xbgr.mr_n77243872)
print v(xbgr.mr_n77244304)
print v(xbgr.mr_n77244736)
print v(xbgr.mr_n77245168)
print v(xbgr.mr_n77245600)
print v(xbgr.mr_n77246032)
print v(xbgr.mr_n77246464)
print v(xbgr.mr_n77246896)
print v(xbgr.mr_n77247328)
print v(xbgr.mr_n77247760)
print v(xbgr.mr_n77248192)
print v(xbgr.mr_n77248624)
print v(xbgr.mr_n77249056)
print v(xbgr.mr_n77249488)
print v(xbgr.mr_n77249920)
print v(xbgr.mr_n77250352)
print v(xbgr.mr_n77250784)
print v(xbgr.mr_n77251216)
print v(xbgr.mr_n77251648)
print v(xbgr.mr_n77252080)
print v(xbgr.mr_n77252512)
print v(xbgr.mr_n77252944)
print v(xbgr.mr_n77253376)
print v(xbgr.mr_n77253808)
print v(xbgr.mr_n77254240)
print v(xbgr.mr_n77254672)
print v(xbgr.mr_n77255104)
print v(xbgr.mr_n77255536)
print v(xbgr.mr_n77255968)
print v(xbgr.mr_n77256400)
print v(xbgr.mr_n77256832)
print v(xbgr.mr_n77257264)
print v(xbgr.mr_n77257696)
print v(xbgr.mr_n77258128)
print v(xbgr.mr_n77258560)
print v(xbgr.mr_n77258992)
print v(xbgr.mr_n77259424)
print v(xbgr.mr_n77259856)
print v(xbgr.mr_n77260288)
print v(xbgr.mr_n77260720)
print v(xbgr.mr_n77261152)
print v(xbgr.mr_n77261584)
print v(xbgr.mr_n77262016)
print v(xbgr.mr_n77262448)
print v(xbgr.mr_n77262880)
print v(xbgr.mr_n77263312)
print v(xbgr.mr_n77263744)
print v(xbgr.mr_n77264176)
print v(xbgr.mr_n77264608)
print v(xbgr.mr_n77265040)
print v(xbgr.mr_n77265472)
print v(xbgr.mr_n77265904)
print v(xbgr.mr_n77266336)
print v(xbgr.mr_n77266768)
print v(xbgr.mr_n77267200)
print v(xbgr.mr_n77267632)
print v(xbgr.mr_n77268064)
print v(xbgr.mr_n77268496)
print v(xbgr.mr_n77268928)
print v(xbgr.mr_n77269360)
print v(xbgr.mr_n77269792)
print v(xbgr.mr_n77270224)
print v(xbgr.mr_n77270656)
print v(xbgr.mr_n77271088)
print v(xbgr.mr_n77271520)
print v(xbgr.mr_n77271952)
print v(xbgr.mr_n77272384)
print v(xbgr.mr_n77272816)
print v(xbgr.mr_n77273248)
print v(xbgr.mr_n77273680)
print v(xbgr.mr_n77274112)
print v(xbgr.mr_n77274544)
print v(xbgr.mr_n77274976)
print v(xbgr.mr_n77275408)
print v(xbgr.mr_n77275840)
print v(xbgr.mr_n77276272)
print v(xbgr.mr_n77276704)
print v(xbgr.mr_n77277136)
print v(xbgr.mr_n77277568)
print v(xbgr.mr_n77278000)
print v(xbgr.mr_n77278432)
print v(xbgr.mr_n77278864)
print v(xbgr.mr_n77279296)
print v(xbgr.mr_n77279728)
print v(xbgr.mr_n77280048)
print v(xbgr.mr_n77280160)
print v(xbgr.mr_n77280480)
print v(xbgr.mr_n77280592)
print v(xbgr.mr_n77280912)
print v(xbgr.mr_n77281024)
print v(xbgr.mr_n77281344)
print v(xbgr.mr_n77281456)
print v(xbgr.mr_n77281776)
print v(xbgr.mr_n77281888)
print v(xbgr.mr_n77282208)
print v(xbgr.mr_n77282320)
print v(xbgr.mr_n77282640)
print v(xbgr.mr_n77282752)
print v(xbgr.mr_n77283072)
print v(xbgr.mr_n77283184)
print v(xbgr.mr_n77283504)
print v(xbgr.mr_n77283616)
print v(xbgr.mr_n77283936)
print v(xbgr.mr_n77284048)
print v(xbgr.mr_n77284368)
print v(xbgr.mr_n77284480)
print v(xbgr.mr_n77284800)
print v(xbgr.mr_n77284912)
print v(xbgr.mr_n77285232)
print v(xbgr.mr_n77285344)
print v(xbgr.mr_n77285664)
print v(xbgr.mr_n77285776)
print v(xbgr.mr_n77286096)
print v(xbgr.mr_n77286208)
print v(xbgr.mr_n77286528)
print v(xbgr.mr_n77286640)
print v(xbgr.mr_n77286960)
print v(xbgr.mr_n77287072)
print v(xbgr.mr_n77287392)
print v(xbgr.mr_n77287504)
print v(xbgr.mr_n77287824)
print v(xbgr.mr_n77288368)
print v(xbgr.mr_n77288688)
print v(xbgr.mr_n77289120)
print v(xbgr.mr_n77289232)
print v(xbgr.mr_n77289552)
print v(xbgr.mr_n77289664)
print v(xbgr.mr_n77290096)
print v(xbgr.mr_n77290416)
print v(xbgr.mr_n77291280)
print v(xbgr.mr_n77291392)
print v(xbgr.mr_n77291824)
print v(xbgr.mr_n77292144)
print v(xbgr.mr_n77293008)
print v(xbgr.mr_n77293120)
print v(xbgr.mr_n77293552)
print v(xbgr.mr_n77293872)
print v(xbgr.mr_n77293984)
print v(xbgr.mr_n77294416)
print v(xbgr.mr_n77294848)
print v(xbgr.mr_n77295168)
print v(xbgr.mr_n77296032)
print v(xbgr.mr_n77297008)
print v(xbgr.mr_n77297328)
print v(xbgr.mr_n77297440)
print v(xbgr.mr_n77297872)
print v(xbgr.mr_n77298192)
print v(xbgr.mr_n77298304)
print v(xbgr.mr_n77298736)
print v(xbgr.mr_n77299056)
print v(xbgr.mr_n77299168)
print v(xbgr.mr_n77299488)
print v(xbgr.mr_n77299600)
print v(xbgr.mr_n77299920)
print v(xbgr.mr_n77300032)
print v(xbgr.mr_n77300352)
print v(xbgr.mr_n77300464)
print v(xbgr.mr_n77300784)
print v(xbgr.mr_n77300896)
print v(xbgr.mr_n77301216)
print v(xbgr.mr_n77301328)
print v(xbgr.mr_n77301648)
print v(xbgr.mr_n77301760)
print v(xbgr.mr_n77302080)
print v(xbgr.mr_n77302192)
print v(xbgr.mr_n77302512)
print v(xbgr.mr_n77302624)
print v(xbgr.mr_n77302944)
print v(xbgr.mr_n77303056)
print v(xbgr.mr_n77303376)
print v(xbgr.mr_n77303488)
print v(xbgr.mr_n77303808)
print v(xbgr.mr_n77303920)
print v(xbgr.mr_n77304240)
print v(xbgr.mr_n77305104)
print v(xbgr.mr_n77305968)
print v(xbgr.mr_n77306400)
print v(xbgr.mr_n77306832)
print v(xbgr.mr_n77307264)
print v(xbgr.mr_n77307696)
print v(xbgr.mr_n77308128)
print v(xbgr.mr_n77308560)
print v(xbgr.mr_n77308992)
print v(xbgr.mr_n77309424)
print v(xbgr.mr_n77309856)
print v(xbgr.mr_n77310288)
print v(xbgr.mr_n77310720)
print v(xbgr.mr_n77311152)
print v(xbgr.mr_n77311264)
print v(xbgr.mr_n77311584)
print v(xbgr.mr_n77311696)
print v(xbgr.mr_n77312016)
print v(xbgr.mr_n77312128)
print v(xbgr.mr_n77312448)
print v(xbgr.mr_n77312560)
print v(xbgr.mr_n77312880)
print v(xbgr.mr_n77312992)
print v(xbgr.mr_n77313312)
print v(xbgr.mr_n77313424)
print v(xbgr.mr_n77313744)
print v(xbgr.mr_n77313856)
print v(xbgr.mr_n77314176)
print v(xbgr.mr_n77314288)
print v(xbgr.mr_n77314608)
print v(xbgr.mr_n77314720)
print v(xbgr.mr_n77315040)
print v(xbgr.mr_n77315152)
print v(xbgr.mr_n77315472)
print v(xbgr.mr_n77315584)
print v(xbgr.mr_n77315904)
print v(xbgr.mr_n77316016)
print v(xbgr.mr_n77316336)
print v(xbgr.mr_n77316768)
print v(xbgr.mr_n77316880)
print v(xbgr.mr_n77317200)
print v(xbgr.mr_n77317312)
print v(xbgr.mr_n77317632)
print v(xbgr.mr_n77317744)
print v(xbgr.mr_n77318064)
print v(xbgr.mr_n77318176)
print v(xbgr.mr_n77318496)
print v(xbgr.mr_n77318608)
print v(xbgr.mr_n77318928)
print v(xbgr.mr_n77319040)
print v(xbgr.mr_n77319360)
print v(xbgr.mr_n77319472)
print v(xbgr.mr_n77319792)
print v(xbgr.mr_n77319904)
print v(xbgr.mr_n77320224)
print v(xbgr.mr_n77320336)
print v(xbgr.mr_n77320656)
print v(xbgr.mr_n77320768)
print v(xbgr.mr_n77321088)
print v(xbgr.mr_n77321520)
print v(xbgr.mr_n77321632)
print v(xbgr.mr_n77321952)
print v(xbgr.mr_n77322064)
print v(xbgr.mr_n77322384)
print v(xbgr.mr_n77322496)
print v(xbgr.mr_n77322816)
print v(xbgr.mr_n77322928)
print v(xbgr.mr_n77323248)
print v(xbgr.mr_n77323360)
print v(xbgr.mr_n77323680)
print v(xbgr.mr_n77323792)
print v(xbgr.mr_n77324112)
print v(xbgr.mr_n77324224)
print v(xbgr.mr_n77324544)
print v(xbgr.mr_n77324656)
print v(xbgr.mr_n77324976)
print v(xbgr.mr_n77325088)
print v(xbgr.mr_n77325408)
print v(xbgr.mr_n77325520)
print v(xbgr.mr_n77325840)
print v(xbgr.mr_n77325952)
print v(xbgr.mr_n77326272)
print v(xbgr.mr_n77326384)
print v(xbgr.mr_n77326704)
print v(xbgr.mr_n77326816)
print v(xbgr.mr_n77327136)
print v(xbgr.mr_n77327248)
print v(xbgr.mr_n77327568)
print v(xbgr.mr_n77327680)
print v(xbgr.mr_n77328000)
print v(xbgr.mr_n77328112)
print v(xbgr.mr_n77328432)
print v(xbgr.mr_n77328544)
print v(xbgr.mr_n77328864)
print v(xbgr.mr_n77328976)
print v(xbgr.mr_n77329296)
print v(xbgr.mr_n77329408)
print v(xbgr.mr_n77329728)
print v(xbgr.mr_n77329840)
print v(xbgr.mr_n77330160)
print v(xbgr.mr_n77330272)
print v(xbgr.mr_n77330592)
print v(xbgr.mr_n77330704)
print v(xbgr.mr_n77331024)
print v(xbgr.mr_n77331136)
print v(xbgr.mr_n77331456)
print v(xbgr.mr_n77331568)
print v(xbgr.mr_n77331888)
print v(xbgr.mr_n77332000)
print v(xbgr.mr_n77332320)
print v(xbgr.mr_n77332432)
print v(xbgr.mr_n77332752)
print v(xbgr.mr_n77332864)
print v(xbgr.mr_n77333184)
print v(xbgr.mr_n77333296)
print v(xbgr.mr_n77333616)
print v(xbgr.mr_n77333728)
print v(xbgr.mr_n77334048)
print v(xbgr.mr_n77334160)
print v(xbgr.mr_n77334480)
print v(xbgr.mr_n77334592)
print v(xbgr.mr_n77334912)
print v(xbgr.mr_n77335024)
print v(xbgr.mr_n77335344)
print v(xbgr.mr_n77335456)
print v(xbgr.mr_n77335776)
print v(xbgr.mr_n77335888)
print v(xbgr.mr_n77336208)
print v(xbgr.mr_n77336320)
print v(xbgr.mr_n77336640)
print v(xbgr.mr_n77336752)
print v(xbgr.mr_n77337072)
print v(xbgr.mr_n77337184)
print v(xbgr.mr_n77337504)
print v(xbgr.mr_n77337616)
print v(xbgr.mr_n77337936)
print v(xbgr.mr_n77338048)
print v(xbgr.mr_n77338368)
print v(xbgr.mr_n77338480)
print v(xbgr.mr_n77338800)
print v(xbgr.mr_n77338912)
print v(xbgr.mr_n77339232)
print v(xbgr.mr_n77339344)
print v(xbgr.mr_n77339664)
print v(xbgr.mr_n77339776)
print v(xbgr.mr_n77340096)
print v(xbgr.mr_n77340208)
print v(xbgr.mr_n77340528)
print v(xbgr.mr_n77340640)
print v(xbgr.mr_n77340960)
print v(xbgr.mr_n77341072)
print v(xbgr.mr_n77341392)
print v(xbgr.mr_n77341504)
print v(xbgr.mr_n77341824)
print v(xbgr.mr_n77341936)
print v(xbgr.mr_n77342256)
print v(xbgr.mr_n77342368)
print v(xbgr.mr_n77342688)
print v(xbgr.mr_n77342800)
print v(xbgr.mr_n77343120)
print v(xbgr.mr_n77343232)
print v(xbgr.mr_n77343552)
print v(xbgr.mr_n77343664)
print v(xbgr.mr_n77343984)
print v(xbgr.mr_n77344096)
print v(xbgr.mr_n77344416)
print v(xbgr.mr_n77344528)
print v(xbgr.mr_n77344848)
print v(xbgr.mr_n77344960)
print v(xbgr.mr_n77345280)
print v(xbgr.mr_n77345392)
print v(xbgr.mr_n77345712)
print v(xbgr.mr_n77345824)
print v(xbgr.mr_n77346144)
print v(xbgr.mr_n77346256)
print v(xbgr.mr_n77346576)
print v(xbgr.mr_n77346688)
print v(xbgr.mr_n77347008)
print v(xbgr.mr_n77347120)
print v(xbgr.mr_n77347440)
print v(xbgr.mr_n77347552)
print v(xbgr.mr_n77347872)
print v(xbgr.mr_n77347984)
print v(xbgr.mr_n77348304)
print v(xbgr.mr_n77348736)
print v(xbgr.mr_n77348848)
print v(xbgr.mr_n77349168)
print v(xbgr.mr_n77349280)
print v(xbgr.mr_n77349600)
print v(xbgr.mr_n77349712)
print v(xbgr.mr_n77350032)
print v(xbgr.mr_n77350144)
print v(xbgr.mr_n77350464)
print v(xbgr.mr_n77350576)
print v(xbgr.mr_n77350896)
print v(xbgr.mr_n77351008)
print v(xbgr.mr_n77351328)
print v(xbgr.mr_n77351440)
print v(xbgr.mr_n77351760)
print v(xbgr.mr_n77351872)
print v(xbgr.mr_n77352192)
print v(xbgr.mr_n77352304)
print v(xbgr.mr_n77352624)
print v(xbgr.mr_n77352736)
print v(xbgr.mr_n77353056)
print v(xbgr.mr_n77353168)
print v(xbgr.mr_n77353488)
print v(xbgr.mr_n77353600)
print v(xbgr.mr_n77353920)
print v(xbgr.mr_n77354032)
print v(xbgr.mr_n77354352)
print v(xbgr.mr_n77354464)
print v(xbgr.mr_n77354784)
print v(xbgr.mr_n77354896)
print v(xbgr.mr_n77355216)
print v(xbgr.mr_n77355328)
print v(xbgr.mr_n77355648)
print v(xbgr.mr_n77355760)
print v(xbgr.mr_n77356080)
print v(xbgr.mr_n77356192)
print v(xbgr.mr_n77356512)
print v(xbgr.mr_n77357056)
print v(xbgr.mr_n77357376)
print v(xbgr.mr_n77357488)
print v(xbgr.mr_n77357808)
print v(xbgr.mr_n77357920)
print v(xbgr.mr_n77358352)
print v(xbgr.mr_n77358784)
print v(xbgr.mr_n77359216)
print v(xbgr.mr_n77359648)
print v(xbgr.mr_n77360080)
print v(xbgr.mr_n77360512)
print v(xbgr.mr_n77360944)
print v(xbgr.mr_n77361376)
print v(xbgr.mr_n77361808)
print v(xbgr.mr_n77362240)
print v(xbgr.mr_n77362672)
print v(xbgr.mr_n77363104)
print v(xbgr.mr_n77363536)
print v(xbgr.mr_n77363968)
print v(xbgr.mr_n77364400)
print v(xbgr.mr_n77364832)
print v(xbgr.mr_n77365264)
print v(xbgr.mr_n77365696)
print v(xbgr.mr_n77366128)
print v(xbgr.mr_n77366560)
print v(xbgr.mr_n77366992)
print v(xbgr.mr_n77367424)
print v(xbgr.mr_n77367856)
print v(xbgr.mr_n77368288)
print v(xbgr.mr_n77368720)
print v(xbgr.mr_n77369152)
print v(xbgr.mr_n77369584)
print v(xbgr.mr_n77370016)
print v(xbgr.mr_n77370448)
print v(xbgr.mr_n77370880)
print v(xbgr.mr_n77371312)
print v(xbgr.mr_n77371744)
print v(xbgr.mr_n77372176)
print v(xbgr.mr_n77372608)
print v(xbgr.mr_n77373040)
print v(xbgr.mr_n77373472)
print v(xbgr.mr_n77373904)
print v(xbgr.mr_n77374336)
print v(xbgr.mr_n77374768)
print v(xbgr.mr_n77375200)
print v(xbgr.mr_n77375632)
print v(xbgr.mr_n77376064)
print v(xbgr.mr_n77376496)
print v(xbgr.mr_n77376928)
print v(xbgr.mr_n77377360)
print v(xbgr.mr_n77377792)
print v(xbgr.mr_n77378224)
print v(xbgr.mr_n77378656)
print v(xbgr.mr_n77379088)
print v(xbgr.mr_n77379520)
print v(xbgr.mr_n77379952)
print v(xbgr.mr_n77380384)
print v(xbgr.mr_n77380816)
print v(xbgr.mr_n77381248)
print v(xbgr.mr_n77381680)
print v(xbgr.mr_n77382112)
print v(xbgr.mr_n77382544)
print v(xbgr.mr_n77382976)
print v(xbgr.mr_n77383408)
print v(xbgr.mr_n77383840)
print v(xbgr.mr_n77384272)
print v(xbgr.mr_n77384704)
print v(xbgr.mr_n77385136)
print v(xbgr.mr_n77385568)
print v(xbgr.mr_n77386000)
print v(xbgr.mr_n77386432)
print v(xbgr.mr_n77386864)
print v(xbgr.mr_n77387296)
print v(xbgr.mr_n77387728)
print v(xbgr.mr_n77388160)
print v(xbgr.mr_n77388592)
print v(xbgr.mr_n77389024)
print v(xbgr.mr_n77389456)
print v(xbgr.mr_n77389888)
print v(xbgr.mr_n77390320)
print v(xbgr.mr_n77390752)
print v(xbgr.mr_n77391184)
print v(xbgr.mr_n77391616)
print v(xbgr.mr_n77392048)
print v(xbgr.mr_n77392480)
print v(xbgr.mr_n77392912)
print v(xbgr.mr_n77393344)
print v(xbgr.mr_n77393776)
print v(xbgr.mr_n77394208)
print v(xbgr.mr_n77394640)
print v(xbgr.mr_n77395072)
print v(xbgr.mr_n77395504)
print v(xbgr.mr_n77395936)
print v(xbgr.mr_n77396368)
print v(xbgr.mr_n77396800)
print v(xbgr.mr_n77397232)
print v(xbgr.mr_n77397664)
print v(xbgr.mr_n77398096)
print v(xbgr.mr_n77398528)
print v(xbgr.mr_n77398960)
print v(xbgr.mr_n77399392)
print v(xbgr.mr_n77399824)
print v(xbgr.mr_n77400256)
print v(xbgr.mr_n77400688)
print v(xbgr.mr_n77401120)
print v(xbgr.mr_n77401552)
print v(xbgr.mr_n77401984)
print v(xbgr.mr_n77402416)
print v(xbgr.mr_n77402848)
print v(xbgr.mr_n77403280)
print v(xbgr.mr_n77403600)
print v(xbgr.mr_n77403712)
print v(xbgr.mr_n77404032)
print v(xbgr.mr_n77404144)
print v(xbgr.mr_n77404464)
print v(xbgr.mr_n77404576)
print v(xbgr.mr_n77404896)
print v(xbgr.mr_n77405008)
print v(xbgr.mr_n77405328)
print v(xbgr.mr_n77405440)
print v(xbgr.mr_n77405760)
print v(xbgr.mr_n77405872)
print v(xbgr.mr_n77406192)
print v(xbgr.mr_n77406304)
print v(xbgr.mr_n77406624)
print v(xbgr.mr_n77406736)
print v(xbgr.mr_n77407056)
print v(xbgr.mr_n77407168)
print v(xbgr.mr_n77407488)
print v(xbgr.mr_n77407600)
print v(xbgr.mr_n77407920)
print v(xbgr.mr_n77408032)
print v(xbgr.mr_n77408352)
print v(xbgr.mr_n77408464)
print v(xbgr.mr_n77408784)
print v(xbgr.mr_n77408896)
print v(xbgr.mr_n77409216)
print v(xbgr.mr_n77409328)
print v(xbgr.mr_n77409648)
print v(xbgr.mr_n77409760)
print v(xbgr.mr_n77410080)
print v(xbgr.mr_n77410192)
print v(xbgr.mr_n77410512)
print v(xbgr.mr_n77410624)
print v(xbgr.mr_n77410944)
print v(xbgr.mr_n77411056)
print v(xbgr.mr_n77411376)
print v(xbgr.mr_n77411488)
print v(xbgr.mr_n77411808)
print v(xbgr.mr_n77411920)
print v(xbgr.mr_n77412240)
print v(xbgr.mr_n77412352)
print v(xbgr.mr_n77412672)
print v(xbgr.mr_n77412784)
print v(xbgr.mr_n77413104)
print v(xbgr.mr_n77413216)
print v(xbgr.mr_n77413536)
print v(xbgr.mr_n77413648)
print v(xbgr.mr_n77413968)
print v(xbgr.mr_n77414080)
print v(xbgr.mr_n77414400)
print v(xbgr.mr_n77414512)
print v(xbgr.mr_n77414832)
print v(xbgr.mr_n77414944)
print v(xbgr.mr_n77415264)
print v(xbgr.mr_n77415376)
print v(xbgr.mr_n77415696)
print v(xbgr.mr_n77415808)
print v(xbgr.mr_n77416128)
print v(xbgr.mr_n77416240)
print v(xbgr.mr_n77416560)
print v(xbgr.mr_n77416672)
print v(xbgr.mr_n77416992)
print v(xbgr.mr_n77417104)
print v(xbgr.mr_n77417424)
print v(xbgr.mr_n77417536)
print v(xbgr.mr_n77417856)
print v(xbgr.mr_n77417968)
print v(xbgr.mr_n77418288)
print v(xbgr.mr_n77418400)
print v(xbgr.mr_n77418720)
print v(xbgr.mr_n77418832)
print v(xbgr.mr_n77419152)
print v(xbgr.mr_n77419264)
print v(xbgr.mr_n77419584)
print v(xbgr.mr_n77419696)
print v(xbgr.mr_n77420016)
print v(xbgr.mr_n77420128)
print v(xbgr.mr_n77420448)
print v(xbgr.mr_n77420560)
print v(xbgr.mr_n77420880)
print v(xbgr.mr_n77420992)
print v(xbgr.mr_n77421312)
print v(xbgr.mr_n77421424)
print v(xbgr.mr_n77421744)
print v(xbgr.mr_n77422176)
print v(xbgr.mr_n77422288)
print v(xbgr.mr_n77422608)
print v(xbgr.mr_n77422720)
print v(xbgr.mr_n77423040)
print v(xbgr.mr_n77423152)
print v(xbgr.mr_n77423472)
print v(xbgr.mr_n77423584)
print v(xbgr.mr_n77423904)
print v(xbgr.mr_n77424016)
print v(xbgr.mr_n77424336)
print v(xbgr.mr_n77424448)
print v(xbgr.mr_n77424768)
print v(xbgr.mr_n77424880)
print v(xbgr.mr_n77425200)
print v(xbgr.mr_n77425312)
print v(xbgr.mr_n77425632)
print v(xbgr.mr_n77425744)
print v(xbgr.mr_n77426064)
print v(xbgr.mr_n77426176)
print v(xbgr.mr_n77426496)
print v(xbgr.mr_n77426608)
print v(xbgr.mr_n77426928)
print v(xbgr.mr_n77427040)
print v(xbgr.mr_n77427360)
print v(xbgr.mr_n77427472)
print v(xbgr.mr_n77427792)
print v(xbgr.mr_n77427904)
print v(xbgr.mr_n77428224)
print v(xbgr.mr_n77428336)
print v(xbgr.mr_n77428656)
print v(xbgr.mr_n77428768)
print v(xbgr.mr_n77429088)
print v(xbgr.mr_n77429200)
print v(xbgr.mr_n77429520)
print v(xbgr.mr_n77429632)
print v(xbgr.mr_n77429952)
print v(xbgr.mr_n77430064)
print v(xbgr.mr_n77430384)
print v(xbgr.mr_n77430496)
print v(xbgr.mr_n77430816)
print v(xbgr.mr_n77430928)
print v(xbgr.mr_n77431248)
print v(xbgr.mr_n77431360)
print v(xbgr.mr_n77431680)
print v(xbgr.mr_n77431792)
print v(xbgr.mr_n77432112)
print v(xbgr.mr_n77432224)
print v(xbgr.mr_n77432544)
print v(xbgr.mr_n77432656)
print v(xbgr.mr_n77432976)
print v(xbgr.mr_n77433088)
print v(xbgr.mr_n77433408)
print v(xbgr.mr_n77433520)
print v(xbgr.mr_n77433840)
print v(xbgr.mr_n77433952)
print v(xbgr.mr_n77434272)
print v(xbgr.mr_n77434384)
print v(xbgr.mr_n77434704)
print v(xbgr.mr_n77434816)
print v(xbgr.mr_n77435136)
print v(xbgr.mr_n77435248)
print v(xbgr.mr_n77435568)
print v(xbgr.mr_n77435680)
print v(xbgr.mr_n77436000)
print v(xbgr.mr_n77436112)
print v(xbgr.mr_n77436432)
print v(xbgr.mr_n77436544)
print v(xbgr.mr_n77436864)
print v(xbgr.mr_n77436976)
print v(xbgr.mr_n77437296)
print v(xbgr.mr_n77437408)
print v(xbgr.mr_n77437728)
print v(xbgr.mr_n77437840)
print v(xbgr.mr_n77438160)
print v(xbgr.mr_n77438272)
print v(xbgr.mr_n77438592)
print v(xbgr.mr_n77438704)
print v(xbgr.mr_n77439024)
print v(xbgr.mr_n77439136)
print v(xbgr.mr_n77439456)
print v(xbgr.mr_n77439568)
print v(xbgr.mr_n77439888)
print v(xbgr.mr_n77440000)
print v(xbgr.mr_n77440320)
print v(xbgr.mr_n77440432)
print v(xbgr.mr_n77440752)
print v(xbgr.mr_n77440864)
print v(xbgr.mr_n77441184)
print v(xbgr.mr_n77441296)
print v(xbgr.mr_n77441616)
print v(xbgr.mr_n77441728)
print v(xbgr.mr_n77442048)
print v(xbgr.mr_n77442160)
print v(xbgr.mr_n77442480)
print v(xbgr.mr_n77442592)
print v(xbgr.mr_n77442912)
print v(xbgr.mr_n77443024)
print v(xbgr.mr_n77443344)
print v(xbgr.mr_n77443456)
print v(xbgr.mr_n77443776)
print v(xbgr.mr_n77443888)
print v(xbgr.mr_n77444208)
print v(xbgr.mr_n77444320)
print v(xbgr.mr_n77444640)
print v(xbgr.mr_n77444752)
print v(xbgr.mr_n77445072)
print v(xbgr.mr_n77445184)
print v(xbgr.mr_n77445504)
print v(xbgr.mr_n77445616)
print v(xbgr.mr_n77445936)
print v(xbgr.mr_n77446048)
print v(xbgr.mr_n77446368)
print v(xbgr.mr_n77446480)
print v(xbgr.mr_n77446800)
print v(xbgr.mr_n77446912)
print v(xbgr.mr_n77447232)
print v(xbgr.mr_n77447344)
print v(xbgr.mr_n77447664)
print v(xbgr.mr_n77447776)
print v(xbgr.mr_n77448096)
print v(xbgr.mr_n77448208)
print v(xbgr.mr_n77448528)
print v(xbgr.mr_n77448640)
print v(xbgr.mr_n77448960)
print v(xbgr.mr_n77449072)
print v(xbgr.mr_n77449392)
print v(xbgr.mr_n77449504)
print v(xbgr.mr_n77449824)
print v(xbgr.mr_n77449936)
print v(xbgr.mr_n77450256)
print v(xbgr.mr_n77450368)
print v(xbgr.mr_n77450688)
print v(xbgr.mr_n77450800)
print v(xbgr.mr_n77451120)
print v(xbgr.mr_n77451232)
print v(xbgr.mr_n77451552)
print v(xbgr.mr_n77451664)
print v(xbgr.mr_n77451984)
print v(xbgr.mr_n77452096)
print v(xbgr.mr_n77452416)
print v(xbgr.mr_n77452528)
print v(xbgr.mr_n77452848)
print v(xbgr.mr_n77452960)
print v(xbgr.mr_n77453280)
print v(xbgr.mr_n77453392)
print v(xbgr.mr_n77453712)
print v(xbgr.mr_n77453824)
print v(xbgr.mr_n77454144)
print v(xbgr.mr_n77454256)
print v(xbgr.mr_n77454576)
print v(xbgr.mr_n77454688)
print v(xbgr.mr_n77455008)
print v(xbgr.mr_n77455120)
print v(xbgr.mr_n77455440)
print v(xbgr.mr_n77455552)
print v(xbgr.mr_n77455872)
print v(xbgr.mr_n77455984)
print v(xbgr.mr_n77456304)
print v(xbgr.mr_n77456416)
print v(xbgr.mr_n77456736)
print v(xbgr.mr_n77456848)
print v(xbgr.mr_n77457168)
print v(xbgr.mr_n77457280)
print v(xbgr.mr_n77457600)
print v(xbgr.mr_n77457712)
print v(xbgr.mr_n77458032)
print v(xbgr.mr_n77458144)
print v(xbgr.mr_n77458464)
print v(xbgr.mr_n77458576)
print v(xbgr.mr_n77458896)
print v(xbgr.mr_n77459008)
print v(xbgr.mr_n77459328)
print v(xbgr.mr_n77459440)
print v(xbgr.mr_n77459760)
print v(xbgr.mr_n77459872)
print v(xbgr.mr_n77460192)
print v(xbgr.mr_n77460304)
print v(xbgr.mr_n77460624)
print v(xbgr.mr_n77460736)
print v(xbgr.mr_n77461056)
print v(xbgr.mr_n77461168)
print v(xbgr.mr_n77461488)
print v(xbgr.mr_n77461600)
print v(xbgr.mr_n77461920)
print v(xbgr.mr_n77462032)
print v(xbgr.mr_n77462352)
print v(xbgr.mr_n77462464)
print v(xbgr.mr_n77462784)
print v(xbgr.mr_n77462896)
print v(xbgr.mr_n77463216)
print v(xbgr.mr_n77463328)
print v(xbgr.mr_n77463648)
print v(xbgr.mr_n77463760)
print v(xbgr.mr_n77464080)
print v(xbgr.mr_n77464192)
print v(xbgr.mr_n77464512)
print v(xbgr.mr_n77464624)
print v(xbgr.mr_n77464944)
print v(xbgr.mr_n77465056)
print v(xbgr.mr_n77465376)
print v(xbgr.mr_n77465488)
print v(xbgr.mr_n77465808)
print v(xbgr.mr_n77465920)
print v(xbgr.mr_n77466240)
print v(xbgr.mr_n77466352)
print v(xbgr.mr_n77466672)
print v(xbgr.mr_n77466784)
print v(xbgr.mr_n77467104)
print v(xbgr.mr_n77467216)
print v(xbgr.mr_n77467536)
print v(xbgr.mr_n77467648)
print v(xbgr.mr_n77467968)
print v(xbgr.mr_n77468080)
print v(xbgr.mr_n77468400)
print v(xbgr.mr_n77468512)
print v(xbgr.mr_n77468832)
print v(xbgr.mr_n77468944)
print v(xbgr.mr_n77469264)
print v(xbgr.mr_n77469376)
print v(xbgr.mr_n77469696)
print v(xbgr.mr_n77469808)
print v(xbgr.mr_n77470128)
print v(xbgr.mr_n77470240)
print v(xbgr.mr_n77470560)
print v(xbgr.mr_n77470672)
print v(xbgr.mr_n77470992)
print v(xbgr.mr_n77471104)
print v(xbgr.mr_n77471424)
print v(xbgr.mr_n77471536)
print v(xbgr.mr_n77471856)
print v(xbgr.mr_n77472288)
print v(xbgr.mr_n77472400)
print v(xbgr.mr_n77472720)
print v(xbgr.mr_n77472832)
print v(xbgr.mr_n77473152)
print v(xbgr.mr_n77473264)
print v(xbgr.mr_n77473584)
print v(xbgr.mr_n77473696)
print v(xbgr.mr_n77474016)
print v(xbgr.mr_n77474128)
print v(xbgr.mr_n77474448)
print v(xbgr.mr_n77474560)
print v(xbgr.mr_n77474880)
print v(xbgr.mr_n77474992)
print v(xbgr.mr_n77475312)
print v(xbgr.mr_n77475424)
print v(xbgr.mr_n77475744)
print v(xbgr.mr_n77475856)
print v(xbgr.mr_n77476176)
print v(xbgr.mr_n77476288)
print v(xbgr.mr_n77476608)
print v(xbgr.mr_n77476720)
print v(xbgr.mr_n77477040)
print v(xbgr.mr_n77477152)
print v(xbgr.mr_n77477472)
print v(xbgr.mr_n77477584)
print v(xbgr.mr_n77477904)
print v(xbgr.mr_n77478016)
print v(xbgr.mr_n77478336)
print v(xbgr.mr_n77478448)
print v(xbgr.mr_n77478768)
print v(xbgr.mr_n77478880)
print v(xbgr.mr_n77479200)
print v(xbgr.mr_n77479312)
print v(xbgr.mr_n77479632)
print v(xbgr.mr_n77479744)
print v(xbgr.mr_n77480064)
print v(xbgr.mr_n77480176)
print v(xbgr.mr_n77480496)
print v(xbgr.mr_n77480608)
print v(xbgr.mr_n77480928)
print v(xbgr.mr_n77481040)
print v(xbgr.mr_n77481360)
print v(xbgr.mr_n77481472)
print v(xbgr.mr_n77481792)
print v(xbgr.mr_n77481904)
print v(xbgr.mr_n77482224)
print v(xbgr.mr_n77482336)
print v(xbgr.mr_n77482656)
print v(xbgr.mr_n77482768)
print v(xbgr.mr_n77483088)
print v(xbgr.mr_n77483200)
print v(xbgr.mr_n77483520)
print v(xbgr.mr_n77483632)
print v(xbgr.mr_n77483952)
print v(xbgr.mr_n77484064)
print v(xbgr.mr_n77484384)
print v(xbgr.mr_n77484496)
print v(xbgr.mr_n77484816)
print v(xbgr.mr_n77484928)
print v(xbgr.mr_n77485248)
print v(xbgr.mr_n77485360)
print v(xbgr.mr_n77485680)
print v(xbgr.mr_n77485792)
print v(xbgr.mr_n77486112)
print v(xbgr.mr_n77486224)
print v(xbgr.mr_n77486544)
print v(xbgr.mr_n77486656)
print v(xbgr.mr_n77486976)
print v(xbgr.mr_n77487088)
print v(xbgr.mr_n77487408)
print v(xbgr.mr_n77487520)
print v(xbgr.mr_n77487840)
print v(xbgr.mr_n77487952)
print v(xbgr.mr_n77488272)
print v(xbgr.mr_n77488384)
print v(xbgr.mr_n77488704)
print v(xbgr.mr_n77488816)
print v(xbgr.mr_n77489136)
print v(xbgr.mr_n77489248)
print v(xbgr.mr_n77489568)
print v(xbgr.mr_n77489680)
print v(xbgr.mr_n77490000)
print v(xbgr.mr_n77490112)
print v(xbgr.mr_n77490432)
print v(xbgr.mr_n77490544)
print v(xbgr.mr_n77490864)
print v(xbgr.mr_n77490976)
print v(xbgr.mr_n77491296)
print v(xbgr.mr_n77491408)
print v(xbgr.mr_n77491728)
print v(xbgr.mr_n77491840)
print v(xbgr.mr_n77492160)
print v(xbgr.mr_n77492272)
print v(xbgr.mr_n77492592)
print v(xbgr.mr_n77493024)
print v(xbgr.mr_n77493136)
print v(xbgr.mr_n77493456)
print v(xbgr.mr_n77493568)
print v(xbgr.mr_n77493888)
print v(xbgr.mr_n77494000)
print v(xbgr.mr_n77494320)
print v(xbgr.mr_n77494432)
print v(xbgr.mr_n77494752)
print v(xbgr.mr_n77494864)
print v(xbgr.mr_n77495184)
print v(xbgr.mr_n77495296)
print v(xbgr.mr_n77495728)
print v(xbgr.mr_n77496160)
print v(xbgr.mr_n77496480)
print v(xbgr.mr_n77496592)
print v(xbgr.mr_n77496912)
print v(xbgr.mr_n77497024)
print v(xbgr.mr_n77497344)
print v(xbgr.mr_n77497456)
print v(xbgr.mr_n77497776)
print v(xbgr.mr_n77497888)
print v(xbgr.mr_n77498208)
print v(xbgr.mr_n77498320)
print v(xbgr.mr_n77498640)
print v(xbgr.mr_n77498752)
print v(xbgr.mr_n77499072)
print v(xbgr.mr_n77499184)
print v(xbgr.mr_n77499504)
print v(xbgr.mr_n77499616)
print v(xbgr.mr_n77499936)
print v(xbgr.mr_n77500048)
print v(xbgr.mr_n77500368)
print v(xbgr.mr_n77500480)
print v(xbgr.mr_n77500800)
print v(xbgr.mr_n77500912)
print v(xbgr.mr_n77501232)
print v(xbgr.mr_n77501344)
print v(xbgr.mr_n77501664)
print v(xbgr.mr_n77501776)
print v(xbgr.mr_n77502096)
print v(xbgr.mr_n77502208)
print v(xbgr.mr_n77502528)
print v(xbgr.mr_n77502640)
print v(xbgr.mr_n77502960)
print v(xbgr.mr_n77503072)
print v(xbgr.mr_n77503392)
print v(xbgr.mr_n77503504)
print v(xbgr.mr_n77503824)
print v(xbgr.mr_n77503936)
print v(xbgr.mr_n77504256)
print v(xbgr.mr_n77504368)
print v(xbgr.mr_n77504688)
print v(xbgr.mr_n77504800)
print v(xbgr.mr_n77505120)
print v(xbgr.mr_n77505232)
print v(xbgr.mr_n77505552)
print v(xbgr.mr_n77505664)
print v(xbgr.mr_n77505984)
print v(xbgr.mr_n77506096)
print v(xbgr.mr_n77506416)
print v(xbgr.mr_n77506528)
print v(xbgr.mr_n77506848)
print v(xbgr.mr_n77506960)
print v(xbgr.mr_n77507280)
print v(xbgr.mr_n77507392)
print v(xbgr.mr_n77507712)
print v(xbgr.mr_n77507824)
print v(xbgr.mr_n77508144)
print v(xbgr.mr_n77508256)
print v(xbgr.mr_n77508576)
print v(xbgr.mr_n77508688)
print v(xbgr.mr_n77509008)
print v(xbgr.mr_n77509120)
print v(xbgr.mr_n77509440)
print v(xbgr.mr_n77509552)
print v(xbgr.mr_n77509872)
print v(xbgr.mr_n77509984)
print v(xbgr.mr_n77510304)
print v(xbgr.mr_n77510416)
print v(xbgr.mr_n77510736)
print v(xbgr.mr_n77510848)
print v(xbgr.mr_n77511168)
print v(xbgr.mr_n77511280)
print v(xbgr.mr_n77511600)
print v(xbgr.mr_n77511712)
print v(xbgr.mr_n77512032)
print v(xbgr.mr_n77512144)
print v(xbgr.mr_n77512464)
print v(xbgr.mr_n77512576)
print v(xbgr.mr_n77512896)
print v(xbgr.mr_n77513008)
print v(xbgr.mr_n77513328)
print v(xbgr.mr_n77513440)
print v(xbgr.mr_n77513760)
print v(xbgr.mr_n77513872)
print v(xbgr.mr_n77514192)
print v(xbgr.mr_n77514304)
print v(xbgr.mr_n77514624)
print v(xbgr.mr_n77514736)
print v(xbgr.mr_n77515056)
print v(xbgr.mr_n77515168)
print v(xbgr.mr_n77515488)
print v(xbgr.mr_n77515600)
print v(xbgr.mr_n77515920)
print v(xbgr.mr_n77516032)
print v(xbgr.mr_n77516352)
print v(xbgr.mr_n77516464)
print v(xbgr.mr_n77516784)
print v(xbgr.mr_n77516896)
print v(xbgr.mr_n77517216)
print v(xbgr.mr_n77517328)
print v(xbgr.mr_n77517648)
print v(xbgr.mr_n77517760)
print v(xbgr.mr_n77518080)
print v(xbgr.mr_n77518192)
print v(xbgr.mr_n77518512)
print v(xbgr.mr_n77518624)
print v(xbgr.mr_n77518944)
print v(xbgr.mr_n77519056)
print v(xbgr.mr_n77519376)
print v(xbgr.mr_n77519488)
print v(xbgr.mr_n77519808)
print v(xbgr.mr_n77519920)
print v(xbgr.mr_n77520240)
print v(xbgr.mr_n77520352)
print v(xbgr.mr_n77520672)
print v(xbgr.mr_n77520784)
print v(xbgr.mr_n77521104)
print v(xbgr.mr_n77521216)
print v(xbgr.mr_n77521536)
print v(xbgr.mr_n77521648)
print v(xbgr.mr_n77521968)
print v(xbgr.mr_n77522080)
print v(xbgr.mr_n77522400)
print v(xbgr.mr_n77522512)
print v(xbgr.mr_n77522832)
print v(xbgr.mr_n77522944)
print v(xbgr.mr_n77523264)
print v(xbgr.mr_n77523376)
print v(xbgr.mr_n77523696)
print v(xbgr.mr_n77523808)
print v(xbgr.mr_n77524128)
print v(xbgr.mr_n77524240)
print v(xbgr.mr_n77524560)
print v(xbgr.mr_n77524672)
print v(xbgr.mr_n77524992)
print v(xbgr.mr_n77525104)
print v(xbgr.mr_n77525424)
print v(xbgr.mr_n77525536)
print v(xbgr.mr_n77525856)
print v(xbgr.mr_n77525968)
print v(xbgr.mr_n77526288)
print v(xbgr.mr_n77526400)
print v(xbgr.mr_n77526720)
print v(xbgr.mr_n77526832)
print v(xbgr.mr_n77527152)
print v(xbgr.mr_n77527264)
print v(xbgr.mr_n77527584)
print v(xbgr.mr_n77527696)
print v(xbgr.mr_n77528016)
print v(xbgr.mr_n77528128)
print v(xbgr.mr_n77528448)
print v(xbgr.mr_n77528560)
print v(xbgr.mr_n77528880)
print v(xbgr.mr_n77528992)
print v(xbgr.mr_n77529312)
print v(xbgr.mr_n77529424)
print v(xbgr.mr_n77529744)
print v(xbgr.mr_n77529856)
print v(xbgr.mr_n77530176)
print v(xbgr.mr_n77530288)
print v(xbgr.mr_n77530608)
print v(xbgr.mr_n77530720)
print v(xbgr.mr_n77531040)
print v(xbgr.mr_n77531152)
print v(xbgr.mr_n77531472)
print v(xbgr.mr_n77531584)
print v(xbgr.mr_n77531904)
print v(xbgr.mr_n77532016)
print v(xbgr.mr_n77532336)
print v(xbgr.mr_n77532448)
print v(xbgr.mr_n77532768)
print v(xbgr.mr_n77532880)
print v(xbgr.mr_n77533200)
print v(xbgr.mr_n77533312)
print v(xbgr.mr_n77533632)
print v(xbgr.mr_n77533744)
print v(xbgr.mr_n77534064)
print v(xbgr.mr_n77534176)
print v(xbgr.mr_n77534496)
print v(xbgr.mr_n77534608)
print v(xbgr.mr_n77534928)
print v(xbgr.mr_n77535040)
print v(xbgr.mr_n77535360)
print v(xbgr.mr_n77535472)
print v(xbgr.mr_n77535792)
print v(xbgr.mr_n77535904)
print v(xbgr.mr_n77536224)
print v(xbgr.mr_n77536336)
print v(xbgr.mr_n77536656)
print v(xbgr.mr_n77536768)
print v(xbgr.mr_n77537088)
print v(xbgr.mr_n77537200)
print v(xbgr.mr_n77537520)
print v(xbgr.mr_n77537632)
print v(xbgr.mr_n77537952)
print v(xbgr.mr_n77538064)
print v(xbgr.mr_n77538384)
print v(xbgr.mr_n77538496)
print v(xbgr.mr_n77538816)
print v(xbgr.mr_n77538928)
print v(xbgr.mr_n77539248)
print v(xbgr.mr_n77539360)
print v(xbgr.mr_n77539680)
print v(xbgr.mr_n77539792)
print v(xbgr.mr_n77540112)
print v(xbgr.mr_n77540224)
print v(xbgr.mr_n77540544)
print v(xbgr.mr_n77540656)
print v(xbgr.mr_n77540976)
print v(xbgr.mr_n77541088)
print v(xbgr.mr_n77541408)
print v(xbgr.mr_n77541520)
print v(xbgr.mr_n77541840)
print v(xbgr.mr_n77541952)
print v(xbgr.mr_n77542272)
print v(xbgr.mr_n77542384)
print v(xbgr.mr_n77542704)
print v(xbgr.mr_n77542816)
print v(xbgr.mr_n77543136)
print v(xbgr.mr_n77543248)
print v(xbgr.mr_n77543568)
print v(xbgr.mr_n77543680)
print v(xbgr.mr_n77544000)
print v(xbgr.mr_n77544112)
print v(xbgr.mr_n77544432)
print v(xbgr.mr_n77544544)
print v(xbgr.mr_n77544864)
print v(xbgr.mr_n77544976)
print v(xbgr.mr_n77545296)
print v(xbgr.mr_n77545408)
print v(xbgr.mr_n77545728)
print v(xbgr.mr_n77545840)
print v(xbgr.mr_n77546160)
print v(xbgr.mr_n77546272)
print v(xbgr.mr_n77546592)
print v(xbgr.mr_n77546704)
print v(xbgr.mr_n77547024)
print v(xbgr.mr_n77547136)
print v(xbgr.mr_n77547456)
print v(xbgr.mr_n77547568)
print v(xbgr.mr_n77547888)
print v(xbgr.mr_n77548000)
print v(xbgr.mr_n77548320)
print v(xbgr.mr_n77548432)
print v(xbgr.mr_n77548752)
print v(xbgr.mr_n77548864)
print v(xbgr.mr_n77549184)
print v(xbgr.mr_n77549296)
print v(xbgr.mr_n77549616)
print v(xbgr.mr_n77549728)
print v(xbgr.mr_n77550048)
print v(xbgr.mr_n77550160)
print v(xbgr.mr_n77550480)
print v(xbgr.mr_n77550592)
print v(xbgr.mr_n77550912)
print v(xbgr.mr_n77551024)
print v(xbgr.mr_n77551344)
print v(xbgr.mr_n77551456)
print v(xbgr.mr_n77551776)
print v(xbgr.mr_n77551888)
print v(xbgr.mr_n77552320)
print v(xbgr.mr_n77552752)
print v(xbgr.mr_n77553184)
print v(xbgr.mr_n77553616)
print v(xbgr.mr_n77554048)
print v(xbgr.mr_n77554480)
print v(xbgr.mr_n77554912)
print v(xbgr.mr_n77555344)
print v(xbgr.mr_n77555776)
print v(xbgr.mr_n77556208)
print v(xbgr.mr_n77556640)
print v(xbgr.mr_n77557072)
print v(xbgr.mr_n77557504)
print v(xbgr.mr_n77557936)
print v(xbgr.mr_n77558368)
print v(xbgr.mr_n77558800)
print v(xbgr.mr_n77559232)
print v(xbgr.mr_n77559664)
print v(xbgr.mr_n77560096)
print v(xbgr.mr_n77560528)
print v(xbgr.mr_n77560960)
print v(xbgr.mr_n77561392)
print v(xbgr.mr_n77561824)
print v(xbgr.mr_n77562256)
print v(xbgr.mr_n77562688)
print v(xbgr.mr_n77563120)
print v(xbgr.mr_n77563552)
print v(xbgr.mr_n77563984)
print v(xbgr.mr_n77564416)
print v(xbgr.mr_n77564848)
print v(xbgr.mr_n77565280)
print v(xbgr.mr_n77565712)
print v(xbgr.mr_n77566144)
print v(xbgr.mr_n77566576)
print v(xbgr.mr_n77567008)
print v(xbgr.mr_n77567440)
print v(xbgr.mr_n77567872)
print v(xbgr.mr_n77568304)
print v(xbgr.mr_n77568736)
print v(xbgr.mr_n77569168)
print v(xbgr.mr_n77569600)
print v(xbgr.mr_n77570032)
print v(xbgr.mr_n77570464)
print v(xbgr.mr_n77570896)
print v(xbgr.mr_n77571328)
print v(xbgr.mr_n77571760)
print v(xbgr.mr_n77572192)
print v(xbgr.mr_n77572624)
print v(xbgr.mr_n77573056)
print v(xbgr.mr_n77573488)
print v(xbgr.mr_n77573920)
print v(xbgr.mr_n77574352)
print v(xbgr.mr_n77574784)
print v(xbgr.mr_n77575216)
print v(xbgr.mr_n77575648)
print v(xbgr.mr_n77576080)
print v(xbgr.mr_n77576512)
print v(xbgr.mr_n77576944)
print v(xbgr.mr_n77577376)
print v(xbgr.mr_n77577808)
print v(xbgr.mr_n77578240)
print v(xbgr.mr_n77578672)
print v(xbgr.mr_n77579104)
print v(xbgr.mr_n77579536)
print v(xbgr.mr_n77579968)
print v(xbgr.mr_n77580400)
print v(xbgr.mr_n77580832)
print v(xbgr.mr_n77581264)
print v(xbgr.mr_n77581696)
print v(xbgr.mr_n77582128)
print v(xbgr.mr_n77582560)
print v(xbgr.mr_n77582992)
print v(xbgr.mr_n77583424)
print v(xbgr.mr_n77583856)
print v(xbgr.mr_n77584288)
print v(xbgr.mr_n77584720)
print v(xbgr.mr_n77585152)
print v(xbgr.mr_n77585584)
print v(xbgr.mr_n77586016)
print v(xbgr.mr_n77586448)
print v(xbgr.mr_n77586880)
print v(xbgr.mr_n77587312)
print v(xbgr.mr_n77587744)
print v(xbgr.mr_n77588176)
print v(xbgr.mr_n77588608)
print v(xbgr.mr_n77589040)
print v(xbgr.mr_n77589472)
print v(xbgr.mr_n77589904)
print v(xbgr.mr_n77590336)
print v(xbgr.mr_n77590768)
print v(xbgr.mr_n77591200)
print v(xbgr.mr_n77591632)
print v(xbgr.mr_n77592064)
print v(xbgr.mr_n77592496)
print v(xbgr.mr_n77592928)
print v(xbgr.mr_n77593360)
print v(xbgr.mr_n77593792)
print v(xbgr.mr_n77594224)
print v(xbgr.mr_n77594544)
print v(xbgr.mr_n77594656)
print v(xbgr.mr_n77594976)
print v(xbgr.mr_n77595088)
print v(xbgr.mr_n77595408)
print v(xbgr.mr_n77595520)
print v(xbgr.mr_n77595840)
print v(xbgr.mr_n77595952)
print v(xbgr.mr_n77596272)
print v(xbgr.mr_n77596384)
print v(xbgr.mr_n77596704)
print v(xbgr.mr_n77596816)
print v(xbgr.mr_n77597136)
print v(xbgr.mr_n77597248)
print v(xbgr.mr_n77597568)
print v(xbgr.mr_n77597680)
print v(xbgr.mr_n77598000)
print v(xbgr.mr_n77598112)
print v(xbgr.mr_n77598432)
print v(xbgr.mr_n77598544)
print v(xbgr.mr_n77598864)
print v(xbgr.mr_n77598976)
print v(xbgr.mr_n77599296)
print v(xbgr.mr_n77599408)
print v(xbgr.mr_n77599728)
print v(xbgr.mr_n77599840)
print v(xbgr.mr_n77600160)
print v(xbgr.mr_n77600272)
print v(xbgr.mr_n77600592)
print v(xbgr.mr_n77600704)
print v(xbgr.mr_n77601024)
print v(xbgr.mr_n77601136)
print v(xbgr.mr_n77601456)
print v(xbgr.mr_n77601568)
print v(xbgr.mr_n77601888)
print v(xbgr.mr_n77602000)
print v(xbgr.mr_n77602320)
print v(xbgr.mr_n77602432)
print v(xbgr.mr_n77602752)
print v(xbgr.mr_n77602864)
print v(xbgr.mr_n77603184)
print v(xbgr.mr_n77603296)
print v(xbgr.mr_n77603616)
print v(xbgr.mr_n77603728)
print v(xbgr.mr_n77604048)
print v(xbgr.mr_n77604160)
print v(xbgr.mr_n77604480)
print v(xbgr.mr_n77604592)
print v(xbgr.mr_n77604912)
print v(xbgr.mr_n77605024)
print v(xbgr.mr_n77605344)
print v(xbgr.mr_n77605456)
print v(xbgr.mr_n77605776)
print v(xbgr.mr_n77605888)
print v(xbgr.mr_n77606208)
print v(xbgr.mr_n77606320)
print v(xbgr.mr_n77606640)
print v(xbgr.mr_n77606752)
print v(xbgr.mr_n77607072)
print v(xbgr.mr_n77607184)
print v(xbgr.mr_n77607504)
print v(xbgr.mr_n77607616)
print v(xbgr.mr_n77607936)
print v(xbgr.mr_n77608048)
print v(xbgr.mr_n77608368)
print v(xbgr.mr_n77608480)
print v(xbgr.mr_n77608800)
print v(xbgr.mr_n77608912)
print v(xbgr.mr_n77609232)
print v(xbgr.mr_n77609344)
print v(xbgr.mr_n77609664)
print v(xbgr.mr_n77609776)
print v(xbgr.mr_n77610096)
print v(xbgr.mr_n77610208)
print v(xbgr.mr_n77610528)
print v(xbgr.mr_n77610640)
print v(xbgr.mr_n77610960)
print v(xbgr.mr_n77611072)
print v(xbgr.mr_n77611392)
print v(xbgr.mr_n77611504)
print v(xbgr.mr_n77611824)
print v(xbgr.mr_n77611936)
print v(xbgr.mr_n77612256)
print v(xbgr.mr_n77612368)
print v(xbgr.mr_n77612688)
print v(xbgr.mr_n77612800)
print v(xbgr.mr_n77613120)
print v(xbgr.mr_n77613232)
print v(xbgr.mr_n77613552)
print v(xbgr.mr_n77613664)
print v(xbgr.mr_n77613984)
print v(xbgr.mr_n77614096)
print v(xbgr.mr_n77614416)
print v(xbgr.mr_n77614528)
print v(xbgr.mr_n77614848)
print v(xbgr.mr_n77614960)
print v(xbgr.mr_n77615280)
print v(xbgr.mr_n77615392)
print v(xbgr.mr_n77615712)
print v(xbgr.mr_n77615824)
print v(xbgr.mr_n77616144)
print v(xbgr.mr_n77616256)
print v(xbgr.mr_n77616576)
print v(xbgr.mr_n77616688)
print v(xbgr.mr_n77617008)
print v(xbgr.mr_n77617120)
print v(xbgr.mr_n77617440)
print v(xbgr.mr_n77617552)
print v(xbgr.mr_n77617872)
print v(xbgr.mr_n77617984)
print v(xbgr.mr_n77618304)
print v(xbgr.mr_n77618416)
print v(xbgr.mr_n77618736)
print v(xbgr.mr_n77618848)
print v(xbgr.mr_n77619168)
print v(xbgr.mr_n77619280)
print v(xbgr.mr_n77619600)
print v(xbgr.mr_n77619712)
print v(xbgr.mr_n77620032)
print v(xbgr.mr_n77620144)
print v(xbgr.mr_n77620464)
print v(xbgr.mr_n77620576)
print v(xbgr.mr_n77620896)
print v(xbgr.mr_n77621008)
print v(xbgr.mr_n77621328)
print v(xbgr.mr_n77621440)
print v(xbgr.mr_n77621760)
print v(xbgr.mr_n77621872)
print v(xbgr.mr_n77622192)
print v(xbgr.mr_n77622304)
print v(xbgr.mr_n77622624)
print v(xbgr.mr_n77622736)
print v(xbgr.mr_n77623056)
print v(xbgr.mr_n77623168)
print v(xbgr.mr_n77623488)
print v(xbgr.mr_n77623600)
print v(xbgr.mr_n77623920)
print v(xbgr.mr_n77624032)
print v(xbgr.mr_n77624352)
print v(xbgr.mr_n77624464)
print v(xbgr.mr_n77624784)
print v(xbgr.mr_n77624896)
print v(xbgr.mr_n77625216)
print v(xbgr.mr_n77625328)
print v(xbgr.mr_n77625648)
print v(xbgr.mr_n77625760)
print v(xbgr.mr_n77626080)
print v(xbgr.mr_n77626192)
print v(xbgr.mr_n77626512)
print v(xbgr.mr_n77626624)
print v(xbgr.mr_n77626944)
print v(xbgr.mr_n77627056)
print v(xbgr.mr_n77627376)
print v(xbgr.mr_n77627488)
print v(xbgr.mr_n77627808)
print v(xbgr.mr_n77627920)
print v(xbgr.mr_n77628240)
print v(xbgr.mr_n77628352)
print v(xbgr.mr_n77628672)
print v(xbgr.mr_n77628784)
print v(xbgr.mr_n77629104)
print v(xbgr.mr_n77629216)
print v(xbgr.mr_n77629536)
print v(xbgr.mr_n77629648)
print v(xbgr.mr_n77629968)
print v(xbgr.mr_n77630080)
print v(xbgr.mr_n77630400)
print v(xbgr.mr_n77630512)
print v(xbgr.mr_n77630832)
print v(xbgr.mr_n77630944)
print v(xbgr.mr_n77631264)
print v(xbgr.mr_n77631376)
print v(xbgr.mr_n77631696)
print v(xbgr.mr_n77631808)
print v(xbgr.mr_n77632128)
print v(xbgr.mr_n77632240)
print v(xbgr.mr_n77632560)
print v(xbgr.mr_n77632672)
print v(xbgr.mr_n77632992)
print v(xbgr.mr_n77633104)
print v(xbgr.mr_n77633424)
print v(xbgr.mr_n77633536)
print v(xbgr.mr_n77633856)
print v(xbgr.mr_n77633968)
print v(xbgr.mr_n77634288)
print v(xbgr.mr_n77634400)
print v(xbgr.mr_n77634720)
print v(xbgr.mr_n77634832)
print v(xbgr.mr_n77635152)
print v(xbgr.mr_n77635264)
print v(xbgr.mr_n77635584)
print v(xbgr.mr_n77635696)
print v(xbgr.mr_n77636016)
print v(xbgr.mr_n77636128)
print v(xbgr.mr_n77636448)
print v(xbgr.mr_n77636560)
print v(xbgr.mr_n77636880)
print v(xbgr.mr_n77636992)
print v(xbgr.mr_n77637312)
print v(xbgr.mr_n77637424)
print v(xbgr.mr_n77637744)
print v(xbgr.mr_n77637856)
print v(xbgr.mr_n77638176)
print v(xbgr.mr_n77638288)
print v(xbgr.mr_n77638608)
print v(xbgr.mr_n77638720)
print v(xbgr.mr_n77639040)
print v(xbgr.mr_n77639152)
print v(xbgr.mr_n77639472)
print v(xbgr.mr_n77639584)
print v(xbgr.mr_n77639904)
print v(xbgr.mr_n77640016)
print v(xbgr.mr_n77640336)
print v(xbgr.mr_n77640448)
print v(xbgr.mr_n77640768)
print v(xbgr.mr_n77640880)
print v(xbgr.mr_n77641200)
print v(xbgr.mr_n77641312)
print v(xbgr.mr_n77641632)
print v(xbgr.mr_n77641744)
print v(xbgr.mr_n77642064)
print v(xbgr.mr_n77642176)
print v(xbgr.mr_n77642496)
print v(xbgr.mr_n77642608)
print v(xbgr.mr_n77642928)
print v(xbgr.mr_n77643040)
print v(xbgr.mr_n77643360)
print v(xbgr.mr_n77643472)
print v(xbgr.mr_n77643792)
print v(xbgr.mr_n77643904)
print v(xbgr.mr_n77644224)
print v(xbgr.mr_n77644336)
print v(xbgr.mr_n77644656)
print v(xbgr.mr_n77644768)
print v(xbgr.mr_n77645088)
print v(xbgr.mr_n77645200)
print v(xbgr.mr_n77645520)
print v(xbgr.mr_n77645632)
print v(xbgr.mr_n77645952)
print v(xbgr.mr_n77646064)
print v(xbgr.mr_n77646384)
print v(xbgr.mr_n77646496)
print v(xbgr.mr_n77646816)
print v(xbgr.mr_n77646928)
print v(xbgr.mr_n77647248)
print v(xbgr.mr_n77647360)
print v(xbgr.mr_n77647680)
print v(xbgr.mr_n77647792)
print v(xbgr.mr_n77648112)
print v(xbgr.mr_n77648224)
print v(xbgr.mr_n77648544)
print v(xbgr.mr_n77648656)
print v(xbgr.mr_n77648976)
print v(xbgr.mr_n77649088)
print v(xbgr.mr_n77649408)
print v(xbgr.mr_n77649520)
print v(xbgr.mr_n77649840)
print v(xbgr.mr_n77649952)
print v(xbgr.mr_n77650272)
print v(xbgr.mr_n77650384)
print v(xbgr.mr_n77650704)
print v(xbgr.mr_n77650816)
print v(xbgr.mr_n77651136)
print v(xbgr.mr_n77651248)
print v(xbgr.mr_n77651568)
print v(xbgr.mr_n77651680)
print v(xbgr.mr_n77652000)
print v(xbgr.mr_n77652112)
print v(xbgr.mr_n77652432)
print v(xbgr.mr_n77652544)
print v(xbgr.mr_n77652864)
print v(xbgr.mr_n77652976)
print v(xbgr.mr_n77653296)
print v(xbgr.mr_n77653408)
print v(xbgr.mr_n77653728)
print v(xbgr.mr_n77653840)
print v(xbgr.mr_n77654160)
print v(xbgr.mr_n77654272)
print v(xbgr.mr_n77654592)
print v(xbgr.mr_n77654704)
print v(xbgr.mr_n77655024)
print v(xbgr.mr_n77655136)
print v(xbgr.mr_n77655456)
print v(xbgr.mr_n77655568)
print v(xbgr.mr_n77655888)
print v(xbgr.mr_n77656000)
print v(xbgr.mr_n77656320)
print v(xbgr.mr_n77656432)
print v(xbgr.mr_n77656752)
print v(xbgr.mr_n77656864)
print v(xbgr.mr_n77657184)
print v(xbgr.mr_n77657296)
print v(xbgr.mr_n77657728)
print v(xbgr.mr_n77658160)
print v(xbgr.mr_n77658592)
print v(xbgr.mr_n77659024)
print v(xbgr.mr_n77659456)
print v(xbgr.mr_n77659888)
print v(xbgr.mr_n77660320)
print v(xbgr.mr_n77660752)
print v(xbgr.mr_n77661184)
print v(xbgr.mr_n77661616)
print v(xbgr.mr_n77662048)
print v(xbgr.mr_n77662480)
print v(xbgr.mr_n77662912)
print v(xbgr.mr_n77663344)
print v(xbgr.mr_n77663776)
print v(xbgr.mr_n77664208)
print v(xbgr.mr_n77664640)
print v(xbgr.mr_n77665072)
print v(xbgr.mr_n77665504)
print v(xbgr.mr_n77665936)
print v(xbgr.mr_n77666368)
print v(xbgr.mr_n77666800)
print v(xbgr.mr_n77667232)
print v(xbgr.mr_n77667664)
print v(xbgr.mr_n77668096)
print v(xbgr.mr_n77668528)
print v(xbgr.mr_n77668960)
print v(xbgr.mr_n77669392)
print v(xbgr.mr_n77669824)
print v(xbgr.mr_n77670256)
print v(xbgr.mr_n77670688)
print v(xbgr.mr_n77671120)
print v(xbgr.mr_n77671552)
print v(xbgr.mr_n77671984)
print v(xbgr.mr_n77672416)
print v(xbgr.mr_n77672848)
print v(xbgr.mr_n77673280)
print v(xbgr.mr_n77673712)
print v(xbgr.mr_n77674144)
print v(xbgr.mr_n77674576)
print v(xbgr.mr_n77675008)
print v(xbgr.mr_n77675440)
print v(xbgr.mr_n77675872)
print v(xbgr.mr_n77676304)
print v(xbgr.mr_n77676736)
print v(xbgr.mr_n77677168)
print v(xbgr.mr_n77677600)
print v(xbgr.mr_n77678032)
print v(xbgr.mr_n77678464)
print v(xbgr.mr_n77678896)
print v(xbgr.mr_n77679328)
print v(xbgr.mr_n77679760)
print v(xbgr.mr_n77680192)
print v(xbgr.mr_n77680624)
print v(xbgr.mr_n77681056)
print v(xbgr.mr_n77681488)
print v(xbgr.mr_n77681920)
print v(xbgr.mr_n77682352)
print v(xbgr.mr_n77682784)
print v(xbgr.mr_n77683216)
print v(xbgr.mr_n77683648)
print v(xbgr.mr_n77684080)
print v(xbgr.mr_n77684512)
print v(xbgr.mr_n77684944)
print v(xbgr.mr_n77685376)
print v(xbgr.mr_n77685808)
print v(xbgr.mr_n77686240)
print v(xbgr.mr_n77686672)
print v(xbgr.mr_n77687104)
print v(xbgr.mr_n77687536)
print v(xbgr.mr_n77687968)
print v(xbgr.mr_n77688400)
print v(xbgr.mr_n77688832)
print v(xbgr.mr_n77689264)
print v(xbgr.mr_n77689696)
print v(xbgr.mr_n77690128)
print v(xbgr.mr_n77690560)
print v(xbgr.mr_n77690992)
print v(xbgr.mr_n77691424)
print v(xbgr.mr_n77691856)
print v(xbgr.mr_n77692288)
print v(xbgr.mr_n77692720)
print v(xbgr.mr_n77693152)
print v(xbgr.mr_n77693584)
print v(xbgr.mr_n77694016)
print v(xbgr.mr_n77694448)
print v(xbgr.mr_n77694880)
print v(xbgr.mr_n77695312)
print v(xbgr.mr_n77695744)
print v(xbgr.mr_n77696176)
print v(xbgr.mr_n77696608)
print v(xbgr.mr_n77697040)
print v(xbgr.mr_n77697472)
print v(xbgr.mr_n77697904)
print v(xbgr.mr_n77698336)
print v(xbgr.mr_n77698768)
print v(xbgr.mr_n77699200)
print v(xbgr.mr_n77699632)
print v(xbgr.mr_n77700064)
print v(xbgr.mr_n77700496)
print v(xbgr.mr_n77700928)
print v(xbgr.mr_n77701360)
print v(xbgr.mr_n77701792)
print v(xbgr.mr_n77702224)
print v(xbgr.mr_n77702656)
print v(xbgr.mr_n77703088)
print v(xbgr.mr_n77703520)
print v(xbgr.mr_n77703952)
print v(xbgr.mr_n77704384)
print v(xbgr.mr_n77704816)
print v(xbgr.mr_n77705248)
print v(xbgr.mr_n77705680)
print v(xbgr.mr_n77706112)
print v(xbgr.mr_n77706544)
print v(xbgr.mr_n77706976)
print v(xbgr.mr_n77707408)
print v(xbgr.mr_n77707840)
print v(xbgr.mr_n77708272)
print v(xbgr.mr_n77708704)
print v(xbgr.mr_n77709136)
print v(xbgr.mr_n77709568)
print v(xbgr.mr_n77710000)
print v(xbgr.mr_n77710432)
print v(xbgr.mr_n77710864)
print v(xbgr.mr_n77711296)
print v(xbgr.mr_n77711728)
print v(xbgr.mr_n77712160)
print v(xbgr.mr_n77712592)
print v(xbgr.mr_n77713024)
print v(xbgr.mr_n77713456)
print v(xbgr.mr_n77713888)
print v(xbgr.mr_n77714320)
print v(xbgr.mr_n77714752)
print v(xbgr.mr_n77715184)
print v(xbgr.mr_n77715616)
print v(xbgr.mr_n77716048)
print v(xbgr.mr_n77716480)
print v(xbgr.mr_n77716912)
print v(xbgr.mr_n77717344)
print v(xbgr.mr_n77717776)
print v(xbgr.mr_n77718208)
print v(xbgr.mr_n77718640)
print v(xbgr.mr_n77719072)
print v(xbgr.mr_n77719504)
print v(xbgr.mr_n77719936)
print v(xbgr.mr_n77720368)
print v(xbgr.mr_n77720800)
print v(xbgr.mr_n77721232)
print v(xbgr.mr_n77721664)
print v(xbgr.mr_n77722096)
print v(xbgr.mr_n77722528)
print v(xbgr.mr_n77722960)
print v(xbgr.mr_n77723392)
print v(xbgr.mr_n77723824)
print v(xbgr.mr_n77724256)
print v(xbgr.mr_n77724688)
print v(xbgr.mr_n77725120)
print v(xbgr.mr_n77725552)
print v(xbgr.mr_n77725984)
print v(xbgr.mr_n77726416)
print v(xbgr.mr_n77726848)
print v(xbgr.mr_n77727280)
print v(xbgr.mr_n77727712)
print v(xbgr.mr_n77728144)
print v(xbgr.mr_n77728576)
print v(xbgr.mr_n77729008)
print v(xbgr.mr_n77729440)
print v(xbgr.mr_n77729872)
print v(xbgr.mr_n77730304)
print v(xbgr.mr_n77730736)
print v(xbgr.mr_n77731168)
print v(xbgr.mr_n77731600)
print v(xbgr.mr_n77732032)
print v(xbgr.mr_n77732464)
print v(xbgr.mr_n77732896)
print v(xbgr.mr_n77733328)
print v(xbgr.mr_n77733760)
print v(xbgr.mr_n77734192)
print v(xbgr.mr_n77734624)
print v(xbgr.mr_n77735056)
print v(xbgr.mr_n77735488)
print v(xbgr.mr_n77735920)
print v(xbgr.mr_n77736352)
print v(xbgr.mr_n77736784)
print v(xbgr.mr_n77737216)
print v(xbgr.mr_n77737648)
print v(xbgr.mr_n77738080)
print v(xbgr.mr_n77738512)
print v(xbgr.mr_n77738944)
print v(xbgr.mr_n77739376)
print v(xbgr.mr_n77739808)
print v(xbgr.mr_n77740240)
print v(xbgr.mr_n77740672)
print v(xbgr.mr_n77741104)
print v(xbgr.mr_n77741536)
print v(xbgr.mr_n77741968)
print v(xbgr.mr_n77742400)
print v(xbgr.mr_n77742832)
print v(xbgr.mr_n77743264)
print v(xbgr.mr_n77743696)
print v(xbgr.mr_n77744128)
print v(xbgr.mr_n77744560)
print v(xbgr.mr_n77744992)
print v(xbgr.mr_n77745424)
print v(xbgr.mr_n77745856)
print v(xbgr.mr_n77746288)
print v(xbgr.mr_n77746720)
print v(xbgr.mr_n77747152)
print v(xbgr.mr_n77747584)
print v(xbgr.mr_n77748016)
print v(xbgr.mr_n77748448)
print v(xbgr.mr_n77748880)
print v(xbgr.mr_n77749312)
print v(xbgr.mr_n77749744)
print v(xbgr.mr_n77750064)
print v(xbgr.mr_n77750176)
print v(xbgr.mr_n77750496)
print v(xbgr.mr_n77750608)
print v(xbgr.mr_n77750928)
print v(xbgr.mr_n77751040)
print v(xbgr.mr_n77751360)
print v(xbgr.mr_n77751472)
print v(xbgr.mr_n77751792)
print v(xbgr.mr_n77751904)
print v(xbgr.mr_n77752224)
print v(xbgr.mr_n77752336)
print v(xbgr.mr_n77752656)
print v(xbgr.mr_n77752768)
print v(xbgr.mr_n77753088)
print v(xbgr.mr_n77753200)
print v(xbgr.mr_n77753520)
print v(xbgr.mr_n77753632)
print v(xbgr.mr_n77753952)
print v(xbgr.mr_n77754064)
print v(xbgr.mr_n77754384)
print v(xbgr.mr_n77754496)
print v(xbgr.mr_n77754816)
print v(xbgr.mr_n77754928)
print v(xbgr.mr_n77755248)
print v(xbgr.mr_n77755360)
print v(xbgr.mr_n77755680)
print v(xbgr.mr_n77755792)
print v(xbgr.mr_n77756112)
print v(xbgr.mr_n77756224)
print v(xbgr.mr_n77756544)
print v(xbgr.mr_n77756656)
print v(xbgr.mr_n77756976)
print v(xbgr.mr_n77757088)
print v(xbgr.mr_n77757408)
print v(xbgr.mr_n77757520)
print v(xbgr.mr_n77757840)
print v(xbgr.mr_n77757952)
print v(xbgr.mr_n77758272)
print v(xbgr.mr_n77758384)
print v(xbgr.mr_n77758704)
print v(xbgr.mr_n77758816)
print v(xbgr.mr_n77759136)
print v(xbgr.mr_n77759248)
print v(xbgr.mr_n77759568)
print v(xbgr.mr_n77759680)
print v(xbgr.mr_n77760000)
print v(xbgr.mr_n77760112)
print v(xbgr.mr_n77760432)
print v(xbgr.mr_n77760544)
print v(xbgr.mr_n77760864)
print v(xbgr.mr_n77760976)
print v(xbgr.mr_n77761296)
print v(xbgr.mr_n77761408)
print v(xbgr.mr_n77761728)
print v(xbgr.mr_n77761840)
print v(xbgr.mr_n77762160)
print v(xbgr.mr_n77762272)
print v(xbgr.mr_n77762592)
print v(xbgr.mr_n77762704)
print v(xbgr.mr_n77763024)
print v(xbgr.mr_n77763136)
print v(xbgr.mr_n77763456)
print v(xbgr.mr_n77763568)
print v(xbgr.mr_n77763888)
print v(xbgr.mr_n77764000)
print v(xbgr.mr_n77764320)
print v(xbgr.mr_n77764432)
print v(xbgr.mr_n77764752)
print v(xbgr.mr_n77764864)
print v(xbgr.mr_n77765184)
print v(xbgr.mr_n77765296)
print v(xbgr.mr_n77765616)
print v(xbgr.mr_n77765728)
print v(xbgr.mr_n77766048)
print v(xbgr.mr_n77766160)
print v(xbgr.mr_n77766480)
print v(xbgr.mr_n77766592)
print v(xbgr.mr_n77766912)
print v(xbgr.mr_n77767024)
print v(xbgr.mr_n77767344)
print v(xbgr.mr_n77767456)
print v(xbgr.mr_n77767776)
print v(xbgr.mr_n77767888)
print v(xbgr.mr_n77768208)
print v(xbgr.mr_n77768320)
print v(xbgr.mr_n77768640)
print v(xbgr.mr_n77768752)
print v(xbgr.mr_n77769072)
print v(xbgr.mr_n77769184)
print v(xbgr.mr_n77769504)
print v(xbgr.mr_n77769616)
print v(xbgr.mr_n77769936)
print v(xbgr.mr_n77770048)
print v(xbgr.mr_n77770368)
print v(xbgr.mr_n77770480)
print v(xbgr.mr_n77770800)
print v(xbgr.mr_n77770912)
print v(xbgr.mr_n77771232)
print v(xbgr.mr_n77771344)
print v(xbgr.mr_n77771664)
print v(xbgr.mr_n77771776)
print v(xbgr.mr_n77772096)
print v(xbgr.mr_n77772208)
print v(xbgr.mr_n77772528)
print v(xbgr.mr_n77772640)
print v(xbgr.mr_n77772960)
print v(xbgr.mr_n77773072)
print v(xbgr.mr_n77773392)
print v(xbgr.mr_n77773504)
print v(xbgr.mr_n77773824)
print v(xbgr.mr_n77773936)
print v(xbgr.mr_n77774256)
print v(xbgr.mr_n77774368)
print v(xbgr.mr_n77774688)
print v(xbgr.mr_n77774800)
print v(xbgr.mr_n77775120)
print v(xbgr.mr_n77775232)
print v(xbgr.mr_n77775552)
print v(xbgr.mr_n77775664)
print v(xbgr.mr_n77775984)
print v(xbgr.mr_n77776096)
print v(xbgr.mr_n77776416)
print v(xbgr.mr_n77776528)
print v(xbgr.mr_n77776848)
print v(xbgr.mr_n77776960)
print v(xbgr.mr_n77777280)
print v(xbgr.mr_n77777392)
print v(xbgr.mr_n77777712)
print v(xbgr.mr_n77777824)
print v(xbgr.mr_n77778144)
print v(xbgr.mr_n77778256)
print v(xbgr.mr_n77778576)
print v(xbgr.mr_n77778688)
print v(xbgr.mr_n77779008)
print v(xbgr.mr_n77779120)
print v(xbgr.mr_n77779440)
print v(xbgr.mr_n77779552)
print v(xbgr.mr_n77779872)
print v(xbgr.mr_n77779984)
print v(xbgr.mr_n77780304)
print v(xbgr.mr_n77780416)
print v(xbgr.mr_n77780736)
print v(xbgr.mr_n77780848)
print v(xbgr.mr_n77781168)
print v(xbgr.mr_n77781280)
print v(xbgr.mr_n77781600)
print v(xbgr.mr_n77781712)
print v(xbgr.mr_n77782032)
print v(xbgr.mr_n77782144)
print v(xbgr.mr_n77782464)
print v(xbgr.mr_n77782576)
print v(xbgr.mr_n77782896)
print v(xbgr.mr_n77783008)
print v(xbgr.mr_n77783328)
print v(xbgr.mr_n77783440)
print v(xbgr.mr_n77783760)
print v(xbgr.mr_n77783872)
print v(xbgr.mr_n77784192)
print v(xbgr.mr_n77784304)
print v(xbgr.mr_n77784624)
print v(xbgr.mr_n77784736)
print v(xbgr.mr_n77785056)
print v(xbgr.mr_n77785168)
print v(xbgr.mr_n77785488)
print v(xbgr.mr_n77785600)
print v(xbgr.mr_n77785920)
print v(xbgr.mr_n77786032)
print v(xbgr.mr_n77786352)
print v(xbgr.mr_n77786464)
print v(xbgr.mr_n77786784)
print v(xbgr.mr_n77786896)
print v(xbgr.mr_n77787216)
print v(xbgr.mr_n77787328)
print v(xbgr.mr_n77787648)
print v(xbgr.mr_n77787760)
print v(xbgr.mr_n77788080)
print v(xbgr.mr_n77788192)
print v(xbgr.mr_n77788512)
print v(xbgr.mr_n77788624)
print v(xbgr.mr_n77788944)
print v(xbgr.mr_n77789056)
print v(xbgr.mr_n77789376)
print v(xbgr.mr_n77789488)
print v(xbgr.mr_n77789808)
print v(xbgr.mr_n77789920)
print v(xbgr.mr_n77790240)
print v(xbgr.mr_n77790352)
print v(xbgr.mr_n77790672)
print v(xbgr.mr_n77790784)
print v(xbgr.mr_n77791104)
print v(xbgr.mr_n77791216)
print v(xbgr.mr_n77791536)
print v(xbgr.mr_n77791648)
print v(xbgr.mr_n77791968)
print v(xbgr.mr_n77792080)
print v(xbgr.mr_n77792400)
print v(xbgr.mr_n77792512)
print v(xbgr.mr_n77792832)
print v(xbgr.mr_n77792944)
print v(xbgr.mr_n77793264)
print v(xbgr.mr_n77793376)
print v(xbgr.mr_n77793696)
print v(xbgr.mr_n77793808)
print v(xbgr.mr_n77794128)
print v(xbgr.mr_n77794240)
print v(xbgr.mr_n77794560)
print v(xbgr.mr_n77794672)
print v(xbgr.mr_n77794992)
print v(xbgr.mr_n77795104)
print v(xbgr.mr_n77795424)
print v(xbgr.mr_n77795536)
print v(xbgr.mr_n77795856)
print v(xbgr.mr_n77795968)
print v(xbgr.mr_n77796288)
print v(xbgr.mr_n77796400)
print v(xbgr.mr_n77796720)
print v(xbgr.mr_n77796832)
print v(xbgr.mr_n77797152)
print v(xbgr.mr_n77797264)
print v(xbgr.mr_n77797584)
print v(xbgr.mr_n77797696)
print v(xbgr.mr_n77798016)
print v(xbgr.mr_n77798128)
print v(xbgr.mr_n77798448)
print v(xbgr.mr_n77798560)
print v(xbgr.mr_n77798880)
print v(xbgr.mr_n77798992)
print v(xbgr.mr_n77799312)
print v(xbgr.mr_n77799424)
print v(xbgr.mr_n77799744)
print v(xbgr.mr_n77799856)
print v(xbgr.mr_n77800176)
print v(xbgr.mr_n77800288)
print v(xbgr.mr_n77800608)
print v(xbgr.mr_n77800720)
print v(xbgr.mr_n77801040)
print v(xbgr.mr_n77801152)
print v(xbgr.mr_n77801472)
print v(xbgr.mr_n77801584)
print v(xbgr.mr_n77801904)
print v(xbgr.mr_n77802016)
print v(xbgr.mr_n77802336)
print v(xbgr.mr_n77802448)
print v(xbgr.mr_n77802768)
print v(xbgr.mr_n77802880)
print v(xbgr.mr_n77803200)
print v(xbgr.mr_n77803312)
print v(xbgr.mr_n77803632)
print v(xbgr.mr_n77803744)
print v(xbgr.mr_n77804064)
print v(xbgr.mr_n77804176)
print v(xbgr.mr_n77804496)
print v(xbgr.mr_n77804608)
print v(xbgr.mr_n77804928)
print v(xbgr.mr_n77805040)
print v(xbgr.mr_n77805360)
print v(xbgr.mr_n77805472)
print v(xbgr.mr_n77805792)
print v(xbgr.mr_n77805904)
print v(xbgr.mr_n77806224)
print v(xbgr.mr_n77806336)
print v(xbgr.mr_n77806656)
print v(xbgr.mr_n77806768)
print v(xbgr.mr_n77807088)
print v(xbgr.mr_n77807200)
print v(xbgr.mr_n77807520)
print v(xbgr.mr_n77807632)
print v(xbgr.mr_n77807952)
print v(xbgr.mr_n77808064)
print v(xbgr.mr_n77808384)
print v(xbgr.mr_n77808496)
print v(xbgr.mr_n77808816)
print v(xbgr.mr_n77808928)
print v(xbgr.mr_n77809248)
print v(xbgr.mr_n77809360)
print v(xbgr.mr_n77809680)
print v(xbgr.mr_n77809792)
print v(xbgr.mr_n77810112)
print v(xbgr.mr_n77810224)
print v(xbgr.mr_n77810544)
print v(xbgr.mr_n77810656)
print v(xbgr.mr_n77810976)
print v(xbgr.mr_n77811088)
print v(xbgr.mr_n77811408)
print v(xbgr.mr_n77811520)
print v(xbgr.mr_n77811840)
print v(xbgr.mr_n77811952)
print v(xbgr.mr_n77812272)
print v(xbgr.mr_n77812384)
print v(xbgr.mr_n77812704)
print v(xbgr.mr_n77812816)
print v(xbgr.mr_n77813136)
print v(xbgr.mr_n77813248)
print v(xbgr.mr_n77813568)
print v(xbgr.mr_n77813680)
print v(xbgr.mr_n77814000)
print v(xbgr.mr_n77814112)
print v(xbgr.mr_n77814432)
print v(xbgr.mr_n77814544)
print v(xbgr.mr_n77814864)
print v(xbgr.mr_n77814976)
print v(xbgr.mr_n77815296)
print v(xbgr.mr_n77815408)
print v(xbgr.mr_n77815728)
print v(xbgr.mr_n77815840)
print v(xbgr.mr_n77816160)
print v(xbgr.mr_n77816272)
print v(xbgr.mr_n77816592)
print v(xbgr.mr_n77816704)
print v(xbgr.mr_n77817024)
print v(xbgr.mr_n77817136)
print v(xbgr.mr_n77817456)
print v(xbgr.mr_n77817568)
print v(xbgr.mr_n77817888)
print v(xbgr.mr_n77818000)
print v(xbgr.mr_n77818320)
print v(xbgr.mr_n77818432)
print v(xbgr.mr_n77818752)
print v(xbgr.mr_n77818864)
print v(xbgr.mr_n77819184)
print v(xbgr.mr_n77819296)
print v(xbgr.mr_n77819616)
print v(xbgr.mr_n77819728)
print v(xbgr.mr_n77820048)
print v(xbgr.mr_n77820160)
print v(xbgr.mr_n77820480)
print v(xbgr.mr_n77820592)
print v(xbgr.mr_n77820912)
print v(xbgr.mr_n77821024)
print v(xbgr.mr_n77821344)
print v(xbgr.mr_n77821456)
print v(xbgr.mr_n77821776)
print v(xbgr.mr_n77821888)
print v(xbgr.mr_n77822208)
print v(xbgr.mr_n77822320)
print v(xbgr.mr_n77822640)
print v(xbgr.mr_n77822752)
print v(xbgr.mr_n77823072)
print v(xbgr.mr_n77823184)
print v(xbgr.mr_n77823504)
print v(xbgr.mr_n77823616)
print v(xbgr.mr_n77823936)
print v(xbgr.mr_n77824048)
print v(xbgr.mr_n77824368)
print v(xbgr.mr_n77824480)
print v(xbgr.mr_n77824800)
print v(xbgr.mr_n77824912)
print v(xbgr.mr_n77825232)
print v(xbgr.mr_n77825344)
print v(xbgr.mr_n77825664)
print v(xbgr.mr_n77825776)
print v(xbgr.mr_n77826096)
print v(xbgr.mr_n77826208)
print v(xbgr.mr_n77826528)
print v(xbgr.mr_n77826640)
print v(xbgr.mr_n77826960)
print v(xbgr.mr_n77827072)
print v(xbgr.mr_n77827392)
print v(xbgr.mr_n77827504)
print v(xbgr.mr_n77827824)
print v(xbgr.mr_n77827936)
print v(xbgr.mr_n77828256)
print v(xbgr.mr_n77828368)
print v(xbgr.mr_n77828688)
print v(xbgr.mr_n77828800)
print v(xbgr.mr_n77829120)
print v(xbgr.mr_n77829232)
print v(xbgr.mr_n77829552)
print v(xbgr.mr_n77829664)
print v(xbgr.mr_n77829984)
print v(xbgr.mr_n77830096)
print v(xbgr.mr_n77830416)
print v(xbgr.mr_n77830528)
print v(xbgr.mr_n77830848)
print v(xbgr.mr_n77830960)
print v(xbgr.mr_n77831280)
print v(xbgr.mr_n77831392)
print v(xbgr.mr_n77831712)
print v(xbgr.mr_n77831824)
print v(xbgr.mr_n77832144)
print v(xbgr.mr_n77832256)
print v(xbgr.mr_n77832576)
print v(xbgr.mr_n77832688)
print v(xbgr.mr_n77833008)
print v(xbgr.mr_n77833120)
print v(xbgr.mr_n77833440)
print v(xbgr.mr_n77833552)
print v(xbgr.mr_n77833872)
print v(xbgr.mr_n77833984)
print v(xbgr.mr_n77834304)
print v(xbgr.mr_n77834416)
print v(xbgr.mr_n77834736)
print v(xbgr.mr_n77834848)
print v(xbgr.mr_n77835168)
print v(xbgr.mr_n77835280)
print v(xbgr.mr_n77835600)
print v(xbgr.mr_n77835712)
print v(xbgr.mr_n77836032)
print v(xbgr.mr_n77836144)
print v(xbgr.mr_n77836464)
print v(xbgr.mr_n77836576)
print v(xbgr.mr_n77836896)
print v(xbgr.mr_n77837008)
print v(xbgr.mr_n77837328)
print v(xbgr.mr_n77837440)
print v(xbgr.mr_n77837760)
print v(xbgr.mr_n77837872)
print v(xbgr.mr_n77838192)
print v(xbgr.mr_n77838304)
print v(xbgr.mr_n77838624)
print v(xbgr.mr_n77838736)
print v(xbgr.mr_n77839056)
print v(xbgr.mr_n77839168)
print v(xbgr.mr_n77839488)
print v(xbgr.mr_n77839600)
print v(xbgr.mr_n77839920)
print v(xbgr.mr_n77840032)
print v(xbgr.mr_n77840352)
print v(xbgr.mr_n77840464)
print v(xbgr.mr_n77840784)
print v(xbgr.mr_n77840896)
print v(xbgr.mr_n77841216)
print v(xbgr.mr_n77841328)
print v(xbgr.mr_n77841648)
print v(xbgr.mr_n77841760)
print v(xbgr.mr_n77842080)
print v(xbgr.mr_n77842192)
print v(xbgr.mr_n77842512)
print v(xbgr.mr_n77842624)
print v(xbgr.mr_n77842944)
print v(xbgr.mr_n77843056)
print v(xbgr.mr_n77843376)
print v(xbgr.mr_n77843488)
print v(xbgr.mr_n77843808)
print v(xbgr.mr_n77843920)
print v(xbgr.mr_n77844784)
print v(xbgr.mr_n77845216)
print v(xbgr.mr_n77845648)
print v(xbgr.mr_n77846080)
print v(xbgr.mr_n77846512)
print v(xbgr.mr_n77846944)
print v(xbgr.mr_n77847376)
print v(xbgr.mr_n77847808)
print v(xbgr.mr_n77848240)
print v(xbgr.mr_n77848672)
print v(xbgr.mr_n77849104)
print v(xbgr.mr_n77849536)
print v(xbgr.mr_n77849968)
print v(xbgr.mr_n77850400)
print v(xbgr.mr_n77850832)
print v(xbgr.mr_n77851264)
print v(xbgr.mr_n77851696)
print v(xbgr.mr_n77852128)
print v(xbgr.mr_n77852560)
print v(xbgr.mr_n77852992)
print v(xbgr.mr_n77853424)
print v(xbgr.mr_n77853856)
print v(xbgr.mr_n77854288)
print v(xbgr.mr_n77854720)
print v(xbgr.mr_n77856880)
print v(xbgr.mr_n77857312)
print v(xbgr.mr_n77857744)
print v(xbgr.mr_n77858176)
print v(xbgr.mr_n77858608)
print v(xbgr.mr_n77859040)
print v(xbgr.mr_n77859472)
print v(xbgr.mr_n77859904)
print v(xbgr.mr_n77860336)
print v(xbgr.mr_n77860768)
print v(xbgr.mr_n77861200)
print v(xbgr.mr_n77861632)
print v(xbgr.mr_n77862064)
print v(xbgr.mr_n77862496)
print v(xbgr.mr_n77862928)
print v(xbgr.mr_n77863360)
print v(xbgr.mr_n77863792)
print v(xbgr.mr_n77864224)
print v(xbgr.mr_n77864656)
print v(xbgr.mr_n77865088)
print v(xbgr.mr_n77865520)
print v(xbgr.mr_n77865952)
print v(xbgr.mr_n77866384)
print v(xbgr.mr_n77866816)
print v(xbgr.mr_n77870704)
print v(xbgr.mr_n77871136)
print v(xbgr.mr_n77871568)
print v(xbgr.mr_n77872000)
print v(xbgr.mr_n77872432)
print v(xbgr.mr_n77872864)
print v(xbgr.mr_n77873296)
print v(xbgr.mr_n77873728)
print v(xbgr.mr_n77874160)
print v(xbgr.mr_n77874592)
print v(xbgr.mr_n77875024)
print v(xbgr.mr_n77875456)
print v(xbgr.mr_n77875888)
print v(xbgr.mr_n77876320)
print v(xbgr.mr_n77876752)
print v(xbgr.mr_n77878048)
print v(xbgr.mr_n77878480)
print v(xbgr.mr_n77878912)
print v(xbgr.mr_n77879344)
print v(xbgr.mr_n77879776)
print v(xbgr.mr_n77880208)
print v(xbgr.mr_n77880640)
print v(xbgr.mr_n77881072)
print v(xbgr.mr_n77881504)
print v(xbgr.mr_n77881936)
print v(xbgr.mr_n77883232)
print v(xbgr.mr_n77883664)
print v(xbgr.mr_n77884096)
print v(xbgr.mr_n77884528)
print v(xbgr.mr_n77884960)
print v(xbgr.mr_n77885392)
print v(xbgr.mr_n77885824)
print v(xbgr.mr_n77886256)
print v(xbgr.mr_n77886576)
print v(xbgr.mr_n77886688)
print v(xbgr.mr_n77887008)
print v(xbgr.mr_n77887120)
print v(xbgr.mr_n77887440)
print v(xbgr.mr_n77887552)
print v(xbgr.mr_n77887872)
print v(xbgr.mr_n77887984)
print v(xbgr.mr_n77888304)
print v(xbgr.mr_n77888416)
print v(xbgr.mr_n77888736)
print v(xbgr.mr_n77888848)
print v(xbgr.mr_n77889168)
print v(xbgr.mr_n77889280)
print v(xbgr.mr_n77889600)
print v(xbgr.mr_n77889712)
print v(xbgr.mr_n77890032)
print v(xbgr.mr_n77890144)
print v(xbgr.mr_n77890464)
print v(xbgr.mr_n77890576)
print v(xbgr.mr_n77890896)
print v(xbgr.mr_n77891008)
print v(xbgr.mr_n77891328)
print v(xbgr.mr_n77891440)
print v(xbgr.mr_n77891760)
print v(xbgr.mr_n77891872)
print v(xbgr.mr_n77892192)
print v(xbgr.mr_n77892304)
print v(xbgr.mr_n77892624)
print v(xbgr.mr_n77892736)
print v(xbgr.mr_n77893056)
print v(xbgr.mr_n77893168)
print v(xbgr.mr_n77893488)
print v(xbgr.mr_n77893600)
print v(xbgr.mr_n77893920)
print v(xbgr.mr_n77894032)
print v(xbgr.mr_n77894352)
print v(xbgr.mr_n77894464)
print v(xbgr.mr_n77894784)
print v(xbgr.mr_n77894896)
print v(xbgr.mr_n77895216)
print v(xbgr.mr_n77895328)
print v(xbgr.mr_n77895648)
print v(xbgr.mr_n77895760)
print v(xbgr.mr_n77896080)
print v(xbgr.mr_n77896192)
print v(xbgr.mr_n77896512)
print v(xbgr.mr_n77896624)
print v(xbgr.mr_n77896944)
print v(xbgr.mr_n77897056)
print v(xbgr.mr_n77897376)
print v(xbgr.mr_n77897488)
print v(xbgr.mr_n77897808)
print v(xbgr.mr_n77897920)
print v(xbgr.mr_n77898240)
print v(xbgr.mr_n77898352)
print v(xbgr.mr_n77898672)
print v(xbgr.mr_n77898784)
print v(xbgr.mr_n77899104)
print v(xbgr.mr_n77899216)
print v(xbgr.mr_n77899536)
print v(xbgr.mr_n77899648)
print v(xbgr.mr_n77899968)
print v(xbgr.mr_n77900080)
print v(xbgr.mr_n77900400)
print v(xbgr.mr_n77900512)
print v(xbgr.mr_n77900832)
print v(xbgr.mr_n77900944)
print v(xbgr.mr_n77901264)
print v(xbgr.mr_n77901376)
print v(xbgr.mr_n77901696)
print v(xbgr.mr_n77901808)
print v(xbgr.mr_n77902128)
print v(xbgr.mr_n77902240)
print v(xbgr.mr_n77902560)
print v(xbgr.mr_n77902672)
print v(xbgr.mr_n77902992)
print v(xbgr.mr_n77903104)
print v(xbgr.mr_n77903424)
print v(xbgr.mr_n77903536)
print v(xbgr.mr_n77903856)
print v(xbgr.mr_n77903968)
print v(xbgr.mr_n77904288)
print v(xbgr.mr_n77904400)
print v(xbgr.mr_n77904720)
print v(xbgr.mr_n77904832)
print v(xbgr.mr_n77905152)
print v(xbgr.mr_n77905264)
print v(xbgr.mr_n77905584)
print v(xbgr.mr_n77905696)
print v(xbgr.mr_n77906016)
print v(xbgr.mr_n77906128)
print v(xbgr.mr_n77906448)
print v(xbgr.mr_n77906560)
print v(xbgr.mr_n77906880)
print v(xbgr.mr_n77906992)
print v(xbgr.mr_n77907312)
print v(xbgr.mr_n77907424)
print v(xbgr.mr_n77907744)
print v(xbgr.mr_n77907856)
print v(xbgr.mr_n77908176)
print v(xbgr.mr_n77908288)
print v(xbgr.mr_n77908608)
print v(xbgr.mr_n77908720)
print v(xbgr.mr_n77909040)
print v(xbgr.mr_n77909152)
print v(xbgr.mr_n77909472)
print v(xbgr.mr_n77909584)
print v(xbgr.mr_n77909904)
print v(xbgr.mr_n77910016)
print v(xbgr.mr_n77910336)
print v(xbgr.mr_n77910448)
print v(xbgr.mr_n77910768)
print v(xbgr.mr_n77910880)
print v(xbgr.mr_n77911200)
print v(xbgr.mr_n77911312)
print v(xbgr.mr_n77911632)
print v(xbgr.mr_n77911744)
print v(xbgr.mr_n77912064)
print v(xbgr.mr_n77912176)
print v(xbgr.mr_n77912496)
print v(xbgr.mr_n77912608)
print v(xbgr.mr_n77912928)
print v(xbgr.mr_n77913040)
print v(xbgr.mr_n77913360)
print v(xbgr.mr_n77913472)
print v(xbgr.mr_n77913792)
print v(xbgr.mr_n77913904)
print v(xbgr.mr_n77914224)
print v(xbgr.mr_n77914336)
print v(xbgr.mr_n77914656)
print v(xbgr.mr_n77914768)
print v(xbgr.mr_n77915088)
print v(xbgr.mr_n77915200)
print v(xbgr.mr_n77915520)
print v(xbgr.mr_n77915632)
print v(xbgr.mr_n77915952)
print v(xbgr.mr_n77916064)
print v(xbgr.mr_n77916384)
print v(xbgr.mr_n77916496)
print v(xbgr.mr_n77916816)
print v(xbgr.mr_n77916928)
print v(xbgr.mr_n77917248)
print v(xbgr.mr_n77917360)
print v(xbgr.mr_n77917680)
print v(xbgr.mr_n77917792)
print v(xbgr.mr_n77918112)
print v(xbgr.mr_n77918224)
print v(xbgr.mr_n77918544)
print v(xbgr.mr_n77918656)
print v(xbgr.mr_n77918976)
print v(xbgr.mr_n77919088)
print v(xbgr.mr_n77919408)
print v(xbgr.mr_n77919520)
print v(xbgr.mr_n77919840)
print v(xbgr.mr_n77919952)
print v(xbgr.mr_n77920272)
print v(xbgr.mr_n77920384)
print v(xbgr.mr_n77920704)
print v(xbgr.mr_n77920816)
print v(xbgr.mr_n77921136)
print v(xbgr.mr_n77921248)
print v(xbgr.mr_n77921568)
print v(xbgr.mr_n77921680)
print v(xbgr.mr_n77922000)
print v(xbgr.mr_n77922112)
print v(xbgr.mr_n77922432)
print v(xbgr.mr_n77922544)
print v(xbgr.mr_n77922864)
print v(xbgr.mr_n77922976)
print v(xbgr.mr_n77923296)
print v(xbgr.mr_n77923408)
print v(xbgr.mr_n77923728)
print v(xbgr.mr_n77923840)
print v(xbgr.mr_n77924160)
print v(xbgr.mr_n77924272)
print v(xbgr.mr_n77924592)
print v(xbgr.mr_n77924704)
print v(xbgr.mr_n77925024)
print v(xbgr.mr_n77925136)
print v(xbgr.mr_n77925456)
print v(xbgr.mr_n77925568)
print v(xbgr.mr_n77925888)
print v(xbgr.mr_n77926000)
print v(xbgr.mr_n77926320)
print v(xbgr.mr_n77926432)
print v(xbgr.mr_n77926752)
print v(xbgr.mr_n77926864)
print v(xbgr.mr_n77927184)
print v(xbgr.mr_n77927296)
print v(xbgr.mr_n77927616)
print v(xbgr.mr_n77927728)
print v(xbgr.mr_n77928048)
print v(xbgr.mr_n77928160)
print v(xbgr.mr_n77928480)
print v(xbgr.mr_n77928592)
print v(xbgr.mr_n77928912)
print v(xbgr.mr_n77929024)
print v(xbgr.mr_n77929344)
print v(xbgr.mr_n77929456)
print v(xbgr.mr_n77929776)
print v(xbgr.mr_n77929888)
print v(xbgr.mr_n77930208)
print v(xbgr.mr_n77930320)
print v(xbgr.mr_n77930640)
print v(xbgr.mr_n77930752)
print v(xbgr.mr_n77931072)
print v(xbgr.mr_n77931184)
print v(xbgr.mr_n77931504)
print v(xbgr.mr_n77931616)
print v(xbgr.mr_n77931936)
print v(xbgr.mr_n77932048)
print v(xbgr.mr_n77932368)
print v(xbgr.mr_n77932480)
print v(xbgr.mr_n77932800)
print v(xbgr.mr_n77932912)
print v(xbgr.mr_n77933232)
print v(xbgr.mr_n77933664)
print v(xbgr.mr_n77933776)
print v(xbgr.mr_n77934096)
print v(xbgr.mr_n77934208)
print v(xbgr.mr_n77934528)
print v(xbgr.mr_n77934640)
print v(xbgr.mr_n77934960)
print v(xbgr.mr_n77935072)
print v(xbgr.mr_n77935392)
print v(xbgr.mr_n77935504)
print v(xbgr.mr_n77935824)
print v(xbgr.mr_n77935936)
print v(xbgr.mr_n77936256)
print v(xbgr.mr_n77936368)
print v(xbgr.mr_n77936688)
print v(xbgr.mr_n77936800)
print v(xbgr.mr_n77937120)
print v(xbgr.mr_n77937232)
print v(xbgr.mr_n77937552)
print v(xbgr.mr_n77937664)
print v(xbgr.mr_n77937984)
print v(xbgr.mr_n77938096)
print v(xbgr.mr_n77938416)
print v(xbgr.mr_n77938528)
print v(xbgr.mr_n77938848)
print v(xbgr.mr_n77938960)
print v(xbgr.mr_n77939280)
print v(xbgr.mr_n77939392)
print v(xbgr.mr_n77939712)
print v(xbgr.mr_n77939824)
print v(xbgr.mr_n77940144)
print v(xbgr.mr_n77940256)
print v(xbgr.mr_n77940576)
print v(xbgr.mr_n77940688)
print v(xbgr.mr_n77941008)
print v(xbgr.mr_n77941120)
print v(xbgr.mr_n77941440)
print v(xbgr.mr_n77941552)
print v(xbgr.mr_n77941872)
print v(xbgr.mr_n77941984)
print v(xbgr.mr_n77942304)
print v(xbgr.mr_n77942416)
print v(xbgr.mr_n77942736)
print v(xbgr.mr_n77942848)
print v(xbgr.mr_n77943168)
print v(xbgr.mr_n77943280)
print v(xbgr.mr_n77943600)
print v(xbgr.mr_n77943712)
print v(xbgr.mr_n77944032)
print v(xbgr.mr_n77944144)
print v(xbgr.mr_n77944464)
print v(xbgr.mr_n77944576)
print v(xbgr.mr_n77944896)
print v(xbgr.mr_n77945008)
print v(xbgr.mr_n77945328)
print v(xbgr.mr_n77945440)
print v(xbgr.mr_n77945760)
print v(xbgr.mr_n77945872)
print v(xbgr.mr_n77946192)
print v(xbgr.mr_n77946304)
print v(xbgr.mr_n77946624)
print v(xbgr.mr_n77946736)
print v(xbgr.mr_n77947056)
print v(xbgr.mr_n77947168)
print v(xbgr.mr_n77947488)
print v(xbgr.mr_n77947600)
print v(xbgr.mr_n77947920)
print v(xbgr.mr_n77948032)
print v(xbgr.mr_n77948352)
print v(xbgr.mr_n77948464)
print v(xbgr.mr_n77948784)
print v(xbgr.mr_n77949216)
print v(xbgr.mr_n77949328)
print v(xbgr.mr_n77949648)
print v(xbgr.mr_n77949760)
print v(xbgr.mr_n77950080)
print v(xbgr.mr_n77950192)
print v(xbgr.mr_n77950512)
print v(xbgr.mr_n77950944)
print v(xbgr.mr_n77951056)
print v(xbgr.mr_n77951376)
print v(xbgr.mr_n77951488)
print v(xbgr.mr_n77951808)
print v(xbgr.mr_n77951920)
print v(xbgr.mr_n77952240)
print v(xbgr.mr_n77952672)
print v(xbgr.mr_n77952784)
print v(xbgr.mr_n77953104)
print v(xbgr.mr_n77953216)
print v(xbgr.mr_n77953536)
print v(xbgr.mr_n77953648)
print v(xbgr.mr_n77953968)
print v(xbgr.mr_n77954080)
print v(xbgr.mr_n77954400)
print v(xbgr.mr_n77954512)
print v(xbgr.mr_n77954832)
print v(xbgr.mr_n77954944)
print v(xbgr.mr_n77955264)
print v(xbgr.mr_n77955376)
print v(xbgr.mr_n77955696)
print v(xbgr.mr_n77955808)
print v(xbgr.mr_n77956128)
print v(xbgr.mr_n77956240)
print v(xbgr.mr_n77956560)
print v(xbgr.mr_n77956672)
print v(xbgr.mr_n77956992)
print v(xbgr.mr_n77957104)
print v(xbgr.mr_n77957424)
print v(xbgr.mr_n77957536)
print v(xbgr.mr_n77957856)
print v(xbgr.mr_n77957968)
print v(xbgr.mr_n77958288)
print v(xbgr.mr_n77958400)
print v(xbgr.mr_n77958720)
print v(xbgr.mr_n77958832)
print v(xbgr.mr_n77959152)
print v(xbgr.mr_n77959264)
print v(xbgr.mr_n77959584)
print v(xbgr.mr_n77960016)
print v(xbgr.mr_n77960128)
print v(xbgr.mr_n77960448)
print v(xbgr.mr_n77960560)
print v(xbgr.mr_n77960880)
print v(xbgr.mr_n77960992)
print v(xbgr.mr_n77961312)
print v(xbgr.mr_n77961424)
print v(xbgr.mr_n77961744)
print v(xbgr.mr_n77961856)
print v(xbgr.mr_n77962176)
print v(xbgr.mr_n77962288)
print v(xbgr.mr_n77962608)
print v(xbgr.mr_n77962720)
print v(xbgr.mr_n77963040)
print v(xbgr.mr_n77963152)
print v(xbgr.mr_n77963472)
print v(xbgr.mr_n77963584)
print v(xbgr.mr_n77963904)
print v(xbgr.mr_n77964016)
print v(xbgr.mr_n77964336)
print v(xbgr.mr_n77964768)
print v(xbgr.mr_n77964880)
print v(xbgr.mr_n77965200)
print v(xbgr.mr_n77965632)
print v(xbgr.mr_n77965744)
print v(xbgr.mr_n77966064)
print v(xbgr.mr_n77966176)
print v(xbgr.mr_n77966496)
print v(xbgr.mr_n77966608)
print v(xbgr.mr_n77966928)
print v(xbgr.mr_n77967040)
print v(xbgr.mr_n77967360)
print v(xbgr.mr_n77967472)
print v(xbgr.mr_n77967792)
print v(xbgr.mr_n77968224)
print v(xbgr.mr_n77968336)
print v(xbgr.mr_n77968656)
print v(xbgr.mr_n77968768)
print v(xbgr.mr_n77969088)
print v(xbgr.mr_n77969200)
print v(xbgr.mr_n77973296)
print v(xbgr.mr_n77973408)
print v(xbgr.mr_n77973744)
print v(xbgr.mr_n77973856)
print v(xbgr.mr_n77974176)
print v(xbgr.mr_n77974288)
print v(xbgr.mr_n77974656)
print v(xbgr.mr_n77974768)
print v(xbgr.mr_n77975088)
print v(xbgr.mr_n77975200)
print v(xbgr.mr_n77975520)
print v(xbgr.mr_n77975872)
print v(xbgr.mr_n77975984)
print v(xbgr.mr_n77976304)
print v(xbgr.mr_n77976736)
print v(xbgr.mr_n77976848)
print v(xbgr.mr_n77977168)
print v(xbgr.mr_n77977280)
print v(xbgr.mr_n77977600)
print v(xbgr.mr_n77977712)
print v(xbgr.mr_n77978032)
print v(xbgr.mr_n77978144)
print v(xbgr.mr_n77978464)
print v(xbgr.mr_n77978576)
print v(xbgr.mr_n77978896)
print v(xbgr.mr_n77979328)
print v(xbgr.mr_n77979440)
print v(xbgr.mr_n77979760)
print v(xbgr.mr_n77980192)
print v(xbgr.mr_n77980304)
print v(xbgr.mr_n77980624)
print v(xbgr.mr_n77980736)
print v(xbgr.mr_n77981056)
print v(xbgr.mr_n77981168)
print v(xbgr.mr_n77981488)
print v(xbgr.mr_n77981600)
print v(xbgr.mr_n77981920)
print v(xbgr.mr_n77982032)
print v(xbgr.mr_n77982352)
print v(xbgr.mr_n77982464)
print v(xbgr.mr_n77982784)
print v(xbgr.mr_n77982896)
print v(xbgr.mr_n77983216)
print v(xbgr.mr_n77983648)
print v(xbgr.mr_n77983760)
print v(xbgr.mr_n77984080)
print v(xbgr.mr_n77984192)
print v(xbgr.mr_n77984512)
print v(xbgr.mr_n77984624)
print v(xbgr.mr_n77984944)
print v(xbgr.mr_n77985056)
print v(xbgr.mr_n77985376)
print v(xbgr.mr_n77985488)
print v(xbgr.mr_n77985808)
print v(xbgr.mr_n77985920)
print v(xbgr.mr_n77986240)
print v(xbgr.mr_n77986352)
print v(xbgr.mr_n77986672)
print v(xbgr.mr_n77987104)
print v(xbgr.mr_n77987216)
print v(xbgr.mr_n77987536)
print v(xbgr.mr_n77987968)
print v(xbgr.mr_n77988080)
print v(xbgr.mr_n77988400)
print v(xbgr.mr_n77988512)
print v(xbgr.mr_n77988832)
print v(xbgr.mr_n77988944)
print v(xbgr.mr_n77989264)
print v(xbgr.mr_n77989376)
print v(xbgr.mr_n77989696)
print v(xbgr.mr_n77989808)
print v(xbgr.mr_n77990128)
print v(xbgr.mr_n77990240)
print v(xbgr.mr_n77990560)
print v(xbgr.mr_n77990672)
print v(xbgr.mr_n77990992)
print v(xbgr.mr_n77991424)
print v(xbgr.mr_n77991536)
print v(xbgr.mr_n77991856)
print v(xbgr.mr_n77991968)
print v(xbgr.mr_n77992288)
print v(xbgr.mr_n77992400)
print v(xbgr.mr_n77992720)
print v(xbgr.mr_n77993152)
print v(xbgr.mr_n77993264)
print v(xbgr.mr_n77993584)
print v(xbgr.mr_n77993696)
print v(xbgr.mr_n77994016)
print v(xbgr.mr_n77994128)
print v(xbgr.mr_n77994448)
print v(xbgr.mr_n77994560)
print v(xbgr.mr_n77994880)
print v(xbgr.mr_n77994992)
print v(xbgr.mr_n77995312)
print v(xbgr.mr_n77995424)
print v(xbgr.mr_n77995744)
print v(xbgr.mr_n77995856)
print v(xbgr.mr_n77996176)
print v(xbgr.mr_n77996608)
print v(xbgr.mr_n77996720)
print v(xbgr.mr_n77997040)
print v(xbgr.mr_n77997152)
print v(xbgr.mr_n77997472)
print v(xbgr.mr_n77997584)
print v(xbgr.mr_n77997904)
print v(xbgr.mr_n77998336)
print v(xbgr.mr_n77998448)
print v(xbgr.mr_n77998768)
print v(xbgr.mr_n77998880)
print v(xbgr.mr_n77999200)
print v(xbgr.mr_n77999312)
print v(xbgr.mr_n77999632)
print v(xbgr.mr_n77999744)
print v(xbgr.mr_n78000064)
print v(xbgr.mr_n78000176)
print v(xbgr.mr_n78000496)
print v(xbgr.mr_n78000608)
print v(xbgr.mr_n78000928)
print v(xbgr.mr_n78001040)
print v(xbgr.mr_n78001360)
print v(xbgr.mr_n78001472)
print v(xbgr.mr_n78001792)
print v(xbgr.mr_n78001904)
print v(xbgr.mr_n78002224)
print v(xbgr.mr_n78002656)
print v(xbgr.mr_n78002768)
print v(xbgr.mr_n78003088)
print v(xbgr.mr_n78003200)
print v(xbgr.mr_n78003424)
print v(xbgr.mr_n78003792)
print v(xbgr.mr_n78003904)
print v(xbgr.mr_n78004160)
print v(xbgr.mr_n78004272)
print v(xbgr.mr_n78004528)
print v(xbgr.mr_n78004640)
print v(xbgr.mr_n78004896)
print v(xbgr.mr_n78005008)
print v(xbgr.mr_n78005264)
print v(xbgr.mr_n78005376)
print v(xbgr.mr_n78005632)
print v(xbgr.mr_n78006000)
print v(xbgr.mr_n78006112)
print v(xbgr.mr_n78006368)
print v(xbgr.mr_n78006736)
print v(xbgr.mr_n78006848)
print v(xbgr.mr_n78007104)
print v(xbgr.mr_n78007472)
print v(xbgr.mr_n78007584)
print v(xbgr.mr_n78007840)
print v(xbgr.mr_n78007952)
print v(xbgr.mr_n78008208)
print v(xbgr.mr_n78008320)
print v(xbgr.mr_n78008576)
print v(xbgr.mr_n78008944)
print v(xbgr.mr_n78009056)
print v(xbgr.mr_n78009312)
print v(xbgr.mr_n78009680)
print v(xbgr.mr_n78009792)
print v(xbgr.mr_n78010048)
print v(xbgr.mr_n78010416)
print v(xbgr.mr_n78010528)
print v(xbgr.mr_n78010784)
print v(xbgr.mr_n78010896)
print v(xbgr.mr_n78011152)
print v(xbgr.mr_n78011264)
print v(xbgr.mr_n78011520)
print v(xbgr.mr_n78011632)
print v(xbgr.mr_n78011888)
print v(xbgr.mr_n78012000)
print v(xbgr.mr_n78012256)
print v(xbgr.mr_n78012624)
print v(xbgr.mr_n78012736)
print v(xbgr.mr_n78012992)
print v(xbgr.mr_n78013104)
print v(xbgr.mr_n78013360)
print v(xbgr.mr_n78013472)
print v(xbgr.mr_n78013728)
print v(xbgr.mr_n78013840)
print v(xbgr.mr_n78014096)
print v(xbgr.mr_n78014208)
print v(xbgr.mr_n78014464)
print v(xbgr.mr_n78014832)
print v(xbgr.mr_n78014944)
print v(xbgr.mr_n78015200)
print v(xbgr.mr_n78015568)
print v(xbgr.mr_n78015680)
print v(xbgr.mr_n78015936)
print v(xbgr.mr_n78016048)
print v(xbgr.mr_n78016304)
print v(xbgr.mr_n78016416)
print v(xbgr.mr_n78016736)
print v(xbgr.mr_n78017168)
print v(xbgr.mr_n78017280)
print v(xbgr.mr_n78017600)
print v(xbgr.mr_n78018032)
print v(xbgr.mr_n78018144)
print v(xbgr.mr_n78018464)
print v(xbgr.mr_n78018576)
print v(xbgr.mr_n78018896)
print v(xbgr.mr_n78019008)
print v(xbgr.mr_n78019328)
print v(xbgr.mr_n78019440)
print v(xbgr.mr_n78019760)
print v(xbgr.mr_n78019872)
print v(xbgr.mr_n78020192)
print v(xbgr.mr_n78020304)
print v(xbgr.mr_n78020624)
print v(xbgr.mr_n78020736)
print v(xbgr.mr_n78021056)
print v(xbgr.mr_n78021488)
print v(xbgr.mr_n78021600)
print v(xbgr.mr_n78021920)
print v(xbgr.mr_n78022032)
print v(xbgr.mr_n78022352)
print v(xbgr.mr_n78022464)
print v(xbgr.mr_n78022784)
print v(xbgr.mr_n78022896)
print v(xbgr.mr_n78023216)
print v(xbgr.mr_n78023328)
print v(xbgr.mr_n78023648)
print v(xbgr.mr_n78024080)
print v(xbgr.mr_n78024192)
print v(xbgr.mr_n78024512)
print v(xbgr.mr_n78024944)
print v(xbgr.mr_n78025056)
print v(xbgr.mr_n78025376)
print v(xbgr.mr_n78025488)
print v(xbgr.mr_n78025808)
print v(xbgr.mr_n78025920)
print v(xbgr.mr_n78026240)
print v(xbgr.mr_n78026352)
print v(xbgr.mr_n78026672)
print v(xbgr.mr_n78026784)
print v(xbgr.mr_n78027104)
print v(xbgr.mr_n78027216)
print v(xbgr.mr_n78027536)
print v(xbgr.mr_n78027648)
print v(xbgr.mr_n78027968)
print v(xbgr.mr_n78028080)
print v(xbgr.mr_n78028400)
print v(xbgr.mr_n78028944)
print v(xbgr.mr_n78029376)
print v(xbgr.mr_n78029808)
print v(xbgr.mr_n78030240)
print v(xbgr.mr_n78030672)
print v(xbgr.mr_n78031104)
print v(xbgr.mr_n78031536)
print v(xbgr.mr_n78031968)
print v(xbgr.mr_n78032400)
print v(xbgr.mr_n78032832)
print v(xbgr.mr_n78033152)
print v(xbgr.mr_n78033584)
print v(xbgr.mr_n78034016)
print v(xbgr.mr_n78034448)
print v(xbgr.mr_n78034880)
print v(xbgr.mr_n78035312)
print v(xbgr.mr_n78035744)
print v(xbgr.mr_n78036176)
print v(xbgr.mr_n78036608)
print v(xbgr.mr_n78037040)
print v(xbgr.mr_n78037472)
print v(xbgr.mr_n78037904)
print v(xbgr.mr_n78038336)
print v(xbgr.mr_n78038768)
print v(xbgr.mr_n78039200)
print v(xbgr.mr_n78039632)
print v(xbgr.mr_n78040064)
print v(xbgr.mr_n78040496)
print v(xbgr.mr_n78040928)
print v(xbgr.mr_n78041360)
print v(xbgr.mr_n78041792)
print v(xbgr.mr_n78042224)
print v(xbgr.mr_n78042656)
print v(xbgr.mr_n78043088)
print v(xbgr.mr_n78043520)
print v(xbgr.mr_n78043952)
print v(xbgr.mr_n78044384)
print v(xbgr.mr_n78044816)
print v(xbgr.mr_n78045248)
print v(xbgr.mr_n78045680)
print v(xbgr.mr_n78046112)
print v(xbgr.mr_n78046544)
print v(xbgr.mr_n78046976)
print v(xbgr.mr_n78047408)
print v(xbgr.mr_n78047840)
print v(xbgr.mr_n78048272)
print v(xbgr.mr_n78048704)
print v(xbgr.mr_n78049136)
print v(xbgr.mr_n78049568)
print v(xbgr.mr_n78050000)
print v(xbgr.mr_n78050432)
print v(xbgr.mr_n78050864)
print v(xbgr.mr_n78051296)
print v(xbgr.mr_n78051728)
print v(xbgr.mr_n78052160)
print v(xbgr.mr_n78052592)
print v(xbgr.mr_n78053024)
print v(xbgr.mr_n78053456)
print v(xbgr.mr_n78054752)
print v(xbgr.mr_n78055184)
print v(xbgr.mr_n78055616)
print v(xbgr.mr_n78056048)
print v(xbgr.mr_n78056480)
print v(xbgr.mr_n78056912)
print v(xbgr.mr_n78057344)
print v(xbgr.mr_n78057776)
print v(xbgr.mr_n78058208)
print v(xbgr.mr_n78058640)
print v(xbgr.mr_n78059072)
print v(xbgr.mr_n78059504)
print v(xbgr.mr_n78061664)
print v(xbgr.mr_n78062096)
print v(xbgr.mr_n78062528)
print v(xbgr.mr_n78062960)
print v(xbgr.mr_n78063392)
print v(xbgr.mr_n78063824)
print v(xbgr.mr_n78064256)
print v(xbgr.mr_n78064688)
print v(xbgr.mr_n78065120)
print v(xbgr.mr_n78065552)
print v(xbgr.mr_n78066848)
print v(xbgr.mr_n78067280)
print v(xbgr.mr_n78067712)
print v(xbgr.mr_n78068144)
print v(xbgr.mr_n78068576)
print v(xbgr.mr_n78069008)
print v(xbgr.mr_n78069440)
print v(xbgr.mr_n78069872)
print v(xbgr.mr_n78070304)
print v(xbgr.mr_n78070736)
print v(xbgr.mr_n78071168)
print v(xbgr.mr_n78071600)
print v(xbgr.mr_n78072896)
print v(xbgr.mr_n78073328)
print v(xbgr.mr_n78074624)
print v(xbgr.mr_n78075056)
print v(xbgr.mr_n78075488)
print v(xbgr.mr_n78075920)
print v(xbgr.mr_n78076352)
print v(xbgr.mr_n78076784)
print v(xbgr.mr_n78077216)
print v(xbgr.mr_n78077648)
print v(xbgr.mr_n78078944)
print v(xbgr.mr_n78079376)
print v(xbgr.mr_n78079696)
print v(xbgr.mr_n78079808)
print v(xbgr.mr_n78080128)
print v(xbgr.mr_n78080240)
print v(xbgr.mr_n78080560)
print v(xbgr.mr_n78080672)
print v(xbgr.mr_n78080992)
print v(xbgr.mr_n78081104)
print v(xbgr.mr_n78081424)
print v(xbgr.mr_n78081536)
print v(xbgr.mr_n78081856)
print v(xbgr.mr_n78081968)
print v(xbgr.mr_n78082288)
print v(xbgr.mr_n78082400)
print v(xbgr.mr_n78082720)
print v(xbgr.mr_n78082832)
print v(xbgr.mr_n78083264)
print v(xbgr.mr_n78083696)
print v(xbgr.mr_n78084128)
print v(xbgr.mr_n78084560)
print v(xbgr.mr_n78084992)
print v(xbgr.mr_n78085424)
print v(xbgr.mr_n78085856)
print v(xbgr.mr_n78086288)
print v(xbgr.mr_n78086720)
print v(xbgr.mr_n78087152)
print v(xbgr.mr_n78087584)
print v(xbgr.mr_n78088016)
print v(xbgr.mr_n78088448)
print v(xbgr.mr_n78088880)
print v(xbgr.mr_n78089312)
print v(xbgr.mr_n78089744)
print v(xbgr.mr_n78090176)
print v(xbgr.mr_n78090608)
print v(xbgr.mr_n78091040)
print v(xbgr.mr_n78091472)
print v(xbgr.mr_n78091904)
print v(xbgr.mr_n78092336)
print v(xbgr.mr_n78092768)
print v(xbgr.mr_n78093200)
print v(xbgr.mr_n78093632)
print v(xbgr.mr_n78094064)
print v(xbgr.mr_n78094704)
print v(xbgr.mr_n78095136)
print v(xbgr.mr_n78095568)
print v(xbgr.mr_n78096000)
print v(xbgr.mr_n78096432)
print v(xbgr.mr_n78096864)
print v(xbgr.mr_n78097296)
print v(xbgr.mr_n78097728)
print v(xbgr.mr_n78098160)
print v(xbgr.mr_n78098592)
print v(xbgr.mr_n78099024)
print v(xbgr.mr_n78099456)
print v(xbgr.mr_n78099888)
print v(xbgr.mr_n78100320)
print v(xbgr.mr_n78100752)
print v(xbgr.mr_n78101184)
print v(xbgr.mr_n78101616)
print v(xbgr.mr_n78102048)
print v(xbgr.mr_n78102480)
print v(xbgr.mr_n78102912)
print v(xbgr.mr_n78103344)
print v(xbgr.mr_n78103776)
print v(xbgr.mr_n78104208)
print v(xbgr.mr_n78104640)
print v(xbgr.mr_n78105072)
print v(xbgr.mr_n78105504)
print v(xbgr.mr_n78105936)
print v(xbgr.mr_n78106368)
print v(xbgr.mr_n78106800)
print v(xbgr.mr_n78107232)
print v(xbgr.mr_n78107664)
print v(xbgr.mr_n78108096)
print v(xbgr.mr_n78108528)
print v(xbgr.mr_n78108960)
print v(xbgr.mr_n78109392)
print v(xbgr.mr_n78109824)
print v(xbgr.mr_n78110256)
print v(xbgr.mr_n78110688)
print v(xbgr.mr_n78111120)
print v(xbgr.mr_n78111552)
print v(xbgr.mr_n78111984)
print v(xbgr.mr_n78112416)
print v(xbgr.mr_n78112848)
print v(xbgr.mr_n78113280)
print v(xbgr.mr_n78113712)
print v(xbgr.mr_n78114144)
print v(xbgr.mr_n78114576)
print v(xbgr.mr_n78115008)
print v(xbgr.mr_n78115440)
print v(xbgr.mr_n78115872)
print v(xbgr.mr_n78116304)
print v(xbgr.mr_n78116736)
print v(xbgr.mr_n78117168)
print v(xbgr.mr_n78117600)
print v(xbgr.mr_n78118032)
print v(xbgr.mr_n78118464)
print v(xbgr.mr_n78118896)
print v(xbgr.mr_n78119328)
print v(xbgr.mr_n78119760)
print v(xbgr.mr_n78120192)
print v(xbgr.mr_n78120624)
print v(xbgr.mr_n78121056)
print v(xbgr.mr_n78121488)
print v(xbgr.mr_n78121920)
print v(xbgr.mr_n78122352)
print v(xbgr.mr_n78122784)
print v(xbgr.mr_n78123216)
print v(xbgr.mr_n78123648)
print v(xbgr.mr_n78124080)
print v(xbgr.mr_n78124512)
print v(xbgr.mr_n78124944)
print v(xbgr.mr_n78125376)
print v(xbgr.mr_n78125808)
print v(xbgr.mr_n78126240)
print v(xbgr.mr_n78126672)
print v(xbgr.mr_n78127104)
print v(xbgr.mr_n78127536)
print v(xbgr.mr_n78127968)
print v(xbgr.mr_n78128400)
print v(xbgr.mr_n78128832)
print v(xbgr.mr_n78129264)
print v(xbgr.mr_n78129696)
print v(xbgr.mr_n78130128)
print v(xbgr.mr_n78130560)
print v(xbgr.mr_n78130992)
print v(xbgr.mr_n78131312)
print v(xbgr.mr_n78131424)
print v(xbgr.mr_n78131744)
print v(xbgr.mr_n78131856)
print v(xbgr.mr_n78132176)
print v(xbgr.mr_n78132288)
print v(xbgr.mr_n78132608)
print v(xbgr.mr_n78132720)
print v(xbgr.mr_n78133152)
print v(xbgr.mr_n78133584)
print v(xbgr.mr_n78134016)
print v(xbgr.mr_n78134448)
print v(xbgr.mr_n78134880)
print v(xbgr.mr_n78135312)
print v(xbgr.mr_n78135744)
print v(xbgr.mr_n78136176)
print v(xbgr.mr_n78136608)
print v(xbgr.mr_n78137040)
print v(xbgr.mr_n78137472)
print v(xbgr.mr_n78137904)
print v(xbgr.mr_n78138336)
print v(xbgr.mr_n78138768)
print v(xbgr.mr_n78139200)
print v(xbgr.mr_n78139632)
print v(xbgr.mr_n78140064)
print v(xbgr.mr_n78140496)
print v(xbgr.mr_n78140928)
print v(xbgr.mr_n78141360)
print v(xbgr.mr_n78141792)
print v(xbgr.mr_n78142224)
print v(xbgr.mr_n78142656)
print v(xbgr.mr_n78143088)
print v(xbgr.mr_n78143520)
print v(xbgr.mr_n78143952)
print v(xbgr.mr_n78144384)
print v(xbgr.mr_n78144816)
print v(xbgr.mr_n78145248)
print v(xbgr.mr_n78145680)
print v(xbgr.mr_n78146112)
print v(xbgr.mr_n78146544)
print v(xbgr.mr_n78146976)
print v(xbgr.mr_n78147408)
print v(xbgr.mr_n78147840)
print v(xbgr.mr_n78148272)
print v(xbgr.mr_n78148704)
print v(xbgr.mr_n78149136)
print v(xbgr.mr_n78149568)
print v(xbgr.mr_n78150000)
print v(xbgr.mr_n78150432)
print v(xbgr.mr_n78150864)
print v(xbgr.mr_n78151296)
print v(xbgr.mr_n78151728)
print v(xbgr.mr_n78152160)
print v(xbgr.mr_n78152592)
print v(xbgr.mr_n78153024)
print v(xbgr.mr_n78153456)
print v(xbgr.mr_n78153888)
print v(xbgr.mr_n78154320)
print v(xbgr.mr_n78154752)
print v(xbgr.mr_n78155184)
print v(xbgr.mr_n78155616)
print v(xbgr.mr_n78156048)
print v(xbgr.mr_n78156480)
print v(xbgr.mr_n78156912)
print v(xbgr.mr_n78157344)
print v(xbgr.mr_n78157776)
print v(xbgr.mr_n78158208)
print v(xbgr.mr_n78158640)
print v(xbgr.mr_n78159072)
print v(xbgr.mr_n78159504)
print v(xbgr.mr_n78159936)
print v(xbgr.mr_n78160368)
print v(xbgr.mr_n78161664)
print v(xbgr.mr_n78162096)
print v(xbgr.mr_n78163392)
print v(xbgr.mr_n78163824)
print v(xbgr.mr_n78165120)
print v(xbgr.mr_n78165552)
print v(xbgr.mr_n78165984)
print v(xbgr.mr_n78166416)
print v(xbgr.mr_n78166848)
print v(xbgr.mr_n78167280)
print v(xbgr.mr_n78167712)
print v(xbgr.mr_n78168144)
print v(xbgr.mr_n78168576)
print v(xbgr.mr_n78169008)
print v(xbgr.mr_n78169440)
print v(xbgr.mr_n78169872)
print v(xbgr.mr_n78170304)
print v(xbgr.mr_n78170736)
print v(xbgr.mr_n78171168)
print v(xbgr.mr_n78171600)
print v(xbgr.mr_n78172896)
print v(xbgr.mr_n78173328)
print v(xbgr.mr_n78173760)
print v(xbgr.mr_n78174192)
print v(xbgr.mr_n78174624)
print v(xbgr.mr_n78175056)
print v(xbgr.mr_n78176352)
print v(xbgr.mr_n78176784)
print v(xbgr.mr_n78177216)
print v(xbgr.mr_n78177648)
print v(xbgr.mr_n78178080)
print v(xbgr.mr_n78178512)
print v(xbgr.mr_n78178944)
print v(xbgr.mr_n78179376)
print v(xbgr.mr_n78179808)
print v(xbgr.mr_n78180240)
print v(xbgr.mr_n78180672)
print v(xbgr.mr_n78181104)
print v(xbgr.mr_n78181536)
print v(xbgr.mr_n78181968)
print v(xbgr.mr_n78182400)
print v(xbgr.mr_n78182832)
print v(xbgr.mr_n78183264)
print v(xbgr.mr_n78183696)
print v(xbgr.mr_n78184128)
print v(xbgr.mr_n78184560)
print v(xbgr.mr_n78184992)
print v(xbgr.mr_n78185424)
print v(xbgr.mr_n78185856)
print v(xbgr.mr_n78186288)
print v(xbgr.mr_n78186720)
print v(xbgr.mr_n78187152)
print v(xbgr.mr_n78187584)
print v(xbgr.mr_n78188016)
print v(xbgr.mr_n78188448)
print v(xbgr.mr_n78188880)
print v(xbgr.mr_n78189312)
print v(xbgr.mr_n78189744)
print v(xbgr.mr_n78190176)
print v(xbgr.mr_n78190608)
print v(xbgr.mr_n78191040)
print v(xbgr.mr_n78191472)
print v(xbgr.mr_n78191904)
print v(xbgr.mr_n78192336)
print v(xbgr.mr_n78192768)
print v(xbgr.mr_n78193200)
print v(xbgr.mr_n78193632)
print v(xbgr.mr_n78194064)
print v(xbgr.mr_n78194496)
print v(xbgr.mr_n78194928)
print v(xbgr.mr_n78195360)
print v(xbgr.mr_n78195792)
print v(xbgr.mr_n78196224)
print v(xbgr.mr_n78196656)
print v(xbgr.mr_n78197088)
print v(xbgr.mr_n78197520)
print v(xbgr.mr_n78197952)
print v(xbgr.mr_n78198384)
print v(xbgr.mr_n78198816)
print v(xbgr.mr_n78199248)
print v(xbgr.mr_n78199680)
print v(xbgr.mr_n78200112)
print v(xbgr.mr_n78200544)
print v(xbgr.mr_n78200864)
print v(xbgr.mr_n78200976)
print v(xbgr.mr_n78201296)
print v(xbgr.mr_n78201408)
print v(xbgr.mr_n78201728)
print v(xbgr.mr_n78201840)
print v(xbgr.mr_n78202160)
print v(xbgr.mr_n78202272)
print v(xbgr.mr_n78202592)
print v(xbgr.mr_n78202704)
print v(xbgr.mr_n78203024)
print v(xbgr.mr_n78203136)
print v(xbgr.mr_n78203456)
print v(xbgr.mr_n78203568)
print v(xbgr.mr_n78203888)
print v(xbgr.mr_n78204000)
print v(xbgr.mr_n78204320)
print v(xbgr.mr_n78204432)
print v(xbgr.mr_n78204752)
print v(xbgr.mr_n78204864)
print v(xbgr.mr_n78205184)
print v(xbgr.mr_n78205296)
print v(xbgr.mr_n78205616)
print v(xbgr.mr_n78205728)
print v(xbgr.mr_n78206048)
print v(xbgr.mr_n78206160)
print v(xbgr.mr_n78206480)
print v(xbgr.mr_n78206592)
print v(xbgr.mr_n78206912)
print v(xbgr.mr_n78207024)
print v(xbgr.mr_n78207344)
print v(xbgr.mr_n78207456)
print v(xbgr.mr_n78207776)
print v(xbgr.mr_n78207888)
print v(xbgr.mr_n78208208)
print v(xbgr.mr_n78208320)
print v(xbgr.mr_n78208640)
print v(xbgr.mr_n78208752)
print v(xbgr.mr_n78209072)
print v(xbgr.mr_n78209184)
print v(xbgr.mr_n78209504)
print v(xbgr.mr_n78209616)
print v(xbgr.mr_n78209936)
print v(xbgr.mr_n78210048)
print v(xbgr.mr_n78210368)
print v(xbgr.mr_n78210480)
print v(xbgr.mr_n78210800)
print v(xbgr.mr_n78210912)
print v(xbgr.mr_n78211232)
print v(xbgr.mr_n78211344)
print v(xbgr.mr_n78211664)
print v(xbgr.mr_n78211776)
print v(xbgr.mr_n78212096)
print v(xbgr.mr_n78212208)
print v(xbgr.mr_n78212528)
print v(xbgr.mr_n78212640)
print v(xbgr.mr_n78212960)
print v(xbgr.mr_n78213072)
print v(xbgr.mr_n78213392)
print v(xbgr.mr_n78213504)
print v(xbgr.mr_n78213824)
print v(xbgr.mr_n78213936)
print v(xbgr.mr_n78214256)
print v(xbgr.mr_n78214368)
print v(xbgr.mr_n78214688)
print v(xbgr.mr_n78214800)
print v(xbgr.mr_n78215120)
print v(xbgr.mr_n78215232)
print v(xbgr.mr_n78215552)
print v(xbgr.mr_n78215664)
print v(xbgr.mr_n78215984)
print v(xbgr.mr_n78216096)
print v(xbgr.mr_n78216416)
print v(xbgr.mr_n78216528)
print v(xbgr.mr_n78216848)
print v(xbgr.mr_n78216960)
print v(xbgr.mr_n78217376)
print v(xbgr.mr_n78217808)
print v(xbgr.mr_n78218240)
print v(xbgr.mr_n78218672)
print v(xbgr.mr_n78219104)
print v(xbgr.mr_n78219536)
print v(xbgr.mr_n78219968)
print v(xbgr.mr_n78220400)
print v(xbgr.mr_n78220832)
print v(xbgr.mr_n78221264)
print v(xbgr.mr_n78221696)
print v(xbgr.mr_n78222128)
print v(xbgr.mr_n78222448)
print v(xbgr.mr_n78222560)
print v(xbgr.mr_n78222880)
print v(xbgr.mr_n78222992)
print v(xbgr.mr_n78223424)
print v(xbgr.mr_n78223856)
print v(xbgr.mr_n78224288)
print v(xbgr.mr_n78224720)
print v(xbgr.mr_n78225152)
print v(xbgr.mr_n78225584)
print v(xbgr.mr_n78226016)
print v(xbgr.mr_n78226448)
print v(xbgr.mr_n78226880)
print v(xbgr.mr_n78227312)
print v(xbgr.mr_n78227744)
print v(xbgr.mr_n78228176)
print v(xbgr.mr_n78228608)
print v(xbgr.mr_n78229040)
print v(xbgr.mr_n78229472)
print v(xbgr.mr_n78229904)
print v(xbgr.mr_n78230336)
print v(xbgr.mr_n78230768)
print v(xbgr.mr_n78231200)
print v(xbgr.mr_n78231632)
print v(xbgr.mr_n78232064)
print v(xbgr.mr_n78232496)
print v(xbgr.mr_n78232928)
print v(xbgr.mr_n78233360)
print v(xbgr.mr_n78233792)
print v(xbgr.mr_n78234224)
print v(xbgr.mr_n78234656)
print v(xbgr.mr_n78235088)
print v(xbgr.mr_n78235520)
print v(xbgr.mr_n78235952)
print v(xbgr.mr_n78236384)
print v(xbgr.mr_n78236816)
print v(xbgr.mr_n78237248)
print v(xbgr.mr_n78237680)
print v(xbgr.mr_n78238112)
print v(xbgr.mr_n78238544)
print v(xbgr.mr_n78238976)
print v(xbgr.mr_n78239408)
print v(xbgr.mr_n78239840)
print v(xbgr.mr_n78240272)
print v(xbgr.mr_n78240592)
print v(xbgr.mr_n78240704)
print v(xbgr.mr_n78241024)
print v(xbgr.mr_n78241136)
print v(xbgr.mr_n78241568)
print v(xbgr.mr_n78241888)
print v(xbgr.mr_n78242000)
print v(xbgr.mr_n78242432)
print v(xbgr.mr_n78242864)
print v(xbgr.mr_n78243296)
print v(xbgr.mr_n78243728)
print v(xbgr.mr_n78244160)
print v(xbgr.mr_n78244592)
print v(xbgr.mr_n78245024)
print v(xbgr.mr_n78245456)
print v(xbgr.mr_n78245888)
print v(xbgr.mr_n78246320)
print v(xbgr.mr_n78246752)
print v(xbgr.mr_n78247184)
print v(xbgr.mr_n78247616)
print v(xbgr.mr_n78248048)
print v(xbgr.mr_n78248480)
print v(xbgr.mr_n78248912)
print v(xbgr.mr_n78249344)
print v(xbgr.mr_n78249776)
print v(xbgr.mr_n78250208)
print v(xbgr.mr_n78250640)
print v(xbgr.mr_n78251072)
print v(xbgr.mr_n78251504)
print v(xbgr.mr_n78251936)
print v(xbgr.mr_n78252368)
print v(xbgr.mr_n78252800)
print v(xbgr.mr_n78253232)
print v(xbgr.mr_n78253664)
print v(xbgr.mr_n78254096)
print v(xbgr.mr_n78254528)
print v(xbgr.mr_n78254960)
print v(xbgr.mr_n78255392)
print v(xbgr.mr_n78255824)
print v(xbgr.mr_n78256256)
print v(xbgr.mr_n78256688)
print v(xbgr.mr_n78257120)
print v(xbgr.mr_n78257552)
print v(xbgr.mr_n78257984)
print v(xbgr.mr_n78258416)
print v(xbgr.mr_n78258848)
print v(xbgr.mr_n78259280)
print v(xbgr.mr_n78259712)
print v(xbgr.mr_n78260144)
print v(xbgr.mr_n78260576)
print v(xbgr.mr_n78261008)
print v(xbgr.mr_n78261440)
print v(xbgr.mr_n78261872)
print v(xbgr.mr_n78262304)
print v(xbgr.mr_n78262624)
print v(xbgr.mr_n78262736)
print v(xbgr.mr_n78263168)
print v(xbgr.mr_n78263600)
print v(xbgr.mr_n78263920)
print v(xbgr.mr_n78264032)
print v(xbgr.mr_n78264352)
print v(xbgr.mr_n78264464)
print v(xbgr.mr_n78264784)
print v(xbgr.mr_n78264896)
print v(xbgr.mr_n78265216)
print v(xbgr.mr_n78265328)
print v(xbgr.mr_n78265648)
print v(xbgr.mr_n78265760)
print v(xbgr.mr_n78266080)
print v(xbgr.mr_n78266192)
print v(xbgr.mr_n78266624)
print v(xbgr.mr_n78266944)
print v(xbgr.mr_n78267056)
print v(xbgr.mr_n78267376)
print v(xbgr.mr_n78267488)
print v(xbgr.mr_n78267808)
print v(xbgr.mr_n78267920)
print v(xbgr.mr_n78268240)
print v(xbgr.mr_n78268352)
print v(xbgr.mr_n78268672)
print v(xbgr.mr_n78268784)
print v(xbgr.mr_n78269104)
print v(xbgr.mr_n78269216)
print v(xbgr.mr_n78269648)
print v(xbgr.mr_n78269968)
print v(xbgr.mr_n78270080)
print v(xbgr.mr_n78270400)
print v(xbgr.mr_n78270512)
print v(xbgr.mr_n78270832)
print v(xbgr.mr_n78270944)
print v(xbgr.mr_n78271264)
print v(xbgr.mr_n78271376)
print v(xbgr.mr_n78271696)
print v(xbgr.mr_n78271808)
print v(xbgr.mr_n78272128)
print v(xbgr.mr_n78272240)
print v(xbgr.mr_n78272672)
print v(xbgr.mr_n78272992)
print v(xbgr.mr_n78273104)
print v(xbgr.mr_n78273424)
print v(xbgr.mr_n78273536)
print v(xbgr.mr_n78273856)
print v(xbgr.mr_n78273968)
print v(xbgr.mr_n78274400)
print v(xbgr.mr_n78274720)
print v(xbgr.mr_n78274832)
print v(xbgr.mr_n78275264)
print v(xbgr.mr_n78275696)
print v(xbgr.mr_n78276128)
print v(xbgr.mr_n78276560)
print v(xbgr.mr_n78277856)
print v(xbgr.mr_n78278288)
print v(xbgr.mr_n78279584)
print v(xbgr.mr_n78280016)
print v(xbgr.mr_n78280336)
print v(xbgr.mr_n78280448)
print v(xbgr.mr_n78280768)
print v(xbgr.mr_n78280880)
print v(xbgr.mr_n78281200)
print v(xbgr.mr_n78281312)
print v(xbgr.mr_n78281632)
print v(xbgr.mr_n78282176)
print v(xbgr.mr_n78282928)
print v(xbgr.mr_n78283040)
print v(xbgr.mr_n78283360)
print v(xbgr.mr_n78285632)
print v(xbgr.mr_n78286496)
print v(xbgr.mr_n78287360)
print v(xbgr.mr_n78287792)
print v(xbgr.mr_n78288224)
print v(xbgr.mr_n78288656)
print v(xbgr.mr_n78290704)
print v(xbgr.mr_n78290816)
print v(xbgr.mr_n78291248)
print v(xbgr.mr_n78291568)
print v(xbgr.mr_n78291680)
print v(xbgr.mr_n78292000)
print v(xbgr.mr_n78292112)
print v(xbgr.mr_n78292544)
print v(xbgr.mr_n78292864)
print v(xbgr.mr_n78292976)
print v(xbgr.mr_n78293296)
print v(xbgr.mr_n78293408)
print v(xbgr.mr_n78293728)
print v(xbgr.mr_n78293840)
print v(xbgr.mr_n78294272)
print v(xbgr.mr_n78294592)
print v(xbgr.mr_n78294704)
print v(xbgr.mr_n78295024)
print v(xbgr.mr_n78295136)
print v(xbgr.mr_n78295456)
print v(xbgr.mr_n78295568)
print v(xbgr.mr_n78296000)
print v(xbgr.mr_n78296320)
print v(xbgr.mr_n78296432)
print v(xbgr.mr_n78296752)
print v(xbgr.mr_n78296864)
print v(xbgr.mr_n78297184)
print v(xbgr.mr_n78297296)
print v(xbgr.mr_n78297616)
print v(xbgr.mr_n78297728)
print v(xbgr.mr_n78298048)
print v(xbgr.mr_n78298160)
print v(xbgr.mr_n78298592)
print v(xbgr.mr_n78298912)
print v(xbgr.mr_n78299024)
print v(xbgr.mr_n78299344)
print v(xbgr.mr_n78299456)
print v(xbgr.mr_n78299776)
print v(xbgr.mr_n78299888)
print v(xbgr.mr_n78300208)
print v(xbgr.mr_n78300320)
print v(xbgr.mr_n78300752)
print v(xbgr.mr_n78301072)
print v(xbgr.mr_n78301184)
print v(xbgr.mr_n78301504)
print v(xbgr.mr_n78301616)
print v(xbgr.mr_n78302048)
print v(xbgr.mr_n78302368)
print v(xbgr.mr_n78302480)
print v(xbgr.mr_n78302800)
print v(xbgr.mr_n78302912)
print v(xbgr.mr_n78303232)
print v(xbgr.mr_n78303344)
print v(xbgr.mr_n78303776)
print v(xbgr.mr_n78304096)
print v(xbgr.mr_n78304208)
print v(xbgr.mr_n78304528)
print v(xbgr.mr_n78304640)
print v(xbgr.mr_n78304960)
print v(xbgr.mr_n78305072)
print v(xbgr.mr_n78305504)
print v(xbgr.mr_n78305824)
print v(xbgr.mr_n78305936)
print v(xbgr.mr_n78306256)
print v(xbgr.mr_n78306368)
print v(xbgr.mr_n78306688)
print v(xbgr.mr_n78306800)
print v(xbgr.mr_n78307120)
print v(xbgr.mr_n78307232)
print v(xbgr.mr_n78307552)
print v(xbgr.mr_n78307664)
print v(xbgr.mr_n78307984)
print v(xbgr.mr_n78308096)
print v(xbgr.mr_n78308416)
print v(xbgr.mr_n78308528)
print v(xbgr.mr_n78308848)
print v(xbgr.mr_n78308960)
print v(xbgr.mr_n78309280)
print v(xbgr.mr_n78309392)
print v(xbgr.mr_n78309712)
print v(xbgr.mr_n78309824)
print v(xbgr.mr_n78310144)
print v(xbgr.mr_n78310256)
print v(xbgr.mr_n78310576)
print v(xbgr.mr_n78310688)
print v(xbgr.mr_n78311008)
print v(xbgr.mr_n78311120)
print v(xbgr.mr_n78311552)
print v(xbgr.mr_n78311872)
print v(xbgr.mr_n78311984)
print v(xbgr.mr_n78312304)
print v(xbgr.mr_n78312416)
print v(xbgr.mr_n78312736)
print v(xbgr.mr_n78312848)
print v(xbgr.mr_n78313168)
print v(xbgr.mr_n78313280)
print v(xbgr.mr_n78313600)
print v(xbgr.mr_n78313712)
print v(xbgr.mr_n78314032)
print v(xbgr.mr_n78314144)
print v(xbgr.mr_n78314464)
print v(xbgr.mr_n78314576)
print v(xbgr.mr_n78314896)
print v(xbgr.mr_n78315008)
print v(xbgr.mr_n78315328)
print v(xbgr.mr_n78315440)
print v(xbgr.mr_n78315760)
print v(xbgr.mr_n78315872)
print v(xbgr.mr_n78316304)
print v(xbgr.mr_n78316624)
print v(xbgr.mr_n78316736)
print v(xbgr.mr_n78317056)
print v(xbgr.mr_n78317168)
print v(xbgr.mr_n78317488)
print v(xbgr.mr_n78317600)
print v(xbgr.mr_n78317920)
print v(xbgr.mr_n78318032)
print v(xbgr.mr_n78318352)
print v(xbgr.mr_n78318464)
print v(xbgr.mr_n78318784)
print v(xbgr.mr_n78318896)
print v(xbgr.mr_n78319216)
print v(xbgr.mr_n78319328)
print v(xbgr.mr_n78319648)
print v(xbgr.mr_n78319760)
print v(xbgr.mr_n78320080)
print v(xbgr.mr_n78320192)
print v(xbgr.mr_n78320512)
print v(xbgr.mr_n78320624)
print v(xbgr.mr_n78320944)
print v(xbgr.mr_n78321056)
print v(xbgr.mr_n78321376)
print v(xbgr.mr_n78321488)
print v(xbgr.mr_n78321808)
print v(xbgr.mr_n78321920)
print v(xbgr.mr_n78322240)
print v(xbgr.mr_n78322352)
print v(xbgr.mr_n78322672)
print v(xbgr.mr_n78322784)
print v(xbgr.mr_n78323104)
print v(xbgr.mr_n78323216)
print v(xbgr.mr_n78323648)
print v(xbgr.mr_n78323968)
print v(xbgr.mr_n78324080)
print v(xbgr.mr_n78324400)
print v(xbgr.mr_n78324512)
print v(xbgr.mr_n78324832)
print v(xbgr.mr_n78324944)
print v(xbgr.mr_n78325264)
print v(xbgr.mr_n78325376)
print v(xbgr.mr_n78325696)
print v(xbgr.mr_n78325808)
print v(xbgr.mr_n78326128)
print v(xbgr.mr_n78326240)
print v(xbgr.mr_n78326560)
print v(xbgr.mr_n78326672)
print v(xbgr.mr_n78326992)
print v(xbgr.mr_n78327104)
print v(xbgr.mr_n78327424)
print v(xbgr.mr_n78327536)
print v(xbgr.mr_n78327856)
print v(xbgr.mr_n78327968)
print v(xbgr.mr_n78328288)
print v(xbgr.mr_n78328400)
print v(xbgr.mr_n78328720)
print v(xbgr.mr_n78328832)
print v(xbgr.mr_n78329264)
print v(xbgr.mr_n78329584)
print v(xbgr.mr_n78329696)
print v(xbgr.mr_n78330016)
print v(xbgr.mr_n78330128)
print v(xbgr.mr_n78330448)
print v(xbgr.mr_n78330560)
print v(xbgr.mr_n78330880)
print v(xbgr.mr_n78330992)
print v(xbgr.mr_n78331312)
print v(xbgr.mr_n78331424)
print v(xbgr.mr_n78331744)
print v(xbgr.mr_n78331856)
print v(xbgr.mr_n78332176)
print v(xbgr.mr_n78332288)
print v(xbgr.mr_n78332608)
print v(xbgr.mr_n78332720)
print v(xbgr.mr_n78333040)
print v(xbgr.mr_n78333152)
print v(xbgr.mr_n78333472)
print v(xbgr.mr_n78333584)
print v(xbgr.mr_n78333904)
print v(xbgr.mr_n78334016)
print v(xbgr.mr_n78334336)
print v(xbgr.mr_n78334448)
print v(xbgr.mr_n78334768)
print v(xbgr.mr_n78334880)
print v(xbgr.mr_n78335200)
print v(xbgr.mr_n78335312)
print v(xbgr.mr_n78335632)
print v(xbgr.mr_n78335744)
print v(xbgr.mr_n78336064)
print v(xbgr.mr_n78336176)
print v(xbgr.mr_n78336496)
print v(xbgr.mr_n78336608)
print v(xbgr.mr_n78336928)
print v(xbgr.mr_n78337040)
print v(xbgr.mr_n78337360)
print v(xbgr.mr_n78337472)
print v(xbgr.mr_n78337792)
print v(xbgr.mr_n78337904)
print v(xbgr.mr_n78338336)
print v(xbgr.mr_n78338656)
print v(xbgr.mr_n78338768)
print v(xbgr.mr_n78339088)
print v(xbgr.mr_n78339200)
print v(xbgr.mr_n78339520)
print v(xbgr.mr_n78339632)
print v(xbgr.mr_n78339952)
print v(xbgr.mr_n78340064)
print v(xbgr.mr_n78340384)
print v(xbgr.mr_n78340496)
print v(xbgr.mr_n78340816)
print v(xbgr.mr_n78340928)
print v(xbgr.mr_n78341248)
print v(xbgr.mr_n78341360)
print v(xbgr.mr_n78341680)
print v(xbgr.mr_n78341792)
print v(xbgr.mr_n78342112)
print v(xbgr.mr_n78342224)
print v(xbgr.mr_n78342544)
print v(xbgr.mr_n78342656)
print v(xbgr.mr_n78342976)
print v(xbgr.mr_n78343088)
print v(xbgr.mr_n78343408)
print v(xbgr.mr_n78343520)
print v(xbgr.mr_n78343840)
print v(xbgr.mr_n78343952)
print v(xbgr.mr_n78344272)
print v(xbgr.mr_n78344384)
print v(xbgr.mr_n78344704)
print v(xbgr.mr_n78344816)
print v(xbgr.mr_n78345136)
print v(xbgr.mr_n78345248)
print v(xbgr.mr_n78345568)
print v(xbgr.mr_n78345680)
print v(xbgr.mr_n78346000)
print v(xbgr.mr_n78346112)
print v(xbgr.mr_n78346432)
print v(xbgr.mr_n78346544)
print v(xbgr.mr_n78346864)
print v(xbgr.mr_n78346976)
print v(xbgr.mr_n78347296)
print v(xbgr.mr_n78347408)
print v(xbgr.mr_n78347728)
print v(xbgr.mr_n78347840)
print v(xbgr.mr_n78348272)
print v(xbgr.mr_n78348592)
print v(xbgr.mr_n78348704)
print v(xbgr.mr_n78349024)
print v(xbgr.mr_n78349136)
print v(xbgr.mr_n78349456)
print v(xbgr.mr_n78349568)
print v(xbgr.mr_n78349888)
print v(xbgr.mr_n78350000)
print v(xbgr.mr_n78350320)
print v(xbgr.mr_n78350432)
print v(xbgr.mr_n78350752)
print v(xbgr.mr_n78350864)
print v(xbgr.mr_n78351184)
print v(xbgr.mr_n78351296)
print v(xbgr.mr_n78351616)
print v(xbgr.mr_n78351728)
print v(xbgr.mr_n78352048)
print v(xbgr.mr_n78352160)
print v(xbgr.mr_n78352480)
print v(xbgr.mr_n78352592)
print v(xbgr.mr_n78352912)
print v(xbgr.mr_n78353024)
print v(xbgr.mr_n78353344)
print v(xbgr.mr_n78353456)
print v(xbgr.mr_n78353888)
print v(xbgr.mr_n78354320)
print v(xbgr.mr_n78354752)
print v(xbgr.mr_n78355184)
print v(xbgr.mr_n78355616)
print v(xbgr.mr_n78356048)
print v(xbgr.mr_n78356480)
print v(xbgr.mr_n78356912)
print v(xbgr.mr_n78357344)
print v(xbgr.mr_n78357776)
print v(xbgr.mr_n78358208)
print v(xbgr.mr_n78358640)
print v(xbgr.mr_n78359072)
print v(xbgr.mr_n78359504)
print v(xbgr.mr_n78359936)
print v(xbgr.mr_n78360368)
print v(xbgr.mr_n78360800)
print v(xbgr.mr_n78361232)
print v(xbgr.mr_n78361664)
print v(xbgr.mr_n78362096)
print v(xbgr.mr_n78362528)
print v(xbgr.mr_n78362960)
print v(xbgr.mr_n78363392)
print v(xbgr.mr_n78363824)
print v(xbgr.mr_n78364256)
print v(xbgr.mr_n78364688)
print v(xbgr.mr_n78365120)
print v(xbgr.mr_n78365552)
print v(xbgr.mr_n78365984)
print v(xbgr.mr_n78366416)
print v(xbgr.mr_n78366848)
print v(xbgr.mr_n78367280)
print v(xbgr.mr_n78367712)
print v(xbgr.mr_n78368144)
print v(xbgr.mr_n78368576)
print v(xbgr.mr_n78369008)
print v(xbgr.mr_n78369440)
print v(xbgr.mr_n78369872)
print v(xbgr.mr_n78370304)
print v(xbgr.mr_n78370736)
print v(xbgr.mr_n78371168)
print v(xbgr.mr_n78371600)
print v(xbgr.mr_n78372032)
print v(xbgr.mr_n78372464)
print v(xbgr.mr_n78372896)
print v(xbgr.mr_n78373328)
print v(xbgr.mr_n78373760)
print v(xbgr.mr_n78374192)
print v(xbgr.mr_n78374624)
print v(xbgr.mr_n78375056)
print v(xbgr.mr_n78375488)
print v(xbgr.mr_n78375920)
print v(xbgr.mr_n78376352)
print v(xbgr.mr_n78376784)
print v(xbgr.mr_n78377216)
print v(xbgr.mr_n78377648)
print v(xbgr.mr_n78378080)
print v(xbgr.mr_n78378512)
print v(xbgr.mr_n78378944)
print v(xbgr.mr_n78379376)
print v(xbgr.mr_n78379808)
print v(xbgr.mr_n78380240)
print v(xbgr.mr_n78380672)
print v(xbgr.mr_n78381104)
print v(xbgr.mr_n78381536)
print v(xbgr.mr_n78381968)
print v(xbgr.mr_n78382400)
print v(xbgr.mr_n78382832)
print v(xbgr.mr_n78383264)
print v(xbgr.mr_n78383696)
print v(xbgr.mr_n78384128)
print v(xbgr.mr_n78384560)
print v(xbgr.mr_n78384992)
print v(xbgr.mr_n78385424)
print v(xbgr.mr_n78385856)
print v(xbgr.mr_n78386288)
print v(xbgr.mr_n78386720)
print v(xbgr.mr_n78387152)
print v(xbgr.mr_n78387584)
print v(xbgr.mr_n78388016)
print v(xbgr.mr_n78388448)
print v(xbgr.mr_n78388880)
print v(xbgr.mr_n78389312)
print v(xbgr.mr_n78389744)
print v(xbgr.mr_n78390176)
print v(xbgr.mr_n78390608)
print v(xbgr.mr_n78391040)
print v(xbgr.mr_n78391472)
print v(xbgr.mr_n78391904)
print v(xbgr.mr_n78392336)
print v(xbgr.mr_n78392768)
print v(xbgr.mr_n78393200)
print v(xbgr.mr_n78393632)
print v(xbgr.mr_n78394064)
print v(xbgr.mr_n78394496)
print v(xbgr.mr_n78394928)
print v(xbgr.mr_n78395360)
print v(xbgr.mr_n78395792)
print v(xbgr.mr_n78396224)
print v(xbgr.mr_n78396656)
print v(xbgr.mr_n78397088)
print v(xbgr.mr_n78397520)
print v(xbgr.mr_n78397952)
print v(xbgr.mr_n78398384)
print v(xbgr.mr_n78398816)
print v(xbgr.mr_n78399248)
print v(xbgr.mr_n78399680)
print v(xbgr.mr_n78400112)
print v(xbgr.mr_n78400544)
print v(xbgr.mr_n78400976)
print v(xbgr.mr_n78401296)
print v(xbgr.mr_n78401408)
print v(xbgr.mr_n78401728)
print v(xbgr.mr_n78401840)
print v(xbgr.mr_n78402160)
print v(xbgr.mr_n78402272)
print v(xbgr.mr_n78402592)
print v(xbgr.mr_n78402704)
print v(xbgr.mr_n78403024)
print v(xbgr.mr_n78403136)
print v(xbgr.mr_n78403456)
print v(xbgr.mr_n78403568)
print v(xbgr.mr_n78403888)
print v(xbgr.mr_n78404000)
print v(xbgr.mr_n78404320)
print v(xbgr.mr_n78404432)
print v(xbgr.mr_n78404752)
print v(xbgr.mr_n78404864)
print v(xbgr.mr_n78405184)
print v(xbgr.mr_n78405296)
print v(xbgr.mr_n78405616)
print v(xbgr.mr_n78405728)
print v(xbgr.mr_n78406048)
print v(xbgr.mr_n78406160)
print v(xbgr.mr_n78406480)
print v(xbgr.mr_n78406592)
print v(xbgr.mr_n78406912)
print v(xbgr.mr_n78407024)
print v(xbgr.mr_n78407344)
print v(xbgr.mr_n78407456)
print v(xbgr.mr_n78407776)
print v(xbgr.mr_n78407888)
print v(xbgr.mr_n78408208)
print v(xbgr.mr_n78408320)
print v(xbgr.mr_n78408640)
print v(xbgr.mr_n78408752)
print v(xbgr.mr_n78409072)
print v(xbgr.mr_n78409184)
print v(xbgr.mr_n78409504)
print v(xbgr.mr_n78409616)
print v(xbgr.mr_n78409936)
print v(xbgr.mr_n78410048)
print v(xbgr.mr_n78410368)
print v(xbgr.mr_n78410480)
print v(xbgr.mr_n78410800)
print v(xbgr.mr_n78410912)
print v(xbgr.mr_n78411232)
print v(xbgr.mr_n78411344)
print v(xbgr.mr_n78411664)
print v(xbgr.mr_n78411776)
print v(xbgr.mr_n78412096)
print v(xbgr.mr_n78412208)
print v(xbgr.mr_n78412528)
print v(xbgr.mr_n78412640)
print v(xbgr.mr_n78412960)
print v(xbgr.mr_n78413072)
print v(xbgr.mr_n78413392)
print v(xbgr.mr_n78413504)
print v(xbgr.mr_n78413824)
print v(xbgr.mr_n78413936)
print v(xbgr.mr_n78414256)
print v(xbgr.mr_n78414368)
print v(xbgr.mr_n78414688)
print v(xbgr.mr_n78414800)
print v(xbgr.mr_n78415120)
print v(xbgr.mr_n78415232)
print v(xbgr.mr_n78415552)
print v(xbgr.mr_n78415664)
print v(xbgr.mr_n78415984)
print v(xbgr.mr_n78416096)
print v(xbgr.mr_n78416416)
print v(xbgr.mr_n78416528)
print v(xbgr.mr_n78416848)
print v(xbgr.mr_n78416960)
print v(xbgr.mr_n78417280)
print v(xbgr.mr_n78417392)
print v(xbgr.mr_n78417712)
print v(xbgr.mr_n78417824)
print v(xbgr.mr_n78418144)
print v(xbgr.mr_n78418256)
print v(xbgr.mr_n78418576)
print v(xbgr.mr_n78418688)
print v(xbgr.mr_n78419008)
print v(xbgr.mr_n78419120)
print v(xbgr.mr_n78419440)
print v(xbgr.mr_n78419552)
print v(xbgr.mr_n78419872)
print v(xbgr.mr_n78419984)
print v(xbgr.mr_n78420304)
print v(xbgr.mr_n78420416)
print v(xbgr.mr_n78420736)
print v(xbgr.mr_n78420848)
print v(xbgr.mr_n78421168)
print v(xbgr.mr_n78421280)
print v(xbgr.mr_n78421600)
print v(xbgr.mr_n78421712)
print v(xbgr.mr_n78422032)
print v(xbgr.mr_n78422144)
print v(xbgr.mr_n78422464)
print v(xbgr.mr_n78422576)
print v(xbgr.mr_n78423008)
print v(xbgr.mr_n78423328)
print v(xbgr.mr_n78423440)
print v(xbgr.mr_n78423760)
print v(xbgr.mr_n78423872)
print v(xbgr.mr_n78424192)
print v(xbgr.mr_n78424304)
print v(xbgr.mr_n78424624)
print v(xbgr.mr_n78424736)
print v(xbgr.mr_n78425056)
print v(xbgr.mr_n78425168)
print v(xbgr.mr_n78425488)
print v(xbgr.mr_n78425600)
print v(xbgr.mr_n78425920)
print v(xbgr.mr_n78426032)
print v(xbgr.mr_n78426352)
print v(xbgr.mr_n78426464)
print v(xbgr.mr_n78426784)
print v(xbgr.mr_n78426896)
print v(xbgr.mr_n78427216)
print v(xbgr.mr_n78427328)
print v(xbgr.mr_n78427648)
print v(xbgr.mr_n78427760)
print v(xbgr.mr_n78428080)
print v(xbgr.mr_n78428192)
print v(xbgr.mr_n78428512)
print v(xbgr.mr_n78428624)
print v(xbgr.mr_n78428944)
print v(xbgr.mr_n78429056)
print v(xbgr.mr_n78429376)
print v(xbgr.mr_n78429488)
print v(xbgr.mr_n78429808)
print v(xbgr.mr_n78429920)
print v(xbgr.mr_n78430368)
print v(xbgr.mr_n78430480)
print v(xbgr.mr_n78430800)
print v(xbgr.mr_n78430912)
print v(xbgr.mr_n78431232)
print v(xbgr.mr_n78431344)
print v(xbgr.mr_n78431664)
print v(xbgr.mr_n78431776)
print v(xbgr.mr_n78432096)
print v(xbgr.mr_n78432208)
print v(xbgr.mr_n78432528)
print v(xbgr.mr_n78432640)
print v(xbgr.mr_n78432960)
print v(xbgr.mr_n78433072)
print v(xbgr.mr_n78433392)
print v(xbgr.mr_n78433504)
print v(xbgr.mr_n78433824)
print v(xbgr.mr_n78433936)
print v(xbgr.mr_n78434256)
print v(xbgr.mr_n78434368)
print v(xbgr.mr_n78434688)
print v(xbgr.mr_n78434800)
print v(xbgr.mr_n78435232)
print v(xbgr.mr_n78435552)
print v(xbgr.mr_n78435664)
print v(xbgr.mr_n78435984)
print v(xbgr.mr_n78436096)
print v(xbgr.mr_n78436416)
print v(xbgr.mr_n78436528)
print v(xbgr.mr_n78436848)
print v(xbgr.mr_n78436960)
print v(xbgr.mr_n78437392)
print v(xbgr.mr_n78437824)
print v(xbgr.mr_n78438144)
print v(xbgr.mr_n78438256)
print v(xbgr.mr_n78438576)
print v(xbgr.mr_n78438688)
print v(xbgr.mr_n78439008)
print v(xbgr.mr_n78439120)
print v(xbgr.mr_n78439440)
print v(xbgr.mr_n78439552)
print v(xbgr.mr_n78439872)
print v(xbgr.mr_n78439984)
print v(xbgr.mr_n78440304)
print v(xbgr.mr_n78440416)
print v(xbgr.mr_n78440848)
print v(xbgr.mr_n78441168)
print v(xbgr.mr_n78441280)
print v(xbgr.mr_n78441600)
print v(xbgr.mr_n78441712)
print v(xbgr.mr_n78442032)
print v(xbgr.mr_n78442144)
print v(xbgr.mr_n78442464)
print v(xbgr.mr_n78442576)
print v(xbgr.mr_n78442896)
print v(xbgr.mr_n78443008)
print v(xbgr.mr_n78443328)
print v(xbgr.mr_n78443440)
print v(xbgr.mr_n78443760)
print v(xbgr.mr_n78443872)
print v(xbgr.mr_n78444192)
print v(xbgr.mr_n78444304)
print v(xbgr.mr_n78444624)
print v(xbgr.mr_n78444736)
print v(xbgr.mr_n78445056)
print v(xbgr.mr_n78445168)
print v(xbgr.mr_n78445488)
print v(xbgr.mr_n78445600)
print v(xbgr.mr_n78445920)
print v(xbgr.mr_n78446032)
print v(xbgr.mr_n78446464)
print v(xbgr.mr_n78446896)
print v(xbgr.mr_n78447328)
print v(xbgr.mr_n78447760)
print v(xbgr.mr_n78448256)
print v(xbgr.mr_n78448368)
print v(xbgr.mr_n78448704)
print v(xbgr.mr_n78448816)
print v(xbgr.mr_n78449136)
print v(xbgr.mr_n78449248)
print v(xbgr.mr_n78449616)
print v(xbgr.mr_n78449728)
print v(xbgr.mr_n78450048)
print v(xbgr.mr_n78450160)
print v(xbgr.mr_n78450480)
print v(xbgr.mr_n78450592)
print v(xbgr.mr_n78450832)
print v(xbgr.mr_n78450944)
print v(xbgr.mr_n78451264)
print v(xbgr.mr_n78451376)
print v(xbgr.mr_n78451696)
print v(xbgr.mr_n78451808)
print v(xbgr.mr_n78452128)
print v(xbgr.mr_n78452240)
print v(xbgr.mr_n78452560)
print v(xbgr.mr_n78452672)
print v(xbgr.mr_n78452992)
print v(xbgr.mr_n78453104)
print v(xbgr.mr_n78453424)
print v(xbgr.mr_n78453536)
print v(xbgr.mr_n78453856)
print v(xbgr.mr_n78453968)
print v(xbgr.mr_n78454288)
print v(xbgr.mr_n78454400)
print v(xbgr.mr_n78454720)
print v(xbgr.mr_n78454832)
print v(xbgr.mr_n78455152)
print v(xbgr.mr_n78455264)
print v(xbgr.mr_n78455584)
print v(xbgr.mr_n78455696)
print v(xbgr.mr_n78456016)
print v(xbgr.mr_n78456128)
print v(xbgr.mr_n78456448)
print v(xbgr.mr_n78456560)
print v(xbgr.mr_n78456880)
print v(xbgr.mr_n78456992)
print v(xbgr.mr_n78457312)
print v(xbgr.mr_n78457424)
print v(xbgr.mr_n78457744)
print v(xbgr.mr_n78457856)
print v(xbgr.mr_n78458176)
print v(xbgr.mr_n78458288)
print v(xbgr.mr_n78458608)
print v(xbgr.mr_n78458720)
print v(xbgr.mr_n78459040)
print v(xbgr.mr_n78459152)
print v(xbgr.mr_n78459472)
print v(xbgr.mr_n78459584)
print v(xbgr.mr_n78459904)
print v(xbgr.mr_n78460016)
print v(xbgr.mr_n78460336)
print v(xbgr.mr_n78460448)
print v(xbgr.mr_n78460768)
print v(xbgr.mr_n78460880)
print v(xbgr.mr_n78461200)
print v(xbgr.mr_n78461312)
print v(xbgr.mr_n78461744)
print v(xbgr.mr_n78462064)
print v(xbgr.mr_n78463056)
print v(xbgr.mr_n78463168)
print v(xbgr.mr_n78463488)
print v(xbgr.mr_n78463600)
print v(xbgr.mr_n78463920)
print v(xbgr.mr_n78464032)
print v(xbgr.mr_n78464464)
print v(xbgr.mr_n78464784)
print v(xbgr.mr_n78464896)
print v(xbgr.mr_n78465216)
print v(xbgr.mr_n78465328)
print v(xbgr.mr_n78465648)
print v(xbgr.mr_n78465760)
print v(xbgr.mr_n78466080)
print v(xbgr.mr_n78466192)
print v(xbgr.mr_n78466512)
print v(xbgr.mr_n78466624)
print v(xbgr.mr_n78467056)
print v(xbgr.mr_n78467488)
print v(xbgr.mr_n78467920)
print v(xbgr.mr_n78468352)
print v(xbgr.mr_n78468672)
print v(xbgr.mr_n78468784)
print v(xbgr.mr_n78469104)
print v(xbgr.mr_n78469216)
print v(xbgr.mr_n78469536)
print v(xbgr.mr_n78469648)
print v(xbgr.mr_n78470080)
print v(xbgr.mr_n78470512)
print v(xbgr.mr_n78470832)
print v(xbgr.mr_n78470944)
print v(xbgr.mr_n78471264)
print v(xbgr.mr_n78471376)
print v(xbgr.mr_n78471696)
print v(xbgr.mr_n78471808)
print v(xbgr.mr_n78472128)
print v(xbgr.mr_n78472240)
print v(xbgr.mr_n78472672)
print v(xbgr.mr_n78473104)
print v(xbgr.mr_n78473536)
print v(xbgr.mr_n78473968)
print v(xbgr.mr_n78474400)
print v(xbgr.mr_n78474720)
print v(xbgr.mr_n78474832)
print v(xbgr.mr_n78475152)
print v(xbgr.mr_n78475264)
print v(xbgr.mr_n78475584)
print v(xbgr.mr_n78475696)
print v(xbgr.mr_n78476016)
print v(xbgr.mr_n78476128)
print v(xbgr.mr_n78476448)
print v(xbgr.mr_n78476560)
print v(xbgr.mr_n78476880)
print v(xbgr.mr_n78476992)
print v(xbgr.mr_n78477312)
print v(xbgr.mr_n78477424)
print v(xbgr.mr_n78477744)
print v(xbgr.mr_n78477856)
print v(xbgr.mr_n78478176)
print v(xbgr.mr_n78478288)
print v(xbgr.mr_n78478608)
print v(xbgr.mr_n78478720)
print v(xbgr.mr_n78479040)
print v(xbgr.mr_n78479152)
print v(xbgr.mr_n78479472)
print v(xbgr.mr_n78479584)
print v(xbgr.mr_n78480016)
print v(xbgr.mr_n78480336)
print v(xbgr.mr_n78480448)
print v(xbgr.mr_n78480768)
print v(xbgr.mr_n78480880)
print v(xbgr.mr_n78481200)
print v(xbgr.mr_n78481312)
print v(xbgr.mr_n78481632)
print v(xbgr.mr_n78481744)
print v(xbgr.mr_n78482064)
print v(xbgr.mr_n78482176)
print v(xbgr.mr_n78482608)
print v(xbgr.mr_n78483040)
print v(xbgr.mr_n78483472)
print v(xbgr.mr_n78483904)
print v(xbgr.mr_n78484224)
print v(xbgr.mr_n78484336)
print v(xbgr.mr_n78484656)
print v(xbgr.mr_n78484768)
print v(xbgr.mr_n78485088)
print v(xbgr.mr_n78485200)
print v(xbgr.mr_n78485520)
print v(xbgr.mr_n78485632)
print v(xbgr.mr_n78485952)
print v(xbgr.mr_n78486064)
print v(xbgr.mr_n78486384)
print v(xbgr.mr_n78486496)
print v(xbgr.mr_n78486816)
print v(xbgr.mr_n78486928)
print v(xbgr.mr_n78487248)
print v(xbgr.mr_n78487360)
print v(xbgr.mr_n78487680)
print v(xbgr.mr_n78487792)
print v(xbgr.mr_n78488112)
print v(xbgr.mr_n78488224)
print v(xbgr.mr_n78488544)
print v(xbgr.mr_n78488656)
print v(xbgr.mr_n78488976)
print v(xbgr.mr_n78489088)
print v(xbgr.mr_n78489408)
print v(xbgr.mr_n78489520)
print v(xbgr.mr_n78489840)
print v(xbgr.mr_n78489952)
print v(xbgr.mr_n78490272)
print v(xbgr.mr_n78490384)
print v(xbgr.mr_n78490704)
print v(xbgr.mr_n78490816)
print v(xbgr.mr_n78491136)
print v(xbgr.mr_n78491248)
print v(xbgr.mr_n78491568)
print v(xbgr.mr_n78491680)
print v(xbgr.mr_n78492000)
print v(xbgr.mr_n78492112)
print v(xbgr.mr_n78492432)
print v(xbgr.mr_n78492544)
print v(xbgr.mr_n78492864)
print v(xbgr.mr_n78492976)
print v(xbgr.mr_n78493296)
print v(xbgr.mr_n78493408)
print v(xbgr.mr_n78493728)
print v(xbgr.mr_n78493840)
print v(xbgr.mr_n78494160)
print v(xbgr.mr_n78494272)
print v(xbgr.mr_n78494592)
print v(xbgr.mr_n78494704)
print v(xbgr.mr_n78495024)
print v(xbgr.mr_n78495136)
print v(xbgr.mr_n78495456)
print v(xbgr.mr_n78495568)
print v(xbgr.mr_n78495888)
print v(xbgr.mr_n78496000)
print v(xbgr.mr_n78496320)
print v(xbgr.mr_n78496432)
print v(xbgr.mr_n78496752)
print v(xbgr.mr_n78496864)
print v(xbgr.mr_n78497184)
print v(xbgr.mr_n78497296)
print v(xbgr.mr_n78497616)
print v(xbgr.mr_n78497728)
print v(xbgr.mr_n78498048)
print v(xbgr.mr_n78498160)
print v(xbgr.mr_n78498480)
print v(xbgr.mr_n78498592)
print v(xbgr.mr_n78498912)
print v(xbgr.mr_n78499024)
print v(xbgr.mr_n78499344)
print v(xbgr.mr_n78499456)
print v(xbgr.mr_n78499776)
print v(xbgr.mr_n78499888)
print v(xbgr.mr_n78500208)
print v(xbgr.mr_n78500320)
print v(xbgr.mr_n78500640)
print v(xbgr.mr_n78500752)
print v(xbgr.mr_n78501072)
print v(xbgr.mr_n78501184)
print v(xbgr.mr_n78501504)
print v(xbgr.mr_n78501616)
print v(xbgr.mr_n78501936)
print v(xbgr.mr_n78502048)
print v(xbgr.mr_n78502368)
print v(xbgr.mr_n78502480)
print v(xbgr.mr_n78502800)
print v(xbgr.mr_n78502912)
print v(xbgr.mr_n78503344)
print v(xbgr.mr_n78503776)
print v(xbgr.mr_n78504096)
print v(xbgr.mr_n78504208)
print v(xbgr.mr_n78504528)
print v(xbgr.mr_n78504640)
print v(xbgr.mr_n78504960)
print v(xbgr.mr_n78505072)
print v(xbgr.mr_n78505392)
print v(xbgr.mr_n78505504)
print v(xbgr.mr_n78505936)
print v(xbgr.mr_n78506368)
print v(xbgr.mr_n78506688)
print v(xbgr.mr_n78506800)
print v(xbgr.mr_n78507120)
print v(xbgr.mr_n78507232)
print v(xbgr.mr_n78507552)
print v(xbgr.mr_n78507664)
print v(xbgr.mr_n78508096)
print v(xbgr.mr_n78508528)
print v(xbgr.mr_n78508960)
print v(xbgr.mr_n78509392)
print v(xbgr.mr_n78509824)
print v(xbgr.mr_n78510256)
print v(xbgr.mr_n78510688)
print v(xbgr.mr_n78511120)
print v(xbgr.mr_n78511552)
print v(xbgr.mr_n78511984)
print v(xbgr.mr_n78512416)
print v(xbgr.mr_n78512848)
print v(xbgr.mr_n78513280)
print v(xbgr.mr_n78513600)
print v(xbgr.mr_n78514032)
print v(xbgr.mr_n78514464)
print v(xbgr.mr_n78514896)
print v(xbgr.mr_n78515328)
print v(xbgr.mr_n78515760)
print v(xbgr.mr_n78516192)
print v(xbgr.mr_n78516624)
print v(xbgr.mr_n78517056)
print v(xbgr.mr_n78517168)
print v(xbgr.mr_n78517488)
print v(xbgr.mr_n78517600)
print v(xbgr.mr_n78517920)
print v(xbgr.mr_n78518032)
print v(xbgr.mr_n78518352)
print v(xbgr.mr_n78518464)
print v(xbgr.mr_n78518784)
print v(xbgr.mr_n78518896)
print v(xbgr.mr_n78519216)
print v(xbgr.mr_n78519328)
print v(xbgr.mr_n78519648)
print v(xbgr.mr_n78519760)
print v(xbgr.mr_n78520080)
print v(xbgr.mr_n78520192)
print v(xbgr.mr_n78520512)
print v(xbgr.mr_n78520944)
print v(xbgr.mr_n78521376)
print v(xbgr.mr_n78521808)
print v(xbgr.mr_n78522240)
print v(xbgr.mr_n78522672)
print v(xbgr.mr_n78523104)
print v(xbgr.mr_n78523536)
print v(xbgr.mr_n78523968)
print v(xbgr.mr_n78524400)
print v(xbgr.mr_n78524944)
print v(xbgr.mr_n78525376)
print v(xbgr.mr_n78525808)
print v(xbgr.mr_n78526240)
print v(xbgr.mr_n78526672)
print v(xbgr.mr_n78527104)
print v(xbgr.mr_n78527536)
print v(xbgr.mr_n78527968)
print v(xbgr.mr_n78528400)
print v(xbgr.mr_n78528832)
print v(xbgr.mr_n78529264)
print v(xbgr.mr_n78529696)
print v(xbgr.mr_n78530128)
print v(xbgr.mr_n78530560)
print v(xbgr.mr_n78530992)
print v(xbgr.mr_n78531424)
print v(xbgr.mr_n78531856)
print v(xbgr.mr_n78532288)
print v(xbgr.mr_n78532720)
print v(xbgr.mr_n78533152)
print v(xbgr.mr_n78533584)
print v(xbgr.mr_n78534016)
print v(xbgr.mr_n78534448)
print v(xbgr.mr_n78534880)
print v(xbgr.mr_n78535312)
print v(xbgr.mr_n78535744)
print v(xbgr.mr_n78536176)
print v(xbgr.mr_n78536608)
print v(xbgr.mr_n78537040)
print v(xbgr.mr_n78537472)
print v(xbgr.mr_n78537904)
print v(xbgr.mr_n78538336)
print v(xbgr.mr_n78538768)
print v(xbgr.mr_n78539200)
print v(xbgr.mr_n78539632)
print v(xbgr.mr_n78540064)
print v(xbgr.mr_n78540496)
print v(xbgr.mr_n78540928)
print v(xbgr.mr_n78541360)
print v(xbgr.mr_n78541792)
print v(xbgr.mr_n78542224)
print v(xbgr.mr_n78542656)
print v(xbgr.mr_n78543088)
print v(xbgr.mr_n78543520)
print v(xbgr.mr_n78543952)
print v(xbgr.mr_n78544384)
print v(xbgr.mr_n78544816)
print v(xbgr.mr_n78545248)
print v(xbgr.mr_n78545680)
print v(xbgr.mr_n78546112)
print v(xbgr.mr_n78546544)
print v(xbgr.mr_n78546976)
print v(xbgr.mr_n78547408)
print v(xbgr.mr_n78547840)
print v(xbgr.mr_n78548272)
print v(xbgr.mr_n78548704)
print v(xbgr.mr_n78549136)
print v(xbgr.mr_n78549568)
print v(xbgr.mr_n78550000)
print v(xbgr.mr_n78550432)
print v(xbgr.mr_n78550864)
print v(xbgr.mr_n78551296)
print v(xbgr.mr_n78551728)
print v(xbgr.mr_n78552160)
print v(xbgr.mr_n78552480)
print v(xbgr.mr_n78552912)
print v(xbgr.mr_n78553344)
print v(xbgr.mr_n78553776)
print v(xbgr.mr_n78554208)
print v(xbgr.mr_n78554640)
print v(xbgr.mr_n78555184)
print v(xbgr.mr_n78555616)
print v(xbgr.mr_n78556048)
print v(xbgr.mr_n78556480)
print v(xbgr.mr_n78556912)
print v(xbgr.mr_n78557344)
print v(xbgr.mr_n78557776)
print v(xbgr.mr_n78558208)
print v(xbgr.mr_n78558640)
print v(xbgr.mr_n78559072)
print v(xbgr.mr_n78559504)
print v(xbgr.mr_n78559936)
print v(xbgr.mr_n78560368)
print v(xbgr.mr_n78560800)
print v(xbgr.mr_n78561232)
print v(xbgr.mr_n78561664)
print v(xbgr.mr_n78562096)
print v(xbgr.mr_n78562528)
print v(xbgr.mr_n78562960)
print v(xbgr.mr_n78563392)
print v(xbgr.mr_n78563824)
print v(xbgr.mr_n78564256)
print v(xbgr.mr_n78564688)
print v(xbgr.mr_n78565120)
print v(xbgr.mr_n78565552)
print v(xbgr.mr_n78565984)
print v(xbgr.mr_n78566304)
print v(xbgr.mr_n78566416)
print v(xbgr.mr_n78566736)
print v(xbgr.mr_n78566848)
print v(xbgr.mr_n78567168)
print v(xbgr.mr_n78567280)
print v(xbgr.mr_n78567600)
print v(xbgr.mr_n78567712)
print v(xbgr.mr_n78568032)
print v(xbgr.mr_n78568144)
print v(xbgr.mr_n78568464)
print v(xbgr.mr_n78568576)
print v(xbgr.mr_n78568896)
print v(xbgr.mr_n78569008)
print v(xbgr.mr_n78569328)
print v(xbgr.mr_n78569440)
print v(xbgr.mr_n78569760)
print v(xbgr.mr_n78569872)
print v(xbgr.mr_n78570192)
print v(xbgr.mr_n78570304)
print v(xbgr.mr_n78570624)
print v(xbgr.mr_n78570736)
print v(xbgr.mr_n78571056)
print v(xbgr.mr_n78571168)
print v(xbgr.mr_n78571488)
print v(xbgr.mr_n78571600)
print v(xbgr.mr_n78571920)
print v(xbgr.mr_n78572032)
print v(xbgr.mr_n78572352)
print v(xbgr.mr_n78572464)
print v(xbgr.mr_n78572784)
print v(xbgr.mr_n78573216)
print v(xbgr.mr_n78573328)
print v(xbgr.mr_n78573648)
print v(xbgr.mr_n78574080)
print v(xbgr.mr_n78574192)
print v(xbgr.mr_n78574512)
print v(xbgr.mr_n78574624)
print v(xbgr.mr_n78574944)
print v(xbgr.mr_n78575056)
print v(xbgr.mr_n78575376)
print v(xbgr.mr_n78575488)
print v(xbgr.mr_n78575808)
print v(xbgr.mr_n78575920)
print v(xbgr.mr_n78576240)
print v(xbgr.mr_n78576352)
print v(xbgr.mr_n78576672)
print v(xbgr.mr_n78576784)
print v(xbgr.mr_n78577104)
print v(xbgr.mr_n78577536)
print v(xbgr.mr_n78577648)
print v(xbgr.mr_n78577968)
print v(xbgr.mr_n78578080)
print v(xbgr.mr_n78578400)
print v(xbgr.mr_n78578512)
print v(xbgr.mr_n78578832)
print v(xbgr.mr_n78578944)
print v(xbgr.mr_n78579264)
print v(xbgr.mr_n78579376)
print v(xbgr.mr_n78579696)
print v(xbgr.mr_n78579808)
print v(xbgr.mr_n78580128)
print v(xbgr.mr_n78580240)
print v(xbgr.mr_n78580560)
print v(xbgr.mr_n78580672)
print v(xbgr.mr_n78580992)
print v(xbgr.mr_n78581104)
print v(xbgr.mr_n78581424)
print v(xbgr.mr_n78581536)
print v(xbgr.mr_n78581856)
print v(xbgr.mr_n78581968)
print v(xbgr.mr_n78582288)
print v(xbgr.mr_n78582720)
print v(xbgr.mr_n78582832)
print v(xbgr.mr_n78583152)
print v(xbgr.mr_n78583264)
print v(xbgr.mr_n78583584)
print v(xbgr.mr_n78583696)
print v(xbgr.mr_n78584016)
print v(xbgr.mr_n78584128)
print v(xbgr.mr_n78584448)
print v(xbgr.mr_n78584560)
print v(xbgr.mr_n78584880)
print v(xbgr.mr_n78584992)
print v(xbgr.mr_n78585312)
print v(xbgr.mr_n78585424)
print v(xbgr.mr_n78585744)
print v(xbgr.mr_n78585856)
print v(xbgr.mr_n78586176)
print v(xbgr.mr_n78586288)
print v(xbgr.mr_n78586608)
print v(xbgr.mr_n78586720)
print v(xbgr.mr_n78587040)
print v(xbgr.mr_n78587152)
print v(xbgr.mr_n78587472)
print v(xbgr.mr_n78587584)
print v(xbgr.mr_n78587904)
print v(xbgr.mr_n78588016)
print v(xbgr.mr_n78588336)
print v(xbgr.mr_n78588768)
print v(xbgr.mr_n78588880)
print v(xbgr.mr_n78589200)
print v(xbgr.mr_n78589312)
print v(xbgr.mr_n78589632)
print v(xbgr.mr_n78589744)
print v(xbgr.mr_n78590064)
print v(xbgr.mr_n78590176)
print v(xbgr.mr_n78590496)
print v(xbgr.mr_n78590608)
print v(xbgr.mr_n78590928)
print v(xbgr.mr_n78591040)
print v(xbgr.mr_n78591360)
print v(xbgr.mr_n78591472)
print v(xbgr.mr_n78591792)
print v(xbgr.mr_n78592224)
print v(xbgr.mr_n78592336)
print v(xbgr.mr_n78592656)
print v(xbgr.mr_n78593088)
print v(xbgr.mr_n78593200)
print v(xbgr.mr_n78593520)
print v(xbgr.mr_n78593632)
print v(xbgr.mr_n78593952)
print v(xbgr.mr_n78594064)
print v(xbgr.mr_n78594384)
print v(xbgr.mr_n78594496)
print v(xbgr.mr_n78594816)
print v(xbgr.mr_n78594928)
print v(xbgr.mr_n78595248)
print v(xbgr.mr_n78595360)
print v(xbgr.mr_n78595680)
print v(xbgr.mr_n78595792)
print v(xbgr.mr_n78596112)
print v(xbgr.mr_n78596224)
print v(xbgr.mr_n78596544)
print v(xbgr.mr_n78596656)
print v(xbgr.mr_n78596976)
print v(xbgr.mr_n78597088)
print v(xbgr.mr_n78597408)
print v(xbgr.mr_n78597520)
print v(xbgr.mr_n78597840)
print v(xbgr.mr_n78597952)
print v(xbgr.mr_n78598384)
print v(xbgr.mr_n78598816)
print v(xbgr.mr_n78599248)
print v(xbgr.mr_n78599680)
print v(xbgr.mr_n78600112)
print v(xbgr.mr_n78600544)
print v(xbgr.mr_n78600976)
print v(xbgr.mr_n78601408)
print v(xbgr.mr_n78601840)
print v(xbgr.mr_n78602272)
print v(xbgr.mr_n78602704)
print v(xbgr.mr_n78603136)
print v(xbgr.mr_n78603568)
print v(xbgr.mr_n78604000)
print v(xbgr.mr_n78604432)
print v(xbgr.mr_n78604864)
print v(xbgr.mr_n78605296)
print v(xbgr.mr_n78605728)
print v(xbgr.mr_n78606160)
print v(xbgr.mr_n78606592)
print v(xbgr.mr_n78607024)
print v(xbgr.mr_n78607456)
print v(xbgr.mr_n78607888)
print v(xbgr.mr_n78608320)
print v(xbgr.mr_n78608752)
print v(xbgr.mr_n78609184)
print v(xbgr.mr_n78609616)
print v(xbgr.mr_n78610048)
print v(xbgr.mr_n78610480)
print v(xbgr.mr_n78610912)
print v(xbgr.mr_n78611344)
print v(xbgr.mr_n78611776)
print v(xbgr.mr_n78612208)
print v(xbgr.mr_n78612640)
print v(xbgr.mr_n78613072)
print v(xbgr.mr_n78613504)
print v(xbgr.mr_n78613936)
print v(xbgr.mr_n78614368)
print v(xbgr.mr_n78614800)
print v(xbgr.mr_n78615232)
print v(xbgr.mr_n78615664)
print v(xbgr.mr_n78616096)
print v(xbgr.mr_n78616528)
print v(xbgr.mr_n78616960)
print v(xbgr.mr_n78617392)
print v(xbgr.mr_n78617824)
print v(xbgr.mr_n78618256)
print v(xbgr.mr_n78618688)
print v(xbgr.mr_n78619120)
print v(xbgr.mr_n78619552)
print v(xbgr.mr_n78619984)
print v(xbgr.mr_n78620416)
print v(xbgr.mr_n78620848)
print v(xbgr.mr_n78621280)
print v(xbgr.mr_n78621712)
print v(xbgr.mr_n78622144)
print v(xbgr.mr_n78622576)
print v(xbgr.mr_n78623008)
print v(xbgr.mr_n78623440)
print v(xbgr.mr_n78623872)
print v(xbgr.mr_n78624304)
print v(xbgr.mr_n78624736)
print v(xbgr.mr_n78625168)
print v(xbgr.mr_n78625600)
print v(xbgr.mr_n78626032)
print v(xbgr.mr_n78626464)
print v(xbgr.mr_n78626896)
print v(xbgr.mr_n78627328)
print v(xbgr.mr_n78627760)
print v(xbgr.mr_n78628192)
print v(xbgr.mr_n78628624)
print v(xbgr.mr_n78629056)
print v(xbgr.mr_n78629488)
print v(xbgr.mr_n78629920)
print v(xbgr.mr_n78630352)
print v(xbgr.mr_n78630784)
print v(xbgr.mr_n78631216)
print v(xbgr.mr_n78631648)
print v(xbgr.mr_n78631968)
print v(xbgr.mr_n78632080)
print v(xbgr.mr_n78632400)
print v(xbgr.mr_n78632512)
print v(xbgr.mr_n78632944)
print v(xbgr.mr_n78633376)
print v(xbgr.mr_n78633696)
print v(xbgr.mr_n78633808)
print v(xbgr.mr_n78634128)
print v(xbgr.mr_n78634672)
print v(xbgr.mr_n78635104)
print v(xbgr.mr_n78635424)
print v(xbgr.mr_n78635536)
print v(xbgr.mr_n78635856)
print v(xbgr.mr_n78635968)
print v(xbgr.mr_n78636288)
print v(xbgr.mr_n78636400)
print v(xbgr.mr_n78636720)
print v(xbgr.mr_n78636832)
print v(xbgr.mr_n78637152)
print v(xbgr.mr_n78637264)
print v(xbgr.mr_n78637584)
print v(xbgr.mr_n78637696)
print v(xbgr.mr_n78638016)
print v(xbgr.mr_n78638128)
print v(xbgr.mr_n78638448)
print v(xbgr.mr_n78638560)
print v(xbgr.mr_n78638880)
print v(xbgr.mr_n78638992)
print v(xbgr.mr_n78639312)
print v(xbgr.mr_n78639424)
print v(xbgr.mr_n78639744)
print v(xbgr.mr_n78639856)
print v(xbgr.mr_n78640176)
print v(xbgr.mr_n78640288)
print v(xbgr.mr_n78640720)
print v(xbgr.mr_n78641152)
print v(xbgr.mr_n78641472)
print v(xbgr.mr_n78641584)
print v(xbgr.mr_n78641904)
print v(xbgr.mr_n78642016)
print v(xbgr.mr_n78642448)
print v(xbgr.mr_n78642880)
print v(xbgr.mr_n78643312)
print v(xbgr.mr_n78643744)
print v(xbgr.mr_n78644176)
print v(xbgr.mr_n78644608)
print v(xbgr.mr_n78645040)
print v(xbgr.mr_n78645472)
print v(xbgr.mr_n78645904)
print v(xbgr.mr_n78646336)
print v(xbgr.mr_n78646768)
print v(xbgr.mr_n78647200)
print v(xbgr.mr_n78647632)
print v(xbgr.mr_n78648064)
print v(xbgr.mr_n78648496)
print v(xbgr.mr_n78648928)
print v(xbgr.mr_n78649360)
print v(xbgr.mr_n78649792)
print v(xbgr.mr_n78650224)
print v(xbgr.mr_n78650656)
print v(xbgr.mr_n78651088)
print v(xbgr.mr_n78651520)
print v(xbgr.mr_n78651952)
print v(xbgr.mr_n78652384)
print v(xbgr.mr_n78652816)
print v(xbgr.mr_n78653248)
print v(xbgr.mr_n78653680)
print v(xbgr.mr_n78654112)
print v(xbgr.mr_n78654544)
print v(xbgr.mr_n78654976)
print v(xbgr.mr_n78655408)
print v(xbgr.mr_n78655840)
print v(xbgr.mr_n78656272)
print v(xbgr.mr_n78656704)
print v(xbgr.mr_n78657136)
print v(xbgr.mr_n78657568)
print v(xbgr.mr_n78658000)
print v(xbgr.mr_n78658432)
print v(xbgr.mr_n78658864)
print v(xbgr.mr_n78659296)
print v(xbgr.mr_n78659728)
print v(xbgr.mr_n78660160)
print v(xbgr.mr_n78660592)
print v(xbgr.mr_n78661024)
print v(xbgr.mr_n78661456)
print v(xbgr.mr_n78661888)
print v(xbgr.mr_n78662320)
print v(xbgr.mr_n78662752)
print v(xbgr.mr_n78663184)
print v(xbgr.mr_n78663616)
print v(xbgr.mr_n78664048)
print v(xbgr.mr_n78664480)
print v(xbgr.mr_n78664912)
print v(xbgr.mr_n78665344)
print v(xbgr.mr_n78665776)
print v(xbgr.mr_n78666208)
print v(xbgr.mr_n78666640)
print v(xbgr.mr_n78667072)
print v(xbgr.mr_n78667504)
print v(xbgr.mr_n78667936)
print v(xbgr.mr_n78668368)
print v(xbgr.mr_n78668800)
print v(xbgr.mr_n78669232)
print v(xbgr.mr_n78669664)
print v(xbgr.mr_n78670096)
print v(xbgr.mr_n78670528)
print v(xbgr.mr_n78670960)
print v(xbgr.mr_n78671392)
print v(xbgr.mr_n78671824)
print v(xbgr.mr_n78672256)
print v(xbgr.mr_n78672688)
print v(xbgr.mr_n78673120)
print v(xbgr.mr_n78673552)
print v(xbgr.mr_n78673984)
print v(xbgr.mr_n78674416)
print v(xbgr.mr_n78674848)
print v(xbgr.mr_n78675280)
print v(xbgr.mr_n78675712)
print v(xbgr.mr_n78676144)
print v(xbgr.mr_n78676576)
print v(xbgr.mr_n78677008)
print v(xbgr.mr_n78677440)
print v(xbgr.mr_n78677872)
print v(xbgr.mr_n78678304)
print v(xbgr.mr_n78678736)
print v(xbgr.mr_n78679168)
print v(xbgr.mr_n78679600)
print v(xbgr.mr_n78680032)
print v(xbgr.mr_n78680464)
print v(xbgr.mr_n78680896)
print v(xbgr.mr_n78681328)
print v(xbgr.mr_n78681760)
print v(xbgr.mr_n78682192)
print v(xbgr.mr_n78682624)
print v(xbgr.mr_n78683056)
print v(xbgr.mr_n78683488)
print v(xbgr.mr_n78683920)
print v(xbgr.mr_n78684352)
print v(xbgr.mr_n78684784)
print v(xbgr.mr_n78685216)
print v(xbgr.mr_n78685648)
print v(xbgr.mr_n78686080)
print v(xbgr.mr_n78686512)
print v(xbgr.mr_n78686944)
print v(xbgr.mr_n78687376)
print v(xbgr.mr_n78687808)
print v(xbgr.mr_n78688240)
print v(xbgr.mr_n78688672)
print v(xbgr.mr_n78689104)
print v(xbgr.mr_n78689536)
print v(xbgr.mr_n78689968)
print v(xbgr.mr_n78690400)
print v(xbgr.mr_n78690832)
print v(xbgr.mr_n78691264)
print v(xbgr.mr_n78691696)
print v(xbgr.mr_n78692128)
print v(xbgr.mr_n78692560)
print v(xbgr.mr_n78692992)
print v(xbgr.mr_n78693424)
print v(xbgr.mr_n78693856)
print v(xbgr.mr_n78694288)
print v(xbgr.mr_n78694720)
print v(xbgr.mr_n78695152)
print v(xbgr.mr_n78695584)
print v(xbgr.mr_n78696016)
print v(xbgr.mr_n78696448)
print v(xbgr.mr_n78696880)
print v(xbgr.mr_n78697312)
print v(xbgr.mr_n78697744)
print v(xbgr.mr_n78698176)
print v(xbgr.mr_n78698608)
print v(xbgr.mr_n78699040)
print v(xbgr.mr_n78699472)
print v(xbgr.mr_n78699904)
print v(xbgr.mr_n78700336)
print v(xbgr.mr_n78700768)
print v(xbgr.mr_n78701088)
print v(xbgr.mr_n78701200)
print v(xbgr.mr_n78701520)
print v(xbgr.mr_n78701632)
print v(xbgr.mr_n78701952)
print v(xbgr.mr_n78702064)
print v(xbgr.mr_n78702384)
print v(xbgr.mr_n78702496)
print v(xbgr.mr_n78702816)
print v(xbgr.mr_n78702928)
print v(xbgr.mr_n78703248)
print v(xbgr.mr_n78703360)
print v(xbgr.mr_n78703680)
print v(xbgr.mr_n78703792)
print v(xbgr.mr_n78704112)
print v(xbgr.mr_n78704224)
print v(xbgr.mr_n78704544)
print v(xbgr.mr_n78704656)
print v(xbgr.mr_n78704976)
print v(xbgr.mr_n78705088)
print v(xbgr.mr_n78705408)
print v(xbgr.mr_n78705520)
print v(xbgr.mr_n78705840)
print v(xbgr.mr_n78705952)
print v(xbgr.mr_n78706272)
print v(xbgr.mr_n78706384)
print v(xbgr.mr_n78706704)
print v(xbgr.mr_n78706816)
print v(xbgr.mr_n78707136)
print v(xbgr.mr_n78707248)
print v(xbgr.mr_n78707568)
print v(xbgr.mr_n78707680)
print v(xbgr.mr_n78708000)
print v(xbgr.mr_n78708112)
print v(xbgr.mr_n78708432)
print v(xbgr.mr_n78708544)
print v(xbgr.mr_n78708864)
print v(xbgr.mr_n78708976)
print v(xbgr.mr_n78709296)
print v(xbgr.mr_n78709408)
print v(xbgr.mr_n78709728)
print v(xbgr.mr_n78709840)
print v(xbgr.mr_n78710160)
print v(xbgr.mr_n78710272)
print v(xbgr.mr_n78710592)
print v(xbgr.mr_n78710704)
print v(xbgr.mr_n78711024)
print v(xbgr.mr_n78711136)
print v(xbgr.mr_n78711456)
print v(xbgr.mr_n78711568)
print v(xbgr.mr_n78711888)
print v(xbgr.mr_n78712000)
print v(xbgr.mr_n78712320)
print v(xbgr.mr_n78712432)
print v(xbgr.mr_n78712752)
print v(xbgr.mr_n78712864)
print v(xbgr.mr_n78713184)
print v(xbgr.mr_n78713296)
print v(xbgr.mr_n78713616)
print v(xbgr.mr_n78713728)
print v(xbgr.mr_n78714160)
print v(xbgr.mr_n78714592)
print v(xbgr.mr_n78715024)
print v(xbgr.mr_n78715456)
print v(xbgr.mr_n78715776)
print v(xbgr.mr_n78715888)
print v(xbgr.mr_n78716208)
print v(xbgr.mr_n78716320)
print v(xbgr.mr_n78716640)
print v(xbgr.mr_n78716752)
print v(xbgr.mr_n78717072)
print v(xbgr.mr_n78717184)
print v(xbgr.mr_n78717504)
print v(xbgr.mr_n78717616)
print v(xbgr.mr_n78717936)
print v(xbgr.mr_n78718048)
print v(xbgr.mr_n78718480)
print v(xbgr.mr_n78718912)
print v(xbgr.mr_n78719344)
print v(xbgr.mr_n78719664)
print v(xbgr.mr_n78719776)
print v(xbgr.mr_n78720096)
print v(xbgr.mr_n78720208)
print v(xbgr.mr_n78720528)
print v(xbgr.mr_n78720640)
print v(xbgr.mr_n78720960)
print v(xbgr.mr_n78721072)
print v(xbgr.mr_n78721392)
print v(xbgr.mr_n78721504)
print v(xbgr.mr_n78721824)
print v(xbgr.mr_n78721936)
print v(xbgr.mr_n78722256)
print v(xbgr.mr_n78722368)
print v(xbgr.mr_n78722688)
print v(xbgr.mr_n78722800)
print v(xbgr.mr_n78723120)
print v(xbgr.mr_n78723232)
print v(xbgr.mr_n78723552)
print v(xbgr.mr_n78723664)
print v(xbgr.mr_n78724096)
print v(xbgr.mr_n78724528)
print v(xbgr.mr_n78724960)
print v(xbgr.mr_n78725392)
print v(xbgr.mr_n78725824)
print v(xbgr.mr_n78726256)
print v(xbgr.mr_n78726688)
print v(xbgr.mr_n78727120)
print v(xbgr.mr_n78727552)
print v(xbgr.mr_n78727984)
print v(xbgr.mr_n78728416)
print v(xbgr.mr_n78728848)
print v(xbgr.mr_n78729280)
print v(xbgr.mr_n78729600)
print v(xbgr.mr_n78729712)
print v(xbgr.mr_n78730032)
print v(xbgr.mr_n78730144)
print v(xbgr.mr_n78730464)
print v(xbgr.mr_n78730576)
print v(xbgr.mr_n78730896)
print v(xbgr.mr_n78731008)
print v(xbgr.mr_n78731328)
print v(xbgr.mr_n78731440)
print v(xbgr.mr_n78731872)
print v(xbgr.mr_n78732304)
print v(xbgr.mr_n78732736)
print v(xbgr.mr_n78733168)
print v(xbgr.mr_n78733600)
print v(xbgr.mr_n78734032)
print v(xbgr.mr_n78734352)
print v(xbgr.mr_n78734464)
print v(xbgr.mr_n78734784)
print v(xbgr.mr_n78734896)
print v(xbgr.mr_n78735328)
print v(xbgr.mr_n78735760)
print v(xbgr.mr_n78736080)
print v(xbgr.mr_n78736192)
print v(xbgr.mr_n78736512)
print v(xbgr.mr_n78736624)
print v(xbgr.mr_n78736944)
print v(xbgr.mr_n78737056)
print v(xbgr.mr_n78737376)
print v(xbgr.mr_n78737488)
print v(xbgr.mr_n78737808)
print v(xbgr.mr_n78737920)
print v(xbgr.mr_n78738240)
print v(xbgr.mr_n78738352)
print v(xbgr.mr_n78738672)
print v(xbgr.mr_n78738784)
print v(xbgr.mr_n78739104)
print v(xbgr.mr_n78739216)
print v(xbgr.mr_n78739536)
print v(xbgr.mr_n78739648)
print v(xbgr.mr_n78739968)
print v(xbgr.mr_n78740080)
print v(xbgr.mr_n78740400)
print v(xbgr.mr_n78740512)
print v(xbgr.mr_n78740832)
print v(xbgr.mr_n78740944)
print v(xbgr.mr_n78741264)
print v(xbgr.mr_n78741376)
print v(xbgr.mr_n78741696)
print v(xbgr.mr_n78741808)
print v(xbgr.mr_n78742240)
print v(xbgr.mr_n78742672)
print v(xbgr.mr_n78742992)
print v(xbgr.mr_n78743104)
print v(xbgr.mr_n78743424)
print v(xbgr.mr_n78743536)
print v(xbgr.mr_n78743856)
print v(xbgr.mr_n78743968)
print v(xbgr.mr_n78744288)
print v(xbgr.mr_n78744400)
print v(xbgr.mr_n78744720)
print v(xbgr.mr_n78744832)
print v(xbgr.mr_n78745152)
print v(xbgr.mr_n78745264)
print v(xbgr.mr_n78745696)
print v(xbgr.mr_n78746128)
print v(xbgr.mr_n78746448)
print v(xbgr.mr_n78746560)
print v(xbgr.mr_n78746880)
print v(xbgr.mr_n78746992)
print v(xbgr.mr_n78747312)
print v(xbgr.mr_n78747424)
print v(xbgr.mr_n78747744)
print v(xbgr.mr_n78747856)
print v(xbgr.mr_n78748176)
print v(xbgr.mr_n78748288)
print v(xbgr.mr_n78748608)
print v(xbgr.mr_n78748720)
print v(xbgr.mr_n78749040)
print v(xbgr.mr_n78749152)
print v(xbgr.mr_n78749472)
print v(xbgr.mr_n78749584)
print v(xbgr.mr_n78749904)
print v(xbgr.mr_n78750016)
print v(xbgr.mr_n78750336)
print v(xbgr.mr_n78750448)
print v(xbgr.mr_n78750768)
print v(xbgr.mr_n78750880)
print v(xbgr.mr_n78751200)
print v(xbgr.mr_n78751312)
print v(xbgr.mr_n78751632)
print v(xbgr.mr_n78751744)
print v(xbgr.mr_n78752064)
print v(xbgr.mr_n78752176)
print v(xbgr.mr_n78752496)
print v(xbgr.mr_n78752608)
print v(xbgr.mr_n78752928)
print v(xbgr.mr_n78753040)
print v(xbgr.mr_n78753360)
print v(xbgr.mr_n78753472)
print v(xbgr.mr_n78753792)
print v(xbgr.mr_n78753904)
print v(xbgr.mr_n78754224)
print v(xbgr.mr_n78754336)
print v(xbgr.mr_n78754656)
print v(xbgr.mr_n78754768)
print v(xbgr.mr_n78755088)
print v(xbgr.mr_n78755200)
print v(xbgr.mr_n78755520)
print v(xbgr.mr_n78755632)
print v(xbgr.mr_n78755952)
print v(xbgr.mr_n78756064)
print v(xbgr.mr_n78756384)
print v(xbgr.mr_n78756496)
print v(xbgr.mr_n78756816)
print v(xbgr.mr_n78756928)
print v(xbgr.mr_n78757248)
print v(xbgr.mr_n78757360)
print v(xbgr.mr_n78757680)
print v(xbgr.mr_n78757792)
print v(xbgr.mr_n78758112)
print v(xbgr.mr_n78758224)
print v(xbgr.mr_n78758544)
print v(xbgr.mr_n78758656)
print v(xbgr.mr_n78758976)
print v(xbgr.mr_n78759088)
print v(xbgr.mr_n78759408)
print v(xbgr.mr_n78759520)
print v(xbgr.mr_n78759840)
print v(xbgr.mr_n78759952)
print v(xbgr.mr_n78760272)
print v(xbgr.mr_n78760384)
print v(xbgr.mr_n78760704)
print v(xbgr.mr_n78760816)
print v(xbgr.mr_n78761136)
print v(xbgr.mr_n78761248)
print v(xbgr.mr_n78761568)
print v(xbgr.mr_n78761680)
print v(xbgr.mr_n78762000)
print v(xbgr.mr_n78762112)
print v(xbgr.mr_n78762432)
print v(xbgr.mr_n78762544)
print v(xbgr.mr_n78762864)
print v(xbgr.mr_n78762976)
print v(xbgr.mr_n78763296)
print v(xbgr.mr_n78763408)
print v(xbgr.mr_n78763728)
print v(xbgr.mr_n78763840)
print v(xbgr.mr_n78764160)
print v(xbgr.mr_n78764272)
print v(xbgr.mr_n78764592)
print v(xbgr.mr_n78764704)
print v(xbgr.mr_n78765024)
print v(xbgr.mr_n78765136)
print v(xbgr.mr_n78765456)
print v(xbgr.mr_n78765568)
print v(xbgr.mr_n78765888)
print v(xbgr.mr_n78766000)
print v(xbgr.mr_n78766320)
print v(xbgr.mr_n78766432)
print v(xbgr.mr_n78766752)
print v(xbgr.mr_n78766864)
print v(xbgr.mr_n78767184)
print v(xbgr.mr_n78767296)
print v(xbgr.mr_n78767616)
print v(xbgr.mr_n78767728)
print v(xbgr.mr_n78768048)
print v(xbgr.mr_n78768160)
print v(xbgr.mr_n78768480)
print v(xbgr.mr_n78768592)
print v(xbgr.mr_n78768912)
print v(xbgr.mr_n78769024)
print v(xbgr.mr_n78769344)
print v(xbgr.mr_n78769456)
print v(xbgr.mr_n78769776)
print v(xbgr.mr_n78769888)
print v(xbgr.mr_n78770208)
print v(xbgr.mr_n78770320)
print v(xbgr.mr_n78770640)
print v(xbgr.mr_n78770752)
print v(xbgr.mr_n78771072)
print v(xbgr.mr_n78771184)
print v(xbgr.mr_n78771504)
print v(xbgr.mr_n78771616)
print v(xbgr.mr_n78771936)
print v(xbgr.mr_n78772048)
print v(xbgr.mr_n78772368)
print v(xbgr.mr_n78772480)
print v(xbgr.mr_n78772800)
print v(xbgr.mr_n78772912)
print v(xbgr.mr_n78773232)
print v(xbgr.mr_n78773344)
print v(xbgr.mr_n78773664)
print v(xbgr.mr_n78773776)
print v(xbgr.mr_n78774096)
print v(xbgr.mr_n78774208)
print v(xbgr.mr_n78774528)
print v(xbgr.mr_n78774640)
print v(xbgr.mr_n78774960)
print v(xbgr.mr_n78775072)
print v(xbgr.mr_n78775392)
print v(xbgr.mr_n78775504)
print v(xbgr.mr_n78775824)
print v(xbgr.mr_n78775936)
print v(xbgr.mr_n78776256)
print v(xbgr.mr_n78776368)
print v(xbgr.mr_n78776688)
print v(xbgr.mr_n78776800)
print v(xbgr.mr_n78777120)
print v(xbgr.mr_n78777232)
print v(xbgr.mr_n78777552)
print v(xbgr.mr_n78777664)
print v(xbgr.mr_n78777984)
print v(xbgr.mr_n78778096)
print v(xbgr.mr_n78778416)
print v(xbgr.mr_n78778528)
print v(xbgr.mr_n78778848)
print v(xbgr.mr_n78778960)
print v(xbgr.mr_n78779280)
print v(xbgr.mr_n78779392)
print v(xbgr.mr_n78779712)
print v(xbgr.mr_n78779824)
print v(xbgr.mr_n78780144)
print v(xbgr.mr_n78780256)
print v(xbgr.mr_n78780576)
print v(xbgr.mr_n78780688)
print v(xbgr.mr_n78781008)
print v(xbgr.mr_n78781120)
print v(xbgr.mr_n78781440)
print v(xbgr.mr_n78781552)
print v(xbgr.mr_n78781872)
print v(xbgr.mr_n78781984)
print v(xbgr.mr_n78782304)
print v(xbgr.mr_n78782416)
print v(xbgr.mr_n78782736)
print v(xbgr.mr_n78782848)
print v(xbgr.mr_n78783168)
print v(xbgr.mr_n78783280)
print v(xbgr.mr_n78783600)
print v(xbgr.mr_n78783712)
print v(xbgr.mr_n78784032)
print v(xbgr.mr_n78784144)
print v(xbgr.mr_n78784464)
print v(xbgr.mr_n78784576)
print v(xbgr.mr_n78784896)
print v(xbgr.mr_n78785008)
print v(xbgr.mr_n78785328)
print v(xbgr.mr_n78785440)
print v(xbgr.mr_n78785760)
print v(xbgr.mr_n78785872)
print v(xbgr.mr_n78786192)
print v(xbgr.mr_n78786304)
print v(xbgr.mr_n78786624)
print v(xbgr.mr_n78786736)
print v(xbgr.mr_n78787056)
print v(xbgr.mr_n78787168)
print v(xbgr.mr_n78787488)
print v(xbgr.mr_n78787600)
print v(xbgr.mr_n78787920)
print v(xbgr.mr_n78788032)
print v(xbgr.mr_n78788352)
print v(xbgr.mr_n78788464)
print v(xbgr.mr_n78788784)
print v(xbgr.mr_n78788896)
print v(xbgr.mr_n78789216)
print v(xbgr.mr_n78789328)
print v(xbgr.mr_n78789648)
print v(xbgr.mr_n78789760)
print v(xbgr.mr_n78790080)
print v(xbgr.mr_n78790192)
print v(xbgr.mr_n78790512)
print v(xbgr.mr_n78790624)
print v(xbgr.mr_n78790944)
print v(xbgr.mr_n78791056)
print v(xbgr.mr_n78791376)
print v(xbgr.mr_n78791488)
print v(xbgr.mr_n78791808)
print v(xbgr.mr_n78791920)
print v(xbgr.mr_n78792240)
print v(xbgr.mr_n78792352)
print v(xbgr.mr_n78792672)
print v(xbgr.mr_n78792784)
print v(xbgr.mr_n78793104)
print v(xbgr.mr_n78793216)
print v(xbgr.mr_n78793536)
print v(xbgr.mr_n78793648)
print v(xbgr.mr_n78793968)
print v(xbgr.mr_n78794080)
print v(xbgr.mr_n78794400)
print v(xbgr.mr_n78794512)
print v(xbgr.mr_n78794832)
print v(xbgr.mr_n78794944)
print v(xbgr.mr_n78795264)
print v(xbgr.mr_n78795376)
print v(xbgr.mr_n78795696)
print v(xbgr.mr_n78795808)
print v(xbgr.mr_n78796128)
print v(xbgr.mr_n78796240)
print v(xbgr.mr_n78796560)
print v(xbgr.mr_n78796672)
print v(xbgr.mr_n78797104)
print v(xbgr.mr_n78797536)
print v(xbgr.mr_n78797968)
print v(xbgr.mr_n78798400)
print v(xbgr.mr_n78798832)
print v(xbgr.mr_n78799264)
print v(xbgr.mr_n78799696)
print v(xbgr.mr_n78800128)
print v(xbgr.mr_n78800560)
print v(xbgr.mr_n78800992)
print v(xbgr.mr_n78801424)
print v(xbgr.mr_n78801856)
print v(xbgr.mr_n78802288)
print v(xbgr.mr_n78802720)
print v(xbgr.mr_n78803152)
print v(xbgr.mr_n78803584)
print v(xbgr.mr_n78804016)
print v(xbgr.mr_n78804448)
print v(xbgr.mr_n78804880)
print v(xbgr.mr_n78805312)
print v(xbgr.mr_n78805744)
print v(xbgr.mr_n78806176)
print v(xbgr.mr_n78806608)
print v(xbgr.mr_n78807040)
print v(xbgr.mr_n78807472)
print v(xbgr.mr_n78807904)
print v(xbgr.mr_n78808336)
print v(xbgr.mr_n78808768)
print v(xbgr.mr_n78809200)
print v(xbgr.mr_n78809632)
print v(xbgr.mr_n78810064)
print v(xbgr.mr_n78810496)
print v(xbgr.mr_n78810928)
print v(xbgr.mr_n78811360)
print v(xbgr.mr_n78811680)
print v(xbgr.mr_n78811792)
print v(xbgr.mr_n78812112)
print v(xbgr.mr_n78812224)
print v(xbgr.mr_n78812656)
print v(xbgr.mr_n78812976)
print v(xbgr.mr_n78813088)
print v(xbgr.mr_n78813408)
print v(xbgr.mr_n78813520)
print v(xbgr.mr_n78813840)
print v(xbgr.mr_n78813952)
print v(xbgr.mr_n78814272)
print v(xbgr.mr_n78814384)
print v(xbgr.mr_n78814704)
print v(xbgr.mr_n78814816)
print v(xbgr.mr_n78815136)
print v(xbgr.mr_n78815248)
print v(xbgr.mr_n78815568)
print v(xbgr.mr_n78815680)
print v(xbgr.mr_n78816000)
print v(xbgr.mr_n78816112)
print v(xbgr.mr_n78816544)
print v(xbgr.mr_n78816976)
print v(xbgr.mr_n78817408)
print v(xbgr.mr_n78817840)
print v(xbgr.mr_n78818272)
print v(xbgr.mr_n78818704)
print v(xbgr.mr_n78819136)
print v(xbgr.mr_n78819568)
print v(xbgr.mr_n78820000)
print v(xbgr.mr_n78820320)
print v(xbgr.mr_n78820432)
print v(xbgr.mr_n78820752)
print v(xbgr.mr_n78820864)
print v(xbgr.mr_n78821184)
print v(xbgr.mr_n78821296)
print v(xbgr.mr_n78821616)
print v(xbgr.mr_n78821728)
print v(xbgr.mr_n78822160)
print v(xbgr.mr_n78822592)
print v(xbgr.mr_n78823024)
print v(xbgr.mr_n78823456)
print v(xbgr.mr_n78823888)
print v(xbgr.mr_n78824320)
print v(xbgr.mr_n78824752)
print v(xbgr.mr_n78825184)
print v(xbgr.mr_n78825616)
print v(xbgr.mr_n78826048)
print v(xbgr.mr_n78826480)
print v(xbgr.mr_n78826912)
print v(xbgr.mr_n78827344)
print v(xbgr.mr_n78827776)
print v(xbgr.mr_n78828208)
print v(xbgr.mr_n78828640)
print v(xbgr.mr_n78829072)
print v(xbgr.mr_n78829504)
print v(xbgr.mr_n78829936)
print v(xbgr.mr_n78830368)
print v(xbgr.mr_n78830800)
print v(xbgr.mr_n78831232)
print v(xbgr.mr_n78831664)
print v(xbgr.mr_n78832096)
print v(xbgr.mr_n78832528)
print v(xbgr.mr_n78832960)
print v(xbgr.mr_n78833392)
print v(xbgr.mr_n78833824)
print v(xbgr.mr_n78834256)
print v(xbgr.mr_n78834576)
print v(xbgr.mr_n78834688)
print v(xbgr.mr_n78835008)
print v(xbgr.mr_n78835120)
print v(xbgr.mr_n78835440)
print v(xbgr.mr_n78835552)
print v(xbgr.mr_n78835872)
print v(xbgr.mr_n78835984)
print v(xbgr.mr_n78836304)
print v(xbgr.mr_n78836416)
print v(xbgr.mr_n78836736)
print v(xbgr.mr_n78836848)
print v(xbgr.mr_n79099328)
print v(xbgr.mr_n79100112)
print v(xbgr.mr_n79100976)
print v(xbgr.mr_n79101088)
print v(xbgr.mr_n79101408)
print v(xbgr.mr_n79101840)
print v(xbgr.mr_n79102272)
print v(xbgr.mr_n79102704)
print v(xbgr.mr_n79102816)
print v(xbgr.mr_n79103136)
print v(xbgr.mr_n79103568)
print v(xbgr.mr_n79104000)
print v(xbgr.mr_n79104432)
print v(xbgr.mr_n79104544)
print v(xbgr.mr_n79104864)
print v(xbgr.mr_n79104976)
print v(xbgr.mr_n79105296)
print v(xbgr.mr_n79105408)
print v(xbgr.mr_n79105840)
print v(xbgr.mr_n79106272)
print v(xbgr.mr_n79106704)
print v(xbgr.mr_n79107024)
print v(xbgr.mr_n79107888)
print v(xbgr.mr_n79108000)
print v(xbgr.mr_n79108320)
print v(xbgr.mr_n79108432)
print v(xbgr.mr_n79108752)
print v(xbgr.mr_n79109728)
print v(xbgr.mr_n79110160)
print v(xbgr.mr_n79110480)
print v(xbgr.mr_n79111344)
print v(xbgr.mr_n79111456)
print v(xbgr.mr_n79111776)
print v(xbgr.mr_n79111888)
print v(xbgr.mr_n79112208)
print v(xbgr.mr_n79112320)
print v(xbgr.mr_n79114816)
print v(xbgr.mr_n79115248)
print v(xbgr.mr_n79115568)
print v(xbgr.mr_n79116544)
print v(xbgr.mr_n79116864)
print v(xbgr.mr_n79117840)
print v(xbgr.mr_n79118160)
print v(xbgr.mr_n79119136)
print v(xbgr.mr_n79119456)
print v(xbgr.mr_n79119568)
print v(xbgr.mr_n79120000)
print v(xbgr.mr_n79120432)
print v(xbgr.mr_n79120752)
print v(xbgr.mr_n79121728)
print v(xbgr.mr_n79122048)
print v(xbgr.mr_n79123024)
print v(xbgr.mr_n79123344)
print v(xbgr.mr_n79124320)
print v(xbgr.mr_n79124640)
print v(xbgr.mr_n79124752)
print v(xbgr.mr_n79125504)
print v(xbgr.mr_n79125616)
print v(xbgr.mr_n79126368)
print v(xbgr.mr_n79126480)
print v(xbgr.mr_n79127232)
print v(xbgr.mr_n79127344)
print v(xbgr.mr_n79128096)
print v(xbgr.mr_n79128208)
print v(xbgr.mr_n79128960)
print v(xbgr.mr_n79129072)
print v(xbgr.mr_n79129824)
print v(xbgr.mr_n79129936)
print v(xbgr.mr_n79130688)
print v(xbgr.mr_n79130800)
print v(xbgr.mr_n79131664)
print v(xbgr.mr_n79132096)
print v(xbgr.mr_n79132528)
print v(xbgr.mr_n79132960)
print v(xbgr.mr_n79133392)
print v(xbgr.mr_n79133824)
print v(xbgr.mr_n79134256)
print v(xbgr.mr_n79134688)
print v(xbgr.mr_n79135120)
print v(xbgr.mr_n79135552)
print v(xbgr.mr_n79135984)
print v(xbgr.mr_n79136416)
print v(xbgr.mr_n79136848)
print v(xbgr.mr_n79137280)
print v(xbgr.mr_n79137712)
print v(xbgr.mr_n79138144)
print v(xbgr.mr_n79138576)
print v(xbgr.mr_n79139008)
print v(xbgr.mr_n79139440)
print v(xbgr.mr_n79139872)
print v(xbgr.mr_n79140304)
print v(xbgr.mr_n79140736)
print v(xbgr.mr_n79141168)
print v(xbgr.mr_n79141600)
print v(xbgr.mr_n79201232)
print v(xbgr.mr_n79201744)
print v(xbgr.mr_n79202400)
print v(xbgr.mr_n79202960)
print v(xbgr.mr_n79203296)
print v(xbgr.mr_n79203648)
print v(xbgr.mr_n79204304)
print v(xbgr.mr_n79204544)
print v(xbgr.mr_n79204752)
print v(xbgr.mr_n79205648)
print v(xbgr.mr_n79205888)
print v(xbgr.mr_n79206544)
print v(xbgr.mr_n79208912)
print v(xbgr.mr_n79209872)
print v(xbgr.mr_n79210144)
print v(xbgr.mr_n79213216)
print v(xbgr.mr_n79213552)
print v(xbgr.mr_n79217312)
print v(xbgr.mr_n79217488)
print v(xbgr.mr_n79217824)
print v(xbgr.mr_n79219504)
print v(xbgr.mr_n79220880)
print v(xbgr.mr_n79221056)
print v(xbgr.mr_n79224176)
print v(xbgr.mr_n79226256)
print v(xbgr.mr_n79228592)
print v(xbgr.mr_n79231392)
print v(xbgr.mr_n79231984)
print v(xbgr.mr_n79232288)
print v(xbgr.mr_n79232624)
print v(xbgr.mr_n79233632)
print v(xbgr.mr_n79234976)
print v(xbgr.mr_n79236384)
print v(xbgr.mr_n79236960)
print v(xbgr.mr_n79238352)
print v(xbgr.mr_n79238624)
print v(xbgr.mr_n79241936)
print v(xbgr.mr_n79242208)
print v(xbgr.mr_n79340144)
print v(xbgr.mr_n79342176)
print v(xbgr.mr_n79351344)
print v(xbgr.mr_n79368928)
print v(xbgr.mr_n79371296)
print v(xbgr.mr_n79376416)
print v(xbgr.mr_n79378144)
print v(xbgr.mr_n79380000)
print v(xbgr.mr_n79386544)
print v(xbgr.mr_n79388512)
print v(xbgr.mr_n79392816)
print v(xbgr.mr_n79456464)
print v(xbgr.mr_n79457072)
print v(xbgr.mr_n79459312)
print v(xbgr.mr_n79459552)
print v(xbgr.mr_n79459696)
print v(xbgr.mr_n79461616)
print v(xbgr.mr_n79462448)
print v(xbgr.mr_n79462960)
print v(xbgr.mr_n79466032)
print v(xbgr.mr_n79467168)
print v(xbgr.mr_n79467376)
print v(xbgr.mr_n79467760)
print v(xbgr.mr_n79468512)
print v(xbgr.mr_n79469408)
print v(xbgr.mr_n79469616)
print v(xbgr.mr_n79470512)
print v(xbgr.mr_n79471024)
print v(xbgr.mr_n79472992)
print v(xbgr.mr_n79473440)
print v(xbgr.mr_n79473712)
print v(xbgr.mr_n79473888)
print v(xbgr.mr_n79474432)
print v(xbgr.mr_n79475328)
print v(xbgr.mr_n79478128)
print v(xbgr.mr_n79479088)
print v(xbgr.mr_n79479472)
print v(xbgr.mr_n79480432)
print v(xbgr.mr_n79481152)
print v(xbgr.mr_n79482304)
print v(xbgr.mr_n79482608)
print v(xbgr.mr_n79484912)
print v(xbgr.mr_n79485808)
print v(xbgr.mr_n79487728)
print v(xbgr.mr_n79488496)
print v(xbgr.mr_n79505264)
print v(xbgr.mr_n79511152)
print v(xbgr.mr_n79514032)
print v(xbgr.mr_n79516224)
print v(xbgr.mr_n79517248)
print v(xbgr.mr_n79541552)
print v(xbgr.mr_n79553616)
print v(xbgr.mr_n79553904)
print v(xbgr.mr_n79554096)
print v(xbgr.mr_n79555792)
print v(xbgr.mr_n79558368)
print v(xbgr.mr_n79561024)
print v(xbgr.mr_n79563072)
print v(xbgr.mr_n79563728)
print v(xbgr.mr_n79564224)
print v(xbgr.mr_n79564464)
print v(xbgr.mr_n79566880)
print v(xbgr.mr_n79567984)
print v(xbgr.mr_n79568464)
print v(xbgr.mr_n79569312)
print v(xbgr.mr_n79574304)
print v(xbgr.mr_n79574672)
print v(xbgr.mr_n79575408)
print v(xbgr.mr_n79581296)
print v(xbgr.mr_n79581472)
print v(xbgr.mr_n79582816)
print v(xbgr.mr_n79583008)
print v(xbgr.mr_n79583312)
print v(xbgr.mr_n79583600)
print v(xbgr.mr_n79584000)
print v(xbgr.mr_n79584112)
print v(xbgr.mr_n79586336)
print v(xbgr.mr_n79588800)
print v(xbgr.mr_n79590272)
print v(xbgr.mr_n79590560)
print v(xbgr.mr_n79590800)
print v(xbgr.mr_n79590976)
print v(xbgr.mr_n79591616)
print v(xbgr.mr_n79619856)
print v(xbgr.mr_n79620304)
print v(xbgr.mr_n79624704)
print v(xbgr.mr_n79638176)
print v(xbgr.mr_n79651424)
print v(xbgr.mr_n79696288)
print v(xbgr.mr_n79763488)
print v(xbgr.mr_n79915680)
print v(xbgr.mr_n79916384)
print v(xbgr.mr_n79916624)
print v(xbgr.mr_n79920176)
print v(xbgr.mr_n79954288)
print v(xbgr.mr_n79956560)
print v(xbgr.mr_n79973504)
print v(xbgr.mr_n79979712)
print v(xbgr.mr_n79989744)
print v(xbgr.mr_n79990064)
print v(xbgr.mr_n80014832)
print v(xbgr.mr_n80018496)
print v(xbgr.mr_n80023280)
print v(xbgr.mr_n80023664)
print v(xbgr.mr_n80027760)
print v(xbgr.mr_n80028464)
print v(xbgr.mr_n80030768)
print v(xbgr.mr_n80032496)
print v(xbgr.mr_n80036720)
print v(xbgr.mr_n80047392)
print v(xbgr.mr_n80047824)
print v(xbgr.mr_n80048096)
print v(xbgr.mr_n80048272)
print v(xbgr.mr_n80049936)
print v(xbgr.mr_n80050144)
print v(xbgr.mr_n80050464)
print v(xbgr.mr_n80055824)
print v(xbgr.mr_n80057040)
print v(xbgr.mr_n80057952)
print v(xbgr.mr_n80061888)
print v(xbgr.mr_n80063440)
print v(xbgr.mr_n80064688)
print v(xbgr.mr_n80064800)
print v(xbgr.mr_n80064912)
print v(xbgr.mr_n80065024)
print v(xbgr.mr_n80065328)
print v(xbgr.mr_n80065600)
print v(xbgr.mr_n80065872)
print v(xbgr.mr_n80067984)
print v(xbgr.mr_n80068448)
print v(xbgr.mr_n80068848)
print v(xbgr.mr_n80069376)
print v(xbgr.mr_n80069840)
print v(xbgr.mr_n80070304)
print v(xbgr.mr_n80070768)
print v(xbgr.mr_n80071232)
print v(xbgr.mr_n80071696)
print v(xbgr.mr_n80072160)
print v(xbgr.mr_n80072624)
print v(xbgr.mr_n80076544)
print v(xbgr.mr_n80076784)
print v(xbgr.mr_n80077632)
print v(xbgr.mr_n80080800)
print v(xbgr.mr_n80081648)
print v(xbgr.mr_n80082624)
print v(xbgr.mr_n80083536)
print v(xbgr.mr_n80087616)
print v(xbgr.mr_n80087792)
print v(xbgr.mr_n80088880)
print v(xbgr.mr_n80089376)
print v(xbgr.mr_n80089792)
print v(xbgr.mr_n80090352)
print v(xbgr.mr_n80091344)
print v(xbgr.mr_n80091984)
print v(xbgr.mr_n80093024)
print v(xbgr.mr_n80095376)
print v(xbgr.mr_n80097424)
print v(xbgr.mr_n80100736)
print v(xbgr.mr_n80101264)
print v(xbgr.mr_n80102144)
print v(xbgr.mr_n80103696)
print v(xbgr.mr_n80105104)
print v(xbgr.mr_n80105872)
print v(xbgr.mr_n80106048)
print v(xbgr.mr_n80107072)
print v(xbgr.mr_n80107280)
print v(xbgr.mr_n80107984)
print v(xbgr.mr_n80108480)
print v(xbgr.mr_n80109456)
print v(xbgr.mr_n80110160)
print v(xbgr.mr_n80112208)
print v(xbgr.mr_n80113616)
print v(xbgr.mr_n80117136)
print v(xbgr.mr_n80117632)
print v(xbgr.mr_n80118336)
print v(xbgr.mr_n80119040)
print v(xbgr.mr_n80120448)
print v(xbgr.mr_n80120656)
print v(xbgr.mr_n80124672)
print v(xbgr.mr_n80124880)
print v(xbgr.mr_n80125376)
print v(xbgr.mr_n80125520)
print v(xbgr.mr_n80126080)
print v(xbgr.mr_n80130304)
print v(xbgr.mr_n80130512)
print v(xbgr.mr_n80134032)
print v(xbgr.mr_n80135552)
print v(xbgr.mr_n80135936)
print v(xbgr.mr_n80137552)
print v(xbgr.mr_n80140256)
print v(xbgr.mr_n80140368)
print v(xbgr.mr_n80141568)
print v(xbgr.mr_n80144416)
print v(xbgr.mr_n80145360)
print v(xbgr.mr_n80146640)
print v(xbgr.mr_n80147200)
print v(xbgr.mr_n80147904)
print v(xbgr.mr_n80149216)
print v(xbgr.mr_n80152896)
print v(xbgr.mr_n80154704)
print v(xbgr.mr_n80155232)
print v(xbgr.mr_n80155696)
print v(xbgr.mr_n80156160)
print v(xbgr.mr_n80156624)
print v(xbgr.mr_n80157088)
print v(xbgr.mr_n80157552)
print v(xbgr.mr_n80158016)
print v(xbgr.mr_n80158480)
print v(xbgr.mr_n80158944)
print v(xbgr.mr_n80159344)
print v(xbgr.mr_n80159968)
print v(xbgr.mr_n80161616)
print v(xbgr.mr_n80161728)
print v(xbgr.mr_n80162400)
print v(xbgr.mr_n80163008)
print v(xbgr.mr_n80163552)
print v(xbgr.mr_n80163856)
print v(xbgr.mr_n80165328)
print v(xbgr.mr_n80165440)
print v(xbgr.mr_n80167264)
print v(xbgr.mr_n80168112)
print v(xbgr.mr_n80170480)
print v(xbgr.mr_n80170912)
print v(xbgr.mr_n80171168)
print v(xbgr.mr_n80171824)
print v(xbgr.mr_n80173888)
print v(xbgr.mr_n80174000)
print v(xbgr.mr_n80174864)
print v(xbgr.mr_n80175712)
print v(xbgr.mr_n80177232)
print v(xbgr.mr_n80181904)
print v(xbgr.mr_n80184032)
print v(xbgr.mr_n80184272)
print v(xbgr.mr_n80187616)
print v(xbgr.mr_n80187984)
print v(xbgr.mr_n80191120)
print v(xbgr.mr_n80191680)
print v(xbgr.mr_n80192128)
print v(xbgr.mr_n80193136)
print v(xbgr.mr_n80194528)
print v(xbgr.mr_n80195152)
print v(xbgr.mr_n80196896)
print v(xbgr.mr_n80198816)
print v(xbgr.mr_n80203648)
print v(xbgr.mr_n80203840)
print v(xbgr.mr_n80205952)
print v(xbgr.mr_n80206352)
print v(xbgr.mr_n80206880)
print v(xbgr.mr_n80207344)
print v(xbgr.mr_n80207808)
print v(xbgr.mr_n80208272)
print v(xbgr.mr_n80208736)
print v(xbgr.mr_n80209200)
print v(xbgr.mr_n80209664)
print v(xbgr.mr_n80210128)
print v(xbgr.mr_n80210400)
print v(xbgr.mr_n80210592)
print v(xbgr.mr_n80210992)
print v(xbgr.mr_n80211520)
print v(xbgr.mr_n80211984)
print v(xbgr.mr_n80212448)
print v(xbgr.mr_n80212912)
print v(xbgr.mr_n80213376)
print v(xbgr.mr_n80213840)
print v(xbgr.mr_n80214304)
print v(xbgr.mr_n80214704)
print v(xbgr.mr_n80215232)
print v(xbgr.mr_n80215696)
print v(xbgr.mr_n80216160)
print v(xbgr.mr_n80216624)
print v(xbgr.mr_n80217088)
print v(xbgr.mr_n80217552)
print v(xbgr.mr_n80218016)
print v(xbgr.mr_n80218480)
print v(xbgr.mr_n80218944)
print v(xbgr.mr_n80219344)
print v(xbgr.mr_n80219872)
print v(xbgr.mr_n80220272)
print v(xbgr.mr_n80220800)
print v(xbgr.mr_n80221264)
print v(xbgr.mr_n80221728)
print v(xbgr.mr_n80222192)
print v(xbgr.mr_n80222656)
print v(xbgr.mr_n80223120)
print v(xbgr.mr_n80223584)
print v(xbgr.mr_n80223920)
print v(xbgr.mr_n80224448)
print v(xbgr.mr_n80224784)
print v(xbgr.mr_n80225296)
print v(xbgr.mr_n80225760)
print v(xbgr.mr_n80226224)
print v(xbgr.mr_n80226688)
print v(xbgr.mr_n80227152)
print v(xbgr.mr_n80227616)
print v(xbgr.mr_n80228080)
print v(xbgr.mr_n80228480)
print v(xbgr.mr_n80228896)
print v(xbgr.mr_n80229008)
print v(xbgr.mr_n80229408)
print v(xbgr.mr_n80229936)
print v(xbgr.mr_n80230400)
print v(xbgr.mr_n80230864)
print v(xbgr.mr_n80231328)
print v(xbgr.mr_n80231792)
print v(xbgr.mr_n80232256)
print v(xbgr.mr_n80232720)
print v(xbgr.mr_n80233120)
print v(xbgr.mr_n80233648)
print v(xbgr.mr_n80234048)
print v(xbgr.mr_n80234576)
print v(xbgr.mr_n80235040)
print v(xbgr.mr_n80235504)
print v(xbgr.mr_n80235968)
print v(xbgr.mr_n80236432)
print v(xbgr.mr_n80236896)
print v(xbgr.mr_n80237360)
print v(xbgr.mr_n80237760)
print v(xbgr.mr_n80238288)
print v(xbgr.mr_n80238688)
print v(xbgr.mr_n80239216)
print v(xbgr.mr_n80239680)
print v(xbgr.mr_n80239984)
print v(xbgr.mr_n80240144)
print v(xbgr.mr_n80240608)
print v(xbgr.mr_n80241072)
print v(xbgr.mr_n80241536)
print v(xbgr.mr_n80242000)
print v(xbgr.mr_n80242400)
print v(xbgr.mr_n80242928)
print v(xbgr.mr_n80243392)
print v(xbgr.mr_n80243856)
print v(xbgr.mr_n80244128)
print v(xbgr.mr_n80244320)
print v(xbgr.mr_n80244784)
print v(xbgr.mr_n80245248)
print v(xbgr.mr_n80245712)
print v(xbgr.mr_n80246176)
print v(xbgr.mr_n80246640)
print v(xbgr.mr_n80247040)
print v(xbgr.mr_n80247568)
print v(xbgr.mr_n80247968)
print v(xbgr.mr_n80248496)
print v(xbgr.mr_n80248960)
print v(xbgr.mr_n80249424)
print v(xbgr.mr_n80249888)
print v(xbgr.mr_n80250352)
print v(xbgr.mr_n80250816)
print v(xbgr.mr_n80251280)
print v(xbgr.mr_n80251680)
print v(xbgr.mr_n80252208)
print v(xbgr.mr_n80252608)
print v(xbgr.mr_n80253136)
print v(xbgr.mr_n80253600)
print v(xbgr.mr_n80254064)
print v(xbgr.mr_n80254528)
print v(xbgr.mr_n80254992)
print v(xbgr.mr_n80255456)
print v(xbgr.mr_n80255920)
print v(xbgr.mr_n80256320)
print v(xbgr.mr_n80256848)
print v(xbgr.mr_n80257312)
print v(xbgr.mr_n80257776)
print v(xbgr.mr_n80258240)
print v(xbgr.mr_n80258704)
print v(xbgr.mr_n80259168)
print v(xbgr.mr_n80259632)
print v(xbgr.mr_n80260096)
print v(xbgr.mr_n80260560)
print v(xbgr.mr_n80260960)
print v(xbgr.mr_n80261072)
print v(xbgr.mr_n80261536)
print v(xbgr.mr_n80261648)
print v(xbgr.mr_n80262272)
print v(xbgr.mr_n80262496)
print v(xbgr.mr_n80263008)
print v(xbgr.mr_n80263232)
print v(xbgr.mr_n80263744)
print v(xbgr.mr_n80263856)
print v(xbgr.mr_n80263968)
print v(xbgr.mr_n80264480)
print v(xbgr.mr_n80264592)
print v(xbgr.mr_n80264704)
print v(xbgr.mr_n80265216)
print v(xbgr.mr_n80265328)
print v(xbgr.mr_n80265440)
print v(xbgr.mr_n80265952)
print v(xbgr.mr_n80266224)
print v(xbgr.mr_n80266496)
print v(xbgr.mr_n80266880)
print v(xbgr.mr_n80266992)
print v(xbgr.mr_n80267504)
print v(xbgr.mr_n80267776)
print v(xbgr.mr_n80268048)
print v(xbgr.mr_n80268320)
print v(xbgr.mr_n80268592)
print v(xbgr.mr_n80269136)
print v(xbgr.mr_n80269408)
print v(xbgr.mr_n80269680)
print v(xbgr.mr_n80269952)
print v(xbgr.mr_n80270224)
print v(xbgr.mr_n80270496)
print v(xbgr.mr_n80270768)
print v(xbgr.mr_n80271040)
print v(xbgr.mr_n80271312)
print v(xbgr.mr_n80271584)
print v(xbgr.mr_n80271856)
print v(xbgr.mr_n80272128)
print v(xbgr.mr_n80272400)
print v(xbgr.mr_n80272672)
print v(xbgr.mr_n80272944)
print v(xbgr.mr_n80273216)
print v(xbgr.mr_n80273488)
print v(xbgr.mr_n80273760)
print v(xbgr.mr_n80274032)
print v(xbgr.mr_n80274496)
print v(xbgr.mr_n80274768)
print v(xbgr.mr_n80274960)
print v(xbgr.mr_n80275424)
print v(xbgr.mr_n80275888)
print v(xbgr.mr_n80276352)
print v(xbgr.mr_n80276816)
print v(xbgr.mr_n80277280)
print v(xbgr.mr_n80277744)
print v(xbgr.mr_n80278208)
print v(xbgr.mr_n80278672)
print v(xbgr.mr_n80279136)
print v(xbgr.mr_n80279600)
print v(xbgr.mr_n80283920)
print v(xbgr.mr_n80284496)
print v(xbgr.mr_n80284992)
print v(xbgr.mr_n80288720)
print v(xbgr.mr_n80290176)
print v(xbgr.mr_n80291520)
print v(xbgr.mr_n80292352)
print v(xbgr.mr_n80293456)
print v(xbgr.mr_n80294720)
print v(xbgr.mr_n80296784)
print v(xbgr.mr_n80297312)
print v(xbgr.mr_n80297904)
print v(xbgr.mr_n80298432)
print v(xbgr.mr_n80299088)
print v(xbgr.mr_n80299680)
print v(xbgr.mr_n80300272)
print v(xbgr.mr_n80300784)
print v(xbgr.mr_n80301520)
print v(xbgr.mr_n80302048)
print v(xbgr.mr_n80302640)
print v(xbgr.mr_n80303168)
print v(xbgr.mr_n80303824)
print v(xbgr.mr_n80304416)
print v(xbgr.mr_n80305008)
print v(xbgr.mr_n80305376)
print v(xbgr.mr_n80305600)
print v(xbgr.mr_n80306192)
print v(xbgr.mr_n80306784)
print v(xbgr.mr_n80307296)
print v(xbgr.mr_n80307968)
print v(xbgr.mr_n80308560)
print v(xbgr.mr_n80309152)
print v(xbgr.mr_n80309664)
print v(xbgr.mr_n80310336)
print v(xbgr.mr_n80310928)
print v(xbgr.mr_n80311520)
print v(xbgr.mr_n80312112)
print v(xbgr.mr_n80312704)
print v(xbgr.mr_n80313296)
print v(xbgr.mr_n80313888)
print v(xbgr.mr_n80314768)
print v(xbgr.mr_n80322736)
print v(xbgr.mr_n80327312)
print v(xbgr.mr_n80328464)
print v(xbgr.mr_n80330656)
print v(xbgr.mr_n80333760)
print v(xbgr.mr_n80333936)
print v(xbgr.mr_n80334288)
print v(xbgr.mr_n80337872)
print v(xbgr.mr_n80342320)
print v(xbgr.mr_n80344832)
print v(xbgr.mr_n80351920)
print v(xbgr.mr_n80359952)
print v(xbgr.mr_n80361344)
print v(xbgr.mr_n80361952)
print v(xbgr.mr_n80362064)
print v(xbgr.mr_n80362672)
print v(xbgr.mr_n80362784)
print v(xbgr.mr_n80363392)
print v(xbgr.mr_n80363504)
print v(xbgr.mr_n80364112)
print v(xbgr.mr_n80364832)
print v(xbgr.mr_n80364944)
print v(xbgr.mr_n80365552)
print v(xbgr.mr_n80366496)
print v(xbgr.mr_n80371952)
print v(xbgr.mr_n80372192)
print v(xbgr.mr_n80372560)
print v(xbgr.mr_n80372800)
print v(xbgr.mr_n80373712)
print v(xbgr.mr_n80374016)
print v(xbgr.mr_n80374992)
print v(xbgr.mr_n80375232)
print v(xbgr.mr_n80375840)
print v(xbgr.mr_n80376448)
print v(xbgr.mr_n80377360)
print v(xbgr.mr_n80377936)
print v(xbgr.mr_n80378640)
print v(xbgr.mr_n80380464)
print v(xbgr.mr_n80382592)
print v(xbgr.mr_n80382896)
print v(xbgr.mr_n80384112)
print v(xbgr.mr_n80384352)
print v(xbgr.mr_n80385568)
print v(xbgr.mr_n80388672)
print v(xbgr.mr_n80389280)
print v(xbgr.mr_n80390368)
print v(xbgr.mr_n80390800)
print v(xbgr.mr_n80391040)
print v(xbgr.mr_n80391408)
print v(xbgr.mr_n80391648)
print v(xbgr.mr_n80392560)
print v(xbgr.mr_n80392992)
print v(xbgr.mr_n80394272)
print v(xbgr.mr_n80397120)
print v(xbgr.mr_n80397424)
print v(xbgr.mr_n80398336)
print v(xbgr.mr_n80400592)
print v(xbgr.mr_n80400768)
print v(xbgr.mr_n80402912)
print v(xbgr.mr_n80404672)
print v(xbgr.mr_n80404928)
print v(xbgr.mr_n80405136)
print v(xbgr.mr_n80405376)
print v(xbgr.mr_n80408160)
print v(xbgr.mr_n80408400)
print v(xbgr.mr_n80409408)
print v(xbgr.mr_n80410416)
print v(xbgr.mr_n80411424)
print v(xbgr.mr_n80411664)
print v(xbgr.mr_n80411984)
print v(xbgr.mr_n80412432)
print v(xbgr.mr_n80412864)
print v(xbgr.mr_n80413264)
print v(xbgr.mr_n80413872)
print v(xbgr.mr_n80414192)
print v(xbgr.mr_n80418752)
print v(xbgr.mr_n80418928)
print v(xbgr.mr_n80419104)
print v(xbgr.mr_n80421008)
print v(xbgr.mr_n80421520)
print v(xbgr.mr_n80422112)
print v(xbgr.mr_n80422704)
print v(xbgr.mr_n80423296)
print v(xbgr.mr_n80423888)
print v(xbgr.mr_n80424480)
print v(xbgr.mr_n80425072)
print v(xbgr.mr_n80425664)
print v(xbgr.mr_n80426256)
print v(xbgr.mr_n80426848)
print v(xbgr.mr_n80427440)
print v(xbgr.mr_n80428032)
print v(xbgr.mr_n80428624)
print v(xbgr.mr_n80429152)
print v(xbgr.mr_n80429808)
print v(xbgr.mr_n80430400)
print v(xbgr.mr_n80430912)
print v(xbgr.mr_n80431584)
print v(xbgr.mr_n80432176)
print v(xbgr.mr_n80432768)
print v(xbgr.mr_n80433360)
print v(xbgr.mr_n80433888)
print v(xbgr.mr_n80434544)
print v(xbgr.mr_n80435136)
print v(xbgr.mr_n80435728)
print v(xbgr.mr_n80436320)
print v(xbgr.mr_n80436912)
print v(xbgr.mr_n80437504)
print v(xbgr.mr_n80438096)
print v(xbgr.mr_n80438688)
print v(xbgr.mr_n80439280)
print v(xbgr.mr_n80439872)
print v(xbgr.mr_n80440464)
print v(xbgr.mr_n80441056)
print v(xbgr.mr_n80442240)
print v(xbgr.mr_n80442832)
print v(xbgr.mr_n80443344)
print v(xbgr.mr_n80444016)
print v(xbgr.mr_n80444432)
print v(xbgr.mr_n80444608)
print v(xbgr.mr_n80444944)
print v(xbgr.mr_n80445728)
print v(xbgr.mr_n80446384)
print v(xbgr.mr_n80446976)
print v(xbgr.mr_n80447568)
print v(xbgr.mr_n80448160)
print v(xbgr.mr_n80448752)
print v(xbgr.mr_n80449344)
print v(xbgr.mr_n80449488)
print v(xbgr.mr_n80449600)
print v(xbgr.mr_n80450208)
print v(xbgr.mr_n80450912)
print v(xbgr.mr_n80451472)
print v(xbgr.mr_n80452704)
print v(xbgr.mr_n80453328)
print v(xbgr.mr_n80453920)
print v(xbgr.mr_n80454512)
print v(xbgr.mr_n80455104)
print v(xbgr.mr_n80455680)
print v(xbgr.mr_n80456272)
print v(xbgr.mr_n80456864)
print v(xbgr.mr_n80457456)
print v(xbgr.mr_n80458048)
print v(xbgr.mr_n80458640)
print v(xbgr.mr_n80459232)
print v(xbgr.mr_n80459824)
print v(xbgr.mr_n80460416)
print v(xbgr.mr_n80461008)
print v(xbgr.mr_n80461520)
print v(xbgr.mr_n80462192)
print v(xbgr.mr_n80462784)
print v(xbgr.mr_n80463376)
print v(xbgr.mr_n80463968)
print v(xbgr.mr_n80464560)
print v(xbgr.mr_n80465152)
print v(xbgr.mr_n80465744)
print v(xbgr.mr_n80466336)
print v(xbgr.mr_n80466928)
print v(xbgr.mr_n80467520)
print v(xbgr.mr_n80468112)
print v(xbgr.mr_n80468704)
print v(xbgr.mr_n80469120)
print v(xbgr.mr_n80469296)
print v(xbgr.mr_n80469888)
print v(xbgr.mr_n80470480)
print v(xbgr.mr_n80470992)
print v(xbgr.mr_n80471664)
print v(xbgr.mr_n80472256)
print v(xbgr.mr_n80472848)
print v(xbgr.mr_n80473440)
print v(xbgr.mr_n80474032)
print v(xbgr.mr_n80474624)
print v(xbgr.mr_n80475216)
print v(xbgr.mr_n80475808)
print v(xbgr.mr_n80476400)
print v(xbgr.mr_n80476992)
print v(xbgr.mr_n80477584)
print v(xbgr.mr_n80478176)
print v(xbgr.mr_n80478768)
print v(xbgr.mr_n80479360)
print v(xbgr.mr_n80479952)
print v(xbgr.mr_n80480544)
print v(xbgr.mr_n80481136)
print v(xbgr.mr_n80481728)
print v(xbgr.mr_n80482320)
print v(xbgr.mr_n80482912)
print v(xbgr.mr_n80483424)
print v(xbgr.mr_n80484096)
print v(xbgr.mr_n80484688)
print v(xbgr.mr_n80485280)
print v(xbgr.mr_n80485872)
print v(xbgr.mr_n80486464)
print v(xbgr.mr_n80487056)
print v(xbgr.mr_n80487648)
print v(xbgr.mr_n80488160)
print v(xbgr.mr_n80488832)
print v(xbgr.mr_n80489424)
print v(xbgr.mr_n80490016)
print v(xbgr.mr_n80490608)
print v(xbgr.mr_n80491200)
print v(xbgr.mr_n80492304)
print v(xbgr.mr_n80493568)
print v(xbgr.mr_n80494160)
print v(xbgr.mr_n80494752)
print v(xbgr.mr_n80495344)
print v(xbgr.mr_n80495936)
print v(xbgr.mr_n80496528)
print v(xbgr.mr_n80497120)
print v(xbgr.mr_n80497712)
print v(xbgr.mr_n80498304)
print v(xbgr.mr_n80499136)
print v(xbgr.mr_n80499376)
print v(xbgr.mr_n80499616)
print v(xbgr.mr_n80500256)
print v(xbgr.mr_n80501056)
print v(xbgr.mr_n80501456)
print v(xbgr.mr_n80501856)
print v(xbgr.mr_n80502256)
print v(xbgr.mr_n80502656)
print v(xbgr.mr_n80503760)
print v(xbgr.mr_n80505712)
print v(xbgr.mr_n80509664)
print v(xbgr.mr_n80514208)
print v(xbgr.mr_n80515552)
print v(xbgr.mr_n80522128)
print v(xbgr.mr_n80528832)
print v(xbgr.mr_n80529504)
print v(xbgr.mr_n80531184)
print v(xbgr.mr_n80532016)
print v(xbgr.mr_n80532768)
print v(xbgr.mr_n80533920)
print v(xbgr.mr_n80534512)
print v(xbgr.mr_n80535104)
print v(xbgr.mr_n80535696)
print v(xbgr.mr_n80536112)
print v(xbgr.mr_n80536288)
print v(xbgr.mr_n80536880)
print v(xbgr.mr_n80537472)
print v(xbgr.mr_n80538064)
print v(xbgr.mr_n80538656)
print v(xbgr.mr_n80539248)
print v(xbgr.mr_n80539840)
print v(xbgr.mr_n80548448)
print v(xbgr.mr_n80549216)
print v(xbgr.mr_n80550288)
print v(xbgr.mr_n80550688)
print v(xbgr.mr_n80551376)
print v(xbgr.mr_n80552032)
print v(xbgr.mr_n80552416)
print v(xbgr.mr_n80559712)
print v(xbgr.mr_n80573872)
print v(xbgr.mr_n80574592)
print v(xbgr.mr_n80575568)
print v(xbgr.mr_n80576368)
print v(xbgr.mr_n80577248)
print v(xbgr.mr_n80577392)
print v(xbgr.mr_n80578368)
print v(xbgr.mr_n80578960)
print v(xbgr.mr_n80579552)
print v(xbgr.mr_n80580144)
print v(xbgr.mr_n80580736)
print v(xbgr.mr_n80581328)
print v(xbgr.mr_n80582512)
print v(xbgr.mr_n80583104)
print v(xbgr.mr_n80583696)
print v(xbgr.mr_n80584288)
print v(xbgr.mr_n80584752)
print v(xbgr.mr_n80584864)
print v(xbgr.mr_n80585264)
print v(xbgr.mr_n80585888)
print v(xbgr.mr_n80586800)
print v(xbgr.mr_n80587392)
print v(xbgr.mr_n80588576)
print v(xbgr.mr_n80589168)
print v(xbgr.mr_n80589760)
print v(xbgr.mr_n80590352)
print v(xbgr.mr_n80590944)
print v(xbgr.mr_n80591536)
print v(xbgr.mr_n80592128)
print v(xbgr.mr_n80592720)
print v(xbgr.mr_n80593312)
print v(xbgr.mr_n80593904)
print v(xbgr.mr_n80594496)
print v(xbgr.mr_n80595088)
print v(xbgr.mr_n80595680)
print v(xbgr.mr_n80596272)
print v(xbgr.mr_n80596864)
print v(xbgr.mr_n80597456)
print v(xbgr.mr_n80598048)
print v(xbgr.mr_n80598640)
print v(xbgr.mr_n80599232)
print v(xbgr.mr_n80599824)
print v(xbgr.mr_n80601008)
print v(xbgr.mr_n80601600)
print v(xbgr.mr_n80602784)
print v(xbgr.mr_n80603376)
print v(xbgr.mr_n80603968)
print v(xbgr.mr_n80604384)
print v(xbgr.mr_n80604560)
print v(xbgr.mr_n80605152)
print v(xbgr.mr_n80605744)
print v(xbgr.mr_n80606336)
print v(xbgr.mr_n80606928)
print v(xbgr.mr_n80607520)
print v(xbgr.mr_n80608112)
print v(xbgr.mr_n80608704)
print v(xbgr.mr_n80609296)
print v(xbgr.mr_n80609888)
print v(xbgr.mr_n80610480)
print v(xbgr.mr_n80611072)
print v(xbgr.mr_n80611664)
print v(xbgr.mr_n80612256)
print v(xbgr.mr_n80612848)
print v(xbgr.mr_n80613440)
print v(xbgr.mr_n80614032)
print v(xbgr.mr_n80614624)
print v(xbgr.mr_n80615216)
print v(xbgr.mr_n80615808)
print v(xbgr.mr_n80616992)
print v(xbgr.mr_n80617584)
print v(xbgr.mr_n80618176)
print v(xbgr.mr_n80618512)
print v(xbgr.mr_n80618768)
print v(xbgr.mr_n80619360)
print v(xbgr.mr_n80619952)
print v(xbgr.mr_n80620544)
print v(xbgr.mr_n80621136)
print v(xbgr.mr_n80621728)
print v(xbgr.mr_n80622320)
print v(xbgr.mr_n80622912)
print v(xbgr.mr_n80623504)
print v(xbgr.mr_n80624096)
print v(xbgr.mr_n80624688)
print v(xbgr.mr_n80625280)
print v(xbgr.mr_n80625872)
print v(xbgr.mr_n80626464)
print v(xbgr.mr_n80627056)
print v(xbgr.mr_n80627648)
print v(xbgr.mr_n80628064)
print v(xbgr.mr_n80628240)
print v(xbgr.mr_n80628832)
print v(xbgr.mr_n80629424)
print v(xbgr.mr_n80630016)
print v(xbgr.mr_n80630608)
print v(xbgr.mr_n80631200)
print v(xbgr.mr_n80631792)
print v(xbgr.mr_n80632384)
print v(xbgr.mr_n80632976)
print v(xbgr.mr_n80633568)
print v(xbgr.mr_n80634160)
print v(xbgr.mr_n80634752)
print v(xbgr.mr_n80635344)
print v(xbgr.mr_n80635936)
print v(xbgr.mr_n80636528)
print v(xbgr.mr_n80637120)
print v(xbgr.mr_n80637712)
print v(xbgr.mr_n80638304)
print v(xbgr.mr_n80638896)
print v(xbgr.mr_n80639488)
print v(xbgr.mr_n80640080)
print v(xbgr.mr_n80640672)
print v(xbgr.mr_n80641264)
print v(xbgr.mr_n80641856)
print v(xbgr.mr_n80642448)
print v(xbgr.mr_n80643040)
print v(xbgr.mr_n80643632)
print v(xbgr.mr_n80644224)
print v(xbgr.mr_n80644816)
print v(xbgr.mr_n80645408)
print v(xbgr.mr_n80646000)
print v(xbgr.mr_n80646592)
print v(xbgr.mr_n80647184)
print v(xbgr.mr_n80648064)
print v(xbgr.mr_n80648528)
print v(xbgr.mr_n80648640)
print v(xbgr.mr_n80648992)
print v(xbgr.mr_n80649456)
print v(xbgr.mr_n80649568)
print v(xbgr.mr_n80649920)
print v(xbgr.mr_n80650032)
print v(xbgr.mr_n80651520)
print v(xbgr.mr_n80651776)
print v(xbgr.mr_n80652112)
print v(xbgr.mr_n80652752)
print v(xbgr.mr_n80653152)
print v(xbgr.mr_n80653552)
print v(xbgr.mr_n80653952)
print v(xbgr.mr_n80654352)
print v(xbgr.mr_n80654752)
print v(xbgr.mr_n80655152)
print v(xbgr.mr_n80655552)
print v(xbgr.mr_n80655952)
print v(xbgr.mr_n80656352)
print v(xbgr.mr_n80656752)
print v(xbgr.mr_n80657152)
print v(xbgr.mr_n80657552)
print v(xbgr.mr_n80657952)
print v(xbgr.mr_n80658352)
print v(xbgr.mr_n80658752)
print v(xbgr.mr_n80659152)
print v(xbgr.mr_n80659552)
print v(xbgr.mr_n80659952)
print v(xbgr.mr_n80660352)
print v(xbgr.mr_n80660752)
print v(xbgr.mr_n80661152)
print v(xbgr.mr_n80661552)
print v(xbgr.mr_n80661952)
print v(xbgr.mr_n80662352)
print v(xbgr.mr_n80662752)
print v(xbgr.mr_n80663152)
print v(xbgr.mr_n80663552)
print v(xbgr.mr_n80663952)
print v(xbgr.mr_n80664352)
print v(xbgr.mr_n80664752)
print v(xbgr.mr_n80665152)
print v(xbgr.mr_n80665552)
print v(xbgr.mr_n80665952)
print v(xbgr.mr_n80666352)
print v(xbgr.mr_n80666752)
print v(xbgr.mr_n80667216)
print v(xbgr.mr_n80667744)
print v(xbgr.mr_n80668400)
print v(xbgr.mr_n80668992)
print v(xbgr.mr_n80669584)
print v(xbgr.mr_n80670176)
print v(xbgr.mr_n80670768)
print v(xbgr.mr_n80671296)
print v(xbgr.mr_n80671952)
print v(xbgr.mr_n80672480)
print v(xbgr.mr_n80673136)
print v(xbgr.mr_n80685184)
print v(xbgr.mr_n80688512)
print v(xbgr.mr_n80690192)
print v(xbgr.mr_n80690784)
print v(xbgr.mr_n80691376)
print v(xbgr.mr_n80691968)
print v(xbgr.mr_n80692560)
print v(xbgr.mr_n80693152)
print v(xbgr.mr_n80693744)
print v(xbgr.mr_n80694336)
print v(xbgr.mr_n80694672)
print v(xbgr.mr_n80694928)
print v(xbgr.mr_n80695520)
print v(xbgr.mr_n80696112)
print v(xbgr.mr_n80696528)
print v(xbgr.mr_n80696704)
print v(xbgr.mr_n80697296)
print v(xbgr.mr_n80697888)
print v(xbgr.mr_n80698480)
print v(xbgr.mr_n80699072)
print v(xbgr.mr_n80699664)
print v(xbgr.mr_n80700256)
print v(xbgr.mr_n80700848)
print v(xbgr.mr_n80701440)
print v(xbgr.mr_n80702560)
print v(xbgr.mr_n80703808)
print v(xbgr.mr_n80704400)
print v(xbgr.mr_n80704816)
print v(xbgr.mr_n80704992)
print v(xbgr.mr_n80705328)
print v(xbgr.mr_n80705584)
print v(xbgr.mr_n80706112)
print v(xbgr.mr_n80706768)
print v(xbgr.mr_n80707360)
print v(xbgr.mr_n80707952)
print v(xbgr.mr_n80708544)
print v(xbgr.mr_n80709136)
print v(xbgr.mr_n80709728)
print v(xbgr.mr_n80710320)
print v(xbgr.mr_n80710848)
print v(xbgr.mr_n80711504)
print v(xbgr.mr_n80712032)
print v(xbgr.mr_n80712688)
print v(xbgr.mr_n80713280)
print v(xbgr.mr_n80713872)
print v(xbgr.mr_n80714464)
print v(xbgr.mr_n80715056)
print v(xbgr.mr_n80715648)
print v(xbgr.mr_n80716240)
print v(xbgr.mr_n80716832)
print v(xbgr.mr_n80717424)
print v(xbgr.mr_n80718080)
print v(xbgr.mr_n80719552)
print v(xbgr.mr_n80720656)
print v(xbgr.mr_n80723392)
print v(xbgr.mr_n80726240)
print v(xbgr.mr_n80727168)
print v(xbgr.mr_n80727472)
print v(xbgr.mr_n80727776)
print v(xbgr.mr_n80727888)
print v(xbgr.mr_n80728944)
print v(xbgr.mr_n80732384)
print v(xbgr.mr_n80736240)
print v(xbgr.mr_n80740848)
print v(xbgr.mr_n80743200)
print v(xbgr.mr_n80743760)
print v(xbgr.mr_n80749888)
print v(xbgr.mr_n80759024)
print v(xbgr.mr_n80761280)
print v(xbgr.mr_n80761776)
print v(xbgr.mr_n80762336)
print v(xbgr.mr_n80763280)
print v(xbgr.mr_n80763392)
print v(xbgr.mr_n80764000)
print v(xbgr.mr_n80764720)
print v(xbgr.mr_n80764832)
print v(xbgr.mr_n80765440)
print v(xbgr.mr_n80766160)
print v(xbgr.mr_n80766272)
print v(xbgr.mr_n80766880)
print v(xbgr.mr_n80777536)
print v(xbgr.mr_n80780288)
print v(xbgr.mr_n80784528)
print v(xbgr.mr_n80785488)
print v(xbgr.mr_n80792800)
print v(xbgr.mr_n80799552)
print v(xbgr.mr_n80800384)
print v(xbgr.mr_n80800864)
print v(xbgr.mr_n80802672)
print v(xbgr.mr_n80803504)
print v(xbgr.mr_n80804064)
print v(xbgr.mr_n80804960)
print v(xbgr.mr_n80805568)
print v(xbgr.mr_n80806208)
print v(xbgr.mr_n80806416)
print v(xbgr.mr_n80806960)
print v(xbgr.mr_n80807472)
print v(xbgr.mr_n80807680)
print v(xbgr.mr_n80808560)
print v(xbgr.mr_n80808848)
print v(xbgr.mr_n80808960)
print v(xbgr.mr_n80810112)
print v(xbgr.mr_n80810304)
print v(xbgr.mr_n80811408)
print v(xbgr.mr_n80811872)
print v(xbgr.mr_n80812336)
print v(xbgr.mr_n80812864)
print v(xbgr.mr_n80813200)
print v(xbgr.mr_n80813456)
print v(xbgr.mr_n80814640)
print v(xbgr.mr_n80815232)
print v(xbgr.mr_n80815824)
print v(xbgr.mr_n80816240)
print v(xbgr.mr_n80816416)
print v(xbgr.mr_n80817008)
print v(xbgr.mr_n80818192)
print v(xbgr.mr_n80818528)
print v(xbgr.mr_n80818784)
print v(xbgr.mr_n80819376)
print v(xbgr.mr_n80819968)
print v(xbgr.mr_n80820560)
print v(xbgr.mr_n80821152)
print v(xbgr.mr_n80821744)
print v(xbgr.mr_n80822336)
print v(xbgr.mr_n80822928)
print v(xbgr.mr_n80823520)
print v(xbgr.mr_n80824112)
print v(xbgr.mr_n80824704)
print v(xbgr.mr_n80825232)
print v(xbgr.mr_n80825888)
print v(xbgr.mr_n80826480)
print v(xbgr.mr_n80827072)
print v(xbgr.mr_n80827664)
print v(xbgr.mr_n80828256)
print v(xbgr.mr_n80828848)
print v(xbgr.mr_n80829440)
print v(xbgr.mr_n80830032)
print v(xbgr.mr_n80830624)
print v(xbgr.mr_n80831216)
print v(xbgr.mr_n80832400)
print v(xbgr.mr_n80832992)
print v(xbgr.mr_n80833584)
print v(xbgr.mr_n80834176)
print v(xbgr.mr_n80834768)
print v(xbgr.mr_n80835360)
print v(xbgr.mr_n80835952)
print v(xbgr.mr_n80836544)
print v(xbgr.mr_n80837136)
print v(xbgr.mr_n80837728)
print v(xbgr.mr_n80838304)
print v(xbgr.mr_n80838896)
print v(xbgr.mr_n80839488)
print v(xbgr.mr_n80840080)
print v(xbgr.mr_n80840672)
print v(xbgr.mr_n80841264)
print v(xbgr.mr_n80841856)
print v(xbgr.mr_n80842448)
print v(xbgr.mr_n80843040)
print v(xbgr.mr_n80843632)
print v(xbgr.mr_n80844224)
print v(xbgr.mr_n80844816)
print v(xbgr.mr_n80845408)
print v(xbgr.mr_n80846560)
print v(xbgr.mr_n80847152)
print v(xbgr.mr_n80847744)
print v(xbgr.mr_n80848160)
print v(xbgr.mr_n80848336)
print v(xbgr.mr_n80848864)
print v(xbgr.mr_n80849520)
print v(xbgr.mr_n80850112)
print v(xbgr.mr_n80850704)
print v(xbgr.mr_n80851296)
print v(xbgr.mr_n80851888)
print v(xbgr.mr_n80852480)
print v(xbgr.mr_n80853072)
print v(xbgr.mr_n80853664)
print v(xbgr.mr_n80854256)
print v(xbgr.mr_n80854848)
print v(xbgr.mr_n80854992)
print v(xbgr.mr_n80855648)
print v(xbgr.mr_n80856352)
print v(xbgr.mr_n80856816)
print v(xbgr.mr_n80858112)
print v(xbgr.mr_n80859056)
print v(xbgr.mr_n80859568)
print v(xbgr.mr_n80860240)
print v(xbgr.mr_n80864336)
print v(xbgr.mr_n80865888)
print v(xbgr.mr_n80866000)
print v(xbgr.mr_n80866112)
print v(xbgr.mr_n80866224)
print v(xbgr.mr_n80866336)
print v(xbgr.mr_n80866448)
print v(xbgr.mr_n80866560)
print v(xbgr.mr_n80866672)
print v(xbgr.mr_n80866784)
print v(xbgr.mr_n80867056)
print v(xbgr.mr_n80867328)
print v(xbgr.mr_n80867600)
print v(xbgr.mr_n80867872)
print v(xbgr.mr_n80868144)
print v(xbgr.mr_n80868416)
print v(xbgr.mr_n80868688)
print v(xbgr.mr_n80868992)
print v(xbgr.mr_n80869392)
print v(xbgr.mr_n80869792)
print v(xbgr.mr_n80870192)
print v(xbgr.mr_n80870592)
print v(xbgr.mr_n80870992)
print v(xbgr.mr_n80871392)
print v(xbgr.mr_n80871792)
print v(xbgr.mr_n80872192)
print v(xbgr.mr_n80872592)
print v(xbgr.mr_n80872992)
print v(xbgr.mr_n80873392)
print v(xbgr.mr_n80873792)
print v(xbgr.mr_n80874192)
print v(xbgr.mr_n80874592)
print v(xbgr.mr_n80874992)
print v(xbgr.mr_n80875392)
print v(xbgr.mr_n80875792)
print v(xbgr.mr_n80876192)
print v(xbgr.mr_n80876592)
print v(xbgr.mr_n80876992)
print v(xbgr.mr_n80877392)
print v(xbgr.mr_n80877792)
print v(xbgr.mr_n80878192)
print v(xbgr.mr_n80878592)
print v(xbgr.mr_n80878992)
print v(xbgr.mr_n80879392)
print v(xbgr.mr_n80879792)
print v(xbgr.mr_n80880192)
print v(xbgr.mr_n80880528)
print v(xbgr.mr_n80880800)
print v(xbgr.mr_n80881072)
print v(xbgr.mr_n80881344)
print v(xbgr.mr_n80881616)
print v(xbgr.mr_n80881888)
print v(xbgr.mr_n80882160)
print v(xbgr.mr_n80882432)
print v(xbgr.mr_n80882704)
print v(xbgr.mr_n80882976)
print v(xbgr.mr_n80883248)
print v(xbgr.mr_n80883520)
print v(xbgr.mr_n80883792)
print v(xbgr.mr_n80884064)
print v(xbgr.mr_n80884336)
print v(xbgr.mr_n80884608)
print v(xbgr.mr_n80884880)
print v(xbgr.mr_n80885152)
print v(xbgr.mr_n80885600)
print v(xbgr.mr_n80885792)
print v(xbgr.mr_n80885984)
print v(xbgr.mr_n80886176)
print v(xbgr.mr_n80887120)
print v(xbgr.mr_n80891072)
print v(xbgr.mr_n80891184)
print v(xbgr.mr_n80891376)
print v(xbgr.mr_n80892128)
print v(xbgr.mr_n80893040)
print v(xbgr.mr_n80893792)
print v(xbgr.mr_n80896064)
print v(xbgr.mr_n80896176)
print v(xbgr.mr_n80896368)
print v(xbgr.mr_n80897120)
print v(xbgr.mr_n80898032)
print v(xbgr.mr_n80898784)
print v(xbgr.mr_n80901056)
print v(xbgr.mr_n80901168)
print v(xbgr.mr_n80901360)
print v(xbgr.mr_n80902112)
print v(xbgr.mr_n80903024)
print v(xbgr.mr_n80903776)
print v(xbgr.mr_n80906048)
print v(xbgr.mr_n80906160)
print v(xbgr.mr_n80906352)
print v(xbgr.mr_n80907104)
print v(xbgr.mr_n80908016)
print v(xbgr.mr_n80908768)
print v(xbgr.mr_n80911040)
print v(xbgr.mr_n80911152)
print v(xbgr.mr_n80911344)
print v(xbgr.mr_n80912096)
print v(xbgr.mr_n80913008)
print v(xbgr.mr_n80913760)
print v(xbgr.mr_n80916032)
print v(xbgr.mr_n80916144)
print v(xbgr.mr_n80916336)
print v(xbgr.mr_n80917088)
print v(xbgr.mr_n80920448)
print v(xbgr.mr_n80921120)
print v(xbgr.mr_n80921552)
print v(xbgr.mr_n80921728)
print v(xbgr.mr_n80922064)
print v(xbgr.mr_n80922576)
print v(xbgr.mr_n80923008)
print v(xbgr.mr_n80923184)
print v(xbgr.mr_n80923440)
print v(xbgr.mr_n80924224)
print v(xbgr.mr_n80924400)
print v(xbgr.mr_n80924576)
print v(xbgr.mr_n80925088)
print v(xbgr.mr_n80925200)
print v(xbgr.mr_n80925760)
print v(xbgr.mr_n80925936)
print v(xbgr.mr_n80926192)
print v(xbgr.mr_n80927136)
print v(xbgr.mr_n80927312)
print v(xbgr.mr_n80927488)
print v(xbgr.mr_n80928000)
print v(xbgr.mr_n80928112)
print v(xbgr.mr_n80928672)
print v(xbgr.mr_n80928848)
print v(xbgr.mr_n80929344)
print v(xbgr.mr_n80929856)
print v(xbgr.mr_n80930288)
print v(xbgr.mr_n80930464)
print v(xbgr.mr_n80930800)
print v(xbgr.mr_n80931504)
print v(xbgr.mr_n80931680)
print v(xbgr.mr_n80931856)
print v(xbgr.mr_n80932368)
print v(xbgr.mr_n80932480)
print v(xbgr.mr_n80933216)
print v(xbgr.mr_n80933632)
print v(xbgr.mr_n80934224)
print v(xbgr.mr_n80934656)
print v(xbgr.mr_n80934832)
print v(xbgr.mr_n80935168)
print v(xbgr.mr_n80935680)
print v(xbgr.mr_n80936112)
print v(xbgr.mr_n80936288)
print v(xbgr.mr_n80936544)
print v(xbgr.mr_n80937328)
print v(xbgr.mr_n80937504)
print v(xbgr.mr_n80937680)
print v(xbgr.mr_n80938192)
print v(xbgr.mr_n80938624)
print v(xbgr.mr_n80938800)
print v(xbgr.mr_n80939056)
print v(xbgr.mr_n80939648)
print v(xbgr.mr_n80940080)
print v(xbgr.mr_n80940256)
print v(xbgr.mr_n80940592)
print v(xbgr.mr_n80941104)
print v(xbgr.mr_n80941216)
print v(xbgr.mr_n80941776)
print v(xbgr.mr_n80941952)
print v(xbgr.mr_n80942448)
print v(xbgr.mr_n80943152)
print v(xbgr.mr_n80943328)
print v(xbgr.mr_n80943504)
print v(xbgr.mr_n80944016)
print v(xbgr.mr_n80944128)
print v(xbgr.mr_n80944240)
print v(xbgr.mr_n80944352)
print v(xbgr.mr_n80944464)
print v(xbgr.mr_n80944736)
print v(xbgr.mr_n80945088)
print v(xbgr.mr_n80945200)
print v(xbgr.mr_n80945472)
print v(xbgr.mr_n80945824)
print v(xbgr.mr_n80946064)
print v(xbgr.mr_n80946400)
print v(xbgr.mr_n80946752)
print v(xbgr.mr_n80946864)
print v(xbgr.mr_n80947056)
print v(xbgr.mr_n80947328)
print v(xbgr.mr_n80947600)
print v(xbgr.mr_n80947872)
print v(xbgr.mr_n80948144)
print v(xbgr.mr_n80948416)
print v(xbgr.mr_n80949040)
print v(xbgr.mr_n80949232)
print v(xbgr.mr_n80949424)
print v(xbgr.mr_n80949616)
print v(xbgr.mr_n80950368)
print v(xbgr.mr_n80968512)
print v(xbgr.mr_n80968688)
print v(xbgr.mr_n80969392)
print v(xbgr.mr_n80969568)
print v(xbgr.mr_n80969744)
print v(xbgr.mr_n80970448)
print v(xbgr.mr_n80970624)
print v(xbgr.mr_n80970800)
print v(xbgr.mr_n80971504)
print v(xbgr.mr_n80971680)
print v(xbgr.mr_n80971856)
print v(xbgr.mr_n80972560)
print v(xbgr.mr_n80972736)
print v(xbgr.mr_n80972912)
print v(xbgr.mr_n80973616)
print v(xbgr.mr_n80973792)
print v(xbgr.mr_n80973968)
print v(xbgr.mr_n80974544)
print v(xbgr.mr_n80974736)
print v(xbgr.mr_n80975008)
print v(xbgr.mr_n80975280)
print v(xbgr.mr_n80975552)
print v(xbgr.mr_n80975824)
print v(xbgr.mr_n80976096)
print v(xbgr.mr_n80976368)
print v(xbgr.mr_n80976640)
print v(xbgr.mr_n80976912)
print v(xbgr.mr_n80980448)
print v(xbgr.mr_n80980784)
print v(xbgr.mr_n80981120)
print v(xbgr.mr_n80981456)
print v(xbgr.mr_n80982112)
print v(xbgr.mr_n80982752)
print v(xbgr.mr_n80983152)
print v(xbgr.mr_n80983552)
print v(xbgr.mr_n80983952)
print v(xbgr.mr_n80984352)
print v(xbgr.mr_n80984752)
print v(xbgr.mr_n80985152)
print v(xbgr.mr_n80985616)
print v(xbgr.mr_n80985792)
print v(xbgr.mr_n80986416)
print v(xbgr.mr_n80986592)
print v(xbgr.mr_n80987216)
print v(xbgr.mr_n80987392)
print v(xbgr.mr_n80988016)
print v(xbgr.mr_n80988192)
print v(xbgr.mr_n80988816)
print v(xbgr.mr_n80988992)
print v(xbgr.mr_n80989616)
print v(xbgr.mr_n80989792)
print v(xbgr.mr_n80990176)
print v(xbgr.mr_n80990288)
print v(xbgr.mr_n80990800)
print v(xbgr.mr_n80991472)
print v(xbgr.mr_n80993296)
print v(xbgr.mr_n80993808)
print v(xbgr.mr_n80995632)
print v(xbgr.mr_n80996384)
print v(xbgr.mr_n80997600)
print v(xbgr.mr_n80998192)
print v(xbgr.mr_n80999408)
print v(xbgr.mr_n81000000)
print v(xbgr.mr_n81001216)
print v(xbgr.mr_n81001808)
print v(xbgr.mr_n81003104)
print v(xbgr.mr_n81003616)
print v(xbgr.mr_n81004912)
print v(xbgr.mr_n81005424)
print v(xbgr.mr_n81006720)
print v(xbgr.mr_n81007232)
print v(xbgr.mr_n81008528)
print v(xbgr.mr_n81009040)
print v(xbgr.mr_n81010336)
print v(xbgr.mr_n81010848)
print v(xbgr.mr_n81012144)
print v(xbgr.mr_n81013952)
print v(xbgr.mr_n81014464)
print v(xbgr.mr_n81015760)
print v(xbgr.mr_n81016272)
print v(xbgr.mr_n81016384)
print v(xbgr.mr_n81016496)
print v(xbgr.mr_n81016608)
print v(xbgr.mr_n81016880)
print v(xbgr.mr_n81016992)
print v(xbgr.mr_n81017344)
print v(xbgr.mr_n81017456)
print v(xbgr.mr_n81017728)
print v(xbgr.mr_n81018080)
print v(xbgr.mr_n81018192)
print v(xbgr.mr_n81018560)
print v(xbgr.mr_n81019056)
print v(xbgr.mr_n81019536)
print v(xbgr.mr_n81019840)
print v(xbgr.mr_n81020192)
print v(xbgr.mr_n81020880)
print v(xbgr.mr_n81021344)
print v(xbgr.mr_n81021760)
print v(xbgr.mr_n81022448)
print v(xbgr.mr_n81022976)
print v(xbgr.mr_n81023328)
print v(xbgr.mr_n81023568)
print v(xbgr.mr_n81024016)
print v(xbgr.mr_n81024480)
print v(xbgr.mr_n81024896)
print v(xbgr.mr_n81025584)
print v(xbgr.mr_n81026112)
print v(xbgr.mr_n81026464)
print v(xbgr.mr_n81027152)
print v(xbgr.mr_n81027680)
print v(xbgr.mr_n81028032)
print v(xbgr.mr_n81028720)
print v(xbgr.mr_n81029248)
print v(xbgr.mr_n81029600)
print v(xbgr.mr_n81030288)
print v(xbgr.mr_n81030816)
print v(xbgr.mr_n81031168)
print v(xbgr.mr_n81031856)
print v(xbgr.mr_n81032320)
print v(xbgr.mr_n81032736)
print v(xbgr.mr_n81033424)
print v(xbgr.mr_n81033888)
print v(xbgr.mr_n81034304)
print v(xbgr.mr_n81034992)
print v(xbgr.mr_n81035456)
print v(xbgr.mr_n81035872)
print v(xbgr.mr_n81036560)
print v(xbgr.mr_n81037024)
print v(xbgr.mr_n81037440)
print v(xbgr.mr_n81038128)
print v(xbgr.mr_n81038656)
print v(xbgr.mr_n81039008)
print v(xbgr.mr_n81039376)
print v(xbgr.mr_n81041040)
print v(xbgr.mr_n81041424)
print v(xbgr.mr_n81042960)
print v(xbgr.mr_n81043984)
print v(xbgr.mr_n81044768)
print v(xbgr.mr_n81045776)
print v(xbgr.mr_n81049552)
print v(xbgr.mr_n81050704)
print v(xbgr.mr_n81051216)
print v(xbgr.mr_n81051600)
print v(xbgr.mr_n81051728)
print v(xbgr.mr_n81051984)
print v(xbgr.mr_n81053392)
print v(xbgr.mr_n81055696)
print v(xbgr.mr_n81056336)
print v(xbgr.mr_n81056464)
print v(xbgr.mr_n81060304)
print v(xbgr.mr_n81061136)
print v(xbgr.mr_n81062064)
print v(xbgr.mr_n81062528)
print v(xbgr.mr_n81062992)
print v(xbgr.mr_n81063456)
print v(xbgr.mr_n81063920)
print v(xbgr.mr_n81064384)
print v(xbgr.mr_n81064848)
print v(xbgr.mr_n81065312)
print v(xbgr.mr_n81065776)
print v(xbgr.mr_n81066240)
print v(xbgr.mr_n81066704)
print v(xbgr.mr_n81067168)
print v(xbgr.mr_n81067632)
print v(xbgr.mr_n81068096)
print v(xbgr.mr_n81068560)
print v(xbgr.mr_n81069024)
print v(xbgr.mr_n81069664)
print v(xbgr.mr_n81069904)
print v(xbgr.mr_n81072880)
print v(xbgr.mr_n81073088)
print v(xbgr.mr_n81073424)
print v(xbgr.mr_n81073760)
print v(xbgr.mr_n81074096)
print v(xbgr.mr_n81074944)
print v(xbgr.mr_n81076416)
print v(xbgr.mr_n81077008)
print v(xbgr.mr_n81077696)
print v(xbgr.mr_n81083712)
print v(xbgr.mr_n81086400)
print v(xbgr.mr_n81087648)
print v(xbgr.mr_n81089488)
print v(xbgr.mr_n81090768)
print v(xbgr.mr_n81091008)
print v(xbgr.mr_n81091152)
print v(xbgr.mr_n81092896)
print v(xbgr.mr_n81093568)
print v(xbgr.mr_n81095200)
print v(xbgr.mr_n81096928)
print v(xbgr.mr_n81097392)
print v(xbgr.mr_n81097856)
print v(xbgr.mr_n81098048)
print v(xbgr.mr_n81098560)
print v(xbgr.mr_n81099568)
print v(xbgr.mr_n81100256)
print v(xbgr.mr_n81100960)
print v(xbgr.mr_n81115152)
print v(xbgr.mr_n81120512)
print v(xbgr.mr_n81121216)
print v(xbgr.mr_n81121392)
print v(xbgr.mr_n81121952)
print v(xbgr.mr_n81122480)
print v(xbgr.mr_n81122656)
print v(xbgr.mr_n81122912)
print v(xbgr.mr_n81123616)
print v(xbgr.mr_n81123792)
print v(xbgr.mr_n81124352)
print v(xbgr.mr_n81124816)
print v(xbgr.mr_n81124992)
print v(xbgr.mr_n81127984)
print v(xbgr.mr_n81128640)
print v(xbgr.mr_n81129424)
print v(xbgr.mr_n81131680)
print v(xbgr.mr_n81131792)
print v(xbgr.mr_n81132256)
print v(xbgr.mr_n81132720)
print v(xbgr.mr_n81133184)
print v(xbgr.mr_n81133648)
print v(xbgr.mr_n81134112)
print v(xbgr.mr_n81134576)
print v(xbgr.mr_n81135040)
print v(xbgr.mr_n81135504)
print v(xbgr.mr_n81135968)
print v(xbgr.mr_n81136432)
print v(xbgr.mr_n81136896)
print v(xbgr.mr_n81137360)
print v(xbgr.mr_n81137824)
print v(xbgr.mr_n81138288)
print v(xbgr.mr_n81138752)
print v(xbgr.mr_n81139216)
print v(xbgr.mr_n81141248)
print v(xbgr.mr_n81141968)
print v(xbgr.mr_n81145216)
print v(xbgr.mr_n81152816)
print v(xbgr.mr_n81156128)
print v(xbgr.mr_n81161664)
print v(xbgr.mr_n81163040)
print v(xbgr.mr_n81165792)
print v(xbgr.mr_n81170272)
print v(xbgr.mr_n81173952)
print v(xbgr.mr_n81174336)
print v(xbgr.mr_n81174704)
print v(xbgr.mr_n81174896)
print v(xbgr.mr_n81175152)
print v(xbgr.mr_n81175408)
print v(xbgr.mr_n81177376)
print v(xbgr.mr_n81178160)
print v(xbgr.mr_n81178272)
print v(xbgr.mr_n81178624)
print v(xbgr.mr_n81181216)
print v(xbgr.mr_n81182544)
print v(xbgr.mr_n81184592)
print v(xbgr.mr_n81187360)
print v(xbgr.mr_n81188688)
print v(xbgr.mr_n81190736)
print v(xbgr.mr_n81193504)
print v(xbgr.mr_n81194832)
print v(xbgr.mr_n81196880)
print v(xbgr.mr_n81199648)
print v(xbgr.mr_n81200976)
print v(xbgr.mr_n81203024)
print v(xbgr.mr_n81205792)
print v(xbgr.mr_n81207120)
print v(xbgr.mr_n81209168)
print v(xbgr.mr_n81211936)
print v(xbgr.mr_n81213264)
print v(xbgr.mr_n81220576)
print v(xbgr.mr_n81220976)
print v(xbgr.mr_n81221376)
print v(xbgr.mr_n81221776)
print v(xbgr.mr_n81222176)
print v(xbgr.mr_n81222576)
print v(xbgr.mr_n81222976)
print v(xbgr.mr_n81223376)
print v(xbgr.mr_n81223776)
print v(xbgr.mr_n81224176)
print v(xbgr.mr_n81224576)
print v(xbgr.mr_n81224976)
print v(xbgr.mr_n81225376)
print v(xbgr.mr_n81225776)
print v(xbgr.mr_n81226176)
print v(xbgr.mr_n81226576)
print v(xbgr.mr_n81226848)
print v(xbgr.mr_n81226960)
print v(xbgr.mr_n81227072)
print v(xbgr.mr_n81227184)
print v(xbgr.mr_n81227296)
print v(xbgr.mr_n81227488)
print v(xbgr.mr_n81227760)
print v(xbgr.mr_n81228032)
print v(xbgr.mr_n81228304)
print v(xbgr.mr_n81228576)
print v(xbgr.mr_n81228848)
print v(xbgr.mr_n81229120)
print v(xbgr.mr_n81229392)
print v(xbgr.mr_n81229728)
print v(xbgr.mr_n81230128)
print v(xbgr.mr_n81233600)
print v(xbgr.mr_n81236928)
print v(xbgr.mr_n81242624)
print v(xbgr.mr_n81244288)
print v(xbgr.mr_n81244896)
print v(xbgr.mr_n81245072)
print v(xbgr.mr_n81245856)
print v(xbgr.mr_n81246400)
print v(xbgr.mr_n81246896)
print v(xbgr.mr_n81247440)
print v(xbgr.mr_n81247616)
print v(xbgr.mr_n81248464)
print v(xbgr.mr_n81248944)
print v(xbgr.mr_n81249376)
print v(xbgr.mr_n81249984)
print v(xbgr.mr_n81250160)
print v(xbgr.mr_n81251008)
print v(xbgr.mr_n81251488)
print v(xbgr.mr_n81251984)
print v(xbgr.mr_n81252528)
print v(xbgr.mr_n81252704)
print v(xbgr.mr_n81253552)
print v(xbgr.mr_n81254032)
print v(xbgr.mr_n81254528)
print v(xbgr.mr_n81255072)
print v(xbgr.mr_n81255248)
print v(xbgr.mr_n81256096)
print v(xbgr.mr_n81256576)
print v(xbgr.mr_n81257072)
print v(xbgr.mr_n81257616)
print v(xbgr.mr_n81257792)
print v(xbgr.mr_n81258640)
print v(xbgr.mr_n81259120)
print v(xbgr.mr_n81259552)
print v(xbgr.mr_n81260160)
print v(xbgr.mr_n81260336)
print v(xbgr.mr_n81260624)
print v(xbgr.mr_n81261312)
print v(xbgr.mr_n81261904)
print v(xbgr.mr_n81262176)
print v(xbgr.mr_n81262448)
print v(xbgr.mr_n81262912)
print v(xbgr.mr_n81263376)
print v(xbgr.mr_n81263840)
print v(xbgr.mr_n81264304)
print v(xbgr.mr_n81270688)
print v(xbgr.mr_n81276432)
print v(xbgr.mr_n81276624)
print v(xbgr.mr_n81276880)
print v(xbgr.mr_n81277136)
print v(xbgr.mr_n81279104)
print v(xbgr.mr_n81301968)
print v(xbgr.mr_n81302464)
print v(xbgr.mr_n81302768)
print v(xbgr.mr_n81303264)
print v(xbgr.mr_n81303568)
print v(xbgr.mr_n81304128)
print v(xbgr.mr_n81304432)
print v(xbgr.mr_n81305312)
print v(xbgr.mr_n81305616)
print v(xbgr.mr_n81306496)
print v(xbgr.mr_n81306800)
print v(xbgr.mr_n81307680)
print v(xbgr.mr_n81307984)
print v(xbgr.mr_n81308864)
print v(xbgr.mr_n81309168)
print v(xbgr.mr_n81310048)
print v(xbgr.mr_n81310352)
print v(xbgr.mr_n81311232)
print v(xbgr.mr_n81311536)
print v(xbgr.mr_n81312416)
print v(xbgr.mr_n81312720)
print v(xbgr.mr_n81313600)
print v(xbgr.mr_n81313904)
print v(xbgr.mr_n81314784)
print v(xbgr.mr_n81315088)
print v(xbgr.mr_n81315968)
print v(xbgr.mr_n81316272)
print v(xbgr.mr_n81317152)
print v(xbgr.mr_n81317456)
print v(xbgr.mr_n81318336)
print v(xbgr.mr_n81318528)
print v(xbgr.mr_n81318800)
print v(xbgr.mr_n81319264)
print v(xbgr.mr_n81324240)
print v(xbgr.mr_n81325712)
print v(xbgr.mr_n81330832)
print v(xbgr.mr_n81331840)
print v(xbgr.mr_n81333008)
print v(xbgr.mr_n81333344)
print v(xbgr.mr_n81333680)
print v(xbgr.mr_n81334016)
print v(xbgr.mr_n81334720)
print v(xbgr.mr_n81336048)
print v(xbgr.mr_n81336816)
print v(xbgr.mr_n81337216)
print v(xbgr.mr_n81337616)
print v(xbgr.mr_n81338016)
print v(xbgr.mr_n81338416)
print v(xbgr.mr_n81338816)
print v(xbgr.mr_n81339216)
print v(xbgr.mr_n81339616)
print v(xbgr.mr_n81340016)
print v(xbgr.mr_n81340416)
print v(xbgr.mr_n81340816)
print v(xbgr.mr_n81341216)
print v(xbgr.mr_n81341616)
print v(xbgr.mr_n81342016)
print v(xbgr.mr_n81342416)
print v(xbgr.mr_n81342816)
print v(xbgr.mr_n81350832)
print v(xbgr.mr_n81353456)
print v(xbgr.mr_n81354736)
print v(xbgr.mr_n81357808)
print v(xbgr.mr_n81365504)
print v(xbgr.mr_n81368176)
print v(xbgr.mr_n81369264)
print v(xbgr.mr_n81370416)
print v(xbgr.mr_n81372592)
print v(xbgr.mr_n81373232)
print v(xbgr.mr_n81373536)
print v(xbgr.mr_n81373840)
print v(xbgr.mr_n81374144)
print v(xbgr.mr_n81374528)
print v(xbgr.mr_n81374992)
print v(xbgr.mr_n81375456)
print v(xbgr.mr_n81375920)
print v(xbgr.mr_n81376384)
print v(xbgr.mr_n81376848)
print v(xbgr.mr_n81377312)
print v(xbgr.mr_n81377776)
print v(xbgr.mr_n81378240)
print v(xbgr.mr_n81381056)
print v(xbgr.mr_n81381408)
print v(xbgr.mr_n81382288)
print v(xbgr.mr_n81382992)
print v(xbgr.mr_n81383520)
print v(xbgr.mr_n81383968)
print v(xbgr.mr_n81391008)
print v(xbgr.mr_n81391344)
print v(xbgr.mr_n81391680)
print v(xbgr.mr_n81392016)
print v(xbgr.mr_n81393152)
print v(xbgr.mr_n81393712)
print v(xbgr.mr_n81395280)
print v(xbgr.mr_n81395424)
print v(xbgr.mr_n81395536)
print v(xbgr.mr_n81395920)
print v(xbgr.mr_n81396192)
print v(xbgr.mr_n81397712)
print v(xbgr.mr_n81398352)
print v(xbgr.mr_n81398464)
print v(xbgr.mr_n81401056)
print v(xbgr.mr_n81401168)
print v(xbgr.mr_n81401280)
print v(xbgr.mr_n81401552)
print v(xbgr.mr_n81403200)
print v(xbgr.mr_n81404336)
print v(xbgr.mr_n81404448)
print v(xbgr.mr_n81406144)
print v(xbgr.mr_n81406256)
print v(xbgr.mr_n81406368)
print v(xbgr.mr_n81406640)
print v(xbgr.mr_n81408752)
print v(xbgr.mr_n81409392)
print v(xbgr.mr_n81409504)
print v(xbgr.mr_n81410768)
print v(xbgr.mr_n81411472)
print v(xbgr.mr_n81412112)
print v(xbgr.mr_n81412224)
print v(xbgr.mr_n81413808)
print v(xbgr.mr_n81414448)
print v(xbgr.mr_n81414560)
print v(xbgr.mr_n81416256)
print v(xbgr.mr_n81416368)
print v(xbgr.mr_n81416480)
print v(xbgr.mr_n81416752)
print v(xbgr.mr_n81418912)
print v(xbgr.mr_n81419024)
print v(xbgr.mr_n81419216)
print v(xbgr.mr_n81420688)
print v(xbgr.mr_n81421024)
print v(xbgr.mr_n81422224)
print v(xbgr.mr_n81422336)
print v(xbgr.mr_n81423920)
print v(xbgr.mr_n81424560)
print v(xbgr.mr_n81424672)
print v(xbgr.mr_n81426368)
print v(xbgr.mr_n81426480)
print v(xbgr.mr_n81426592)
print v(xbgr.mr_n81426864)
print v(xbgr.mr_n81429024)
print v(xbgr.mr_n81429136)
print v(xbgr.mr_n81429328)
print v(xbgr.mr_n81431360)
print v(xbgr.mr_n81431472)
print v(xbgr.mr_n81431584)
print v(xbgr.mr_n81431856)
print v(xbgr.mr_n81434080)
print v(xbgr.mr_n81434192)
print v(xbgr.mr_n81434384)
print v(xbgr.mr_n81434896)
print v(xbgr.mr_n81435232)
print v(xbgr.mr_n81435584)
print v(xbgr.mr_n81436208)
print v(xbgr.mr_n81436592)
print v(xbgr.mr_n81437088)
print v(xbgr.mr_n81437776)
print v(xbgr.mr_n81438304)
print v(xbgr.mr_n81438656)
print v(xbgr.mr_n81439344)
print v(xbgr.mr_n81439872)
print v(xbgr.mr_n81440224)
print v(xbgr.mr_n81440912)
print v(xbgr.mr_n81441376)
print v(xbgr.mr_n81441792)
print v(xbgr.mr_n81442480)
print v(xbgr.mr_n81442944)
print v(xbgr.mr_n81443360)
print v(xbgr.mr_n81444048)
print v(xbgr.mr_n81444512)
print v(xbgr.mr_n81444928)
print v(xbgr.mr_n81445616)
print v(xbgr.mr_n81446080)
print v(xbgr.mr_n81446496)
print v(xbgr.mr_n81447184)
print v(xbgr.mr_n81447712)
print v(xbgr.mr_n81448064)
print v(xbgr.mr_n81448752)
print v(xbgr.mr_n81449136)
print v(xbgr.mr_n81449632)
print v(xbgr.mr_n81450320)
print v(xbgr.mr_n81450848)
print v(xbgr.mr_n81451200)
print v(xbgr.mr_n81451888)
print v(xbgr.mr_n81452416)
print v(xbgr.mr_n81453664)
print v(xbgr.mr_n81456800)
print v(xbgr.mr_n81457632)
print v(xbgr.mr_n81457744)
print v(xbgr.mr_n81457936)
print v(xbgr.mr_n81458320)
print v(xbgr.mr_n81468096)
print v(xbgr.mr_n81469696)
print v(xbgr.mr_n81471296)
print v(xbgr.mr_n81473248)
print v(xbgr.mr_n81473712)
print v(xbgr.mr_n81474176)
print v(xbgr.mr_n81474640)
print v(xbgr.mr_n81475104)
print v(xbgr.mr_n81475568)
print v(xbgr.mr_n81476032)
print v(xbgr.mr_n81476496)
print v(xbgr.mr_n81476960)
print v(xbgr.mr_n81477424)
print v(xbgr.mr_n81477888)
print v(xbgr.mr_n81478352)
print v(xbgr.mr_n81478816)
print v(xbgr.mr_n81479280)
print v(xbgr.mr_n81479744)
print v(xbgr.mr_n81480208)
print v(xbgr.mr_n81480672)
print v(xbgr.mr_n81481136)
print v(xbgr.mr_n81481600)
print v(xbgr.mr_n81483008)
print v(xbgr.mr_n81489680)
print v(xbgr.mr_n81492672)
print v(xbgr.mr_n81497216)
print v(xbgr.mr_n81500384)
print v(xbgr.mr_n81503936)
print v(xbgr.mr_n81505136)
print v(xbgr.mr_n81505328)
print v(xbgr.mr_n81505584)
print v(xbgr.mr_n81505840)
print v(xbgr.mr_n81507808)
print v(xbgr.mr_n81530864)
print v(xbgr.mr_n81531568)
print v(xbgr.mr_n81531680)
print v(xbgr.mr_n81531792)
print v(xbgr.mr_n81532304)
print v(xbgr.mr_n81532416)
print v(xbgr.mr_n81532528)
print v(xbgr.mr_n81533040)
print v(xbgr.mr_n81533152)
print v(xbgr.mr_n81533504)
print v(xbgr.mr_n81533616)
print v(xbgr.mr_n81533968)
print v(xbgr.mr_n81534080)
print v(xbgr.mr_n81534432)
print v(xbgr.mr_n81534544)
print v(xbgr.mr_n81534896)
print v(xbgr.mr_n81535008)
print v(xbgr.mr_n81535360)
print v(xbgr.mr_n81535472)
print v(xbgr.mr_n81535824)
print v(xbgr.mr_n81535936)
print v(xbgr.mr_n81536416)
print v(xbgr.mr_n81536592)
print v(xbgr.mr_n81537072)
print v(xbgr.mr_n81537248)
print v(xbgr.mr_n81537728)
print v(xbgr.mr_n81537904)
print v(xbgr.mr_n81541264)
print v(xbgr.mr_n81541600)
print v(xbgr.mr_n81542256)
print v(xbgr.mr_n81543088)
print v(xbgr.mr_n81543264)
print v(xbgr.mr_n81543440)
print v(xbgr.mr_n81544144)
print v(xbgr.mr_n81544320)
print v(xbgr.mr_n81544880)
print v(xbgr.mr_n81545344)
print v(xbgr.mr_n81545520)
print v(xbgr.mr_n81545696)
print v(xbgr.mr_n81546400)
print v(xbgr.mr_n81546576)
print v(xbgr.mr_n81547200)
print v(xbgr.mr_n81547376)
print v(xbgr.mr_n81547552)
print v(xbgr.mr_n81548064)
print v(xbgr.mr_n81548496)
print v(xbgr.mr_n81548672)
print v(xbgr.mr_n81548928)
print v(xbgr.mr_n81549712)
print v(xbgr.mr_n81549888)
print v(xbgr.mr_n81550512)
print v(xbgr.mr_n81550688)
print v(xbgr.mr_n81550864)
print v(xbgr.mr_n81551568)
print v(xbgr.mr_n81551744)
print v(xbgr.mr_n81552368)
print v(xbgr.mr_n81552544)
print v(xbgr.mr_n81552720)
print v(xbgr.mr_n81553360)
print v(xbgr.mr_n81553632)
print v(xbgr.mr_n81554064)
print v(xbgr.mr_n81554240)
print v(xbgr.mr_n81554496)
print v(xbgr.mr_n81555280)
print v(xbgr.mr_n81555456)
print v(xbgr.mr_n81556080)
print v(xbgr.mr_n81556256)
print v(xbgr.mr_n81556432)
print v(xbgr.mr_n81557072)
print v(xbgr.mr_n81557344)
print v(xbgr.mr_n81557456)
print v(xbgr.mr_n81557568)
print v(xbgr.mr_n81557680)
print v(xbgr.mr_n81557792)
print v(xbgr.mr_n81558064)
print v(xbgr.mr_n81558416)
print v(xbgr.mr_n81558528)
print v(xbgr.mr_n81558640)
print v(xbgr.mr_n81559072)
print v(xbgr.mr_n81559552)
print v(xbgr.mr_n81559728)
print v(xbgr.mr_n81560080)
print v(xbgr.mr_n81560448)
print v(xbgr.mr_n81560784)
print v(xbgr.mr_n81561136)
print v(xbgr.mr_n81561248)
print v(xbgr.mr_n81561744)
print v(xbgr.mr_n81562240)
print v(xbgr.mr_n81562720)
print v(xbgr.mr_n81562896)
print v(xbgr.mr_n81563248)
print v(xbgr.mr_n81563616)
print v(xbgr.mr_n81563952)
print v(xbgr.mr_n81564304)
print v(xbgr.mr_n81564416)
print v(xbgr.mr_n81564912)
print v(xbgr.mr_n81565408)
print v(xbgr.mr_n81565888)
print v(xbgr.mr_n81566064)
print v(xbgr.mr_n81566416)
print v(xbgr.mr_n81566784)
print v(xbgr.mr_n81567120)
print v(xbgr.mr_n81567472)
print v(xbgr.mr_n81570096)
print v(xbgr.mr_n81578144)
print v(xbgr.mr_n81579360)
print v(xbgr.mr_n81579744)
print v(xbgr.mr_n81580208)
print v(xbgr.mr_n81580672)
print v(xbgr.mr_n81581136)
print v(xbgr.mr_n81581600)
print v(xbgr.mr_n81582064)
print v(xbgr.mr_n81582528)
print v(xbgr.mr_n81582992)
print v(xbgr.mr_n81583456)
print v(xbgr.mr_n81583920)
print v(xbgr.mr_n81584384)
print v(xbgr.mr_n81584848)
print v(xbgr.mr_n81585312)
print v(xbgr.mr_n81585776)
print v(xbgr.mr_n81586240)
print v(xbgr.mr_n81586704)
print v(xbgr.mr_n81587168)
print v(xbgr.mr_n81587632)
print v(xbgr.mr_n81588096)
print v(xbgr.mr_n81588560)
print v(xbgr.mr_n81589024)
print v(xbgr.mr_n81589488)
print v(xbgr.mr_n81589952)
print v(xbgr.mr_n81590480)
print v(xbgr.mr_n81591072)
print v(xbgr.mr_n81593440)
print v(xbgr.mr_n81593696)
print v(xbgr.mr_n81600288)
print v(xbgr.mr_n81616272)
print v(xbgr.mr_n81623504)
print v(xbgr.mr_n81623680)
print v(xbgr.mr_n81624016)
print v(xbgr.mr_n81626080)
print v(xbgr.mr_n81626192)
print v(xbgr.mr_n81626384)
print v(xbgr.mr_n81627136)
print v(xbgr.mr_n81629824)
print v(xbgr.mr_n81630576)
print v(xbgr.mr_n81642864)
print v(xbgr.mr_n81646768)
print v(xbgr.mr_n81647552)
print v(xbgr.mr_n81647984)
print v(xbgr.mr_n81648160)
print v(xbgr.mr_n81648496)
print v(xbgr.mr_n81649200)
print v(xbgr.mr_n81649376)
print v(xbgr.mr_n81650000)
print v(xbgr.mr_n81650176)
print v(xbgr.mr_n81650800)
print v(xbgr.mr_n81650976)
print v(xbgr.mr_n81651600)
print v(xbgr.mr_n81651776)
print v(xbgr.mr_n81651888)
print v(xbgr.mr_n81652400)
print v(xbgr.mr_n81652576)
print v(xbgr.mr_n81653200)
print v(xbgr.mr_n81653376)
print v(xbgr.mr_n81654000)
print v(xbgr.mr_n81654176)
print v(xbgr.mr_n81654736)
print v(xbgr.mr_n81655088)
print v(xbgr.mr_n81655504)
print v(xbgr.mr_n81655616)
print v(xbgr.mr_n81656096)
print v(xbgr.mr_n81656704)
print v(xbgr.mr_n81657072)
print v(xbgr.mr_n81657216)
print v(xbgr.mr_n81657920)
print v(xbgr.mr_n81658224)
print v(xbgr.mr_n81659840)
print v(xbgr.mr_n81660256)
print v(xbgr.mr_n81660880)
print v(xbgr.mr_n81662848)
print v(xbgr.mr_n81663408)
print v(xbgr.mr_n81664288)
print v(xbgr.mr_n81664912)
print v(xbgr.mr_n81665344)
print v(xbgr.mr_n81666544)
print v(xbgr.mr_n81667088)
print v(xbgr.mr_n81667776)
print v(xbgr.mr_n81668352)
print v(xbgr.mr_n81668960)
print v(xbgr.mr_n81669104)
print v(xbgr.mr_n81670016)
print v(xbgr.mr_n81670240)
print v(xbgr.mr_n81670416)
print v(xbgr.mr_n81670864)
print v(xbgr.mr_n81671296)
print v(xbgr.mr_n81671584)
print v(xbgr.mr_n81674368)
print v(xbgr.mr_n81674640)
print v(xbgr.mr_n81674928)
print v(xbgr.mr_n81675040)
print v(xbgr.mr_n81675760)
print v(xbgr.mr_n81675872)
print v(xbgr.mr_n81676128)
print v(xbgr.mr_n81676464)
print v(xbgr.mr_n81676640)
print v(xbgr.mr_n81676800)
print v(xbgr.mr_n81676976)
print v(xbgr.mr_n81677136)
print v(xbgr.mr_n81678720)
print v(xbgr.mr_n81680384)
print v(xbgr.mr_n81680544)
print v(xbgr.mr_n81680688)
print v(xbgr.mr_n81681568)
print v(xbgr.mr_n81681808)
print v(xbgr.mr_n81681920)
print v(xbgr.mr_n81684464)
print v(xbgr.mr_n81684784)
print v(xbgr.mr_n81688336)
print v(xbgr.mr_n81688640)
print v(xbgr.mr_n81689184)
print v(xbgr.mr_n81689296)
print v(xbgr.mr_n81689568)
print v(xbgr.mr_n81690704)
print v(xbgr.mr_n81691856)
print v(xbgr.mr_n81692128)
print v(xbgr.mr_n81692864)
print v(xbgr.mr_n81693200)
print v(xbgr.mr_n81693360)
print v(xbgr.mr_n81694864)
print v(xbgr.mr_n81695264)
print v(xbgr.mr_n81696176)
print v(xbgr.mr_n81696640)
print v(xbgr.mr_n81696752)
print v(xbgr.mr_n81696960)
print v(xbgr.mr_n81697488)
print v(xbgr.mr_n81698016)
print v(xbgr.mr_n81698288)
print v(xbgr.mr_n81698400)
print v(xbgr.mr_n81698576)
print v(xbgr.mr_n81698688)
print v(xbgr.mr_n81699680)
print v(xbgr.mr_n81699952)
print v(xbgr.mr_n81700448)
print v(xbgr.mr_n81700816)
print v(xbgr.mr_n81701632)
print v(xbgr.mr_n81702752)
print v(xbgr.mr_n81703504)
print v(xbgr.mr_n81703936)
print v(xbgr.mr_n81704688)
print v(xbgr.mr_n81704800)
print v(xbgr.mr_n81705168)
print v(xbgr.mr_n81705360)
print v(xbgr.mr_n81705968)
print v(xbgr.mr_n81707280)
print v(xbgr.mr_n81707392)
print v(xbgr.mr_n81707648)
print v(xbgr.mr_n81707840)
print v(xbgr.mr_n81708272)
print v(xbgr.mr_n81708464)
print v(xbgr.mr_n81708656)
print v(xbgr.mr_n81709488)
print v(xbgr.mr_n81709712)
print v(xbgr.mr_n81710000)
print v(xbgr.mr_n81710752)
print v(xbgr.mr_n81711024)
print v(xbgr.mr_n81711776)
print v(xbgr.mr_n81712848)
print v(xbgr.mr_n81713280)
print v(xbgr.mr_n81713472)
print v(xbgr.mr_n81713744)
print v(xbgr.mr_n81714016)
print v(xbgr.mr_n81714288)
print v(xbgr.mr_n81714560)
print v(xbgr.mr_n81714832)
print v(xbgr.mr_n81715104)
print v(xbgr.mr_n81715376)
print v(xbgr.mr_n81715648)
print v(xbgr.mr_n81715920)
print v(xbgr.mr_n81716192)
print v(xbgr.mr_n81716464)
print v(xbgr.mr_n81716736)
print v(xbgr.mr_n81717008)
print v(xbgr.mr_n81717344)
print v(xbgr.mr_n81717808)
print v(xbgr.mr_n81718272)
print v(xbgr.mr_n81719360)
print v(xbgr.mr_n81720720)
print v(xbgr.mr_n81723120)
print v(xbgr.mr_n81726448)
print v(xbgr.mr_n81731760)
print v(xbgr.mr_n81733424)
print v(xbgr.mr_n81733536)
print v(xbgr.mr_n81733648)
print v(xbgr.mr_n81733760)
print v(xbgr.mr_n81734944)
print v(xbgr.mr_n81735952)
print v(xbgr.mr_n81738512)
print v(xbgr.mr_n81755856)
print v(xbgr.mr_n81756944)
print v(xbgr.mr_n81763216)
print v(xbgr.mr_n81763552)
print v(xbgr.mr_n81763888)
print v(xbgr.mr_n81764224)
print v(xbgr.mr_n81764560)
print v(xbgr.mr_n81764816)
print v(xbgr.mr_n81764928)
print v(xbgr.mr_n81765040)
print v(xbgr.mr_n81765152)
print v(xbgr.mr_n81765264)
print v(xbgr.mr_n81765536)
print v(xbgr.mr_n81765648)
print v(xbgr.mr_n81765760)
print v(xbgr.mr_n81766192)
print v(xbgr.mr_n81766544)
print v(xbgr.mr_n81766656)
print v(xbgr.mr_n81767008)
print v(xbgr.mr_n81767120)
print v(xbgr.mr_n81767280)
print v(xbgr.mr_n81767600)
print v(xbgr.mr_n81767712)
print v(xbgr.mr_n81767904)
print v(xbgr.mr_n81771024)
print v(xbgr.mr_n81771136)
print v(xbgr.mr_n81771248)
print v(xbgr.mr_n81772288)
print v(xbgr.mr_n81773008)
print v(xbgr.mr_n81773936)
print v(xbgr.mr_n81774640)
print v(xbgr.mr_n81777072)
print v(xbgr.mr_n81777712)
print v(xbgr.mr_n81778192)
print v(xbgr.mr_n81778384)
print v(xbgr.mr_n81778576)
print v(xbgr.mr_n81779472)
print v(xbgr.mr_n81779808)
print v(xbgr.mr_n81780560)
print v(xbgr.mr_n81780752)
print v(xbgr.mr_n81781552)
print v(xbgr.mr_n81781664)
print v(xbgr.mr_n81782000)
print v(xbgr.mr_n81782352)
print v(xbgr.mr_n81782784)
print v(xbgr.mr_n81783088)
print v(xbgr.mr_n81783648)
print v(xbgr.mr_n81784064)
print v(xbgr.mr_n81784496)
print v(xbgr.mr_n81784848)
print v(xbgr.mr_n81785280)
print v(xbgr.mr_n81785744)
print v(xbgr.mr_n81786096)
print v(xbgr.mr_n81786528)
print v(xbgr.mr_n81786832)
print v(xbgr.mr_n81787456)
print v(xbgr.mr_n81787808)
print v(xbgr.mr_n81788240)
print v(xbgr.mr_n81788592)
print v(xbgr.mr_n81789024)
print v(xbgr.mr_n81789488)
print v(xbgr.mr_n81789840)
print v(xbgr.mr_n81790272)
print v(xbgr.mr_n81790576)
print v(xbgr.mr_n81791200)
print v(xbgr.mr_n81791552)
print v(xbgr.mr_n81791920)
print v(xbgr.mr_n81792336)
print v(xbgr.mr_n81792768)
print v(xbgr.mr_n81793232)
print v(xbgr.mr_n81793584)
print v(xbgr.mr_n81794016)
print v(xbgr.mr_n81794320)
print v(xbgr.mr_n81794800)
print v(xbgr.mr_n81795296)
print v(xbgr.mr_n81795408)
print v(xbgr.mr_n81795600)
print v(xbgr.mr_n81795872)
print v(xbgr.mr_n81796144)
print v(xbgr.mr_n81796416)
print v(xbgr.mr_n81796688)
print v(xbgr.mr_n81796960)
print v(xbgr.mr_n81797232)
print v(xbgr.mr_n81797504)
print v(xbgr.mr_n81797776)
print v(xbgr.mr_n81798048)
print v(xbgr.mr_n81798320)
print v(xbgr.mr_n81798592)
print v(xbgr.mr_n81798864)
print v(xbgr.mr_n81799136)
print v(xbgr.mr_n81799408)
print v(xbgr.mr_n81799872)
print v(xbgr.mr_n81800640)
print v(xbgr.mr_n81801776)
print v(xbgr.mr_n81808176)
print v(xbgr.mr_n81808720)
print v(xbgr.mr_n81809328)
print v(xbgr.mr_n81818320)
print v(xbgr.mr_n81818800)
print v(xbgr.mr_n81820144)
print v(xbgr.mr_n81821168)
print v(xbgr.mr_n81821360)
print v(xbgr.mr_n81821552)
print v(xbgr.mr_n81821808)
print v(xbgr.mr_n81822064)
print v(xbgr.mr_n81824032)
print v(xbgr.mr_n81825040)
print v(xbgr.mr_n81828896)
print v(xbgr.mr_n81829072)
print v(xbgr.mr_n81830704)
print v(xbgr.mr_n81831808)
print v(xbgr.mr_n81832448)
print v(xbgr.mr_n81834848)
print v(xbgr.mr_n81835504)
print v(xbgr.mr_n81836016)
print v(xbgr.mr_n81837232)
print v(xbgr.mr_n81837824)
print v(xbgr.mr_n81839040)
print v(xbgr.mr_n81839632)
print v(xbgr.mr_n81840848)
print v(xbgr.mr_n81841440)
print v(xbgr.mr_n81842736)
print v(xbgr.mr_n81843248)
print v(xbgr.mr_n81844464)
print v(xbgr.mr_n81845056)
print v(xbgr.mr_n81846352)
print v(xbgr.mr_n81846864)
print v(xbgr.mr_n81848080)
print v(xbgr.mr_n81848672)
print v(xbgr.mr_n81849888)
print v(xbgr.mr_n81850480)
print v(xbgr.mr_n81850592)
print v(xbgr.mr_n81850704)
print v(xbgr.mr_n81850816)
print v(xbgr.mr_n81850928)
print v(xbgr.mr_n81851120)
print v(xbgr.mr_n81851552)
print v(xbgr.mr_n81851664)
print v(xbgr.mr_n81851936)
print v(xbgr.mr_n81852288)
print v(xbgr.mr_n81852528)
print v(xbgr.mr_n81852928)
print v(xbgr.mr_n81853280)
print v(xbgr.mr_n81853456)
print v(xbgr.mr_n81853712)
print v(xbgr.mr_n81854400)
print v(xbgr.mr_n81855024)
print v(xbgr.mr_n81855568)
print v(xbgr.mr_n81856000)
print v(xbgr.mr_n81856416)
print v(xbgr.mr_n81857104)
print v(xbgr.mr_n81857568)
print v(xbgr.mr_n81857984)
print v(xbgr.mr_n81858416)
print v(xbgr.mr_n81859104)
print v(xbgr.mr_n81859792)
print v(xbgr.mr_n81860272)
print v(xbgr.mr_n81860768)
print v(xbgr.mr_n81861120)
print v(xbgr.mr_n81861808)
print v(xbgr.mr_n81862336)
print v(xbgr.mr_n81862688)
print v(xbgr.mr_n81863120)
print v(xbgr.mr_n81863808)
print v(xbgr.mr_n81864496)
print v(xbgr.mr_n81864976)
print v(xbgr.mr_n81865408)
print v(xbgr.mr_n81865824)
print v(xbgr.mr_n81866512)
print v(xbgr.mr_n81867392)
print v(xbgr.mr_n81867824)
print v(xbgr.mr_n81868512)
print v(xbgr.mr_n81869136)
print v(xbgr.mr_n81869680)
print v(xbgr.mr_n81870112)
print v(xbgr.mr_n81870528)
print v(xbgr.mr_n81871216)
print v(xbgr.mr_n81871744)
print v(xbgr.mr_n81872096)
print v(xbgr.mr_n81872528)
print v(xbgr.mr_n81873216)
print v(xbgr.mr_n81873760)
print v(xbgr.mr_n81874384)
print v(xbgr.mr_n81874816)
print v(xbgr.mr_n81875232)
print v(xbgr.mr_n81875920)
print v(xbgr.mr_n81876384)
print v(xbgr.mr_n81876800)
print v(xbgr.mr_n81877232)
print v(xbgr.mr_n81877424)
print v(xbgr.mr_n81877696)
print v(xbgr.mr_n81877968)
print v(xbgr.mr_n81878240)
print v(xbgr.mr_n81878512)
print v(xbgr.mr_n81878784)
print v(xbgr.mr_n81879056)
print v(xbgr.mr_n81879328)
print v(xbgr.mr_n81879600)
print v(xbgr.mr_n81879872)
print v(xbgr.mr_n81880144)
print v(xbgr.mr_n81880416)
print v(xbgr.mr_n81880688)
print v(xbgr.mr_n81888800)
print v(xbgr.mr_n81892080)
print v(xbgr.mr_n81898080)
print v(xbgr.mr_n81902304)
print v(xbgr.mr_n81903456)
print v(xbgr.mr_n81904880)
print v(xbgr.mr_n81905408)
print v(xbgr.mr_n81905872)
print v(xbgr.mr_n81906336)
print v(xbgr.mr_n81906800)
print v(xbgr.mr_n81907264)
print v(xbgr.mr_n81912320)
print v(xbgr.mr_n81919744)
print v(xbgr.mr_n81920960)
print v(xbgr.mr_n81930288)
print v(xbgr.mr_n81932672)
print v(xbgr.mr_n81936176)
print v(xbgr.mr_n81936368)
print v(xbgr.mr_n81936624)
print v(xbgr.mr_n81938592)
print v(xbgr.mr_n81938976)
print v(xbgr.mr_n81942384)
print v(xbgr.mr_n81945024)
print v(xbgr.mr_n81945872)
print v(xbgr.mr_n81950560)
print v(xbgr.mr_n81951344)
print v(xbgr.mr_n81952560)
print v(xbgr.mr_n81953152)
print v(xbgr.mr_n81954448)
print v(xbgr.mr_n81954960)
print v(xbgr.mr_n81956176)
print v(xbgr.mr_n81956768)
print v(xbgr.mr_n81957664)
print v(xbgr.mr_n81958320)
print v(xbgr.mr_n81958832)
print v(xbgr.mr_n81959728)
print v(xbgr.mr_n81960384)
print v(xbgr.mr_n81960896)
print v(xbgr.mr_n81961792)
print v(xbgr.mr_n81962368)
print v(xbgr.mr_n81962960)
print v(xbgr.mr_n81963856)
print v(xbgr.mr_n81964512)
print v(xbgr.mr_n81965024)
print v(xbgr.mr_n81965920)
print v(xbgr.mr_n81966576)
print v(xbgr.mr_n81967088)
print v(xbgr.mr_n81967984)
print v(xbgr.mr_n81968640)
print v(xbgr.mr_n81969152)
print v(xbgr.mr_n81970048)
print v(xbgr.mr_n81970704)
print v(xbgr.mr_n81971216)
print v(xbgr.mr_n81972112)
print v(xbgr.mr_n81972688)
print v(xbgr.mr_n81973280)
print v(xbgr.mr_n81974176)
print v(xbgr.mr_n81974752)
print v(xbgr.mr_n81975344)
print v(xbgr.mr_n81976240)
print v(xbgr.mr_n81976896)
print v(xbgr.mr_n81977408)
print v(xbgr.mr_n81978304)
print v(xbgr.mr_n81978960)
print v(xbgr.mr_n81979472)
print v(xbgr.mr_n81980368)
print v(xbgr.mr_n81980864)
print v(xbgr.mr_n81981536)
print v(xbgr.mr_n81982832)
print v(xbgr.mr_n81983344)
print v(xbgr.mr_n81983456)
print v(xbgr.mr_n81983568)
print v(xbgr.mr_n81983680)
print v(xbgr.mr_n81983952)
print v(xbgr.mr_n81984064)
print v(xbgr.mr_n81984416)
print v(xbgr.mr_n81984528)
print v(xbgr.mr_n81984640)
print v(xbgr.mr_n81985072)
print v(xbgr.mr_n81985552)
print v(xbgr.mr_n81985728)
print v(xbgr.mr_n81986080)
print v(xbgr.mr_n81986448)
print v(xbgr.mr_n81986784)
print v(xbgr.mr_n81987136)
print v(xbgr.mr_n81987248)
print v(xbgr.mr_n81987744)
print v(xbgr.mr_n81988240)
print v(xbgr.mr_n81988720)
print v(xbgr.mr_n81988896)
print v(xbgr.mr_n81989248)
print v(xbgr.mr_n81989616)
print v(xbgr.mr_n81989952)
print v(xbgr.mr_n81990304)
print v(xbgr.mr_n81990416)
print v(xbgr.mr_n81990912)
print v(xbgr.mr_n81991408)
print v(xbgr.mr_n81991888)
print v(xbgr.mr_n81992064)
print v(xbgr.mr_n81992416)
print v(xbgr.mr_n81992848)
print v(xbgr.mr_n81993232)
print v(xbgr.mr_n81993728)
print v(xbgr.mr_n81994160)
print v(xbgr.mr_n81994848)
print v(xbgr.mr_n81995536)
print v(xbgr.mr_n81996016)
print v(xbgr.mr_n81996512)
print v(xbgr.mr_n81996864)
print v(xbgr.mr_n81997552)
print v(xbgr.mr_n81998016)
print v(xbgr.mr_n81998432)
print v(xbgr.mr_n81998864)
print v(xbgr.mr_n81999552)
print v(xbgr.mr_n82000240)
print v(xbgr.mr_n82000592)
print v(xbgr.mr_n82000704)
print v(xbgr.mr_n82000896)
print v(xbgr.mr_n82001168)
print v(xbgr.mr_n82001440)
print v(xbgr.mr_n82001712)
print v(xbgr.mr_n82001984)
print v(xbgr.mr_n82002256)
print v(xbgr.mr_n82002528)
print v(xbgr.mr_n82002800)
print v(xbgr.mr_n82003072)
print v(xbgr.mr_n82003344)
print v(xbgr.mr_n82003616)
print v(xbgr.mr_n82003888)
print v(xbgr.mr_n82004160)
print v(xbgr.mr_n82004432)
print v(xbgr.mr_n82004704)
print v(xbgr.mr_n82004976)
print v(xbgr.mr_n82019696)
print v(xbgr.mr_n82022848)
print v(xbgr.mr_n82023312)
print v(xbgr.mr_n82023776)
print v(xbgr.mr_n82024240)
print v(xbgr.mr_n82024704)
print v(xbgr.mr_n82025168)
print v(xbgr.mr_n82025632)
print v(xbgr.mr_n82026160)
print v(xbgr.mr_n82026752)
print v(xbgr.mr_n82027344)
print v(xbgr.mr_n82027936)
print v(xbgr.mr_n82028528)
print v(xbgr.mr_n82029120)
print v(xbgr.mr_n82029712)
print v(xbgr.mr_n82030304)
print v(xbgr.mr_n82030896)
print v(xbgr.mr_n82031488)
print v(xbgr.mr_n82031792)
print v(xbgr.mr_n82036224)
print v(xbgr.mr_n82047424)
print v(xbgr.mr_n82050352)
print v(xbgr.mr_n82058240)
print v(xbgr.mr_n82058624)
print v(xbgr.mr_n82060448)
print v(xbgr.mr_n82060640)
print v(xbgr.mr_n82060896)
print v(xbgr.mr_n82061152)
print v(xbgr.mr_n82063312)
print v(xbgr.mr_n82069392)
print v(xbgr.mr_n82070544)
print v(xbgr.mr_n82071184)
print v(xbgr.mr_n82071584)
print v(xbgr.mr_n82072496)
print v(xbgr.mr_n82075488)
print v(xbgr.mr_n82076000)
print v(xbgr.mr_n82077216)
print v(xbgr.mr_n82077808)
print v(xbgr.mr_n82079104)
print v(xbgr.mr_n82079616)
print v(xbgr.mr_n82080912)
print v(xbgr.mr_n82081424)
print v(xbgr.mr_n82082640)
print v(xbgr.mr_n82083232)
print v(xbgr.mr_n82084528)
print v(xbgr.mr_n82085040)
print v(xbgr.mr_n82086336)
print v(xbgr.mr_n82086848)
print v(xbgr.mr_n82088064)
print v(xbgr.mr_n82088656)
print v(xbgr.mr_n82089952)
print v(xbgr.mr_n82090464)
print v(xbgr.mr_n82091680)
print v(xbgr.mr_n82092272)
print v(xbgr.mr_n82093488)
print v(xbgr.mr_n82094080)
print v(xbgr.mr_n82095376)
print v(xbgr.mr_n82095888)
print v(xbgr.mr_n82097104)
print v(xbgr.mr_n82097696)
print v(xbgr.mr_n82098912)
print v(xbgr.mr_n82099504)
print v(xbgr.mr_n82099616)
print v(xbgr.mr_n82099728)
print v(xbgr.mr_n82099840)
print v(xbgr.mr_n82100112)
print v(xbgr.mr_n82100224)
print v(xbgr.mr_n82100576)
print v(xbgr.mr_n82100688)
print v(xbgr.mr_n82100880)
print v(xbgr.mr_n82101312)
print v(xbgr.mr_n82101424)
print v(xbgr.mr_n82101792)
print v(xbgr.mr_n82102208)
print v(xbgr.mr_n82102832)
print v(xbgr.mr_n82103328)
print v(xbgr.mr_n82103680)
print v(xbgr.mr_n82104368)
print v(xbgr.mr_n82104832)
print v(xbgr.mr_n82105248)
print v(xbgr.mr_n82105680)
print v(xbgr.mr_n82106368)
print v(xbgr.mr_n82107056)
print v(xbgr.mr_n82107536)
print v(xbgr.mr_n82107968)
print v(xbgr.mr_n82108384)
print v(xbgr.mr_n82109072)
print v(xbgr.mr_n82109536)
print v(xbgr.mr_n82109952)
print v(xbgr.mr_n82110384)
print v(xbgr.mr_n82111072)
print v(xbgr.mr_n82111696)
print v(xbgr.mr_n82112240)
print v(xbgr.mr_n82112736)
print v(xbgr.mr_n82113088)
print v(xbgr.mr_n82113776)
print v(xbgr.mr_n82114304)
print v(xbgr.mr_n82114656)
print v(xbgr.mr_n82115088)
print v(xbgr.mr_n82115776)
print v(xbgr.mr_n82116464)
print v(xbgr.mr_n82116944)
print v(xbgr.mr_n82117376)
print v(xbgr.mr_n82117792)
print v(xbgr.mr_n82118480)
print v(xbgr.mr_n82118944)
print v(xbgr.mr_n82119360)
print v(xbgr.mr_n82119792)
print v(xbgr.mr_n82120480)
print v(xbgr.mr_n82121168)
print v(xbgr.mr_n82121648)
print v(xbgr.mr_n82122080)
print v(xbgr.mr_n82122496)
print v(xbgr.mr_n82123184)
print v(xbgr.mr_n82123712)
print v(xbgr.mr_n82124064)
print v(xbgr.mr_n82124496)
print v(xbgr.mr_n82125184)
print v(xbgr.mr_n82125872)
print v(xbgr.mr_n82126224)
print v(xbgr.mr_n82126336)
print v(xbgr.mr_n82126528)
print v(xbgr.mr_n82126800)
print v(xbgr.mr_n82127072)
print v(xbgr.mr_n82127344)
print v(xbgr.mr_n82127616)
print v(xbgr.mr_n82127888)
print v(xbgr.mr_n82128160)
print v(xbgr.mr_n82128432)
print v(xbgr.mr_n82128704)
print v(xbgr.mr_n82128976)
print v(xbgr.mr_n82129248)
print v(xbgr.mr_n82129520)
print v(xbgr.mr_n82129792)
print v(xbgr.mr_n82130064)
print v(xbgr.mr_n82130336)
print v(xbgr.mr_n82130608)
print v(xbgr.mr_n82137072)
print v(xbgr.mr_n82139040)
print v(xbgr.mr_n82148192)
print v(xbgr.mr_n82154368)
print v(xbgr.mr_n82154832)
print v(xbgr.mr_n82155296)
print v(xbgr.mr_n82155760)
print v(xbgr.mr_n82156224)
print v(xbgr.mr_n82156688)
print v(xbgr.mr_n82157152)
print v(xbgr.mr_n82157680)
print v(xbgr.mr_n82158272)
print v(xbgr.mr_n82158864)
print v(xbgr.mr_n82159456)
print v(xbgr.mr_n82160048)
print v(xbgr.mr_n82160640)
print v(xbgr.mr_n82161232)
print v(xbgr.mr_n82161824)
print v(xbgr.mr_n82162416)
print v(xbgr.mr_n82163008)
print v(xbgr.mr_n82165856)
print v(xbgr.mr_n82167296)
print v(xbgr.mr_n82180848)
print v(xbgr.mr_n82181024)
print v(xbgr.mr_n82181360)
print v(xbgr.mr_n82182240)
print v(xbgr.mr_n82183136)
print v(xbgr.mr_n82183728)
print v(xbgr.mr_n82184320)
print v(xbgr.mr_n82184912)
print v(xbgr.mr_n82185504)
print v(xbgr.mr_n82186096)
print v(xbgr.mr_n82186688)
print v(xbgr.mr_n82187280)
print v(xbgr.mr_n82187872)
print v(xbgr.mr_n82188464)
print v(xbgr.mr_n82189056)
print v(xbgr.mr_n82189648)
print v(xbgr.mr_n82190240)
print v(xbgr.mr_n82190832)
print v(xbgr.mr_n82191424)
print v(xbgr.mr_n82192016)
print v(xbgr.mr_n82192608)
print v(xbgr.mr_n82193200)
print v(xbgr.mr_n82193792)
print v(xbgr.mr_n82196496)
print v(xbgr.mr_n82198480)
print v(xbgr.mr_n82201040)
print v(xbgr.mr_n82201680)
print v(xbgr.mr_n82202704)
print v(xbgr.mr_n82203248)
print v(xbgr.mr_n82203680)
print v(xbgr.mr_n82204096)
print v(xbgr.mr_n82204208)
print v(xbgr.mr_n82204912)
print v(xbgr.mr_n82206704)
print v(xbgr.mr_n82206816)
print v(xbgr.mr_n82206928)
print v(xbgr.mr_n82207040)
print v(xbgr.mr_n82207360)
print v(xbgr.mr_n82207872)
print v(xbgr.mr_n82208064)
print v(xbgr.mr_n82209008)
print v(xbgr.mr_n82209184)
print v(xbgr.mr_n82211024)
print v(xbgr.mr_n82211440)
print v(xbgr.mr_n82211552)
print v(xbgr.mr_n82212256)
print v(xbgr.mr_n82215008)
print v(xbgr.mr_n82215360)
print v(xbgr.mr_n82215472)
print v(xbgr.mr_n82216176)
print v(xbgr.mr_n82218352)
print v(xbgr.mr_n82218768)
print v(xbgr.mr_n82218880)
print v(xbgr.mr_n82219584)
print v(xbgr.mr_n82221760)
print v(xbgr.mr_n82222176)
print v(xbgr.mr_n82222288)
print v(xbgr.mr_n82222992)
print v(xbgr.mr_n82225232)
print v(xbgr.mr_n82225584)
print v(xbgr.mr_n82225696)
print v(xbgr.mr_n82226400)
print v(xbgr.mr_n82228640)
print v(xbgr.mr_n82228992)
print v(xbgr.mr_n82229104)
print v(xbgr.mr_n82229808)
print v(xbgr.mr_n82231984)
print v(xbgr.mr_n82232400)
print v(xbgr.mr_n82232512)
print v(xbgr.mr_n82233216)
print v(xbgr.mr_n82246784)
print v(xbgr.mr_n82246960)
print v(xbgr.mr_n82247584)
print v(xbgr.mr_n82247760)
print v(xbgr.mr_n82248384)
print v(xbgr.mr_n82248560)
print v(xbgr.mr_n82249184)
print v(xbgr.mr_n82249360)
print v(xbgr.mr_n82249984)
print v(xbgr.mr_n82250160)
print v(xbgr.mr_n82250784)
print v(xbgr.mr_n82250960)
print v(xbgr.mr_n82251584)
print v(xbgr.mr_n82251760)
print v(xbgr.mr_n82252384)
print v(xbgr.mr_n82252560)
print v(xbgr.mr_n82253184)
print v(xbgr.mr_n82253360)
print v(xbgr.mr_n82253984)
print v(xbgr.mr_n82254160)
print v(xbgr.mr_n82254784)
print v(xbgr.mr_n82254960)
print v(xbgr.mr_n82255584)
print v(xbgr.mr_n82255760)
print v(xbgr.mr_n82256384)
print v(xbgr.mr_n82256560)
print v(xbgr.mr_n82257184)
print v(xbgr.mr_n82257360)
print v(xbgr.mr_n82257984)
print v(xbgr.mr_n82258160)
print v(xbgr.mr_n82258784)
print v(xbgr.mr_n82258960)
print v(xbgr.mr_n82259392)
print v(xbgr.mr_n82259504)
print v(xbgr.mr_n82259616)
print v(xbgr.mr_n82259728)
print v(xbgr.mr_n82259920)
print v(xbgr.mr_n82260192)
print v(xbgr.mr_n82260464)
print v(xbgr.mr_n82260736)
print v(xbgr.mr_n82261008)
print v(xbgr.mr_n82261280)
print v(xbgr.mr_n82261552)
print v(xbgr.mr_n82261824)
print v(xbgr.mr_n82262096)
print v(xbgr.mr_n82262368)
print v(xbgr.mr_n82262640)
print v(xbgr.mr_n82262912)
print v(xbgr.mr_n82263184)
print v(xbgr.mr_n82264400)
print v(xbgr.mr_n82266176)
print v(xbgr.mr_n82267600)
print v(xbgr.mr_n82269312)
print v(xbgr.mr_n82272896)
print v(xbgr.mr_n82290304)
print v(xbgr.mr_n82294912)
print v(xbgr.mr_n82299008)
print v(xbgr.mr_n82300672)
print v(xbgr.mr_n82300848)
print v(xbgr.mr_n82301184)
print v(xbgr.mr_n82303024)
print v(xbgr.mr_n82303200)
print v(xbgr.mr_n82304144)
print v(xbgr.mr_n82304800)
print v(xbgr.mr_n82304976)
print v(xbgr.mr_n82305920)
print v(xbgr.mr_n82306576)
print v(xbgr.mr_n82306752)
print v(xbgr.mr_n82307696)
print v(xbgr.mr_n82308352)
print v(xbgr.mr_n82308528)
print v(xbgr.mr_n82309472)
print v(xbgr.mr_n82310128)
print v(xbgr.mr_n82310304)
print v(xbgr.mr_n82311248)
print v(xbgr.mr_n82311904)
print v(xbgr.mr_n82312080)
print v(xbgr.mr_n82313024)
print v(xbgr.mr_n82313680)
print v(xbgr.mr_n82313856)
print v(xbgr.mr_n82314800)
print v(xbgr.mr_n82315456)
print v(xbgr.mr_n82315632)
print v(xbgr.mr_n82316576)
print v(xbgr.mr_n82317232)
print v(xbgr.mr_n82317408)
print v(xbgr.mr_n82318352)
print v(xbgr.mr_n82319008)
print v(xbgr.mr_n82319184)
print v(xbgr.mr_n82320224)
print v(xbgr.mr_n82320496)
print v(xbgr.mr_n82320768)
print v(xbgr.mr_n82321104)
print v(xbgr.mr_n82321568)
print v(xbgr.mr_n82321920)
print v(xbgr.mr_n82322112)
print v(xbgr.mr_n82322304)
print v(xbgr.mr_n82322496)
print v(xbgr.mr_n82323248)
print v(xbgr.mr_n82326832)
print v(xbgr.mr_n82327248)
print v(xbgr.mr_n82327360)
print v(xbgr.mr_n82328064)
print v(xbgr.mr_n82330304)
print v(xbgr.mr_n82330656)
print v(xbgr.mr_n82330768)
print v(xbgr.mr_n82331472)
print v(xbgr.mr_n82333712)
print v(xbgr.mr_n82334064)
print v(xbgr.mr_n82334176)
print v(xbgr.mr_n82334880)
print v(xbgr.mr_n82335056)
print v(xbgr.mr_n82337120)
print v(xbgr.mr_n82337472)
print v(xbgr.mr_n82337584)
print v(xbgr.mr_n82338288)
print v(xbgr.mr_n82339712)
print v(xbgr.mr_n82340528)
print v(xbgr.mr_n82341696)
print v(xbgr.mr_n82342192)
print v(xbgr.mr_n82342304)
print v(xbgr.mr_n82343248)
print v(xbgr.mr_n82346416)
print v(xbgr.mr_n82346912)
print v(xbgr.mr_n82347264)
print v(xbgr.mr_n82347376)
print v(xbgr.mr_n82348080)
print v(xbgr.mr_n82350640)
print v(xbgr.mr_n82351056)
print v(xbgr.mr_n82351168)
print v(xbgr.mr_n82351872)
print v(xbgr.mr_n82354048)
print v(xbgr.mr_n82354464)
print v(xbgr.mr_n82354576)
print v(xbgr.mr_n82355280)
print v(xbgr.mr_n82367840)
print v(xbgr.mr_n82368016)
print v(xbgr.mr_n82368640)
print v(xbgr.mr_n82368816)
print v(xbgr.mr_n82369440)
print v(xbgr.mr_n82369616)
print v(xbgr.mr_n82370240)
print v(xbgr.mr_n82370416)
print v(xbgr.mr_n82371040)
print v(xbgr.mr_n82371216)
print v(xbgr.mr_n82371840)
print v(xbgr.mr_n82372016)
print v(xbgr.mr_n82372640)
print v(xbgr.mr_n82372816)
print v(xbgr.mr_n82373440)
print v(xbgr.mr_n82373616)
print v(xbgr.mr_n82374240)
print v(xbgr.mr_n82374416)
print v(xbgr.mr_n82375040)
print v(xbgr.mr_n82375216)
print v(xbgr.mr_n82375840)
print v(xbgr.mr_n82376016)
print v(xbgr.mr_n82376640)
print v(xbgr.mr_n82376816)
print v(xbgr.mr_n82377440)
print v(xbgr.mr_n82377616)
print v(xbgr.mr_n82378240)
print v(xbgr.mr_n82378416)
print v(xbgr.mr_n82379040)
print v(xbgr.mr_n82379216)
print v(xbgr.mr_n82379840)
print v(xbgr.mr_n82380016)
print v(xbgr.mr_n82381024)
print v(xbgr.mr_n82391648)
print v(xbgr.mr_n82391952)
print v(xbgr.mr_n82392256)
print v(xbgr.mr_n82392560)
print v(xbgr.mr_n82392944)
print v(xbgr.mr_n82393408)
print v(xbgr.mr_n82393872)
print v(xbgr.mr_n82394336)
print v(xbgr.mr_n82394800)
print v(xbgr.mr_n82395264)
print v(xbgr.mr_n82395728)
print v(xbgr.mr_n82396192)
print v(xbgr.mr_n82396656)
print v(xbgr.mr_n82397120)
print v(xbgr.mr_n82397584)
print v(xbgr.mr_n82398048)
print v(xbgr.mr_n82398512)
print v(xbgr.mr_n82398976)
print v(xbgr.mr_n82399440)
print v(xbgr.mr_n82399904)
print v(xbgr.mr_n82400368)
print v(xbgr.mr_n82400832)
print v(xbgr.mr_n82401296)
print v(xbgr.mr_n82401760)
print v(xbgr.mr_n82402224)
print v(xbgr.mr_n82402688)
print v(xbgr.mr_n82403152)
print v(xbgr.mr_n82403616)
print v(xbgr.mr_n82404080)
print v(xbgr.mr_n82404544)
print v(xbgr.mr_n82404992)
print v(xbgr.mr_n82408816)
print v(xbgr.mr_n82412032)
print v(xbgr.mr_n82423664)
print v(xbgr.mr_n82424256)
print v(xbgr.mr_n82429136)
print v(xbgr.mr_n82429600)
print v(xbgr.mr_n82430064)
print v(xbgr.mr_n82430592)
print v(xbgr.mr_n82431184)
print v(xbgr.mr_n82431776)
print v(xbgr.mr_n82432368)
print v(xbgr.mr_n82432960)
print v(xbgr.mr_n82433552)
print v(xbgr.mr_n82434144)
print v(xbgr.mr_n82434736)
print v(xbgr.mr_n82435328)
print v(xbgr.mr_n82435920)
print v(xbgr.mr_n82436512)
print v(xbgr.mr_n82437104)
print v(xbgr.mr_n82437696)
print v(xbgr.mr_n82438288)
print v(xbgr.mr_n82440400)
print v(xbgr.mr_n82456048)
print v(xbgr.mr_n82460672)
print v(xbgr.mr_n82461776)
print v(xbgr.mr_n82461968)
print v(xbgr.mr_n82462224)
print v(xbgr.mr_n82462480)
print v(xbgr.mr_n82464640)
print v(xbgr.mr_n82488384)
print v(xbgr.mr_n82489552)
print v(xbgr.mr_n82489984)
print v(xbgr.mr_n82491776)
print v(xbgr.mr_n82493008)
print v(xbgr.mr_n82497328)
print v(xbgr.mr_n82502576)
print v(xbgr.mr_n82503392)
print v(xbgr.mr_n82506192)
print v(xbgr.mr_n82513808)
print v(xbgr.mr_n82515536)
print v(xbgr.mr_n82520080)
print v(xbgr.mr_n82523856)
print v(xbgr.mr_n82525680)
print v(xbgr.mr_n82530384)
print v(xbgr.mr_n82530976)
print v(xbgr.mr_n82531568)
print v(xbgr.mr_n82532160)
print v(xbgr.mr_n82532752)
print v(xbgr.mr_n82533344)
print v(xbgr.mr_n82533936)
print v(xbgr.mr_n82534528)
print v(xbgr.mr_n82535120)
print v(xbgr.mr_n82535712)
print v(xbgr.mr_n82536304)
print v(xbgr.mr_n82536896)
print v(xbgr.mr_n82537520)
print v(xbgr.mr_n82538928)
print v(xbgr.mr_n82539392)
print v(xbgr.mr_n82539856)
print v(xbgr.mr_n82542208)
print v(xbgr.mr_n82543072)
print v(xbgr.mr_n82543840)
print v(xbgr.mr_n82544016)
print v(xbgr.mr_n82544192)
print v(xbgr.mr_n82545984)
print v(xbgr.mr_n82550448)
print v(xbgr.mr_n82550784)
print v(xbgr.mr_n82551120)
print v(xbgr.mr_n82552704)
print v(xbgr.mr_n82553600)
print v(xbgr.mr_n82553776)
print v(xbgr.mr_n82554288)
print v(xbgr.mr_n82554784)
print v(xbgr.mr_n82554960)
print v(xbgr.mr_n82555376)
print v(xbgr.mr_n82555888)
print v(xbgr.mr_n82556384)
print v(xbgr.mr_n82556720)
print v(xbgr.mr_n82557232)
print v(xbgr.mr_n82557344)
print v(xbgr.mr_n82557456)
print v(xbgr.mr_n82558448)
print v(xbgr.mr_n82558864)
print v(xbgr.mr_n82559376)
print v(xbgr.mr_n82559872)
print v(xbgr.mr_n82560048)
print v(xbgr.mr_n82560464)
print v(xbgr.mr_n82560976)
print v(xbgr.mr_n82561536)
print v(xbgr.mr_n82561712)
print v(xbgr.mr_n82562208)
print v(xbgr.mr_n82562976)
print v(xbgr.mr_n82563152)
print v(xbgr.mr_n82563408)
print v(xbgr.mr_n82563920)
print v(xbgr.mr_n82564032)
print v(xbgr.mr_n82564144)
print v(xbgr.mr_n82564256)
print v(xbgr.mr_n82565744)
print v(xbgr.mr_n82565920)
print v(xbgr.mr_n82566496)
print v(xbgr.mr_n82567200)
print v(xbgr.mr_n82567376)
print v(xbgr.mr_n82567808)
print v(xbgr.mr_n82567920)
print v(xbgr.mr_n82568752)
print v(xbgr.mr_n82568928)
print v(xbgr.mr_n82569184)
print v(xbgr.mr_n82569840)
print v(xbgr.mr_n82570544)
print v(xbgr.mr_n82570720)
print v(xbgr.mr_n82571152)
print v(xbgr.mr_n82571712)
print v(xbgr.mr_n82571888)
print v(xbgr.mr_n82572384)
print v(xbgr.mr_n82572896)
print v(xbgr.mr_n82573008)
print v(xbgr.mr_n82573712)
print v(xbgr.mr_n82574128)
print v(xbgr.mr_n82574640)
print v(xbgr.mr_n82575136)
print v(xbgr.mr_n82575312)
print v(xbgr.mr_n82575728)
print v(xbgr.mr_n82576240)
print v(xbgr.mr_n82576736)
print v(xbgr.mr_n82577072)
print v(xbgr.mr_n82577584)
print v(xbgr.mr_n82577696)
print v(xbgr.mr_n82577808)
print v(xbgr.mr_n82578928)
print v(xbgr.mr_n82579104)
print v(xbgr.mr_n82579360)
print v(xbgr.mr_n82580016)
print v(xbgr.mr_n82580528)
print v(xbgr.mr_n82580640)
print v(xbgr.mr_n82580832)
print v(xbgr.mr_n82581184)
print v(xbgr.mr_n82581296)
print v(xbgr.mr_n82581808)
print v(xbgr.mr_n82581920)
print v(xbgr.mr_n82582032)
print v(xbgr.mr_n82582384)
print v(xbgr.mr_n82582720)
print v(xbgr.mr_n82583664)
print v(xbgr.mr_n82584080)
print v(xbgr.mr_n82584192)
print v(xbgr.mr_n82584752)
print v(xbgr.mr_n82585008)
print v(xbgr.mr_n82585824)
print v(xbgr.mr_n82586256)
print v(xbgr.mr_n82586432)
print v(xbgr.mr_n82587360)
print v(xbgr.mr_n82587536)
print v(xbgr.mr_n82588112)
print v(xbgr.mr_n82588224)
print v(xbgr.mr_n82588336)
print v(xbgr.mr_n82589104)
print v(xbgr.mr_n82589440)
print v(xbgr.mr_n82590384)
print v(xbgr.mr_n82590800)
print v(xbgr.mr_n82590912)
print v(xbgr.mr_n82591472)
print v(xbgr.mr_n82591728)
print v(xbgr.mr_n82592672)
print v(xbgr.mr_n82593088)
print v(xbgr.mr_n82593200)
print v(xbgr.mr_n82593312)
print v(xbgr.mr_n82594080)
print v(xbgr.mr_n82594416)
print v(xbgr.mr_n82595424)
print v(xbgr.mr_n82595600)
print v(xbgr.mr_n82596176)
print v(xbgr.mr_n82596608)
print v(xbgr.mr_n82596784)
print v(xbgr.mr_n82597520)
print v(xbgr.mr_n82597632)
print v(xbgr.mr_n82598192)
print v(xbgr.mr_n82598448)
print v(xbgr.mr_n82599392)
print v(xbgr.mr_n82599808)
print v(xbgr.mr_n82599920)
print v(xbgr.mr_n82600032)
print v(xbgr.mr_n82600800)
print v(xbgr.mr_n82601136)
print v(xbgr.mr_n82601952)
print v(xbgr.mr_n82602064)
print v(xbgr.mr_n82602624)
print v(xbgr.mr_n82602880)
print v(xbgr.mr_n82603824)
print v(xbgr.mr_n82604240)
print v(xbgr.mr_n82604352)
print v(xbgr.mr_n82604912)
print v(xbgr.mr_n82605168)
print v(xbgr.mr_n82605984)
print v(xbgr.mr_n82606416)
print v(xbgr.mr_n82606592)
print v(xbgr.mr_n82607920)
print v(xbgr.mr_n82612192)
print v(xbgr.mr_n82612304)
print v(xbgr.mr_n82612928)
print v(xbgr.mr_n82613392)
print v(xbgr.mr_n82613856)
print v(xbgr.mr_n82614320)
print v(xbgr.mr_n82614784)
print v(xbgr.mr_n82615248)
print v(xbgr.mr_n82615712)
print v(xbgr.mr_n82616176)
print v(xbgr.mr_n82616640)
print v(xbgr.mr_n82617104)
print v(xbgr.mr_n82617568)
print v(xbgr.mr_n82618032)
print v(xbgr.mr_n82618496)
print v(xbgr.mr_n82618944)
print v(xbgr.mr_n82619408)
print v(xbgr.mr_n82619872)
print v(xbgr.mr_n82620336)
print v(xbgr.mr_n82620800)
print v(xbgr.mr_n82621264)
print v(xbgr.mr_n82621728)
print v(xbgr.mr_n82622192)
print v(xbgr.mr_n82622656)
print v(xbgr.mr_n82623120)
print v(xbgr.mr_n82623872)
print v(xbgr.mr_n82637824)
print v(xbgr.mr_n82641952)
print v(xbgr.mr_n82647424)
print v(xbgr.mr_n82648032)
print v(xbgr.mr_n82650384)
print v(xbgr.mr_n82650592)
print v(xbgr.mr_n82651936)
print v(xbgr.mr_n82654848)
print v(xbgr.mr_n82655456)
print v(xbgr.mr_n82659040)
print v(xbgr.mr_n82661952)
print v(xbgr.mr_n82662960)
print v(xbgr.mr_n82666624)
print v(xbgr.mr_n82666880)
print v(xbgr.mr_n82667216)
print v(xbgr.mr_n82667552)
print v(xbgr.mr_n82669584)
print v(xbgr.mr_n82670224)
print v(xbgr.mr_n82670336)
print v(xbgr.mr_n82672160)
print v(xbgr.mr_n82672272)
print v(xbgr.mr_n82673968)
print v(xbgr.mr_n82674080)
print v(xbgr.mr_n82675776)
print v(xbgr.mr_n82675888)
print v(xbgr.mr_n82677584)
print v(xbgr.mr_n82677696)
print v(xbgr.mr_n82679392)
print v(xbgr.mr_n82679504)
print v(xbgr.mr_n82681200)
print v(xbgr.mr_n82681312)
print v(xbgr.mr_n82683008)
print v(xbgr.mr_n82683120)
print v(xbgr.mr_n82684816)
print v(xbgr.mr_n82684928)
print v(xbgr.mr_n82686624)
print v(xbgr.mr_n82686736)
print v(xbgr.mr_n82688432)
print v(xbgr.mr_n82688544)
print v(xbgr.mr_n82690240)
print v(xbgr.mr_n82690352)
print v(xbgr.mr_n82692048)
print v(xbgr.mr_n82692160)
print v(xbgr.mr_n82693856)
print v(xbgr.mr_n82693968)
print v(xbgr.mr_n82695664)
print v(xbgr.mr_n82695776)
print v(xbgr.mr_n82697472)
print v(xbgr.mr_n82697584)
print v(xbgr.mr_n82699280)
print v(xbgr.mr_n82699392)
print v(xbgr.mr_n82701824)
print v(xbgr.mr_n82704448)
print v(xbgr.mr_n82705088)
print v(xbgr.mr_n82725392)
print v(xbgr.mr_n82725856)
print v(xbgr.mr_n82725968)
print v(xbgr.mr_n82726784)
print v(xbgr.mr_n82727248)
print v(xbgr.mr_n82727360)
print v(xbgr.mr_n82728176)
print v(xbgr.mr_n82728704)
print v(xbgr.mr_n82728880)
print v(xbgr.mr_n82729824)
print v(xbgr.mr_n82730480)
print v(xbgr.mr_n82730656)
print v(xbgr.mr_n82731600)
print v(xbgr.mr_n82732256)
print v(xbgr.mr_n82732432)
print v(xbgr.mr_n82733376)
print v(xbgr.mr_n82734032)
print v(xbgr.mr_n82734208)
print v(xbgr.mr_n82735152)
print v(xbgr.mr_n82735808)
print v(xbgr.mr_n82735984)
print v(xbgr.mr_n82736928)
print v(xbgr.mr_n82737584)
print v(xbgr.mr_n82737760)
print v(xbgr.mr_n82738704)
print v(xbgr.mr_n82739360)
print v(xbgr.mr_n82739536)
print v(xbgr.mr_n82740480)
print v(xbgr.mr_n82741072)
print v(xbgr.mr_n82741664)
print v(xbgr.mr_n82742256)
print v(xbgr.mr_n82742848)
print v(xbgr.mr_n82743440)
print v(xbgr.mr_n82744032)
print v(xbgr.mr_n82744624)
print v(xbgr.mr_n82745216)
print v(xbgr.mr_n82745808)
print v(xbgr.mr_n82746400)
print v(xbgr.mr_n82746992)
print v(xbgr.mr_n82747376)
print v(xbgr.mr_n82747600)
print v(xbgr.mr_n82747712)
print v(xbgr.mr_n82747824)
print v(xbgr.mr_n82748736)
print v(xbgr.mr_n82749776)
print v(xbgr.mr_n82750368)
print v(xbgr.mr_n82750960)
print v(xbgr.mr_n82751552)
print v(xbgr.mr_n82752144)
print v(xbgr.mr_n82752736)
print v(xbgr.mr_n82753328)
print v(xbgr.mr_n82753920)
print v(xbgr.mr_n82754512)
print v(xbgr.mr_n82755104)
print v(xbgr.mr_n82755696)
print v(xbgr.mr_n82756288)
print v(xbgr.mr_n82756880)
print v(xbgr.mr_n82757472)
print v(xbgr.mr_n82758064)
print v(xbgr.mr_n82758656)
print v(xbgr.mr_n82759248)
print v(xbgr.mr_n82760672)
print v(xbgr.mr_n82767008)
print v(xbgr.mr_n82772768)
print v(xbgr.mr_n82776064)
print v(xbgr.mr_n82776400)
print v(xbgr.mr_n82776816)
print v(xbgr.mr_n82777568)
print v(xbgr.mr_n82777680)
print v(xbgr.mr_n82779376)
print v(xbgr.mr_n82779488)
print v(xbgr.mr_n82781184)
print v(xbgr.mr_n82781296)
print v(xbgr.mr_n82782992)
print v(xbgr.mr_n82783104)
print v(xbgr.mr_n82784800)
print v(xbgr.mr_n82784912)
print v(xbgr.mr_n82786608)
print v(xbgr.mr_n82786720)
print v(xbgr.mr_n82788416)
print v(xbgr.mr_n82788528)
print v(xbgr.mr_n82790224)
print v(xbgr.mr_n82790336)
print v(xbgr.mr_n82792032)
print v(xbgr.mr_n82792144)
print v(xbgr.mr_n82793840)
print v(xbgr.mr_n82793952)
print v(xbgr.mr_n82795648)
print v(xbgr.mr_n82795760)
print v(xbgr.mr_n82795872)
print v(xbgr.mr_n82797712)
print v(xbgr.mr_n82797824)
print v(xbgr.mr_n82797936)
print v(xbgr.mr_n82799776)
print v(xbgr.mr_n82799888)
print v(xbgr.mr_n82800000)
print v(xbgr.mr_n82801840)
print v(xbgr.mr_n82801952)
print v(xbgr.mr_n82802064)
print v(xbgr.mr_n82803904)
print v(xbgr.mr_n82804016)
print v(xbgr.mr_n82804128)
print v(xbgr.mr_n82805968)
print v(xbgr.mr_n82806080)
print v(xbgr.mr_n82806192)
print v(xbgr.mr_n82808032)
print v(xbgr.mr_n82808144)
print v(xbgr.mr_n82808256)
print v(xbgr.mr_n82809168)
print v(xbgr.mr_n82809520)
print v(xbgr.mr_n82810032)
print v(xbgr.mr_n82810576)
print v(xbgr.mr_n82811120)
print v(xbgr.mr_n82811664)
print v(xbgr.mr_n82812208)
print v(xbgr.mr_n82812752)
print v(xbgr.mr_n82813296)
print v(xbgr.mr_n82813840)
print v(xbgr.mr_n82814384)
print v(xbgr.mr_n82814928)
print v(xbgr.mr_n82815472)
print v(xbgr.mr_n82816016)
print v(xbgr.mr_n82816560)
print v(xbgr.mr_n82817104)
print v(xbgr.mr_n82817648)
print v(xbgr.mr_n82818192)
print v(xbgr.mr_n82818736)
print v(xbgr.mr_n82819280)
print v(xbgr.mr_n82819824)
print v(xbgr.mr_n82820368)
print v(xbgr.mr_n82820912)
print v(xbgr.mr_n82821456)
print v(xbgr.mr_n82822000)
print v(xbgr.mr_n82822544)
print v(xbgr.mr_n82823088)
print v(xbgr.mr_n82823552)
print v(xbgr.mr_n82824288)
print v(xbgr.mr_n82824592)
print v(xbgr.mr_n82824896)
print v(xbgr.mr_n82825360)
print v(xbgr.mr_n82825824)
print v(xbgr.mr_n82826288)
print v(xbgr.mr_n82826752)
print v(xbgr.mr_n82827216)
print v(xbgr.mr_n82827680)
print v(xbgr.mr_n82828144)
print v(xbgr.mr_n82828608)
print v(xbgr.mr_n82829072)
print v(xbgr.mr_n82829536)
print v(xbgr.mr_n82830000)
print v(xbgr.mr_n82830464)
print v(xbgr.mr_n82830928)
print v(xbgr.mr_n82831392)
print v(xbgr.mr_n82831856)
print v(xbgr.mr_n82832320)
print v(xbgr.mr_n82832784)
print v(xbgr.mr_n82833248)
print v(xbgr.mr_n82833712)
print v(xbgr.mr_n82834176)
print v(xbgr.mr_n82834672)
print v(xbgr.mr_n82835264)
print v(xbgr.mr_n82835856)
print v(xbgr.mr_n82836448)
print v(xbgr.mr_n82837040)
print v(xbgr.mr_n82837632)
print v(xbgr.mr_n82838224)
print v(xbgr.mr_n82839728)
print v(xbgr.mr_n82841984)
print v(xbgr.mr_n82843120)
print v(xbgr.mr_n82846528)
print v(xbgr.mr_n82851328)
print v(xbgr.mr_n82851600)
print v(xbgr.mr_n82851776)
print v(xbgr.mr_n82853712)
print v(xbgr.mr_n82853904)
print v(xbgr.mr_n82890240)
print v(xbgr.mr_n82891072)
print v(xbgr.mr_n82891584)
print v(xbgr.mr_n82891872)
print v(xbgr.mr_n82897168)
print v(xbgr.mr_n82897536)
print v(xbgr.mr_n82897728)
print v(xbgr.mr_n82902528)
print v(xbgr.mr_n82909056)
print v(xbgr.mr_n82909232)
print v(xbgr.mr_n82910256)
print v(xbgr.mr_n82915744)
print v(xbgr.mr_n82916016)
print v(xbgr.mr_n82917056)
print v(xbgr.mr_n82917232)
print v(xbgr.mr_n82917408)
print v(xbgr.mr_n82920192)
print v(xbgr.mr_n82925584)
print v(xbgr.mr_n82926704)
print v(xbgr.mr_n82928272)
print v(xbgr.mr_n82929232)
print v(xbgr.mr_n82931136)
print v(xbgr.mr_n82934112)
print v(xbgr.mr_n82934416)
print v(xbgr.mr_n82936320)
print v(xbgr.mr_n82936928)
print v(xbgr.mr_n82939136)
print v(xbgr.mr_n82942192)
print v(xbgr.mr_n82943664)
print v(xbgr.mr_n82946352)
print v(xbgr.mr_n82946688)
print v(xbgr.mr_n82947024)
print v(xbgr.mr_n82947360)
print v(xbgr.mr_n82947776)
print v(xbgr.mr_n82948016)
print v(xbgr.mr_n82948400)
print v(xbgr.mr_n82948912)
print v(xbgr.mr_n82949024)
print v(xbgr.mr_n82949136)
print v(xbgr.mr_n82950976)
print v(xbgr.mr_n82951088)
print v(xbgr.mr_n82951200)
print v(xbgr.mr_n82953040)
print v(xbgr.mr_n82953152)
print v(xbgr.mr_n82953264)
print v(xbgr.mr_n82955104)
print v(xbgr.mr_n82955216)
print v(xbgr.mr_n82955328)
print v(xbgr.mr_n82957168)
print v(xbgr.mr_n82957280)
print v(xbgr.mr_n82957392)
print v(xbgr.mr_n82959232)
print v(xbgr.mr_n82959344)
print v(xbgr.mr_n82959456)
print v(xbgr.mr_n82961296)
print v(xbgr.mr_n82961408)
print v(xbgr.mr_n82961520)
print v(xbgr.mr_n82963360)
print v(xbgr.mr_n82963472)
print v(xbgr.mr_n82963584)
print v(xbgr.mr_n82965424)
print v(xbgr.mr_n82965536)
print v(xbgr.mr_n82965648)
print v(xbgr.mr_n82967488)
print v(xbgr.mr_n82967600)
print v(xbgr.mr_n82967712)
print v(xbgr.mr_n82969552)
print v(xbgr.mr_n82969664)
print v(xbgr.mr_n82969776)
print v(xbgr.mr_n82971616)
print v(xbgr.mr_n82971728)
print v(xbgr.mr_n82971840)
print v(xbgr.mr_n82973680)
print v(xbgr.mr_n82973792)
print v(xbgr.mr_n82973904)
print v(xbgr.mr_n82976448)
print v(xbgr.mr_n82976560)
print v(xbgr.mr_n82976928)
print v(xbgr.mr_n82980432)
print v(xbgr.mr_n82980544)
print v(xbgr.mr_n82980912)
print v(xbgr.mr_n82984416)
print v(xbgr.mr_n82984528)
print v(xbgr.mr_n82984896)
print v(xbgr.mr_n82988400)
print v(xbgr.mr_n82988512)
print v(xbgr.mr_n82988880)
print v(xbgr.mr_n82991472)
print v(xbgr.mr_n82991584)
print v(xbgr.mr_n82993088)
print v(xbgr.mr_n82993808)
print v(xbgr.mr_n82993984)
print v(xbgr.mr_n82995552)
print v(xbgr.mr_n82996368)
print v(xbgr.mr_n82996544)
print v(xbgr.mr_n82996912)
print v(xbgr.mr_n82998112)
print v(xbgr.mr_n82998928)
print v(xbgr.mr_n82999104)
print v(xbgr.mr_n83000672)
print v(xbgr.mr_n83001488)
print v(xbgr.mr_n83001664)
print v(xbgr.mr_n83003232)
print v(xbgr.mr_n83004048)
print v(xbgr.mr_n83004224)
print v(xbgr.mr_n83005792)
print v(xbgr.mr_n83006608)
print v(xbgr.mr_n83006784)
print v(xbgr.mr_n83008352)
print v(xbgr.mr_n83009168)
print v(xbgr.mr_n83009344)
print v(xbgr.mr_n83010912)
print v(xbgr.mr_n83011728)
print v(xbgr.mr_n83011904)
print v(xbgr.mr_n83013472)
print v(xbgr.mr_n83014288)
print v(xbgr.mr_n83014464)
print v(xbgr.mr_n83016032)
print v(xbgr.mr_n83016848)
print v(xbgr.mr_n83017024)
print v(xbgr.mr_n83017536)
print v(xbgr.mr_n83017712)
print v(xbgr.mr_n83017824)
print v(xbgr.mr_n83018432)
print v(xbgr.mr_n83018704)
print v(xbgr.mr_n83020368)
print v(xbgr.mr_n83020864)
print v(xbgr.mr_n83020976)
print v(xbgr.mr_n83023216)
print v(xbgr.mr_n83024608)
print v(xbgr.mr_n83024784)
print v(xbgr.mr_n83026352)
print v(xbgr.mr_n83027168)
print v(xbgr.mr_n83027344)
print v(xbgr.mr_n83028912)
print v(xbgr.mr_n83029728)
print v(xbgr.mr_n83029904)
print v(xbgr.mr_n83031472)
print v(xbgr.mr_n83032288)
print v(xbgr.mr_n83032464)
print v(xbgr.mr_n83034032)
print v(xbgr.mr_n83034848)
print v(xbgr.mr_n83035024)
print v(xbgr.mr_n83036592)
print v(xbgr.mr_n83037408)
print v(xbgr.mr_n83037584)
print v(xbgr.mr_n83039152)
print v(xbgr.mr_n83039968)
print v(xbgr.mr_n83040144)
print v(xbgr.mr_n83041712)
print v(xbgr.mr_n83042528)
print v(xbgr.mr_n83042704)
print v(xbgr.mr_n83043408)
print v(xbgr.mr_n83044272)
print v(xbgr.mr_n83045088)
print v(xbgr.mr_n83045264)
print v(xbgr.mr_n83046832)
print v(xbgr.mr_n83047648)
print v(xbgr.mr_n83047824)
print v(xbgr.mr_n83049392)
print v(xbgr.mr_n83050208)
print v(xbgr.mr_n83050384)
print v(xbgr.mr_n83051952)
print v(xbgr.mr_n83052768)
print v(xbgr.mr_n83052944)
print v(xbgr.mr_n83054512)
print v(xbgr.mr_n83055328)
print v(xbgr.mr_n83055504)
print v(xbgr.mr_n83057072)
print v(xbgr.mr_n83057440)
print v(xbgr.mr_n83057888)
print v(xbgr.mr_n83058064)
print v(xbgr.mr_n83059632)
print v(xbgr.mr_n83102160)
print v(xbgr.mr_n83103232)
print v(xbgr.mr_n83137040)
print v(xbgr.mr_n83142672)
print v(xbgr.mr_n83143264)
print v(xbgr.mr_n83144960)
print v(xbgr.mr_n83150416)
print v(xbgr.mr_n83150848)
print v(xbgr.mr_n83159184)
print v(xbgr.mr_n83160768)
print v(xbgr.mr_n83162960)
print v(xbgr.mr_n83163136)
print v(xbgr.mr_n83170448)
print v(xbgr.mr_n83172240)
print v(xbgr.mr_n83172688)
print v(xbgr.mr_n83172864)
print v(xbgr.mr_n83174528)
print v(xbgr.mr_n83174912)
print v(xbgr.mr_n83175440)
print v(xbgr.mr_n83176512)
print v(xbgr.mr_n83176624)
print v(xbgr.mr_n83176928)
print v(xbgr.mr_n83177280)
print v(xbgr.mr_n83178464)
print v(xbgr.mr_n83179888)
print v(xbgr.mr_n83279504)
print v(xbgr.mr_n83279616)
print v(xbgr.mr_n83280448)
print v(xbgr.mr_n83280560)
print v(xbgr.mr_n83281392)
print v(xbgr.mr_n83281504)
print v(xbgr.mr_n83281824)
print v(xbgr.mr_n83282336)
print v(xbgr.mr_n83282448)
print v(xbgr.mr_n83283280)
print v(xbgr.mr_n83283392)
print v(xbgr.mr_n83284224)
print v(xbgr.mr_n83284336)
print v(xbgr.mr_n83285168)
print v(xbgr.mr_n83285280)
print v(xbgr.mr_n83286112)
print v(xbgr.mr_n83286224)
print v(xbgr.mr_n83287056)
print v(xbgr.mr_n83287168)
print v(xbgr.mr_n83288656)
print v(xbgr.mr_n83288928)
print v(xbgr.mr_n83289120)
print v(xbgr.mr_n83289632)
print v(xbgr.mr_n83290480)
print v(xbgr.mr_n83290624)
print v(xbgr.mr_n83290784)
print v(xbgr.mr_n83294288)
print v(xbgr.mr_n83296592)
print v(xbgr.mr_n83297344)
print v(xbgr.mr_n83301664)
print v(xbgr.mr_n83301856)
print v(xbgr.mr_n83304400)
print v(xbgr.mr_n83306016)
print v(xbgr.mr_n83307696)
print v(xbgr.mr_n83309952)
print v(xbgr.mr_n83312208)
print v(xbgr.mr_n83314464)
print v(xbgr.mr_n83316720)
print v(xbgr.mr_n83318976)
print v(xbgr.mr_n83321232)
print v(xbgr.mr_n83323488)
print v(xbgr.mr_n83330656)
print v(xbgr.mr_n83331152)
print v(xbgr.mr_n83338720)
print v(xbgr.mr_n83341648)
print v(xbgr.mr_n83343408)
print v(xbgr.mr_n83343520)
print v(xbgr.mr_n83348640)
print v(xbgr.mr_n83349760)
print v(xbgr.mr_n83349872)
print v(xbgr.mr_n83350496)
print v(xbgr.mr_n83352032)
print v(xbgr.mr_n83352896)
print v(xbgr.mr_n83353856)
print v(xbgr.mr_n83353968)
print v(xbgr.mr_n83354912)
print v(xbgr.mr_n83356032)
print v(xbgr.mr_n83356144)
print v(xbgr.mr_n83356768)
print v(xbgr.mr_n83358304)
print v(xbgr.mr_n83359168)
print v(xbgr.mr_n83360128)
print v(xbgr.mr_n83360240)
print v(xbgr.mr_n83361184)
print v(xbgr.mr_n83362304)
print v(xbgr.mr_n83362416)
print v(xbgr.mr_n83363040)
print v(xbgr.mr_n83364576)
print v(xbgr.mr_n83365440)
print v(xbgr.mr_n83366400)
print v(xbgr.mr_n83366512)
print v(xbgr.mr_n83367456)
print v(xbgr.mr_n83368576)
print v(xbgr.mr_n83368688)
print v(xbgr.mr_n83369312)
print v(xbgr.mr_n83370848)
print v(xbgr.mr_n83371712)
print v(xbgr.mr_n83372672)
print v(xbgr.mr_n83372784)
print v(xbgr.mr_n83373728)
print v(xbgr.mr_n83374848)
print v(xbgr.mr_n83374960)
print v(xbgr.mr_n83375584)
print v(xbgr.mr_n83377120)
print v(xbgr.mr_n83377984)
print v(xbgr.mr_n83378944)
print v(xbgr.mr_n83379056)
print v(xbgr.mr_n83380000)
print v(xbgr.mr_n83380448)
print v(xbgr.mr_n83381120)
print v(xbgr.mr_n83381232)
print v(xbgr.mr_n83381856)
print v(xbgr.mr_n83384032)
print v(xbgr.mr_n83384208)
print v(xbgr.mr_n83386096)
print v(xbgr.mr_n83386784)
print v(xbgr.mr_n83387472)
print v(xbgr.mr_n83388224)
print v(xbgr.mr_n83389168)
print v(xbgr.mr_n83390112)
print v(xbgr.mr_n83391056)
print v(xbgr.mr_n83392000)
print v(xbgr.mr_n83392944)
print v(xbgr.mr_n83393888)
print v(xbgr.mr_n83394832)
print v(xbgr.mr_n83395776)
print v(xbgr.mr_n83396720)
print v(xbgr.mr_n83397664)
print v(xbgr.mr_n83398608)
print v(xbgr.mr_n83399552)
print v(xbgr.mr_n83400496)
print v(xbgr.mr_n83401440)
print v(xbgr.mr_n83402368)
print v(xbgr.mr_n83403312)
print v(xbgr.mr_n83404256)
print v(xbgr.mr_n83405168)
print v(xbgr.mr_n83406112)
print v(xbgr.mr_n83407056)
print v(xbgr.mr_n83407968)
print v(xbgr.mr_n83408912)
print v(xbgr.mr_n83409856)
print v(xbgr.mr_n83410768)
print v(xbgr.mr_n83411712)
print v(xbgr.mr_n83412656)
print v(xbgr.mr_n83413568)
print v(xbgr.mr_n83414512)
print v(xbgr.mr_n83415456)
print v(xbgr.mr_n83416368)
print v(xbgr.mr_n83417312)
print v(xbgr.mr_n83418256)
print v(xbgr.mr_n83424064)
print v(xbgr.mr_n83424304)
print v(xbgr.mr_n83425232)
print v(xbgr.mr_n83425344)
print v(xbgr.mr_n83426880)
print v(xbgr.mr_n83426992)
print v(xbgr.mr_n83428976)
print v(xbgr.mr_n83429088)
print v(xbgr.mr_n83430240)
print v(xbgr.mr_n83430352)
print v(xbgr.mr_n83431504)
print v(xbgr.mr_n83431616)
print v(xbgr.mr_n83432768)
print v(xbgr.mr_n83432880)
print v(xbgr.mr_n83434032)
print v(xbgr.mr_n83434144)
print v(xbgr.mr_n83435296)
print v(xbgr.mr_n83435408)
print v(xbgr.mr_n83436560)
print v(xbgr.mr_n83436672)
print v(xbgr.mr_n83437824)
print v(xbgr.mr_n83437936)
print v(xbgr.mr_n83439088)
print v(xbgr.mr_n83439200)
print v(xbgr.mr_n83445904)
print v(xbgr.mr_n83446432)
print v(xbgr.mr_n83447120)
print v(xbgr.mr_n83452304)
print v(xbgr.mr_n83453088)
print v(xbgr.mr_n83456176)
print v(xbgr.mr_n83456432)
print v(xbgr.mr_n83456688)
print v(xbgr.mr_n83456944)
print v(xbgr.mr_n83459536)
print v(xbgr.mr_n83459648)
print v(xbgr.mr_n83460768)
print v(xbgr.mr_n83467888)
print v(xbgr.mr_n83469136)
print v(xbgr.mr_n83469248)
print v(xbgr.mr_n83471248)
print v(xbgr.mr_n83472992)
print v(xbgr.mr_n83473264)
print v(xbgr.mr_n83473456)
print v(xbgr.mr_n83476752)
print v(xbgr.mr_n83476944)
print v(xbgr.mr_n83481024)
print v(xbgr.mr_n83481296)
print v(xbgr.mr_n83481488)
print v(xbgr.mr_n83484720)
print v(xbgr.mr_n83484912)
print v(xbgr.mr_n83487936)
print v(xbgr.mr_n83489056)
print v(xbgr.mr_n83489328)
print v(xbgr.mr_n83489520)
print v(xbgr.mr_n83491328)
print v(xbgr.mr_n83491440)
print v(xbgr.mr_n83492752)
print v(xbgr.mr_n83492944)
print v(xbgr.mr_n83497088)
print v(xbgr.mr_n83497360)
print v(xbgr.mr_n83497552)
print v(xbgr.mr_n83501280)
print v(xbgr.mr_n83502528)
print v(xbgr.mr_n83502640)
print v(xbgr.mr_n83505680)
print v(xbgr.mr_n83505872)
print v(xbgr.mr_n83506064)
print v(xbgr.mr_n83507312)
print v(xbgr.mr_n83507424)
print v(xbgr.mr_n83509040)
print v(xbgr.mr_n83511840)
print v(xbgr.mr_n83513088)
print v(xbgr.mr_n83513200)
print v(xbgr.mr_n83522720)
print v(xbgr.mr_n83525136)
print v(xbgr.mr_n83525968)
print v(xbgr.mr_n83526080)
print v(xbgr.mr_n83526912)
print v(xbgr.mr_n83527024)
print v(xbgr.mr_n83527856)
print v(xbgr.mr_n83527968)
print v(xbgr.mr_n83529056)
print v(xbgr.mr_n83529168)
print v(xbgr.mr_n83530320)
print v(xbgr.mr_n83530432)
print v(xbgr.mr_n83531584)
print v(xbgr.mr_n83531696)
print v(xbgr.mr_n83532848)
print v(xbgr.mr_n83532960)
print v(xbgr.mr_n83534112)
print v(xbgr.mr_n83534224)
print v(xbgr.mr_n83535376)
print v(xbgr.mr_n83535488)
print v(xbgr.mr_n83536640)
print v(xbgr.mr_n83536752)
print v(xbgr.mr_n83537904)
print v(xbgr.mr_n83538016)
print v(xbgr.mr_n83539168)
print v(xbgr.mr_n83539280)
print v(xbgr.mr_n83540432)
print v(xbgr.mr_n83540544)
print v(xbgr.mr_n83541696)
print v(xbgr.mr_n83541808)
print v(xbgr.mr_n83542960)
print v(xbgr.mr_n83543072)
print v(xbgr.mr_n83550480)
print v(xbgr.mr_n83551168)
print v(xbgr.mr_n83551856)
print v(xbgr.mr_n83552576)
print v(xbgr.mr_n83553936)
print v(xbgr.mr_n83555472)
print v(xbgr.mr_n83555584)
print v(xbgr.mr_n83556528)
print v(xbgr.mr_n83557680)
print v(xbgr.mr_n83557792)
print v(xbgr.mr_n83558256)
print v(xbgr.mr_n83560240)
print v(xbgr.mr_n83560352)
print v(xbgr.mr_n83562528)
print v(xbgr.mr_n83563872)
print v(xbgr.mr_n83564416)
print v(xbgr.mr_n83565760)
print v(xbgr.mr_n83566304)
print v(xbgr.mr_n83566960)
print v(xbgr.mr_n83567648)
print v(xbgr.mr_n83568192)
print v(xbgr.mr_n83569536)
print v(xbgr.mr_n83570080)
print v(xbgr.mr_n83571424)
print v(xbgr.mr_n83571968)
print v(xbgr.mr_n83573312)
print v(xbgr.mr_n83573856)
print v(xbgr.mr_n83575200)
print v(xbgr.mr_n83575744)
print v(xbgr.mr_n83577088)
print v(xbgr.mr_n83577632)
print v(xbgr.mr_n83578976)
print v(xbgr.mr_n83579840)
print v(xbgr.mr_n83580800)
print v(xbgr.mr_n83580912)
print v(xbgr.mr_n83581856)
print v(xbgr.mr_n83583008)
print v(xbgr.mr_n83583120)
print v(xbgr.mr_n83584064)
print v(xbgr.mr_n83585216)
print v(xbgr.mr_n83585328)
print v(xbgr.mr_n83587696)
print v(xbgr.mr_n83590048)
print v(xbgr.mr_n83592608)
print v(xbgr.mr_n83594736)
print v(xbgr.mr_n83596576)
print v(xbgr.mr_n83601632)
print v(xbgr.mr_n83602320)
print v(xbgr.mr_n83603008)
print v(xbgr.mr_n83603728)
print v(xbgr.mr_n83604672)
print v(xbgr.mr_n83604864)
print v(xbgr.mr_n83605056)
print v(xbgr.mr_n83605248)
print v(xbgr.mr_n83605440)
print v(xbgr.mr_n83605632)
print v(xbgr.mr_n83607776)
print v(xbgr.mr_n83607888)
print v(xbgr.mr_n83609904)
print v(xbgr.mr_n83611920)
print v(xbgr.mr_n83612032)
print v(xbgr.mr_n83617680)
print v(xbgr.mr_n83618624)
print v(xbgr.mr_n83629808)
print v(xbgr.mr_n83633648)
print v(xbgr.mr_n83634592)
print v(xbgr.mr_n83635536)
print v(xbgr.mr_n83636480)
print v(xbgr.mr_n83637424)
print v(xbgr.mr_n83638368)
print v(xbgr.mr_n83639312)
print v(xbgr.mr_n83640256)
print v(xbgr.mr_n83642320)
print v(xbgr.mr_n83644176)
print v(xbgr.mr_n83645952)
print v(xbgr.mr_n83646144)
print v(xbgr.mr_n83646832)
print v(xbgr.mr_n83647344)
print v(xbgr.mr_n83649104)
print v(xbgr.mr_n83649296)
print v(xbgr.mr_n83649984)
print v(xbgr.mr_n83650496)
print v(xbgr.mr_n83651600)
print v(xbgr.mr_n83652256)
print v(xbgr.mr_n83652448)
print v(xbgr.mr_n83653136)
print v(xbgr.mr_n83653648)
print v(xbgr.mr_n83655264)
print v(xbgr.mr_n83655456)
print v(xbgr.mr_n83656288)
print v(xbgr.mr_n83656800)
print v(xbgr.mr_n83658560)
print v(xbgr.mr_n83658752)
print v(xbgr.mr_n83659440)
print v(xbgr.mr_n83659952)
print v(xbgr.mr_n83661712)
print v(xbgr.mr_n83661904)
print v(xbgr.mr_n83662592)
print v(xbgr.mr_n83663104)
print v(xbgr.mr_n83664464)
print v(xbgr.mr_n83664864)
print v(xbgr.mr_n83665056)
print v(xbgr.mr_n83665744)
print v(xbgr.mr_n83666256)
print v(xbgr.mr_n83668016)
print v(xbgr.mr_n83668208)
print v(xbgr.mr_n83668896)
print v(xbgr.mr_n83669328)
print v(xbgr.mr_n83670160)
print v(xbgr.mr_n83670592)
print v(xbgr.mr_n83671424)
print v(xbgr.mr_n83672000)
print v(xbgr.mr_n83672688)
print v(xbgr.mr_n83673120)
print v(xbgr.mr_n83673952)
print v(xbgr.mr_n83674528)
print v(xbgr.mr_n83675216)
print v(xbgr.mr_n83675792)
print v(xbgr.mr_n83676480)
print v(xbgr.mr_n83676912)
print v(xbgr.mr_n83677744)
print v(xbgr.mr_n83678640)
print v(xbgr.mr_n83680176)
print v(xbgr.mr_n83680864)
print v(xbgr.mr_n83681552)
print v(xbgr.mr_n83684000)
print v(xbgr.mr_n83684528)
print v(xbgr.mr_n83685088)
print v(xbgr.mr_n83685280)
print v(xbgr.mr_n83685856)
print v(xbgr.mr_n83685968)
print v(xbgr.mr_n83687872)
print v(xbgr.mr_n83688560)
print v(xbgr.mr_n83688832)
print v(xbgr.mr_n83688944)
print v(xbgr.mr_n83689584)
print v(xbgr.mr_n83689696)
print v(xbgr.mr_n83689808)
print v(xbgr.mr_n83690000)
print v(xbgr.mr_n83690192)
print v(xbgr.mr_n83690384)
print v(xbgr.mr_n83692640)
print v(xbgr.mr_n83692912)
print v(xbgr.mr_n83693104)
print v(xbgr.mr_n83695216)
print v(xbgr.mr_n83696896)
print v(xbgr.mr_n83697088)
print v(xbgr.mr_n83697280)
print v(xbgr.mr_n83697472)
print v(xbgr.mr_n83699664)
print v(xbgr.mr_n83699936)
print v(xbgr.mr_n83700128)
print v(xbgr.mr_n83700640)
print v(xbgr.mr_n83702576)
print v(xbgr.mr_n83703088)
print v(xbgr.mr_n83705824)
print v(xbgr.mr_n83706096)
print v(xbgr.mr_n83706288)
print v(xbgr.mr_n83706800)
print v(xbgr.mr_n83708416)
print v(xbgr.mr_n83708608)
print v(xbgr.mr_n83710800)
print v(xbgr.mr_n83711072)
print v(xbgr.mr_n83711264)
print v(xbgr.mr_n83711776)
print v(xbgr.mr_n83712592)
print v(xbgr.mr_n83713712)
print v(xbgr.mr_n83714224)
print v(xbgr.mr_n83716960)
print v(xbgr.mr_n83717232)
print v(xbgr.mr_n83717424)
print v(xbgr.mr_n83717936)
print v(xbgr.mr_n83719552)
print v(xbgr.mr_n83719744)
print v(xbgr.mr_n83721936)
print v(xbgr.mr_n83722208)
print v(xbgr.mr_n83722400)
print v(xbgr.mr_n83722912)
print v(xbgr.mr_n83724848)
print v(xbgr.mr_n83725360)
print v(xbgr.mr_n83728096)
print v(xbgr.mr_n83728368)
print v(xbgr.mr_n83728560)
print v(xbgr.mr_n83729072)
print v(xbgr.mr_n83730688)
print v(xbgr.mr_n83730880)
print v(xbgr.mr_n83733072)
print v(xbgr.mr_n83733344)
print v(xbgr.mr_n83733536)
print v(xbgr.mr_n83734048)
print v(xbgr.mr_n83735984)
print v(xbgr.mr_n83736496)
print v(xbgr.mr_n83739232)
print v(xbgr.mr_n83739504)
print v(xbgr.mr_n83739696)
print v(xbgr.mr_n83740208)
print v(xbgr.mr_n83743920)
print v(xbgr.mr_n83745072)
print v(xbgr.mr_n83745184)
print v(xbgr.mr_n83746336)
print v(xbgr.mr_n83746448)
print v(xbgr.mr_n83747600)
print v(xbgr.mr_n83747712)
print v(xbgr.mr_n83748864)
print v(xbgr.mr_n83748976)
print v(xbgr.mr_n83750128)
print v(xbgr.mr_n83750240)
print v(xbgr.mr_n83751392)
print v(xbgr.mr_n83751504)
print v(xbgr.mr_n83752656)
print v(xbgr.mr_n83752768)
print v(xbgr.mr_n83753920)
print v(xbgr.mr_n83754032)
print v(xbgr.mr_n83755184)
print v(xbgr.mr_n83755296)
print v(xbgr.mr_n83756448)
print v(xbgr.mr_n83756560)
print v(xbgr.mr_n83757712)
print v(xbgr.mr_n83757824)
print v(xbgr.mr_n83758912)
print v(xbgr.mr_n83759024)
print v(xbgr.mr_n83760240)
print v(xbgr.mr_n83760352)
print v(xbgr.mr_n83761504)
print v(xbgr.mr_n83761616)
print v(xbgr.mr_n83762768)
print v(xbgr.mr_n83762880)
print v(xbgr.mr_n83767296)
print v(xbgr.mr_n83768256)
print v(xbgr.mr_n83768944)
print v(xbgr.mr_n83770640)
print v(xbgr.mr_n83770976)
print v(xbgr.mr_n83778128)
print v(xbgr.mr_n83787296)
print v(xbgr.mr_n83792336)
print v(xbgr.mr_n83796560)
print v(xbgr.mr_n83797248)
print v(xbgr.mr_n83798000)
print v(xbgr.mr_n83798944)
print v(xbgr.mr_n83805728)
print v(xbgr.mr_n83805920)
print v(xbgr.mr_n83806608)
print v(xbgr.mr_n83806720)
print v(xbgr.mr_n83806832)
print v(xbgr.mr_n83806944)
print v(xbgr.mr_n83807056)
print v(xbgr.mr_n83808800)
print v(xbgr.mr_n83808992)
print v(xbgr.mr_n83809184)
print v(xbgr.mr_n83809776)
print v(xbgr.mr_n83811952)
print v(xbgr.mr_n83812144)
print v(xbgr.mr_n83812336)
print v(xbgr.mr_n83812528)
print v(xbgr.mr_n83813184)
print v(xbgr.mr_n83814752)
print v(xbgr.mr_n83816368)
print v(xbgr.mr_n83816640)
print v(xbgr.mr_n83818112)
print v(xbgr.mr_n83818384)
print v(xbgr.mr_n83818576)
print v(xbgr.mr_n83819088)
print v(xbgr.mr_n83820384)
print v(xbgr.mr_n83820896)
print v(xbgr.mr_n83824272)
print v(xbgr.mr_n83824736)
print v(xbgr.mr_n83825248)
print v(xbgr.mr_n83827392)
print v(xbgr.mr_n83827504)
print v(xbgr.mr_n83828688)
print v(xbgr.mr_n83829680)
print v(xbgr.mr_n83830992)
print v(xbgr.mr_n83831104)
print v(xbgr.mr_n83831216)
print v(xbgr.mr_n83831408)
print v(xbgr.mr_n83831600)
print v(xbgr.mr_n83833408)
print v(xbgr.mr_n83833600)
print v(xbgr.mr_n83834112)
print v(xbgr.mr_n83837344)
print v(xbgr.mr_n83837456)
print v(xbgr.mr_n83839200)
print v(xbgr.mr_n83839472)
print v(xbgr.mr_n83839664)
print v(xbgr.mr_n83840176)
print v(xbgr.mr_n83841408)
print v(xbgr.mr_n83841920)
print v(xbgr.mr_n83845360)
print v(xbgr.mr_n83845632)
print v(xbgr.mr_n83845824)
print v(xbgr.mr_n83846336)
print v(xbgr.mr_n83848480)
print v(xbgr.mr_n83848592)
print v(xbgr.mr_n83850336)
print v(xbgr.mr_n83850608)
print v(xbgr.mr_n83850800)
print v(xbgr.mr_n83851312)
print v(xbgr.mr_n83852544)
print v(xbgr.mr_n83853056)
print v(xbgr.mr_n83856496)
print v(xbgr.mr_n83856768)
print v(xbgr.mr_n83856960)
print v(xbgr.mr_n83857472)
print v(xbgr.mr_n83859616)
print v(xbgr.mr_n83859728)
print v(xbgr.mr_n83861472)
print v(xbgr.mr_n83861744)
print v(xbgr.mr_n83861936)
print v(xbgr.mr_n83862448)
print v(xbgr.mr_n83863680)
print v(xbgr.mr_n83864192)
print v(xbgr.mr_n83867632)
print v(xbgr.mr_n83867904)
print v(xbgr.mr_n83868096)
print v(xbgr.mr_n83868608)
print v(xbgr.mr_n83870672)
print v(xbgr.mr_n83870784)
print v(xbgr.mr_n83871296)
print v(xbgr.mr_n83871408)
print v(xbgr.mr_n83871920)
print v(xbgr.mr_n83872032)
print v(xbgr.mr_n83872800)
print v(xbgr.mr_n83872912)
print v(xbgr.mr_n83873744)
print v(xbgr.mr_n83873856)
print v(xbgr.mr_n83874688)
print v(xbgr.mr_n83874800)
print v(xbgr.mr_n83875632)
print v(xbgr.mr_n83875744)
print v(xbgr.mr_n83876576)
print v(xbgr.mr_n83876688)
print v(xbgr.mr_n83877584)
print v(xbgr.mr_n83877696)
print v(xbgr.mr_n83878848)
print v(xbgr.mr_n83878960)
print v(xbgr.mr_n83880112)
print v(xbgr.mr_n83880224)
print v(xbgr.mr_n83881376)
print v(xbgr.mr_n83881488)
print v(xbgr.mr_n83882640)
print v(xbgr.mr_n83882752)
print v(xbgr.mr_n83883840)
print v(xbgr.mr_n83883952)
print v(xbgr.mr_n83885168)
print v(xbgr.mr_n83885280)
print v(xbgr.mr_n83886672)
print v(xbgr.mr_n83897056)
print v(xbgr.mr_n83897168)
print v(xbgr.mr_n83898320)
print v(xbgr.mr_n83898432)
print v(xbgr.mr_n83899584)
print v(xbgr.mr_n83899696)
print v(xbgr.mr_n83900848)
print v(xbgr.mr_n83900960)
print v(xbgr.mr_n83902112)
print v(xbgr.mr_n83902224)
print v(xbgr.mr_n83903376)
print v(xbgr.mr_n83903488)
print v(xbgr.mr_n83904640)
print v(xbgr.mr_n83904752)
print v(xbgr.mr_n83905904)
print v(xbgr.mr_n83906016)
print v(xbgr.mr_n83907168)
print v(xbgr.mr_n83907280)
print v(xbgr.mr_n83908432)
print v(xbgr.mr_n83908544)
print v(xbgr.mr_n83909632)
print v(xbgr.mr_n83909744)
print v(xbgr.mr_n83910960)
print v(xbgr.mr_n83911072)
print v(xbgr.mr_n83912224)
print v(xbgr.mr_n83912336)
print v(xbgr.mr_n83913488)
print v(xbgr.mr_n83913600)
print v(xbgr.mr_n83914752)
print v(xbgr.mr_n83914864)
print v(xbgr.mr_n83916016)
print v(xbgr.mr_n83916128)
print v(xbgr.mr_n83917280)
print v(xbgr.mr_n83917392)
print v(xbgr.mr_n83932768)
print v(xbgr.mr_n83938464)
print v(xbgr.mr_n83938640)
print v(xbgr.mr_n83938816)
print v(xbgr.mr_n83939168)
print v(xbgr.mr_n83939280)
print v(xbgr.mr_n83939632)
print v(xbgr.mr_n83940336)
print v(xbgr.mr_n83940576)
print v(xbgr.mr_n83940688)
print v(xbgr.mr_n83941280)
print v(xbgr.mr_n83941632)
print v(xbgr.mr_n83941808)
print v(xbgr.mr_n83942976)
print v(xbgr.mr_n83943504)
print v(xbgr.mr_n83945264)
print v(xbgr.mr_n83945616)
print v(xbgr.mr_n83945792)
print v(xbgr.mr_n83945968)
print v(xbgr.mr_n83946560)
print v(xbgr.mr_n83949552)
print v(xbgr.mr_n83950368)
print v(xbgr.mr_n83950544)
print v(xbgr.mr_n83951488)
print v(xbgr.mr_n83951664)
print v(xbgr.mr_n83952016)
print v(xbgr.mr_n83952304)
print v(xbgr.mr_n83952480)
print v(xbgr.mr_n83954480)
print v(xbgr.mr_n83955008)
print v(xbgr.mr_n83957472)
print v(xbgr.mr_n83957760)
print v(xbgr.mr_n83957936)
print v(xbgr.mr_n83959408)
print v(xbgr.mr_n83959936)
print v(xbgr.mr_n83960944)
print v(xbgr.mr_n83964224)
print v(xbgr.mr_n83964336)
print v(xbgr.mr_n83964656)
print v(xbgr.mr_n83964944)
print v(xbgr.mr_n83965744)
print v(xbgr.mr_n83969088)
print v(xbgr.mr_n83969552)
print v(xbgr.mr_n83970560)
print v(xbgr.mr_n83971376)
print v(xbgr.mr_n83972288)
print v(xbgr.mr_n83972480)
print v(xbgr.mr_n83973168)
print v(xbgr.mr_n83973280)
print v(xbgr.mr_n83973392)
print v(xbgr.mr_n83973504)
print v(xbgr.mr_n83973696)
print v(xbgr.mr_n83973888)
print v(xbgr.mr_n83975696)
print v(xbgr.mr_n83975888)
print v(xbgr.mr_n83976400)
print v(xbgr.mr_n83978496)
print v(xbgr.mr_n83980240)
print v(xbgr.mr_n83980432)
print v(xbgr.mr_n83980624)
print v(xbgr.mr_n83981216)
print v(xbgr.mr_n83983152)
print v(xbgr.mr_n83984896)
print v(xbgr.mr_n83985168)
print v(xbgr.mr_n83985360)
print v(xbgr.mr_n83985872)
print v(xbgr.mr_n83987808)
print v(xbgr.mr_n83989552)
print v(xbgr.mr_n83989824)
print v(xbgr.mr_n83990016)
print v(xbgr.mr_n83990528)
print v(xbgr.mr_n83992464)
print v(xbgr.mr_n83994208)
print v(xbgr.mr_n83994400)
print v(xbgr.mr_n83994592)
print v(xbgr.mr_n83995184)
print v(xbgr.mr_n83997120)
print v(xbgr.mr_n83998864)
print v(xbgr.mr_n83999056)
print v(xbgr.mr_n83999248)
print v(xbgr.mr_n83999840)
print v(xbgr.mr_n84001776)
print v(xbgr.mr_n84003520)
print v(xbgr.mr_n84003792)
print v(xbgr.mr_n84003984)
print v(xbgr.mr_n84004496)
print v(xbgr.mr_n84006672)
print v(xbgr.mr_n84006864)
print v(xbgr.mr_n84007056)
print v(xbgr.mr_n84007248)
print v(xbgr.mr_n84009472)
print v(xbgr.mr_n84011088)
print v(xbgr.mr_n84012832)
print v(xbgr.mr_n84013104)
print v(xbgr.mr_n84013296)
print v(xbgr.mr_n84013808)
print v(xbgr.mr_n84015744)
print v(xbgr.mr_n84017488)
print v(xbgr.mr_n84017760)
print v(xbgr.mr_n84017952)
print v(xbgr.mr_n84018464)
print v(xbgr.mr_n84020400)
print v(xbgr.mr_n84022144)
print v(xbgr.mr_n84022416)
print v(xbgr.mr_n84022608)
print v(xbgr.mr_n84023120)
print v(xbgr.mr_n84025136)
print v(xbgr.mr_n84025328)
print v(xbgr.mr_n84027136)
print v(xbgr.mr_n84027328)
print v(xbgr.mr_n84027840)
print v(xbgr.mr_n84029712)
print v(xbgr.mr_n84031456)
print v(xbgr.mr_n84031728)
print v(xbgr.mr_n84031920)
print v(xbgr.mr_n84032432)
print v(xbgr.mr_n84034368)
print v(xbgr.mr_n84036112)
print v(xbgr.mr_n84036384)
print v(xbgr.mr_n84036576)
print v(xbgr.mr_n84037088)
print v(xbgr.mr_n84039024)
print v(xbgr.mr_n84040768)
print v(xbgr.mr_n84041040)
print v(xbgr.mr_n84041232)
print v(xbgr.mr_n84041744)
print v(xbgr.mr_n84043680)
print v(xbgr.mr_n84045424)
print v(xbgr.mr_n84045696)
print v(xbgr.mr_n84045888)
print v(xbgr.mr_n84046400)
print v(xbgr.mr_n84048576)
print v(xbgr.mr_n84048768)
print v(xbgr.mr_n84048960)
print v(xbgr.mr_n84049152)
print v(xbgr.mr_n84051376)
print v(xbgr.mr_n84053888)
print v(xbgr.mr_n84054672)
print v(xbgr.mr_n84056320)
print v(xbgr.mr_n84056656)
print v(xbgr.mr_n84058864)
print v(xbgr.mr_n84060464)
print v(xbgr.mr_n84061328)
print v(xbgr.mr_n84062752)
print v(xbgr.mr_n84063328)
print v(xbgr.mr_n84063440)
print v(xbgr.mr_n84064384)
print v(xbgr.mr_n84065280)
print v(xbgr.mr_n84065392)
print v(xbgr.mr_n84066336)
print v(xbgr.mr_n84067488)
print v(xbgr.mr_n84067600)
print v(xbgr.mr_n84068544)
print v(xbgr.mr_n84069696)
print v(xbgr.mr_n84069808)
print v(xbgr.mr_n84070752)
print v(xbgr.mr_n84071904)
print v(xbgr.mr_n84072016)
print v(xbgr.mr_n84072960)
print v(xbgr.mr_n84074112)
print v(xbgr.mr_n84074224)
print v(xbgr.mr_n84075168)
print v(xbgr.mr_n84076256)
print v(xbgr.mr_n84076368)
print v(xbgr.mr_n84077312)
print v(xbgr.mr_n84078528)
print v(xbgr.mr_n84078640)
print v(xbgr.mr_n84079584)
print v(xbgr.mr_n84080736)
print v(xbgr.mr_n84080848)
print v(xbgr.mr_n84081792)
print v(xbgr.mr_n84082944)
print v(xbgr.mr_n84083056)
print v(xbgr.mr_n84084000)
print v(xbgr.mr_n84085152)
print v(xbgr.mr_n84085264)
print v(xbgr.mr_n84086208)
print v(xbgr.mr_n84087360)
print v(xbgr.mr_n84087472)
print v(xbgr.mr_n84088416)
print v(xbgr.mr_n84089504)
print v(xbgr.mr_n84089616)
print v(xbgr.mr_n84090560)
print v(xbgr.mr_n84091776)
print v(xbgr.mr_n84091888)
print v(xbgr.mr_n84092832)
print v(xbgr.mr_n84093984)
print v(xbgr.mr_n84094096)
print v(xbgr.mr_n84095248)
print v(xbgr.mr_n84095360)
print v(xbgr.mr_n84095536)
print v(xbgr.mr_n84096448)
print v(xbgr.mr_n84096560)
print v(xbgr.mr_n84100832)
print v(xbgr.mr_n84100944)
print v(xbgr.mr_n84102480)
print v(xbgr.mr_n84102592)
print v(xbgr.mr_n84104928)
print v(xbgr.mr_n84105040)
print v(xbgr.mr_n84106192)
print v(xbgr.mr_n84106304)
print v(xbgr.mr_n84107456)
print v(xbgr.mr_n84107568)
print v(xbgr.mr_n84108720)
print v(xbgr.mr_n84108832)
print v(xbgr.mr_n84109984)
print v(xbgr.mr_n84110096)
print v(xbgr.mr_n84111248)
print v(xbgr.mr_n84111360)
print v(xbgr.mr_n84112512)
print v(xbgr.mr_n84112624)
print v(xbgr.mr_n84117216)
print v(xbgr.mr_n84120288)
print v(xbgr.mr_n84120672)
print v(xbgr.mr_n84124896)
print v(xbgr.mr_n84142176)
print v(xbgr.mr_n84142368)
print v(xbgr.mr_n84142560)
print v(xbgr.mr_n84142752)
print v(xbgr.mr_n84145072)
print v(xbgr.mr_n84145344)
print v(xbgr.mr_n84145536)
print v(xbgr.mr_n84146048)
print v(xbgr.mr_n84149360)
print v(xbgr.mr_n84150464)
print v(xbgr.mr_n84151728)
print v(xbgr.mr_n84152000)
print v(xbgr.mr_n84152192)
print v(xbgr.mr_n84152704)
print v(xbgr.mr_n84154848)
print v(xbgr.mr_n84154960)
print v(xbgr.mr_n84156704)
print v(xbgr.mr_n84156976)
print v(xbgr.mr_n84157168)
print v(xbgr.mr_n84157680)
print v(xbgr.mr_n84158912)
print v(xbgr.mr_n84159424)
print v(xbgr.mr_n84162864)
print v(xbgr.mr_n84163136)
print v(xbgr.mr_n84163328)
print v(xbgr.mr_n84163840)
print v(xbgr.mr_n84165984)
print v(xbgr.mr_n84166096)
print v(xbgr.mr_n84167840)
print v(xbgr.mr_n84168112)
print v(xbgr.mr_n84168304)
print v(xbgr.mr_n84168816)
print v(xbgr.mr_n84170112)
print v(xbgr.mr_n84170624)
print v(xbgr.mr_n84174000)
print v(xbgr.mr_n84174272)
print v(xbgr.mr_n84174464)
print v(xbgr.mr_n84174976)
print v(xbgr.mr_n84177120)
print v(xbgr.mr_n84177232)
print v(xbgr.mr_n84178976)
print v(xbgr.mr_n84179248)
print v(xbgr.mr_n84179440)
print v(xbgr.mr_n84179952)
print v(xbgr.mr_n84181184)
print v(xbgr.mr_n84181696)
print v(xbgr.mr_n84185136)
print v(xbgr.mr_n84185408)
print v(xbgr.mr_n84185600)
print v(xbgr.mr_n84186112)
print v(xbgr.mr_n84188256)
print v(xbgr.mr_n84188368)
print v(xbgr.mr_n84190112)
print v(xbgr.mr_n84190384)
print v(xbgr.mr_n84190576)
print v(xbgr.mr_n84191088)
print v(xbgr.mr_n84192320)
print v(xbgr.mr_n84192832)
print v(xbgr.mr_n84196272)
print v(xbgr.mr_n84196544)
print v(xbgr.mr_n84196736)
print v(xbgr.mr_n84197248)
print v(xbgr.mr_n84199392)
print v(xbgr.mr_n84199504)
print v(xbgr.mr_n84201248)
print v(xbgr.mr_n84201520)
print v(xbgr.mr_n84201712)
print v(xbgr.mr_n84202224)
print v(xbgr.mr_n84202336)
print v(xbgr.mr_n84203456)
print v(xbgr.mr_n84203968)
print v(xbgr.mr_n84205936)
print v(xbgr.mr_n84207744)
print v(xbgr.mr_n84207936)
print v(xbgr.mr_n84208448)
print v(xbgr.mr_n84213584)
print v(xbgr.mr_n84213696)
print v(xbgr.mr_n84214528)
print v(xbgr.mr_n84214640)
print v(xbgr.mr_n84215472)
print v(xbgr.mr_n84215584)
print v(xbgr.mr_n84216672)
print v(xbgr.mr_n84216784)
print v(xbgr.mr_n84217936)
print v(xbgr.mr_n84218048)
print v(xbgr.mr_n84219200)
print v(xbgr.mr_n84219312)
print v(xbgr.mr_n84220464)
print v(xbgr.mr_n84220576)
print v(xbgr.mr_n84221728)
print v(xbgr.mr_n84221840)
print v(xbgr.mr_n84222992)
print v(xbgr.mr_n84223104)
print v(xbgr.mr_n84224256)
print v(xbgr.mr_n84224368)
print v(xbgr.mr_n84225520)
print v(xbgr.mr_n84225632)
print v(xbgr.mr_n84226784)
print v(xbgr.mr_n84226896)
print v(xbgr.mr_n84228048)
print v(xbgr.mr_n84228160)
print v(xbgr.mr_n84229312)
print v(xbgr.mr_n84229424)
print v(xbgr.mr_n84230576)
print v(xbgr.mr_n84230688)
print v(xbgr.mr_n84241328)
print v(xbgr.mr_n84242016)
print v(xbgr.mr_n84242704)
print v(xbgr.mr_n84243392)
print v(xbgr.mr_n84244080)
print v(xbgr.mr_n84244768)
print v(xbgr.mr_n84246608)
print v(xbgr.mr_n84247616)
print v(xbgr.mr_n84248560)
print v(xbgr.mr_n84249504)
print v(xbgr.mr_n84250448)
print v(xbgr.mr_n84251328)
print v(xbgr.mr_n84252864)
print v(xbgr.mr_n84253200)
print v(xbgr.mr_n84255408)
print v(xbgr.mr_n84256976)
print v(xbgr.mr_n84258544)
print v(xbgr.mr_n84260048)
print v(xbgr.mr_n84261680)
print v(xbgr.mr_n84263248)
print v(xbgr.mr_n84264816)
print v(xbgr.mr_n84266384)
print v(xbgr.mr_n84270864)
print v(xbgr.mr_n84271552)
print v(xbgr.mr_n84272240)
print v(xbgr.mr_n84272992)
print v(xbgr.mr_n84274608)
print v(xbgr.mr_n84275824)
print v(xbgr.mr_n84275936)
print v(xbgr.mr_n84276880)
print v(xbgr.mr_n84278096)
print v(xbgr.mr_n84278208)
print v(xbgr.mr_n84279152)
print v(xbgr.mr_n84280304)
print v(xbgr.mr_n84280416)
print v(xbgr.mr_n84281360)
print v(xbgr.mr_n84282512)
print v(xbgr.mr_n84282624)
print v(xbgr.mr_n84283568)
print v(xbgr.mr_n84284720)
print v(xbgr.mr_n84284832)
print v(xbgr.mr_n84285776)
print v(xbgr.mr_n84286928)
print v(xbgr.mr_n84287040)
print v(xbgr.mr_n84287984)
print v(xbgr.mr_n84289136)
print v(xbgr.mr_n84289248)
print v(xbgr.mr_n84290192)
print v(xbgr.mr_n84291344)
print v(xbgr.mr_n84291456)
print v(xbgr.mr_n84292400)
print v(xbgr.mr_n84293552)
print v(xbgr.mr_n84293664)
print v(xbgr.mr_n84294608)
print v(xbgr.mr_n84295760)
print v(xbgr.mr_n84295872)
print v(xbgr.mr_n84296816)
print v(xbgr.mr_n84297968)
print v(xbgr.mr_n84298080)
print v(xbgr.mr_n84299024)
print v(xbgr.mr_n84300176)
print v(xbgr.mr_n84300288)
print v(xbgr.mr_n84301232)
print v(xbgr.mr_n84302384)
print v(xbgr.mr_n84302496)
print v(xbgr.mr_n84303440)
print v(xbgr.mr_n84304592)
print v(xbgr.mr_n84304704)
print v(xbgr.mr_n84305648)
print v(xbgr.mr_n84305824)
print v(xbgr.mr_n84306800)
print v(xbgr.mr_n84306912)
print v(xbgr.mr_n84307856)
print v(xbgr.mr_n84308944)
print v(xbgr.mr_n84309056)
print v(xbgr.mr_n84310000)
print v(xbgr.mr_n84311216)
print v(xbgr.mr_n84311328)
print v(xbgr.mr_n84312208)
print v(xbgr.mr_n84312896)
print v(xbgr.mr_n84313584)
print v(xbgr.mr_n84314304)
print v(xbgr.mr_n84315248)
print v(xbgr.mr_n84316192)
print v(xbgr.mr_n84317136)
print v(xbgr.mr_n84318080)
print v(xbgr.mr_n84319024)
print v(xbgr.mr_n84319968)
print v(xbgr.mr_n84320912)
print v(xbgr.mr_n84322752)
print v(xbgr.mr_n84328464)
print v(xbgr.mr_n84334400)
print v(xbgr.mr_n84340928)
print v(xbgr.mr_n84341440)
print v(xbgr.mr_n84344032)
print v(xbgr.mr_n84345104)
print v(xbgr.mr_n84345296)
print v(xbgr.mr_n84345488)
print v(xbgr.mr_n84345680)
print v(xbgr.mr_n84346016)
print v(xbgr.mr_n84348000)
print v(xbgr.mr_n84348272)
print v(xbgr.mr_n84348464)
print v(xbgr.mr_n84348976)
print v(xbgr.mr_n84353696)
print v(xbgr.mr_n84353968)
print v(xbgr.mr_n84354160)
print v(xbgr.mr_n84354672)
print v(xbgr.mr_n84356816)
print v(xbgr.mr_n84356928)
print v(xbgr.mr_n84358672)
print v(xbgr.mr_n84358944)
print v(xbgr.mr_n84359136)
print v(xbgr.mr_n84359648)
print v(xbgr.mr_n84360880)
print v(xbgr.mr_n84361392)
print v(xbgr.mr_n84364832)
print v(xbgr.mr_n84365296)
print v(xbgr.mr_n84365808)
print v(xbgr.mr_n84368064)
print v(xbgr.mr_n84369664)
print v(xbgr.mr_n84370864)
print v(xbgr.mr_n84371056)
print v(xbgr.mr_n84371248)
print v(xbgr.mr_n84371440)
print v(xbgr.mr_n84373184)
print v(xbgr.mr_n84373456)
print v(xbgr.mr_n84373648)
print v(xbgr.mr_n84374224)
print v(xbgr.mr_n84378320)
print v(xbgr.mr_n84378432)
print v(xbgr.mr_n84380176)
print v(xbgr.mr_n84380448)
print v(xbgr.mr_n84380640)
print v(xbgr.mr_n84381152)
print v(xbgr.mr_n84382384)
print v(xbgr.mr_n84382896)
print v(xbgr.mr_n84386336)
print v(xbgr.mr_n84386528)
print v(xbgr.mr_n84386720)
print v(xbgr.mr_n84387312)
print v(xbgr.mr_n84389456)
print v(xbgr.mr_n84389568)
print v(xbgr.mr_n84389760)
print v(xbgr.mr_n84391312)
print v(xbgr.mr_n84391584)
print v(xbgr.mr_n84391776)
print v(xbgr.mr_n84392288)
print v(xbgr.mr_n84393584)
print v(xbgr.mr_n84394096)
print v(xbgr.mr_n84397472)
print v(xbgr.mr_n84397744)
print v(xbgr.mr_n84397936)
print v(xbgr.mr_n84398448)
print v(xbgr.mr_n84400592)
print v(xbgr.mr_n84400704)
print v(xbgr.mr_n84402448)
print v(xbgr.mr_n84402720)
print v(xbgr.mr_n84402912)
print v(xbgr.mr_n84403424)
print v(xbgr.mr_n84404656)
print v(xbgr.mr_n84405168)
print v(xbgr.mr_n84407296)
print v(xbgr.mr_n84407488)
print v(xbgr.mr_n84407680)
print v(xbgr.mr_n84409904)
print v(xbgr.mr_n84414528)
print v(xbgr.mr_n84414640)
print v(xbgr.mr_n84415472)
print v(xbgr.mr_n84415584)
print v(xbgr.mr_n84416416)
print v(xbgr.mr_n84416528)
print v(xbgr.mr_n84417616)
print v(xbgr.mr_n84417728)
print v(xbgr.mr_n84418880)
print v(xbgr.mr_n84418992)
print v(xbgr.mr_n84420144)
print v(xbgr.mr_n84420256)
print v(xbgr.mr_n84421408)
print v(xbgr.mr_n84421520)
print v(xbgr.mr_n84422672)
print v(xbgr.mr_n84422784)
print v(xbgr.mr_n84423936)
print v(xbgr.mr_n84424048)
print v(xbgr.mr_n84425200)
print v(xbgr.mr_n84425312)
print v(xbgr.mr_n84426464)
print v(xbgr.mr_n84426576)
print v(xbgr.mr_n84427728)
print v(xbgr.mr_n84427840)
print v(xbgr.mr_n84428992)
print v(xbgr.mr_n84429104)
print v(xbgr.mr_n84430256)
print v(xbgr.mr_n84430368)
print v(xbgr.mr_n84431520)
print v(xbgr.mr_n84431632)
print v(xbgr.mr_n84433168)
print v(xbgr.mr_n84433280)
print v(xbgr.mr_n84434432)
print v(xbgr.mr_n84434544)
print v(xbgr.mr_n84435696)
print v(xbgr.mr_n84435808)
print v(xbgr.mr_n84436960)
print v(xbgr.mr_n84437072)
print v(xbgr.mr_n84438224)
print v(xbgr.mr_n84438336)
print v(xbgr.mr_n84439488)
print v(xbgr.mr_n84439600)
print v(xbgr.mr_n84440752)
print v(xbgr.mr_n84440864)
print v(xbgr.mr_n84442016)
print v(xbgr.mr_n84442128)
print v(xbgr.mr_n84443280)
print v(xbgr.mr_n84443392)
print v(xbgr.mr_n84444544)
print v(xbgr.mr_n84444656)
print v(xbgr.mr_n84445808)
print v(xbgr.mr_n84445920)
print v(xbgr.mr_n84447072)
print v(xbgr.mr_n84447184)
print v(xbgr.mr_n84448336)
print v(xbgr.mr_n84448448)
print v(xbgr.mr_n84449600)
print v(xbgr.mr_n84449712)
print v(xbgr.mr_n84450864)
print v(xbgr.mr_n84450976)
print v(xbgr.mr_n84452128)
print v(xbgr.mr_n84452240)
print v(xbgr.mr_n84453392)
print v(xbgr.mr_n84453504)
print v(xbgr.mr_n84455424)
print v(xbgr.mr_n84469248)
print v(xbgr.mr_n84472432)
print v(xbgr.mr_n84473648)
print v(xbgr.mr_n84473760)
print v(xbgr.mr_n84477840)
print v(xbgr.mr_n84489904)
print v(xbgr.mr_n84490592)
print v(xbgr.mr_n84491280)
print v(xbgr.mr_n84492000)
print v(xbgr.mr_n84492944)
print v(xbgr.mr_n84493888)
print v(xbgr.mr_n84494832)
print v(xbgr.mr_n84495776)
print v(xbgr.mr_n84496720)
print v(xbgr.mr_n84497664)
print v(xbgr.mr_n84498608)
print v(xbgr.mr_n84499552)
print v(xbgr.mr_n84500496)
print v(xbgr.mr_n84501440)
print v(xbgr.mr_n84502384)
print v(xbgr.mr_n84503328)
print v(xbgr.mr_n84504272)
print v(xbgr.mr_n84505440)
print v(xbgr.mr_n84506224)
print v(xbgr.mr_n84507520)
print v(xbgr.mr_n84508800)
print v(xbgr.mr_n84509408)
print v(xbgr.mr_n84511200)
print v(xbgr.mr_n84515216)
print v(xbgr.mr_n84520112)
print v(xbgr.mr_n84520304)
print v(xbgr.mr_n84520992)
print v(xbgr.mr_n84521104)
print v(xbgr.mr_n84521216)
print v(xbgr.mr_n84521328)
print v(xbgr.mr_n84521440)
print v(xbgr.mr_n84523184)
print v(xbgr.mr_n84523456)
print v(xbgr.mr_n84523648)
print v(xbgr.mr_n84524160)
print v(xbgr.mr_n84524624)
print v(xbgr.mr_n84525072)
print v(xbgr.mr_n84526752)
print v(xbgr.mr_n84527024)
print v(xbgr.mr_n84527216)
print v(xbgr.mr_n84527728)
print v(xbgr.mr_n84531216)
print v(xbgr.mr_n84531488)
print v(xbgr.mr_n84531680)
print v(xbgr.mr_n84532192)
print v(xbgr.mr_n84533744)
print v(xbgr.mr_n84536000)
print v(xbgr.mr_n84536272)
print v(xbgr.mr_n84536464)
print v(xbgr.mr_n84536976)
print v(xbgr.mr_n84540464)
print v(xbgr.mr_n84540736)
print v(xbgr.mr_n84540928)
print v(xbgr.mr_n84541440)
print v(xbgr.mr_n84542992)
print v(xbgr.mr_n84545248)
print v(xbgr.mr_n84545520)
print v(xbgr.mr_n84545712)
print v(xbgr.mr_n84546224)
print v(xbgr.mr_n84549712)
print v(xbgr.mr_n84549984)
print v(xbgr.mr_n84550176)
print v(xbgr.mr_n84550688)
print v(xbgr.mr_n84552320)
print v(xbgr.mr_n84552512)
print v(xbgr.mr_n84554832)
print v(xbgr.mr_n84555024)
print v(xbgr.mr_n84555536)
print v(xbgr.mr_n84558960)
print v(xbgr.mr_n84559232)
print v(xbgr.mr_n84559424)
print v(xbgr.mr_n84559936)
print v(xbgr.mr_n84561488)
print v(xbgr.mr_n84563744)
print v(xbgr.mr_n84564016)
print v(xbgr.mr_n84564208)
print v(xbgr.mr_n84564720)
print v(xbgr.mr_n84568208)
print v(xbgr.mr_n84568480)
print v(xbgr.mr_n84568672)
print v(xbgr.mr_n84569184)
print v(xbgr.mr_n84572048)
print v(xbgr.mr_n84572320)
print v(xbgr.mr_n84572512)
print v(xbgr.mr_n84573024)
print v(xbgr.mr_n84575888)
print v(xbgr.mr_n84576160)
print v(xbgr.mr_n84576352)
print v(xbgr.mr_n84576864)
print v(xbgr.mr_n84580224)
print v(xbgr.mr_n84580336)
print v(xbgr.mr_n84582080)
print v(xbgr.mr_n84582352)
print v(xbgr.mr_n84582544)
print v(xbgr.mr_n84583056)
print v(xbgr.mr_n84585200)
print v(xbgr.mr_n84585312)
print v(xbgr.mr_n84587056)
print v(xbgr.mr_n84587328)
print v(xbgr.mr_n84587520)
print v(xbgr.mr_n84588032)
print v(xbgr.mr_n84590176)
print v(xbgr.mr_n84590288)
print v(xbgr.mr_n84592032)
print v(xbgr.mr_n84592304)
print v(xbgr.mr_n84592496)
print v(xbgr.mr_n84593008)
print v(xbgr.mr_n84595152)
print v(xbgr.mr_n84595264)
print v(xbgr.mr_n84597008)
print v(xbgr.mr_n84597280)
print v(xbgr.mr_n84597472)
print v(xbgr.mr_n84597984)
print v(xbgr.mr_n84603152)
print v(xbgr.mr_n84605344)
print v(xbgr.mr_n84606912)
print v(xbgr.mr_n84607856)
print v(xbgr.mr_n84609168)
print v(xbgr.mr_n84610048)
print v(xbgr.mr_n84611616)
print v(xbgr.mr_n84612560)
print v(xbgr.mr_n84614752)
print v(xbgr.mr_n84616368)
print v(xbgr.mr_n84616944)
print v(xbgr.mr_n84617056)
print v(xbgr.mr_n84617888)
print v(xbgr.mr_n84618000)
print v(xbgr.mr_n84618832)
print v(xbgr.mr_n84618944)
print v(xbgr.mr_n84619776)
print v(xbgr.mr_n84619888)
print v(xbgr.mr_n84620720)
print v(xbgr.mr_n84620832)
print v(xbgr.mr_n84621664)
print v(xbgr.mr_n84621776)
print v(xbgr.mr_n84622608)
print v(xbgr.mr_n84622720)
print v(xbgr.mr_n84623552)
print v(xbgr.mr_n84623664)
print v(xbgr.mr_n84624496)
print v(xbgr.mr_n84624608)
print v(xbgr.mr_n84625568)
print v(xbgr.mr_n84625680)
print v(xbgr.mr_n84633920)
print v(xbgr.mr_n84638928)
print v(xbgr.mr_n84650016)
print v(xbgr.mr_n84650704)
print v(xbgr.mr_n84651392)
print v(xbgr.mr_n84652080)
print v(xbgr.mr_n84653792)
print v(xbgr.mr_n84654736)
print v(xbgr.mr_n84655680)
print v(xbgr.mr_n84656624)
print v(xbgr.mr_n84657568)
print v(xbgr.mr_n84658512)
print v(xbgr.mr_n84659456)
print v(xbgr.mr_n84660400)
print v(xbgr.mr_n84661344)
print v(xbgr.mr_n84662288)
print v(xbgr.mr_n84663232)
print v(xbgr.mr_n84664176)
print v(xbgr.mr_n84665120)
print v(xbgr.mr_n84666064)
print v(xbgr.mr_n84667008)
print v(xbgr.mr_n84667200)
print v(xbgr.mr_n84667392)
print v(xbgr.mr_n84667584)
print v(xbgr.mr_n84667776)
print v(xbgr.mr_n84667968)
print v(xbgr.mr_n84670112)
print v(xbgr.mr_n84670224)
print v(xbgr.mr_n84673536)
print v(xbgr.mr_n84673648)
print v(xbgr.mr_n84678528)
print v(xbgr.mr_n84680368)
print v(xbgr.mr_n84682208)
print v(xbgr.mr_n84684048)
print v(xbgr.mr_n84688704)
print v(xbgr.mr_n84701216)
print v(xbgr.mr_n84702784)
print v(xbgr.mr_n84704352)
print v(xbgr.mr_n84705920)
print v(xbgr.mr_n84707488)
print v(xbgr.mr_n84709056)
print v(xbgr.mr_n84710624)
print v(xbgr.mr_n84712192)
print v(xbgr.mr_n84713760)
print v(xbgr.mr_n84715328)
print v(xbgr.mr_n84716896)
print v(xbgr.mr_n84718464)
print v(xbgr.mr_n84720032)
print v(xbgr.mr_n84721600)
print v(xbgr.mr_n84723168)
print v(xbgr.mr_n84724736)
print v(xbgr.mr_n84727984)
print v(xbgr.mr_n84728320)
print v(xbgr.mr_n84728432)
print v(xbgr.mr_n84729264)
print v(xbgr.mr_n84729376)
print v(xbgr.mr_n84730208)
print v(xbgr.mr_n84730320)
print v(xbgr.mr_n84731152)
print v(xbgr.mr_n84731264)
print v(xbgr.mr_n84734752)
print v(xbgr.mr_n84735264)
print v(xbgr.mr_n84735376)
print v(xbgr.mr_n84735488)
print v(xbgr.mr_n84735600)
print v(xbgr.mr_n84735712)
print v(xbgr.mr_n84737136)
print v(xbgr.mr_n84737408)
print v(xbgr.mr_n84737600)
print v(xbgr.mr_n84738112)
print v(xbgr.mr_n84740256)
print v(xbgr.mr_n84740368)
print v(xbgr.mr_n84742112)
print v(xbgr.mr_n84742384)
print v(xbgr.mr_n84742576)
print v(xbgr.mr_n84743088)
print v(xbgr.mr_n84745232)
print v(xbgr.mr_n84745344)
print v(xbgr.mr_n84747088)
print v(xbgr.mr_n84747360)
print v(xbgr.mr_n84747552)
print v(xbgr.mr_n84748064)
print v(xbgr.mr_n84750208)
print v(xbgr.mr_n84750320)
print v(xbgr.mr_n84750592)
print v(xbgr.mr_n84752064)
print v(xbgr.mr_n84752336)
print v(xbgr.mr_n84752528)
print v(xbgr.mr_n84753040)
print v(xbgr.mr_n84755184)
print v(xbgr.mr_n84755296)
print v(xbgr.mr_n84757040)
print v(xbgr.mr_n84757312)
print v(xbgr.mr_n84757504)
print v(xbgr.mr_n84758016)
print v(xbgr.mr_n84760160)
print v(xbgr.mr_n84760272)
print v(xbgr.mr_n84762016)
print v(xbgr.mr_n84762288)
print v(xbgr.mr_n84762480)
print v(xbgr.mr_n84762992)
print v(xbgr.mr_n84765296)
print v(xbgr.mr_n84765488)
print v(xbgr.mr_n84765680)
print v(xbgr.mr_n84765872)
print v(xbgr.mr_n84766064)
print v(xbgr.mr_n84768288)
print v(xbgr.mr_n84770112)
print v(xbgr.mr_n84770224)
print v(xbgr.mr_n84771968)
print v(xbgr.mr_n84772240)
print v(xbgr.mr_n84772432)
print v(xbgr.mr_n84772944)
print v(xbgr.mr_n84773840)
print v(xbgr.mr_n84774752)
print v(xbgr.mr_n84777136)
print v(xbgr.mr_n84777744)
print v(xbgr.mr_n84778432)
print v(xbgr.mr_n84779120)
print v(xbgr.mr_n84779808)
print v(xbgr.mr_n84780496)
print v(xbgr.mr_n84781600)
print v(xbgr.mr_n84783440)
print v(xbgr.mr_n84784384)
print v(xbgr.mr_n84785328)
print v(xbgr.mr_n84786272)
print v(xbgr.mr_n84787216)
print v(xbgr.mr_n84788160)
print v(xbgr.mr_n84789104)
print v(xbgr.mr_n84790048)
print v(xbgr.mr_n84790992)
print v(xbgr.mr_n84791936)
print v(xbgr.mr_n84792880)
print v(xbgr.mr_n84793824)
print v(xbgr.mr_n84794768)
print v(xbgr.mr_n84795712)
print v(xbgr.mr_n84797632)
print v(xbgr.mr_n84812656)
print v(xbgr.mr_n84814224)
print v(xbgr.mr_n84815264)
print v(xbgr.mr_n84815376)
print v(xbgr.mr_n84815488)
print v(xbgr.mr_n84817088)
print v(xbgr.mr_n84817200)
print v(xbgr.mr_n84820720)
print v(xbgr.mr_n84821408)
print v(xbgr.mr_n84822624)
print v(xbgr.mr_n84822736)
print v(xbgr.mr_n84826480)
print v(xbgr.mr_n84827952)
print v(xbgr.mr_n84829504)
print v(xbgr.mr_n84831072)
print v(xbgr.mr_n84832640)
print v(xbgr.mr_n84836528)
print v(xbgr.mr_n84837008)
print v(xbgr.mr_n84838720)
print v(xbgr.mr_n84838992)
print v(xbgr.mr_n84841296)
print v(xbgr.mr_n84841488)
print v(xbgr.mr_n84842032)
print v(xbgr.mr_n84842864)
print v(xbgr.mr_n84842976)
print v(xbgr.mr_n84845136)
print v(xbgr.mr_n84846688)
print v(xbgr.mr_n84847808)
print v(xbgr.mr_n84848496)
print v(xbgr.mr_n84851392)
print v(xbgr.mr_n84852960)
print v(xbgr.mr_n84853904)
print v(xbgr.mr_n84861056)
print v(xbgr.mr_n84861568)
print v(xbgr.mr_n84862672)
print v(xbgr.mr_n84862784)
print v(xbgr.mr_n84863936)
print v(xbgr.mr_n84864048)
print v(xbgr.mr_n84865200)
print v(xbgr.mr_n84865312)
print v(xbgr.mr_n84866400)
print v(xbgr.mr_n84866512)
print v(xbgr.mr_n84867664)
print v(xbgr.mr_n84867776)
print v(xbgr.mr_n84868928)
print v(xbgr.mr_n84869040)
print v(xbgr.mr_n84870256)
print v(xbgr.mr_n84870368)
print v(xbgr.mr_n84871456)
print v(xbgr.mr_n84871568)
print v(xbgr.mr_n84872784)
print v(xbgr.mr_n84872896)
print v(xbgr.mr_n84874048)
print v(xbgr.mr_n84874160)
print v(xbgr.mr_n84879648)
print v(xbgr.mr_n84881248)
print v(xbgr.mr_n84884592)
print v(xbgr.mr_n84887088)
print v(xbgr.mr_n84892880)
print v(xbgr.mr_n84893664)
print v(xbgr.mr_n84893776)
print v(xbgr.mr_n84893968)
print v(xbgr.mr_n84894160)
print v(xbgr.mr_n84894352)
print v(xbgr.mr_n84896768)
print v(xbgr.mr_n84902608)
print v(xbgr.mr_n84903552)
print v(xbgr.mr_n84904496)
print v(xbgr.mr_n84905440)
print v(xbgr.mr_n84906384)
print v(xbgr.mr_n84907328)
print v(xbgr.mr_n84908272)
print v(xbgr.mr_n84909216)
print v(xbgr.mr_n84910432)
print v(xbgr.mr_n84910544)
print v(xbgr.mr_n84910736)
print v(xbgr.mr_n84911008)
print v(xbgr.mr_n84911616)
print v(xbgr.mr_n84912304)
print v(xbgr.mr_n84914176)
print v(xbgr.mr_n84915600)
print v(xbgr.mr_n84916544)
print v(xbgr.mr_n84917488)
print v(xbgr.mr_n84918432)
print v(xbgr.mr_n84919376)
print v(xbgr.mr_n84920320)
print v(xbgr.mr_n84921264)
print v(xbgr.mr_n84922208)
print v(xbgr.mr_n84923152)
print v(xbgr.mr_n84924096)
print v(xbgr.mr_n84925040)
print v(xbgr.mr_n84925984)
print v(xbgr.mr_n84926928)
print v(xbgr.mr_n84927872)
print v(xbgr.mr_n84929280)
print v(xbgr.mr_n84931632)
print v(xbgr.mr_n84932576)
print v(xbgr.mr_n84933520)
print v(xbgr.mr_n84933712)
print v(xbgr.mr_n84933904)
print v(xbgr.mr_n84934096)
print v(xbgr.mr_n84934288)
print v(xbgr.mr_n84934480)
print v(xbgr.mr_n84936624)
print v(xbgr.mr_n84936736)
print v(xbgr.mr_n84939824)
print v(xbgr.mr_n84939936)
print v(xbgr.mr_n84945584)
print v(xbgr.mr_n84946528)
print v(xbgr.mr_n84947472)
print v(xbgr.mr_n84948416)
print v(xbgr.mr_n84949360)
print v(xbgr.mr_n84950304)
print v(xbgr.mr_n84952192)
print v(xbgr.mr_n84953136)
print v(xbgr.mr_n84954080)
print v(xbgr.mr_n84956208)
print v(xbgr.mr_n84956784)
print v(xbgr.mr_n84956896)
print v(xbgr.mr_n84957008)
print v(xbgr.mr_n84957840)
print v(xbgr.mr_n84958032)
print v(xbgr.mr_n84958224)
print v(xbgr.mr_n84958416)
print v(xbgr.mr_n84960608)
print v(xbgr.mr_n84960880)
print v(xbgr.mr_n84961072)
print v(xbgr.mr_n84961584)
print v(xbgr.mr_n84962624)
print v(xbgr.mr_n84967072)
print v(xbgr.mr_n84967904)
print v(xbgr.mr_n84968016)
print v(xbgr.mr_n84968128)
print v(xbgr.mr_n84968240)
print v(xbgr.mr_n84968432)
print v(xbgr.mr_n84968624)
print v(xbgr.mr_n84970432)
print v(xbgr.mr_n84970624)
print v(xbgr.mr_n84971136)
print v(xbgr.mr_n84973216)
print v(xbgr.mr_n84973328)
print v(xbgr.mr_n84975072)
print v(xbgr.mr_n84975344)
print v(xbgr.mr_n84975536)
print v(xbgr.mr_n84976048)
print v(xbgr.mr_n84978192)
print v(xbgr.mr_n84978304)
print v(xbgr.mr_n84980048)
print v(xbgr.mr_n84980320)
print v(xbgr.mr_n84980512)
print v(xbgr.mr_n84981024)
print v(xbgr.mr_n84983168)
print v(xbgr.mr_n84983280)
print v(xbgr.mr_n84983616)
print v(xbgr.mr_n84985024)
print v(xbgr.mr_n84985296)
print v(xbgr.mr_n84985488)
print v(xbgr.mr_n84986000)
print v(xbgr.mr_n84988144)
print v(xbgr.mr_n84988256)
print v(xbgr.mr_n84990000)
print v(xbgr.mr_n84990272)
print v(xbgr.mr_n84990464)
print v(xbgr.mr_n84990976)
print v(xbgr.mr_n84993120)
print v(xbgr.mr_n84993424)
print v(xbgr.mr_n84994976)
print v(xbgr.mr_n84995248)
print v(xbgr.mr_n84995952)
print v(xbgr.mr_n84998096)
print v(xbgr.mr_n84998208)
print v(xbgr.mr_n84999952)
print v(xbgr.mr_n85000224)
print v(xbgr.mr_n85000416)
print v(xbgr.mr_n85000928)
print v(xbgr.mr_n85007408)
print v(xbgr.mr_n85009648)
print v(xbgr.mr_n85010400)
print v(xbgr.mr_n85011072)
print v(xbgr.mr_n85011264)
print v(xbgr.mr_n85012304)
print v(xbgr.mr_n85012416)
print v(xbgr.mr_n85018816)
print v(xbgr.mr_n85019504)
print v(xbgr.mr_n85020192)
print v(xbgr.mr_n85020880)
print v(xbgr.mr_n85021568)
print v(xbgr.mr_n85022256)
print v(xbgr.mr_n85022944)
print v(xbgr.mr_n85023632)
print v(xbgr.mr_n85024320)
print v(xbgr.mr_n85025008)
print v(xbgr.mr_n85025696)
print v(xbgr.mr_n85026384)
print v(xbgr.mr_n85030288)
print v(xbgr.mr_n85037312)
print v(xbgr.mr_n85039104)
print v(xbgr.mr_n85039216)
print v(xbgr.mr_n85041616)
print v(xbgr.mr_n85041728)
print v(xbgr.mr_n85042816)
print v(xbgr.mr_n85042928)
print v(xbgr.mr_n85044144)
print v(xbgr.mr_n85044256)
print v(xbgr.mr_n85045456)
print v(xbgr.mr_n85045568)
print v(xbgr.mr_n85045680)
print v(xbgr.mr_n85046448)
print v(xbgr.mr_n85046560)
print v(xbgr.mr_n85047696)
print v(xbgr.mr_n85047808)
print v(xbgr.mr_n85049280)
print v(xbgr.mr_n85049392)
print v(xbgr.mr_n85051600)
print v(xbgr.mr_n85051712)
print v(xbgr.mr_n85052864)
print v(xbgr.mr_n85052976)
print v(xbgr.mr_n85054128)
print v(xbgr.mr_n85054240)
print v(xbgr.mr_n85055328)
print v(xbgr.mr_n85055440)
print v(xbgr.mr_n85056656)
print v(xbgr.mr_n85056768)
print v(xbgr.mr_n85057856)
print v(xbgr.mr_n85057968)
print v(xbgr.mr_n85058336)
print v(xbgr.mr_n85061776)
print v(xbgr.mr_n85062896)
print v(xbgr.mr_n85064368)
print v(xbgr.mr_n85065936)
print v(xbgr.mr_n85067504)
print v(xbgr.mr_n85069072)
print v(xbgr.mr_n85070640)
print v(xbgr.mr_n85072208)
print v(xbgr.mr_n85073776)
print v(xbgr.mr_n85075344)
print v(xbgr.mr_n85076912)
print v(xbgr.mr_n85078480)
print v(xbgr.mr_n85079712)
print v(xbgr.mr_n85080672)
print v(xbgr.mr_n85082240)
print v(xbgr.mr_n85083808)
print v(xbgr.mr_n85086288)
print v(xbgr.mr_n85091040)
print v(xbgr.mr_n85092112)
print v(xbgr.mr_n85095536)
print v(xbgr.mr_n85096608)
print v(xbgr.mr_n85096800)
print v(xbgr.mr_n85096992)
print v(xbgr.mr_n85097184)
print v(xbgr.mr_n85099504)
print v(xbgr.mr_n85099776)
print v(xbgr.mr_n85099968)
print v(xbgr.mr_n85100480)
print v(xbgr.mr_n85101168)
print v(xbgr.mr_n85105296)
print v(xbgr.mr_n85105568)
print v(xbgr.mr_n85105760)
print v(xbgr.mr_n85106272)
print v(xbgr.mr_n85107536)
print v(xbgr.mr_n85109344)
print v(xbgr.mr_n85109536)
print v(xbgr.mr_n85110048)
print v(xbgr.mr_n85112128)
print v(xbgr.mr_n85112240)
print v(xbgr.mr_n85113984)
print v(xbgr.mr_n85114256)
print v(xbgr.mr_n85114448)
print v(xbgr.mr_n85114960)
print v(xbgr.mr_n85116192)
print v(xbgr.mr_n85116704)
print v(xbgr.mr_n85122448)
print v(xbgr.mr_n85124832)
print v(xbgr.mr_n85125024)
print v(xbgr.mr_n85125536)
print v(xbgr.mr_n85126832)
print v(xbgr.mr_n85127344)
print v(xbgr.mr_n85127776)
print v(xbgr.mr_n85129856)
print v(xbgr.mr_n85131664)
print v(xbgr.mr_n85132176)
print v(xbgr.mr_n85134176)
print v(xbgr.mr_n85134688)
print v(xbgr.mr_n85135504)
print v(xbgr.mr_n85137584)
print v(xbgr.mr_n85139328)
print v(xbgr.mr_n85139840)
print v(xbgr.mr_n85140656)
print v(xbgr.mr_n85142736)
print v(xbgr.mr_n85144544)
print v(xbgr.mr_n85145056)
print v(xbgr.mr_n85147056)
print v(xbgr.mr_n85147568)
print v(xbgr.mr_n85149632)
print v(xbgr.mr_n85150144)
print v(xbgr.mr_n85150960)
print v(xbgr.mr_n85152208)
print v(xbgr.mr_n85152720)
print v(xbgr.mr_n85153536)
print v(xbgr.mr_n85153792)
print v(xbgr.mr_n85156064)
print v(xbgr.mr_n85157760)
print v(xbgr.mr_n85161056)
print v(xbgr.mr_n85161168)
print v(xbgr.mr_n85162320)
print v(xbgr.mr_n85162432)
print v(xbgr.mr_n85163584)
print v(xbgr.mr_n85163696)
print v(xbgr.mr_n85164848)
print v(xbgr.mr_n85164960)
print v(xbgr.mr_n85166112)
print v(xbgr.mr_n85166224)
print v(xbgr.mr_n85167376)
print v(xbgr.mr_n85167488)
print v(xbgr.mr_n85168640)
print v(xbgr.mr_n85168752)
print v(xbgr.mr_n85169904)
print v(xbgr.mr_n85170016)
print v(xbgr.mr_n85171168)
print v(xbgr.mr_n85171280)
print v(xbgr.mr_n85172432)
print v(xbgr.mr_n85172544)
print v(xbgr.mr_n85173696)
print v(xbgr.mr_n85173808)
print v(xbgr.mr_n85174896)
print v(xbgr.mr_n85175008)
print v(xbgr.mr_n85176224)
print v(xbgr.mr_n85176336)
print v(xbgr.mr_n85177488)
print v(xbgr.mr_n85177600)
print v(xbgr.mr_n85177792)
print v(xbgr.mr_n85182768)
print v(xbgr.mr_n85190000)
print v(xbgr.mr_n85192880)
print v(xbgr.mr_n85193568)
print v(xbgr.mr_n85194608)
print v(xbgr.mr_n85196256)
print v(xbgr.mr_n85197200)
print v(xbgr.mr_n85198144)
print v(xbgr.mr_n85199088)
print v(xbgr.mr_n85200032)
print v(xbgr.mr_n85200976)
print v(xbgr.mr_n85201920)
print v(xbgr.mr_n85202864)
print v(xbgr.mr_n85203808)
print v(xbgr.mr_n85204752)
print v(xbgr.mr_n85205696)
print v(xbgr.mr_n85206640)
print v(xbgr.mr_n85207584)
print v(xbgr.mr_n85208528)
print v(xbgr.mr_n85209472)
print v(xbgr.mr_n85210416)
print v(xbgr.mr_n85216736)
print v(xbgr.mr_n85218304)
print v(xbgr.mr_n85221648)
print v(xbgr.mr_n85222880)
print v(xbgr.mr_n85222992)
print v(xbgr.mr_n85223936)
print v(xbgr.mr_n85225088)
print v(xbgr.mr_n85225200)
print v(xbgr.mr_n85226976)
print v(xbgr.mr_n85227088)
print v(xbgr.mr_n85228032)
print v(xbgr.mr_n85229184)
print v(xbgr.mr_n85229296)
print v(xbgr.mr_n85231072)
print v(xbgr.mr_n85231184)
print v(xbgr.mr_n85232128)
print v(xbgr.mr_n85233280)
print v(xbgr.mr_n85233392)
print v(xbgr.mr_n85234560)
print v(xbgr.mr_n85235168)
print v(xbgr.mr_n85235280)
print v(xbgr.mr_n85236224)
print v(xbgr.mr_n85237376)
print v(xbgr.mr_n85237488)
print v(xbgr.mr_n85239264)
print v(xbgr.mr_n85239376)
print v(xbgr.mr_n85240320)
print v(xbgr.mr_n85241472)
print v(xbgr.mr_n85241584)
print v(xbgr.mr_n85242752)
print v(xbgr.mr_n85243360)
print v(xbgr.mr_n85243472)
print v(xbgr.mr_n85244416)
print v(xbgr.mr_n85245568)
print v(xbgr.mr_n85245680)
print v(xbgr.mr_n85246848)
print v(xbgr.mr_n85247456)
print v(xbgr.mr_n85247568)
print v(xbgr.mr_n85248512)
print v(xbgr.mr_n85249664)
print v(xbgr.mr_n85249776)
print v(xbgr.mr_n85251552)
print v(xbgr.mr_n85251664)
print v(xbgr.mr_n85252608)
print v(xbgr.mr_n85253760)
print v(xbgr.mr_n85253872)
print v(xbgr.mr_n85255648)
print v(xbgr.mr_n85255760)
print v(xbgr.mr_n85257072)
print v(xbgr.mr_n85258192)
print v(xbgr.mr_n85260288)
print v(xbgr.mr_n85261856)
print v(xbgr.mr_n85263424)
print v(xbgr.mr_n85264992)
print v(xbgr.mr_n85266560)
print v(xbgr.mr_n85268128)
print v(xbgr.mr_n85269696)
print v(xbgr.mr_n85274816)
print v(xbgr.mr_n85288560)
print v(xbgr.mr_n85289632)
print v(xbgr.mr_n85289824)
print v(xbgr.mr_n85290016)
print v(xbgr.mr_n85290208)
print v(xbgr.mr_n85290400)
print v(xbgr.mr_n85292720)
print v(xbgr.mr_n85292992)
print v(xbgr.mr_n85293184)
print v(xbgr.mr_n85293696)
print v(xbgr.mr_n85295984)
print v(xbgr.mr_n85296816)
print v(xbgr.mr_n85299376)
print v(xbgr.mr_n85299648)
print v(xbgr.mr_n85299840)
print v(xbgr.mr_n85300352)
print v(xbgr.mr_n85303088)
print v(xbgr.mr_n85303360)
print v(xbgr.mr_n85303552)
print v(xbgr.mr_n85304064)
print v(xbgr.mr_n85306208)
print v(xbgr.mr_n85306320)
print v(xbgr.mr_n85308064)
print v(xbgr.mr_n85308336)
print v(xbgr.mr_n85308528)
print v(xbgr.mr_n85309040)
print v(xbgr.mr_n85310272)
print v(xbgr.mr_n85310784)
print v(xbgr.mr_n85314224)
print v(xbgr.mr_n85314496)
print v(xbgr.mr_n85314688)
print v(xbgr.mr_n85315200)
print v(xbgr.mr_n85315568)
print v(xbgr.mr_n85315824)
print v(xbgr.mr_n85315936)
print v(xbgr.mr_n85316048)
print v(xbgr.mr_n85317312)
print v(xbgr.mr_n85317584)
print v(xbgr.mr_n85317776)
print v(xbgr.mr_n85318288)
print v(xbgr.mr_n85318880)
print v(xbgr.mr_n85318992)
print v(xbgr.mr_n85319616)
print v(xbgr.mr_n85320992)
print v(xbgr.mr_n85323472)
print v(xbgr.mr_n85323744)
print v(xbgr.mr_n85323936)
print v(xbgr.mr_n85324448)
print v(xbgr.mr_n85327680)
print v(xbgr.mr_n85327792)
print v(xbgr.mr_n85329536)
print v(xbgr.mr_n85329808)
print v(xbgr.mr_n85330000)
print v(xbgr.mr_n85330512)
print v(xbgr.mr_n85331744)
print v(xbgr.mr_n85332256)
print v(xbgr.mr_n85335696)
print v(xbgr.mr_n85335968)
print v(xbgr.mr_n85336160)
print v(xbgr.mr_n85336672)
print v(xbgr.mr_n85338816)
print v(xbgr.mr_n85338928)
print v(xbgr.mr_n85340672)
print v(xbgr.mr_n85340864)
print v(xbgr.mr_n85341056)
print v(xbgr.mr_n85341648)
print v(xbgr.mr_n85342880)
print v(xbgr.mr_n85343392)
print v(xbgr.mr_n85346832)
print v(xbgr.mr_n85347104)
print v(xbgr.mr_n85347296)
print v(xbgr.mr_n85347808)
print v(xbgr.mr_n85349952)
print v(xbgr.mr_n85350064)
print v(xbgr.mr_n85351808)
print v(xbgr.mr_n85352000)
print v(xbgr.mr_n85352192)
print v(xbgr.mr_n85352784)
print v(xbgr.mr_n85354016)
print v(xbgr.mr_n85354528)
print v(xbgr.mr_n85361584)
print v(xbgr.mr_n85361696)
print v(xbgr.mr_n85362528)
print v(xbgr.mr_n85362640)
print v(xbgr.mr_n85363472)
print v(xbgr.mr_n85363584)
print v(xbgr.mr_n85364672)
print v(xbgr.mr_n85364784)
print v(xbgr.mr_n85365936)
print v(xbgr.mr_n85366048)
print v(xbgr.mr_n85367200)
print v(xbgr.mr_n85367312)
print v(xbgr.mr_n85368464)
print v(xbgr.mr_n85368576)
print v(xbgr.mr_n85369728)
print v(xbgr.mr_n85369840)
print v(xbgr.mr_n85370992)
print v(xbgr.mr_n85371104)
print v(xbgr.mr_n85372256)
print v(xbgr.mr_n85372368)
print v(xbgr.mr_n85373520)
print v(xbgr.mr_n85373632)
print v(xbgr.mr_n85374784)
print v(xbgr.mr_n85374896)
print v(xbgr.mr_n85376048)
print v(xbgr.mr_n85376160)
print v(xbgr.mr_n85377312)
print v(xbgr.mr_n85377424)
print v(xbgr.mr_n85378576)
print v(xbgr.mr_n85378688)
print v(xbgr.mr_n85381120)
print v(xbgr.mr_n85385200)
print v(xbgr.mr_n85385888)
print v(xbgr.mr_n85386576)
print v(xbgr.mr_n85387296)
print v(xbgr.mr_n85388240)
print v(xbgr.mr_n85389184)
print v(xbgr.mr_n85390128)
print v(xbgr.mr_n85391072)
print v(xbgr.mr_n85392016)
print v(xbgr.mr_n85392960)
print v(xbgr.mr_n85393904)
print v(xbgr.mr_n85394848)
print v(xbgr.mr_n85395792)
print v(xbgr.mr_n85396736)
print v(xbgr.mr_n85397680)
print v(xbgr.mr_n85398624)
print v(xbgr.mr_n85399568)
print v(xbgr.mr_n85400512)
print v(xbgr.mr_n85401456)
print v(xbgr.mr_n85403744)
print v(xbgr.mr_n85407792)
print v(xbgr.mr_n85411184)
print v(xbgr.mr_n85416992)
print v(xbgr.mr_n85418560)
print v(xbgr.mr_n85421040)
print v(xbgr.mr_n85422176)
print v(xbgr.mr_n85422288)
print v(xbgr.mr_n85423232)
print v(xbgr.mr_n85424384)
print v(xbgr.mr_n85424496)
print v(xbgr.mr_n85425664)
print v(xbgr.mr_n85426272)
print v(xbgr.mr_n85426384)
print v(xbgr.mr_n85427328)
print v(xbgr.mr_n85428480)
print v(xbgr.mr_n85428592)
print v(xbgr.mr_n85430368)
print v(xbgr.mr_n85430480)
print v(xbgr.mr_n85431424)
print v(xbgr.mr_n85432576)
print v(xbgr.mr_n85432688)
print v(xbgr.mr_n85433856)
print v(xbgr.mr_n85434464)
print v(xbgr.mr_n85434576)
print v(xbgr.mr_n85435520)
print v(xbgr.mr_n85436672)
print v(xbgr.mr_n85436784)
print v(xbgr.mr_n85437952)
print v(xbgr.mr_n85438560)
print v(xbgr.mr_n85438672)
print v(xbgr.mr_n85439616)
print v(xbgr.mr_n85440768)
print v(xbgr.mr_n85440880)
print v(xbgr.mr_n85442048)
print v(xbgr.mr_n85442656)
print v(xbgr.mr_n85442768)
print v(xbgr.mr_n85443712)
print v(xbgr.mr_n85444800)
print v(xbgr.mr_n85444912)
print v(xbgr.mr_n85446144)
print v(xbgr.mr_n85446752)
print v(xbgr.mr_n85446864)
print v(xbgr.mr_n85447808)
print v(xbgr.mr_n85448960)
print v(xbgr.mr_n85449072)
print v(xbgr.mr_n85450720)
print v(xbgr.mr_n85450848)
print v(xbgr.mr_n85452480)
print v(xbgr.mr_n85455872)
print v(xbgr.mr_n85457440)
print v(xbgr.mr_n85459008)
print v(xbgr.mr_n85460576)
print v(xbgr.mr_n85462144)
print v(xbgr.mr_n85463712)
print v(xbgr.mr_n85465120)
print v(xbgr.mr_n85471504)
print v(xbgr.mr_n85471760)
print v(xbgr.mr_n85474272)
print v(xbgr.mr_n85474448)
print v(xbgr.mr_n85476208)
print v(xbgr.mr_n85476320)
print v(xbgr.mr_n85478608)
print v(xbgr.mr_n85480688)
print v(xbgr.mr_n85484848)
print v(xbgr.mr_n85491312)
print v(xbgr.mr_n85491696)
print v(xbgr.mr_n85491888)
print v(xbgr.mr_n85492720)
print v(xbgr.mr_n85493152)
print v(xbgr.mr_n85493984)
print v(xbgr.mr_n85494688)
print v(xbgr.mr_n85495248)
print v(xbgr.mr_n85495680)
print v(xbgr.mr_n85496512)
print v(xbgr.mr_n85497088)
print v(xbgr.mr_n85497776)
print v(xbgr.mr_n85498352)
print v(xbgr.mr_n85499040)
print v(xbgr.mr_n85499472)
print v(xbgr.mr_n85500304)
print v(xbgr.mr_n85500736)
print v(xbgr.mr_n85501568)
print v(xbgr.mr_n85502144)
print v(xbgr.mr_n85502832)
print v(xbgr.mr_n85503264)
print v(xbgr.mr_n85504096)
print v(xbgr.mr_n85504800)
print v(xbgr.mr_n85505360)
print v(xbgr.mr_n85506064)
print v(xbgr.mr_n85506624)
print v(xbgr.mr_n85507056)
print v(xbgr.mr_n85507888)
print v(xbgr.mr_n85508592)
print v(xbgr.mr_n85509152)
print v(xbgr.mr_n85509728)
print v(xbgr.mr_n85510416)
print v(xbgr.mr_n85510992)
print v(xbgr.mr_n85511680)
print v(xbgr.mr_n85512256)
print v(xbgr.mr_n85512944)
print v(xbgr.mr_n85516512)
print v(xbgr.mr_n85516704)
print v(xbgr.mr_n85516896)
print v(xbgr.mr_n85517088)
print v(xbgr.mr_n85517344)
print v(xbgr.mr_n85517600)
print v(xbgr.mr_n85517856)
print v(xbgr.mr_n85520400)
print v(xbgr.mr_n85521312)
print v(xbgr.mr_n85521824)
print v(xbgr.mr_n85523376)
print v(xbgr.mr_n85523888)
print v(xbgr.mr_n85525824)
print v(xbgr.mr_n85526336)
print v(xbgr.mr_n85528272)
print v(xbgr.mr_n85528784)
print v(xbgr.mr_n85530720)
print v(xbgr.mr_n85531232)
print v(xbgr.mr_n85533168)
print v(xbgr.mr_n85533680)
print v(xbgr.mr_n85535616)
print v(xbgr.mr_n85536128)
print v(xbgr.mr_n85536944)
print v(xbgr.mr_n85538896)
print v(xbgr.mr_n85540512)
print v(xbgr.mr_n85541024)
print v(xbgr.mr_n85542960)
print v(xbgr.mr_n85543472)
print v(xbgr.mr_n85545328)
print v(xbgr.mr_n85545920)
print v(xbgr.mr_n85547856)
print v(xbgr.mr_n85548368)
print v(xbgr.mr_n85550304)
print v(xbgr.mr_n85550816)
print v(xbgr.mr_n85552752)
print v(xbgr.mr_n85553264)
print v(xbgr.mr_n85555264)
print v(xbgr.mr_n85555776)
print v(xbgr.mr_n85557648)
print v(xbgr.mr_n85558160)
print v(xbgr.mr_n85561616)
print v(xbgr.mr_n85566080)
print v(xbgr.mr_n85567232)
print v(xbgr.mr_n85567344)
print v(xbgr.mr_n85568496)
print v(xbgr.mr_n85568608)
print v(xbgr.mr_n85569760)
print v(xbgr.mr_n85569872)
print v(xbgr.mr_n85571024)
print v(xbgr.mr_n85571136)
print v(xbgr.mr_n85572288)
print v(xbgr.mr_n85572400)
print v(xbgr.mr_n85573552)
print v(xbgr.mr_n85573664)
print v(xbgr.mr_n85574816)
print v(xbgr.mr_n85574928)
print v(xbgr.mr_n85576080)
print v(xbgr.mr_n85576192)
print v(xbgr.mr_n85577344)
print v(xbgr.mr_n85577456)
print v(xbgr.mr_n85578544)
print v(xbgr.mr_n85578656)
print v(xbgr.mr_n85579872)
print v(xbgr.mr_n85579984)
print v(xbgr.mr_n85581136)
print v(xbgr.mr_n85581248)
print v(xbgr.mr_n85582400)
print v(xbgr.mr_n85582512)
print v(xbgr.mr_n85583664)
print v(xbgr.mr_n85583776)
print v(xbgr.mr_n85584928)
print v(xbgr.mr_n85585040)
print v(xbgr.mr_n85585856)
print v(xbgr.mr_n85585968)
print v(xbgr.mr_n85586080)
print v(xbgr.mr_n85586192)
print v(xbgr.mr_n85586592)
print v(xbgr.mr_n85587760)
print v(xbgr.mr_n85588448)
print v(xbgr.mr_n85589520)
print v(xbgr.mr_n85591808)
print v(xbgr.mr_n85592752)
print v(xbgr.mr_n85593696)
print v(xbgr.mr_n85601360)
print v(xbgr.mr_n85602272)
print v(xbgr.mr_n85604432)
print v(xbgr.mr_n85608576)
print v(xbgr.mr_n85613728)
print v(xbgr.mr_n85617424)
print v(xbgr.mr_n85618992)
print v(xbgr.mr_n85620800)
print v(xbgr.mr_n85621984)
print v(xbgr.mr_n85623216)
print v(xbgr.mr_n85623328)
print v(xbgr.mr_n85624272)
print v(xbgr.mr_n85625424)
print v(xbgr.mr_n85625536)
print v(xbgr.mr_n85627248)
print v(xbgr.mr_n85627360)
print v(xbgr.mr_n85628304)
print v(xbgr.mr_n85629520)
print v(xbgr.mr_n85629632)
print v(xbgr.mr_n85631408)
print v(xbgr.mr_n85631520)
print v(xbgr.mr_n85632464)
print v(xbgr.mr_n85633616)
print v(xbgr.mr_n85633728)
print v(xbgr.mr_n85634896)
print v(xbgr.mr_n85635504)
print v(xbgr.mr_n85635616)
print v(xbgr.mr_n85636560)
print v(xbgr.mr_n85637712)
print v(xbgr.mr_n85637824)
print v(xbgr.mr_n85638992)
print v(xbgr.mr_n85639600)
print v(xbgr.mr_n85639712)
print v(xbgr.mr_n85640656)
print v(xbgr.mr_n85641808)
print v(xbgr.mr_n85641920)
print v(xbgr.mr_n85643632)
print v(xbgr.mr_n85643744)
print v(xbgr.mr_n85644688)
print v(xbgr.mr_n85645904)
print v(xbgr.mr_n85646016)
print v(xbgr.mr_n85647184)
print v(xbgr.mr_n85647792)
print v(xbgr.mr_n85647904)
print v(xbgr.mr_n85648848)
print v(xbgr.mr_n85650000)
print v(xbgr.mr_n85650112)
print v(xbgr.mr_n85651280)
print v(xbgr.mr_n85651888)
print v(xbgr.mr_n85652000)
print v(xbgr.mr_n85652944)
print v(xbgr.mr_n85654032)
print v(xbgr.mr_n85654144)
print v(xbgr.mr_n85655984)
print v(xbgr.mr_n85656096)
print v(xbgr.mr_n85657408)
print v(xbgr.mr_n85658528)
print v(xbgr.mr_n85660624)
print v(xbgr.mr_n85662192)
print v(xbgr.mr_n85663760)
print v(xbgr.mr_n85665328)
print v(xbgr.mr_n85666896)
print v(xbgr.mr_n85668464)
print v(xbgr.mr_n85670032)
print v(xbgr.mr_n85678992)
print v(xbgr.mr_n85687776)
print v(xbgr.mr_n85689632)
print v(xbgr.mr_n85689744)
print v(xbgr.mr_n85690688)
print v(xbgr.mr_n85690880)
print v(xbgr.mr_n85691072)
print v(xbgr.mr_n85691264)
print v(xbgr.mr_n85693520)
print v(xbgr.mr_n85693792)
print v(xbgr.mr_n85694496)
print v(xbgr.mr_n85694992)
print v(xbgr.mr_n85696848)
print v(xbgr.mr_n85698624)
print v(xbgr.mr_n85698736)
print v(xbgr.mr_n85700480)
print v(xbgr.mr_n85700752)
print v(xbgr.mr_n85700944)
print v(xbgr.mr_n85701456)
print v(xbgr.mr_n85703600)
print v(xbgr.mr_n85703712)
print v(xbgr.mr_n85705456)
print v(xbgr.mr_n85705728)
print v(xbgr.mr_n85705920)
print v(xbgr.mr_n85706432)
print v(xbgr.mr_n85708576)
print v(xbgr.mr_n85708688)
print v(xbgr.mr_n85710432)
print v(xbgr.mr_n85710704)
print v(xbgr.mr_n85710896)
print v(xbgr.mr_n85711408)
print v(xbgr.mr_n85713552)
print v(xbgr.mr_n85713664)
print v(xbgr.mr_n85715408)
print v(xbgr.mr_n85715680)
print v(xbgr.mr_n85715872)
print v(xbgr.mr_n85716384)
print v(xbgr.mr_n85718528)
print v(xbgr.mr_n85718720)
print v(xbgr.mr_n85718912)
print v(xbgr.mr_n85719184)
print v(xbgr.mr_n85720912)
print v(xbgr.mr_n85721056)
print v(xbgr.mr_n85721520)
print v(xbgr.mr_n85722832)
print v(xbgr.mr_n85723520)
print v(xbgr.mr_n85724528)
print v(xbgr.mr_n85724640)
print v(xbgr.mr_n85724752)
print v(xbgr.mr_n85724944)
print v(xbgr.mr_n85725136)
print v(xbgr.mr_n85726944)
print v(xbgr.mr_n85727136)
print v(xbgr.mr_n85727648)
print v(xbgr.mr_n85731648)
print v(xbgr.mr_n85731760)
print v(xbgr.mr_n85733504)
print v(xbgr.mr_n85733776)
print v(xbgr.mr_n85733968)
print v(xbgr.mr_n85734480)
print v(xbgr.mr_n85736624)
print v(xbgr.mr_n85736736)
print v(xbgr.mr_n85738480)
print v(xbgr.mr_n85738752)
print v(xbgr.mr_n85738944)
print v(xbgr.mr_n85739456)
print v(xbgr.mr_n85741600)
print v(xbgr.mr_n85741712)
print v(xbgr.mr_n85743456)
print v(xbgr.mr_n85743728)
print v(xbgr.mr_n85743920)
print v(xbgr.mr_n85744432)
print v(xbgr.mr_n85746576)
print v(xbgr.mr_n85746688)
print v(xbgr.mr_n85748432)
print v(xbgr.mr_n85748704)
print v(xbgr.mr_n85748896)
print v(xbgr.mr_n85749408)
print v(xbgr.mr_n85751552)
print v(xbgr.mr_n85751664)
print v(xbgr.mr_n85753408)
print v(xbgr.mr_n85753680)
print v(xbgr.mr_n85753872)
print v(xbgr.mr_n85754384)
print v(xbgr.mr_n85756528)
print v(xbgr.mr_n85756640)
print v(xbgr.mr_n85758384)
print v(xbgr.mr_n85758656)
print v(xbgr.mr_n85758848)
print v(xbgr.mr_n85759360)
print v(xbgr.mr_n85761504)
print v(xbgr.mr_n85761616)
print v(xbgr.mr_n85763360)
print v(xbgr.mr_n85763632)
print v(xbgr.mr_n85763824)
print v(xbgr.mr_n85764336)
print v(xbgr.mr_n85766480)
print v(xbgr.mr_n85766592)
print v(xbgr.mr_n85768336)
print v(xbgr.mr_n85768608)
print v(xbgr.mr_n85768800)
print v(xbgr.mr_n85769312)
print v(xbgr.mr_n85771456)
print v(xbgr.mr_n85771568)
print v(xbgr.mr_n85773312)
print v(xbgr.mr_n85773584)
print v(xbgr.mr_n85773776)
print v(xbgr.mr_n85774288)
print v(xbgr.mr_n85794672)
print v(xbgr.mr_n85795712)
print v(xbgr.mr_n85799808)
print v(xbgr.mr_n85804240)
print v(xbgr.mr_n85806608)
print v(xbgr.mr_n85807056)
print v(xbgr.mr_n85808288)
print v(xbgr.mr_n85811776)
print v(xbgr.mr_n85811888)
print v(xbgr.mr_n85813040)
print v(xbgr.mr_n85813152)
print v(xbgr.mr_n85814304)
print v(xbgr.mr_n85814416)
print v(xbgr.mr_n85815568)
print v(xbgr.mr_n85815680)
print v(xbgr.mr_n85816832)
print v(xbgr.mr_n85816944)
print v(xbgr.mr_n85818096)
print v(xbgr.mr_n85818208)
print v(xbgr.mr_n85819360)
print v(xbgr.mr_n85819472)
print v(xbgr.mr_n85820624)
print v(xbgr.mr_n85820736)
print v(xbgr.mr_n85821888)
print v(xbgr.mr_n85822000)
print v(xbgr.mr_n85823152)
print v(xbgr.mr_n85823264)
print v(xbgr.mr_n85824416)
print v(xbgr.mr_n85824528)
print v(xbgr.mr_n85825680)
print v(xbgr.mr_n85825792)
print v(xbgr.mr_n85826944)
print v(xbgr.mr_n85827056)
print v(xbgr.mr_n85828208)
print v(xbgr.mr_n85828320)
print v(xbgr.mr_n85829472)
print v(xbgr.mr_n85829584)
print v(xbgr.mr_n85833728)
print v(xbgr.mr_n85834688)
print v(xbgr.mr_n85839744)
print v(xbgr.mr_n85840432)
print v(xbgr.mr_n85841120)
print v(xbgr.mr_n85841840)
print v(xbgr.mr_n85842784)
print v(xbgr.mr_n85843728)
print v(xbgr.mr_n85844672)
print v(xbgr.mr_n85845616)
print v(xbgr.mr_n85846560)
print v(xbgr.mr_n85847504)
print v(xbgr.mr_n85848448)
print v(xbgr.mr_n85849392)
print v(xbgr.mr_n85850336)
print v(xbgr.mr_n85851280)
print v(xbgr.mr_n85852224)
print v(xbgr.mr_n85853168)
print v(xbgr.mr_n85854112)
print v(xbgr.mr_n85855056)
print v(xbgr.mr_n85856000)
print v(xbgr.mr_n85856448)
print v(xbgr.mr_n85857136)
print v(xbgr.mr_n85857744)
print v(xbgr.mr_n85859712)
print v(xbgr.mr_n85861200)
print v(xbgr.mr_n85862144)
print v(xbgr.mr_n85872816)
print v(xbgr.mr_n85879168)
print v(xbgr.mr_n85879392)
print v(xbgr.mr_n85879616)
print v(xbgr.mr_n85882624)
print v(xbgr.mr_n85883328)
print v(xbgr.mr_n85884208)
print v(xbgr.mr_n85885504)
print v(xbgr.mr_n85886384)
print v(xbgr.mr_n85887728)
print v(xbgr.mr_n85887968)
print v(xbgr.mr_n85888608)
print v(xbgr.mr_n85889136)
print v(xbgr.mr_n85889664)
print v(xbgr.mr_n85891600)
print v(xbgr.mr_n85892832)
print v(xbgr.mr_n85893136)
print v(xbgr.mr_n85896880)
print v(xbgr.mr_n85898704)
print v(xbgr.mr_n85899168)
print v(xbgr.mr_n85899344)
print v(xbgr.mr_n85900752)
print v(xbgr.mr_n85901808)
print v(xbgr.mr_n85903216)
print v(xbgr.mr_n85903392)
print v(xbgr.mr_n85903632)
print v(xbgr.mr_n85903968)
print v(xbgr.mr_n85904960)
print v(xbgr.mr_n85905168)
print v(xbgr.mr_n85905776)
print v(xbgr.mr_n85906128)
print v(xbgr.mr_n85908128)
print v(xbgr.mr_n85909072)
print v(xbgr.mr_n85910016)
print v(xbgr.mr_n85910960)
print v(xbgr.mr_n85911904)
print v(xbgr.mr_n85912848)
print v(xbgr.mr_n85913792)
print v(xbgr.mr_n85914736)
print v(xbgr.mr_n85915680)
print v(xbgr.mr_n85916624)
print v(xbgr.mr_n85917568)
print v(xbgr.mr_n85918512)
print v(xbgr.mr_n85919456)
print v(xbgr.mr_n85920400)
print v(xbgr.mr_n85921344)
print v(xbgr.mr_n85922288)
print v(xbgr.mr_n85923232)
print v(xbgr.mr_n85924176)
print v(xbgr.mr_n85925120)
print v(xbgr.mr_n85926064)
print v(xbgr.mr_n85927008)
print v(xbgr.mr_n85927952)
print v(xbgr.mr_n85928896)
print v(xbgr.mr_n85929840)
print v(xbgr.mr_n85930784)
print v(xbgr.mr_n85931728)
print v(xbgr.mr_n85932672)
print v(xbgr.mr_n85933616)
print v(xbgr.mr_n85934560)
print v(xbgr.mr_n85935504)
print v(xbgr.mr_n85936448)
print v(xbgr.mr_n85937392)
print v(xbgr.mr_n85938336)
print v(xbgr.mr_n85939280)
print v(xbgr.mr_n85940224)
print v(xbgr.mr_n85941168)
print v(xbgr.mr_n85942112)
print v(xbgr.mr_n85943056)
print v(xbgr.mr_n85944000)
print v(xbgr.mr_n85944944)
print v(xbgr.mr_n85945888)
print v(xbgr.mr_n85946832)
print v(xbgr.mr_n85947776)
print v(xbgr.mr_n85948720)
print v(xbgr.mr_n85949664)
print v(xbgr.mr_n85950608)
print v(xbgr.mr_n85951552)
print v(xbgr.mr_n85952496)
print v(xbgr.mr_n85953440)
print v(xbgr.mr_n85954384)
print v(xbgr.mr_n85955328)
print v(xbgr.mr_n85956272)
print v(xbgr.mr_n85957216)
print v(xbgr.mr_n85958160)
print v(xbgr.mr_n85959104)
print v(xbgr.mr_n85960048)
print v(xbgr.mr_n85960992)
print v(xbgr.mr_n85961936)
print v(xbgr.mr_n85962880)
print v(xbgr.mr_n85963824)
print v(xbgr.mr_n85964768)
print v(xbgr.mr_n85965712)
print v(xbgr.mr_n85966656)
print v(xbgr.mr_n85967600)
print v(xbgr.mr_n85968544)
print v(xbgr.mr_n85969488)
print v(xbgr.mr_n85970432)
print v(xbgr.mr_n85971376)
print v(xbgr.mr_n85972320)
print v(xbgr.mr_n85973264)
print v(xbgr.mr_n85974208)
print v(xbgr.mr_n85975152)
print v(xbgr.mr_n85976096)
print v(xbgr.mr_n85977040)
print v(xbgr.mr_n85977984)
print v(xbgr.mr_n85978928)
print v(xbgr.mr_n85979872)
print v(xbgr.mr_n85980816)
print v(xbgr.mr_n85981760)
print v(xbgr.mr_n85982704)
print v(xbgr.mr_n85983648)
print v(xbgr.mr_n85984592)
print v(xbgr.mr_n85985536)
print v(xbgr.mr_n85986480)
print v(xbgr.mr_n85987424)
print v(xbgr.mr_n85988368)
print v(xbgr.mr_n85989312)
print v(xbgr.mr_n85990256)
print v(xbgr.mr_n85991200)
print v(xbgr.mr_n85991536)
print v(xbgr.mr_n85991648)
print v(xbgr.mr_n85992256)
print v(xbgr.mr_n85993504)
print v(xbgr.mr_n85995056)
print v(xbgr.mr_n85995632)
print v(xbgr.mr_n85995744)
print v(xbgr.mr_n85998736)
print v(xbgr.mr_n85998928)
print v(xbgr.mr_n85999120)
print v(xbgr.mr_n85999312)
print v(xbgr.mr_n86000224)
print v(xbgr.mr_n86000496)
print v(xbgr.mr_n86000688)
print v(xbgr.mr_n86001200)
print v(xbgr.mr_n86004880)
print v(xbgr.mr_n86004992)
print v(xbgr.mr_n86005904)
print v(xbgr.mr_n86006176)
print v(xbgr.mr_n86006368)
print v(xbgr.mr_n86006880)
print v(xbgr.mr_n86009680)
print v(xbgr.mr_n86009792)
print v(xbgr.mr_n86009904)
print v(xbgr.mr_n86010016)
print v(xbgr.mr_n86011760)
print v(xbgr.mr_n86012032)
print v(xbgr.mr_n86012224)
print v(xbgr.mr_n86012736)
print v(xbgr.mr_n86014032)
print v(xbgr.mr_n86014544)
print v(xbgr.mr_n86017328)
print v(xbgr.mr_n86017440)
print v(xbgr.mr_n86019184)
print v(xbgr.mr_n86019456)
print v(xbgr.mr_n86019648)
print v(xbgr.mr_n86020160)
print v(xbgr.mr_n86023344)
print v(xbgr.mr_n86023456)
print v(xbgr.mr_n86023568)
print v(xbgr.mr_n86023680)
print v(xbgr.mr_n86025424)
print v(xbgr.mr_n86025696)
print v(xbgr.mr_n86025888)
print v(xbgr.mr_n86026400)
print v(xbgr.mr_n86029584)
print v(xbgr.mr_n86029696)
print v(xbgr.mr_n86029808)
print v(xbgr.mr_n86029920)
print v(xbgr.mr_n86031664)
print v(xbgr.mr_n86031936)
print v(xbgr.mr_n86032128)
print v(xbgr.mr_n86032640)
print v(xbgr.mr_n86032752)
print v(xbgr.mr_n86034704)
print v(xbgr.mr_n86037232)
print v(xbgr.mr_n86037344)
print v(xbgr.mr_n86039088)
print v(xbgr.mr_n86039280)
print v(xbgr.mr_n86039472)
print v(xbgr.mr_n86040064)
print v(xbgr.mr_n86043248)
print v(xbgr.mr_n86043360)
print v(xbgr.mr_n86043472)
print v(xbgr.mr_n86043584)
print v(xbgr.mr_n86045328)
print v(xbgr.mr_n86045600)
print v(xbgr.mr_n86045792)
print v(xbgr.mr_n86046304)
print v(xbgr.mr_n86049488)
print v(xbgr.mr_n86049600)
print v(xbgr.mr_n86049712)
print v(xbgr.mr_n86049824)
print v(xbgr.mr_n86051568)
print v(xbgr.mr_n86051840)
print v(xbgr.mr_n86052032)
print v(xbgr.mr_n86052544)
print v(xbgr.mr_n86053776)
print v(xbgr.mr_n86054288)
print v(xbgr.mr_n86057136)
print v(xbgr.mr_n86057248)
print v(xbgr.mr_n86058992)
print v(xbgr.mr_n86059264)
print v(xbgr.mr_n86059456)
print v(xbgr.mr_n86059968)
print v(xbgr.mr_n86063152)
print v(xbgr.mr_n86063264)
print v(xbgr.mr_n86063376)
print v(xbgr.mr_n86063488)
print v(xbgr.mr_n86065232)
print v(xbgr.mr_n86065424)
print v(xbgr.mr_n86065616)
print v(xbgr.mr_n86066208)
print v(xbgr.mr_n86069392)
print v(xbgr.mr_n86069504)
print v(xbgr.mr_n86069616)
print v(xbgr.mr_n86069728)
print v(xbgr.mr_n86071472)
print v(xbgr.mr_n86071744)
print v(xbgr.mr_n86071936)
print v(xbgr.mr_n86072448)
print v(xbgr.mr_n86072816)
print v(xbgr.mr_n86073680)
print v(xbgr.mr_n86074192)
print v(xbgr.mr_n86077040)
print v(xbgr.mr_n86077152)
print v(xbgr.mr_n86078896)
print v(xbgr.mr_n86079168)
print v(xbgr.mr_n86079360)
print v(xbgr.mr_n86079872)
print v(xbgr.mr_n86081936)
print v(xbgr.mr_n86082048)
print v(xbgr.mr_n86082560)
print v(xbgr.mr_n86082672)
print v(xbgr.mr_n86083184)
print v(xbgr.mr_n86083296)
print v(xbgr.mr_n86084064)
print v(xbgr.mr_n86084176)
print v(xbgr.mr_n86085008)
print v(xbgr.mr_n86085120)
print v(xbgr.mr_n86086208)
print v(xbgr.mr_n86086320)
print v(xbgr.mr_n86087472)
print v(xbgr.mr_n86087584)
print v(xbgr.mr_n86088736)
print v(xbgr.mr_n86088848)
print v(xbgr.mr_n86090000)
print v(xbgr.mr_n86090112)
print v(xbgr.mr_n86091264)
print v(xbgr.mr_n86091376)
print v(xbgr.mr_n86092528)
print v(xbgr.mr_n86092640)
print v(xbgr.mr_n86093792)
print v(xbgr.mr_n86093904)
print v(xbgr.mr_n86095056)
print v(xbgr.mr_n86095168)
print v(xbgr.mr_n86096320)
print v(xbgr.mr_n86096432)
print v(xbgr.mr_n86097584)
print v(xbgr.mr_n86097696)
print v(xbgr.mr_n86098848)
print v(xbgr.mr_n86098960)
print v(xbgr.mr_n86108352)
print v(xbgr.mr_n86119312)
print v(xbgr.mr_n86119808)
print v(xbgr.mr_n86120896)
print v(xbgr.mr_n86121440)
print v(xbgr.mr_n86123360)
print v(xbgr.mr_n86125280)
print v(xbgr.mr_n86127424)
print v(xbgr.mr_n86127536)
print v(xbgr.mr_n86127840)
print v(xbgr.mr_n86127952)
print v(xbgr.mr_n86128064)
print v(xbgr.mr_n86129488)
print v(xbgr.mr_n86129600)
print v(xbgr.mr_n86135328)
print v(xbgr.mr_n86145376)
print v(xbgr.mr_n86148672)
print v(xbgr.mr_n86152384)
print v(xbgr.mr_n86156112)
print v(xbgr.mr_n86157008)
print v(xbgr.mr_n86164432)
print v(xbgr.mr_n86165376)
print v(xbgr.mr_n86166320)
print v(xbgr.mr_n86167264)
print v(xbgr.mr_n86168208)
print v(xbgr.mr_n86169152)
print v(xbgr.mr_n86170096)
print v(xbgr.mr_n86171040)
print v(xbgr.mr_n86171984)
print v(xbgr.mr_n86172928)
print v(xbgr.mr_n86173872)
print v(xbgr.mr_n86174816)
print v(xbgr.mr_n86175760)
print v(xbgr.mr_n86176704)
print v(xbgr.mr_n86177648)
print v(xbgr.mr_n86178592)
print v(xbgr.mr_n86179536)
print v(xbgr.mr_n86180480)
print v(xbgr.mr_n86181424)
print v(xbgr.mr_n86182368)
print v(xbgr.mr_n86183312)
print v(xbgr.mr_n86184256)
print v(xbgr.mr_n86185200)
print v(xbgr.mr_n86186144)
print v(xbgr.mr_n86187744)
print v(xbgr.mr_n86192080)
print v(xbgr.mr_n86193024)
print v(xbgr.mr_n86193968)
print v(xbgr.mr_n86195296)
print v(xbgr.mr_n86200304)
print v(xbgr.mr_n86200496)
print v(xbgr.mr_n86201184)
print v(xbgr.mr_n86201296)
print v(xbgr.mr_n86201408)
print v(xbgr.mr_n86201520)
print v(xbgr.mr_n86201632)
print v(xbgr.mr_n86203376)
print v(xbgr.mr_n86203648)
print v(xbgr.mr_n86203840)
print v(xbgr.mr_n86204352)
print v(xbgr.mr_n86206288)
print v(xbgr.mr_n86208032)
print v(xbgr.mr_n86208304)
print v(xbgr.mr_n86208496)
print v(xbgr.mr_n86209008)
print v(xbgr.mr_n86210944)
print v(xbgr.mr_n86212688)
print v(xbgr.mr_n86212960)
print v(xbgr.mr_n86213152)
print v(xbgr.mr_n86213664)
print v(xbgr.mr_n86215600)
print v(xbgr.mr_n86217344)
print v(xbgr.mr_n86217616)
print v(xbgr.mr_n86217808)
print v(xbgr.mr_n86218320)
print v(xbgr.mr_n86220256)
print v(xbgr.mr_n86222000)
print v(xbgr.mr_n86222272)
print v(xbgr.mr_n86222464)
print v(xbgr.mr_n86222976)
print v(xbgr.mr_n86224912)
print v(xbgr.mr_n86226656)
print v(xbgr.mr_n86226928)
print v(xbgr.mr_n86227120)
print v(xbgr.mr_n86227632)
print v(xbgr.mr_n86229648)
print v(xbgr.mr_n86229840)
print v(xbgr.mr_n86231648)
print v(xbgr.mr_n86231840)
print v(xbgr.mr_n86232352)
print v(xbgr.mr_n86234224)
print v(xbgr.mr_n86235968)
print v(xbgr.mr_n86236240)
print v(xbgr.mr_n86236432)
print v(xbgr.mr_n86236944)
print v(xbgr.mr_n86238880)
print v(xbgr.mr_n86240624)
print v(xbgr.mr_n86240896)
print v(xbgr.mr_n86241088)
print v(xbgr.mr_n86241600)
print v(xbgr.mr_n86243536)
print v(xbgr.mr_n86245280)
print v(xbgr.mr_n86245472)
print v(xbgr.mr_n86245664)
print v(xbgr.mr_n86246256)
print v(xbgr.mr_n86248192)
print v(xbgr.mr_n86249936)
print v(xbgr.mr_n86250128)
print v(xbgr.mr_n86250320)
print v(xbgr.mr_n86250912)
print v(xbgr.mr_n86252848)
print v(xbgr.mr_n86254592)
print v(xbgr.mr_n86254864)
print v(xbgr.mr_n86255056)
print v(xbgr.mr_n86255568)
print v(xbgr.mr_n86257504)
print v(xbgr.mr_n86259248)
print v(xbgr.mr_n86259520)
print v(xbgr.mr_n86259712)
print v(xbgr.mr_n86260224)
print v(xbgr.mr_n86261744)
print v(xbgr.mr_n86262720)
print v(xbgr.mr_n86263760)
print v(xbgr.mr_n86263952)
print v(xbgr.mr_n86264640)
print v(xbgr.mr_n86265648)
print v(xbgr.mr_n86266432)
print v(xbgr.mr_n86267040)
print v(xbgr.mr_n86267632)
print v(xbgr.mr_n86269232)
print v(xbgr.mr_n86269424)
print v(xbgr.mr_n86270112)
print v(xbgr.mr_n86270624)
print v(xbgr.mr_n86272832)
print v(xbgr.mr_n86274784)
print v(xbgr.mr_n86276752)
print v(xbgr.mr_n86278704)
print v(xbgr.mr_n86280336)
print v(xbgr.mr_n86282160)
print v(xbgr.mr_n86282736)
print v(xbgr.mr_n86283312)
print v(xbgr.mr_n86283888)
print v(xbgr.mr_n86284432)
print v(xbgr.mr_n86287696)
print v(xbgr.mr_n86288272)
print v(xbgr.mr_n86293040)
print v(xbgr.mr_n86293712)
print v(xbgr.mr_n86294096)
print v(xbgr.mr_n86295760)
print v(xbgr.mr_n86297072)
print v(xbgr.mr_n86298544)
print v(xbgr.mr_n86300432)
print v(xbgr.mr_n86300752)
print v(xbgr.mr_n86301664)
print v(xbgr.mr_n86306448)
print v(xbgr.mr_n86306592)
print v(xbgr.mr_n86307552)
print v(xbgr.mr_n86307664)
print v(xbgr.mr_n86309168)
print v(xbgr.mr_n86309872)
print v(xbgr.mr_n86311328)
print v(xbgr.mr_n86311728)
print v(xbgr.mr_n86312496)
print v(xbgr.mr_n86312640)
print v(xbgr.mr_n86315840)
print v(xbgr.mr_n86317376)
print v(xbgr.mr_n86317600)
print v(xbgr.mr_n86320576)
print v(xbgr.mr_n86322848)
print v(xbgr.mr_n86323808)
print v(xbgr.mr_n86324128)
print v(xbgr.mr_n86325888)
print v(xbgr.mr_n86327872)
print v(xbgr.mr_n86328608)
print v(xbgr.mr_n86328720)
print v(xbgr.mr_n86329712)
print v(xbgr.mr_n86332416)
print v(xbgr.mr_n86332640)
print v(xbgr.mr_n86335360)
print v(xbgr.mr_n86336992)
print v(xbgr.mr_n86337424)
print v(xbgr.mr_n86337936)
print v(xbgr.mr_n86338048)
print v(xbgr.mr_n86338480)
print v(xbgr.mr_n86338992)
print v(xbgr.mr_n86339104)
print v(xbgr.mr_n86339536)
print v(xbgr.mr_n86340560)
print v(xbgr.mr_n86341888)
print v(xbgr.mr_n86343840)
print v(xbgr.mr_n86344272)
print v(xbgr.mr_n86344688)
print v(xbgr.mr_n86345280)
print v(xbgr.mr_n86345472)
print v(xbgr.mr_n86349536)
print v(xbgr.mr_n86355008)
print v(xbgr.mr_n86357200)
print v(xbgr.mr_n86357392)
print v(xbgr.mr_n86357824)
print v(xbgr.mr_n86358016)
print v(xbgr.mr_n86358864)
print v(xbgr.mr_n86362096)
print v(xbgr.mr_n86362208)
print v(xbgr.mr_n86362896)
print v(xbgr.mr_n86363088)
print v(xbgr.mr_n86363760)
print v(xbgr.mr_n86365136)
print v(xbgr.mr_n86365328)
print v(xbgr.mr_n86365792)
print v(xbgr.mr_n86366256)
print v(xbgr.mr_n86366720)
print v(xbgr.mr_n86366912)
print v(xbgr.mr_n86367424)
print v(xbgr.mr_n86367760)
print v(xbgr.mr_n86368224)
print v(xbgr.mr_n86368688)
print v(xbgr.mr_n86368880)
print v(xbgr.mr_n86369584)
print v(xbgr.mr_n86372096)
print v(xbgr.mr_n86372288)
print v(xbgr.mr_n86372608)
print v(xbgr.mr_n86373024)
print v(xbgr.mr_n86373488)
print v(xbgr.mr_n86373952)
print v(xbgr.mr_n86374416)
print v(xbgr.mr_n86374608)
print v(xbgr.mr_n86375552)
print v(xbgr.mr_n86375888)
print v(xbgr.mr_n86377424)
print v(xbgr.mr_n86378048)
print v(xbgr.mr_n86378736)
print v(xbgr.mr_n86385600)
print v(xbgr.mr_n86385712)
print v(xbgr.mr_n86386592)
print v(xbgr.mr_n86387280)
print v(xbgr.mr_n86387968)
print v(xbgr.mr_n86388656)
print v(xbgr.mr_n86389344)
print v(xbgr.mr_n86390032)
print v(xbgr.mr_n86390720)
print v(xbgr.mr_n86391408)
print v(xbgr.mr_n86392096)
print v(xbgr.mr_n86392784)
print v(xbgr.mr_n86393472)
print v(xbgr.mr_n86394160)
print v(xbgr.mr_n86394848)
print v(xbgr.mr_n86395536)
print v(xbgr.mr_n86396224)
print v(xbgr.mr_n86397152)
print v(xbgr.mr_n86397664)
print v(xbgr.mr_n86397776)
print v(xbgr.mr_n86400528)
print v(xbgr.mr_n86400640)
print v(xbgr.mr_n86401728)
print v(xbgr.mr_n86401840)
print v(xbgr.mr_n86402672)
print v(xbgr.mr_n86402784)
print v(xbgr.mr_n86403616)
print v(xbgr.mr_n86403728)
print v(xbgr.mr_n86404560)
print v(xbgr.mr_n86404672)
print v(xbgr.mr_n86405504)
print v(xbgr.mr_n86405616)
print v(xbgr.mr_n86406448)
print v(xbgr.mr_n86406560)
print v(xbgr.mr_n86407392)
print v(xbgr.mr_n86407504)
print v(xbgr.mr_n86408336)
print v(xbgr.mr_n86408448)
print v(xbgr.mr_n86409280)
print v(xbgr.mr_n86409392)
print v(xbgr.mr_n86410224)
print v(xbgr.mr_n86410336)
print v(xbgr.mr_n86411168)
print v(xbgr.mr_n86411280)
print v(xbgr.mr_n86412112)
print v(xbgr.mr_n86412224)
print v(xbgr.mr_n86413376)
print v(xbgr.mr_n86413488)
print v(xbgr.mr_n86414640)
print v(xbgr.mr_n86414752)
print v(xbgr.mr_n86415904)
print v(xbgr.mr_n86416016)
print v(xbgr.mr_n86429968)
print v(xbgr.mr_n86434624)
print v(xbgr.mr_n86434816)
print v(xbgr.mr_n86435008)
print v(xbgr.mr_n86435200)
print v(xbgr.mr_n86437520)
print v(xbgr.mr_n86437792)
print v(xbgr.mr_n86437984)
print v(xbgr.mr_n86438496)
print v(xbgr.mr_n86438608)
print v(xbgr.mr_n86438720)
print v(xbgr.mr_n86438832)
print v(xbgr.mr_n86439024)
print v(xbgr.mr_n86439216)
print v(xbgr.mr_n86439408)
print v(xbgr.mr_n86442976)
print v(xbgr.mr_n86462528)
print v(xbgr.mr_n86464144)
print v(xbgr.mr_n86465824)
print v(xbgr.mr_n86468080)
print v(xbgr.mr_n86470336)
print v(xbgr.mr_n86472592)
print v(xbgr.mr_n86474848)
print v(xbgr.mr_n86496144)
print v(xbgr.mr_n86496576)
print v(xbgr.mr_n86497408)
print v(xbgr.mr_n86497984)
print v(xbgr.mr_n86498672)
print v(xbgr.mr_n86499104)
print v(xbgr.mr_n86499936)
print v(xbgr.mr_n86500368)
print v(xbgr.mr_n86501200)
print v(xbgr.mr_n86501632)
print v(xbgr.mr_n86502464)
print v(xbgr.mr_n86502896)
print v(xbgr.mr_n86503728)
print v(xbgr.mr_n86504432)
print v(xbgr.mr_n86504992)
print v(xbgr.mr_n86509008)
print v(xbgr.mr_n86527504)
print v(xbgr.mr_n86528720)
print v(xbgr.mr_n86532080)
print v(xbgr.mr_n86532960)
print v(xbgr.mr_n86533536)
print v(xbgr.mr_n86534208)
print v(xbgr.mr_n86534352)
print v(xbgr.mr_n86534928)
print v(xbgr.mr_n86535344)
print v(xbgr.mr_n86535952)
print v(xbgr.mr_n86536528)
print v(xbgr.mr_n86536944)
print v(xbgr.mr_n86537824)
print v(xbgr.mr_n86537936)
print v(xbgr.mr_n86538048)
print v(xbgr.mr_n86538160)
print v(xbgr.mr_n86538272)
print v(xbgr.mr_n86538384)
print v(xbgr.mr_n86538496)
print v(xbgr.mr_n86538608)
print v(xbgr.mr_n86538880)
print v(xbgr.mr_n86538992)
print v(xbgr.mr_n86539904)
print v(xbgr.mr_n86540096)
print v(xbgr.mr_n86540432)
print v(xbgr.mr_n86542416)
print v(xbgr.mr_n86542816)
print v(xbgr.mr_n86543008)
print v(xbgr.mr_n86543408)
print v(xbgr.mr_n86543600)
print v(xbgr.mr_n86544000)
print v(xbgr.mr_n86544400)
print v(xbgr.mr_n86545216)
print v(xbgr.mr_n86545488)
print v(xbgr.mr_n86546240)
print v(xbgr.mr_n86548656)
print v(xbgr.mr_n86548768)
print v(xbgr.mr_n86549280)
print v(xbgr.mr_n86549392)
print v(xbgr.mr_n86549904)
print v(xbgr.mr_n86550016)
print v(xbgr.mr_n86550528)
print v(xbgr.mr_n86550640)
print v(xbgr.mr_n86551152)
print v(xbgr.mr_n86551264)
print v(xbgr.mr_n86551776)
print v(xbgr.mr_n86551888)
print v(xbgr.mr_n86552400)
print v(xbgr.mr_n86552512)
print v(xbgr.mr_n86553024)
print v(xbgr.mr_n86553136)
print v(xbgr.mr_n86553504)
print v(xbgr.mr_n86556400)
print v(xbgr.mr_n86557232)
print v(xbgr.mr_n86559392)
print v(xbgr.mr_n86564976)
print v(xbgr.mr_n86566752)
print v(xbgr.mr_n86567440)
print v(xbgr.mr_n86568128)
print v(xbgr.mr_n86568816)
print v(xbgr.mr_n86569504)
print v(xbgr.mr_n86570192)
print v(xbgr.mr_n86571776)
print v(xbgr.mr_n86573072)
print v(xbgr.mr_n86574016)
print v(xbgr.mr_n86574960)
print v(xbgr.mr_n86575904)
print v(xbgr.mr_n86576848)
print v(xbgr.mr_n86577792)
print v(xbgr.mr_n86578736)
print v(xbgr.mr_n86579680)
print v(xbgr.mr_n86580624)
print v(xbgr.mr_n86581568)
print v(xbgr.mr_n86581904)
print v(xbgr.mr_n86582512)
print v(xbgr.mr_n86589952)
print v(xbgr.mr_n86590336)
print v(xbgr.mr_n86590800)
print v(xbgr.mr_n86592256)
print v(xbgr.mr_n86592640)
print v(xbgr.mr_n86593024)
print v(xbgr.mr_n86593408)
print v(xbgr.mr_n86594944)
print v(xbgr.mr_n86595328)
print v(xbgr.mr_n86595712)
print v(xbgr.mr_n86597632)
print v(xbgr.mr_n86598016)
print v(xbgr.mr_n86598400)
print v(xbgr.mr_n86599168)
print v(xbgr.mr_n86599552)
print v(xbgr.mr_n86600400)
print v(xbgr.mr_n86600992)
print v(xbgr.mr_n86601760)
print v(xbgr.mr_n86602656)
print v(xbgr.mr_n86602976)
print v(xbgr.mr_n86604352)
print v(xbgr.mr_n86605120)
print v(xbgr.mr_n86607424)
print v(xbgr.mr_n86607808)
print v(xbgr.mr_n86609984)
print v(xbgr.mr_n86610208)
print v(xbgr.mr_n86610320)
print v(xbgr.mr_n86617456)
print v(xbgr.mr_n86625648)
print v(xbgr.mr_n86626704)
print v(xbgr.mr_n86627888)
print v(xbgr.mr_n86628432)
print v(xbgr.mr_n86629712)
print v(xbgr.mr_n86631440)
print v(xbgr.mr_n86634160)
print v(xbgr.mr_n86634416)
print v(xbgr.mr_n86634672)
print v(xbgr.mr_n86636656)
print v(xbgr.mr_n86637392)
print v(xbgr.mr_n86652000)
print v(xbgr.mr_n86653184)
print v(xbgr.mr_n86653952)
print v(xbgr.mr_n86654464)
print v(xbgr.mr_n86656224)
print v(xbgr.mr_n86656448)
print v(xbgr.mr_n86656960)
print v(xbgr.mr_n86660160)
print v(xbgr.mr_n86660624)
print v(xbgr.mr_n86661088)
print v(xbgr.mr_n86661552)
print v(xbgr.mr_n86661744)
print v(xbgr.mr_n86663680)
print v(xbgr.mr_n86668608)
print v(xbgr.mr_n86668720)
print v(xbgr.mr_n86672064)
print v(xbgr.mr_n86672608)
print v(xbgr.mr_n86674048)
print v(xbgr.mr_n86674848)
print v(xbgr.mr_n86675616)
print v(xbgr.mr_n86676544)
print v(xbgr.mr_n86677344)
print v(xbgr.mr_n86680576)
print v(xbgr.mr_n86681152)
print v(xbgr.mr_n86681632)
print v(xbgr.mr_n86682304)
print v(xbgr.mr_n86682736)
print v(xbgr.mr_n86686016)
print v(xbgr.mr_n86687056)
print v(xbgr.mr_n86687456)
print v(xbgr.mr_n86690016)
print v(xbgr.mr_n86690448)
print v(xbgr.mr_n86690960)
print v(xbgr.mr_n86691072)
print v(xbgr.mr_n86691504)
print v(xbgr.mr_n86692016)
print v(xbgr.mr_n86692128)
print v(xbgr.mr_n86692560)
print v(xbgr.mr_n86693072)
print v(xbgr.mr_n86693184)
print v(xbgr.mr_n86693616)
print v(xbgr.mr_n86694128)
print v(xbgr.mr_n86694304)
print v(xbgr.mr_n86695104)
print v(xbgr.mr_n86695328)
print v(xbgr.mr_n86695440)
print v(xbgr.mr_n86695632)
print v(xbgr.mr_n86695824)
print v(xbgr.mr_n86696912)
print v(xbgr.mr_n86697312)
print v(xbgr.mr_n86697776)
print v(xbgr.mr_n86698240)
print v(xbgr.mr_n86698704)
print v(xbgr.mr_n86698896)
print v(xbgr.mr_n86699360)
print v(xbgr.mr_n86699824)
print v(xbgr.mr_n86700288)
print v(xbgr.mr_n86701232)
print v(xbgr.mr_n86702048)
print v(xbgr.mr_n86702384)
print v(xbgr.mr_n86702848)
print v(xbgr.mr_n86703792)
print v(xbgr.mr_n86704128)
print v(xbgr.mr_n86704592)
print v(xbgr.mr_n86705056)
print v(xbgr.mr_n86705728)
print v(xbgr.mr_n86706352)
print v(xbgr.mr_n86710848)
print v(xbgr.mr_n86712496)
print v(xbgr.mr_n86712960)
print v(xbgr.mr_n86713456)
print v(xbgr.mr_n86713920)
print v(xbgr.mr_n86714112)
print v(xbgr.mr_n86714400)
print v(xbgr.mr_n86714624)
print v(xbgr.mr_n86714832)
print v(xbgr.mr_n86716304)
print v(xbgr.mr_n86717968)
print v(xbgr.mr_n86718528)
print v(xbgr.mr_n86720512)
print v(xbgr.mr_n86720912)
print v(xbgr.mr_n86723648)
print v(xbgr.mr_n86723760)
print v(xbgr.mr_n86724192)
print v(xbgr.mr_n86724704)
print v(xbgr.mr_n86724816)
print v(xbgr.mr_n86725248)
print v(xbgr.mr_n86725760)
print v(xbgr.mr_n86725872)
print v(xbgr.mr_n86726304)
print v(xbgr.mr_n86726816)
print v(xbgr.mr_n86726928)
print v(xbgr.mr_n86727360)
print v(xbgr.mr_n86727872)
print v(xbgr.mr_n86727984)
print v(xbgr.mr_n86728416)
print v(xbgr.mr_n86728928)
print v(xbgr.mr_n86729040)
print v(xbgr.mr_n86729472)
print v(xbgr.mr_n86729984)
print v(xbgr.mr_n86730096)
print v(xbgr.mr_n86730528)
print v(xbgr.mr_n86731040)
print v(xbgr.mr_n86731152)
print v(xbgr.mr_n86731584)
print v(xbgr.mr_n86732096)
print v(xbgr.mr_n86732208)
print v(xbgr.mr_n86732640)
print v(xbgr.mr_n86733728)
print v(xbgr.mr_n86733840)
print v(xbgr.mr_n86734720)
print v(xbgr.mr_n86735408)
print v(xbgr.mr_n86736096)
print v(xbgr.mr_n86736784)
print v(xbgr.mr_n86737472)
print v(xbgr.mr_n86738160)
print v(xbgr.mr_n86738848)
print v(xbgr.mr_n86739536)
print v(xbgr.mr_n86740224)
print v(xbgr.mr_n86740912)
print v(xbgr.mr_n86741600)
print v(xbgr.mr_n86742288)
print v(xbgr.mr_n86742976)
print v(xbgr.mr_n86743664)
print v(xbgr.mr_n86744352)
print v(xbgr.mr_n86745040)
print v(xbgr.mr_n86745728)
print v(xbgr.mr_n86746416)
print v(xbgr.mr_n86747104)
print v(xbgr.mr_n86748176)
print v(xbgr.mr_n86749408)
print v(xbgr.mr_n86750352)
print v(xbgr.mr_n86751296)
print v(xbgr.mr_n86752240)
print v(xbgr.mr_n86753184)
print v(xbgr.mr_n86754128)
print v(xbgr.mr_n86755072)
print v(xbgr.mr_n86756016)
print v(xbgr.mr_n86756960)
print v(xbgr.mr_n86757904)
print v(xbgr.mr_n86758848)
print v(xbgr.mr_n86759792)
print v(xbgr.mr_n86760736)
print v(xbgr.mr_n86761680)
print v(xbgr.mr_n86762624)
print v(xbgr.mr_n86763568)
print v(xbgr.mr_n86764512)
print v(xbgr.mr_n86765456)
print v(xbgr.mr_n86766400)
print v(xbgr.mr_n86767344)
print v(xbgr.mr_n86768288)
print v(xbgr.mr_n86769232)
print v(xbgr.mr_n86770176)
print v(xbgr.mr_n86771120)
print v(xbgr.mr_n86772064)
print v(xbgr.mr_n86773008)
print v(xbgr.mr_n86777808)
print v(xbgr.mr_n86778064)
print v(xbgr.mr_n86778320)
print v(xbgr.mr_n86778576)
print v(xbgr.mr_n86778832)
print v(xbgr.mr_n86779088)
print v(xbgr.mr_n86779488)
print v(xbgr.mr_n86781888)
print v(xbgr.mr_n86782336)
print v(xbgr.mr_n86782528)
print v(xbgr.mr_n86782720)
print v(xbgr.mr_n86782912)
print v(xbgr.mr_n86783104)
print v(xbgr.mr_n86783296)
print v(xbgr.mr_n86783552)
print v(xbgr.mr_n86788560)
print v(xbgr.mr_n86792592)
print v(xbgr.mr_n86792768)
print v(xbgr.mr_n86795248)
print v(xbgr.mr_n86803888)
print v(xbgr.mr_n86804000)
print v(xbgr.mr_n86807600)
print v(xbgr.mr_n86808368)
print v(xbgr.mr_n86809072)
print v(xbgr.mr_n86810128)
print v(xbgr.mr_n86822096)
print v(xbgr.mr_n86823664)
print v(xbgr.mr_n86823776)
print v(xbgr.mr_n86824560)
print v(xbgr.mr_n86826992)
print v(xbgr.mr_n86828784)
print v(xbgr.mr_n86830240)
print v(xbgr.mr_n86830576)
print v(xbgr.mr_n86831248)
print v(xbgr.mr_n86831872)
print v(xbgr.mr_n86832256)
print v(xbgr.mr_n86833904)
print v(xbgr.mr_n87111456)
print v(xbgr.mr_n87112032)
print v(xbgr.mr_n87125792)
print v(xbgr.mr_n87126304)
print v(xbgr.mr_n87168384)
print v(xbgr.mr_n87169280)
print v(xbgr.mr_n87169568)
print v(xbgr.mr_n87214656)
print v(xbgr.mr_n87215552)
print v(xbgr.mr_n87244064)
print v(xbgr.mr_n87254400)
print v(xbgr.mr_n87255168)
print v(xbgr.mr_n87255680)
print v(xbgr.mr_n87272464)
print v(xbgr.mr_n87272688)
print v(xbgr.mr_n87273136)
print v(xbgr.mr_n87273616)
print v(xbgr.mr_n87342304)
print v(xbgr.mr_n87342496)
print v(xbgr.mr_n87342848)
print v(xbgr.mr_n87343040)
print v(xbgr.mr_n87343232)
print v(xbgr.mr_n87353776)
print v(xbgr.mr_n87375664)
print v(xbgr.mr_n87376112)
print v(xbgr.mr_n87391440)
print v(xbgr.mr_n87424064)
print v(xbgr.mr_n87443952)
print v(xbgr.mr_n87483872)
print v(xbgr.mr_n87497344)
print v(xbgr.mr_n87507504)
print v(xbgr.mr_n87507728)
print v(xbgr.mr_n87604816)
print v(xbgr.mr_n87618624)
print v(xbgr.mr_n87621936)
print v(xbgr.mr_n87639856)
print v(xbgr.mr_n87640784)
print v(xbgr.mr_n87692320)
print v(xbgr.mr_n87709680)
print v(xbgr.mr_n87709792)
print v(xbgr.mr_n87710688)
print v(xbgr.mr_n87711104)
print v(xbgr.mr_n87716752)
print v(xbgr.mr_n87717408)
print v(xbgr.mr_n87717680)
print v(xbgr.mr_n87717872)
print v(xbgr.mr_n87719088)
print v(xbgr.mr_n87719360)
print v(xbgr.mr_n87748864)
print v(xbgr.mr_n87750864)
print v(xbgr.mr_n87755808)
print v(xbgr.mr_n87776192)
print v(xbgr.mr_n87778960)
print v(xbgr.mr_n87780368)
print v(xbgr.mr_n87785392)
print v(xbgr.mr_n87785808)
print v(xbgr.mr_n87786608)
print v(xbgr.mr_n87793488)
print v(xbgr.mr_n87834400)
print v(xbgr.mr_n87834512)
print v(xbgr.mr_n87835456)
print v(xbgr.mr_n87845328)
print v(xbgr.mr_n87872832)
print v(xbgr.mr_n87875504)
print v(xbgr.mr_n87883008)
print v(xbgr.mr_n87883280)
print v(xbgr.mr_n87887312)
print v(xbgr.mr_n87889104)
print v(xbgr.mr_n87894864)
print v(xbgr.mr_n87895056)
print v(xbgr.mr_n87895248)
print v(xbgr.mr_n87895440)
print v(xbgr.mr_n87895632)
print v(xbgr.mr_n87926704)
print v(xbgr.mr_n87927712)
print v(xbgr.n1)
print v(xbgr.n_10)
print v(xbgr.n_11)
print v(xbgr.n_12)
print v(xbgr.n_13)
print v(xbgr.n_14)
print v(xbgr.n_15)
print v(xbgr.n_16)
print v(xbgr.n_17)
print v(xbgr.n_18)
print v(xbgr.n_19)
print v(xbgr.n_2)
print v(xbgr.n_21)
print v(xbgr.n_22)
print v(xbgr.n_23)
print v(xbgr.n_24)
print v(xbgr.n_25)
print v(xbgr.n_26)
print v(xbgr.n_27)
print v(xbgr.n_3)
print v(xbgr.n_30)
print v(xbgr.n_31)
print v(xbgr.n_33)
print v(xbgr.n_34)
print v(xbgr.n_36)
print v(xbgr.n_37)
print v(xbgr.n_4)
print v(xbgr.n_5)
print v(xbgr.n_6)
print v(xbgr.n_7)
print v(xbgr.n_8)
print v(xbgr.n_9)
print v(pbias)
print v(pcasc)
print v(r4)
print v(xbgr.r4n)
print v(xbgr.vb2)
print v(vbe)
print v(xbgr.vbe3)
print v(xbgr.vd1)
print v(xbgr.vd2)
print v(vdd)
print v(vref)
print v(vdd)-v(vdd)
echo METALLIC_ALL_NODE_VOLTAGES_END
quit
.endc
.end
