* G1_DUT schematic netlist (CDL) for LVS: one npn13G2, Nx=1, default emitter 0.07 x 0.90 um.
* Pin order of the PDK subckt npn13G2: c b e bn. Substrate (bn) is the p+ ring on VSS.
.subckt g1_dut HBT_C HBT_B HBT_E VSS
Q1 HBT_C HBT_B HBT_E VSS npn13G2 le=900e-9 we=70.0n Nx=1
.ends g1_dut
