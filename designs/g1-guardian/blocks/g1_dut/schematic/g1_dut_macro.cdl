* G1_DUT macro netlist (CDL) for LVS of layout/g1_dut_macro.gds: one npn13G2 (Nx=1) with the macro pin
* names (Metal3 stubs HBT_C, HBT_B, HBT_E on the west edge; vss = p+ substrate ring, bar on the south edge).
.subckt g1_dut_macro HBT_C HBT_B HBT_E vss
Q1 HBT_C HBT_B HBT_E vss npn13G2 le=900e-9 we=70.0n Nx=1
.ends g1_dut_macro
