* ngspice translation of raw_pex.spice
* Source SHA256 1cc4c8a02b9fd4abad1dd4eef235c6066f0d54f6bdbf7dcbf962247c22e01c0c
.SUBCKT g1_dut_macro HBT_B HBT_C HBT_E vss
XQ1 HBT_C HBT_B HBT_E vss npn13G2 we=0.07u le=0.9u Nx=1 m=1 selft=1
Cext_1 HBT_B HBT_C 1.74141e-17
Cext_2 HBT_B HBT_E 4.64742e-16
Cext_3 HBT_B vss 1.37179e-16
Cext_4 HBT_B vss 1.59689f
Cext_5 HBT_C HBT_E 1.04413f
Cext_6 HBT_C vss 1.11214e-16
Cext_7 HBT_C vss 1.22183f
Cext_8 HBT_E vss 1.29223e-16
Cext_9 HBT_E vss 2.06589f
Cext_10 vss vss 5.8822f
.ENDS g1_dut_macro
