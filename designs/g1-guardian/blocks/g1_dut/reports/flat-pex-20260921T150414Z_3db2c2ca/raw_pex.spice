*********************************************************
*** NGSPICE file created by KLayout-PEX 0.3.12
*** -----------------------------------------------------
***     Extraction Engine: KPEX/2.5D
***     Technology: ihp_sg13g2
***     Date: 2026-09-21 17:04:25
*********************************************************

.SUBCKT g1_dut_macro HBT_B HBT_C HBT_E vss
Q$1 HBT_C HBT_B HBT_E vss npn13G2 we=0.07 le=0.9 Nx=1 m=1
Cext_1 HBT_B HBT_C 17.4141a
Cext_2 HBT_B HBT_E 464.742a
Cext_3 HBT_B vss 137.179a
Cext_4 HBT_B VSUBS 1.59689f
Cext_5 HBT_C HBT_E 1.04413f
Cext_6 HBT_C vss 111.214a
Cext_7 HBT_C VSUBS 1.22183f
Cext_8 HBT_E vss 129.223a
Cext_9 HBT_E VSUBS 2.06589f
Cext_10 VSUBS vss 5.8822f
.ENDS g1_dut_macro
