* cell g1_dut_macro
* pin HBT_B
* pin HBT_C
* pin HBT_E
* pin vss
.SUBCKT g1_dut_macro 2 4 3 1
* net 1 vss
* net 2 HBT_B
* net 3 HBT_E
* net 4 HBT_C
* device instance $1 r0 *1 13.475,14.57 npn13G2
Q$1 4 2 3 1 npn13G2 we=0.07 le=0.9 Nx=1 m=1
.ENDS g1_dut_macro
