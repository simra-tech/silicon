* Extracted by KLayout with SG13G2 LVS runset on : 19/09/2026 13:09

.SUBCKT g1_dut_macro HBT_B HBT_C HBT_E vss
Q$1 HBT_C HBT_B HBT_E vss npn13G2 we=70n le=900n Nx=1 m=1
.ENDS g1_dut_macro
