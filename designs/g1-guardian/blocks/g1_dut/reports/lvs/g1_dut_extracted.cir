* Extracted by KLayout with SG13G2 LVS runset on : 18/09/2026 20:15

.SUBCKT g1_dut HBT_B HBT_C HBT_E VSS
Q$1 HBT_C HBT_B HBT_E VSS npn13G2 we=70n le=900n Nx=1 m=1
.ENDS g1_dut
