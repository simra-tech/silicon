* Streaming rawfile .tran control, not a GATE circuit
V1 in 0 pulse(0 1 0 1n 1n 5n 10n)
R1 in out 1k
C1 out 0 1p
.tran 1n 20n 0 1n
.end
