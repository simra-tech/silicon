* G1_GATE power-up: supply ramps in both orders with EN pad low, then EN high; GATE pad with 5 nF
.lib /foss/pdks/ihp-sg13g2/libs.tech/ngspice/models/cornerMOSlv.lib mos_tt
.lib /foss/pdks/ihp-sg13g2/libs.tech/ngspice/models/cornerMOShv.lib mos_tt
.lib /foss/pdks/ihp-sg13g2/libs.tech/ngspice/models/cornerRES.lib res_typ
.lib /foss/pdks/ihp-sg13g2/libs.tech/ngspice/models/cornerCAP.lib cap_typ
.lib /foss/pdks/ihp-sg13g2/libs.tech/ngspice/models/cornerDIO.lib dio_tt
.include /foss/pdks/ihp-sg13g2/libs.ref/sg13g2_io/spice/sg13g2_io.spi
.include netlist/g1_gate.spice
.temp 27
.global sub!
Vsub sub! 0 dc 0
* convergence with the IO pad model: supplies through 0.5 Ohm with 1 nF local decoupling, gear integration
.option method=gear reltol=0.005 itl4=100 abstol=1e-9 vntol=1e-5 chgtol=1e-13
Rsa vdda_s vdda 0.5
Cda vdda 0 1n
Rsd vdd_s vdd 0.5
Cdd vdd 0 1n
* @@ORDER@@ : A = IOVDD ramps 1-3 us, VDD 5-7 us; B = VDD 1-3 us, IOVDD 5-7 us; EN pad high at 9 us
Vdda vdda_s 0 pwl(@@PWLA@@)
Vdd vdd_s 0 pwl(@@PWLD@@)
* EN pad: @@ENPWL@@
Ven en_pad 0 pwl(@@ENPWL@@)
Vz trip_d 0 dc 0
Vc clr_d 0 dc 0
Vf fast_en 0 dc 0
Vh hard_cmp 0 dc 0
XPE en_pad en_core vdd 0 vdda 0 sg13g2_IOPadIn
XG trip_d clr_d fast_en hard_cmp en_core gate_core fault_core tripped vdd vdda 0 g1_gate
XPG gate gate_core vdd 0 vdda 0 sg13g2_IOPadOut30mA
* external gate network: 10 Ohm series (board gate resistor) + 5 nF
Rg gate gfet 10
Cgate gfet 0 5n
Rgate_ext gate 0 @@RPD@@
.control
set filetype=ascii
tran 5n 11u
meas tran gmax_ramps max v(gate) from=0 to=8.9u
meas tran g_end find v(gate) at=10.9u
meas tran gc_max max v(gate_core) from=0 to=8.9u
echo "POWERUP @@ORDER@@ Rpd=@@RPD@@: GATE max during ramps (EN low) =" $&gmax_ramps " gate_core max=" $&gc_max " GATE after EN high=" $&g_end
.endc
.end
