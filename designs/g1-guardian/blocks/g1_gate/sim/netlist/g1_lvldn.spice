** sch_path: /work/designs/g1-guardian/blocks/g1_gate/schematic/g1_lvldn.sch
.subckt g1_lvldn a ab y vdd vss
*.ipin a
*.ipin ab
*.opin y
*.iopin vdd
*.iopin vss
XMN1 yb a vss vss sg13_hv_nmos w=2u l=0.45u ng=1 m=1 mm_ok=1
XMN2 y ab vss vss sg13_hv_nmos w=2u l=0.45u ng=1 m=1 mm_ok=1
XMP1 y yb vdd vdd sg13_lv_pmos w=1u l=0.13u ng=1 m=1 mm_ok=1
XMP2 yb y vdd vdd sg13_lv_pmos w=1u l=0.13u ng=1 m=1 mm_ok=1
.ends
