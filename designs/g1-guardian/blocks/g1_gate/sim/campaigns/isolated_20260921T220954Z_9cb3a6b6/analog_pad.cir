* Isolated unadopted IO receiver and driver
.lib /foss/pdks/ihp-sg13g2/libs.tech/ngspice/models/cornerMOSlv.lib mos_tt
.lib /foss/pdks/ihp-sg13g2/libs.tech/ngspice/models/cornerMOShv.lib mos_tt
.lib /foss/pdks/ihp-sg13g2/libs.tech/ngspice/models/cornerRES.lib res_typ
.lib /foss/pdks/ihp-sg13g2/libs.tech/ngspice/models/cornerCAP.lib cap_typ
.lib /foss/pdks/ihp-sg13g2/libs.tech/ngspice/models/cornerDIO.lib dio_tt
.include /foss/pdks/ihp-sg13g2/libs.ref/sg13g2_io/spice/sg13g2_io.spi
.include /work/designs/g1-guardian/blocks/g1_gate/sim/campaigns/isolated_20260921T220954Z_9cb3a6b6/candidate_source.spice
.temp 27
.global sub!
Vsub sub! 0 0
.option method=gear bypass=0 reltol=1e-5 abstol=1e-14 vntol=1e-7 chgtol=1e-14 itl4=100
Va as 0 3.3
Ra as va .5
Ca va 0 1n
Vd vd 0 1.2
Vin core 0 pwl(0 0 1u 0 1.1u 1.2 4u 1.2 4.1u 0 8u 0)
Xreceiver core drive va 0 g1_io_buffer_candidate
Xpad gate drive vd 0 va 0 sg13g2_IOPadAnalog
Rg gate gfet 10
Cg gfet 0 5n
Rpd gate 0 10k
.control
set num_threads=1
set numdgt=17
set wr_singlescale
set wr_vecnames
dc Vin 0 1.2 .005
wrdata /work/designs/g1-guardian/blocks/g1_gate/sim/campaigns/isolated_20260921T220954Z_9cb3a6b6/analog_pad_dc.tsv v(core) v(xreceiver.sense) v(drive) v(gate) v(gfet) i(va) i(vin)
reset
tran 0.5n 8u 0 0.5n
wrdata /work/designs/g1-guardian/blocks/g1_gate/sim/campaigns/isolated_20260921T220954Z_9cb3a6b6/analog_pad_tran.tsv v(core) v(xreceiver.sense) v(drive) v(gate) v(gfet) i(va) i(vin)
quit 0
.endc
.end
