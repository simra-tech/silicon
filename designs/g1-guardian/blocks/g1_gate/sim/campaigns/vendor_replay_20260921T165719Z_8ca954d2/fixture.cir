* Vendor-only numerical isolation, ideal imposed observed VGS
.param ptrc1=3.25e-3 ptrc2=9.0e-6 pwidth=1.3392864 perim=2.7
.incpslt /work/build/g1_gate/vendor/CSD16340Q3.lib
.temp 27.0
.option method=gear itl4=100 reltol=0.005 abstol=1e-9 vntol=1e-5 chgtol=1e-13
Vbus bus 0 5
Rload bus load 1.25
Lload load drain 100n
Vfet drain dfet 0
XFET dfet gfet source CSD16340Q3
Rsource source 0 35m
Dfly drain bus fixture_clamp
.model fixture_clamp D(is=1n n=1 rs=0.05 tt=10n cjo=50p bv=60)
Vdrive gfet source pwl(0 6.1922469260843221e-06
+ 9.9999999999999994e-12 6.1922498191641111e-06
+ 1.9999999999999999e-11 6.192248344849047e-06
+ 3.9999999999999998e-11 6.1922472133192999e-06
+ 8.0000000000000008e-11 6.1922415864604213e-06
+ 1.5999999999999999e-10 6.1922504431886104e-06
+ 3.1999999999999998e-10 6.1922411044988336e-06
+ 6.4000000000000006e-10 6.192249929004784e-06
+ 1.2799999999999999e-09 6.1922439202012422e-06
+ 2.28e-09 6.1922482990439972e-06
+ 3.2799999999999998e-09 6.1922433761437038e-06
+ 4.2800000000000001e-09 6.1922489504507906e-06
+ 5.28e-09 6.1922448755832186e-06
+ 6.2799999999999998e-09 6.1922468099238051e-06
+ 7.2799999999999997e-09 6.1922440055343516e-06
+ 8.2800000000000004e-09 6.1922497185386358e-06
+ 9.280000000000001e-09 6.19224174555935e-06
+ 1.028e-08 6.1922508068473638e-06
+ 1.1280000000000001e-08 6.1922423509847989e-06
+ 1.228e-08 6.1922478600341949e-06
+ 1.328e-08 6.1922456204871173e-06
+ 1.4279999999999999e-08 6.1922466396131774e-06
+ 1.5280000000000008e-08 6.1922462689064467e-06
+ 1.6280000000000001e-08 6.1922446734826338e-06
+ 1.728e-08 6.1922474564026557e-06
+ 1.8279999999999999e-08 6.1922444716903588e-06
+ 1.9280000000000001e-08 6.192248314390685e-06
+ 2.028e-08 6.1922449360659306e-06
+ 2.1279999999999999e-08 6.1922449267148589e-06
+ 2.2280000000000002e-08 6.1922493334251918e-06
+ 2.3280000000000001e-08 6.1922423063979443e-06
+ 2.428e-08 6.1922470053049013e-06
+ 2.5279999999999999e-08 6.1922491376889931e-06
+ 2.6279999999999991e-08 6.1922415926813388e-06
+ 2.727999999999999e-08 6.1922509710456052e-06
+ 2.8279999999999989e-08 6.1922448255166249e-06
+ 2.9279999999999992e-08 6.1922454960927946e-06
+ 3.0279999999999991e-08 6.1922474610171133e-06
+ 3.1279999999999993e-08 6.1922468854002556e-06
+ 3.2280000000000002e-08 6.1922443895417781e-06
+ 3.3279999999999998e-08 6.1922507764816934e-06
+ 3.428e-08 6.1922426510406174e-06
+ 3.5280000000000002e-08 6.1922508009651426e-06
+ 3.6279999999999998e-08 6.192243071130559e-06
+ 3.7280000000000007e-08 6.1922481423260079e-06
+ 3.8280000000000009e-08 6.1922493199790528e-06
+ 3.9280000000000012e-08 6.192242646030066e-06
+ 4.0280000000000007e-08 6.1922500681851348e-06
+ 4.1280000000000023e-08 6.1922462136232896e-06
+ 4.2280000000000019e-08 6.1922449436214476e-06
+ 4.3280000000000021e-08 6.1922520106787514e-06
+ 4.4280000000000023e-08 6.1922403551689574e-06
+ 4.5280000000000032e-08 6.1922538632003081e-06
+ 4.6280000000000028e-08 6.1922406928409618e-06
+ 4.728000000000003e-08 6.192251216522511e-06
+ 4.8280000000000033e-08 6.1922464397899821e-06
+ 4.9280000000000028e-08 6.192243837980817e-06
+ 5.0280000000000037e-08 6.1922524880061804e-06
+ 5.128000000000004e-08 6.1922412090917189e-06
+ 5.2280000000000042e-08 6.1922510946783182e-06
+ 5.3280000000000038e-08 6.1922468094605602e-06
+ 5.4280000000000053e-08 6.1922433079221151e-06
+ 5.5280000000000049e-08 6.1922532028991393e-06
+ 5.6280000000000051e-08 6.1922391646021328e-06
+ 5.7280000000000047e-08 6.192253822232239e-06
+ 5.8280000000000063e-08 6.192241463924865e-06
+ 5.9280000000000058e-08 6.1922493398529216e-06
+ 6.0280000000000061e-08 6.1922468854784189e-06
+ 6.1280000000000056e-08 6.1922429854185717e-06
+ 6.2280000000000052e-08 6.1922511453212187e-06
+ 6.3280000000000048e-08 6.1922414677205247e-06
+ 6.4280000000000044e-08 6.1922505975194559e-06
+ 6.5280000000000039e-08 6.1922436647037181e-06
+ 6.6280000000000035e-08 6.1922452837990797e-06
+ 6.7280000000000031e-08 6.1922506370100301e-06
+ 6.8280000000000026e-08 6.1922394988008278e-06
+ 6.9280000000000022e-08 6.1922546317349182e-06
+ 7.0280000000000018e-08 6.1922380885341109e-06
+ 7.1280000000000014e-08 6.1922514351785894e-06
+ 7.2280000000000009e-08 6.1922445513883258e-06
+ 7.3280000000000005e-08 6.1922443477897259e-06
+ 7.4280000000000001e-08 6.192251037391531e-06
+ 7.5279999999999996e-08 6.1922401477379002e-06
+ 7.6279999999999992e-08 6.1922522917416703e-06
+ 7.7279999999999988e-08 6.1922417461901752e-06
+ 7.8279999999999984e-08 6.192248425591088e-06
+ 7.9279999999999979e-08 6.1922470798949657e-06
+ 8.0279999999999975e-08 6.1922428159699321e-06
+ 8.1279999999999971e-08 6.1922550405319167e-06
+ 8.2279999999999967e-08 6.19223703572497e-06
+ 8.3279999999999962e-08 6.1922547749017094e-06
+ 8.4279999999999958e-08 6.1922432505954529e-06
+ 8.5279999999999954e-08 6.1922472364803647e-06
+ 8.6279999999999949e-08 6.1922523523080607e-06
+ 8.7279999999999945e-08 6.1922397266132121e-06
+ 8.8279999999999941e-08 6.1922558402946987e-06
+ 8.9279999999999937e-08 6.1922409492643429e-06
+ 9.0279999999999932e-08 6.1922520144450131e-06
+ 9.1279999999999928e-08 6.1922455123604266e-06
+ 9.2279999999999924e-08 6.1922456824112066e-06
+ 9.3279999999999919e-08 6.1922551918949231e-06
+ 9.4279999999999915e-08 6.192236424161573e-06
+ 9.5279999999999911e-08 6.1922576020725383e-06
+ 9.6279999999999907e-08 6.1922420595143658e-06
+ 9.7279999999999902e-08 6.1922466049125178e-06
+ 9.8279999999999898e-08 6.1922545697848724e-06
+ 9.9279999999999894e-08 6.1922369654583608e-06
+ 1.002799999999999e-07 6.192257999413041e-06
+ 1.012799999999999e-07 6.19224013660749e-06
+ 1.0227999999999989e-07 6.1922503568151488e-06
+ 1.032799999999999e-07 6.1922489235164278e-06
+ 1.042799999999999e-07 6.1922409440610144e-06
+ 1.0527999999999989e-07 6.1922562329944442e-06
+ 1.062799999999999e-07 6.1922376576859979e-06
+ 1.072799999999999e-07 6.1922551044884854e-06
+ 1.0827999999999989e-07 6.1922430271086914e-06
+ 1.092799999999999e-07 6.1922442145533796e-06
+ 1.1027999999999979e-07 6.1922551764873997e-06
+ 1.112799999999998e-07 6.1922370896998609e-06
+ 1.122799999999998e-07 6.1922572043077272e-06
+ 1.1327999999999979e-07 6.1922392911460921e-06
+ 1.142799999999998e-07 6.1922512412369037e-06
+ 1.152799999999998e-07 6.1922478674385944e-06
+ 1.1627999999999979e-07 6.1922396205764279e-06
+ 1.172799999999998e-07 6.1922586148252473e-06
+ 1.182799999999998e-07 6.1922356679694331e-06
+ 1.1927999999999981e-07 6.1922553162328113e-06
+ 1.202799999999998e-07 6.1922438202022214e-06
+ 1.212799999999998e-07 6.1922437012311661e-06
+ 1.222799999999998e-07 6.1922549391819199e-06
+ 1.2327999999999979e-07 6.1922356113820799e-06
+ 1.2427999999999981e-07 6.1922567686432697e-06
+ 1.2527999999999981e-07 6.1922397518855616e-06
+ 1.262799999999998e-07 6.1922462179661834e-06
+ 1.272799999999998e-07 6.1922529875337754e-06
+ 1.282799999999998e-07 6.1922365708033558e-06
+ 1.2927999999999979e-07 6.1922552304894364e-06
+ 1.3027999999999979e-07 6.1922379744631344e-06
+ 1.3127999999999981e-07 6.1922484006912992e-06
+ 1.3227999999999981e-07 6.1922493625614963e-06
+ 1.332799999999997e-07 6.1922390120054662e-06
+ 1.3427999999999969e-07 6.1922526488192801e-06
+ 1.3527999999999971e-07 6.1922406485671367e-06
+ 1.3627999999999971e-07 6.1922475983885677e-06
+ 1.372799999999997e-07 6.1922473549316907e-06
+ 1.382799999999997e-07 6.1922408481079964e-06
+ 1.392799999999997e-07 6.1922521818223276e-06
+ 1.4027999999999969e-07 6.1922412553054774e-06
+ 1.4127999999999969e-07 6.1922488032146304e-06
+ 1.4227999999999971e-07 6.1922447489831214e-06
+ 1.4327999999999971e-07 6.1922470097603242e-06
+ 1.442799999999997e-07 6.1922460682884346e-06
+ 1.452799999999997e-07 6.1922468673103237e-06
+ 1.4627999999999969e-07 6.1922485109279117e-06
+ 1.4727999999999969e-07 6.1922429066626391e-06
+ 1.4827999999999971e-07 6.1922517598747682e-06
+ 1.4927999999999971e-07 6.192245108254776e-06
+ 1.502799999999997e-07 6.1922459578461897e-06
+ 1.512799999999997e-07 6.1922521525690791e-06
+ 1.5227999999999969e-07 6.1922419111280552e-06
+ 1.5327999999999969e-07 6.1922532392197274e-06
+ 1.5427999999999971e-07 6.1922434364436278e-06
+ 1.5527999999999971e-07 6.1922504626233231e-06
+ 1.562799999999996e-07 6.1922474653292852e-06
+ 1.5727999999999959e-07 6.1922467290293067e-06
+ 1.5827999999999959e-07 6.1922492666871906e-06
+ 1.5927999999999961e-07 6.19224649865108e-06
+ 1.6027999999999961e-07 6.1922498227115486e-06
+ 1.612799999999996e-07 6.192245784929106e-06
+ 1.622799999999996e-07 6.1922484776005406e-06
+ 1.6327999999999959e-07 6.1922497543415191e-06
+ 1.6427999999999959e-07 6.1922430666714912e-06
+ 1.6527999999999961e-07 6.1922532268235747e-06
+ 1.6627999999999961e-07 6.1922416732006956e-06
+ 1.672799999999996e-07 6.1922514990769092e-06
+ 1.682799999999996e-07 6.1922455977245146e-06
+ 1.6927999999999959e-07 6.1922468639597282e-06
+ 1.7027999999999959e-07 6.1922488323732848e-06
+ 1.7127999999999961e-07 6.1922436230140219e-06
+ 1.7227999999999961e-07 6.1922501212809064e-06
+ 1.732799999999996e-07 6.1922444325453071e-06
+ 1.742799999999996e-07 6.1922483005984839e-06
+ 1.7527999999999959e-07 6.1922482628185334e-06
+ 1.7627999999999959e-07 6.192240526549109e-06
+ 1.7727999999999961e-07 6.1922543507396688e-06
+ 1.7827999999999961e-07 6.1922400146126516e-06
+ 1.792799999999996e-07 6.1922499342419209e-06
+ 1.8027999999999949e-07 6.1922468026847973e-06
+ 1.8127999999999949e-07 6.1922425656298417e-06
+ 1.8227999999999951e-07 6.1922507893321302e-06
+ 1.8327999999999951e-07 6.1922429188278246e-06
+ 1.842799999999995e-07 6.1922497603281438e-06
+ 1.852799999999995e-07 6.1922447495768254e-06
+ 1.8627999999999949e-07 6.1922462041481123e-06
+ 1.8727999999999949e-07 6.1922495710881034e-06
+ 1.8827999999999951e-07 6.1922422047014432e-06
+ 1.8927999999999951e-07 6.1922515831939242e-06
+ 1.902799999999995e-07 6.1922422636755302e-06
+ 1.912799999999995e-07 6.1922482674046476e-06
+ 1.922799999999995e-07 6.1922485957264773e-06
+ 1.9327999999999949e-07 6.192242579200952e-06
+ 1.9427999999999949e-07 6.1922495549114521e-06
+ 1.9527999999999951e-07 6.1922438866420179e-06
+ 1.9627999999999951e-07 6.1922493387998818e-06
+ 1.972799999999995e-07 6.1922442788513508e-06
+ 1.982799999999995e-07 6.1922464191521743e-06
+ 1.991399999999997e-07 6.1922500289080426e-06
+ 1.9999999999999999e-07 6.1922421515652538e-06
+ 2.001e-07 6.192710695653599e-06
+ 2.0029999999999999e-07 6.1920472106865364e-06
+ 2.0069999999999999e-07 6.1929606798153887e-06
+ 2.0135000000000001e-07 6.1895599607675953e-06
+ 2.0200000000000001e-07 6.1883060778300614e-06
+ 2.0209999999999999e-07 6.1855292223710223e-06
+ 2.023e-07 6.1872621019724206e-06
+ 2.0270000000000001e-07 6.18062357443992e-06
+ 2.0349999999999999e-07 6.1850460575209818e-06
+ 2.0450000000000001e-07 6.0142981077882194e-06
+ 2.0550000000000001e-07 -3.7464007556711583e-05
+ 2.065e-07 0.0011493135047771249
+ 2.075e-07 0.038073915958624277
+ 2.0849999999999999e-07 0.042458185251133929
+ 2.0949999999999999e-07 0.066156720980360476
+ 2.1050000000000001e-07 0.080326539338336653
+ 2.1150000000000001e-07 0.1040378210756368
+ 2.125e-07 0.1196954264575633
+ 2.135e-07 0.1432504509834516
+ 2.145e-07 0.15814893625018919
+ 2.1549999999999999e-07 0.18264112032881161
+ 2.1650000000000001e-07 0.1967591908210933
+ 2.1750000000000001e-07 0.22121774460484139
+ 2.185e-07 0.23611086368095871
+ 2.195e-07 0.25892596293564257
+ 2.205e-07 0.27569816120498181
+ 2.2149999999999999e-07 0.2966290549304445
+ 2.2249999999999999e-07 0.31455413446124247
+ 2.2350000000000001e-07 0.33506403267491791
+ 2.2450000000000001e-07 0.35237676692226838
+ 2.254999999999999e-07 0.37398730016663168
+ 2.2649999999999989e-07 0.38984863301827671
+ 2.2749999999999991e-07 0.41248097832996239
+ 2.2849999999999991e-07 0.42781651649292413
+ 2.294999999999999e-07 0.45000931740950401
+ 2.304999999999999e-07 0.46633704924645852
+ 2.314999999999999e-07 0.48697480471961663
+ 2.3249999999999989e-07 0.50467593503820363
+ 2.3349999999999989e-07 0.52418801661664538
+ 2.3449999999999991e-07 0.54217442917838732
+ 2.3549999999999991e-07 0.56194297523250425
+ 2.364999999999999e-07 0.57894389793737766
+ 2.374999999999999e-07 0.59974332623986992
+ 2.3849999999999992e-07 0.61565992607300801
+ 2.3949999999999989e-07 0.63688652588379491
+ 2.4050000000000002e-07 0.65278640526797549
+ 2.4149999999999999e-07 0.67318075483751838
+ 2.4250000000000001e-07 0.69010362325294528
+ 2.4349999999999998e-07 0.70904165157387311
+ 2.445000000000001e-07 0.72696201197567212
+ 2.4550000000000007e-07 0.74496201213126489
+ 2.465000000000001e-07 0.76288824982321779
+ 2.4750000000000012e-07 0.78096313178400401
+ 2.4850000000000009e-07 0.79789467633201139
+ 2.4950000000000022e-07 0.81653241338447968
+ 2.5050000000000019e-07 0.83225364081169428
+ 2.5150000000000021e-07 0.85099076865988876
+ 2.5250000000000018e-07 0.86604330386580453
+ 2.535000000000003e-07 0.8838522841906199
+ 2.5450000000000027e-07 0.89890496173339085
+ 2.555000000000003e-07 0.9149060328944898
+ 2.5650000000000032e-07 0.93011593221585742
+ 2.5750000000000029e-07 0.94406871165473105
+ 2.5850000000000042e-07 0.95889117862279816
+ 2.5950000000000038e-07 0.97117457990259914
+ 2.6050000000000041e-07 0.98470374168864516
+ 2.6150000000000038e-07 0.99593179869130632
+ 2.625000000000005e-07 1.007461236565802
+ 2.6350000000000047e-07 1.0180434527061539
+ 2.645000000000005e-07 1.027484651181293
+ 2.6550000000000052e-07 1.037416707538074
+ 2.6650000000000049e-07 1.045325450035778
+ 2.6750000000000062e-07 1.054295650702703
+ 2.6850000000000058e-07 1.061547017608202
+ 2.6950000000000061e-07 1.06923035882113
+ 2.7050000000000058e-07 1.076583056031533
+ 2.715000000000007e-07 1.0829148589109781
+ 2.7250000000000073e-07 1.090710942403563
+ 2.735000000000007e-07 1.0959893173160971
+ 2.7450000000000072e-07 1.1041057467731881
+ 2.7550000000000069e-07 1.108892245703601
+ 2.7650000000000081e-07 1.11691236447036
+ 2.7750000000000078e-07 1.1218052696534391
+ 2.7850000000000081e-07 1.1292878171640071
+ 2.7950000000000078e-07 1.134689044342063
+ 2.805000000000009e-07 1.141398475769402
+ 2.8150000000000093e-07 1.147378447177072
+ 2.825000000000009e-07 1.153385171525966
+ 2.8350000000000092e-07 1.1596924787388949
+ 2.8450000000000089e-07 1.1653224340969459
+ 2.8550000000000101e-07 1.171518846173863
+ 2.8650000000000098e-07 1.177196183848328
+ 2.8750000000000101e-07 1.1828502133017009
+ 2.8850000000000098e-07 1.18891229521329
+ 2.895000000000011e-07 1.193770552347587
+ 2.9050000000000113e-07 1.200333454058913
+ 2.9150000000000109e-07 1.2044076438655369
+ 2.9250000000000112e-07 1.211329912569669
+ 2.9350000000000109e-07 1.214876234360309
+ 2.9450000000000121e-07 1.22182506751225
+ 2.9550000000000118e-07 1.2252347473365981
+ 2.9650000000000121e-07 1.2318200185451471
+ 2.9750000000000118e-07 1.2354694503015851
+ 2.985000000000013e-07 1.2413901442639379
+ 2.9950000000000133e-07 1.245508068999563
+ 3.0050000000000129e-07 1.250657264329408
+ 3.0150000000000132e-07 1.2552544252816651
+ 3.0250000000000129e-07 1.2597492109219419
+ 3.0350000000000141e-07 1.2646299784504149
+ 3.0450000000000138e-07 1.268762468997886
+ 3.0550000000000141e-07 1.273609219752865
+ 3.0650000000000137e-07 1.2777446350903581
+ 3.075000000000014e-07 1.282247501370277
+ 3.0850000000000152e-07 1.2867205206127099
+ 3.0950000000000149e-07 1.2907209894261971
+ 3.1050000000000152e-07 1.295761061335762
+ 3.1150000000000149e-07 1.299305261417232
+ 3.1250000000000161e-07 1.304928009333906
+ 3.1350000000000158e-07 1.3082092223134729
+ 3.1450000000000161e-07 1.3142412438963771
+ 3.1550000000000157e-07 1.317602716369187
+ 3.165000000000016e-07 1.323825943232998
+ 3.1750000000000172e-07 1.3277267816420599
+ 3.1850000000000169e-07 1.334134424013752
+ 3.1950000000000172e-07 1.3396358803825781
+ 3.2050000000000169e-07 1.3480292084828751
+ 3.2150000000000181e-07 1.3572539107032511
+ 3.2250000000000178e-07 1.3667657555483379
+ 3.235000000000018e-07 1.3769501714074941
+ 3.2450000000000177e-07 1.3862722479863741
+ 3.255000000000018e-07 1.3966152088984189
+ 3.2650000000000192e-07 1.405756503411441
+ 3.2750000000000189e-07 1.416003592718057
+ 3.2850000000000192e-07 1.4252170389323531
+ 3.2950000000000189e-07 1.4351145602484821
+ 3.3050000000000201e-07 1.444610313387819
+ 3.3150000000000198e-07 1.4540085048546101
+ 3.32500000000002e-07 1.463870526121074
+ 3.3350000000000197e-07 1.4727664811475609
+ 3.34500000000002e-07 1.482924847912336
+ 3.3550000000000212e-07 1.4914598769960761
+ 3.3650000000000209e-07 1.501717384803656
+ 3.3750000000000212e-07 1.5101281654295959
+ 3.3850000000000208e-07 1.520227631429969
+ 3.3950000000000221e-07 1.52876756773344
+ 3.4050000000000218e-07 1.538476504597788
+ 3.415000000000022e-07 1.5473333810140011
+ 3.4250000000000217e-07 1.5565183440131229
+ 3.435000000000022e-07 1.5657549481409301
+ 3.4450000000000232e-07 1.574421996807595
+ 3.4550000000000229e-07 1.5839582947433091
+ 3.4650000000000232e-07 1.592247510764887
+ 3.4750000000000228e-07 1.601889089069692
+ 3.4850000000000241e-07 1.610026156209645
+ 3.4950000000000238e-07 1.619528625447165
+ 3.505000000000024e-07 1.627750184519515
+ 3.5150000000000243e-07 1.6368979350645441
+ 3.525000000000024e-07 1.6453754040685149
+ 3.5350000000000252e-07 1.654049054912238
+ 3.5450000000000249e-07 1.662835434040046
+ 3.5550000000000251e-07 1.671046628463712
+ 3.5650000000000248e-07 1.680062761435261
+ 3.5750000000000261e-07 1.687946026096627
+ 3.5850000000000258e-07 1.697009662846366
+ 3.595000000000026e-07 1.704775116996764
+ 3.6050000000000263e-07 1.713662278228925
+ 3.615000000000026e-07 1.7215254501408199
+ 3.6250000000000272e-07 1.7300435046456091
+ 3.6350000000000269e-07 1.7381554166675299
+ 3.6450000000000271e-07 1.746204088730116
+ 3.6550000000000268e-07 1.7546040441283921
+ 3.6650000000000281e-07 1.7622051054449079
+ 3.6750000000000278e-07 1.770810695047802
+ 3.685000000000028e-07 1.7780976879430761
+ 3.6950000000000283e-07 1.786734177547864
+ 3.7050000000000279e-07 1.793906589503075
+ 3.7150000000000292e-07 1.802365146449137
+ 3.7250000000000289e-07 1.809622740137703
+ 3.7350000000000291e-07 1.8177280006815619
+ 3.7450000000000288e-07 1.825206925669564
+ 3.7550000000000301e-07 1.8328719636699411
+ 3.7650000000000298e-07 1.840603087212711
+ 3.77500000000003e-07 1.8478545151695409
+ 3.7850000000000303e-07 1.8557566959361811
+ 3.7950000000000299e-07 1.862722706140528
+ 3.8050000000000312e-07 1.8706321609089589
+ 3.8150000000000309e-07 1.8774984062907349
+ 3.8250000000000311e-07 1.8852237126571421
+ 3.8350000000000308e-07 1.8921720957297441
+ 3.8450000000000321e-07 1.899556459290205
+ 3.8550000000000318e-07 1.9067069378698489
+ 3.865000000000032e-07 1.913677560610191
+ 3.8750000000000323e-07 1.9210515247157021
+ 3.8850000000000319e-07 1.9276406361084331
+ 3.8950000000000332e-07 1.935156954110629
+ 3.9050000000000329e-07 1.9414885995586171
+ 3.9150000000000331e-07 1.9489926383489391
+ 3.9250000000000328e-07 1.955240462718224
+ 3.9350000000000341e-07 1.962555815374925
+ 3.9450000000000338e-07 1.9688862139656
+ 3.955000000000034e-07 1.9758719004446059
+ 3.9650000000000342e-07 1.982391169382516
+ 3.9750000000000339e-07 1.988985835663913
+ 3.9850000000000352e-07 1.9957081196030859
+ 3.9950000000000349e-07 2.0019474734113309
+ 4.0050000000000351e-07 2.0087931505646748
+ 4.0150000000000348e-07 2.0147958486952762
+ 4.0250000000000361e-07 2.0216199636875132
+ 4.0350000000000358e-07 2.027547404661453
+ 4.045000000000036e-07 2.03418815629378
+ 4.0550000000000362e-07 2.0401918175072491
+ 4.0650000000000359e-07 2.0465229924164241
+ 4.0750000000000372e-07 2.0526965259313141
+ 4.0850000000000369e-07 2.058666991737037
+ 4.0950000000000371e-07 2.0650182530915719
+ 4.1050000000000368e-07 2.0706662721491411
+ 4.1150000000000381e-07 2.0771176248612302
+ 4.1250000000000378e-07 2.0825561702514519
+ 4.135000000000038e-07 2.088972115971703
+ 4.1450000000000382e-07 2.0943507570731059
+ 4.1550000000000379e-07 2.1005832346401259
+ 4.1650000000000392e-07 2.10603948033854
+ 4.1750000000000389e-07 2.1119758224561922
+ 4.1850000000000391e-07 2.1175917885746638
+ 4.1950000000000388e-07 2.1231899315578828
+ 4.2050000000000401e-07 2.1289680160158122
+ 4.2150000000000398e-07 2.134268099473533
+ 4.22500000000004e-07 2.140132859555429
+ 4.2350000000000402e-07 2.1452422262488442
+ 4.2450000000000399e-07 2.151067062769159
+ 4.2550000000000412e-07 2.156124256468523
+ 4.2650000000000409e-07 2.1617736285858231
+ 4.2750000000000411e-07 2.166903524547811
+ 4.2850000000000408e-07 2.1722767423868561
+ 4.2950000000000421e-07 2.1775514063206431
+ 4.3050000000000418e-07 2.1826139713641068
+ 4.315000000000042e-07 2.1880315676791651
+ 4.3250000000000422e-07 2.1928244358014068
+ 4.3350000000000419e-07 2.198312366706316
+ 4.3450000000000432e-07 2.202936850991454
+ 4.3550000000000429e-07 2.2083773838880889
+ 4.3650000000000431e-07 2.212961259544767
+ 4.3750000000000428e-07 2.2182307760337459
+ 4.3850000000000441e-07 2.2228869782860059
+ 4.3950000000000438e-07 2.2278959033202268
+ 4.405000000000044e-07 2.2326872232062822
+ 4.4150000000000442e-07 2.2374078736077321
+ 4.4250000000000439e-07 2.2423287311539242
+ 4.4350000000000452e-07 2.2468025693875249
+ 4.4450000000000449e-07 2.2517831547023501
+ 4.4550000000000451e-07 2.256105765620616
+ 4.4650000000000448e-07 2.261036540233905
+ 4.4750000000000461e-07 2.265325806052767
+ 4.4850000000000458e-07 2.270093924415594
+ 4.495000000000046e-07 2.274452063369953
+ 4.5050000000000462e-07 2.2789777328791541
+ 4.5150000000000459e-07 2.2834594953860901
+ 4.5250000000000472e-07 2.2877206824539882
+ 4.5350000000000469e-07 2.292317656117576
+ 4.5450000000000471e-07 2.296355619499741
+ 4.5550000000000468e-07 2.301001150937898
+ 4.5650000000000481e-07 2.3049056284177429
+ 4.5750000000000478e-07 2.309498157592238
+ 4.585000000000048e-07 2.313377554835939
+ 4.5950000000000482e-07 2.3178143558901509
+ 4.6050000000000479e-07 2.3217609019576981
+ 4.6150000000000492e-07 2.3259711548876418
+ 4.6250000000000489e-07 2.330032285338548
+ 4.6350000000000491e-07 2.3339989586954868
+ 4.6450000000000488e-07 2.3381638542107428
+ 4.6550000000000501e-07 2.341927770487962
+ 4.6650000000000498e-07 2.346132872715831
+ 4.67500000000005e-07 2.3497782111602201
+ 4.6850000000000502e-07 2.353929371663511
+ 4.6950000000000499e-07 2.3575558013055709
+ 4.7050000000000512e-07 2.3615594920135212
+ 4.7150000000000509e-07 2.3652502269180768
+ 4.7250000000000511e-07 2.3690435879397032
+ 4.7350000000000508e-07 2.372839668083202
+ 4.7450000000000521e-07 2.37640985610859
+ 4.7550000000000518e-07 2.3802986546088598
+ 4.765000000000052e-07 2.3836856593601712
+ 4.7750000000000517e-07 2.3876068366931009
+ 4.7850000000000514e-07 2.3908893799924722
+ 4.7950000000000511e-07 2.394755848262319
+ 4.8050000000000508e-07 2.398025380886228
+ 4.8150000000000505e-07 2.4017521357871008
+ 4.8250000000000502e-07 2.4050835826384351
+ 4.8350000000000498e-07 2.408614976628038
+ 4.8450000000000495e-07 2.412043647935918
+ 4.8550000000000492e-07 2.4153704673334011
+ 4.8650000000000489e-07 2.418882297506082
+ 4.8750000000000486e-07 2.4220435215552958
+ 4.8850000000000483e-07 2.4255813306039631
+ 4.895000000000048e-07 2.428650487531077
+ 4.9050000000000477e-07 2.4321337740476081
+ 4.9150000000000474e-07 2.4351947164466461
+ 4.9250000000000471e-07 2.4385462598388239
+ 4.9350000000000468e-07 2.4416664008151372
+ 4.9450000000000465e-07 2.444836991469062
+ 4.9550000000000462e-07 2.4480466014964839
+ 4.9650000000000458e-07 2.4510300835898922
+ 4.9750000000000455e-07 2.4543140510371639
+ 4.9850000000000452e-07 2.4571481899555421
+ 4.9950000000000449e-07 2.4604524811014419
+ 5.0050000000000446e-07 2.4632058197576101
+ 5.0150000000000443e-07 2.466456124991546
+ 5.025000000000044e-07 2.4692054484425721
+ 5.0350000000000437e-07 2.4723317003301708
+ 5.0450000000000434e-07 2.4751375739208021
+ 5.0550000000000431e-07 2.4780963503112359
+ 5.0650000000000428e-07 2.480984577425974
+ 5.0750000000000425e-07 2.4837723247021888
+ 5.0850000000000422e-07 2.486727041741287
+ 5.0950000000000419e-07 2.4893801951695642
+ 5.1050000000000415e-07 2.4923504393494138
+ 5.1150000000000412e-07 2.4949328099577071
+ 5.1250000000000409e-07 2.497850050345038
+ 5.1350000000000406e-07 2.5004318887914478
+ 5.1450000000000403e-07 2.503232600063412
+ 5.15500000000004e-07 2.5058682593238371
+ 5.1650000000000397e-07 2.5085141974877958
+ 5.1750000000000394e-07 2.5112255464049351
+ 5.1850000000000391e-07 2.5137153458828339
+ 5.1950000000000388e-07 2.516486032610076
+ 5.2050000000000385e-07 2.5188547047241419
+ 5.2150000000000382e-07 2.5216367575031851
+ 5.2250000000000379e-07 2.5239436268833648
+ 5.2350000000000375e-07 2.5266739073992941
+ 5.2450000000000372e-07 2.528983185092009
+ 5.2550000000000369e-07 2.5316041521403019
+ 5.2650000000000366e-07 2.5339645561426272
+ 5.2750000000000363e-07 2.5364425988188581
+ 5.285000000000036e-07 2.5388725358736259
+ 5.2950000000000357e-07 2.5412081191569542
+ 5.3050000000000354e-07 2.5436909689973888
+ 5.3150000000000351e-07 2.545917619234757
+ 5.3250000000000348e-07 2.5484083065615408
+ 5.3350000000000345e-07 2.5505811077002689
+ 5.3450000000000342e-07 2.5530215189982681
+ 5.3550000000000339e-07 2.5551991065232258
+ 5.3650000000000335e-07 2.5575371712201531
+ 5.3750000000000332e-07 2.559763154875605
+ 5.3850000000000329e-07 2.561969406402421
+ 5.3950000000000326e-07 2.564259149318405
+ 5.4050000000000323e-07 2.5663355764823228
+ 5.415000000000032e-07 2.5686723692523592
+ 5.4250000000000317e-07 2.5706509829491591
+ 5.4350000000000314e-07 2.5729925364521131
+ 5.4450000000000311e-07 2.5749244287218089
+ 5.4550000000000308e-07 2.577217298225138
+ 5.4650000000000305e-07 2.5791559706940239
+ 5.4750000000000302e-07 2.5813530755169372
+ 5.4850000000000299e-07 2.5833375190843588
+ 5.4950000000000296e-07 2.585413088593707
+ 5.5050000000000292e-07 2.5874560040579881
+ 5.5150000000000289e-07 2.5894132765871261
+ 5.5250000000000286e-07 2.5914980222714998
+ 5.5350000000000283e-07 2.5933674746760582
+ 5.545000000000028e-07 2.59545443927095
+ 5.5550000000000277e-07 2.5972834060994749
+ 5.5650000000000274e-07 2.5993234853449052
+ 5.5750000000000271e-07 2.601160738284733
+ 5.5850000000000268e-07 2.603111407343305
+ 5.5950000000000265e-07 2.6049917568196181
+ 5.6050000000000262e-07 2.6068305456450278
+ 5.6150000000000259e-07 2.6087643611258242
+ 5.6250000000000256e-07 2.6104955284868812
+ 5.6350000000000252e-07 2.6124663565981092
+ 5.6450000000000249e-07 2.6141188529349551
+ 5.6550000000000246e-07 2.6160896377265699
+ 5.6650000000000243e-07 2.617707277078356
+ 5.675000000000024e-07 2.6196329353475911
+ 5.6850000000000237e-07 2.6212601454261422
+ 5.6950000000000234e-07 2.6231022993311108
+ 5.7050000000000231e-07 2.62477011959805
+ 5.7150000000000228e-07 2.6265092341288931
+ 5.7250000000000225e-07 2.6282260067554111
+ 5.7350000000000222e-07 2.6298671536222811
+ 5.7450000000000219e-07 2.6316167207785259
+ 5.7550000000000216e-07 2.6331873352881798
+ 5.7650000000000212e-07 2.6349350811901009
+ 5.7750000000000209e-07 2.6364756759305581
+ 5.7850000000000206e-07 2.6381802469482092
+ 5.7950000000000203e-07 2.6397312555372152
+ 5.80500000000002e-07 2.6413580539876231
+ 5.8150000000000197e-07 2.6429471093591932
+ 5.8250000000000194e-07 2.644479214879492
+ 5.8350000000000191e-07 2.6461128936462019
+ 5.8450000000000188e-07 2.6475560200838379
+ 5.8550000000000185e-07 2.6492185382122262
+ 5.8650000000000182e-07 2.65059863667374
+ 5.8750000000000179e-07 2.6522576936185911
+ 5.8850000000000176e-07 2.653612194043109
+ 5.8950000000000173e-07 2.6552298833967449
+ 5.9050000000000169e-07 2.6565955585892089
+ 5.9150000000000166e-07 2.6581407176156882
+ 5.9250000000000163e-07 2.6595421341030581
+ 5.935000000000016e-07 2.661000160679531
+ 5.9450000000000157e-07 2.6624423699995918
+ 5.9550000000000154e-07 2.6638194651305191
+ 5.9650000000000151e-07 2.6652871264949738
+ 5.9750000000000148e-07 2.6666077881757611
+ 5.9850000000000145e-07 2.6680708000354132
+ 5.9950000000000142e-07 2.6693695766467558
+ 6.0050000000000139e-07 2.6707932228631872
+ 6.0150000000000136e-07 2.6721035277395768
+ 6.0250000000000133e-07 2.673459771257908
+ 6.0350000000000129e-07 2.674803406607853
+ 6.0450000000000126e-07 2.6760797042392559
+ 6.0550000000000123e-07 2.6774604027512701
+ 6.065000000000012e-07 2.678663316416396
+ 6.0750000000000117e-07 2.6800662279076151
+ 6.0850000000000114e-07 2.6812188473668388
+ 6.0950000000000111e-07 2.682615947404551
+ 6.1050000000000108e-07 2.6837501377566801
+ 6.1150000000000105e-07 2.6851096532630332
+ 6.1250000000000102e-07 2.686255753961964
+ 6.1350000000000099e-07 2.6875524835193931
+ 6.1450000000000096e-07 2.6887298134807431
+ 6.1550000000000093e-07 2.689953033530637
+ 6.1650000000000089e-07 2.6911641954761851
+ 6.1750000000000086e-07 2.6923207147850499
+ 6.1850000000000083e-07 2.6935513903655992
+ 6.195000000000008e-07 2.6946629338913648
+ 6.2050000000000077e-07 2.6958870626093669
+ 6.2150000000000074e-07 2.69698299419629
+ 6.2250000000000071e-07 2.6981715210582098
+ 6.2350000000000068e-07 2.6992793644433308
+ 6.2450000000000065e-07 2.7004096637624362
+ 6.2550000000000062e-07 2.7015465041272479
+ 6.2650000000000059e-07 2.702609462685901
+ 6.2750000000000056e-07 2.7037769344094071
+ 6.2850000000000053e-07 2.7047795158559369
+ 6.295000000000005e-07 2.705963857293789
+ 6.3050000000000046e-07 2.706926474357001
+ 6.3150000000000043e-07 2.7081034733503451
+ 6.325000000000004e-07 2.7090531660170161
+ 6.3350000000000037e-07 2.7101962707492202
+ 6.3450000000000034e-07 2.711157990377369
+ 6.3550000000000031e-07 2.712246908181974
+ 6.3650000000000028e-07 2.7132357374230631
+ 6.3750000000000025e-07 2.7142627730461468
+ 6.3850000000000022e-07 2.715279525212408
+ 6.3950000000000019e-07 2.7162517148077439
+ 6.4050000000000016e-07 2.717283205460058
+ 6.4150000000000013e-07 2.7182196999330368
+ 6.425000000000001e-07 2.7192434578103128
+ 6.4350000000000006e-07 2.7201691362720419
+ 6.4450000000000003e-07 2.7211609169354598
+ 6.455e-07 2.7220983785138162
+ 6.4649999999999997e-07 2.723040004603225
+ 6.4749999999999994e-07 2.7240025348754151
+ 6.4849999999999991e-07 2.7248875607792789
+ 6.4949999999999988e-07 2.7258752778325008
+ 6.5049999999999985e-07 2.7267107465983691
+ 6.5149999999999982e-07 2.7277110518999721
+ 6.5249999999999979e-07 2.7285149086222109
+ 6.5349999999999976e-07 2.7295069643243228
+ 6.5449999999999973e-07 2.7303020844481272
+ 6.554999999999997e-07 2.731263767739486
+ 6.5649999999999966e-07 2.7320706045403611
+ 6.5749999999999963e-07 2.7329856510093031
+ 6.584999999999996e-07 2.7338158824542749
+ 6.5949999999999957e-07 2.7346789421851532
+ 6.6049999999999954e-07 2.73553210503785
+ 6.6149999999999951e-07 2.7363501700149011
+ 6.6249999999999948e-07 2.7372142572031
+ 6.6349999999999945e-07 2.7380041202812668
+ 6.6449999999999942e-07 2.738859827279696
+ 6.6549999999999939e-07 2.7396425049024198
+ 6.6649999999999936e-07 2.7404696610112582
+ 6.6749999999999933e-07 2.7412636475737111
+ 6.684999999999993e-07 2.7420477195415418
+ 6.6949999999999927e-07 2.7428632539718358
+ 6.7049999999999923e-07 2.7435998527594192
+ 6.714999999999992e-07 2.7444359877254292
+ 6.7249999999999917e-07 2.7451320088117228
+ 6.7349999999999914e-07 2.7459773260177771
+ 6.7449999999999911e-07 2.746648466564408
+ 6.7549999999999908e-07 2.747485096344422
+ 6.7649999999999905e-07 2.7481506520595871
+ 6.7749999999999902e-07 2.7489602160716151
+ 6.7849999999999899e-07 2.7496368967974298
+ 6.7949999999999896e-07 2.7504064248231401
+ 6.8049999999999893e-07 2.7511031851129522
+ 6.814999999999989e-07 2.7518291264147612
+ 6.8249999999999887e-07 2.7525446220984979
+ 6.8349999999999883e-07 2.7532337363755461
+ 6.844999999999988e-07 2.75395713296788
+ 6.8549999999999877e-07 2.754624075774069
+ 6.8649999999999874e-07 2.755338846564086
+ 6.8749999999999871e-07 2.756001320364255
+ 6.8849999999999868e-07 2.7566907332825759
+ 6.8949999999999865e-07 2.7573638215867668
+ 6.9049999999999862e-07 2.7580163181310549
+ 6.9149999999999859e-07 2.758707828955512
+ 6.9249999999999856e-07 2.7593205891978618
+ 6.9349999999999853e-07 2.760028855973335
+ 6.944999999999985e-07 2.760608473717185
+ 6.9549999999999847e-07 2.7613232353189798
+ 6.9649999999999843e-07 2.7618833796347371
+ 6.974999999999984e-07 2.7625893631633129
+ 6.9849999999999837e-07 2.7631462641133751
+ 6.9949999999999834e-07 2.763828246978318
+ 7.0049999999999831e-07 2.7643955084624272
+ 7.0149999999999828e-07 2.765043204663904
+ 7.0249999999999825e-07 2.7656276139267049
+ 7.0349999999999822e-07 2.766238837297478
+ 7.0449999999999819e-07 2.7668384714627741
+ 7.0549999999999816e-07 2.7674196248011
+ 7.0649999999999813e-07 2.7680247839862071
+ 7.074999999999981e-07 2.768588602669622
+ 7.0849999999999807e-07 2.769185184362037
+ 7.0949999999999804e-07 2.7697465377387038
+ 7.10499999999998e-07 2.7703207034513908
+ 7.1149999999999797e-07 2.7708918492593169
+ 7.1249999999999794e-07 2.7714344599262719
+ 7.1349999999999791e-07 2.77202127695853
+ 7.1449999999999788e-07 2.7725306949039861
+ 7.1549999999999785e-07 2.7731310603514849
+ 7.1649999999999782e-07 2.773613478785117
+ 7.1749999999999779e-07 2.7742182385080429
+ 7.1849999999999776e-07 2.774685511545818
+ 7.1949999999999773e-07 2.7752816534875868
+ 7.204999999999977e-07 2.7757473948017979
+ 7.2149999999999767e-07 2.776322347912604
+ 7.2249999999999764e-07 2.7767975921479762
+ 7.234999999999976e-07 2.7773432494134251
+ 7.2449999999999757e-07 2.7778330687690689
+ 7.2549999999999754e-07 2.778348264649031
+ 7.2649999999999751e-07 2.7788503857513152
+ 7.2749999999999748e-07 2.7793410893755799
+ 7.2849999999999745e-07 2.7798468870933499
+ 7.2949999999999742e-07 2.780324121623432
+ 7.3049999999999739e-07 2.7808215993368561
+ 7.3149999999999736e-07 2.7812978201097991
+ 7.3249999999999733e-07 2.7817755670037889
+ 7.334999999999973e-07 2.7822606977814131
+ 7.3449999999999727e-07 2.7827115350049949
+ 7.3549999999999724e-07 2.783209932596566
+ 7.364999999999972e-07 2.783633099486416
+ 7.3749999999999717e-07 2.7841423820850979
+ 7.3849999999999714e-07 2.7845436136693338
+ 7.3949999999999711e-07 2.7850556666316071
+ 7.4049999999999708e-07 2.7854452040790432
+ 7.4149999999999705e-07 2.785948975124652
+ 7.4249999999999702e-07 2.7863382063040869
+ 7.4349999999999699e-07 2.7868233457207872
+ 7.4449999999999696e-07 2.787221186405124
+ 7.4549999999999693e-07 2.7876813490265819
+ 7.464999999999969e-07 2.788091522778684
+ 7.4749999999999687e-07 2.7885262931769468
+ 7.4849999999999684e-07 2.7889463459883741
+ 7.4949999999999681e-07 2.7893612184444971
+ 7.5049999999999677e-07 2.7897835266980771
+ 7.5149999999999674e-07 2.7901880074753822
+ 7.5249999999999671e-07 2.7906023963011051
+ 7.5349999999999668e-07 2.7910068902507019
+ 7.5449999999999665e-07 2.7914039796870749
+ 7.5549999999999662e-07 2.7918164886748911
+ 7.5649999999999659e-07 2.7921906815435089
+ 7.5749999999999656e-07 2.7926143696763668
+ 7.5849999999999653e-07 2.7929655430654221
+ 7.594999999999965e-07 2.793397915103657
+ 7.6049999999999647e-07 2.7937313187752908
+ 7.6149999999999644e-07 2.7941652220733202
+ 7.6249999999999641e-07 2.7944896724549291
+ 7.6349999999999637e-07 2.7949157467499348
+ 7.6449999999999634e-07 2.795240743943936
+ 7.6549999999999631e-07 2.7956504950869432
+ 7.6649999999999628e-07 2.7959832128046989
+ 7.6749999999999625e-07 2.796371714181396
+ 7.6849999999999622e-07 2.7967148230152148
+ 7.6949999999999619e-07 2.7970821980345342
+ 7.7049999999999616e-07 2.7974331874951548
+ 7.7149999999999613e-07 2.7977844404399148
+ 7.724999999999961e-07 2.798136608057217
+ 7.7349999999999607e-07 2.7984799089801018
+ 7.7449999999999604e-07 2.798824649782623
+ 7.7549999999999601e-07 2.799168667012716
+ 7.7649999999999597e-07 2.7994982950616958
+ 7.7749999999999594e-07 2.799849452822798
+ 7.7849999999999591e-07 2.8001596415868022
+ 7.7949999999999588e-07 2.8005201764307599
+ 7.8049999999999585e-07 2.8008112546121051
+ 7.8149999999999582e-07 2.8011786630861439
+ 7.8249999999999579e-07 2.8014553901738841
+ 7.8349999999999576e-07 2.8018233994700248
+ 7.8449999999999573e-07 2.8020933401488262
+ 7.854999999999957e-07 2.802454045449144
+ 7.8649999999999567e-07 2.8027251034231608
+ 7.8749999999999564e-07 2.8030715561635362
+ 7.8849999999999561e-07 2.803349477410467
+ 7.8949999999999558e-07 2.803677887927956
+ 7.9049999999999554e-07 2.8039645276311989
+ 7.9149999999999551e-07 2.8042753944937919
+ 7.9249999999999548e-07 2.8045682742808471
+ 7.9349999999999545e-07 2.8048661152422669
+ 7.9449999999999542e-07 2.805159370836436
+ 7.9549999999999539e-07 2.805451184881731
+ 7.9649999999999536e-07 2.8057375593514911
+ 7.9749999999999533e-07 2.806030548390857
+ 7.984999999999953e-07 2.8063037648192921
+ 7.9949999999999527e-07 2.8066030621868929
+ 8.0049999999999524e-07 2.8068598099857942
+ 8.0149999999999521e-07 2.8071669372407202
+ 8.0249999999999518e-07 2.807407853174464
+ 8.0349999999999514e-07 2.8077203726085469
+ 8.0449999999999511e-07 2.807949736459451
+ 8.0549999999999508e-07 2.8082621721164229
+ 8.0649999999999505e-07 2.808486454117975
+ 8.0749999999999502e-07 2.8087921488087848
+ 8.0849999999999499e-07 2.8090179064695442
+ 8.0949999999999496e-07 2.809311195341734
+ 8.1049999999999493e-07 2.8095430083501798
+ 8.114999999999949e-07 2.80982100847746
+ 8.1249999999999487e-07 2.8100601066077302
+ 8.1349999999999484e-07 2.8103235661059731
+ 8.1449999999999481e-07 2.810567564267858
+ 8.1549999999999478e-07 2.810820530743102
+ 8.1649999999999474e-07 2.8110643205402548
+ 8.1749999999999471e-07 2.811312771349046
+ 8.1849999999999468e-07 2.8115502495100708
+ 8.1949999999999465e-07 2.811800151680234
+ 8.2049999999999462e-07 2.812026209896775
+ 8.2149999999999459e-07 2.812281644041672
+ 8.2249999999999456e-07 2.8124937798006422
+ 8.2349999999999453e-07 2.8127557220749528
+ 8.244999999999945e-07 2.8129547706295348
+ 8.2549999999999447e-07 2.8132208990200369
+ 8.2649999999999444e-07 2.8134106815935849
+ 8.2749999999999441e-07 2.8136762358723049
+ 8.2849999999999438e-07 2.8138622699609241
+ 8.2949999999999435e-07 2.814121658944535
+ 8.3049999999999431e-07 2.8143093699745898
+ 8.3149999999999428e-07 2.814557991944834
+ 8.3249999999999425e-07 2.814751010150538
+ 8.3349999999999422e-07 2.8149867013694969
+ 8.3449999999999419e-07 2.8151857823118092
+ 8.3549999999999416e-07 2.8154094451303888
+ 8.3649999999999413e-07 2.8156123372030701
+ 8.374999999999941e-07 2.8158275740205561
+ 8.3849999999999407e-07 2.8160298452524319
+ 8.3949999999999404e-07 2.8162417458989601
+ 8.4049999999999401e-07 2.8164382771966938
+ 8.4149999999999398e-07 2.816651771630764
+ 8.4249999999999395e-07 2.8168384210904689
+ 8.4349999999999391e-07 2.8170567344487258
+ 8.4449999999999388e-07 2.8172316385957399
+ 8.4549999999999385e-07 2.8174553362177339
+ 8.4649999999999382e-07 2.8176194461915021
+ 8.4749999999999379e-07 2.8178463534649798
+ 8.4849999999999376e-07 2.8180030598714052
+ 8.4949999999999373e-07 2.8182290548453062
+ 8.504999999999937e-07 2.8183830491383079
+ 8.5149999999999367e-07 2.8186034486336342
+ 8.5249999999999364e-07 2.8187592067896419
+ 8.5349999999999361e-07 2.8189702869702749
+ 8.5449999999999358e-07 2.8191306690846849
+ 8.5549999999999355e-07 2.8193308331701519
+ 8.5649999999999351e-07 2.8194962402435699
+ 8.5749999999999348e-07 2.819686473485981
+ 8.5849999999999345e-07 2.8198548117647881
+ 8.5949999999999342e-07 2.820038301569626
+ 8.6049999999999339e-07 2.8202057403669061
+ 8.6149999999999336e-07 2.8203868085146331
+ 8.6249999999999333e-07 2.820549065790829
+ 8.634999999999933e-07 2.8207317736392312
+ 8.6449999999999327e-07 2.820885504312201
+ 8.6549999999999324e-07 2.8210723843985042
+ 8.6649999999999321e-07 2.8212162270893861
+ 8.6749999999999318e-07 2.821407540127252
+ 8.6849999999999315e-07 2.821542500542396
+ 8.6949999999999312e-07 2.821736237339405
+ 8.7049999999999308e-07 2.8218653073609792
+ 8.7149999999999305e-07 2.822057911613153
+ 8.7249999999999302e-07 2.8221850691652892
+ 8.7349999999999299e-07 2.822372628820343
+ 8.7449999999999296e-07 2.822501555733913
+ 8.7549999999999293e-07 2.8226810696914049
+ 8.764999999999929e-07 2.822814003776366
+ 8.7749999999999287e-07 2.8229843191306818
+ 8.7849999999999284e-07 2.8231214009282031
+ 8.7949999999999281e-07 2.8232835333635289
+ 8.8049999999999278e-07 2.823422839551915
+ 8.8149999999999275e-07 2.8235795945149391
+ 8.8249999999999272e-07 2.8237178257526612
+ 8.8349999999999268e-07 2.8238728627562439
+ 8.8449999999999265e-07 2.8240064468517079
+ 8.8549999999999262e-07 2.8241631017005688
+ 8.8649999999999259e-07 2.824289348569248
+ 8.8749999999999256e-07 2.8244495953010098
+ 8.8849999999999253e-07 2.824567535162966
+ 8.894999999999925e-07 2.8247314130942001
+ 8.9049999999999247e-07 2.8248420615901568
+ 8.9149999999999244e-07 2.8250077348615639
+ 8.9249999999999241e-07 2.8251137188967639
+ 8.9349999999999238e-07 2.825278129701577
+ 8.9449999999999235e-07 2.8253828130010059
+ 8.9549999999999232e-07 2.8255427022924868
+ 8.9649999999999228e-07 2.8256491042185439
+ 8.9749999999999225e-07 2.8258020640632049
+ 8.9849999999999222e-07 2.8259119216865898
+ 8.9949999999999219e-07 2.8260571439489279
+ 9.0049999999999216e-07 2.826170410838174
+ 9.0149999999999213e-07 2.82630890390256
+ 9.024999999999921e-07 2.8264238311258119
+ 9.0349999999999207e-07 2.8265580525455918
+ 9.0449999999999204e-07 2.8266718078326338
+ 9.0549999999999201e-07 2.8268048479927281
+ 9.0649999999999198e-07 2.826914459423338
+ 9.0749999999999195e-07 2.8270490496888638
+ 9.0849999999999192e-07 2.827152363897905
+ 9.0949999999999189e-07 2.8272900298765831
+ 9.1049999999999185e-07 2.827386379909179
+ 9.1149999999999182e-07 2.8275270042615528
+ 9.1249999999999179e-07 2.8276173840467589
+ 9.1349999999999176e-07 2.8277593048524259
+ 9.1449999999999173e-07 2.8278460103952381
+ 9.154999999999917e-07 2.82798660697246
+ 9.1649999999999167e-07 2.828072475035456
+ 9.1749999999999164e-07 2.8282090397712571
+ 9.1849999999999161e-07 2.8282965385782388
+ 9.1949999999999158e-07 2.8284271487989008
+ 9.2049999999999155e-07 2.8285176142897441
+ 9.2149999999999152e-07 2.8286417271929398
+ 9.2249999999999149e-07 2.828734982885404
+ 9.2349999999999145e-07 2.8288535732445892
+ 9.2449999999999142e-07 2.828948042400135
+ 9.2549999999999139e-07 2.8290632536872868
+ 9.2649999999999136e-07 2.829156512654623
+ 9.2749999999999133e-07 2.8292709477282569
+ 9.284999999999913e-07 2.829360530797195
+ 9.2949999999999127e-07 2.8294764188379729
+ 9.3049999999999124e-07 2.8295606109957738
+ 9.3149999999999121e-07 2.8296791192422299
+ 9.3249999999999118e-07 2.8297574853708811
+ 9.3349999999999115e-07 2.829878389748528
+ 9.3449999999999112e-07 2.829951880438458
+ 9.3549999999999109e-07 2.830073688430546
+ 9.3649999999999105e-07 2.830144302121147
+ 9.3749999999999102e-07 2.830264774614331
+ 9.3849999999999099e-07 2.8303348973593301
+ 9.3949999999999096e-07 2.8304517911288389
+ 9.4049999999999093e-07 2.830523433878573
+ 9.414999999999909e-07 2.8306352218963222
+ 9.4249999999999087e-07 2.8307094008278502
+ 9.4349999999999084e-07 2.8308157422610489
+ 9.4449999999999081e-07 2.830892194516466
+ 9.4549999999999078e-07 2.8309940129853159
+ 9.4649999999999075e-07 2.831071327569306
+ 9.4749999999999072e-07 2.8311704851327879
+ 9.4849999999999069e-07 2.8312465943239191
+ 9.4949999999999066e-07 2.8313452774848629
+ 9.5049999999999062e-07 2.831418141301516
+ 9.5149999999999059e-07 2.8315181631560651
+ 9.5249999999999056e-07 2.831586423360998
+ 9.5349999999999053e-07 2.8316886662235778
+ 9.5449999999999061e-07 2.8317520630615478
+ 9.5549999999999068e-07 2.8318562342183928
+ 9.5649999999999076e-07 2.8319156609644862
+ 9.5749999999999083e-07 2.8320204292931401
+ 9.5849999999999091e-07 2.8320776186841639
+ 9.5949999999999098e-07 2.8321810767554321
+ 9.6049999999999106e-07 2.8322380305028889
+ 9.6149999999999113e-07 2.8323383251205851
+ 9.6249999999999121e-07 2.8323966758295982
+ 9.6349999999999128e-07 2.8324926013980201
+ 9.6449999999999136e-07 2.83255311172526
+ 9.6549999999999143e-07 2.8326444791134802
+ 9.6649999999999151e-07 2.8327068329556968
+ 9.6749999999999158e-07 2.8327945037457711
+ 9.6849999999999166e-07 2.8328574466048462
+ 9.6949999999999173e-07 2.83294303237478
+ 9.7049999999999181e-07 2.8330048053211518
+ 9.7149999999999188e-07 2.8330901380387772
+ 9.7249999999999196e-07 2.833149058172368
+ 9.7349999999999203e-07 2.833235607149978
+ 9.7449999999999211e-07 2.8332906055484881
+ 9.7549999999999218e-07 2.8333790278647082
+ 9.7649999999999226e-07 2.8334299754643668
+ 9.7749999999999234e-07 2.833519938473815
+ 9.7849999999999241e-07 2.8335676630306978
+ 9.7949999999999249e-07 2.833657986788471
+ 9.8049999999999256e-07 2.8337039852556538
+ 9.8149999999999264e-07 2.8337930495424999
+ 9.8249999999999271e-07 2.8338389968233439
+ 9.8349999999999279e-07 2.8339252751405941
+ 9.8449999999999286e-07 2.8339724916872941
+ 9.8549999999999294e-07 2.8340550385895962
+ 9.8649999999999301e-07 2.8341040872741758
+ 9.8749999999999309e-07 2.8341828256942412
+ 9.8849999999999316e-07 2.8342333619529758
+ 9.8949999999999324e-07 2.8343090855357098
+ 9.9049999999999331e-07 2.834360000422107
+ 9.9149999999999339e-07 2.834434099099576
+ 9.9249999999999346e-07 2.834483900582808
+ 9.9349999999999354e-07 2.8345579052789081
+ 9.9449999999999361e-07 2.834605209161642
+ 9.9549999999999369e-07 2.834680305958853
+ 9.9649999999999376e-07 2.8347242770114991
+ 9.9749999999999384e-07 2.834800946078746
+ 9.9849999999999391e-07 2.8348415508197271
+ 9.9949999999999399e-07 2.8349194408824299
+ 1.0004999999999941e-06 2.834957437630766
+ 1.0014999999999939e-06 2.8350355084481671
+ 1.002499999999994e-06 2.8350721860782708
+ 1.0034999999999941e-06 2.835149065232681
+ 1.0044999999999939e-06 2.8351858215338859
+ 1.005499999999994e-06 2.8352602554444188
+ 1.0064999999999949e-06 2.835298154078655
+ 1.007499999999995e-06 2.835369406997839
+ 1.0084999999999951e-06 2.8354088544766949
+ 1.009499999999995e-06 2.8354769303559682
+ 1.010499999999995e-06 2.8355175718762391
+ 1.0114999999999951e-06 2.8355831941947538
+ 1.012499999999995e-06 2.835624054536956
+ 1.013499999999995e-06 2.835688418121423
+ 1.0144999999999949e-06 2.8357282351375361
+ 1.015499999999995e-06 2.8357926159905911
+ 1.0164999999999951e-06 2.8358302546813321
+ 1.0174999999999949e-06 2.8358956062363561
+ 1.018499999999995e-06 2.8359304193394972
+ 1.0194999999999951e-06 2.835997083831034
+ 1.020499999999996e-06 2.8360291060543812
+ 1.0214999999999961e-06 2.8360967290721608
+ 1.0224999999999959e-06 2.8361266485055392
+ 1.023499999999996e-06 2.8361943174828421
+ 1.0244999999999961e-06 2.8362232402849821
+ 1.0254999999999959e-06 2.836289795879769
+ 1.026499999999996e-06 2.8363188854989949
+ 1.0274999999999961e-06 2.8363833015084841
+ 1.028499999999996e-06 2.8364134110006982
+ 1.029499999999996e-06 2.836475119964621
+ 1.0304999999999961e-06 2.8365065344275622
+ 1.031499999999996e-06 2.8365655971931578
+ 1.032499999999996e-06 2.836597964676181
+ 1.033499999999997e-06 2.8366550349716202
+ 1.034499999999997e-06 2.8366875018771411
+ 1.0354999999999969e-06 2.8367436035998139
+ 1.036499999999997e-06 2.8367751051269159
+ 1.0374999999999971e-06 2.836831298992569
+ 1.0384999999999969e-06 2.8368609074785121
+ 1.039499999999997e-06 2.8369179564099269
+ 1.0404999999999971e-06 2.8369451750892121
+ 1.0414999999999969e-06 2.837003314683515
+ 1.042499999999997e-06 2.8370282252612409
+ 1.0434999999999971e-06 2.8370871089478999
+ 1.0444999999999969e-06 2.8371103307102739
+ 1.045499999999997e-06 2.837169161520797
+ 1.0464999999999979e-06 2.837191640906779
+ 1.047499999999998e-06 2.8372494421248629
+ 1.0484999999999981e-06 2.837272144941275
+ 1.049499999999998e-06 2.8373280792861171
+ 1.050499999999998e-06 2.8373516864058201
+ 1.0514999999999979e-06 2.8374053208240921
+ 1.052499999999998e-06 2.837430023930303
+ 1.053499999999998e-06 2.8374814575913661
+ 1.0544999999999979e-06 2.8375069167039739
+ 1.055499999999998e-06 2.8375567358455491
+ 1.0564999999999981e-06 2.837582207031943
+ 1.0574999999999979e-06 2.837631286450748
+ 1.058499999999998e-06 2.8376558737946871
+ 1.0594999999999981e-06 2.837705092870074
+ 1.060499999999999e-06 2.837728040744711
+ 1.0614999999999991e-06 2.8377780068992302
+ 1.0624999999999989e-06 2.8377989384284739
+ 1.063499999999999e-06 2.8378498056398249
+ 1.0644999999999991e-06 2.837868833291282
+ 1.0654999999999989e-06 2.8379202703185782
+ 1.066499999999999e-06 2.8379379475197561
+ 1.0674999999999991e-06 2.837989261226463
+ 1.068499999999999e-06 2.838006395379888
+ 1.069499999999999e-06 2.838056765096646
+ 1.0704999999999989e-06 2.838074155754827
+ 1.071499999999999e-06 2.8381229007371478
+ 1.072499999999999e-06 2.8381410884716831
+ 1.0735e-06 2.838187882445637
+ 1.0745e-06 2.8382069878496852
+ 1.0754999999999999e-06 2.838251954158785
+ 1.0765e-06 2.8382716552916012
+ 1.0775000000000001e-06 2.8383153161769901
+ 1.0784999999999999e-06 2.8383349672585831
+ 1.0795e-06 2.8383780679766399
+ 1.0805000000000001e-06 2.8383969171822798
+ 1.0814999999999999e-06 2.838440184773237
+ 1.0825e-06 2.8384576188204131
+ 1.0835000000000001e-06 2.8385015342171269
+ 1.0845e-06 2.8385172712057938
+ 1.0855e-06 2.838561926658874
+ 1.0865000000000009e-06 2.8385760975321381
+ 1.087500000000001e-06 2.838621181958787
+ 1.0885000000000011e-06 2.838634278214708
+ 1.089500000000001e-06 2.8386791910982341
+ 1.090500000000001e-06 2.8386918995721091
+ 1.0915000000000009e-06 2.8387359531858158
+ 1.092500000000001e-06 2.8387489339442911
+ 1.0935000000000011e-06 2.8387915768777261
+ 1.0945000000000009e-06 2.8388052565710771
+ 1.095500000000001e-06 2.838846246881956
+ 1.0965000000000011e-06 2.8388606927167568
+ 1.0975000000000009e-06 2.8389001672877612
+ 1.098500000000001e-06 2.8389150791163309
+ 1.0995000000000019e-06 2.8389535004544988
+ 1.100500000000002e-06 2.838968319776173
+ 1.1015000000000021e-06 2.839006321010793
+ 1.1025000000000019e-06 2.8390204185821282
+ 1.103500000000002e-06 2.8390585991056061
+ 1.1045000000000021e-06 2.83907147908524
+ 1.105500000000002e-06 2.8391102173116249
+ 1.106500000000002e-06 2.83912167256827
+ 1.1075000000000021e-06 2.8391610147518889
+ 1.108500000000002e-06 2.8391711855380599
+ 1.109500000000002e-06 2.839210843576653
+ 1.1105000000000019e-06 2.839220163971258
+ 1.111500000000002e-06 2.8392596194619939
+ 1.1125000000000021e-06 2.8392686721269209
+ 1.113500000000003e-06 2.8393073502775441
+ 1.1145000000000031e-06 2.839316678555416
+ 1.1155000000000029e-06 2.8393541345031599
+ 1.116500000000003e-06 2.839364072890636
+ 1.1175000000000031e-06 2.839400130852527
+ 1.1185000000000029e-06 2.8394107071242369
+ 1.119500000000003e-06 2.839445509659567
+ 1.1205000000000031e-06 2.8394564474796939
+ 1.1215000000000029e-06 2.839490402045294
+ 1.122500000000003e-06 2.8395012200771128
+ 1.1235000000000031e-06 2.839534863084594
+ 1.124500000000003e-06 2.8395450360743379
+ 1.125500000000003e-06 2.839578860236196
+ 1.126500000000004e-06 2.839587988948804
+ 1.127500000000004e-06 2.8396222899110182
+ 1.1285000000000041e-06 2.8396302256600769
+ 1.129500000000004e-06 2.8396650160378281
+ 1.130500000000004e-06 2.8396719016755658
+ 1.1315000000000039e-06 2.839706917678626
+ 1.132500000000004e-06 2.8397131346568818
+ 1.1335000000000041e-06 2.839747930285625
+ 1.1345000000000039e-06 2.8397539715611839
+ 1.135500000000004e-06 2.8397880676952152
+ 1.1365000000000041e-06 2.8397943791881342
+ 1.1375000000000039e-06 2.839827418476605
+ 1.138500000000004e-06 2.8398342604368252
+ 1.1395000000000049e-06 2.8398661186069449
+ 1.140500000000005e-06 2.839873490301255
+ 1.1415000000000051e-06 2.8399043098955632
+ 1.1425000000000049e-06 2.83991195954744
+ 1.143500000000005e-06 2.83994209781702
+ 1.1445000000000051e-06 2.8399496119579588
+ 1.145500000000005e-06 2.8399795221647981
+ 1.146500000000005e-06 2.8399864635151668
+ 1.1475000000000049e-06 2.8400165494472551
+ 1.148500000000005e-06 2.8400225979977751
+ 1.149500000000005e-06 2.8400530887569522
+ 1.1505000000000049e-06 2.840058141132773
+ 1.151500000000005e-06 2.8400890253342439
+ 1.1525000000000051e-06 2.8400932221917499
+ 1.153500000000006e-06 2.8401242606056858
+ 1.1545000000000061e-06 2.840127935623606
+ 1.1555000000000059e-06 2.8401587457779272
+ 1.156500000000006e-06 2.8401623149140378
+ 1.1575000000000061e-06 2.8401924985150608
+ 1.1585000000000059e-06 2.8401963265913119
+ 1.159500000000006e-06 2.840225597938304
+ 1.1605000000000061e-06 2.84022988564731
+ 1.1615000000000059e-06 2.8402581602169961
+ 1.162500000000006e-06 2.840262886804338
+ 1.1635000000000061e-06 2.8402903031175182
+ 1.164500000000006e-06 2.8402952411939841
+ 1.165500000000006e-06 2.8403221111205972
+ 1.166500000000007e-06 2.840326906629798
+ 1.167500000000007e-06 2.8403536121689461
+ 1.1685000000000069e-06 2.840357902056851
+ 1.169500000000007e-06 2.840384773069248
+ 1.170500000000007e-06 2.840388302087419
+ 1.1715000000000069e-06 2.840415514419079
+ 1.172500000000007e-06 2.8404182139870691
+ 1.1735000000000071e-06 2.8404457397069831
+ 1.1745000000000069e-06 2.8404477449735941
+ 1.175500000000007e-06 2.8404753688911759
+ 1.1765000000000071e-06 2.8404769705236061
+ 1.1775000000000069e-06 2.8405043656548901
+ 1.178500000000007e-06 2.8405059137219379
+ 1.1795000000000079e-06 2.8405327498751469
+ 1.180500000000008e-06 2.8405345418692098
+ 1.1815000000000081e-06 2.8405605918136172
+ 1.1825000000000079e-06 2.8405627808803868
+ 1.183500000000008e-06 2.8405879904476969
+ 1.1845000000000081e-06 2.8405905423428139
+ 1.185500000000008e-06 2.8406150433278188
+ 1.186500000000008e-06 2.8406177542386022
+ 1.1875000000000079e-06 2.8406418178020001
+ 1.188500000000008e-06 2.8406443854578618
+ 1.1895000000000081e-06 2.8406683327073452
+ 1.1905000000000079e-06 2.840670456512
+ 1.191500000000008e-06 2.8406945560135308
+ 1.1925000000000081e-06 2.8406960334779039
+ 1.193500000000009e-06 2.8407204186688739
+ 1.1945000000000091e-06 2.840721207625748
+ 1.1955000000000089e-06 2.840745839736317
+ 1.196500000000009e-06 2.84074606765288
+ 1.1975000000000091e-06 2.840770754484037
+ 1.1985000000000089e-06 2.840770673577679
+ 1.199500000000009e-06 2.8407951364119
+ 1.2005000000000091e-06 2.8407950405338669
+ 1.201500000000009e-06 2.8408190064084091
+ 1.202500000000009e-06 2.8408191373044009
+ 1.2035000000000091e-06 2.8408424265362648
+ 1.204500000000009e-06 2.84084289959323
+ 1.205500000000009e-06 2.8408654809031288
+ 1.20650000000001e-06 2.8408662533605651
+ 1.20750000000001e-06 2.8408882501026889
+ 1.2085000000000099e-06 2.8408891404870151
+ 1.20950000000001e-06 2.840910787547704
+ 1.2105000000000101e-06 2.840911538546417
+ 1.2115000000000099e-06 2.8409331051531268
+ 1.21250000000001e-06 2.8409334685876182
+ 1.2135000000000101e-06 2.840955172626118
+ 1.2145000000000099e-06 2.8409549888338108
+ 1.21550000000001e-06 2.8409769301568262
+ 1.2165000000000101e-06 2.840976176743268
+ 1.2175000000000099e-06 2.8409983100614249
+ 1.21850000000001e-06 2.8409971054980399
+ 1.2195000000000109e-06 2.8410192602164441
+ 1.220500000000011e-06 2.8410178225636562
+ 1.2215000000000111e-06 2.8410397617876608
+ 1.222500000000011e-06 2.8410383370684982
+ 1.223500000000011e-06 2.8410598357989212
+ 1.2245000000000111e-06 2.8410586197315189
+ 1.225500000000011e-06 2.8410795368084019
+ 1.226500000000011e-06 2.841078614969422
+ 1.2275000000000109e-06 2.8410989361046641
+ 1.228500000000011e-06 2.8410982609531672
+ 1.2295000000000111e-06 2.8411181000933752
+ 1.2305000000000109e-06 2.8411175109925439
+ 1.231500000000011e-06 2.8411370708905341
+ 1.2325000000000111e-06 2.8411363494143931
+ 1.233500000000012e-06 2.8411558552186178
+ 1.2345000000000121e-06 2.841154797064116
+ 1.2355000000000119e-06 2.8411744248733388
+ 1.236500000000012e-06 2.841172905009826
+ 1.2375000000000121e-06 2.8411927282455869
+ 1.2385000000000119e-06 2.8411907388213402
+ 1.239500000000012e-06 2.8412107088945979
+ 1.2405000000000121e-06 2.8412083587142951
+ 1.241500000000012e-06 2.8412283250477932
+ 1.242500000000012e-06 2.841225801997278
+ 1.2435000000000119e-06 2.8412455638059151
+ 1.244500000000012e-06 2.8412430733279259
+ 1.245500000000012e-06 2.8412624457062039
+ 1.246500000000013e-06 2.8412601456247519
+ 1.247500000000013e-06 2.8412790184994758
+ 1.2485000000000129e-06 2.8412769710120971
+ 1.249500000000013e-06 2.841295342457284
+ 1.2505000000000131e-06 2.8412934980053079
+ 1.2515000000000129e-06 2.8413114721424528
+ 1.252500000000013e-06 2.84130968928116
+ 1.2535000000000131e-06 2.841327440547547
+ 1.2545000000000129e-06 2.8413255343686541
+ 1.255500000000013e-06 2.8413432505640701
+ 1.2565000000000131e-06 2.8413410533922012
+ 1.2575000000000129e-06 2.841358876262583
+ 1.258500000000013e-06 2.8413562909564249
+ 1.2595000000000139e-06 2.8413742732684679
+ 1.260500000000014e-06 2.8413713024291201
+ 1.2615000000000141e-06 2.8413893946513289
+ 1.262500000000014e-06 2.8413861372163378
+ 1.263500000000014e-06 2.8414042071077068
+ 1.2645000000000139e-06 2.8414008244397611
+ 1.265500000000014e-06 2.8414187022860391
+ 1.266500000000014e-06 2.8414153654906911
+ 1.2675000000000139e-06 2.8414328998111089
+ 1.268500000000014e-06 2.8414297356083149
+ 1.2695000000000141e-06 2.8414468413077301
+ 1.2705000000000139e-06 2.8414438936985098
+ 1.271500000000014e-06 2.841460577606826
+ 1.2725000000000141e-06 2.8414577970140562
+ 1.273500000000015e-06 2.8414741534112302
+ 1.2745000000000151e-06 2.8414714158818279
+ 1.2755000000000149e-06 2.841487594374362
+ 1.276500000000015e-06 2.8414847437945912
+ 1.2775000000000151e-06 2.8415009006199758
+ 1.2785000000000149e-06 2.8414977998102779
+ 1.279500000000015e-06 2.841514048558905
+ 1.2805000000000151e-06 2.8415106227375309
+ 1.281500000000015e-06 2.8415270001656978
+ 1.282500000000015e-06 2.8415232592140418
+ 1.2835000000000149e-06 2.841539716531972
+ 1.284500000000015e-06 2.8415357496573042
+ 1.2855000000000151e-06 2.8415521712583121
+ 1.286500000000016e-06 2.8415481166174819
+ 1.287500000000016e-06 2.8415643594358868
+ 1.2885000000000159e-06 2.8415603591567709
+ 1.289500000000016e-06 2.8415762995020502
+ 1.2905000000000161e-06 2.84157245485284
+ 1.2915000000000159e-06 2.8415880276066541
+ 1.292500000000016e-06 2.8415843685485478
+ 1.2935000000000161e-06 2.8415995865132562
+ 1.2945000000000159e-06 2.8415960648567968
+ 1.295500000000016e-06 2.8416110127358429
+ 1.2965000000000161e-06 2.8416075203297382
+ 1.297500000000016e-06 2.8416223260491371
+ 1.298500000000016e-06 2.8416187314392878
+ 1.299500000000017e-06 2.84163352463412
+ 1.300500000000017e-06 2.841629715962779
+ 1.3015000000000171e-06 2.841644587220487
+ 1.302500000000017e-06 2.8416405075443509
+ 1.303500000000017e-06 2.8416554813282469
+ 1.3045000000000169e-06 2.84165114537271
+ 1.305500000000017e-06 2.841666174796365
+ 1.3065000000000171e-06 2.8416616624092068
+ 1.3075000000000169e-06 2.841676646834026
+ 1.308500000000017e-06 2.8416720759517569
+ 1.3095000000000171e-06 2.841686895098916
+ 1.3105000000000169e-06 2.8416823834579761
+ 1.311500000000017e-06 2.8416969366798681
+ 1.3125000000000179e-06 2.8416925647897848
+ 1.313500000000018e-06 2.8417068028612542
+ 1.3145000000000181e-06 2.84170258996489
+ 1.3155000000000179e-06 2.8417165295332718
+ 1.316500000000018e-06 2.8417124297771101
+ 1.3175000000000181e-06 2.8417261464255121
+ 1.318500000000018e-06 2.8417220658260089
+ 1.319500000000018e-06 2.8417356686266162
+ 1.3205000000000181e-06 2.841731496783968
+ 1.321500000000018e-06 2.841745093008242
+ 1.322500000000018e-06 2.8417407390327099
+ 1.3235000000000179e-06 2.841754400537484
+ 1.324500000000018e-06 2.841749821640041
+ 1.3255000000000181e-06 2.8417635635577181
+ 1.326500000000019e-06 2.8417587774554232
+ 1.3275000000000191e-06 2.841772555566529
+ 1.3285000000000189e-06 2.841767633272096
+ 1.329500000000019e-06 2.8417813603103941
+ 1.3305000000000191e-06 2.8417764022113938
+ 1.3315000000000189e-06 2.8417899773241211
+ 1.332500000000019e-06 2.8417850806797991
+ 1.3335000000000191e-06 2.8417984222707209
+ 1.3345000000000189e-06 2.8417936507196369
+ 1.335500000000019e-06 2.84180672213681
+ 1.3365000000000191e-06 2.8418020868390128
+ 1.337500000000019e-06 2.8418149069697249
+ 1.338500000000019e-06 2.841810365009493
+ 1.33950000000002e-06 2.8418230008943799
+ 1.34050000000002e-06 2.8418184709046912
+ 1.3415000000000201e-06 2.8418310152823678
+ 1.34250000000002e-06 2.8418264047882569
+ 1.34350000000002e-06 2.841838946177869
+ 1.3445000000000199e-06 2.8418341816026138
+ 1.34550000000002e-06 2.8418467766639899
+ 1.3465000000000201e-06 2.8418418263820708
+ 1.3475000000000199e-06 2.8418544832613279
+ 1.34850000000002e-06 2.8418493665956341
+ 1.3495000000000201e-06 2.841862044201116
+ 1.3505000000000199e-06 2.8418568239463209
+ 1.35150000000002e-06 2.8418694468843588
+ 1.3525000000000209e-06 2.8418642082528098
+ 1.353500000000021e-06 2.8418766921843739
+ 1.3545000000000211e-06 2.8418715152877878
+ 1.3555000000000209e-06 2.841883794324501
+ 1.356500000000021e-06 2.8418787291388452
+ 1.3575000000000211e-06 2.8418907765106032
+ 1.358500000000021e-06 2.841885828196935
+ 1.359500000000021e-06 2.8418976638377509
+ 1.3605000000000209e-06 2.8418927927573199
+ 1.361500000000021e-06 2.8419044758123611
+ 1.362500000000021e-06 2.8418996117684499
+ 1.3635000000000209e-06 2.8419112208748598
+ 1.364500000000021e-06 2.841906286609797
+ 1.3655000000000211e-06 2.8419178946036978
+ 1.366500000000022e-06 2.841912830794556
+ 1.3675000000000221e-06 2.8419244820515068
+ 1.3685000000000219e-06 2.8419192658175678
+ 1.369500000000022e-06 2.8419309633445802
+ 1.3705000000000221e-06 2.8419256145921739
+ 1.3715000000000219e-06 2.841937320661549
+ 1.372500000000022e-06 2.8419318946332912
+ 1.3735000000000221e-06 2.8419435443335801
+ 1.3745000000000219e-06 2.8419381131635002
+ 1.375500000000022e-06 2.8419496361544589
+ 1.3765000000000221e-06 2.8419442656334
+ 1.377500000000022e-06 2.8419556089378148
+ 1.378500000000022e-06 2.841950338021682
+ 1.379500000000023e-06 2.8419614825793249
+ 1.380500000000023e-06 2.8419563120643092
+ 1.3815000000000229e-06 2.8419672779863259
+ 1.382500000000023e-06 2.8419621716573502
+ 1.383500000000023e-06 2.841973010870285
+ 1.3845000000000229e-06 2.84196790836811
+ 1.385500000000023e-06 2.8419786873759638
+ 1.3865000000000231e-06 2.8419735243254962
+ 1.3875000000000229e-06 2.84198430288258
+ 1.388500000000023e-06 2.8419790316593958
+ 1.3895000000000231e-06 2.8419898442536309
+ 1.3905000000000229e-06 2.8419844487728092
+ 1.391500000000023e-06 2.8419952947151379
+ 1.3925000000000239e-06 2.8419897947320352
+ 1.393500000000024e-06 2.8420006397283908
+ 1.3945000000000241e-06 2.8419950836157821
+ 1.395500000000024e-06 2.8420058719618999
+ 1.396500000000024e-06 2.8420003206196771
+ 1.3975000000000241e-06 2.842010993810018
+ 1.398500000000024e-06 2.842005501099528
+ 1.399500000000024e-06 2.842016016736451
+ 1.4005000000000239e-06 2.8420106127631781
+ 1.401500000000024e-06 2.8420209577508482
+ 1.4025000000000241e-06 2.8420156402171219
+ 1.4035000000000239e-06 2.8420258342286711
+ 1.404500000000024e-06 2.8420205703487569
+ 1.4055000000000241e-06 2.842030658771201
+ 1.406500000000025e-06 2.8420253968077822
+ 1.4075000000000251e-06 2.8420354357388309
+ 1.4085000000000249e-06 2.8420301221938038
+ 1.409500000000025e-06 2.8420401605034868
+ 1.4105000000000251e-06 2.8420347573249289
+ 1.4115000000000249e-06 2.8420448215759211
+ 1.412500000000025e-06 2.8420393179131271
+ 1.4135000000000251e-06 2.8420494048387428
+ 1.414500000000025e-06 2.842043819783477
+ 1.415500000000025e-06 2.8420538984760482
+ 1.4165000000000251e-06 2.8420482742029018
+ 1.417500000000025e-06 2.842058297009892
+ 1.418500000000025e-06 2.8420526847982792
+ 1.419500000000026e-06 2.842062603192308
+ 1.420500000000026e-06 2.8420570469920929
+ 1.4215000000000259e-06 2.8420668272169829
+ 1.422500000000026e-06 2.8420613500583118
+ 1.4235000000000261e-06 2.8420709835860598
+ 1.4245000000000259e-06 2.8420655810602131
+ 1.425500000000026e-06 2.842075086702978
+ 1.4265000000000261e-06 2.8420697293609849
+ 1.4275000000000259e-06 2.8420791466294011
+ 1.428500000000026e-06 2.842073790257325
+ 1.4295000000000261e-06 2.8420831663494459
+ 1.4305000000000259e-06 2.8420777666091408
+ 1.431500000000026e-06 2.8420871413635398
+ 1.4325000000000269e-06 2.842081668008865
+ 1.433500000000027e-06 2.8420910616679929
+ 1.4345000000000271e-06 2.8420855078348088
+ 1.435500000000027e-06 2.8420949154148691
+ 1.436500000000027e-06 2.8420892991885962
+ 1.4375000000000269e-06 2.8420986930385368
+ 1.438500000000027e-06 2.8420930510442699
+ 1.439500000000027e-06 2.8421023905221858
+ 1.4405000000000269e-06 2.8420967658250391
+ 1.441500000000027e-06 2.842106010793803
+ 1.4425000000000271e-06 2.8421004391325959
+ 1.4435000000000269e-06 2.842109562868377
+ 1.444500000000027e-06 2.8421040616467139
+ 1.4455000000000271e-06 2.8421130590783892
+ 1.446500000000028e-06 2.8421076225254991
+ 1.4475000000000281e-06 2.8421165113327
+ 1.4485000000000279e-06 2.8421111131762911
+ 1.449500000000028e-06 2.842119927624664
+ 1.4505000000000281e-06 2.842114530189447
+ 1.4515000000000279e-06 2.8421233098885108
+ 1.452500000000028e-06 2.8421178765292678
+ 1.4535000000000281e-06 2.8421266538439669
+ 1.454500000000028e-06 2.8421211606579111
+ 1.455500000000028e-06 2.8421299508165738
+ 1.4565000000000279e-06 2.8421243939368739
+ 1.457500000000028e-06 2.8421331908910159
+ 1.458500000000028e-06 2.84212758718453
+ 1.459500000000029e-06 2.8421363663567338
+ 1.460500000000029e-06 2.8421307475111681
+ 1.4615000000000289e-06 2.8421394743397199
+ 1.462500000000029e-06 2.8421338764266122
+ 1.4635000000000291e-06 2.8421425178117898
+ 1.4645000000000289e-06 2.8421369697845922
+ 1.465500000000029e-06 2.8421455047059818
+ 1.4665000000000291e-06 2.8421400195192512
+ 1.4675000000000289e-06 2.842148445482608
+ 1.468500000000029e-06 2.8421430165697039
+ 1.4695000000000291e-06 2.8421513499619468
+ 1.470500000000029e-06 2.8421459540257121
+ 1.471500000000029e-06 2.8421542244586
+ 1.4725000000000299e-06 2.842148829485442
+ 1.47350000000003e-06 2.8421570701161158
+ 1.4745000000000301e-06 2.8421516459045471
+ 1.47550000000003e-06 2.8421598829308921
+ 1.47650000000003e-06 2.8421544107136181
+ 1.4775000000000299e-06 2.8421626554101178
+ 1.47850000000003e-06 2.8421571335365221
+ 1.47950000000003e-06 2.8421653792792458
+ 1.4805000000000299e-06 2.8421598232824561
+ 1.48150000000003e-06 2.842168048351783
+ 1.4825000000000301e-06 2.8421624855514782
+ 1.4835000000000299e-06 2.84217066064042
+ 1.48450000000003e-06 2.8421651211709191
+ 1.4855000000000309e-06 2.842173219065097
+ 1.486500000000031e-06 2.8421677262900138
+ 1.4875000000000311e-06 2.8421757305766442
+ 1.4885000000000309e-06 2.8421702939539411
+ 1.489500000000031e-06 2.842178204024314
+ 1.4905000000000311e-06 2.8421728166127989
+ 1.491500000000031e-06 2.8421806474839149
+ 1.492500000000031e-06 2.8421752887354481
+ 1.4935000000000311e-06 2.8421830659133351
+ 1.494500000000031e-06 2.8421777086984532
+ 1.495500000000031e-06 2.8421854598685918
+ 1.4965000000000309e-06 2.8421800793697689
+ 1.497500000000031e-06 2.842187825655953
+ 1.4985000000000311e-06 2.8421824072457542
+ 1.499500000000032e-06 2.842190156825799
+ 1.5005000000000321e-06 2.842184700458934
+ 1.5015000000000319e-06 2.8421924464930481
+ 1.502500000000032e-06 2.8421869663249368
+ 1.5035000000000321e-06 2.8421946897192392
+ 1.5045000000000319e-06 2.8421892092257028
+ 1.505500000000032e-06 2.8421968851979522
+ 1.5065000000000321e-06 2.8421914294865172
+ 1.5075000000000319e-06 2.842199035731594
+ 1.508500000000032e-06 2.8421936235743992
+ 1.5095000000000321e-06 2.8422011473855209
+ 1.510500000000032e-06 2.842195785513784
+ 1.511500000000032e-06 2.8422032276280702
+ 1.512500000000033e-06 2.8421979090310421
+ 1.513500000000033e-06 2.8422052830814311
+ 1.5145000000000331e-06 2.842199989723226
+ 1.515500000000033e-06 2.84220731761051
+ 1.516500000000033e-06 2.842202026561206
+ 1.5175000000000329e-06 2.8422093313437311
+ 1.518500000000033e-06 2.8422040222721239
+ 1.5195000000000331e-06 2.8422113209100721
+ 1.5205000000000329e-06 2.8422059825134518
+ 1.521500000000033e-06 2.8422132807778109
+ 1.5225000000000331e-06 2.8422079141396019
+ 1.5235000000000329e-06 2.8422152052343761
+ 1.524500000000033e-06 2.842209823141121
+ 1.5255000000000339e-06 2.842217090359529
+ 1.526500000000034e-06 2.8422117129203679
+ 1.5275000000000341e-06 2.8422189353640461
+ 1.5285000000000339e-06 2.8422135834411022
+ 1.529500000000034e-06 2.8422207428904769
+ 1.5305000000000341e-06 2.8422154314949162
+ 1.531500000000034e-06 2.8422225182106899
+ 1.532500000000034e-06 2.8422172519650162
+ 1.5335000000000339e-06 2.8422242676120089
+ 1.534500000000034e-06 2.842219039653946
+ 1.535500000000034e-06 2.8422259965088101
+ 1.5365000000000339e-06 2.842220791077176
+ 1.537500000000034e-06 2.8422277078889029
+ 1.5385000000000341e-06 2.842222505654143
+ 1.539500000000035e-06 2.842229401577967
+ 1.5405000000000351e-06 2.8422241859365238
+ 1.5415000000000349e-06 2.842231074528252
+ 1.542500000000035e-06 2.8422258368334821
+ 1.5435000000000351e-06 2.8422327220102299
+ 1.5445000000000349e-06 2.842227464108527
+ 1.545500000000035e-06 2.8422343392983498
+ 1.5465000000000351e-06 2.8422290726521551
+ 1.5475000000000349e-06 2.842235923300175
+ 1.548500000000035e-06 2.8422306650823952
+ 1.5495000000000351e-06 2.842237473614071
+ 1.550500000000035e-06 2.8422322411106218
+ 1.551500000000035e-06 2.8422389926963518
+ 1.552500000000036e-06 2.8422337978484342
+ 1.553500000000036e-06 2.842240485113094
+ 1.5545000000000359e-06 2.842235330928482
+ 1.555500000000036e-06 2.8422419561442749
+ 1.556500000000036e-06 2.8422368360578858
+ 1.5575000000000359e-06 2.8422434102030181
+ 1.558500000000036e-06 2.8422383104972262
+ 1.5595000000000361e-06 2.842244849577455
+ 1.5605000000000359e-06 2.842239753998653
+ 1.561500000000036e-06 2.8422462738851042
+ 1.5625000000000361e-06 2.8422411689200922
+ 1.5635000000000359e-06 2.8422476803929202
+ 1.564500000000036e-06 2.842242559506257
+ 1.5655000000000369e-06 2.8422490650701082
+ 1.566500000000037e-06 2.8422439305916338
+ 1.5675000000000371e-06 2.8422504240195798
+ 1.5685000000000369e-06 2.842245286155562
+ 1.569500000000037e-06 2.8422517548195061
+ 1.5705000000000371e-06 2.8422466281918588
+ 1.571500000000037e-06 2.8422530573523201
+ 1.572500000000037e-06 2.842247956243813
+ 1.5735000000000369e-06 2.8422543338750619
+ 1.574500000000037e-06 2.8422492677298652
+ 1.5755000000000371e-06 2.8422555883298188
+ 1.5765000000000369e-06 2.8422505589335181
+ 1.577500000000037e-06 2.8422568251403311
+ 1.5785000000000371e-06 2.842251826320104
+ 1.579500000000038e-06 2.842258047890875
+ 1.5805000000000381e-06 2.8422530677533819
+ 1.5815000000000379e-06 2.842259258313367
+ 1.582500000000038e-06 2.8422542832267541
+ 1.5835000000000381e-06 2.84226045589166
+ 1.5845000000000379e-06 2.8422554748956581
+ 1.585500000000038e-06 2.842261638191077
+ 1.5865000000000381e-06 2.842256646418901
+ 1.587500000000038e-06 2.8422628017872822
+ 1.588500000000038e-06 2.8422578018419631
+ 1.5895000000000381e-06 2.842263943476254
+ 1.590500000000038e-06 2.8422589443916619
+ 1.591500000000038e-06 2.8422650613768599
+ 1.592500000000039e-06 2.8422600755670042
+ 1.593500000000039e-06 2.842266155576195
+ 1.5945000000000389e-06 2.8422611948066039
+ 1.595500000000039e-06 2.8422672281273429
+ 1.5965000000000391e-06 2.8422622998187141
+ 1.5975000000000389e-06 2.842268282422904
+ 1.598500000000039e-06 2.8422633874504708
+ 1.5995000000000391e-06 2.8422693221599671
+ 1.6005000000000389e-06 2.8422644548007829
+ 1.601500000000039e-06 2.8422703502403182
+ 1.6025000000000391e-06 2.842265500217565
+ 1.6035000000000389e-06 2.842271367956307
+ 1.604500000000039e-06 2.8422665238656601
+ 1.6055000000000399e-06 2.8422723747125271
+ 1.60650000000004e-06 2.8422675276977101
+ 1.6075000000000401e-06 2.8422733683539971
+ 1.60850000000004e-06 2.842268514857953
+ 1.60950000000004e-06 2.8422743459797202
+ 1.6105000000000401e-06 2.8422694887230961
+ 1.61150000000004e-06 2.8422753049644789
+ 1.61250000000004e-06 2.842270451900581
+ 1.6135000000000399e-06 2.8422762438610349
+ 1.61450000000004e-06 2.84227140550008
+ 1.6155000000000401e-06 2.8422771628979469
+ 1.6165000000000399e-06 2.8422723489024921
+ 1.61750000000004e-06 2.8422780639285241
+ 1.6185000000000401e-06 2.8422732800851209
+ 1.619500000000041e-06 2.8422789498635579
+ 1.6205000000000411e-06 2.842274196380902
+ 1.6215000000000409e-06 2.8422798237853319
+ 1.622500000000041e-06 2.8422750954170009
+ 1.6235000000000411e-06 2.8422806880339029
+ 1.6245000000000409e-06 2.8422759759296148
+ 1.625500000000041e-06 2.8422815435565458
+ 1.6265000000000411e-06 2.8422768381995609
+ 1.627500000000041e-06 2.8422823897194411
+ 1.628500000000041e-06 2.842277683982565
+ 1.6295000000000409e-06 2.8422832246262248
+ 1.630500000000041e-06 2.842278515972275
+ 1.631500000000041e-06 2.8422840458258811
+ 1.632500000000042e-06 2.8422793369806651
+ 1.633500000000042e-06 2.842284851175096
+ 1.6345000000000419e-06 2.8422801491066489
+ 1.635500000000042e-06 2.8422856395729932
+ 1.6365000000000421e-06 2.842280953154666
+ 1.6375000000000419e-06 2.8422864113421271
+ 1.638500000000042e-06 2.842281748483467
+ 1.6395000000000421e-06 2.842287168143121
+ 1.6405000000000419e-06 2.8422825333169901
+ 1.641500000000042e-06 2.842287912466265
+ 1.6425000000000421e-06 2.842283305405866
+ 1.6435000000000419e-06 2.842288646874878
+ 1.644500000000042e-06 2.842284062816153
+ 1.6455000000000429e-06 2.842289373248438
+ 1.646500000000043e-06 2.8422848045929991
+ 1.6475000000000431e-06 2.8422900922656318
+ 1.648500000000043e-06 2.8422855310914539
+ 1.649500000000043e-06 2.8422908032838601
+ 1.6505000000000429e-06 2.842286243879681
+ 1.651500000000043e-06 2.8422915046419499
+ 1.652500000000043e-06 2.8422869452592172
+ 1.6535000000000429e-06 2.842292194275517
+ 1.654500000000043e-06 2.842287637565903
+ 1.6555000000000431e-06 2.8422928704409789
+ 1.6565000000000429e-06 2.8422883224815609
+ 1.657500000000043e-06 2.842293532312715
+ 1.6585000000000431e-06 2.84228900057433
+ 1.659500000000044e-06 2.8422941802706361
+ 1.6605000000000441e-06 2.842289671205573
+ 1.6615000000000439e-06 2.842294815793287
+ 1.662500000000044e-06 2.8422903328235392
+ 1.6635000000000441e-06 2.8422954410055961
+ 1.6645000000000439e-06 2.8422909835360892
+ 1.665500000000044e-06 2.8422960580340271
+ 1.6665000000000441e-06 2.8422916217728611
+ 1.667500000000044e-06 2.8422966683815232
+ 1.668500000000044e-06 2.8422922468241132
+ 1.6695000000000439e-06 2.842297272518544
+ 1.670500000000044e-06 2.8422928590875229
+ 1.6715000000000441e-06 2.8422978698150798
+ 1.672500000000045e-06 2.8422934599553749
+ 1.673500000000045e-06 2.842298458822734
+ 1.6745000000000449e-06 2.842294051388643
+ 1.675500000000045e-06 2.842299037807996
+ 1.6765000000000451e-06 2.842294635322713
+ 1.6775000000000449e-06 2.8422996053573599
+ 1.678500000000045e-06 2.8422952130996189
+ 1.6795000000000451e-06 2.8423001608629832
+ 1.6805000000000449e-06 2.842295785104664
+ 1.681500000000045e-06 2.842300704734583
+ 1.6825000000000451e-06 2.8422963507202659
+ 1.683500000000045e-06 2.8423012382811681
+ 1.684500000000045e-06 2.842296908596011
+ 1.6855000000000459e-06 2.8423017633111329
+ 1.686500000000046e-06 2.8422974571451611
+ 1.6875000000000461e-06 2.842302281584161
+ 1.688500000000046e-06 2.842297995097661
+ 1.689500000000046e-06 2.8423027942960668
+ 1.6905000000000459e-06 2.842298521936335
+ 1.691500000000046e-06 2.8423033017582049
+ 1.6925000000000461e-06 2.842299038077932
+ 1.6935000000000459e-06 2.8423038033673609
+ 1.694500000000046e-06 2.8422995447523638
+ 1.6955000000000461e-06 2.8423042978659381
+ 1.6965000000000459e-06 2.8423000436260302
+ 1.697500000000046e-06 2.8423047838021889
+ 1.6985000000000469e-06 2.8423005362981968
+ 1.699500000000047e-06 2.8423052600356269
+ 1.7005000000000471e-06 2.8423010238338771
+ 1.7015000000000469e-06 2.842305726128699
+ 1.702500000000047e-06 2.8423015064802288
+ 1.7035000000000471e-06 2.8423061825005131
+ 1.704500000000047e-06 2.8423019836513341
+ 1.705500000000047e-06 2.842306630304789
+ 1.7065000000000471e-06 2.8423024541773478
+ 1.707500000000047e-06 2.842307071076041
+ 1.708500000000047e-06 2.8423029167313731
+ 1.7095000000000469e-06 2.842307506266347
+ 1.710500000000047e-06 2.842303370290955
+ 1.7115000000000471e-06 2.8423079368224129
+ 1.712500000000048e-06 2.842303814488611
+ 1.7135000000000481e-06 2.8423083629355892
+ 1.7145000000000479e-06 2.8423042497432061
+ 1.715500000000048e-06 2.8423087840385231
+ 1.7165000000000481e-06 2.8423046771356431
+ 1.7175000000000479e-06 2.8423091990439162
+ 1.718500000000048e-06 2.8423050980787981
+ 1.7195000000000481e-06 2.8423096067388949
+ 1.7205000000000479e-06 2.8423055138908988
+ 1.721500000000048e-06 2.8423100062074198
+ 1.7225000000000481e-06 2.842305925412405
+ 1.723500000000048e-06 2.8423103971441321
+ 1.724500000000048e-06 2.842306332786257
+ 1.725500000000049e-06 2.8423107799637459
+ 1.726500000000049e-06 2.842306735465816
+ 1.7275000000000491e-06 2.8423111556778791
+ 1.728500000000049e-06 2.8423071324416092
+ 1.729500000000049e-06 2.8423115255857652
+ 1.7305000000000489e-06 2.8423075226064349
+ 1.731500000000049e-06 2.842311890882911
+ 1.7325000000000491e-06 2.8423079051411642
+ 1.7335000000000489e-06 2.8423122523140298
+ 1.734500000000049e-06 2.8423082797948771
+ 1.7355000000000491e-06 2.8423126099801772
+ 1.7365000000000489e-06 2.842308646976127
+ 1.737500000000049e-06 2.8423129633561328
+ 1.7385000000000499e-06 2.8423090076308228
+ 1.73950000000005e-06 2.8423133115047858
+ 1.7405000000000501e-06 2.8423093629539351
+ 1.7415000000000499e-06 2.8423136534159581
+ 1.74250000000005e-06 2.842309714028997
+ 1.7435000000000501e-06 2.842313988357446
+ 1.74450000000005e-06 2.8423100615149379
+ 1.74550000000005e-06 2.842314316126147
+ 1.7465000000000499e-06 2.8423104054774471
+ 1.74750000000005e-06 2.842314637121941
+ 1.74850000000005e-06 2.8423107454132062
+ 1.7495000000000499e-06 2.842314952228318
+ 1.75050000000005e-06 2.8423110804540359
+ 1.7515000000000501e-06 2.8423152625424759
+ 1.752500000000051e-06 2.8423114096792612
+ 1.7535000000000511e-06 2.8423155690457231
+ 1.7545000000000509e-06 2.84231173243582
+ 1.755500000000051e-06 2.8423158723198889
+ 1.7565000000000511e-06 2.8423120485619142
+ 1.7575000000000509e-06 2.84231617240044
+ 1.758500000000051e-06 2.8423123584477019
+ 1.7595000000000511e-06 2.842316468805766
+ 1.7605000000000509e-06 2.8423126629179891
+ 1.761500000000051e-06 2.842316760731725
+ 1.7625000000000511e-06 2.842312962980416
+ 1.763500000000051e-06 2.842317047339503
+ 1.764500000000051e-06 2.842313259522951
+ 1.765500000000052e-06 2.8423173280469372
+ 1.766500000000052e-06 2.842313553058943
+ 1.7675000000000519e-06 2.8423176027283419
+ 1.768500000000052e-06 2.8423138435979611
+ 1.769500000000052e-06 2.8423178717623059
+ 1.7705000000000519e-06 2.84231413068157
+ 1.771500000000052e-06 2.8423181359176399
+ 1.7725000000000521e-06 2.84231441356506
+ 1.7735000000000519e-06 2.8423183961188951
+ 1.774500000000052e-06 2.8423146914855391
+ 1.7755000000000521e-06 2.8423186531688152
+ 1.7765000000000519e-06 2.8423149639253271
+ 1.777500000000052e-06 2.8423189075184778
+ 1.7785000000000529e-06 2.842315230790176
+ 1.779500000000053e-06 2.8423191591560109
+ 1.7805000000000531e-06 2.8423154924464309
+ 1.781500000000053e-06 2.8423194076451641
+ 1.782500000000053e-06 2.842315749610254
+ 1.7835000000000531e-06 2.8423196522972329
+ 1.784500000000053e-06 2.8423160031299539
+ 1.785500000000053e-06 2.8423198924176769
+ 1.7865000000000529e-06 2.8423162537309299
+ 1.787500000000053e-06 2.84232012754729
+ 1.7885000000000531e-06 2.8423165018089769
+ 1.7895000000000529e-06 2.842320357618247
+ 1.790500000000053e-06 2.8423167473347322
+ 1.7915000000000531e-06 2.8423205829836569
+ 1.792500000000054e-06 2.8423169898939999
+ 1.7935000000000541e-06 2.8423208043098471
+ 1.7945000000000539e-06 2.8423172288510821
+ 1.795500000000054e-06 2.8423210223738158
+ 1.7965000000000541e-06 2.842317463574787
+ 1.7975000000000539e-06 2.8423212378306442
+ 1.798500000000054e-06 2.8423176936577339
+ 1.7995000000000541e-06 2.8423214510268089
+ 1.800500000000054e-06 2.8423179190560011
+ 1.801500000000054e-06 2.8423216619175391
+ 1.8025000000000541e-06 2.84231814010881
+ 1.803500000000054e-06 2.8423218701108341
+ 1.804500000000054e-06 2.8423183574359521
+ 1.805500000000055e-06 2.8423220750192528
+ 1.806500000000055e-06 2.8423185717494501
+ 1.8075000000000549e-06 2.842322276069436
+ 1.808500000000055e-06 2.84231878364043
+ 1.8095000000000551e-06 2.8423224729008179
+ 1.8105000000000549e-06 2.8423189934115558
+ 1.811500000000055e-06 2.8423226654887959
+ 1.8125000000000551e-06 2.842319201006323
+ 1.8135000000000549e-06 2.8423228541587071
+ 1.814500000000055e-06 2.8423194060539738
+ 1.8155000000000551e-06 2.8423230394862919
+ 1.8165000000000549e-06 2.842319608012684
+ 1.817500000000055e-06 2.8423232221231012
+ 1.8185000000000559e-06 2.8423198063625832
+ 1.819500000000056e-06 2.8423234026016488
+ 1.8205000000000561e-06 2.8423200007852221
+ 1.821500000000056e-06 2.8423235811854051
+ 1.822500000000056e-06 2.842320191273092
+ 1.8235000000000559e-06 2.8423237578080638
+ 1.824500000000056e-06 2.842320378137297
+ 1.825500000000056e-06 2.842323932119641
+ 1.8265000000000559e-06 2.8423205619125538
+ 1.827500000000056e-06 2.8423241036201619
+ 1.8285000000000561e-06 2.84232074319524
+ 1.8295000000000559e-06 2.8423242718380388
+ 1.830500000000056e-06 2.8423209224654218
+ 1.8315000000000561e-06 2.8423244364923641
+ 1.832500000000057e-06 2.8423210999514441
+ 1.8335000000000571e-06 2.842324597590332
+ 1.8345000000000569e-06 2.8423212755792329
+ 1.835500000000057e-06 2.8423247554284679
+ 1.8365000000000571e-06 2.842321449019233
+ 1.8375000000000569e-06 2.8423249105024659
+ 1.838500000000057e-06 2.8423216198115502
+ 1.8395000000000571e-06 2.8423250633571921
+ 1.840500000000057e-06 2.842321787528955
+ 1.841500000000057e-06 2.842325214424497
+ 1.8425000000000569e-06 2.8423219519246392
+ 1.843500000000057e-06 2.8423253639016681
+ 1.844500000000057e-06 2.8423221130176208
+ 1.845500000000058e-06 2.8423255117091641
+ 1.846500000000058e-06 2.8423222710901181
+ 1.8475000000000579e-06 2.8423256575363141
+ 1.848500000000058e-06 2.8423224266024181
+ 1.8495000000000581e-06 2.8423258009594319
+ 1.8505000000000579e-06 2.8423225800521572
+ 1.851500000000058e-06 2.842325941592081
+ 1.8525000000000581e-06 2.8423227318275108
+ 1.8535000000000579e-06 2.8423260792177909
+ 1.854500000000058e-06 2.8423228820985562
+ 1.8555000000000581e-06 2.8423262138648089
+ 1.8565000000000579e-06 2.8423230307821079
+ 1.857500000000058e-06 2.8423263458011601
+ 1.8585000000000589e-06 2.842323177586052
+ 1.859500000000059e-06 2.8423264754532318
+ 1.8605000000000591e-06 2.8423233221209609
+ 1.861500000000059e-06 2.8423266032751542
+ 1.862500000000059e-06 2.8423234640374671
+ 1.8635000000000589e-06 2.8423267296153938
+ 1.864500000000059e-06 2.8423236031464212
+ 1.865500000000059e-06 2.842326854619651
+ 1.8665000000000589e-06 2.842323739484248
+ 1.867500000000059e-06 2.8423269782016232
+ 1.8685000000000591e-06 2.842323873305427
+ 1.8695000000000589e-06 2.8423271000872572
+ 1.870500000000059e-06 2.842324005004301
+ 1.8715000000000599e-06 2.8423272199183338
+ 1.87250000000006e-06 2.8423241349959989
+ 1.8735000000000601e-06 2.8423273373788929
+ 1.8745000000000599e-06 2.8423242635931332
+ 1.87550000000006e-06 2.8423274523039659
+ 1.8765000000000601e-06 2.8423243909200542
+ 1.87750000000006e-06 2.842327564736455
+ 1.87850000000006e-06 2.84232451688858
+ 1.8795000000000601e-06 2.8423276749171071
+ 1.88050000000006e-06 2.8423246412424619
+ 1.88150000000006e-06 2.8423277832103659
+ 1.8825000000000599e-06 2.8423247636527491
+ 1.88350000000006e-06 2.8423278899945679
+ 1.8845000000000601e-06 2.8423248838345452
+ 1.885500000000061e-06 2.8423279955498901
+ 1.8865000000000611e-06 2.8423250016441872
+ 1.8875000000000609e-06 2.842328099981724
+ 1.888500000000061e-06 2.8423251171300978
+ 1.8895000000000611e-06 2.8423282032010739
+ 1.8905000000000609e-06 2.8423252305197031
+ 1.891500000000061e-06 2.8423283049678369
+ 1.8925000000000611e-06 2.8423253421502199
+ 1.8935000000000609e-06 2.8423284049798818
+ 1.894500000000061e-06 2.842325452366834
+ 1.8955000000000611e-06 2.8423285029798562
+ 1.896500000000061e-06 2.8423255614203802
+ 1.897500000000061e-06 2.8423285988436011
+ 1.898500000000062e-06 2.8423256693995942
+ 1.899500000000062e-06 2.8423286926234201
+ 1.9005000000000621e-06 2.842325776215556
+ 1.901500000000062e-06 2.8423287845336032
+ 1.902500000000062e-06 2.8423258816442591
+ 1.9035000000000619e-06 2.8423288748853812
+ 1.904500000000062e-06 2.8423259854087131
+ 1.9055000000000621e-06 2.8423289639930318
+ 1.9065000000000619e-06 2.8423260872771881
+ 1.9075000000000622e-06 2.842329052080979
+ 1.9085000000000619e-06 2.8423261871425152
+ 1.9095000000000619e-06 2.8423291392229961
+ 1.910500000000062e-06 2.8423262850601971
+ 1.9115000000000629e-06 2.842329225331043
+ 1.912500000000063e-06 2.8423263812321768
+ 1.9135000000000631e-06 2.8423293101953369
+ 1.9145000000000632e-06 2.8423264759462761
+ 1.9155000000000628e-06 2.8423293935621761
+ 1.9165000000000629e-06 2.842326569488375
+ 1.917500000000063e-06 2.8423294752227228
+ 1.918500000000063e-06 2.8423266620593051
+ 1.9195000000000631e-06 2.8423295550848251
+ 1.9205000000000632e-06 2.8423267537201111
+ 1.9215000000000628e-06 2.8423296332058592
+ 1.9225000000000629e-06 2.8423268443838521
+ 1.923500000000063e-06 2.8423297097761631
+ 1.9245000000000631e-06 2.842326933855444
+ 1.925500000000064e-06 2.842329785060572
+ 1.9265000000000641e-06 2.8423270219022769
+ 1.9275000000000641e-06 2.842329859319435
+ 1.9285000000000642e-06 2.842327108336804
+ 1.9295000000000639e-06 2.8423299327313529
+ 1.9305000000000639e-06 2.8423271930808771
+ 1.931500000000064e-06 2.8423300053461849
+ 1.9325000000000641e-06 2.842327276192917
+ 1.9335000000000642e-06 2.8423300770789011
+ 1.9345000000000638e-06 2.8423273578518939
+ 1.9355000000000639e-06 2.842330147747254
+ 1.936500000000064e-06 2.8423274383022341
+ 1.937500000000064e-06 2.842330217138314
+ 1.938500000000065e-06 2.842327517780884
+ 1.939500000000065e-06 2.8423302850835639
+ 1.9405000000000651e-06 2.8423275964467578
+ 1.9415000000000652e-06 2.8423303515165901
+ 1.9425000000000648e-06 2.8423276743403632
+ 1.9435000000000649e-06 2.8423304164962868
+ 1.944500000000065e-06 2.8423277513787268
+ 1.9455000000000651e-06 2.8423304801906029
+ 1.9465000000000651e-06 2.842327827392328
+ 1.9475000000000652e-06 2.8423305428246879
+ 1.9485000000000649e-06 2.842327902186724
+ 1.9495000000000649e-06 2.842330604613299
+ 1.950500000000065e-06 2.8423279756110129
+ 1.9515000000000659e-06 2.8423306656979901
+ 1.952500000000066e-06 2.84232804760908
+ 1.9535000000000661e-06 2.84233072611024
+ 1.9545000000000662e-06 2.842328118240423
+ 1.9555000000000658e-06 2.8423307857696769
+ 1.9565000000000659e-06 2.8423281876624942
+ 1.957500000000066e-06 2.8423308445186639
+ 1.958500000000066e-06 2.8423282560822738
+ 1.9595000000000661e-06 2.8423309021794689
+ 1.9605000000000662e-06 2.8423283236950811
+ 1.9615000000000658e-06 2.842330958616579
+ 1.9625000000000659e-06 2.8423283906269998
+ 1.963500000000066e-06 2.842331013782855
+ 1.9645000000000661e-06 2.8423284569023162
+ 1.965500000000067e-06 2.8423310677373381
+ 1.9665000000000671e-06 2.84232852244349
+ 1.9675000000000671e-06 2.8423311206271422
+ 1.9685000000000672e-06 2.842328587104066
+ 1.9695000000000669e-06 2.8423311726430942
+ 1.9705000000000669e-06 2.84232865072175
+ 1.971500000000067e-06 2.842331223962093
+ 1.9725000000000671e-06 2.8423287131753638
+ 1.9735000000000672e-06 2.8423312746957561
+ 1.9745000000000668e-06 2.8423287744262939
+ 1.9755000000000669e-06 2.8423313248618598
+ 1.976500000000067e-06 2.842328834532927
+ 1.977500000000067e-06 2.8423313743856462
+ 1.978500000000068e-06 2.842328893632962
+ 1.979500000000068e-06 2.8423314231308141
+ 1.9805000000000681e-06 2.8423289519021222
+ 1.9815000000000682e-06 2.8423314709495342
+ 1.9825000000000678e-06 2.8423290095004581
+ 1.9835000000000679e-06 2.8423315177333781
+ 1.984500000000068e-06 2.842329066527097
+ 1.9855000000000681e-06 2.8423315634506778
+ 1.9865000000000681e-06 2.8423291229946668
+ 1.9875000000000678e-06 2.8423316081584238
+ 1.9885000000000679e-06 2.8423291788313829
+ 1.9895000000000679e-06 2.8423316519852491
+ 1.990500000000068e-06 2.842329233911324
+ 1.9915000000000689e-06 2.8423316950921329
+ 1.992500000000069e-06 2.8423292880996631
+ 1.9935000000000691e-06 2.8423317376243622
+ 1.9945000000000692e-06 2.842329341299564
+ 1.9955000000000688e-06 2.842331779669621
+ 1.9965000000000689e-06 2.842329393485695
+ 1.997500000000069e-06 2.842331821235383
+ 1.998500000000069e-06 2.8423294447138181
+ 1.9995000000000691e-06 2.8423318622531659
+ 2.0005000000000692e-06 2.842329495104067
+ 2.0015000000000688e-06 2.842331902606114
+ 2.0025000000000689e-06 2.8423295448046648
+ 2.003500000000069e-06 2.8423319421709912
+ 2.0045000000000691e-06 2.8423295939470652
+ 2.00550000000007e-06 2.8423319808614829
+ 2.0065000000000701e-06 2.8423296426089828
+ 2.0075000000000701e-06 2.8423320186574732
+ 2.0085000000000698e-06 2.8423296907939761
+ 2.0095000000000699e-06 2.8423320556132041
+ 2.0105000000000699e-06 2.8423297384367552
+ 2.01150000000007e-06 2.8423320918403681
+ 2.0125000000000701e-06 2.8423297854294178
+ 2.0135000000000702e-06 2.842332127474978
+ 2.0145000000000698e-06 2.8423298316597099
+ 2.0155000000000699e-06 2.842332162636048
+ 2.01650000000007e-06 2.8423298770508172
+ 2.01750000000007e-06 2.8423321973918361
+ 2.018500000000071e-06 2.8423299215874391
+ 2.019500000000071e-06 2.8423322317425801
+ 2.0205000000000711e-06 2.8423299653221679
+ 2.0215000000000712e-06 2.8423322656258518
+ 2.0225000000000708e-06 2.8423300083595868
+ 2.0235000000000709e-06 2.8423322989415061
+ 2.024500000000071e-06 2.8423300508243221
+ 2.0255000000000711e-06 2.8423323315875151
+ 2.0265000000000711e-06 2.8423300928242372
+ 2.0275000000000708e-06 2.8423323634952742
+ 2.0285000000000709e-06 2.8423301344193881
+ 2.0295000000000709e-06 2.8423323946537291
+ 2.030500000000071e-06 2.8423301756071289
+ 2.0315000000000719e-06 2.8423324251134039
+ 2.032500000000072e-06 2.8423302163284641
+ 2.0335000000000721e-06 2.8423324549715621
+ 2.0345000000000722e-06 2.8423302564907722
+ 2.0355000000000718e-06 2.84233248434245
+ 2.0365000000000719e-06 2.8423302960014518
+ 2.037500000000072e-06 2.842332513323238
+ 2.038500000000072e-06 2.8423303347999669
+ 2.0395000000000721e-06 2.8423325419664001
+ 2.0405000000000722e-06 2.8423303728786782
+ 2.0415000000000718e-06 2.8423325702669842
+ 2.0425000000000719e-06 2.842330410286436
+ 2.043500000000072e-06 2.8423325981689578
+ 2.0445000000000721e-06 2.8423304471135409
+ 2.045500000000073e-06 2.8423326255866548
+ 2.0465000000000731e-06 2.842330483465076
+ 2.0475000000000731e-06 2.842332652435823
+ 2.0485000000000728e-06 2.842330519428673
+ 2.0495000000000729e-06 2.8423326786628631
+ 2.0505000000000729e-06 2.8423305550502271
+ 2.051500000000073e-06 2.8423327042628781
+ 2.0525000000000731e-06 2.842330590323348
+ 2.0535000000000732e-06 2.8423327292825471
+ 2.0545000000000728e-06 2.8423306251950691
+ 2.0555000000000729e-06 2.8423327538056489
+ 2.056500000000073e-06 2.842330659586445
+ 2.0575000000000731e-06 2.842332777928398
+ 2.058500000000074e-06 2.842330693420887
+ 2.059500000000074e-06 2.842332801729782
+ 2.0605000000000741e-06 2.842330726650979
+ 2.0615000000000742e-06 2.8423328252502502
+ 2.0625000000000738e-06 2.8423307592744682
+ 2.0635000000000739e-06 2.842332848481
+ 2.064500000000074e-06 2.8423307913367362
+ 2.0655000000000741e-06 2.8423328713716569
+ 2.0665000000000742e-06 2.8423308229156001
+ 2.0675000000000738e-06 2.8423328938497319
+ 2.0685000000000739e-06 2.8423308540989569
+ 2.069500000000074e-06 2.8423329158457791
+ 2.070500000000074e-06 2.8423308849579469
+ 2.0715000000000749e-06 2.8423329373176398
+ 2.072500000000075e-06 2.8423309155280809
+ 2.0735000000000751e-06 2.8423329582651822
+ 2.0745000000000752e-06 2.8423309457995432
+ 2.0755000000000748e-06 2.842332978731509
+ 2.0765000000000749e-06 2.842330975724936
+ 2.077500000000075e-06 2.8423329987888928
+ 2.0785000000000751e-06 2.8423310052372961
+ 2.0795000000000751e-06 2.8423330185176301
+ 2.0805000000000752e-06 2.8423310342737338
+ 2.0815000000000749e-06 2.842333037982034
+ 2.0825000000000749e-06 2.8423310627972329
+ 2.083500000000075e-06 2.8423330572120729
+ 2.0845000000000759e-06 2.8423310908102031
+ 2.085500000000076e-06 2.8423330761972538
+ 2.0865000000000761e-06 2.8423311183532989
+ 2.0875000000000762e-06 2.8423330948924548
+ 2.0885000000000758e-06 2.8423311454941702
+ 2.0895000000000759e-06 2.842333113236192
+ 2.090500000000076e-06 2.8423311723057649
+ 2.091500000000076e-06 2.8423331311714879
+ 2.0925000000000761e-06 2.8423311988460469
+ 2.0935000000000762e-06 2.8423331486659009
+ 2.0945000000000758e-06 2.8423312251411068
+ 2.0955000000000759e-06 2.8423331657230282
+ 2.096500000000076e-06 2.842331251179619
+ 2.0975000000000761e-06 2.8423331823815041
+ 2.098500000000077e-06 2.8423312769197699
+ 2.0995000000000771e-06 2.8423331987034088
+ 2.1005000000000771e-06 2.842331302304856
+ 2.1015000000000772e-06 2.842333214755858
+ 2.1025000000000769e-06 2.8423313272831772
+ 2.1035000000000769e-06 2.8423332305908802
+ 2.104500000000077e-06 2.8423313518265818
+ 2.1055000000000771e-06 2.842333246230333
+ 2.1065000000000772e-06 2.8423313759401898
+ 2.1075000000000768e-06 2.8423332616626462
+ 2.1085000000000769e-06 2.842331399660416
+ 2.109500000000077e-06 2.842333276848414
+ 2.110500000000077e-06 2.8423314230451422
+ 2.111500000000078e-06 2.8423332917351418
+ 2.112500000000078e-06 2.842331446155772
+ 2.1135000000000781e-06 2.842333306276287
+ 2.1145000000000782e-06 2.842331469038724
+ 2.1155000000000778e-06 2.842333320447064
+ 2.1165000000000779e-06 2.8423314917133289
+ 2.117500000000078e-06 2.8423333342531851
+ 2.1185000000000781e-06 2.842331514167642
+ 2.1195000000000781e-06 2.842333347729264
+ 2.1205000000000782e-06 2.8423315363644401
+ 2.1215000000000779e-06 2.8423333609293162
+ 2.1225000000000779e-06 2.8423315582554491
+ 2.123500000000078e-06 2.8423333739086698
+ 2.1245000000000789e-06 2.8423315797991728
+ 2.125500000000079e-06 2.842333386709063
+ 2.1265000000000791e-06 2.8423316009740351
+ 2.1275000000000792e-06 2.8423333993466828
+ 2.1285000000000788e-06 2.8423316217867338
+ 2.1295000000000789e-06 2.8423334118090788
+ 2.130500000000079e-06 2.8423316422703051
+ 2.131500000000079e-06 2.842333424061791
+ 2.1325000000000791e-06 2.8423316624738328
+ 2.1335000000000792e-06 2.842333436060517
+ 2.1345000000000788e-06 2.842331682448977
+ 2.1355000000000789e-06 2.8423334477668591
+ 2.136500000000079e-06 2.8423317022327259
+ 2.1375000000000791e-06 2.8423334591629308
+ 2.13850000000008e-06 2.8423317218386681
+ 2.1395000000000801e-06 2.842333470255507
+ 2.1405000000000801e-06 2.8423317412548639
+ 2.1415000000000802e-06 2.8423334810756189
+ 2.1425000000000799e-06 2.8423317604487108
+ 2.1435000000000799e-06 2.8423334916689909
+ 2.14450000000008e-06 2.842331779379951
+ 2.1455000000000801e-06 2.8423335020818028
+ 2.1465000000000802e-06 2.8423317980143099
+ 2.1475000000000798e-06 2.8423335123476989
+ 2.1485000000000799e-06 2.8423318163357569
+ 2.14950000000008e-06 2.8423335224780182
+ 2.15050000000008e-06 2.842331834352068
+ 2.151500000000081e-06 2.8423335324603021
+ 2.152500000000081e-06 2.8423318520928218
+ 2.1535000000000811e-06 2.842333542264325
+ 2.1545000000000812e-06 2.8423318696000162
+ 2.1555000000000808e-06 2.842333551852716
+ 2.1565000000000809e-06 2.842331886916003
+ 2.157500000000081e-06 2.842333561194931
+ 2.1585000000000811e-06 2.8423319040706092
+ 2.1595000000000811e-06 2.8423335702771939
+ 2.1605000000000808e-06 2.84233192107334
+ 2.1615000000000809e-06 2.8423335791073079
+ 2.1625000000000809e-06 2.8423319379123622
+ 2.163500000000081e-06 2.8423335877127429
+ 2.1645000000000819e-06 2.8423319545594832
+ 2.165500000000082e-06 2.8423335961322329
+ 2.1665000000000821e-06 2.842331970980692
+ 2.1675000000000822e-06 2.8423336044045482
+ 2.1685000000000818e-06 2.842331987148206
+ 2.1695000000000819e-06 2.8423336125559162
+ 2.170500000000082e-06 2.8423320030505761
+ 2.171500000000082e-06 2.842333620594419
+ 2.1725000000000821e-06 2.8423320186956138
+ 2.1735000000000822e-06 2.8423336285083338
+ 2.1745000000000818e-06 2.84233203410942
+ 2.1755000000000819e-06 2.8423336362709399
+ 2.176500000000082e-06 2.8423320493280588
+ 2.1775000000000821e-06 2.8423336438511591
+ 2.178500000000083e-06 2.842332064386456
+ 2.1795000000000831e-06 2.8423336512239228
+ 2.1805000000000831e-06 2.842332079308731
+ 2.1815000000000828e-06 2.842333658379097
+ 2.1825000000000829e-06 2.842332094101109
+ 2.1835000000000829e-06 2.84233366532502
+ 2.184500000000083e-06 2.8423321087521218
+ 2.1855000000000831e-06 2.8423336720861259
+ 2.1865000000000832e-06 2.84233212323704
+ 2.1875000000000828e-06 2.8423336786953151
+ 2.1885000000000829e-06 2.8423321375275941
+ 2.189500000000083e-06 2.84233368518451
+ 2.190500000000083e-06 2.8423321516013682
+ 2.191500000000084e-06 2.842333691574733
+ 2.192500000000084e-06 2.8423321654497951
+ 2.1935000000000841e-06 2.842333697871295
+ 2.1945000000000842e-06 2.842332179081331
+ 2.1955000000000838e-06 2.84233370406265
+ 2.1965000000000839e-06 2.842332192519196
+ 2.197500000000084e-06 2.842333710125529
+ 2.1985000000000841e-06 2.8423322057939688
+ 2.1995000000000841e-06 2.8423337160341058
+ 2.2005000000000838e-06 2.842332218934104
+ 2.2015000000000839e-06 2.8423337217686191
+ 2.2025000000000839e-06 2.8423322319586641
+ 2.203500000000084e-06 2.84233372732144
+ 2.2045000000000849e-06 2.8423322448718369
+ 2.205500000000085e-06 2.8423337327011731
+ 2.2065000000000851e-06 2.8423322576624428
+ 2.2075000000000852e-06 2.842333737929271
+ 2.2085000000000848e-06 2.8423322703093579
+ 2.2095000000000849e-06 2.8423337430334992
+ 2.210500000000085e-06 2.8423322827888229
+ 2.211500000000085e-06 2.842333748040232
+ 2.2125000000000851e-06 2.8423322950830392
+ 2.2135000000000852e-06 2.8423337529656392
+ 2.2145000000000848e-06 2.842332307186425
+ 2.2155000000000849e-06 2.8423337578130772
+ 2.216500000000085e-06 2.8423323191068799
+ 2.2175000000000851e-06 2.8423337625719838
+ 2.218500000000086e-06 2.8423323308645578
+ 2.2195000000000861e-06 2.8423337672224158
+ 2.2205000000000861e-06 2.8423323424853399
+ 2.2215000000000858e-06 2.8423337717429549
+ 2.2225000000000859e-06 2.8423323539926701
+ 2.2235000000000859e-06 2.8423337761173348
+ 2.224500000000086e-06 2.8423323654019512
+ 2.2255000000000861e-06 2.842333780340387
+ 2.2265000000000862e-06 2.842332376715393
+ 2.2275000000000858e-06 2.8423337844203069
+ 2.2285000000000859e-06 2.842332387922677
+ 2.229500000000086e-06 2.8423337883760391
+ 2.230500000000086e-06 2.842332399005425
+ 2.231500000000087e-06 2.8423337922312548
+ 2.232500000000087e-06 2.8423324099438929
+ 2.2335000000000871e-06 2.842333796007082
+ 2.2345000000000872e-06 2.8423324207241221
+ 2.2355000000000868e-06 2.842333799716886
+ 2.2365000000000869e-06 2.8423324313418981
+ 2.237500000000087e-06 2.842333803362048
+ 2.2385000000000871e-06 2.8423324418053402
+ 2.2395000000000871e-06 2.8423338069327468
+ 2.2405000000000868e-06 2.8423324521320712
+ 2.2415000000000869e-06 2.842333810411882
+ 2.2425000000000869e-06 2.8423324623438559
+ 2.243500000000087e-06 2.8423338137814049
+ 2.2445000000000879e-06 2.8423324724602681
+ 2.245500000000088e-06 2.8423338170284418
+ 2.2465000000000881e-06 2.8423324824929961
+ 2.2475000000000882e-06 2.8423338201499289
+ 2.2485000000000878e-06 2.8423324924427109
+ 2.2495000000000879e-06 2.8423338231537669
+ 2.250500000000088e-06 2.8423325023000121
+ 2.251500000000088e-06 2.842333826056306
+ 2.2525000000000881e-06 2.8423325120494112
+ 2.2535000000000882e-06 2.8423338288772859
+ 2.2545000000000879e-06 2.8423325216744439
+ 2.2555000000000879e-06 2.8423338316342539
+ 2.256500000000088e-06 2.8423325311640149
+ 2.2575000000000889e-06 2.8423338343373472
+ 2.258500000000089e-06 2.8423325405156432
+ 2.2595000000000891e-06 2.8423338369868052
+ 2.2605000000000891e-06 2.842332549737169
+ 2.2615000000000888e-06 2.8423338395735458
+ 2.2625000000000889e-06 2.8423325588437618
+ 2.263500000000089e-06 2.842333842083185
+ 2.264500000000089e-06 2.8423325678535121
+ 2.2655000000000891e-06 2.8423338445010429
+ 2.2665000000000892e-06 2.8423325767823711
+ 2.2675000000000888e-06 2.8423338468167101
+ 2.2685000000000889e-06 2.842332585639312
+ 2.269500000000089e-06 2.8423338490286691
+ 2.2705000000000891e-06 2.8423325944243838
+ 2.27150000000009e-06 2.8423338511438079
+ 2.2725000000000901e-06 2.8423326031292149
+ 2.2735000000000901e-06 2.8423338531763971
+ 2.2745000000000902e-06 2.842332611740443
+ 2.2755000000000899e-06 2.8423338551429631
+ 2.2765000000000899e-06 2.8423326202448149
+ 2.27750000000009e-06 2.8423338570578029
+ 2.2785000000000901e-06 2.8423326286329762
+ 2.2795000000000902e-06 2.842333858929138
+ 2.2805000000000898e-06 2.8423326369037971
+ 2.2815000000000899e-06 2.842333860756399
+ 2.28250000000009e-06 2.842332645064324
+ 2.28350000000009e-06 2.8423338625313672
+ 2.284500000000091e-06 2.8423326531277051
+ 2.285500000000091e-06 2.842333864241926
+ 2.2865000000000911e-06 2.8423326611093001
+ 2.2875000000000912e-06 2.8423338658752901
+ 2.2885000000000908e-06 2.842332669022523
+ 2.2895000000000909e-06 2.842333867423501
+ 2.290500000000091e-06 2.8423326768742321
+ 2.2915000000000911e-06 2.842333868885762
+ 2.2925000000000911e-06 2.8423326846635271
+ 2.2935000000000912e-06 2.8423338702688561
+ 2.2945000000000909e-06 2.842332692382965
+ 2.2955000000000909e-06 2.8423338715849051
+ 2.296500000000091e-06 2.842332700021025
+ 2.2975000000000919e-06 2.842333872848096
+ 2.298500000000092e-06 2.8423327075664488
+ 2.2995000000000921e-06 2.8423338740702508
+ 2.3005000000000922e-06 2.8423327150121058
+ 2.3015000000000918e-06 2.8423338752573368
+ 2.3025000000000919e-06 2.842332722358019
+ 2.303500000000092e-06 2.8423338764078139
+ 2.304500000000092e-06 2.8423327296105669
+ 2.3055000000000921e-06 2.8423338775149429
+ 2.3065000000000922e-06 2.8423327367811391
+ 2.3075000000000918e-06 2.842333878567731
+ 2.3085000000000919e-06 2.8423327438829551
+ 2.309500000000092e-06 2.8423338795561031
+ 2.3105000000000921e-06 2.842332750926138
+ 2.311500000000093e-06 2.8423338804739928
+ 2.3125000000000931e-06 2.8423327579162971
+ 2.3135000000000931e-06 2.8423338813210579
+ 2.3145000000000932e-06 2.8423327648521051
+ 2.3155000000000929e-06 2.8423338821037349
+ 2.3165000000000929e-06 2.8423327717265781
+ 2.317500000000093e-06 2.8423338828327109
+ 2.3185000000000931e-06 2.842332778529987
+ 2.3195000000000932e-06 2.8423338835194021
+ 2.3205000000000928e-06 2.842332785253737
+ 2.3215000000000929e-06 2.842333884172966
+ 2.322500000000093e-06 2.842332791892205
+ 2.323500000000093e-06 2.8423338847983159
+ 2.324500000000094e-06 2.842332798445423
+ 2.325500000000094e-06 2.8423338853939968
+ 2.3265000000000941e-06 2.84233280491947
+ 2.3275000000000942e-06 2.842333885953451
+ 2.3285000000000938e-06 2.8423328113242472
+ 2.3295000000000939e-06 2.8423338864678112
+ 2.330500000000094e-06 2.8423328176702012
+ 2.3315000000000941e-06 2.8423338869287291
+ 2.3325000000000941e-06 2.8423328239662018
+ 2.3335000000000942e-06 2.8423338873313821
+ 2.3345000000000939e-06 2.8423328302161091
+ 2.3355000000000939e-06 2.842333887676149
+ 2.336500000000094e-06 2.842332836418469
+ 2.3375000000000949e-06 2.8423338879685449
+ 2.338500000000095e-06 2.8423328425675232
+ 2.3395000000000951e-06 2.8423338882173601
+ 2.3405000000000952e-06 2.8423328486549422
+ 2.3415000000000948e-06 2.842333888432742
+ 2.3425000000000949e-06 2.8423328546730762
+ 2.343500000000095e-06 2.8423338886223011
+ 2.344500000000095e-06 2.84233286061778
+ 2.3455000000000951e-06 2.8423338887894531
+ 2.3465000000000952e-06 2.842332866489734
+ 2.3475000000000948e-06 2.8423338889324059
+ 2.3485000000000949e-06 2.8423328722944361
+ 2.349500000000095e-06 2.8423338890453969
+ 2.3505000000000951e-06 2.8423328780403478
+ 2.351500000000096e-06 2.842333889120872
+ 2.3525000000000961e-06 2.8423328837363431
+ 2.3535000000000961e-06 2.8423338891521159
+ 2.3545000000000962e-06 2.842332889389334
+ 2.3555000000000959e-06 2.842333889135376
+ 2.3565000000000959e-06 2.8423328950022442
+ 2.357500000000096e-06 2.8423338890715679
+ 2.3585000000000961e-06 2.842332900573215
+ 2.3595000000000962e-06 2.8423338889656029
+ 2.3605000000000958e-06 2.8423329060973979
+ 2.3615000000000959e-06 2.8423338888251202
+ 2.362500000000096e-06 2.842332911567651
+ 2.363500000000096e-06 2.842333888658263
+ 2.364500000000097e-06 2.8423329169780489
+ 2.365500000000097e-06 2.842333888471118
+ 2.3665000000000971e-06 2.8423329223255309
+ 2.3675000000000972e-06 2.8423338882658671
+ 2.3685000000000968e-06 2.8423329276109981
+ 2.3695000000000969e-06 2.8423338880411908
+ 2.370500000000097e-06 2.8423329328390752
+ 2.3715000000000971e-06 2.8423338877919702
+ 2.3725000000000971e-06 2.8423329380168512
+ 2.3735000000000968e-06 2.842333887512134
+ 2.3745000000000969e-06 2.8423329431518871
+ 2.3755000000000969e-06 2.842333887195907
+ 2.376500000000097e-06 2.8423329482494979
+ 2.3775000000000979e-06 2.8423338868405832
+ 2.378500000000098e-06 2.8423329533122019
+ 2.3795000000000981e-06 2.8423338864467729
+ 2.3805000000000982e-06 2.8423329583384538
+ 2.3815000000000978e-06 2.8423338860190581
+ 2.3825000000000979e-06 2.842332963323464
+ 2.383500000000098e-06 2.8423338855640981
+ 2.384500000000098e-06 2.842332968261474
+ 2.3855000000000981e-06 2.8423338850884239
+ 2.3865000000000982e-06 2.8423329731475659
+ 2.3875000000000978e-06 2.8423338845971
+ 2.3885000000000979e-06 2.842332977979428
+ 2.389500000000098e-06 2.8423338840919592
+ 2.3905000000000981e-06 2.8423329827579229
+ 2.391500000000099e-06 2.8423338835713872
+ 2.3925000000000991e-06 2.8423329874871621
+ 2.3935000000000991e-06 2.8423338830312019
+ 2.3945000000000988e-06 2.842332992173243
+ 2.3955000000000989e-06 2.8423338824657258
+ 2.3965000000000989e-06 2.8423329968227251
+ 2.397500000000099e-06 2.842333881870386
+ 2.3985000000000991e-06 2.842333001440124
+ 2.3995000000000992e-06 2.8423338812430639
+ 2.4005000000000988e-06 2.8423330060268168
+ 2.4015000000000989e-06 2.8423338805847629
+ 2.402500000000099e-06 2.842333010581378
+ 2.403500000000099e-06 2.8423338798993472
+ 2.4045000000001e-06 2.842333015099864
+ 2.4055000000001e-06 2.8423338791925712
+ 2.4065000000001001e-06 2.8423330195770018
+ 2.4075000000001002e-06 2.8423338784701682
+ 2.4085000000000998e-06 2.842333024008981
+ 2.4095000000000999e-06 2.842333877735963
+ 2.4105000000001e-06 2.8423330283938819
+ 2.4115000000001001e-06 2.842333876991296
+ 2.4125000000001001e-06 2.8423330327329248
+ 2.4135000000000998e-06 2.8423338762344201
+ 2.4145000000000999e-06 2.8423330370299391
+ 2.4155000000000999e-06 2.8423338754616219
+ 2.4165000000001e-06 2.8423330412899879
+ 2.4175000000001009e-06 2.842333874668372
+ 2.418500000000101e-06 2.8423330455183011
+ 2.4195000000001011e-06 2.8423338738509889
+ 2.4205000000001012e-06 2.8423330497185759
+ 2.4215000000001008e-06 2.8423338730075729
+ 2.4225000000001009e-06 2.842333053892045
+ 2.423500000000101e-06 2.842333872139478
+ 2.424500000000101e-06 2.842333058036921
+ 2.4255000000001011e-06 2.8423338712501041
+ 2.4265000000001012e-06 2.8423330621499119
+ 2.4275000000001008e-06 2.8423338703441692
+ 2.4285000000001009e-06 2.8423330662268169
+ 2.429500000000101e-06 2.8423338694263758
+ 2.4305000000001011e-06 2.8423330702642411
+ 2.431500000000102e-06 2.8423338685000372
+ 2.4325000000001021e-06 2.8423330742610502
+ 2.4335000000001021e-06 2.8423338675658649
+ 2.4345000000001018e-06 2.8423330782182639
+ 2.4355000000001019e-06 2.842333866622377
+ 2.4365000000001019e-06 2.842333082139116
+ 2.437500000000102e-06 2.8423338656664021
+ 2.4385000000001021e-06 2.842333086028102
+ 2.4395000000001022e-06 2.8423338646938978
+ 2.4405000000001018e-06 2.8423330898897561
+ 2.4415000000001019e-06 2.8423338637016928
+ 2.442500000000102e-06 2.842333093727003
+ 2.4435000000001021e-06 2.842333862688724
+ 2.444500000000103e-06 2.8423330975404619
+ 2.445500000000103e-06 2.8423338616561979
+ 2.4465000000001031e-06 2.8423331013285269
+ 2.4475000000001032e-06 2.842333860607213
+ 2.4485000000001028e-06 2.842333105088326
+ 2.4495000000001029e-06 2.8423338595457111
+ 2.450500000000103e-06 2.8423331088162769
+ 2.4515000000001031e-06 2.8423338584757611
+ 2.4525000000001032e-06 2.8423331125096531
+ 2.4535000000001028e-06 2.8423338573997978
+ 2.4545000000001029e-06 2.8423331161677021
+ 2.455500000000103e-06 2.8423338563182812
+ 2.456500000000103e-06 2.8423331197916011
+ 2.4575000000001039e-06 2.8423338552295601
+ 2.458500000000104e-06 2.8423331233843321
+ 2.4595000000001041e-06 2.84233385413093
+ 2.4605000000001042e-06 2.842333126949669
+ 2.4615000000001038e-06 2.8423338530190621
+ 2.4625000000001039e-06 2.8423331304911641
+ 2.463500000000104e-06 2.842333851891508
+ 2.4645000000001041e-06 2.8423331340111702
+ 2.4655000000001041e-06 2.8423338507476248
+ 2.4665000000001042e-06 2.8423331375098329
+ 2.4675000000001039e-06 2.8423338495886452
+ 2.4685000000001039e-06 2.8423331409858572
+ 2.469500000000104e-06 2.8423338484170899
+ 2.4705000000001049e-06 2.8423331444366502
+ 2.471500000000105e-06 2.842333847236584
+ 2.4725000000001051e-06 2.842333147859101
+ 2.4735000000001052e-06 2.8423338460502459
+ 2.4745000000001048e-06 2.8423331512514589
+ 2.4755000000001049e-06 2.842333844859763
+ 2.476500000000105e-06 2.84233315461322
+ 2.477500000000105e-06 2.8423338436653829
+ 2.4785000000001051e-06 2.8423331579454589
+ 2.4795000000001052e-06 2.842333842465762
+ 2.4805000000001048e-06 2.84233316125081
+ 2.4815000000001049e-06 2.842333841258383
+ 2.482500000000105e-06 2.8423331645323322
+ 2.4835000000001051e-06 2.8423338400407512
+ 2.484500000000106e-06 2.8423331677929058
+ 2.4855000000001061e-06 2.8423338388108998
+ 2.4865000000001061e-06 2.842333171034352
+ 2.4875000000001062e-06 2.842333837568304
+ 2.4885000000001059e-06 2.8423331742568738
+ 2.4895000000001059e-06 2.8423338363141322
+ 2.490500000000106e-06 2.8423331774589342
+ 2.4915000000001061e-06 2.8423338350508969
+ 2.4925000000001062e-06 2.8423331806384011
+ 2.4935000000001058e-06 2.8423338337812352
+ 2.4945000000001059e-06 2.842333183793031
+ 2.495500000000106e-06 2.8423338325077552
+ 2.496500000000106e-06 2.8423331869212132
+ 2.497500000000107e-06 2.8423338312317772
+ 2.498500000000107e-06 2.842333190022702
+ 2.4995000000001071e-06 2.8423338299535188
+ 2.5005000000001072e-06 2.8423331930984221
+ 2.5015000000001068e-06 2.8423338286715878
+ 2.5025000000001069e-06 2.8423331961509191
+ 2.503500000000107e-06 2.8423338273837082
+ 2.5045000000001071e-06 2.842333199182717
+ 2.5055000000001071e-06 2.8423338260879851
+ 2.5065000000001072e-06 2.8423332021959249
+ 2.5075000000001069e-06 2.842333824783049
+ 2.5085000000001069e-06 2.8423332051919661
+ 2.509500000000107e-06 2.8423338234684472
+ 2.5105000000001079e-06 2.842333208170984
+ 2.511500000000108e-06 2.8423338221452652
+ 2.5125000000001081e-06 2.8423332111316402
+ 2.5135000000001082e-06 2.842333820815544
+ 2.5145000000001078e-06 2.842333214072156
+ 2.5155000000001079e-06 2.8423338194815679
+ 2.516500000000108e-06 2.8423332169906761
+ 2.517500000000108e-06 2.842333818145466
+ 2.5185000000001081e-06 2.842333219885917
+ 2.5195000000001082e-06 2.8423338168081731
+ 2.5205000000001078e-06 2.8423332227578508
+ 2.5215000000001079e-06 2.84233381546969
+ 2.522500000000108e-06 2.8423332256074429
+ 2.5235000000001081e-06 2.8423338141289101
+ 2.524500000000109e-06 2.842333228436523
+ 2.5255000000001091e-06 2.842333812784096
+ 2.5265000000001091e-06 2.842333231247304
+ 2.5275000000001092e-06 2.842333811433436
+ 2.5285000000001089e-06 2.8423332340417899
+ 2.5295000000001089e-06 2.8423338100757962
+ 2.530500000000109e-06 2.842333236820878
+ 2.5315000000001091e-06 2.8423338087110221
+ 2.5325000000001092e-06 2.8423332395845669
+ 2.5335000000001088e-06 2.8423338073401809
+ 2.5345000000001089e-06 2.842333242331724
+ 2.535500000000109e-06 2.8423338059648628
+ 2.536500000000109e-06 2.8423332450608689
+ 2.53750000000011e-06 2.8423338045871129
+ 2.53850000000011e-06 2.842333247770306
+ 2.5395000000001101e-06 2.842333803208652
+ 2.5405000000001102e-06 2.842333250459236
+ 2.5415000000001098e-06 2.842333801830045
+ 2.5425000000001099e-06 2.8423332531277339
+ 2.54350000000011e-06 2.8423338004511862
+ 2.5445000000001101e-06 2.8423332557767069
+ 2.5455000000001101e-06 2.8423337990711408
+ 2.5465000000001098e-06 2.8423332584076841
+ 2.5475000000001099e-06 2.8423337976884571
+ 2.5485000000001099e-06 2.8423332610225001
+ 2.54950000000011e-06 2.8423337963015798
+ 2.5505000000001109e-06 2.8423332636227898
+ 2.551500000000111e-06 2.8423337949097931
+ 2.5525000000001111e-06 2.842333266209061
+ 2.5535000000001112e-06 2.8423337935130668
+ 2.5545000000001108e-06 2.8423332687814229
+ 2.5555000000001109e-06 2.8423337921121439
+ 2.556500000000111e-06 2.84233327133889
+ 2.557500000000111e-06 2.842333790708528
+ 2.5585000000001111e-06 2.8423332738800871
+ 2.5595000000001112e-06 2.8423337893038858
+ 2.5605000000001108e-06 2.8423332764038052
+ 2.5615000000001109e-06 2.8423337878995221
+ 2.562500000000111e-06 2.8423332789093609
+ 2.5635000000001111e-06 2.8423337864959648
+ 2.564500000000112e-06 2.8423332813967681
+ 2.5655000000001121e-06 2.842333785093107
+ 2.5665000000001121e-06 2.842333283866993
+ 2.5675000000001118e-06 2.8423337836898872
+ 2.5685000000001119e-06 2.8423332863214341
+ 2.5695000000001119e-06 2.8423337822850492
+ 2.570500000000112e-06 2.8423332887616359
+ 2.5715000000001121e-06 2.8423337808775679
+ 2.5725000000001122e-06 2.8423332911886532
+ 2.5735000000001118e-06 2.8423337794667618
+ 2.5745000000001119e-06 2.8423332936031191
+ 2.575500000000112e-06 2.8423337780527209
+ 2.576500000000112e-06 2.842333296004762
+ 2.577500000000113e-06 2.842333776636313
+ 2.578500000000113e-06 2.8423332983927718
+ 2.5795000000001131e-06 2.8423337752186
+ 2.5805000000001132e-06 2.8423333007661902
+ 2.5815000000001128e-06 2.8423337738009882
+ 2.5825000000001129e-06 2.8423333031240019
+ 2.583500000000113e-06 2.8423337723843769
+ 2.5845000000001131e-06 2.842333305465746
+ 2.5855000000001131e-06 2.8423337709692769
+ 2.5865000000001128e-06 2.8423333077914692
+ 2.5875000000001129e-06 2.8423337695554571
+ 2.5885000000001129e-06 2.8423333101019921
+ 2.589500000000113e-06 2.8423337681420962
+ 2.5905000000001139e-06 2.8423333123984329
+ 2.591500000000114e-06 2.8423337667282209
+ 2.5925000000001141e-06 2.842333314682099
+ 2.5935000000001142e-06 2.8423337653128349
+ 2.5945000000001138e-06 2.8423333169538951
+ 2.5955000000001139e-06 2.842333763895625
+ 2.596500000000114e-06 2.8423333192140419
+ 2.597500000000114e-06 2.8423337624767062
+ 2.5985000000001141e-06 2.842333321462549
+ 2.5995000000001142e-06 2.8423337610564658
+ 2.6005000000001138e-06 2.8423333236988602
+ 2.6015000000001139e-06 2.8423337596360181
+ 2.602500000000114e-06 2.84233332592208
+ 2.6035000000001141e-06 2.8423337582163581
+ 2.604500000000115e-06 2.8423333281313758
+ 2.6055000000001151e-06 2.8423337567984741
+ 2.6065000000001151e-06 2.8423333303262628
+ 2.6075000000001148e-06 2.8423337553826311
+ 2.6085000000001149e-06 2.8423333325068492
+ 2.6095000000001149e-06 2.842333753968767
+ 2.610500000000115e-06 2.8423333346737221
+ 2.6115000000001151e-06 2.8423337525561649
+ 2.6125000000001152e-06 2.842333336827882
+ 2.6135000000001148e-06 2.842333751144142
+ 2.6145000000001149e-06 2.842333338970271
+ 2.615500000000115e-06 2.8423337497316941
+ 2.616500000000115e-06 2.8423333411019391
+ 2.617500000000116e-06 2.8423337483182531
+ 2.618500000000116e-06 2.8423333432234581
+ 2.6195000000001161e-06 2.84233374690375
+ 2.6205000000001162e-06 2.84233334533462
+ 2.6215000000001158e-06 2.8423337454889581
+ 2.6225000000001159e-06 2.8423333474346451
+ 2.623500000000116e-06 2.842333744074832
+ 2.6245000000001161e-06 2.842333349522649
+ 2.6255000000001161e-06 2.842333742662384
+ 2.6265000000001158e-06 2.8423333515980809
+ 2.6275000000001159e-06 2.8423337412522658
+ 2.6285000000001159e-06 2.8423333536604209
+ 2.629500000000116e-06 2.8423337398449249
+ 2.6305000000001169e-06 2.8423333557097168
+ 2.631500000000117e-06 2.8423337384401739
+ 2.6325000000001171e-06 2.842333357746655
+ 2.6335000000001172e-06 2.8423337370372099
+ 2.6345000000001168e-06 2.8423333597722822
+ 2.6355000000001169e-06 2.842333735635183
+ 2.636500000000117e-06 2.8423333617875408
+ 2.637500000000117e-06 2.842333734233383
+ 2.6385000000001171e-06 2.8423333637931631
+ 2.6395000000001172e-06 2.8423337328314742
+ 2.6405000000001169e-06 2.8423333657894041
+ 2.6415000000001169e-06 2.8423337314295778
+ 2.642500000000117e-06 2.8423333677759839
+ 2.6435000000001171e-06 2.842333730028233
+ 2.644500000000118e-06 2.84233336975249
+ 2.6455000000001181e-06 2.8423337286282431
+ 2.6465000000001181e-06 2.8423333717180359
+ 2.6475000000001178e-06 2.842333727230542
+ 2.6485000000001179e-06 2.8423333736720422
+ 2.649500000000118e-06 2.8423337258357648
+ 2.650500000000118e-06 2.842333375614202
+ 2.6515000000001181e-06 2.842333724443951
+ 2.6525000000001182e-06 2.842333377544799
+ 2.6535000000001178e-06 2.8423337230550758
+ 2.6545000000001179e-06 2.8423333794641952
+ 2.655500000000118e-06 2.8423337216684028
+ 2.6565000000001181e-06 2.8423333813734351
+ 2.657500000000119e-06 2.8423337202831518
+ 2.6585000000001191e-06 2.8423333832732629
+ 2.6595000000001191e-06 2.8423337188988151
+ 2.6605000000001192e-06 2.8423333851642978
+ 2.6615000000001189e-06 2.8423337175150372
+ 2.6625000000001189e-06 2.8423333870467249
+ 2.663500000000119e-06 2.842333716132007
+ 2.6645000000001191e-06 2.842333388920288
+ 2.6655000000001192e-06 2.8423337147502759
+ 2.6665000000001188e-06 2.8423333907844821
+ 2.6675000000001189e-06 2.8423337133705591
+ 2.668500000000119e-06 2.84233339263865
+ 2.669500000000119e-06 2.8423337119935912
+ 2.67050000000012e-06 2.8423333944822029
+ 2.67150000000012e-06 2.8423337106198798
+ 2.6725000000001201e-06 2.842333396315063
+ 2.6735000000001202e-06 2.842333709249492
+ 2.6745000000001198e-06 2.8423333981374301
+ 2.6755000000001199e-06 2.84233370788212
+ 2.67650000000012e-06 2.842333399949867
+ 2.6775000000001201e-06 2.8423337065171972
+ 2.6785000000001201e-06 2.8423334017531281
+ 2.6795000000001202e-06 2.8423337051540969
+ 2.6805000000001199e-06 2.8423334035478618
+ 2.6815000000001199e-06 2.842333703792336
+ 2.68250000000012e-06 2.8423334053345091
+ 2.6835000000001209e-06 2.842333702431965
+ 2.684500000000121e-06 2.8423334071129962
+ 2.6855000000001211e-06 2.842333701072981
+ 2.6865000000001212e-06 2.8423334088833201
+ 2.6875000000001208e-06 2.8423336997158248
+ 2.6885000000001209e-06 2.8423334106449061
+ 2.689500000000121e-06 2.8423336983612648
+ 2.690500000000121e-06 2.8423334123972461
+ 2.6915000000001211e-06 2.8423336970097322
+ 2.6925000000001212e-06 2.842333414140032
+ 2.6935000000001208e-06 2.842333695661615
+ 2.6945000000001209e-06 2.842333415873076
+ 2.695500000000121e-06 2.8423336943169222
+ 2.6965000000001211e-06 2.8423334175967119
+ 2.697500000000122e-06 2.842333692975386
+ 2.6985000000001221e-06 2.8423334193113741
+ 2.6995000000001221e-06 2.84233369163656
+ 2.7005000000001222e-06 2.8423334210176319
+ 2.7015000000001219e-06 2.8423336902999261
+ 2.7025000000001219e-06 2.8423334227160111
+ 2.703500000000122e-06 2.8423336889652608
+ 2.7045000000001221e-06 2.8423334244068328
+ 2.7055000000001222e-06 2.8423336876322249
+ 2.7065000000001218e-06 2.8423334260902928
+ 2.7075000000001219e-06 2.8423336863011559
+ 2.708500000000122e-06 2.8423334277659609
+ 2.709500000000122e-06 2.8423336849724681
+ 2.710500000000123e-06 2.8423334294335292
+ 2.711500000000123e-06 2.8423336836466682
+ 2.7125000000001231e-06 2.8423334310926451
+ 2.7135000000001232e-06 2.842333682324107
+ 2.7145000000001228e-06 2.842333432742902
+ 2.7155000000001229e-06 2.8423336810051998
+ 2.716500000000123e-06 2.842333434384428
+ 2.7175000000001231e-06 2.8423336796897209
+ 2.7185000000001231e-06 2.8423334360173409
+ 2.7195000000001232e-06 2.842333678377543
+ 2.7205000000001229e-06 2.842333437642159
+ 2.7215000000001229e-06 2.842333677068114
+ 2.722500000000123e-06 2.8423334392593889
+ 2.7235000000001239e-06 2.8423336757612558
+ 2.724500000000124e-06 2.8423334408692611
+ 2.7255000000001241e-06 2.842333674456627
+ 2.7265000000001242e-06 2.8423334424720852
+ 2.7275000000001238e-06 2.8423336731542519
+ 2.7285000000001239e-06 2.8423334440679091
+ 2.729500000000124e-06 2.8423336718542358
+ 2.730500000000124e-06 2.842333445656462
+ 2.7315000000001241e-06 2.8423336705569389
+ 2.7325000000001242e-06 2.8423334472375199
+ 2.7335000000001238e-06 2.8423336692626751
+ 2.7345000000001239e-06 2.8423334488107632
+ 2.735500000000124e-06 2.8423336679719888
+ 2.7365000000001241e-06 2.8423334503759059
+ 2.737500000000125e-06 2.842333666684822
+ 2.7385000000001251e-06 2.842333451933126
+ 2.7395000000001251e-06 2.842333665401191
+ 2.7405000000001252e-06 2.8423334534825231
+ 2.7415000000001249e-06 2.8423336641208992
+ 2.7425000000001249e-06 2.842333455024495
+ 2.743500000000125e-06 2.8423336628436049
+ 2.7445000000001251e-06 2.8423334565593881
+ 2.7455000000001252e-06 2.8423336615690529
+ 2.7465000000001248e-06 2.8423334580875048
+ 2.7475000000001249e-06 2.842333660297117
+ 2.748500000000125e-06 2.8423334596089891
+ 2.749500000000125e-06 2.8423336590276489
+ 2.750500000000126e-06 2.8423334611239608
+ 2.751500000000126e-06 2.8423336577608311
+ 2.7525000000001261e-06 2.842333462632165
+ 2.7535000000001262e-06 2.8423336564969959
+ 2.7545000000001258e-06 2.84233346413333
+ 2.7555000000001259e-06 2.8423336552364771
+ 2.756500000000126e-06 2.8423334656272661
+ 2.7575000000001261e-06 2.8423336539794271
+ 2.7585000000001261e-06 2.842333467113864
+ 2.7595000000001258e-06 2.8423336527260248
+ 2.7605000000001259e-06 2.842333468593067
+ 2.7615000000001259e-06 2.8423336514762951
+ 2.762500000000126e-06 2.8423334700650251
+ 2.7635000000001269e-06 2.8423336502300249
+ 2.764500000000127e-06 2.8423334715301252
+ 2.7655000000001271e-06 2.8423336489868158
+ 2.7665000000001272e-06 2.8423334729887979
+ 2.7675000000001268e-06 2.8423336477463672
+ 2.7685000000001269e-06 2.8423334744412472
+ 2.769500000000127e-06 2.8423336465087701
+ 2.770500000000127e-06 2.8423334758873948
+ 2.7715000000001271e-06 2.8423336452739409
+ 2.7725000000001272e-06 2.8423334773274509
+ 2.7735000000001268e-06 2.8423336440419149
+ 2.7745000000001269e-06 2.8423334787611472
+ 2.775500000000127e-06 2.842333642813164
+ 2.7765000000001271e-06 2.8423334801881479
+ 2.777500000000128e-06 2.842333641587905
+ 2.7785000000001281e-06 2.8423334816084478
+ 2.7795000000001281e-06 2.8423336403661801
+ 2.7805000000001278e-06 2.8423334830219482
+ 2.7815000000001279e-06 2.84233363914805
+ 2.7825000000001279e-06 2.842333484428837
+ 2.783500000000128e-06 2.8423336379334372
+ 2.7845000000001281e-06 2.842333485829049
+ 2.7855000000001282e-06 2.842333636722334
+ 2.7865000000001278e-06 2.8423334872229611
+ 2.7875000000001279e-06 2.8423336355143829
+ 2.788500000000128e-06 2.8423334886108158
+ 2.789500000000128e-06 2.8423336343093979
+ 2.790500000000129e-06 2.842333489992765
+ 2.791500000000129e-06 2.842333633107506
+ 2.7925000000001291e-06 2.842333491368759
+ 2.7935000000001292e-06 2.8423336319086072
+ 2.7945000000001288e-06 2.8423334927388559
+ 2.7955000000001289e-06 2.842333630712762
+ 2.796500000000129e-06 2.8423334941031602
+ 2.7975000000001291e-06 2.8423336295200672
+ 2.7985000000001291e-06 2.842333495461391
+ 2.7995000000001288e-06 2.8423336283307372
+ 2.8005000000001289e-06 2.8423334968134339
+ 2.8015000000001289e-06 2.8423336271450328
+ 2.802500000000129e-06 2.8423334981590962
+ 2.8035000000001299e-06 2.8423336259631
+ 2.80450000000013e-06 2.8423334994984071
+ 2.8055000000001301e-06 2.842333624784795
+ 2.8065000000001302e-06 2.8423335008315962
+ 2.8075000000001298e-06 2.8423336236098899
+ 2.8085000000001299e-06 2.842333502158966
+ 2.80950000000013e-06 2.8423336224382312
+ 2.81050000000013e-06 2.842333503480551
+ 2.8115000000001301e-06 2.842333621269804
+ 2.8125000000001302e-06 2.842333504796601
+ 2.8135000000001298e-06 2.8423336201043479
+ 2.8145000000001299e-06 2.8423335061072428
+ 2.81550000000013e-06 2.8423336189419102
+ 2.8165000000001301e-06 2.8423335074124521
+ 2.817500000000131e-06 2.84233361778253
+ 2.8185000000001311e-06 2.8423335087121879
+ 2.8195000000001311e-06 2.8423336166264028
+ 2.8205000000001308e-06 2.8423335100061831
+ 2.8215000000001309e-06 2.8423336154738248
+ 2.8225000000001309e-06 2.8423335112942691
+ 2.823500000000131e-06 2.8423336143249518
+ 2.8245000000001311e-06 2.8423335125764111
+ 2.8255000000001312e-06 2.8423336131797199
+ 2.8265000000001308e-06 2.8423335138526831
+ 2.8275000000001309e-06 2.842333612038221
+ 2.828500000000131e-06 2.8423335151231388
+ 2.8295000000001311e-06 2.842333610900146
+ 2.830500000000132e-06 2.8423335163880949
+ 2.831500000000132e-06 2.842333609765419
+ 2.8325000000001321e-06 2.8423335176477562
+ 2.8335000000001322e-06 2.8423336086337021
+ 2.8345000000001318e-06 2.8423335189023362
+ 2.8355000000001319e-06 2.8423336075050751
+ 2.836500000000132e-06 2.8423335201518221
+ 2.8375000000001321e-06 2.8423336063794342
+ 2.8385000000001322e-06 2.842333521396287
+ 2.8395000000001318e-06 2.842333605256897
+ 2.8405000000001319e-06 2.8423335226355069
+ 2.841500000000132e-06 2.842333604137754
+ 2.842500000000132e-06 2.8423335238692871
+ 2.8435000000001329e-06 2.842333603022194
+ 2.844500000000133e-06 2.8423335250974699
+ 2.8455000000001331e-06 2.8423336019103851
+ 2.8465000000001332e-06 2.8423335263200369
+ 2.8475000000001328e-06 2.8423336008022662
+ 2.8485000000001329e-06 2.8423335275370349
+ 2.849500000000133e-06 2.842333599697878
+ 2.8505000000001331e-06 2.8423335287485938
+ 2.8515000000001331e-06 2.8423335985968561
+ 2.8525000000001332e-06 2.842333529955166
+ 2.8535000000001329e-06 2.8423335974989379
+ 2.8545000000001329e-06 2.8423335311569149
+ 2.855500000000133e-06 2.8423335964040128
+ 2.8565000000001339e-06 2.8423335323539471
+ 2.857500000000134e-06 2.8423335953120992
+ 2.8585000000001341e-06 2.8423335335461721
+ 2.8595000000001342e-06 2.8423335942233212
+ 2.8605000000001338e-06 2.8423335347334961
+ 2.8615000000001339e-06 2.8423335931379339
+ 2.862500000000134e-06 2.8423335359156181
+ 2.863500000000134e-06 2.8423335920561028
+ 2.8645000000001341e-06 2.8423335370926179
+ 2.8655000000001342e-06 2.8423335909776961
+ 2.8665000000001338e-06 2.8423335382644699
+ 2.8675000000001339e-06 2.84233358990295
+ 2.868500000000134e-06 2.8423335394310869
+ 2.8695000000001341e-06 2.8423335888318171
+ 2.870500000000135e-06 2.8423335405925871
+ 2.8715000000001351e-06 2.8423335877641112
+ 2.8725000000001351e-06 2.8423335417491802
+ 2.8735000000001352e-06 2.8423335866997501
+ 2.8745000000001349e-06 2.8423335429009668
+ 2.8755000000001349e-06 2.84233358563863
+ 2.876500000000135e-06 2.842333544048095
+ 2.8775000000001351e-06 2.842333584580651
+ 2.8785000000001352e-06 2.8423335451906371
+ 2.8795000000001348e-06 2.8423335835257069
+ 2.8805000000001349e-06 2.8423335463286361
+ 2.881500000000135e-06 2.8423335824739548
+ 2.882500000000135e-06 2.8423335474620179
+ 2.883500000000136e-06 2.8423335814254789
+ 2.884500000000136e-06 2.8423335485906351
+ 2.8855000000001361e-06 2.842333580380334
+ 2.8865000000001362e-06 2.842333549714485
+ 2.8875000000001358e-06 2.8423335793387081
+ 2.8885000000001359e-06 2.842333550833414
+ 2.889500000000136e-06 2.8423335783006638
+ 2.8905000000001361e-06 2.8423335519474091
+ 2.8915000000001361e-06 2.8423335772661962
+ 2.8925000000001362e-06 2.8423335530565028
+ 2.8935000000001359e-06 2.8423335762352671
+ 2.8945000000001359e-06 2.842333554160994
+ 2.895500000000136e-06 2.8423335752074679
+ 2.8965000000001369e-06 2.8423335552609852
+ 2.897500000000137e-06 2.8423335741829079
+ 2.8985000000001371e-06 2.8423335563566789
+ 2.8995000000001372e-06 2.8423335731613499
+ 2.9005000000001368e-06 2.8423335574480082
+ 2.9015000000001369e-06 2.8423335721429441
+ 2.902500000000137e-06 2.842333558535048
+ 2.903500000000137e-06 2.8423335711276878
+ 2.9045000000001371e-06 2.8423335596175519
+ 2.9055000000001372e-06 2.8423335701157679
+ 2.9065000000001368e-06 2.8423335606955802
+ 2.9075000000001369e-06 2.8423335691072849
+ 2.908500000000137e-06 2.8423335617689589
+ 2.9095000000001371e-06 2.842333568102176
+ 2.910500000000138e-06 2.8423335628377981
+ 2.9115000000001381e-06 2.8423335671006029
+ 2.9125000000001381e-06 2.8423335639020002
+ 2.9135000000001382e-06 2.8423335661023712
+ 2.9145000000001379e-06 2.8423335649618182
+ 2.9155000000001379e-06 2.8423335651074351
+ 2.916500000000138e-06 2.8423335660173108
+ 2.9175000000001381e-06 2.8423335641156542
+ 2.9185000000001382e-06 2.842333567068549
+ 2.9195000000001378e-06 2.8423335631271129
+ 2.9205000000001379e-06 2.8423335681155359
+ 2.921500000000138e-06 2.8423335621416719
+ 2.922500000000138e-06 2.8423335691584
+ 2.923500000000139e-06 2.84233356115941
+ 2.924500000000139e-06 2.842333570197014
+ 2.9255000000001391e-06 2.842333560180283
+ 2.9265000000001392e-06 2.842333571231475
+ 2.9275000000001388e-06 2.8423335592044352
+ 2.9285000000001389e-06 2.8423335722615688
+ 2.929500000000139e-06 2.8423335582319611
+ 2.9305000000001391e-06 2.8423335732874189
+ 2.9315000000001391e-06 2.842333557262704
+ 2.9325000000001388e-06 2.8423335743089821
+ 2.9335000000001389e-06 2.8423335562968539
+ 2.9345000000001389e-06 2.8423335753262449
+ 2.935500000000139e-06 2.8423335553343532
+ 2.9365000000001399e-06 2.842333576339255
+ 2.93750000000014e-06 2.842333554375025
+ 2.9385000000001401e-06 2.8423335773481462
+ 2.9395000000001402e-06 2.8423335534189431
+ 2.9405000000001398e-06 2.8423335783530539
+ 2.9415000000001399e-06 2.8423335524659019
+ 2.94250000000014e-06 2.8423335793538982
+ 2.94350000000014e-06 2.842333551516
+ 2.9445000000001401e-06 2.8423335803508532
+ 2.9455000000001402e-06 2.8423335505691991
+ 2.9465000000001398e-06 2.8423335813437571
+ 2.9475000000001399e-06 2.8423335496255522
+ 2.94850000000014e-06 2.8423335823326048
+ 2.9495000000001401e-06 2.8423335486851178
+ 2.950500000000141e-06 2.8423335833174792
+ 2.9515000000001411e-06 2.8423335477478431
+ 2.9525000000001411e-06 2.8423335842982711
+ 2.9535000000001408e-06 2.8423335468139288
+ 2.9545000000001409e-06 2.842333585274941
+ 2.9555000000001409e-06 2.842333545883188
+ 2.956500000000141e-06 2.8423335862476868
+ 2.9575000000001411e-06 2.8423335449556282
+ 2.9585000000001412e-06 2.8423335872164128
+ 2.9595000000001408e-06 2.8423335440313031
+ 2.9605000000001409e-06 2.842333588181106
+ 2.961500000000141e-06 2.8423335431101959
+ 2.962500000000141e-06 2.8423335891419979
+ 2.963500000000142e-06 2.8423335421920841
+ 2.964500000000142e-06 2.8423335900990421
+ 2.9655000000001421e-06 2.8423335412770281
+ 2.9665000000001422e-06 2.8423335910523888
+ 2.9675000000001418e-06 2.8423335403650172
+ 2.9685000000001419e-06 2.842333592001888
+ 2.969500000000142e-06 2.8423335394561291
+ 2.9705000000001421e-06 2.842333592947567
+ 2.9715000000001421e-06 2.842333538550319
+ 2.9725000000001418e-06 2.8423335938893919
+ 2.9735000000001419e-06 2.842333537647685
+ 2.9745000000001419e-06 2.8423335948274349
+ 2.975500000000142e-06 2.842333536748181
+ 2.9765000000001429e-06 2.8423335957616129
+ 2.977500000000143e-06 2.8423335358518491
+ 2.9785000000001431e-06 2.8423335966918959
+ 2.9795000000001432e-06 2.842333534958708
+ 2.9805000000001428e-06 2.8423335976184712
+ 2.9815000000001429e-06 2.8423335340685978
+ 2.982500000000143e-06 2.842333598541344
+ 2.983500000000143e-06 2.8423335331815371
+ 2.9845000000001431e-06 2.8423335994604431
+ 2.9855000000001432e-06 2.8423335322976189
+ 2.9865000000001428e-06 2.8423336003758388
+ 2.9875000000001429e-06 2.8423335314167248
+ 2.988500000000143e-06 2.8423336012876561
+ 2.9895000000001431e-06 2.8423335305387738
+ 2.990500000000144e-06 2.8423336021959038
+ 2.9915000000001441e-06 2.842333529663791
+ 2.9925000000001441e-06 2.8423336031005628
+ 2.9935000000001438e-06 2.8423335287918419
+ 2.9945000000001439e-06 2.8423336040015208
+ 2.9955000000001439e-06 2.8423335279229738
+ 2.996500000000144e-06 2.8423336048988981
+ 2.9975000000001441e-06 2.8423335270571899
+ 2.9985000000001442e-06 2.8423336057925659
+ 2.9995000000001438e-06 2.8423335261944458
+ 3.0005000000001439e-06 2.8423336066826481
+ 3.001500000000144e-06 2.8423335253347748
+ 3.002500000000144e-06 2.842333607569143
+ 3.003500000000145e-06 2.842333524478049
+ 3.004500000000145e-06 2.8423336084520612
+ 3.0055000000001451e-06 2.8423335236244869
+ 3.0065000000001452e-06 2.842333609331356
+ 3.0075000000001448e-06 2.8423335227739162
+ 3.0085000000001449e-06 2.842333610207127
+ 3.009500000000145e-06 2.842333521926327
+ 3.0105000000001451e-06 2.8423336110794448
+ 3.0115000000001451e-06 2.842333521081517
+ 3.0125000000001448e-06 2.842333611948499
+ 3.0135000000001449e-06 2.8423335202396531
+ 3.0145000000001449e-06 2.8423336128140599
+ 3.015500000000145e-06 2.842333519400718
+ 3.0165000000001459e-06 2.8423336136761401
+ 3.017500000000146e-06 2.8423335185647911
+ 3.0185000000001461e-06 2.842333614534764
+ 3.0195000000001462e-06 2.842333517731821
+ 3.0205000000001458e-06 2.8423336153898879
+ 3.0215000000001459e-06 2.8423335169019182
+ 3.022500000000146e-06 2.842333616241524
+ 3.023500000000146e-06 2.8423335160748802
+ 3.0245000000001461e-06 2.8423336170898219
+ 3.0255000000001462e-06 2.8423335152508931
+ 3.0265000000001459e-06 2.8423336179346208
+ 3.0275000000001459e-06 2.8423335144298432
+ 3.028500000000146e-06 2.8423336187760522
+ 3.0295000000001461e-06 2.842333513611667
+ 3.030500000000147e-06 2.8423336196141529
+ 3.0315000000001471e-06 2.8423335127963809
+ 3.0325000000001471e-06 2.8423336204489891
+ 3.0335000000001468e-06 2.842333511983878
+ 3.0345000000001469e-06 2.8423336212806118
+ 3.035500000000147e-06 2.8423335111741919
+ 3.036500000000147e-06 2.842333622108915
+ 3.0375000000001471e-06 2.842333510367467
+ 3.0385000000001472e-06 2.8423336229338552
+ 3.0395000000001468e-06 2.8423335095636371
+ 3.0405000000001469e-06 2.8423336237554699
+ 3.041500000000147e-06 2.842333508762755
+ 3.0425000000001471e-06 2.8423336245737691
+ 3.043500000000148e-06 2.8423335079647289
+ 3.0445000000001481e-06 2.8423336253888221
+ 3.0455000000001481e-06 2.8423335071695619
+ 3.0465000000001482e-06 2.8423336262006109
+ 3.0475000000001479e-06 2.8423335063772042
+ 3.0485000000001479e-06 2.842333627009249
+ 3.049500000000148e-06 2.842333505587701
+ 3.0505000000001481e-06 2.8423336278145519
+ 3.0515000000001482e-06 2.8423335048011338
+ 3.0525000000001478e-06 2.8423336286166418
+ 3.0535000000001479e-06 2.842333504017359
+ 3.054500000000148e-06 2.8423336294155832
+ 3.055500000000148e-06 2.8423335032363339
+ 3.056500000000149e-06 2.8423336302114199
+ 3.057500000000149e-06 2.8423335024580649
+ 3.0585000000001491e-06 2.842333631004121
+ 3.0595000000001492e-06 2.8423335016825608
+ 3.0605000000001488e-06 2.8423336317937178
+ 3.0615000000001489e-06 2.842333500909791
+ 3.062500000000149e-06 2.842333632580238
+ 3.0635000000001491e-06 2.84233350013981
+ 3.0645000000001491e-06 2.8423336333635718
+ 3.0655000000001492e-06 2.8423334993726881
+ 3.0665000000001489e-06 2.8423336341436349
+ 3.0675000000001489e-06 2.84233349860857
+ 3.068500000000149e-06 2.8423336349204531
+ 3.0695000000001499e-06 2.842333497847259
+ 3.07050000000015e-06 2.8423336356941689
+ 3.0715000000001501e-06 2.8423334970886929
+ 3.0725000000001502e-06 2.8423336364648581
+ 3.0735000000001498e-06 2.8423334963327882
+ 3.0745000000001499e-06 2.842333637232628
+ 3.07550000000015e-06 2.842333495579453
+ 3.07650000000015e-06 2.8423336379975042
+ 3.0775000000001501e-06 2.8423334948287939
+ 3.0785000000001502e-06 2.8423336387593432
+ 3.0795000000001498e-06 2.8423334940807399
+ 3.0805000000001499e-06 2.8423336395183481
+ 3.08150000000015e-06 2.8423334933353721
+ 3.0825000000001501e-06 2.8423336402742172
+ 3.083500000000151e-06 2.8423334925928909
+ 3.0845000000001511e-06 2.8423336410269089
+ 3.0855000000001511e-06 2.8423334918532892
+ 3.0865000000001512e-06 2.8423336417764489
+ 3.0875000000001509e-06 2.8423334911164999
+ 3.0885000000001509e-06 2.842333642522894
+ 3.089500000000151e-06 2.8423334903825461
+ 3.0905000000001511e-06 2.842333643266302
+ 3.0915000000001512e-06 2.84233348965122
+ 3.0925000000001508e-06 2.84233364400691
+ 3.0935000000001509e-06 2.8423334889223919
+ 3.094500000000151e-06 2.842333644744754
+ 3.095500000000151e-06 2.8423334881960591
+ 3.096500000000152e-06 2.842333645479787
+ 3.097500000000152e-06 2.8423334874722959
+ 3.0985000000001521e-06 2.8423336462120141
+ 3.0995000000001522e-06 2.842333486751071
+ 3.1005000000001518e-06 2.8423336469413831
+ 3.1015000000001519e-06 2.8423334860324632
+ 3.102500000000152e-06 2.8423336476678731
+ 3.1035000000001521e-06 2.8423334853166038
+ 3.1045000000001521e-06 2.8423336483913189
+ 3.1055000000001522e-06 2.8423334846035289
+ 3.1065000000001519e-06 2.8423336491117062
+ 3.1075000000001519e-06 2.8423334838932521
+ 3.108500000000152e-06 2.8423336498291421
+ 3.1095000000001529e-06 2.8423334831856191
+ 3.110500000000153e-06 2.8423336505436589
+ 3.1115000000001531e-06 2.842333482480671
+ 3.1125000000001532e-06 2.8423336512553541
+ 3.1135000000001528e-06 2.8423334817782528
+ 3.1145000000001529e-06 2.8423336519642688
+ 3.115500000000153e-06 2.8423334810783718
+ 3.116500000000153e-06 2.842333652670427
+ 3.1175000000001531e-06 2.8423334803809981
+ 3.1185000000001532e-06 2.8423336533739199
+ 3.1195000000001528e-06 2.8423334796860771
+ 3.1205000000001529e-06 2.8423336540747322
+ 3.121500000000153e-06 2.842333478993571
+ 3.1225000000001531e-06 2.8423336547728759
+ 3.123500000000154e-06 2.8423334783035901
+ 3.1245000000001541e-06 2.8423336554683001
+ 3.1255000000001541e-06 2.8423334776161102
+ 3.1265000000001542e-06 2.842333656160879
+ 3.1275000000001539e-06 2.842333476931338
+ 3.1285000000001539e-06 2.8423336568506081
+ 3.129500000000154e-06 2.8423334762492058
+ 3.1305000000001541e-06 2.8423336575374201
+ 3.1315000000001542e-06 2.842333475569804
+ 3.1325000000001538e-06 2.8423336582213659
+ 3.1335000000001539e-06 2.8423334748929592
+ 3.134500000000154e-06 2.8423336589026369
+ 3.135500000000154e-06 2.842333474218615
+ 3.136500000000155e-06 2.8423336595811821
+ 3.137500000000155e-06 2.8423334735467578
+ 3.1385000000001551e-06 2.8423336602570952
+ 3.1395000000001552e-06 2.8423334728773222
+ 3.1405000000001548e-06 2.8423336609304291
+ 3.1415000000001549e-06 2.8423334722102571
+ 3.142500000000155e-06 2.8423336616011832
+ 3.1435000000001551e-06 2.842333471545619
+ 3.1445000000001551e-06 2.8423336622693691
+ 3.1455000000001548e-06 2.8423334708833319
+ 3.1465000000001549e-06 2.8423336629349691
+ 3.1475000000001549e-06 2.842333470223509
+ 3.148500000000155e-06 2.8423336635978962
+ 3.1495000000001559e-06 2.8423334695661988
+ 3.150500000000156e-06 2.8423336642581489
+ 3.1515000000001561e-06 2.842333468911427
+ 3.1525000000001562e-06 2.842333664915639
+ 3.1535000000001558e-06 2.8423334682592478
+ 3.1545000000001559e-06 2.8423336655703881
+ 3.155500000000156e-06 2.8423334676095999
+ 3.156500000000156e-06 2.8423336662224861
+ 3.1575000000001561e-06 2.8423334669623999
+ 3.1585000000001562e-06 2.8423336668719772
+ 3.1595000000001558e-06 2.8423334663176689
+ 3.1605000000001559e-06 2.8423336675188851
+ 3.161500000000156e-06 2.842333465675237
+ 3.1625000000001561e-06 2.8423336681634042
+ 3.163500000000157e-06 2.842333465035062
+ 3.1645000000001571e-06 2.842333668805475
+ 3.1655000000001571e-06 2.8423334643972149
+ 3.1665000000001568e-06 2.8423336694450452
+ 3.1675000000001569e-06 2.8423334637616899
+ 3.1685000000001569e-06 2.8423336700821151
+ 3.169500000000157e-06 2.8423334631285928
+ 3.1705000000001571e-06 2.8423336707165978
+ 3.1715000000001572e-06 2.842333462497928
+ 3.1725000000001568e-06 2.8423336713484559
+ 3.1735000000001569e-06 2.84233346186973
+ 3.174500000000157e-06 2.8423336719777281
+ 3.175500000000157e-06 2.8423334612440021
+ 3.176500000000158e-06 2.842333672604378
+ 3.177500000000158e-06 2.8423334606207362
+ 3.1785000000001581e-06 2.8423336732284761
+ 3.1795000000001582e-06 2.8423334599998089
+ 3.1805000000001578e-06 2.8423336738501281
+ 3.1815000000001579e-06 2.8423334593811771
+ 3.182500000000158e-06 2.842333674469375
+ 3.1835000000001581e-06 2.8423334587647902
+ 3.1845000000001581e-06 2.8423336750862029
+ 3.1855000000001578e-06 2.842333458150732
+ 3.1865000000001579e-06 2.842333675700659
+ 3.1875000000001579e-06 2.842333457538833
+ 3.188500000000158e-06 2.8423336763128151
+ 3.1895000000001589e-06 2.842333456929159
+ 3.190500000000159e-06 2.8423336769225398
+ 3.1915000000001591e-06 2.8423334563218541
+ 3.1925000000001592e-06 2.8423336775297718
+ 3.1935000000001588e-06 2.8423334557168909
+ 3.1945000000001589e-06 2.842333678134517
+ 3.195500000000159e-06 2.8423334551143311
+ 3.196500000000159e-06 2.8423336787367228
+ 3.1975000000001591e-06 2.8423334545141792
+ 3.1985000000001592e-06 2.8423336793364462
+ 3.1995000000001588e-06 2.8423334539163241
+ 3.2005000000001589e-06 2.8423336799337799
+ 3.201500000000159e-06 2.8423334533207609
+ 3.2025000000001591e-06 2.842333680528724
+ 3.20350000000016e-06 2.8423334527274209
+ 3.2045000000001601e-06 2.842333681121358
+ 3.2055000000001601e-06 2.8423334521362622
+ 3.2065000000001598e-06 2.8423336817117031
+ 3.2075000000001599e-06 2.8423334515473
+ 3.2085000000001599e-06 2.842333682299742
+ 3.20950000000016e-06 2.8423334509605049
+ 3.2105000000001601e-06 2.842333682885509
+ 3.2115000000001602e-06 2.842333450375897
+ 3.2125000000001598e-06 2.8423336834689632
+ 3.2135000000001599e-06 2.8423334497935109
+ 3.21450000000016e-06 2.8423336840500859
+ 3.2155000000001601e-06 2.8423334492133709
+ 3.216500000000161e-06 2.8423336846288012
+ 3.217500000000161e-06 2.8423334486355678
+ 3.2185000000001611e-06 2.8423336852050989
+ 3.2195000000001612e-06 2.842333448060038
+ 3.2205000000001608e-06 2.8423336857790269
+ 3.2215000000001609e-06 2.8423334474867818
+ 3.222500000000161e-06 2.8423336863506599
+ 3.2235000000001611e-06 2.84233344691568
+ 3.2245000000001611e-06 2.8423336869200151
+ 3.2255000000001608e-06 2.8423334463467289
+ 3.2265000000001609e-06 2.842333687487161
+ 3.227500000000161e-06 2.8423334457798748
+ 3.228500000000161e-06 2.8423336880521388
+ 3.2295000000001619e-06 2.8423334452150901
+ 3.230500000000162e-06 2.8423336886149202
+ 3.2315000000001621e-06 2.8423334446524429
+ 3.2325000000001622e-06 2.8423336891754518
+ 3.2335000000001618e-06 2.8423334440919601
+ 3.2345000000001619e-06 2.8423336897337181
+ 3.235500000000162e-06 2.8423334435336902
+ 3.2365000000001621e-06 2.8423336902896619
+ 3.2375000000001621e-06 2.8423334429776652
+ 3.2385000000001622e-06 2.8423336908432808
+ 3.2395000000001619e-06 2.8423334424238131
+ 3.2405000000001619e-06 2.842333691394678
+ 3.241500000000162e-06 2.8423334418721131
+ 3.2425000000001629e-06 2.842333691943856
+ 3.243500000000163e-06 2.8423334413225279
+ 3.2445000000001631e-06 2.8423336924908389
+ 3.2455000000001632e-06 2.8423334407750129
+ 3.2465000000001628e-06 2.8423336930356879
+ 3.2475000000001629e-06 2.842333440229571
+ 3.248500000000163e-06 2.8423336935784098
+ 3.249500000000163e-06 2.842333439686163
+ 3.2505000000001631e-06 2.842333694118977
+ 3.2515000000001632e-06 2.8423334391448378
+ 3.2525000000001628e-06 2.8423336946574049
+ 3.2535000000001629e-06 2.8423334386055741
+ 3.254500000000163e-06 2.842333695193648
+ 3.2555000000001631e-06 2.842333438068458
+ 3.256500000000164e-06 2.8423336957276901
+ 3.2575000000001641e-06 2.8423334375334099
+ 3.2585000000001641e-06 2.8423336962596042
+ 3.2595000000001642e-06 2.8423334370004931
+ 3.2605000000001639e-06 2.8423336967893169
+ 3.2615000000001639e-06 2.842333436469616
+ 3.262500000000164e-06 2.842333697316886
+ 3.2635000000001641e-06 2.8423334359408718
+ 3.2645000000001642e-06 2.8423336978422529
+ 3.2655000000001638e-06 2.8423334354142389
+ 3.2665000000001639e-06 2.8423336983654961
+ 3.267500000000164e-06 2.842333434889603
+ 3.268500000000164e-06 2.842333698886681
+ 3.269500000000165e-06 2.842333434366958
+ 3.270500000000165e-06 2.8423336994058421
+ 3.2715000000001651e-06 2.842333433846266
+ 3.2725000000001652e-06 2.8423336999229258
+ 3.2735000000001648e-06 2.842333433327576
+ 3.2745000000001649e-06 2.8423337004379858
+ 3.275500000000165e-06 2.84233343281086
+ 3.2765000000001651e-06 2.8423337009509861
+ 3.2775000000001651e-06 2.8423334322961331
+ 3.2785000000001652e-06 2.8423337014619161
+ 3.2795000000001649e-06 2.8423334317834699
+ 3.2805000000001649e-06 2.8423337019706958
+ 3.281500000000165e-06 2.8423334312728601
+ 3.2825000000001659e-06 2.8423337024774109
+ 3.283500000000166e-06 2.8423334307642438
+ 3.2845000000001661e-06 2.8423337029820308
+ 3.2855000000001662e-06 2.8423334302576651
+ 3.2865000000001658e-06 2.842333703484563
+ 3.2875000000001659e-06 2.8423334297531579
+ 3.288500000000166e-06 2.8423337039849752
+ 3.289500000000166e-06 2.8423334292505942
+ 3.2905000000001661e-06 2.8423337044834689
+ 3.2915000000001662e-06 2.8423334287499111
+ 3.2925000000001658e-06 2.8423337049799642
+ 3.2935000000001659e-06 2.842333428251155
+ 3.294500000000166e-06 2.8423337054745561
+ 3.2955000000001661e-06 2.8423334277542369
+ 3.296500000000167e-06 2.8423337059672011
+ 3.2975000000001671e-06 2.8423334272592422
+ 3.2985000000001671e-06 2.8423337064578531
+ 3.2995000000001672e-06 2.8423334267661722
+ 3.3005000000001669e-06 2.8423337069465511
+ 3.3015000000001669e-06 2.8423334262750579
+ 3.302500000000167e-06 2.842333707433164
+ 3.3035000000001671e-06 2.842333425785978
+ 3.3045000000001672e-06 2.842333707917744
+ 3.3055000000001668e-06 2.842333425298833
+ 3.3065000000001669e-06 2.8423337084003268
+ 3.307500000000167e-06 2.842333424813702
+ 3.308500000000167e-06 2.8423337088808331
+ 3.309500000000168e-06 2.8423334243305152
+ 3.310500000000168e-06 2.8423337093594099
+ 3.3115000000001681e-06 2.842333423849194
+ 3.3125000000001682e-06 2.8423337098360579
+ 3.3135000000001678e-06 2.8423334233697082
+ 3.3145000000001679e-06 2.8423337103108941
+ 3.315500000000168e-06 2.8423334228919801
+ 3.3165000000001681e-06 2.8423337107839122
+ 3.3175000000001681e-06 2.842333422416043
+ 3.3185000000001678e-06 2.842333711255058
+ 3.3195000000001679e-06 2.84233342194198
+ 3.3205000000001679e-06 2.8423337117242462
+ 3.321500000000168e-06 2.842333421469827
+ 3.3225000000001689e-06 2.8423337121915311
+ 3.323500000000169e-06 2.8423334209995148
+ 3.3245000000001691e-06 2.8423337126568651
+ 3.3255000000001692e-06 2.8423334205311361
+ 3.3265000000001688e-06 2.8423337131202242
+ 3.3275000000001689e-06 2.8423334200647692
+ 3.328500000000169e-06 2.8423337135814708
+ 3.329500000000169e-06 2.84233341960037
+ 3.3305000000001691e-06 2.842333714040838
+ 3.3315000000001692e-06 2.8423334191377601
+ 3.3325000000001688e-06 2.8423337144983929
+ 3.3335000000001689e-06 2.8423334186768932
+ 3.334500000000169e-06 2.8423337149541892
+ 3.3355000000001691e-06 2.8423334182177449
+ 3.33650000000017e-06 2.8423337154082349
+ 3.3375000000001701e-06 2.8423334177602859
+ 3.3385000000001701e-06 2.842333715860542
+ 3.3395000000001698e-06 2.8423334173045731
+ 3.3405000000001699e-06 2.8423337163110092
+ 3.3415000000001699e-06 2.8423334168507042
+ 3.34250000000017e-06 2.8423337167595641
+ 3.3435000000001701e-06 2.8423334163987031
+ 3.3445000000001702e-06 2.8423337172062282
+ 3.3455000000001698e-06 2.8423334159485529
+ 3.3465000000001699e-06 2.8423337176510288
+ 3.34750000000017e-06 2.8423334155002289
+ 3.34850000000017e-06 2.842333718093923
+ 3.349500000000171e-06 2.8423334150537851
+ 3.350500000000171e-06 2.8423337185349351
+ 3.3515000000001711e-06 2.8423334146091461
+ 3.3525000000001712e-06 2.842333718974118
+ 3.3535000000001708e-06 2.8423334141663021
+ 3.3545000000001709e-06 2.842333719411501
+ 3.355500000000171e-06 2.8423334137251719
+ 3.3565000000001711e-06 2.842333719847177
+ 3.3575000000001711e-06 2.842333413285683
+ 3.3585000000001708e-06 2.8423337202811898
+ 3.3595000000001709e-06 2.8423334128478581
+ 3.3605000000001709e-06 2.842333720713464
+ 3.361500000000171e-06 2.842333412411723
+ 3.3625000000001719e-06 2.8423337211439952
+ 3.363500000000172e-06 2.84233341197737
+ 3.3645000000001721e-06 2.842333721572714
+ 3.3655000000001722e-06 2.842333411544784
+ 3.3665000000001718e-06 2.8423337219995961
+ 3.3675000000001719e-06 2.8423334111140051
+ 3.368500000000172e-06 2.842333722424681
+ 3.369500000000172e-06 2.842333410684998
+ 3.3705000000001721e-06 2.8423337228479419
+ 3.3715000000001722e-06 2.84233341025777
+ 3.3725000000001718e-06 2.842333723269475
+ 3.3735000000001719e-06 2.8423334098321349
+ 3.374500000000172e-06 2.8423337236893009
+ 3.3755000000001721e-06 2.84233340940827
+ 3.376500000000173e-06 2.8423337241073958
+ 3.3775000000001731e-06 2.8423334089860708
+ 3.3785000000001731e-06 2.8423337245237801
+ 3.3795000000001728e-06 2.8423334085655592
+ 3.3805000000001729e-06 2.8423337249384528
+ 3.3815000000001729e-06 2.842333408146712
+ 3.382500000000173e-06 2.8423337253514389
+ 3.3835000000001731e-06 2.8423334077295448
+ 3.3845000000001732e-06 2.8423337257627521
+ 3.3855000000001728e-06 2.8423334073139679
+ 3.3865000000001729e-06 2.8423337261723862
+ 3.387500000000173e-06 2.8423334069001749
+ 3.388500000000173e-06 2.8423337265801991
+ 3.389500000000174e-06 2.8423334064880388
+ 3.390500000000174e-06 2.842333726986376
+ 3.3915000000001741e-06 2.8423334060775809
+ 3.3925000000001742e-06 2.84233372739084
+ 3.3935000000001738e-06 2.8423334056687439
+ 3.3945000000001739e-06 2.8423337277936711
+ 3.395500000000174e-06 2.842333405261543
+ 3.3965000000001741e-06 2.8423337281948262
+ 3.3975000000001741e-06 2.842333404856034
+ 3.3985000000001738e-06 2.842333728594272
+ 3.3995000000001739e-06 2.8423334044521482
+ 3.4005000000001739e-06 2.842333728992092
+ 3.401500000000174e-06 2.842333404049862
+ 3.4025000000001749e-06 2.8423337293882489
+ 3.403500000000175e-06 2.8423334036492638
+ 3.4045000000001751e-06 2.8423337297827351
+ 3.4055000000001752e-06 2.8423334032502638
+ 3.4065000000001748e-06 2.842333730175592
+ 3.4075000000001749e-06 2.8423334028528888
+ 3.408500000000175e-06 2.842333730566831
+ 3.409500000000175e-06 2.8423334024570641
+ 3.4105000000001751e-06 2.8423337309564718
+ 3.4115000000001752e-06 2.8423334020628652
+ 3.4125000000001749e-06 2.842333731344433
+ 3.4135000000001749e-06 2.842333401670321
+ 3.414500000000175e-06 2.8423337317307649
+ 3.4155000000001751e-06 2.84233340127932
+ 3.416500000000176e-06 2.842333732115554
+ 3.4175000000001761e-06 2.8423334008898808
+ 3.4185000000001761e-06 2.8423337324987061
+ 3.4195000000001758e-06 2.8423334005020462
+ 3.4205000000001759e-06 2.8423337328802658
+ 3.421500000000176e-06 2.8423334001157921
+ 3.422500000000176e-06 2.8423337332602729
+ 3.4235000000001761e-06 2.8423333997310229
+ 3.4245000000001762e-06 2.842333733638692
+ 3.4255000000001758e-06 2.8423333993478721
+ 3.4265000000001759e-06 2.8423337340154888
+ 3.427500000000176e-06 2.8423333989663382
+ 3.4285000000001761e-06 2.8423337343906629
+ 3.429500000000177e-06 2.842333398586375
+ 3.430500000000177e-06 2.842333734764257
+ 3.4315000000001771e-06 2.8423333982079968
+ 3.4325000000001772e-06 2.8423337351362452
+ 3.4335000000001769e-06 2.8423333978311982
+ 3.4345000000001769e-06 2.842333735506636
+ 3.435500000000177e-06 2.842333397455973
+ 3.4365000000001771e-06 2.8423337358754308
+ 3.4375000000001772e-06 2.8423333970822591
+ 3.4385000000001768e-06 2.8423337362427601
+ 3.4395000000001769e-06 2.8423333967099529
+ 3.440500000000177e-06 2.8423337366086949
+ 3.441500000000177e-06 2.8423333963390571
+ 3.442500000000178e-06 2.8423337369731541
+ 3.443500000000178e-06 2.842333395969626
+ 3.4445000000001781e-06 2.8423337373361051
+ 3.4455000000001782e-06 2.842333395601762
+ 3.4465000000001778e-06 2.84233373769744
+ 3.4475000000001779e-06 2.8423333952354768
+ 3.448500000000178e-06 2.842333738057178
+ 3.4495000000001781e-06 2.8423333948707712
+ 3.4505000000001781e-06 2.842333738415336
+ 3.4515000000001782e-06 2.8423333945076439
+ 3.4525000000001779e-06 2.842333738771873
+ 3.4535000000001779e-06 2.8423333941460989
+ 3.454500000000178e-06 2.8423337391269081
+ 3.4555000000001789e-06 2.8423333937859638
+ 3.456500000000179e-06 2.8423337394804959
+ 3.4575000000001791e-06 2.8423333934273161
+ 3.4585000000001792e-06 2.842333739832593
+ 3.4595000000001788e-06 2.8423333930700818
+ 3.4605000000001789e-06 2.8423337401832831
+ 3.461500000000179e-06 2.8423333927142811
+ 3.462500000000179e-06 2.8423337405326121
+ 3.4635000000001791e-06 2.8423333923597212
+ 3.4645000000001792e-06 2.8423337408805471
+ 3.4655000000001788e-06 2.8423333920066649
+ 3.4665000000001789e-06 2.8423337412269749
+ 3.467500000000179e-06 2.842333391655135
+ 3.4685000000001791e-06 2.8423337415717982
+ 3.46950000000018e-06 2.8423333913051798
+ 3.4705000000001801e-06 2.842333741915049
+ 3.4715000000001801e-06 2.8423333909567838
+ 3.4725000000001802e-06 2.8423337422567911
+ 3.4735000000001799e-06 2.8423333906098192
+ 3.4745000000001799e-06 2.8423337425970838
+ 3.47550000000018e-06 2.842333390264272
+ 3.4765000000001801e-06 2.8423337429359781
+ 3.4775000000001802e-06 2.8423333899201499
+ 3.4785000000001798e-06 2.8423337432734059
+ 3.4795000000001799e-06 2.8423333895774339
+ 3.48050000000018e-06 2.8423337436094629
+ 3.48150000000018e-06 2.8423333892360652
+ 3.482500000000181e-06 2.842333743944164
+ 3.483500000000181e-06 2.8423333888961042
+ 3.4845000000001811e-06 2.842333744277358
+ 3.4855000000001812e-06 2.8423333885575581
+ 3.4865000000001808e-06 2.8423337446092232
+ 3.4875000000001809e-06 2.842333388220359
+ 3.488500000000181e-06 2.8423337449396842
+ 3.4895000000001811e-06 2.8423333878845791
+ 3.4905000000001811e-06 2.842333745268709
+ 3.4915000000001812e-06 2.8423333875501808
+ 3.4925000000001809e-06 2.8423337455963562
+ 3.4935000000001809e-06 2.8423333872171939
+ 3.494500000000181e-06 2.842333745922514
+ 3.4955000000001819e-06 2.8423333868856702
+ 3.496500000000182e-06 2.8423337462472502
+ 3.4975000000001821e-06 2.842333386555604
+ 3.4985000000001822e-06 2.8423337465704819
+ 3.4995000000001818e-06 2.8423333862270268
+ 3.5005000000001819e-06 2.8423337468922392
+ 3.501500000000182e-06 2.8423333858998459
+ 3.502500000000182e-06 2.8423337472126522
+ 3.5035000000001821e-06 2.842333385573939
+ 3.5045000000001822e-06 2.842333747531776
+ 3.5055000000001818e-06 2.8423333852493422
+ 3.5065000000001819e-06 2.8423337478496822
+ 3.507500000000182e-06 2.8423333849258481
+ 3.5085000000001821e-06 2.8423337481663751
+ 3.509500000000183e-06 2.8423333846036929
+ 3.5105000000001831e-06 2.842333748481682
+ 3.5115000000001831e-06 2.8423333842829321
+ 3.5125000000001832e-06 2.8423337487955309
+ 3.5135000000001829e-06 2.8423333839636409
+ 3.5145000000001829e-06 2.8423337491079481
+ 3.515500000000183e-06 2.8423333836457569
+ 3.5165000000001831e-06 2.84233374941891
+ 3.5175000000001832e-06 2.842333383329319
+ 3.5185000000001828e-06 2.842333749728454
+ 3.5195000000001829e-06 2.8423333830142741
+ 3.520500000000183e-06 2.8423337500365999
+ 3.521500000000183e-06 2.8423333827006001
+ 3.522500000000184e-06 2.8423337503434518
+ 3.523500000000184e-06 2.8423333823881758
+ 3.5245000000001841e-06 2.842333750648959
+ 3.5255000000001842e-06 2.8423333820770211
+ 3.5265000000001838e-06 2.8423337509533289
+ 3.5275000000001839e-06 2.842333381766998
+ 3.528500000000184e-06 2.842333751256489
+ 3.5295000000001841e-06 2.8423333814581961
+ 3.5305000000001841e-06 2.8423337515584639
+ 3.5315000000001838e-06 2.8423333811505911
+ 3.5325000000001839e-06 2.842333751859103
+ 3.5335000000001839e-06 2.842333380844388
+ 3.534500000000184e-06 2.842333752158348
+ 3.5355000000001849e-06 2.8423333805395732
+ 3.536500000000185e-06 2.8423337524561831
+ 3.5375000000001851e-06 2.8423333802361479
+ 3.5385000000001852e-06 2.8423337527525869
+ 3.5395000000001848e-06 2.8423333799341881
+ 3.5405000000001849e-06 2.8423337530475492
+ 3.541500000000185e-06 2.8423333796335992
+ 3.542500000000185e-06 2.842333753341209
+ 3.5435000000001851e-06 2.84233337933426
+ 3.5445000000001852e-06 2.8423337536336799
+ 3.5455000000001848e-06 2.8423333790360061
+ 3.5465000000001849e-06 2.8423337539250411
+ 3.547500000000185e-06 2.8423333787389069
+ 3.5485000000001851e-06 2.8423337542152032
+ 3.549500000000186e-06 2.8423333784430338
+ 3.5505000000001861e-06 2.8423337545041192
+ 3.5515000000001861e-06 2.8423333781484099
+ 3.5525000000001858e-06 2.8423337547917842
+ 3.5535000000001859e-06 2.8423333778550401
+ 3.5545000000001859e-06 2.8423337550781511
+ 3.555500000000186e-06 2.842333377562948
+ 3.5565000000001861e-06 2.8423337553632551
+ 3.5575000000001862e-06 2.8423333772721469
+ 3.5585000000001858e-06 2.8423337556470298
+ 3.5595000000001859e-06 2.8423333769826771
+ 3.560500000000186e-06 2.8423337559294719
+ 3.561500000000186e-06 2.8423333766944978
+ 3.562500000000187e-06 2.8423337562106701
+ 3.563500000000187e-06 2.842333376407538
+ 3.5645000000001871e-06 2.842333756490603
+ 3.5655000000001872e-06 2.8423333761218239
+ 3.5665000000001868e-06 2.842333756769305
+ 3.5675000000001869e-06 2.8423333758373741
+ 3.568500000000187e-06 2.8423337570467289
+ 3.5695000000001871e-06 2.8423333755541331
+ 3.5705000000001871e-06 2.8423337573230039
+ 3.5715000000001868e-06 2.842333375272001
+ 3.5725000000001869e-06 2.8423337575982059
+ 3.5735000000001869e-06 2.8423333749909681
+ 3.574500000000187e-06 2.842333757872209
+ 3.5755000000001879e-06 2.8423333747111301
+ 3.576500000000188e-06 2.842333758145033
+ 3.5775000000001881e-06 2.8423333744324948
+ 3.5785000000001882e-06 2.8423337584166561
+ 3.5795000000001878e-06 2.8423333741550421
+ 3.5805000000001879e-06 2.8423337586870119
+ 3.581500000000188e-06 2.8423333738789021
+ 3.582500000000188e-06 2.842333758956074
+ 3.5835000000001881e-06 2.8423333736040428
+ 3.5845000000001882e-06 2.8423337592238931
+ 3.5855000000001878e-06 2.842333373330364
+ 3.5865000000001879e-06 2.8423337594904798
+ 3.587500000000188e-06 2.8423333730579632
+ 3.5885000000001881e-06 2.842333759755804
+ 3.589500000000189e-06 2.8423333727867579
+ 3.5905000000001891e-06 2.842333760019971
+ 3.5915000000001891e-06 2.8423333725167002
+ 3.5925000000001888e-06 2.842333760283033
+ 3.5935000000001889e-06 2.8423333722477229
+ 3.5945000000001889e-06 2.8423337605449701
+ 3.595500000000189e-06 2.8423333719798309
+ 3.5965000000001891e-06 2.8423337608058321
+ 3.5975000000001892e-06 2.842333371713051
+ 3.5985000000001888e-06 2.8423337610655741
+ 3.5995000000001889e-06 2.8423333714473871
+ 3.600500000000189e-06 2.8423337613241939
+ 3.601500000000189e-06 2.8423333711828409
+ 3.60250000000019e-06 2.842333761581644
+ 3.60350000000019e-06 2.842333370919603
+ 3.6045000000001901e-06 2.8423337618376978
+ 3.6055000000001902e-06 2.8423333706576539
+ 3.6065000000001898e-06 2.8423337620925269
+ 3.6075000000001899e-06 2.8423333703968838
+ 3.60850000000019e-06 2.8423337623462621
+ 3.6095000000001901e-06 2.842333370137208
+ 3.6105000000001901e-06 2.8423337625988609
+ 3.6115000000001898e-06 2.8423333698786011
+ 3.6125000000001899e-06 2.842333762850429
+ 3.61350000000019e-06 2.84233336962106
+ 3.61450000000019e-06 2.8423337631008851
+ 3.6155000000001909e-06 2.842333369364614
+ 3.616500000000191e-06 2.8423337633502421
+ 3.6175000000001911e-06 2.8423333691093009
+ 3.6185000000001912e-06 2.8423337635984591
+ 3.6195000000001908e-06 2.8423333688551158
+ 3.6205000000001909e-06 2.8423337638456241
+ 3.621500000000191e-06 2.8423333686019241
+ 3.6225000000001911e-06 2.8423337640916531
+ 3.6235000000001911e-06 2.8423333683500021
+ 3.6245000000001912e-06 2.8423337643364208
+ 3.6255000000001909e-06 2.842333368099256
+ 3.6265000000001909e-06 2.842333764580053
+ 3.627500000000191e-06 2.8423333678496561
+ 3.6285000000001919e-06 2.842333764822528
+ 3.629500000000192e-06 2.8423333676011739
+ 3.6305000000001921e-06 2.8423337650639069
+ 3.6315000000001922e-06 2.8423333673537612
+ 3.6325000000001918e-06 2.8423337653042302
+ 3.6335000000001919e-06 2.8423333671074009
+ 3.634500000000192e-06 2.8423337655434682
+ 3.635500000000192e-06 2.842333366862118
+ 3.6365000000001921e-06 2.8423337657816901
+ 3.6375000000001922e-06 2.8423333666178299
+ 3.6385000000001918e-06 2.8423337660188999
+ 3.6395000000001919e-06 2.84233336637456
+ 3.640500000000192e-06 2.8423337662550789
+ 3.6415000000001921e-06 2.842333366132324
+ 3.642500000000193e-06 2.8423337664901851
+ 3.6435000000001931e-06 2.8423333658912329
+ 3.6445000000001931e-06 2.8423337667240882
+ 3.6455000000001932e-06 2.8423333656513639
+ 3.6465000000001929e-06 2.8423337669567559
+ 3.6475000000001929e-06 2.8423333654126668
+ 3.648500000000193e-06 2.842333767188344
+ 3.6495000000001931e-06 2.84233336517498
+ 3.6505000000001932e-06 2.8423337674189399
+ 3.6515000000001928e-06 2.842333364938304
+ 3.6525000000001929e-06 2.842333767648511
+ 3.653500000000193e-06 2.8423333647026472
+ 3.654500000000193e-06 2.84233376787703
+ 3.655500000000194e-06 2.8423333644680411
+ 3.656500000000194e-06 2.842333768104528
+ 3.6575000000001941e-06 2.8423333642344368
+ 3.6585000000001942e-06 2.8423337683310419
+ 3.6595000000001938e-06 2.8423333640018069
+ 3.6605000000001939e-06 2.8423337685565548
+ 3.661500000000194e-06 2.8423333637702068
+ 3.6625000000001941e-06 2.8423337687810459
+ 3.6635000000001941e-06 2.8423333635396029
+ 3.6645000000001942e-06 2.842333769004461
+ 3.6655000000001939e-06 2.8423333633101322
+ 3.6665000000001939e-06 2.8423337692267432
+ 3.667500000000194e-06 2.8423333630818108
+ 3.6685000000001949e-06 2.8423337694478779
+ 3.669500000000195e-06 2.8423333628545961
+ 3.6705000000001951e-06 2.8423337696679538
+ 3.6715000000001952e-06 2.842333362628394
+ 3.6725000000001948e-06 2.842333769887019
+ 3.6735000000001949e-06 2.8423333624031768
+ 3.674500000000195e-06 2.842333770105129
+ 3.675500000000195e-06 2.8423333621789379
+ 3.6765000000001951e-06 2.84233377032225
+ 3.6775000000001952e-06 2.8423333619556321
+ 3.6785000000001948e-06 2.8423337705384628
+ 3.6795000000001949e-06 2.842333361733234
+ 3.680500000000195e-06 2.8423337707537351
+ 3.6815000000001951e-06 2.8423333615118271
+ 3.682500000000196e-06 2.842333770967989
+ 3.6835000000001961e-06 2.8423333612914612
+ 3.6845000000001961e-06 2.842333771181182
+ 3.6855000000001962e-06 2.842333361072154
+ 3.6865000000001959e-06 2.8423337713933319
+ 3.6875000000001959e-06 2.8423333608538299
+ 3.688500000000196e-06 2.842333771604483
+ 3.6895000000001961e-06 2.8423333606365602
+ 3.6905000000001962e-06 2.8423337718145958
+ 3.6915000000001958e-06 2.8423333604203189
+ 3.6925000000001959e-06 2.842333772023645
+ 3.693500000000196e-06 2.8423333602051262
+ 3.694500000000196e-06 2.842333772231703
+ 3.695500000000197e-06 2.8423333599908949
+ 3.696500000000197e-06 2.8423337724388671
+ 3.6975000000001971e-06 2.842333359777478
+ 3.6985000000001972e-06 2.8423337726451301
+ 3.6995000000001968e-06 2.842333359565036
+ 3.7005000000001969e-06 2.8423337728504339
+ 3.701500000000197e-06 2.842333359353562
+ 3.7025000000001971e-06 2.842333773054706
+ 3.7035000000001971e-06 2.8423333591431179
+ 3.7045000000001972e-06 2.8423337732580229
+ 3.7055000000001969e-06 2.8423333589336148
+ 3.7065000000001969e-06 2.8423337734603571
+ 3.707500000000197e-06 2.8423333587250839
+ 3.7085000000001979e-06 2.8423337736617391
+ 3.709500000000198e-06 2.8423333585175108
+ 3.7105000000001981e-06 2.842333773862145
+ 3.7115000000001982e-06 2.8423333583109121
+ 3.7125000000001978e-06 2.8423337740616121
+ 3.7135000000001979e-06 2.8423333581052441
+ 3.714500000000198e-06 2.8423337742601058
+ 3.715500000000198e-06 2.8423333579005479
+ 3.7165000000001981e-06 2.842333774457662
+ 3.7175000000001982e-06 2.84233335769677
+ 3.7185000000001978e-06 2.8423337746542758
+ 3.7195000000001979e-06 2.8423333574939309
+ 3.720500000000198e-06 2.842333774849958
+ 3.7215000000001981e-06 2.8423333572920781
+ 3.722500000000199e-06 2.842333775044636
+ 3.7235000000001991e-06 2.8423333570911868
+ 3.7245000000001991e-06 2.8423337752383331
+ 3.7255000000001988e-06 2.8423333568912459
+ 3.7265000000001989e-06 2.8423337754311548
+ 3.7275000000001989e-06 2.8423333566921269
+ 3.728500000000199e-06 2.8423337756231319
+ 3.7295000000001991e-06 2.8423333564939148
+ 3.7305000000001992e-06 2.8423337758142071
+ 3.7315000000001988e-06 2.8423333562965798
+ 3.7325000000001989e-06 2.8423337760043932
+ 3.733500000000199e-06 2.8423333561001418
+ 3.734500000000199e-06 2.8423337761936751
+ 3.7355000000002e-06 2.8423333559046271
+ 3.7365000000002e-06 2.842333776382068
+ 3.7375000000002001e-06 2.842333355709965
+ 3.7385000000002002e-06 2.8423337765695109
+ 3.7395000000001998e-06 2.8423333555163461
+ 3.7405000000001999e-06 2.842333776755877
+ 3.7415000000002e-06 2.8423333553237691
+ 3.7425000000002001e-06 2.8423337769413068
+ 3.7435000000002001e-06 2.8423333551320842
+ 3.7445000000001998e-06 2.8423337771257891
+ 3.7455000000001999e-06 2.8423333549413661
+ 3.7465000000001999e-06 2.84233377730936
+ 3.7475000000002e-06 2.8423333547515059
+ 3.7485000000002009e-06 2.8423337774921089
+ 3.749500000000201e-06 2.8423333545624558
+ 3.7505000000002011e-06 2.8423337776740349
+ 3.7515000000002012e-06 2.8423333543741891
+ 3.7525000000002008e-06 2.8423337778552109
+ 3.7535000000002009e-06 2.8423333541866929
+ 3.754500000000201e-06 2.8423337780355542
+ 3.755500000000201e-06 2.842333354000059
+ 3.7565000000002011e-06 2.8423337782150311
+ 3.7575000000002012e-06 2.842333353814313
+ 3.7585000000002008e-06 2.8423337783935918
+ 3.7595000000002009e-06 2.842333353629555
+ 3.760500000000201e-06 2.8423337785711311
+ 3.7615000000002011e-06 2.84233335344577
+ 3.762500000000202e-06 2.8423337787477299
+ 3.7635000000002021e-06 2.8423333532628869
+ 3.7645000000002021e-06 2.842333778923412
+ 3.7655000000002018e-06 2.8423333530809352
+ 3.7665000000002019e-06 2.8423337790981971
+ 3.7675000000002019e-06 2.842333352899868
+ 3.768500000000202e-06 2.8423337792720851
+ 3.7695000000002021e-06 2.8423333527196628
+ 3.7705000000002022e-06 2.8423337794451862
+ 3.7715000000002018e-06 2.8423333525401908
+ 3.7725000000002019e-06 2.842333779617622
+ 3.773500000000202e-06 2.8423333523613481
+ 3.774500000000202e-06 2.8423337797893269
+ 3.775500000000203e-06 2.8423333521833358
+ 3.776500000000203e-06 2.8423337799601551
+ 3.7775000000002031e-06 2.842333352006245
+ 3.7785000000002032e-06 2.8423337801300388
+ 3.7795000000002028e-06 2.8423333518301028
+ 3.7805000000002029e-06 2.842333780298989
+ 3.781500000000203e-06 2.8423333516548661
+ 3.7825000000002031e-06 2.842333780467031
+ 3.7835000000002031e-06 2.8423333514805371
+ 3.7845000000002028e-06 2.8423337806341911
+ 3.7855000000002029e-06 2.842333351307055
+ 3.7865000000002029e-06 2.842333780800518
+ 3.787500000000203e-06 2.84233335113445
+ 3.7885000000002039e-06 2.8423337809659368
+ 3.789500000000204e-06 2.8423333509626669
+ 3.7905000000002041e-06 2.8423337811306069
+ 3.7915000000002042e-06 2.842333350791614
+ 3.7925000000002038e-06 2.8423337812945388
+ 3.7935000000002039e-06 2.8423333506213071
+ 3.794500000000204e-06 2.8423337814577461
+ 3.795500000000204e-06 2.842333350451745
+ 3.7965000000002041e-06 2.8423337816201819
+ 3.7975000000002042e-06 2.842333350282964
+ 3.7985000000002039e-06 2.8423337817818051
+ 3.7995000000002039e-06 2.8423333501150641
+ 3.800500000000204e-06 2.842333781942461
+ 3.8015000000002041e-06 2.8423333499481029
+ 3.802500000000205e-06 2.842333782102251
+ 3.8035000000002051e-06 2.8423333497819678
+ 3.8045000000002051e-06 2.8423337822612149
+ 3.8055000000002048e-06 2.8423333496166561
+ 3.8065000000002049e-06 2.8423337824193902
+ 3.8075000000002049e-06 2.8423333494521592
+ 3.808500000000205e-06 2.8423337825767319
+ 3.8095000000002051e-06 2.8423333492884408
+ 3.8105000000002052e-06 2.842333782733371
+ 3.8115000000002048e-06 2.8423333491254108
+ 3.8125000000002049e-06 2.842333782889213
+ 3.813500000000205e-06 2.8423333489632379
+ 3.8145000000002051e-06 2.8423337830442308
+ 3.8155000000002051e-06 2.8423333488018381
+ 3.8165000000002048e-06 2.8423337831984661
+ 3.8175000000002036e-06 2.8423333486412798
+ 3.8185000000002041e-06 2.842333783351854
+ 3.8195000000002037e-06 2.8423333484815578
+ 3.8205000000002034e-06 2.8423337835044138
+ 3.821500000000203e-06 2.8423333483225912
+ 3.8225000000002027e-06 2.842333783656267
+ 3.8235000000002023e-06 2.8423333481643751
+ 3.824500000000202e-06 2.8423337838073359
+ 3.8255000000002016e-06 2.8423333480069131
+ 3.8265000000002013e-06 2.8423337839576779
+ 3.8275000000002009e-06 2.8423333478502082
+ 3.8285000000002006e-06 2.8423337841072081
+ 3.8295000000002003e-06 2.8423333476943098
+ 3.8305000000001999e-06 2.8423337842559828
+ 3.8315000000002004e-06 2.8423333475391148
+ 3.8325000000001992e-06 2.8423337844040328
+ 3.8335000000001989e-06 2.8423333473847272
+ 3.8345000000001994e-06 2.8423337845512329
+ 3.8355000000001982e-06 2.8423333472312629
+ 3.8365000000001978e-06 2.8423337846974861
+ 3.8375000000001966e-06 2.842333347078581
+ 3.8385000000001971e-06 2.8423337848430519
+ 3.8395000000001968e-06 2.8423333469266052
+ 3.8405000000001964e-06 2.8423337849879311
+ 3.8415000000001961e-06 2.8423333467753018
+ 3.8425000000001957e-06 2.8423337851321091
+ 3.8435000000001954e-06 2.8423333466247249
+ 3.844500000000195e-06 2.8423337852755628
+ 3.8455000000001947e-06 2.842333346474871
+ 3.8465000000001943e-06 2.8423337854183379
+ 3.847500000000194e-06 2.84233334632563
+ 3.8485000000001936e-06 2.8423337855604189
+ 3.8495000000001933e-06 2.8423333461771949
+ 3.8505000000001929e-06 2.84233378570165
+ 3.8515000000001926e-06 2.8423333460296281
+ 3.8525000000001922e-06 2.8423337858420221
+ 3.8535000000001919e-06 2.842333345882893
+ 3.8545000000001924e-06 2.8423337859815749
+ 3.8555000000001912e-06 2.8423333457369728
+ 3.8565000000001908e-06 2.8423337861203448
+ 3.8575000000001896e-06 2.8423333455917841
+ 3.8585000000001901e-06 2.8423337862584002
+ 3.8595000000001898e-06 2.8423333454473321
+ 3.8605000000001886e-06 2.842333786395709
+ 3.8615000000001891e-06 2.8423333453035862
+ 3.8625000000001888e-06 2.8423337865323628
+ 3.8635000000001884e-06 2.8423333451604722
+ 3.8645000000001881e-06 2.84233378666837
+ 3.8655000000001877e-06 2.8423333450179942
+ 3.8665000000001874e-06 2.8423337868037519
+ 3.867500000000187e-06 2.842333344876204
+ 3.8685000000001867e-06 2.8423337869384211
+ 3.8695000000001863e-06 2.842333344735088
+ 3.870500000000186e-06 2.8423337870724201
+ 3.8715000000001856e-06 2.8423333445946972
+ 3.8725000000001853e-06 2.8423337872056358
+ 3.8735000000001849e-06 2.8423333444551009
+ 3.8745000000001854e-06 2.8423337873380721
+ 3.8755000000001842e-06 2.8423333443163261
+ 3.8765000000001839e-06 2.8423337874696162
+ 3.8775000000001844e-06 2.84233334417838
+ 3.8785000000001832e-06 2.8423337876004058
+ 3.8795000000001828e-06 2.8423333440411809
+ 3.8805000000001816e-06 2.8423337877304879
+ 3.8815000000001821e-06 2.8423333439046492
+ 3.8825000000001818e-06 2.8423337878599111
+ 3.8835000000001806e-06 2.8423333437687992
+ 3.8845000000001811e-06 2.8423337879886632
+ 3.8855000000001807e-06 2.8423333436335549
+ 3.8865000000001804e-06 2.8423337881168869
+ 3.88750000000018e-06 2.8423333434987881
+ 3.8885000000001797e-06 2.8423337882445439
+ 3.8895000000001793e-06 2.842333343364702
+ 3.890500000000179e-06 2.8423337883714659
+ 3.8915000000001787e-06 2.8423333432314268
+ 3.8925000000001783e-06 2.8423337884975859
+ 3.893500000000178e-06 2.842333343098888
+ 3.8945000000001776e-06 2.8423337886229691
+ 3.8955000000001773e-06 2.8423333429671049
+ 3.8965000000001769e-06 2.8423337887475619
+ 3.8975000000001774e-06 2.8423333428361128
+ 3.8985000000001762e-06 2.842333788871394
+ 3.8995000000001759e-06 2.8423333427058419
+ 3.9005000000001764e-06 2.8423337889945728
+ 3.9015000000001752e-06 2.842333342576191
+ 3.9025000000001748e-06 2.8423337891171072
+ 3.9035000000001736e-06 2.8423333424471871
+ 3.9045000000001741e-06 2.8423337892390319
+ 3.9055000000001738e-06 2.842333342318784
+ 3.9065000000001726e-06 2.84233378936033
+ 3.9075000000001731e-06 2.8423333421910111
+ 3.9085000000001727e-06 2.8423337894810108
+ 3.9095000000001724e-06 2.8423333420638608
+ 3.910500000000172e-06 2.8423337896010352
+ 3.9115000000001717e-06 2.8423333419374819
+ 3.9125000000001713e-06 2.842333789720227
+ 3.913500000000171e-06 2.842333341811814
+ 3.9145000000001706e-06 2.8423337898387881
+ 3.9155000000001703e-06 2.8423333416868068
+ 3.9165000000001699e-06 2.8423337899566778
+ 3.9175000000001696e-06 2.842333341562405
+ 3.9185000000001692e-06 2.8423337900740031
+ 3.9195000000001689e-06 2.842333341438648
+ 3.9205000000001694e-06 2.8423337901906982
+ 3.9215000000001682e-06 2.8423333413154341
+ 3.9225000000001679e-06 2.8423337903067631
+ 3.9235000000001683e-06 2.842333341192969
+ 3.9245000000001672e-06 2.842333790422038
+ 3.9255000000001668e-06 2.842333341071289
+ 3.9265000000001656e-06 2.842333790536562
+ 3.9275000000001661e-06 2.842333340950332
+ 3.9285000000001658e-06 2.8423337906503869
+ 3.9295000000001654e-06 2.842333340830058
+ 3.9305000000001651e-06 2.8423337907635342
+ 3.9315000000001647e-06 2.842333340710407
+ 3.9325000000001644e-06 2.8423337908761148
+ 3.933500000000164e-06 2.842333340591312
+ 3.9345000000001637e-06 2.8423337909881492
+ 3.9355000000001633e-06 2.8423333404727531
+ 3.936500000000163e-06 2.8423337910996578
+ 3.9375000000001626e-06 2.8423333403547191
+ 3.9385000000001623e-06 2.8423337912106361
+ 3.9395000000001619e-06 2.8423333402372668
+ 3.9405000000001616e-06 2.8423337913209412
+ 3.9415000000001612e-06 2.8423333401205122
+ 3.9425000000001609e-06 2.8423337914305198
+ 3.9435000000001614e-06 2.8423333400045081
+ 3.9445000000001602e-06 2.842333791539406
+ 3.9455000000001598e-06 2.842333339889183
+ 3.9465000000001586e-06 2.842333791647548
+ 3.9475000000001591e-06 2.8423333397746182
+ 3.9485000000001588e-06 2.8423337917549829
+ 3.9495000000001576e-06 2.842333339660716
+ 3.9505000000001581e-06 2.8423337918617779
+ 3.9515000000001577e-06 2.8423333395474781
+ 3.9525000000001574e-06 2.8423337919678899
+ 3.953500000000157e-06 2.8423333394348229
+ 3.9545000000001567e-06 2.842333792073513
+ 3.9555000000001564e-06 2.8423333393226402
+ 3.956500000000156e-06 2.84233379217866
+ 3.9575000000001557e-06 2.842333339210974
+ 3.9585000000001553e-06 2.8423337922832621
+ 3.959500000000155e-06 2.84233333909981
+ 3.9605000000001546e-06 2.8423337923874001
+ 3.9615000000001543e-06 2.8423333389891439
+ 3.9625000000001539e-06 2.842333792490948
+ 3.9635000000001544e-06 2.8423333388791341
+ 3.9645000000001532e-06 2.8423337925937808
+ 3.9655000000001529e-06 2.842333338769909
+ 3.9665000000001534e-06 2.8423337926958538
+ 3.9675000000001522e-06 2.8423333386614038
+ 3.9685000000001518e-06 2.8423337927971599
+ 3.9695000000001506e-06 2.8423333385536682
+ 3.9705000000001511e-06 2.8423337928977448
+ 3.9715000000001508e-06 2.8423333384466392
+ 3.9725000000001496e-06 2.8423337929976862
+ 3.9735000000001501e-06 2.842333338340135
+ 3.9745000000001497e-06 2.8423337930971599
+ 3.9755000000001494e-06 2.842333338234091
+ 3.976500000000149e-06 2.8423337931961519
+ 3.9775000000001487e-06 2.8423333381285749
+ 3.9785000000001483e-06 2.842333793294618
+ 3.979500000000148e-06 2.8423333380235709
+ 3.9805000000001476e-06 2.8423337933925921
+ 3.9815000000001473e-06 2.8423333379190199
+ 3.9825000000001469e-06 2.8423337934900799
+ 3.9835000000001466e-06 2.8423333378150319
+ 3.9845000000001462e-06 2.8423337935869779
+ 3.9855000000001459e-06 2.842333337711648
+ 3.9865000000001464e-06 2.8423337936832072
+ 3.9875000000001452e-06 2.8423333376090381
+ 3.9885000000001449e-06 2.8423337937786259
+ 3.9895000000001454e-06 2.8423333375071391
+ 3.9905000000001442e-06 2.8423337938733861
+ 3.9915000000001438e-06 2.8423333374059032
+ 3.9925000000001426e-06 2.842333793967541
+ 3.9935000000001431e-06 2.842333337305222
+ 3.9945000000001428e-06 2.842333794061243
+ 3.9955000000001424e-06 2.84233333720492
+ 3.9965000000001421e-06 2.8423337941544582
+ 3.9975000000001417e-06 2.8423333371051789
+ 3.9985000000001414e-06 2.8423337942471081
+ 3.999500000000141e-06 2.8423333370060271
+ 4.0005000000001407e-06 2.8423337943391842
+ 4.0015000000001403e-06 2.8423333369074331
+ 4.00250000000014e-06 2.8423337944306928
+ 4.0035000000001396e-06 2.8423333368093968
+ 4.0045000000001393e-06 2.842333794521636
+ 4.0055000000001389e-06 2.8423333367119699
+ 4.0065000000001386e-06 2.8423337946119229
+ 4.0075000000001382e-06 2.8423333366151891
+ 4.0085000000001379e-06 2.842333794701621
+ 4.0095000000001384e-06 2.8423333365189598
+ 4.0105000000001372e-06 2.8423337947907861
+ 4.0115000000001368e-06 2.8423333364232382
+ 4.0125000000001356e-06 2.842333794879448
+ 4.0135000000001361e-06 2.8423333363280441
+ 4.0145000000001358e-06 2.8423337949675598
+ 4.0155000000001346e-06 2.8423333362334011
+ 4.0165000000001351e-06 2.8423337950551302
+ 4.0175000000001348e-06 2.842333336139276
+ 4.0185000000001344e-06 2.8423337951421819
+ 4.0195000000001341e-06 2.8423333360457028
+ 4.0205000000001337e-06 2.8423337952286518
+ 4.0215000000001334e-06 2.8423333359527199
+ 4.022500000000133e-06 2.8423337953145289
+ 4.0235000000001327e-06 2.8423333358603768
+ 4.0245000000001323e-06 2.8423337953997549
+ 4.025500000000132e-06 2.8423333357686422
+ 4.0265000000001316e-06 2.842333795484421
+ 4.0275000000001313e-06 2.842333335677476
+ 4.0285000000001309e-06 2.842333795568488
+ 4.0295000000001314e-06 2.8423333355868139
+ 4.0305000000001302e-06 2.842333795652161
+ 4.0315000000001299e-06 2.842333335496575
+ 4.0325000000001304e-06 2.8423337957353532
+ 4.0335000000001292e-06 2.8423333354067921
+ 4.0345000000001288e-06 2.8423337958181709
+ 4.0355000000001276e-06 2.8423333353174032
+ 4.0365000000001281e-06 2.84233379590043
+ 4.0375000000001278e-06 2.8423333352286351
+ 4.0385000000001266e-06 2.8423337959820909
+ 4.0395000000001271e-06 2.8423333351404798
+ 4.0405000000001267e-06 2.8423337960631399
+ 4.0415000000001264e-06 2.8423333350529258
+ 4.042500000000126e-06 2.8423337961435822
+ 4.0435000000001257e-06 2.8423333349659918
+ 4.0445000000001253e-06 2.842333796223353
+ 4.045500000000125e-06 2.842333334879739
+ 4.0465000000001246e-06 2.842333796302543
+ 4.0475000000001243e-06 2.842333334793985
+ 4.048500000000124e-06 2.8423337963812751
+ 4.0495000000001236e-06 2.842333334708659
+ 4.0505000000001233e-06 2.8423337964595849
+ 4.0515000000001229e-06 2.8423333346237691
+ 4.0525000000001234e-06 2.84233379653746
+ 4.0535000000001222e-06 2.8423333345392772
+ 4.0545000000001219e-06 2.8423337966149078
+ 4.0555000000001224e-06 2.842333334455267
+ 4.0565000000001212e-06 2.842333796691876
+ 4.0575000000001208e-06 2.842333334371753
+ 4.0585000000001196e-06 2.8423337967683491
+ 4.0595000000001201e-06 2.8423333342887029
+ 4.0605000000001198e-06 2.8423337968443172
+ 4.0615000000001186e-06 2.8423333342062702
+ 4.0625000000001191e-06 2.842333796919581
+ 4.0635000000001187e-06 2.8423333341245209
+ 4.0645000000001184e-06 2.8423337969942302
+ 4.065500000000118e-06 2.842333334043333
+ 4.0665000000001177e-06 2.8423337970683331
+ 4.0675000000001173e-06 2.842333333962705
+ 4.068500000000117e-06 2.8423337971419662
+ 4.0695000000001166e-06 2.8423333338824488
+ 4.0705000000001163e-06 2.8423337972151681
+ 4.0715000000001159e-06 2.8423333338026922
+ 4.0725000000001156e-06 2.842333797287881
+ 4.0735000000001152e-06 2.84233333372338
+ 4.0745000000001149e-06 2.8423337973601441
+ 4.0755000000001154e-06 2.8423333336445609
+ 4.0765000000001142e-06 2.8423337974319161
+ 4.0775000000001138e-06 2.8423333335662142
+ 4.0785000000001143e-06 2.8423337975032381
+ 4.0795000000001132e-06 2.842333333488356
+ 4.0805000000001128e-06 2.8423337975740002
+ 4.0815000000001116e-06 2.842333333411005
+ 4.0825000000001121e-06 2.8423337976443008
+ 4.0835000000001118e-06 2.842333333334162
+ 4.0845000000001114e-06 2.842333797714081
+ 4.0855000000001111e-06 2.8423333332578138
+ 4.0865000000001107e-06 2.842333797783402
+ 4.0875000000001104e-06 2.8423333331819252
+ 4.08850000000011e-06 2.8423337978521861
+ 4.0895000000001097e-06 2.8423333331066152
+ 4.0905000000001093e-06 2.8423337979204191
+ 4.091500000000109e-06 2.8423333330318288
+ 4.0925000000001086e-06 2.8423337979881609
+ 4.0935000000001083e-06 2.842333332957518
+ 4.0945000000001079e-06 2.842333798055416
+ 4.0955000000001076e-06 2.8423333328836788
+ 4.0965000000001072e-06 2.8423337981222221
+ 4.0975000000001069e-06 2.842333332810294
+ 4.0985000000001074e-06 2.8423337981885801
+ 4.0995000000001062e-06 2.8423333327373488
+ 4.1005000000001058e-06 2.8423337982544852
+ 4.1015000000001046e-06 2.8423333326648992
+ 4.1025000000001051e-06 2.8423337983198498
+ 4.1035000000001048e-06 2.842333332592935
+ 4.1045000000001036e-06 2.8423337983848191
+ 4.1055000000001041e-06 2.8423333325213749
+ 4.1065000000001037e-06 2.842333798449312
+ 4.1075000000001034e-06 2.8423333324503068
+ 4.108500000000103e-06 2.8423337985134132
+ 4.1095000000001027e-06 2.8423333323795741
+ 4.1105000000001024e-06 2.8423337985771071
+ 4.111500000000102e-06 2.842333332309348
+ 4.1125000000001017e-06 2.8423337986401869
+ 4.1135000000001013e-06 2.842333332239757
+ 4.114500000000101e-06 2.842333798702708
+ 4.1155000000001006e-06 2.842333332170671
+ 4.1165000000001003e-06 2.842333798764753
+ 4.1175000000000999e-06 2.8423333321020658
+ 4.1185000000001004e-06 2.842333798826266
+ 4.1195000000000992e-06 2.842333332033999
+ 4.1205000000000989e-06 2.8423337988873052
+ 4.1215000000000994e-06 2.8423333319663571
+ 4.1225000000000982e-06 2.8423337989479309
+ 4.1235000000000978e-06 2.8423333318990909
+ 4.1245000000000966e-06 2.8423337990082231
+ 4.1255000000000971e-06 2.8423333318321582
+ 4.1265000000000968e-06 2.8423337990681699
+ 4.1275000000000956e-06 2.842333331765631
+ 4.1285000000000961e-06 2.8423337991276232
+ 4.1295000000000957e-06 2.8423333316995909
+ 4.1305000000000954e-06 2.84233379918664
+ 4.131500000000095e-06 2.8423333316339949
+ 4.1325000000000947e-06 2.8423337992452198
+ 4.1335000000000943e-06 2.8423333315688208
+ 4.134500000000094e-06 2.842333799303312
+ 4.1355000000000936e-06 2.8423333315041841
+ 4.1365000000000933e-06 2.8423337993608571
+ 4.1375000000000929e-06 2.8423333314401571
+ 4.1385000000000926e-06 2.842333799417796
+ 4.1395000000000922e-06 2.8423333313766408
+ 4.1405000000000919e-06 2.8423337994742588
+ 4.1415000000000924e-06 2.8423333313135561
+ 4.1425000000000912e-06 2.8423337995304032
+ 4.1435000000000909e-06 2.8423333312507508
+ 4.1445000000000914e-06 2.842333799586211
+ 4.1455000000000902e-06 2.8423333311883421
+ 4.1465000000000898e-06 2.8423337996415738
+ 4.1475000000000886e-06 2.8423333311263659
+ 4.1485000000000891e-06 2.842333799696529
+ 4.1495000000000888e-06 2.8423333310648009
+ 4.1505000000000884e-06 2.8423337997510809
+ 4.1515000000000881e-06 2.8423333310036538
+ 4.1525000000000877e-06 2.8423337998052061
+ 4.1535000000000874e-06 2.8423333309429122
+ 4.154500000000087e-06 2.842333799858928
+ 4.1555000000000867e-06 2.8423333308826262
+ 4.1565000000000863e-06 2.842333799912125
+ 4.157500000000086e-06 2.8423333308228709
+ 4.1585000000000856e-06 2.842333799964845
+ 4.1595000000000853e-06 2.8423333307635881
+ 4.1605000000000849e-06 2.8423338000170459
+ 4.1615000000000846e-06 2.8423333307048209
+ 4.1625000000000842e-06 2.842333800068769
+ 4.1635000000000839e-06 2.8423333306464942
+ 4.1645000000000844e-06 2.842333800120096
+ 4.1655000000000832e-06 2.8423333305885712
+ 4.1665000000000828e-06 2.842333800170981
+ 4.1675000000000816e-06 2.842333330531051
+ 4.1685000000000821e-06 2.8423338002215548
+ 4.1695000000000818e-06 2.8423333304738159
+ 4.1705000000000806e-06 2.8423338002718181
+ 4.1715000000000811e-06 2.842333330416893
+ 4.1725000000000808e-06 2.842333800321764
+ 4.1735000000000804e-06 2.8423333303603342
+ 4.1745000000000801e-06 2.8423338003712799
+ 4.1755000000000797e-06 2.8423333303042049
+ 4.1765000000000794e-06 2.8423338004203651
+ 4.177500000000079e-06 2.8423333302486329
+ 4.1785000000000787e-06 2.8423338004688001
+ 4.1795000000000783e-06 2.8423333301936222
+ 4.180500000000078e-06 2.8423338005167902
+ 4.1815000000000776e-06 2.8423333301390441
+ 4.1825000000000773e-06 2.8423338005643899
+ 4.1835000000000769e-06 2.8423333300847728
+ 4.1845000000000774e-06 2.8423338006116281
+ 4.1855000000000762e-06 2.842333330030935
+ 4.1865000000000759e-06 2.8423338006584489
+ 4.1875000000000764e-06 2.842333329977516
+ 4.1885000000000752e-06 2.8423338007048549
+ 4.1895000000000748e-06 2.8423333299244962
+ 4.1905000000000736e-06 2.8423338007508772
+ 4.1915000000000741e-06 2.8423333298718569
+ 4.1925000000000738e-06 2.8423338007964829
+ 4.1935000000000726e-06 2.842333329819644
+ 4.1945000000000731e-06 2.8423338008417152
+ 4.1955000000000727e-06 2.8423333297677522
+ 4.1965000000000724e-06 2.8423338008866108
+ 4.197500000000072e-06 2.8423333297162459
+ 4.1985000000000717e-06 2.8423338009311059
+ 4.1995000000000713e-06 2.8423333296651419
+ 4.200500000000071e-06 2.8423338009751982
+ 4.2015000000000706e-06 2.8423333296144349
+ 4.2025000000000703e-06 2.8423338010188841
+ 4.20350000000007e-06 2.842333329564148
+ 4.2045000000000696e-06 2.8423338010621499
+ 4.2055000000000693e-06 2.842333329514271
+ 4.2065000000000689e-06 2.842333801104985
+ 4.2075000000000694e-06 2.842333329464843
+ 4.2085000000000682e-06 2.842333801147376
+ 4.2095000000000679e-06 2.842333329415871
+ 4.2105000000000684e-06 2.84233380118933
+ 4.2115000000000672e-06 2.842333329367337
+ 4.2125000000000668e-06 2.8423338012308199
+ 4.2135000000000656e-06 2.8423333293191861
+ 4.2145000000000661e-06 2.8423338012720132
+ 4.2155000000000658e-06 2.8423333292713351
+ 4.2165000000000646e-06 2.84233380131296
+ 4.2175000000000651e-06 2.8423333292236701
+ 4.2185000000000647e-06 2.8423338013536572
+ 4.2195000000000644e-06 2.842333329176328
+ 4.220500000000064e-06 2.8423338013939792
+ 4.2215000000000637e-06 2.8423333291294459
+ 4.2225000000000633e-06 2.8423338014337758
+ 4.223500000000063e-06 2.8423333290830999
+ 4.2245000000000626e-06 2.842333801473063
+ 4.2255000000000623e-06 2.8423333290371962
+ 4.2265000000000619e-06 2.8423338015119541
+ 4.2275000000000616e-06 2.8423333289916979
+ 4.2285000000000612e-06 2.8423338015504429
+ 4.2295000000000609e-06 2.842333328946562
+ 4.2305000000000614e-06 2.842333801588576
+ 4.2315000000000602e-06 2.8423333289018129
+ 4.2325000000000598e-06 2.8423338016263462
+ 4.2335000000000603e-06 2.8423333288574129
+ 4.2345000000000592e-06 2.842333801663754
+ 4.2355000000000588e-06 2.842333328813317
+ 4.2365000000000576e-06 2.842333801700863
+ 4.2375000000000581e-06 2.8423333287695831
+ 4.2385000000000578e-06 2.8423338017376421
+ 4.2395000000000574e-06 2.8423333287261481
+ 4.2405000000000571e-06 2.84233380177406
+ 4.2415000000000567e-06 2.8423333286830941
+ 4.2425000000000564e-06 2.842333801810097
+ 4.243500000000056e-06 2.8423333286404509
+ 4.2445000000000557e-06 2.84233380184574
+ 4.2455000000000553e-06 2.8423333285981669
+ 4.246500000000055e-06 2.8423338018810109
+ 4.2475000000000546e-06 2.8423333285562822
+ 4.2485000000000543e-06 2.8423338019158702
+ 4.2495000000000539e-06 2.8423333285148349
+ 4.2505000000000536e-06 2.8423338019502951
+ 4.2515000000000532e-06 2.8423333284738379
+ 4.2525000000000529e-06 2.8423338019842581
+ 4.2535000000000534e-06 2.8423333284332029
+ 4.2545000000000522e-06 2.8423338020178912
+ 4.2555000000000518e-06 2.8423333283929089
+ 4.2565000000000506e-06 2.842333802051316
+ 4.2575000000000511e-06 2.8423333283527641
+ 4.2585000000000508e-06 2.8423338020844739
+ 4.2595000000000496e-06 2.8423333283129488
+ 4.2605000000000501e-06 2.8423338021172899
+ 4.2615000000000497e-06 2.8423333282735141
+ 4.2625000000000494e-06 2.8423338021497422
+ 4.263500000000049e-06 2.8423333282344418
+ 4.2645000000000487e-06 2.8423338021817832
+ 4.2655000000000484e-06 2.8423333281957941
+ 4.266500000000048e-06 2.8423338022134002
+ 4.2675000000000477e-06 2.8423333281575771
+ 4.2685000000000473e-06 2.8423338022445939
+ 4.269500000000047e-06 2.8423333281197589
+ 4.2705000000000466e-06 2.8423338022753941
+ 4.2715000000000463e-06 2.842333328082336
+ 4.2725000000000459e-06 2.8423338023058662
+ 4.2735000000000464e-06 2.8423333280451439
+ 4.2745000000000452e-06 2.8423338023360758
+ 4.2755000000000449e-06 2.842333328008293
+ 4.2765000000000454e-06 2.8423338023659701
+ 4.2775000000000442e-06 2.8423333279717409
+ 4.2785000000000438e-06 2.842333802395538
+ 4.2795000000000426e-06 2.842333327935525
+ 4.2805000000000431e-06 2.8423338024247711
+ 4.2815000000000428e-06 2.8423333278996399
+ 4.2825000000000416e-06 2.8423338024536942
+ 4.2835000000000421e-06 2.8423333278640621
+ 4.2845000000000417e-06 2.8423338024822531
+ 4.2855000000000414e-06 2.8423333278288991
+ 4.286500000000041e-06 2.8423338025104199
+ 4.2875000000000407e-06 2.8423333277941389
+ 4.2885000000000403e-06 2.8423338025381191
+ 4.28950000000004e-06 2.8423333277598211
+ 4.2905000000000396e-06 2.8423338025654461
+ 4.2915000000000393e-06 2.8423333277258291
+ 4.2925000000000389e-06 2.842333802592544
+ 4.2935000000000386e-06 2.84233332769199
+ 4.2945000000000382e-06 2.84233380261945
+ 4.2955000000000379e-06 2.84233332765842
+ 4.2965000000000384e-06 2.8423338026460021
+ 4.2975000000000372e-06 2.8423333276252412
+ 4.2985000000000369e-06 2.8423338026722131
+ 4.2995000000000374e-06 2.8423333275923981
+ 4.3005000000000362e-06 2.8423338026980338
+ 4.3015000000000358e-06 2.8423333275599578
+ 4.3025000000000346e-06 2.8423338027234921
+ 4.3035000000000351e-06 2.842333327527879
+ 4.3045000000000348e-06 2.8423338027485339
+ 4.3055000000000344e-06 2.8423333274961959
+ 4.3065000000000341e-06 2.842333802773267
+ 4.3075000000000337e-06 2.842333327464817
+ 4.3085000000000334e-06 2.842333802797655
+ 4.309500000000033e-06 2.842333327433753
+ 4.3105000000000327e-06 2.842333802821797
+ 4.3115000000000323e-06 2.8423333274029359
+ 4.312500000000032e-06 2.8423338028456362
+ 4.3135000000000316e-06 2.8423333273724518
+ 4.3145000000000313e-06 2.8423338028691441
+ 4.3155000000000309e-06 2.842333327342252
+ 4.3165000000000306e-06 2.842333802892401
+ 4.3175000000000302e-06 2.8423333273123199
+ 4.3185000000000299e-06 2.8423338029153631
+ 4.3195000000000304e-06 2.8423333272827089
+ 4.3205000000000292e-06 2.8423338029379548
+ 4.3215000000000288e-06 2.842333327253491
+ 4.3225000000000276e-06 2.842333802960161
+ 4.3235000000000281e-06 2.842333327224662
+ 4.3245000000000278e-06 2.842333802982
+ 4.3255000000000266e-06 2.8423333271961848
+ 4.3265000000000271e-06 2.8423338030034859
+ 4.3275000000000268e-06 2.842333327168117
+ 4.3285000000000264e-06 2.8423338030245442
+ 4.3295000000000261e-06 2.8423333271403508
+ 4.3305000000000257e-06 2.842333803045439
+ 4.3315000000000254e-06 2.842333327112712
+ 4.332500000000025e-06 2.8423338030661278
+ 4.3335000000000247e-06 2.8423333270853388
+ 4.3345000000000243e-06 2.8423338030865328
+ 4.335500000000024e-06 2.8423333270582631
+ 4.3365000000000236e-06 2.8423338031066332
+ 4.3375000000000233e-06 2.8423333270315299
+ 4.3385000000000229e-06 2.8423338031263801
+ 4.3395000000000234e-06 2.8423333270051239
+ 4.3405000000000222e-06 2.8423338031458139
+ 4.3415000000000219e-06 2.8423333269790292
+ 4.3425000000000224e-06 2.842333803164915
+ 4.3435000000000212e-06 2.8423333269533071
+ 4.3445000000000208e-06 2.8423338031836232
+ 4.3455000000000196e-06 2.8423333269279518
+ 4.3465000000000201e-06 2.842333803202
+ 4.3475000000000198e-06 2.8423333269029101
+ 4.3485000000000186e-06 2.84233380322007
+ 4.3495000000000191e-06 2.8423333268782121
+ 4.3505000000000187e-06 2.8423338032377781
+ 4.3515000000000184e-06 2.842333326853824
+ 4.352500000000018e-06 2.842333803255229
+ 4.3535000000000177e-06 2.8423333268296642
+ 4.3545000000000173e-06 2.8423338032725058
+ 4.355500000000017e-06 2.8423333268056639
+ 4.3565000000000166e-06 2.8423338032895811
+ 4.3575000000000163e-06 2.842333326781882
+ 4.358500000000016e-06 2.8423338033064081
+ 4.3595000000000156e-06 2.842333326758411
+ 4.3605000000000153e-06 2.8423338033228971
+ 4.3615000000000149e-06 2.842333326735353
+ 4.3625000000000154e-06 2.8423338033388679
+ 4.3635000000000142e-06 2.842333326712764
+ 4.3645000000000139e-06 2.8423338033545131
+ 4.3655000000000144e-06 2.8423333266904232
+ 4.3665000000000132e-06 2.8423338033699359
+ 4.3675000000000128e-06 2.842333326668276
+ 4.3685000000000116e-06 2.8423338033850798
+ 4.3695000000000121e-06 2.8423333266464841
+ 4.3705000000000118e-06 2.842333803399923
+ 4.3715000000000106e-06 2.8423333266249511
+ 4.3725000000000111e-06 2.84233380341451
+ 4.3735000000000107e-06 2.8423333266036761
+ 4.3745000000000104e-06 2.8423338034288088
+ 4.37550000000001e-06 2.842333326582716
+ 4.3765000000000097e-06 2.8423338034428158
+ 4.3775000000000093e-06 2.8423333265620538
+ 4.378500000000009e-06 2.8423338034564831
+ 4.3795000000000086e-06 2.8423333265417439
+ 4.3805000000000083e-06 2.8423338034698502
+ 4.3815000000000079e-06 2.842333326521679
+ 4.3825000000000076e-06 2.8423338034829548
+ 4.3835000000000072e-06 2.8423333265018722
+ 4.3845000000000069e-06 2.8423338034958481
+ 4.3855000000000074e-06 2.842333326482275
+ 4.3865000000000062e-06 2.842333803508486
+ 4.3875000000000058e-06 2.8423333264629802
+ 4.3885000000000063e-06 2.842333803520813
+ 4.3895000000000052e-06 2.8423333264439932
+ 4.3905000000000048e-06 2.842333803532815
+ 4.3915000000000036e-06 2.842333326425333
+ 4.3925000000000041e-06 2.8423338035445251
+ 4.3935000000000038e-06 2.8423333264069188
+ 4.3945000000000034e-06 2.8423338035559742
+ 4.3955000000000031e-06 2.842333326388832
+ 4.3965000000000027e-06 2.8423338035670831
+ 4.3975000000000024e-06 2.8423333263710271
+ 4.398500000000002e-06 2.8423338035779322
+ 4.3995000000000017e-06 2.8423333263535309
+ 4.4005000000000013e-06 2.8423338035884371
+ 4.401500000000001e-06 2.842333326336397
+ 4.4025000000000006e-06 2.8423338035986192
+ 4.4035000000000003e-06 2.8423333263194688
+ 4.4044999999999999e-06 2.8423338036086192
+ 4.4054999999999996e-06 2.8423333263027581
+ 4.4064999999999992e-06 2.842333803618478
+ 4.4074999999999989e-06 2.842333326286147
+ 4.4084999999999994e-06 2.8423338036281272
+ 4.4094999999999982e-06 2.8423333262698218
+ 4.4104999999999978e-06 2.842333803637505
+ 4.4114999999999966e-06 2.842333326253784
+ 4.4124999999999971e-06 2.8423338036465529
+ 4.4134999999999968e-06 2.8423333262380699
+ 4.4144999999999956e-06 2.8423338036552628
+ 4.4154999999999961e-06 2.8423333262227368
+ 4.4164999999999957e-06 2.8423338036636072
+ 4.4174999999999954e-06 2.8423333262077159
+ 4.418499999999995e-06 2.8423338036716488
+ 4.4194999999999947e-06 2.8423333261930441
+ 4.4204999999999944e-06 2.8423338036793608
+ 4.421499999999994e-06 2.8423333261786299
+ 4.4224999999999937e-06 2.8423338036868269
+ 4.4234999999999933e-06 2.842333326164471
+ 4.424499999999993e-06 2.84233380369407
+ 4.4254999999999926e-06 2.8423333261505008
+ 4.4264999999999923e-06 2.8423338037011892
+ 4.4274999999999919e-06 2.842333326136639
+ 4.4284999999999924e-06 2.8423338037080952
+ 4.4294999999999912e-06 2.842333326123029
+ 4.4304999999999909e-06 2.8423338037148071
+ 4.4314999999999914e-06 2.842333326109586
+ 4.4324999999999902e-06 2.842333803721302
+ 4.4334999999999898e-06 2.842333326096425
+ 4.4344999999999886e-06 2.8423338037274881
+ 4.4354999999999891e-06 2.8423333260836339
+ 4.4364999999999888e-06 2.8423338037332191
+ 4.4374999999999876e-06 2.842333326071286
+ 4.4384999999999881e-06 2.8423338037385668
+ 4.4394999999999877e-06 2.8423333260592538
+ 4.4404999999999874e-06 2.8423338037437138
+ 4.441499999999987e-06 2.8423333260473811
+ 4.4424999999999867e-06 2.8423338037486299
+ 4.4434999999999863e-06 2.8423333260357668
+ 4.444499999999986e-06 2.842333803753307
+ 4.4454999999999856e-06 2.8423333260244039
+ 4.4464999999999853e-06 2.8423338037577328
+ 4.4474999999999849e-06 2.8423333260132431
+ 4.4484999999999846e-06 2.8423338037620121
+ 4.4494999999999842e-06 2.8423333260022332
+ 4.4504999999999839e-06 2.842333803766075
+ 4.4514999999999844e-06 2.8423333259914831
+ 4.4524999999999832e-06 2.8423338037699089
+ 4.4534999999999829e-06 2.842333325980948
+ 4.4544999999999834e-06 2.8423338037734669
+ 4.4554999999999822e-06 2.8423333259707029
+ 4.4564999999999818e-06 2.8423338037767558
+ 4.4574999999999806e-06 2.8423333259607571
+ 4.4584999999999811e-06 2.8423338037797432
+ 4.4594999999999808e-06 2.8423333259511012
+ 4.4604999999999804e-06 2.8423338037824148
+ 4.4614999999999801e-06 2.842333325941758
+ 4.4624999999999797e-06 2.8423338037848018
+ 4.4634999999999794e-06 2.8423333259326622
+ 4.464499999999979e-06 2.8423338037869939
+ 4.4654999999999787e-06 2.8423333259237791
+ 4.4664999999999783e-06 2.8423338037889181
+ 4.467499999999978e-06 2.8423333259151469
+ 4.4684999999999776e-06 2.8423338037906292
+ 4.4694999999999773e-06 2.8423333259067198
+ 4.4704999999999769e-06 2.8423338037921249
+ 4.4714999999999766e-06 2.8423333258984909
+ 4.4724999999999762e-06 2.842333803793454
+ 4.4734999999999759e-06 2.8423333258904551
+ 4.4744999999999764e-06 2.8423338037945438
+ 4.4754999999999752e-06 2.8423333258827328
+ 4.4764999999999748e-06 2.842333803795277
+ 4.4774999999999736e-06 2.8423333258752801
+ 4.4784999999999741e-06 2.8423338037958059
+ 4.4794999999999738e-06 2.842333325868045
+ 4.4804999999999726e-06 2.8423338037961812
+ 4.4814999999999731e-06 2.842333325860924
+ 4.4824999999999728e-06 2.8423338037963441
+ 4.4834999999999724e-06 2.842333325854081
+ 4.4844999999999721e-06 2.8423338037962251
+ 4.4854999999999717e-06 2.8423333258475272
+ 4.4864999999999714e-06 2.8423338037958059
+ 4.487499999999971e-06 2.8423333258412669
+ 4.4884999999999707e-06 2.842333803795098
+ 4.4894999999999703e-06 2.842333325835305
+ 4.49049999999997e-06 2.8423338037941011
+ 4.4914999999999696e-06 2.8423333258296259
+ 4.4924999999999693e-06 2.842333803792835
+ 4.4934999999999689e-06 2.8423333258241779
+ 4.4944999999999694e-06 2.8423338037913828
+ 4.4954999999999682e-06 2.8423333258188759
+ 4.4964999999999679e-06 2.842333803789824
+ 4.4974999999999684e-06 2.842333325813684
+ 4.4984999999999672e-06 2.842333803788097
+ 4.4994999999999668e-06 2.8423333258087031
+ 4.5004999999999656e-06 2.8423338037861372
+ 4.5014999999999661e-06 2.8423333258039829
+ 4.5024999999999658e-06 2.8423338037838981
+ 4.5034999999999646e-06 2.8423333257995052
+ 4.5044999999999651e-06 2.8423338037814578
+ 4.5054999999999647e-06 2.8423333257952468
+ 4.5064999999999644e-06 2.8423338037787649
+ 4.507499999999964e-06 2.8423333257912349
+ 4.5084999999999637e-06 2.8423338037758472
+ 4.5094999999999633e-06 2.842333325787481
+ 4.510499999999963e-06 2.8423338037726351
+ 4.5114999999999626e-06 2.8423333257840402
+ 4.5124999999999623e-06 2.84233380376909
+ 4.513499999999962e-06 2.8423333257808712
+ 4.5144999999999616e-06 2.842333803765392
+ 4.5154999999999613e-06 2.8423333257778158
+ 4.5164999999999609e-06 2.8423338037615129
+ 4.5174999999999614e-06 2.842333325774987
+ 4.5184999999999602e-06 2.8423338037574228
+ 4.5194999999999599e-06 2.8423333257723642
+ 4.5204999999999604e-06 2.8423338037531241
+ 4.5214999999999592e-06 2.842333325769939
+ 4.5224999999999588e-06 2.8423338037486392
+ 4.5234999999999576e-06 2.842333325767687
+ 4.5244999999999581e-06 2.8423338037439558
+ 4.5254999999999578e-06 2.8423333257656731
+ 4.5264999999999566e-06 2.84233380373903
+ 4.5274999999999571e-06 2.8423333257638941
+ 4.5284999999999567e-06 2.8423338037338719
+ 4.5294999999999564e-06 2.8423333257623749
+ 4.530499999999956e-06 2.842333803728438
+ 4.5314999999999557e-06 2.8423333257611132
+ 4.5324999999999553e-06 2.8423338037227719
+ 4.533499999999955e-06 2.8423333257600509
+ 4.5344999999999546e-06 2.842333803716901
+ 4.5354999999999543e-06 2.8423333257592351
+ 4.5364999999999539e-06 2.8423338037107819
+ 4.5374999999999536e-06 2.84233332575866
+ 4.5384999999999532e-06 2.8423338037044572
+ 4.5394999999999529e-06 2.8423333257582142
+ 4.5404999999999534e-06 2.8423338036980139
+ 4.5414999999999522e-06 2.8423333257579428
+ 4.5424999999999518e-06 2.8423338036913859
+ 4.5434999999999523e-06 2.8423333257578478
+ 4.5444999999999512e-06 2.84233380368455
+ 4.5454999999999508e-06 2.8423333257579699
+ 4.5464999999999496e-06 2.8423338036774939
+ 4.5474999999999501e-06 2.842333325758335
+ 4.5484999999999498e-06 2.84233380367017
+ 4.5494999999999494e-06 2.84233332575899
+ 4.5504999999999491e-06 2.842333803662568
+ 4.5514999999999487e-06 2.8423333257599319
+ 4.5524999999999484e-06 2.8423338036546602
+ 4.553499999999948e-06 2.842333325761091
+ 4.5544999999999477e-06 2.842333803646667
+ 4.5554999999999473e-06 2.8423333257623051
+ 4.556499999999947e-06 2.842333803638545
+ 4.5574999999999466e-06 2.842333325763684
+ 4.5584999999999463e-06 2.8423338036302561
+ 4.5594999999999459e-06 2.842333325765269
+ 4.5604999999999456e-06 2.8423338036217349
+ 4.5614999999999452e-06 2.8423333257670751
+ 4.5624999999999449e-06 2.842333803613001
+ 4.5634999999999454e-06 2.842333325769109
+ 4.5644999999999442e-06 2.842333803604026
+ 4.5654999999999438e-06 2.8423333257714312
+ 4.5664999999999426e-06 2.8423338035947521
+ 4.5674999999999431e-06 2.8423333257739638
+ 4.5684999999999428e-06 2.8423338035852992
+ 4.5694999999999416e-06 2.8423333257767029
+ 4.5704999999999421e-06 2.8423338035756749
+ 4.5714999999999417e-06 2.8423333257795731
+ 4.5724999999999414e-06 2.8423338035658832
+ 4.573499999999941e-06 2.8423333257826622
+ 4.5744999999999407e-06 2.8423338035558481
+ 4.5754999999999404e-06 2.8423333257859951
+ 4.57649999999994e-06 2.842333803545618
+ 4.5774999999999397e-06 2.8423333257894599
+ 4.5784999999999393e-06 2.8423338035352508
+ 4.579499999999939e-06 2.8423333257931018
+ 4.5804999999999386e-06 2.8423338035247201
+ 4.5814999999999383e-06 2.8423333257968899
+ 4.5824999999999379e-06 2.8423338035140091
+ 4.5834999999999384e-06 2.8423333258008978
+ 4.5844999999999372e-06 2.8423338035030521
+ 4.5854999999999369e-06 2.8423333258052419
+ 4.5864999999999374e-06 2.8423338034917269
+ 4.5874999999999362e-06 2.842333325809824
+ 4.5884999999999358e-06 2.842333803480305
+ 4.5894999999999346e-06 2.842333325814443
+ 4.5904999999999351e-06 2.842333803468776
+ 4.5914999999999348e-06 2.842333325819256
+ 4.5924999999999336e-06 2.8423338034570369
+ 4.5934999999999341e-06 2.8423333258243129
+ 4.5944999999999337e-06 2.842333803445023
+ 4.5954999999999334e-06 2.8423333258296091
+ 4.596499999999933e-06 2.8423338034328318
+ 4.5974999999999327e-06 2.8423333258350558
+ 4.5984999999999323e-06 2.842333803420483
+ 4.599499999999932e-06 2.842333325840666
+ 4.6004999999999316e-06 2.8423338034079531
+ 4.6014999999999313e-06 2.8423333258464489
+ 4.6024999999999309e-06 2.8423338033952641
+ 4.6034999999999306e-06 2.8423333258524361
+ 4.6044999999999302e-06 2.8423338033823509
+ 4.6054999999999299e-06 2.8423333258586339
+ 4.6064999999999304e-06 2.8423338033692338
+ 4.6074999999999292e-06 2.8423333258650492
+ 4.6084999999999289e-06 2.842333803355896
+ 4.6094999999999294e-06 2.8423333258716679
+ 4.6104999999999282e-06 2.8423338033423842
+ 4.6114999999999278e-06 2.8423333258784189
+ 4.6124999999999266e-06 2.8423338033287351
+ 4.6134999999999271e-06 2.8423333258853769
+ 4.6144999999999268e-06 2.8423338033148311
+ 4.6154999999999264e-06 2.8423333258925529
+ 4.6164999999999261e-06 2.842333803300773
+ 4.6174999999999257e-06 2.8423333258998551
+ 4.6184999999999254e-06 2.842333803286563
+ 4.619499999999925e-06 2.842333325907334
+ 4.6204999999999247e-06 2.8423338032722052
+ 4.6214999999999243e-06 2.8423333259149519
+ 4.622499999999924e-06 2.8423338032576488
+ 4.6234999999999236e-06 2.8423333259228212
+ 4.6244999999999233e-06 2.8423338032428629
+ 4.6254999999999229e-06 2.842333325930912
+ 4.6264999999999226e-06 2.8423338032278238
+ 4.6274999999999222e-06 2.8423333259392392
+ 4.6284999999999219e-06 2.8423338032126368
+ 4.6294999999999224e-06 2.8423333259476191
+ 4.6304999999999212e-06 2.8423338031973482
+ 4.6314999999999208e-06 2.8423333259562131
+ 4.6324999999999196e-06 2.8423338031818202
+ 4.6334999999999201e-06 2.8423333259649959
+ 4.6344999999999198e-06 2.842333803166166
+ 4.6354999999999186e-06 2.8423333259738728
+ 4.6364999999999191e-06 2.8423338031503769
+ 4.6374999999999188e-06 2.8423333259829842
+ 4.6384999999999184e-06 2.842333803134323
+ 4.6394999999999181e-06 2.8423333259923149
+ 4.6404999999999177e-06 2.8423338031180698
+ 4.6414999999999174e-06 2.8423333260018468
+ 4.642499999999917e-06 2.8423338031016159
+ 4.6434999999999167e-06 2.842333326011548
+ 4.6444999999999163e-06 2.8423338030850411
+ 4.645499999999916e-06 2.8423333260214001
+ 4.6464999999999156e-06 2.8423338030682719
+ 4.6474999999999153e-06 2.8423333260314259
+ 4.6484999999999149e-06 2.8423338030513681
+ 4.6494999999999154e-06 2.8423333260415751
+ 4.6504999999999142e-06 2.8423338030343048
+ 4.6514999999999139e-06 2.842333326051921
+ 4.6524999999999144e-06 2.8423338030170582
+ 4.6534999999999132e-06 2.8423333260624162
+ 4.6544999999999128e-06 2.842333802999645
+ 4.6554999999999116e-06 2.8423333260731121
+ 4.6564999999999121e-06 2.8423338029820409
+ 4.6574999999999118e-06 2.8423333260839789
+ 4.6584999999999106e-06 2.842333802964248
+ 4.6594999999999111e-06 2.8423333260950798
+ 4.6604999999999107e-06 2.8423338029462162
+ 4.6614999999999104e-06 2.842333326106429
+ 4.66249999999991e-06 2.842333802927969
+ 4.6634999999999097e-06 2.8423333261178678
+ 4.6644999999999093e-06 2.8423338029097058
+ 4.665499999999909e-06 2.8423333261293209
+ 4.6664999999999086e-06 2.842333802891349
+ 4.6674999999999083e-06 2.8423333261409698
+ 4.668499999999908e-06 2.842333802872794
+ 4.6694999999999076e-06 2.8423333261528092
+ 4.6704999999999073e-06 2.842333802854049
+ 4.6714999999999069e-06 2.8423333261648178
+ 4.6724999999999074e-06 2.842333802835086
+ 4.6734999999999062e-06 2.842333326177076
+ 4.6744999999999059e-06 2.8423338028159022
+ 4.6754999999999064e-06 2.8423333261895269
+ 4.6764999999999052e-06 2.8423338027965501
+ 4.6774999999999048e-06 2.842333326202183
+ 4.6784999999999036e-06 2.8423338027770009
+ 4.6794999999999041e-06 2.8423333262149439
+ 4.6804999999999038e-06 2.842333802757341
+ 4.6814999999999026e-06 2.8423333262278572
+ 4.6824999999999031e-06 2.8423338027375289
+ 4.6834999999999027e-06 2.8423333262409298
+ 4.6844999999999024e-06 2.842333802717588
+ 4.685499999999902e-06 2.842333326254086
+ 4.6864999999999017e-06 2.842333802697548
+ 4.6874999999999013e-06 2.8423333262674131
+ 4.688499999999901e-06 2.84233380267729
+ 4.6894999999999006e-06 2.8423333262809232
+ 4.6904999999999003e-06 2.8423338026569152
+ 4.6914999999998999e-06 2.8423333262945452
+ 4.6924999999998996e-06 2.8423338026363569
+ 4.6934999999998992e-06 2.842333326308379
+ 4.6944999999998989e-06 2.842333802615606
+ 4.6954999999998994e-06 2.8423333263224122
+ 4.6964999999998982e-06 2.8423338025946721
+ 4.6974999999998978e-06 2.8423333263366062
+ 4.6984999999998983e-06 2.8423338025735569
+ 4.6994999999998972e-06 2.8423333263510342
+ 4.7004999999998968e-06 2.8423338025521772
+ 4.7014999999998956e-06 2.8423333263656869
+ 4.7024999999998961e-06 2.8423338025306961
+ 4.7034999999998958e-06 2.8423333263803499
+ 4.7044999999998954e-06 2.8423338025091458
+ 4.7054999999998951e-06 2.8423333263951638
+ 4.7064999999998947e-06 2.842333802487456
+ 4.7074999999998944e-06 2.8423333264100679
+ 4.708499999999894e-06 2.8423338024656801
+ 4.7094999999998937e-06 2.8423333264251029
+ 4.7104999999998933e-06 2.842333802443775
+ 4.711499999999893e-06 2.8423333264402548
+ 4.7124999999998926e-06 2.842333802421686
+ 4.7134999999998923e-06 2.8423333264556221
+ 4.7144999999998919e-06 2.8423338023994038
+ 4.7154999999998916e-06 2.842333326471191
+ 4.7164999999998912e-06 2.8423338023768898
+ 4.7174999999998909e-06 2.8423333264869828
+ 4.7184999999998914e-06 2.8423338023542342
+ 4.7194999999998902e-06 2.8423333265029038
+ 4.7204999999998898e-06 2.8423338023313569
+ 4.7214999999998886e-06 2.8423333265190531
+ 4.7224999999998891e-06 2.8423338023083149
+ 4.7234999999998888e-06 2.8423333265353632
+ 4.7244999999998876e-06 2.8423338022851148
+ 4.7254999999998881e-06 2.8423333265517892
+ 4.7264999999998877e-06 2.842333802261841
+ 4.7274999999998874e-06 2.842333326568244
+ 4.728499999999887e-06 2.8423338022385489
+ 4.7294999999998867e-06 2.842333326584769
+ 4.7304999999998864e-06 2.842333802215149
+ 4.731499999999886e-06 2.8423333266014001
+ 4.7324999999998857e-06 2.8423338021916051
+ 4.7334999999998853e-06 2.8423333266182622
+ 4.734499999999885e-06 2.8423338021677909
+ 4.7354999999998846e-06 2.8423333266354152
+ 4.7364999999998843e-06 2.8423338021436861
+ 4.7374999999998839e-06 2.8423333266527662
+ 4.7384999999998844e-06 2.8423338021195028
+ 4.7394999999998832e-06 2.842333326670138
+ 4.7404999999998829e-06 2.842333802095248
+ 4.7414999999998834e-06 2.8423333266876178
+ 4.7424999999998822e-06 2.8423338020708528
+ 4.7434999999998818e-06 2.8423333267052922
+ 4.7444999999998806e-06 2.8423338020462738
+ 4.7454999999998811e-06 2.8423333267231232
+ 4.7464999999998808e-06 2.8423338020215478
+ 4.7474999999998796e-06 2.8423333267411
+ 4.7484999999998801e-06 2.8423338019966731
+ 4.7494999999998797e-06 2.8423333267592161
+ 4.7504999999998794e-06 2.842333801971674
+ 4.751499999999879e-06 2.842333326777466
+ 4.7524999999998787e-06 2.842333801946535
+ 4.7534999999998783e-06 2.842333326795901
+ 4.754499999999878e-06 2.842333801921181
+ 4.7554999999998776e-06 2.842333326814491
+ 4.7564999999998773e-06 2.84233380189574
+ 4.7574999999998769e-06 2.842333326833133
+ 4.7584999999998766e-06 2.8423338018702262
+ 4.7594999999998762e-06 2.8423333268519029
+ 4.7604999999998759e-06 2.8423338018445832
+ 4.7614999999998764e-06 2.8423333268707678
+ 4.7624999999998752e-06 2.8423338018188451
+ 4.7634999999998749e-06 2.8423333268897921
+ 4.7644999999998754e-06 2.8423338017928752
+ 4.7654999999998742e-06 2.8423333269090478
+ 4.7664999999998738e-06 2.8423338017667161
+ 4.7674999999998726e-06 2.8423333269284758
+ 4.7684999999998731e-06 2.8423338017403981
+ 4.7694999999998728e-06 2.8423333269480442
+ 4.7704999999998724e-06 2.842333801713949
+ 4.7714999999998721e-06 2.842333326967748
+ 4.7724999999998717e-06 2.842333801687325
+ 4.7734999999998714e-06 2.8423333269875801
+ 4.774499999999871e-06 2.8423338016606619
+ 4.7754999999998707e-06 2.842333327007541
+ 4.7764999999998703e-06 2.8423338016337341
+ 4.77749999999987e-06 2.8423333270276951
+ 4.7784999999998696e-06 2.842333801606804
+ 4.7794999999998693e-06 2.8423333270477849
+ 4.7804999999998689e-06 2.842333801579835
+ 4.7814999999998686e-06 2.8423333270679971
+ 4.7824999999998682e-06 2.8423338015527051
+ 4.7834999999998679e-06 2.842333327088383
+ 4.7844999999998684e-06 2.8423338015254491
+ 4.7854999999998672e-06 2.8423333271088809
+ 4.7864999999998668e-06 2.8423338014980351
+ 4.7874999999998656e-06 2.8423333271295959
+ 4.7884999999998661e-06 2.8423338014703812
+ 4.7894999999998658e-06 2.8423333271505258
+ 4.7904999999998646e-06 2.842333801442539
+ 4.7914999999998651e-06 2.8423333271716422
+ 4.7924999999998648e-06 2.8423338014145241
+ 4.7934999999998644e-06 2.8423333271928888
+ 4.7944999999998641e-06 2.8423338013863861
+ 4.7954999999998637e-06 2.842333327214253
+ 4.7964999999998634e-06 2.8423338013581878
+ 4.797499999999863e-06 2.8423333272356648
+ 4.7984999999998627e-06 2.842333801329918
+ 4.7994999999998623e-06 2.842333327257176
+ 4.800499999999862e-06 2.8423338013015318
+ 4.8014999999998616e-06 2.8423333272787552
+ 4.8024999999998613e-06 2.8423338012731181
+ 4.8034999999998609e-06 2.8423333273003921
+ 4.8044999999998614e-06 2.842333801244556
+ 4.8054999999998602e-06 2.8423333273222369
+ 4.8064999999998599e-06 2.842333801215811
+ 4.8074999999998604e-06 2.8423333273442548
+ 4.8084999999998592e-06 2.8423338011868831
+ 4.8094999999998588e-06 2.8423333273664881
+ 4.8104999999998576e-06 2.8423338011577242
+ 4.8114999999998581e-06 2.8423333273888831
+ 4.8124999999998578e-06 2.8423338011285
+ 4.8134999999998566e-06 2.8423333274113012
+ 4.8144999999998571e-06 2.842333801099183
+ 4.8154999999998567e-06 2.8423333274338649
+ 4.8164999999998564e-06 2.8423338010697599
+ 4.817499999999856e-06 2.8423333274565432
+ 4.8184999999998557e-06 2.84233380104016
+ 4.8194999999998553e-06 2.8423333274793801
+ 4.820499999999855e-06 2.8423338010104722
+ 4.8214999999998546e-06 2.8423333275023048
+ 4.8224999999998543e-06 2.8423338009806458
+ 4.823499999999854e-06 2.8423333275253801
+ 4.8244999999998536e-06 2.842333800950708
+ 4.8254999999998533e-06 2.842333327548531
+ 4.8264999999998529e-06 2.8423338009206982
+ 4.8274999999998534e-06 2.842333327571815
+ 4.8284999999998522e-06 2.8423338008905099
+ 4.8294999999998519e-06 2.8423333275952261
+ 4.8304999999998524e-06 2.842333800860235
+ 4.8314999999998512e-06 2.8423333276187441
+ 4.8324999999998508e-06 2.842333800829834
+ 4.8334999999998496e-06 2.8423333276423821
+ 4.8344999999998501e-06 2.84233380079929
+ 4.8354999999998498e-06 2.842333327666164
+ 4.8364999999998486e-06 2.8423338007686221
+ 4.8374999999998491e-06 2.8423333276900991
+ 4.8384999999998487e-06 2.8423338007378049
+ 4.8394999999998484e-06 2.8423333277141758
+ 4.840499999999848e-06 2.8423338007068479
+ 4.8414999999998477e-06 2.842333327738356
+ 4.8424999999998473e-06 2.842333800675779
+ 4.843499999999847e-06 2.8423333277626752
+ 4.8444999999998466e-06 2.8423338006445991
+ 4.8454999999998463e-06 2.8423333277870841
+ 4.8464999999998459e-06 2.8423338006133001
+ 4.8474999999998456e-06 2.8423333278115881
+ 4.8484999999998452e-06 2.8423338005819798
+ 4.8494999999998449e-06 2.842333327836172
+ 4.8504999999998454e-06 2.8423338005504468
+ 4.8514999999998442e-06 2.8423333278609229
+ 4.8524999999998438e-06 2.842333800518881
+ 4.8534999999998443e-06 2.842333327885703
+ 4.8544999999998432e-06 2.8423338004872019
+ 4.8554999999998428e-06 2.842333327910616
+ 4.8564999999998416e-06 2.842333800455378
+ 4.8574999999998421e-06 2.842333327935711
+ 4.8584999999998418e-06 2.842333800423388
+ 4.8594999999998414e-06 2.8423333279609579
+ 4.8604999999998411e-06 2.8423338003912502
+ 4.8614999999998407e-06 2.8423333279863359
+ 4.8624999999998404e-06 2.84233380035898
+ 4.86349999999984e-06 2.8423333280118621
+ 4.8644999999998397e-06 2.842333800326581
+ 4.8654999999998393e-06 2.842333328037479
+ 4.866499999999839e-06 2.8423338002941012
+ 4.8674999999998386e-06 2.8423333280631971
+ 4.8684999999998383e-06 2.8423338002615322
+ 4.8694999999998379e-06 2.8423333280889498
+ 4.8704999999998376e-06 2.842333800228912
+ 4.8714999999998372e-06 2.8423333281147949
+ 4.8724999999998369e-06 2.8423338001962022
+ 4.8734999999998374e-06 2.8423333281407719
+ 4.8744999999998362e-06 2.8423338001633329
+ 4.8754999999998358e-06 2.842333328166859
+ 4.8764999999998346e-06 2.8423338001303931
+ 4.8774999999998351e-06 2.842333328193019
+ 4.8784999999998348e-06 2.8423338000973208
+ 4.8794999999998336e-06 2.8423333282193548
+ 4.8804999999998341e-06 2.842333800064107
+ 4.8814999999998337e-06 2.8423333282458141
+ 4.8824999999998334e-06 2.8423338000307479
+ 4.883499999999833e-06 2.842333328272503
+ 4.8844999999998327e-06 2.8423337999971219
+ 4.8854999999998324e-06 2.8423333282993379
+ 4.886499999999832e-06 2.8423337999634928
+ 4.8874999999998317e-06 2.8423333283261192
+ 4.8884999999998313e-06 2.842333799929853
+ 4.889499999999831e-06 2.842333328352971
+ 4.8904999999998306e-06 2.8423337998961258
+ 4.8914999999998303e-06 2.8423333283799299
+ 4.8924999999998299e-06 2.8423337998622809
+ 4.8934999999998304e-06 2.8423333284070389
+ 4.8944999999998292e-06 2.842333799828296
+ 4.8954999999998289e-06 2.842333328434218
+ 4.8964999999998294e-06 2.8423337997942499
+ 4.8974999999998282e-06 2.842333328461514
+ 4.8984999999998278e-06 2.8423337997600768
+ 4.8994999999998266e-06 2.842333328488917
+ 4.9004999999998271e-06 2.842333799725786
+ 4.9014999999998268e-06 2.8423333285164669
+ 4.9024999999998256e-06 2.84233379969133
+ 4.9034999999998261e-06 2.842333328544159
+ 4.9044999999998257e-06 2.8423337996567719
+ 4.9054999999998254e-06 2.8423333285719652
+ 4.906499999999825e-06 2.8423337996221072
+ 4.9074999999998247e-06 2.8423333285998531
+ 4.9084999999998243e-06 2.8423337995873221
+ 4.909499999999824e-06 2.8423333286278769
+ 4.9104999999998236e-06 2.8423337995524371
+ 4.9114999999998233e-06 2.84233332865601
+ 4.9124999999998229e-06 2.8423337995174331
+ 4.9134999999998226e-06 2.842333328684203
+ 4.9144999999998222e-06 2.8423337994824269
+ 4.9154999999998219e-06 2.8423333287123871
+ 4.9164999999998224e-06 2.8423337994473652
+ 4.9174999999998212e-06 2.84233332874068
+ 4.9184999999998209e-06 2.8423337994121951
+ 4.9194999999998214e-06 2.842333328769088
+ 4.9204999999998202e-06 2.842333799376898
+ 4.9214999999998198e-06 2.8423333287976771
+ 4.9224999999998186e-06 2.8423337993414002
+ 4.9234999999998191e-06 2.8423333288264332
+ 4.9244999999998188e-06 2.84233379930573
+ 4.9254999999998184e-06 2.8423333288553461
+ 4.9264999999998181e-06 2.842333799269988
+ 4.9274999999998177e-06 2.8423333288842318
+ 4.9284999999998174e-06 2.8423337992342552
+ 4.929499999999817e-06 2.842333328913186
+ 4.9304999999998167e-06 2.842333799198415
+ 4.9314999999998163e-06 2.8423333289422921
+ 4.932499999999816e-06 2.8423337991624349
+ 4.9334999999998156e-06 2.8423333289714798
+ 4.9344999999998153e-06 2.8423337991263891
+ 4.9354999999998149e-06 2.8423333290007728
+ 4.9364999999998146e-06 2.8423337990902069
+ 4.9374999999998142e-06 2.8423333290301742
+ 4.9384999999998139e-06 2.8423337990539488
+ 4.9394999999998144e-06 2.8423333290596751
+ 4.9404999999998132e-06 2.842333799017557
+ 4.9414999999998128e-06 2.8423333290893158
+ 4.9424999999998116e-06 2.842333798981048
+ 4.9434999999998121e-06 2.8423333291190138
+ 4.9444999999998118e-06 2.8423337989445021
+ 4.9454999999998106e-06 2.8423333291487509
+ 4.9464999999998111e-06 2.8423337989079198
+ 4.9474999999998108e-06 2.8423333291785728
+ 4.9484999999998104e-06 2.8423337988711941
+ 4.9494999999998101e-06 2.8423333292085471
+ 4.9504999999998097e-06 2.8423337988343111
+ 4.9514999999998094e-06 2.8423333292386812
+ 4.952499999999809e-06 2.8423337987973221
+ 4.9534999999998087e-06 2.8423333292688779
+ 4.9544999999998083e-06 2.8423337987602801
+ 4.955499999999808e-06 2.8423333292991342
+ 4.9564999999998076e-06 2.842333798723137
+ 4.9574999999998073e-06 2.8423333293295401
+ 4.9584999999998069e-06 2.842333798685821
+ 4.9594999999998074e-06 2.8423333293601361
+ 4.9604999999998062e-06 2.8423337986484092
+ 4.9614999999998059e-06 2.8423333293906472
+ 4.9624999999998064e-06 2.8423337986110511
+ 4.9634999999998052e-06 2.8423333294212321
+ 4.9644999999998048e-06 2.8423337985735948
+ 4.9654999999998036e-06 2.8423333294518982
+ 4.9664999999998041e-06 2.842333798536079
+ 4.9674999999998038e-06 2.8423333294826572
+ 4.9684999999998026e-06 2.8423337984984092
+ 4.9694999999998031e-06 2.8423333295135871
+ 4.9704999999998027e-06 2.8423337984605959
+ 4.9714999999998024e-06 2.8423333295446458
+ 4.972499999999802e-06 2.84233379842264
+ 4.9734999999998017e-06 2.8423333295758391
+ 4.9744999999998013e-06 2.8423337983845922
+ 4.975499999999801e-06 2.8423333296070852
+ 4.9764999999998006e-06 2.8423337983464689
+ 4.9774999999998003e-06 2.8423333296384441
+ 4.9784999999998e-06 2.8423337983082511
+ 4.9794999999997996e-06 2.8423333296698599
+ 4.9804999999997993e-06 2.8423337982699781
+ 4.9814999999997989e-06 2.8423333297013431
+ 4.9824999999997994e-06 2.8423337982316479
+ 4.9834999999997982e-06 2.842333329732881
+ 4.9844999999997979e-06 2.8423337981932528
+ 4.9854999999997984e-06 2.8423333297645099
+ 4.9864999999997972e-06 2.8423337981547609
+ 4.9874999999997968e-06 2.8423333297962179
+ 4.9884999999997956e-06 2.8423337981161891
+ 4.9894999999997961e-06 2.8423333298280031
+ 4.9904999999997958e-06 2.8423337980775272
+ 4.9914999999997946e-06 2.842333329859883
+ 4.9924999999997951e-06 2.8423337980387759
+ 4.9934999999997947e-06 2.8423333298918849
+ 4.9944999999997944e-06 2.842333797999872
+ 4.995499999999794e-06 2.842333329924041
+ 4.9964999999997937e-06 2.8423337979608361
+ 4.9974999999997933e-06 2.8423333299563658
+ 4.998499999999793e-06 2.8423337979215928
+ 4.9992499999998963e-06 2.8423333299947791
+ 5.0000000000000004e-06 2.8423337978716221
+ 5.0000999999999998e-06 2.8423335754833619
+ 5.0002999999999994e-06 2.8423335811617179
+ 5.0006999999999994e-06 2.84233358498251
+ 5.00135e-06 2.8423334276432088
+ 5.0020000000000014e-06 2.842333181696151
+ 5.0021000000000008e-06 2.8423331274745229
+ 5.0023000000000004e-06 2.842332999053097
+ 5.0027000000000004e-06 2.842332670655074
+ 5.0034999999999996e-06 2.842331995687017
+ 5.0045000000000001e-06 2.8423306001894959
+ 5.0054999999999998e-06 2.84232225962187
+ 5.005625e-06 2.842324383121924
+ 5.0058749999999997e-06 2.842326305501842
+ 5.006375e-06 2.8423211249024809
+ 5.0073111779111107e-06 2.8349467825076431
+ 5.0083111779111103e-06 2.7982575008989321
+ 5.00931117791111e-06 2.8066666598517211
+ 5.0103111779111096e-06 2.7769689036218579
+ 5.0113111779111093e-06 2.778462878399707
+ 5.0123111779111089e-06 2.752125563600313
+ 5.0133111779111086e-06 2.7487828840333188
+ 5.0143111779111082e-06 2.7268213282877558
+ 5.0153111779111079e-06 2.719732181033788
+ 5.0163111779111084e-06 2.7011284339636088
+ 5.0173111779111072e-06 2.6914090918279978
+ 5.0183111779111068e-06 2.6749893013882011
+ 5.0193111779111056e-06 2.6638046312667929
+ 5.0203111779111061e-06 2.6484707906170222
+ 5.0213111779111058e-06 2.6367843501259749
+ 5.0223111779111046e-06 2.6217533452468058
+ 5.0233111779111051e-06 2.6101229465590339
+ 5.0243111779111047e-06 2.595078366522328
+ 5.0253111779111044e-06 2.5835699703745152
+ 5.0263111779111041e-06 2.568675152775993
+ 5.0273111779111037e-06 2.5569239912396919
+ 5.0283111779111034e-06 2.5426918405963832
+ 5.029311177911103e-06 2.530090790493976
+ 5.0303111779111027e-06 2.5171528458582291
+ 5.0313111779111023e-06 2.5031068413183171
+ 5.032311177911102e-06 2.4919562658937502
+ 5.0333111779111016e-06 2.476120947981769
+ 5.0343111779111013e-06 2.4669115079632848
+ 5.0353111779111009e-06 2.44934059830921
+ 5.0363111779111014e-06 2.441804379473393
+ 5.0373111779111002e-06 2.4229608902059199
+ 5.0383111779110999e-06 2.416468215513937
+ 5.0393111779111004e-06 2.3970992139303302
+ 5.0403111779110992e-06 2.390838045765693
+ 5.0413111779110988e-06 2.371756598997369
+ 5.0423111779110976e-06 2.364970693237189
+ 5.0433111779110981e-06 2.3468176448407578
+ 5.0443111779110978e-06 2.3390250099165701
+ 5.0453111779110966e-06 2.322088278783641
+ 5.0463111779110971e-06 2.3132094317871581
+ 5.0473111779110967e-06 2.2973583888688842
+ 5.0483111779110964e-06 2.2877144503711331
+ 5.049311177911096e-06 2.272468595076945
+ 5.0503111779110957e-06 2.2626521316225512
+ 5.0513111779110953e-06 2.247359484922292
+ 5.052311177911095e-06 2.238022107586092
+ 5.0533111779110946e-06 2.222087723665763
+ 5.0543111779110943e-06 2.2137145359623531
+ 5.0553111779110939e-06 2.1968044582792872
+ 5.0563111779110936e-06 2.1895483692880049
+ 5.0573111779110933e-06 2.1717037151957919
+ 5.0583111779110929e-06 2.1653318907594898
+ 5.0593111779110934e-06 2.1469580483187669
+ 5.0603111779110922e-06 2.1409255232587072
+ 5.0613111779110919e-06 2.1226624859746779
+ 5.0623111779110924e-06 2.116286566141413
+ 5.0633111779110912e-06 2.09880473652496
+ 5.0643111779110908e-06 2.091481750399101
+ 5.0653111779110896e-06 2.0752707734837732
+ 5.0663111779110901e-06 2.066664184723245
+ 5.0673111779110898e-06 2.0518833021654399
+ 5.0683111779110894e-06 2.042022851141573
+ 5.0693111779110891e-06 2.0284600234328458
+ 5.0703111779110887e-06 2.0177215311302059
+ 5.0713111779110884e-06 2.00487246155275
+ 5.072311177911088e-06 1.9938471325524429
+ 5.0733111779110877e-06 1.9810863175616771
+ 5.0743111779110873e-06 1.9703839532556331
+ 5.075311177911087e-06 1.9571706629141581
+ 5.0763111779110866e-06 1.9472216977453931
+ 5.0773111779110863e-06 1.9332736252296721
+ 5.0783111779110859e-06 1.924193985277828
+ 5.0793111779110856e-06 1.9095731133531599
+ 5.0803111779110852e-06 1.901134283839566
+ 5.0813111779110849e-06 1.886219041589176
+ 5.0823111779110854e-06 1.8779308246276381
+ 5.0833111779110842e-06 1.8632859372617321
+ 5.0843111779110838e-06 1.8545627523452091
+ 5.0853111779110826e-06 1.84075107468864
+ 5.0863111779110831e-06 1.831106202600757
+ 5.0873111779110828e-06 1.8185047073476639
+ 5.0883111779110816e-06 1.807708970796569
+ 5.0893111779110821e-06 1.796388442483202
+ 5.0903111779110818e-06 1.784542643677447
+ 5.0913111779110814e-06 1.774247917803911
+ 5.0923111779110811e-06 1.761747621858301
+ 5.0933111779110807e-06 1.751987485340434
+ 5.0943111779110804e-06 1.7393912687229089
+ 5.09531117791108e-06 1.7295964542582849
+ 5.0963111779110797e-06 1.7174494249754959
+ 5.0973111779110793e-06 1.7071564106555379
+ 5.098311177911079e-06 1.6958179177189221
+ 5.0993111779110786e-06 1.6848141466781781
+ 5.1003111779110783e-06 1.674350976965276
+ 5.1013111779110779e-06 1.662735484512019
+ 5.1023111779110784e-06 1.6529123436144999
+ 5.1033111779110772e-06 1.6410543275811009
+ 5.1043111779110769e-06 1.631422632756095
+ 5.1053111779110774e-06 1.61983367480802
+ 5.1063111779110762e-06 1.609887750190049
+ 5.1073111779110758e-06 1.5990510718187601
+ 5.1083111779110746e-06 1.588399657534064
+ 5.1093111779110751e-06 1.578612799158122
+ 5.1103111779110748e-06 1.5671099642172019
+ 5.1113111779110736e-06 1.558391702286513
+ 5.1123111779110741e-06 1.5461856621386381
+ 5.1133111779110737e-06 1.5382760409254399
+ 5.1143111779110734e-06 1.5257619718617881
+ 5.115311177911073e-06 1.5182135289541709
+ 5.1163111779110727e-06 1.50590805347249
+ 5.1173111779110723e-06 1.4982369632450661
+ 5.118311177911072e-06 1.486617418672401
+ 5.1193111779110717e-06 1.478465312543324
+ 5.1203111779110713e-06 1.467828990607718
+ 5.121311177911071e-06 1.4590871876992659
+ 5.1223111779110706e-06 1.4494850664809931
+ 5.1233111779110703e-06 1.4403615797834639
+ 5.1243111779110699e-06 1.4316693732246391
+ 5.1253111779110704e-06 1.4227728001104629
+ 5.1263111779110692e-06 1.415073737312954
+ 5.1273111779110689e-06 1.407834084315162
+ 5.1283111779110694e-06 1.4021462834566509
+ 5.1293111779110682e-06 1.397956040138798
+ 5.1303111779110678e-06 1.393309659976173
+ 5.1313111779110666e-06 1.3908749711208039
+ 5.1323111779110671e-06 1.3861364509450571
+ 5.1333111779110668e-06 1.384918639214946
+ 5.1343111779110656e-06 1.380021344623269
+ 5.1353111779110661e-06 1.3795824629584681
+ 5.1363111779110657e-06 1.374754762697997
+ 5.1373111779110654e-06 1.3745619214829641
+ 5.138311177911065e-06 1.3701372241600049
+ 5.1393111779110647e-06 1.369663323612675
+ 5.1403111779110643e-06 1.365913903509425
+ 5.141311177911064e-06 1.36478978219439
+ 5.1423111779110636e-06 1.3618254926754809
+ 5.1433111779110633e-06 1.3599620059073301
+ 5.1443111779110629e-06 1.357673421024995
+ 5.1453111779110626e-06 1.3552586548995289
+ 5.1463111779110622e-06 1.353320078892382
+ 5.1473111779110619e-06 1.350728749576882
+ 5.1483111779110624e-06 1.348701170499254
+ 5.1493111779110612e-06 1.3463510899608231
+ 5.1503111779110608e-06 1.3438377608910901
+ 5.1513111779110613e-06 1.342029892276998
+ 5.1523111779110602e-06 1.3388228721347999
+ 5.1533111779110598e-06 1.3376210892113951
+ 5.1543111779110586e-06 1.3337816613596021
+ 5.1553111779110591e-06 1.332980338955311
+ 5.1563111779110588e-06 1.328817505678884
+ 5.1573111779110584e-06 1.328015761040104
+ 5.1583111779110581e-06 1.3239637266216151
+ 5.1593111779110577e-06 1.3227245269209389
+ 5.1603111779110574e-06 1.3191611298704
+ 5.161311177911057e-06 1.317196000006313
+ 5.1623111779110567e-06 1.31427390807156
+ 5.1633111779110563e-06 1.3115754004712961
+ 5.164311177911056e-06 1.309142157292253
+ 5.1653111779110556e-06 1.3059980991379689
+ 5.1663111779110553e-06 1.303652658391367
+ 5.1673111779110549e-06 1.300519985727671
+ 5.1683111779110546e-06 1.2977971916693949
+ 5.1693111779110542e-06 1.295076925331196
+ 5.1703111779110539e-06 1.291686200550086
+ 5.1713111779110544e-06 1.2895001790619121
+ 5.1723111779110532e-06 1.2854990630647809
+ 5.1733111779110528e-06 1.2835909854047729
+ 5.1743111779110516e-06 1.2793186802534771
+ 5.1753111779110521e-06 1.2746383897347831
+ 5.1763111779110518e-06 1.249641000982969
+ 5.1773111779110506e-06 1.2261696309497661
+ 5.1783111779110511e-06 1.215022732482983
+ 5.1793111779110507e-06 1.206686406033544
+ 5.1803111779110504e-06 1.196788208033253
+ 5.18131117791105e-06 1.1875186240253961
+ 5.1823111779110497e-06 1.1789210704764981
+ 5.1833111779110494e-06 1.1702779889165871
+ 5.184311177911049e-06 1.1611276667350079
+ 5.1853111779110487e-06 1.151857076310409
+ 5.1863111779110483e-06 1.14243490053841
+ 5.187311177911048e-06 1.1327623619042999
+ 5.1883111779110476e-06 1.1227389118479041
+ 5.1893111779110473e-06 1.1124523474249659
+ 5.1903111779110469e-06 1.1019265452015261
+ 5.1913111779110474e-06 1.091116607648096
+ 5.1923111779110462e-06 1.080053589448611
+ 5.1933111779110459e-06 1.0687372770039321
+ 5.1943111779110464e-06 1.057252969536888
+ 5.1953111779110452e-06 1.045549434589558
+ 5.1963111779110448e-06 1.0337196308152941
+ 5.1973111779110436e-06 1.021725759431187
+ 5.1983111779110441e-06 1.009684124695345
+ 5.1993111779110438e-06 0.99752977832302303
+ 5.2003111779110426e-06 0.98537632881277526
+ 5.2013111779110431e-06 0.97316218450992398
+ 5.2023111779110427e-06 0.96100678879605239
+ 5.2033111779110424e-06 0.94883276273843919
+ 5.204311177911042e-06 0.93675053984457357
+ 5.2053111779110417e-06 0.92468529634743091
+ 5.2063111779110413e-06 0.9127454805890749
+ 5.207311177911041e-06 0.90084946062366344
+ 5.2083111779110406e-06 0.88909485261810706
+ 5.2093111779110403e-06 0.87740495971781007
+ 5.2103111779110399e-06 0.86587225440638704
+ 5.2113111779110396e-06 0.85441979452071393
+ 5.2123111779110392e-06 0.84312909250311907
+ 5.2133111779110389e-06 0.83193027411386933
+ 5.2143111779110394e-06 0.82089827638310642
+ 5.2153111779110382e-06 0.80996701278761096
+ 5.2163111779110379e-06 0.79920083379468276
+ 5.2173111779110384e-06 0.78854181686596403
+ 5.2183111779110372e-06 0.77804710477762973
+ 5.2193111779110368e-06 0.76766467053711951
+ 5.2203111779110356e-06 0.75744169878905787
+ 5.2213111779110361e-06 0.74733454567168334
+ 5.2223111779110358e-06 0.73738308956767606
+ 5.2233111779110354e-06 0.72755041510767404
+ 5.2243111779110351e-06 0.71786727081852808
+ 5.2253111779110347e-06 0.70830476582806079
+ 5.2263111779110344e-06 0.69888663557105035
+ 5.227311177911034e-06 0.68959076098494443
+ 5.2283111779110337e-06 0.68043271689217955
+ 5.2293111779110333e-06 0.67139771547208404
+ 5.230311177911033e-06 0.6624948778641343
+ 5.2313111779110326e-06 0.65371577152637128
+ 5.2323111779110323e-06 0.64506239583045843
+ 5.2333111779110319e-06 0.63653279223137216
+ 5.2343111779110316e-06 0.62812322033756662
+ 5.2353111779110312e-06 0.61983741857538077
+ 5.2363111779110309e-06 0.61166556657370519
+ 5.2373111779110314e-06 0.60361696917198893
+ 5.2383111779110302e-06 0.59567684453928482
+ 5.2393111779110298e-06 0.58785943603773816
+ 5.2403111779110286e-06 0.58014487482829336
+ 5.2413111779110291e-06 0.57255208516250877
+ 5.2423111779110288e-06 0.56505701359760063
+ 5.2433111779110276e-06 0.55768275354595853
+ 5.2443111779110281e-06 0.55040107426935225
+ 5.2453111779110278e-06 0.54323892977063493
+ 5.2463111779110274e-06 0.53616463650983848
+ 5.2473111779110271e-06 0.52920859064487014
+ 5.2483111779110267e-06 0.52233573889308216
+ 5.2493111779110264e-06 0.51557960556913562
+ 5.250311177911026e-06 0.50890234592193084
+ 5.2513111779110257e-06 0.5023402704813662
+ 5.2523111779110253e-06 0.4958528634391654
+ 5.253311177911025e-06 0.4894789275309816
+ 5.2543111779110246e-06 0.48317573454730472
+ 5.2553111779110243e-06 0.47698430093047223
+ 5.2563111779110239e-06 0.47085981912013919
+ 5.2573111779110244e-06 0.46484525776540342
+ 5.2583111779110232e-06 0.45889409136465747
+ 5.2593111779110229e-06 0.45305101509032558
+ 5.2603111779110234e-06 0.44726791620745421
+ 5.2613111779110222e-06 0.44159099188679918
+ 5.2623111779110218e-06 0.43597082509514651
+ 5.2633111779110206e-06 0.43045493321899508
+ 5.2643111779110211e-06 0.42499271495022739
+ 5.2653111779110208e-06 0.41963282008608832
+ 5.2663111779110196e-06 0.41432368311169349
+ 5.2673111779110201e-06 0.40911494075711041
+ 5.2683111779110197e-06 0.40395416873197387
+ 5.2693111779110194e-06 0.39889183672208611
+ 5.270311177911019e-06 0.39387483177428861
+ 5.2713111779110187e-06 0.38895434085656011
+ 5.2723111779110183e-06 0.38407665205587699
+ 5.273311177911018e-06 0.3792935453801648
+ 5.2743111779110176e-06 0.37455084067316752
+ 5.2753111779110173e-06 0.36990081957874649
+ 5.276311177911017e-06 0.36528890817600901
+ 5.2773111779110166e-06 0.36076779080227978
+ 5.2783111779110163e-06 0.35628259963575448
+ 5.2793111779110159e-06 0.35188634989888529
+ 5.2803111779110164e-06 0.34752394052903512
+ 5.2813111779110152e-06 0.34324863966407981
+ 5.2823111779110149e-06 0.33900518890069892
+ 5.2833111779110154e-06 0.33484705314788149
+ 5.2843111779110142e-06 0.33071886530480871
+ 5.2853111779110138e-06 0.3266742261474303
+ 5.2863111779110126e-06 0.32265771726165582
+ 5.2873111779110131e-06 0.31872303158927628
+ 5.2883111779110128e-06 0.31481473790873221
+ 5.2893111779110116e-06 0.31098657406768337
+ 5.2903111779110121e-06 0.30718313924149188
+ 5.2913111779110117e-06 0.30345818226090121
+ 5.2923111779110114e-06 0.29975636286900459
+ 5.293311177911011e-06 0.29613140437502961
+ 5.2943111779110107e-06 0.2925280595083356
+ 5.2953111779110103e-06 0.28899999976319107
+ 5.29631117791101e-06 0.28549209428958899
+ 5.2973111779110096e-06 0.28205793466328333
+ 5.2983111779110093e-06 0.2786425307044077
+ 5.2993111779110089e-06 0.27529937369087198
+ 5.3003111779110086e-06 0.27197363219771631
+ 5.3013111779110082e-06 0.26871867558542523
+ 5.3023111779110079e-06 0.26547984928858093
+ 5.3033111779110084e-06 0.26231038493168962
+ 5.3043111779110072e-06 0.25915581869366128
+ 5.3053111779110068e-06 0.25606922780025232
+ 5.3063111779110073e-06 0.25299635270514798
+ 5.3073111779110062e-06 0.2499901038875291
+ 5.3083111779110058e-06 0.24699643670831439
+ 5.3093111779110046e-06 0.24406808201290409
+ 5.3103111779110051e-06 0.2411512201951386
+ 5.3113111779110048e-06 0.23829839275040379
+ 5.3123111779110044e-06 0.23545601325447371
+ 5.3133111779110041e-06 0.23267642381155709
+ 5.3143111779110037e-06 0.22990627877931341
+ 5.3153111779110034e-06 0.22719771315549819
+ 5.316311177911003e-06 0.22449762833683201
+ 5.3173111779110027e-06 0.22185794430293801
+ 5.3183111779110023e-06 0.2192258152361741
+ 5.319311177911002e-06 0.2166529398887341
+ 5.3203111779110016e-06 0.21408673004605119
+ 5.3213111779110013e-06 0.211578656926285
+ 5.3223111779110009e-06 0.20907639429624339
+ 5.3233111779110006e-06 0.2066311807480665
+ 5.3243111779110002e-06 0.20419095578300861
+ 5.3253111779109999e-06 0.20180672024266941
+ 5.3263111779110004e-06 0.1994266827280155
+ 5.3273111779109992e-06 0.1971016020904196
+ 5.3283111779109988e-06 0.19477995896327691
+ 5.3293111779109976e-06 0.1925122659641052
+ 5.3303111779109981e-06 0.19024727837773281
+ 5.3313111779109978e-06 0.1880352589725795
+ 5.3323111779109966e-06 0.18582523999927089
+ 5.3333111779109971e-06 0.1836672307753664
+ 5.3343111779109967e-06 0.18151054257804591
+ 5.3353111779109964e-06 0.17940492811831221
+ 5.336311177910996e-06 0.17729997951820761
+ 5.3373111779109957e-06 0.17524518976838549
+ 5.3383111779109954e-06 0.1731904334415863
+ 5.339311177910995e-06 0.1711849409788051
+ 5.3403111779109947e-06 0.1691788708350076
+ 5.3413111779109943e-06 0.16722118812088299
+ 5.342311177910994e-06 0.16526233638402851
+ 5.3433111779109936e-06 0.16335101282509029
+ 5.3443111779109933e-06 0.16143794715302809
+ 5.3453111779109929e-06 0.15957156608056
+ 5.3463111779109934e-06 0.15770288635822391
+ 5.3473111779109922e-06 0.15588006174169719
+ 5.3483111779109919e-06 0.15405439674802171
+ 5.3493111779109924e-06 0.1522737978296983
+ 5.3493131310359913e-06 0.15226627855854499
+ 5.3493136193172411e-06 0.15226470353098051
+ 5.3493145958797414e-06 0.15226193162470061
+ 5.3493148400203663e-06 0.15226137877245741
+ 5.349315328301616e-06 0.15226033884152379
+ 5.3493154503719276e-06 0.15226009861708309
+ 5.3493156945125533e-06 0.15225962369974819
+ 5.3493157555477104e-06 0.15225950694031459
+ 5.349315877618022e-06 0.15225927452214921
+ 5.3493159081356001e-06 0.15225921680119661
+ 5.3493159691707563e-06 0.15225910169979659
+ 5.3493159844295458e-06 0.15225907307188041
+ 5.3493160149471239e-06 0.1522590157315922
+ 5.3493160225765182e-06 0.15225900143263141
+ 5.3493160378353077e-06 0.15225897276765171
+ 5.3493160416500053e-06 0.1522589656285378
+ 5.3493160492793996e-06 0.15225895152227911
+ 5.3493160511867484e-06 0.15225894807741139
+ 5.349316055001446e-06 0.15225894105904311
+ 5.3493160626308403e-06 0.15225892649319669
+ 5.3493160628692589e-06 0.15225893010220809
+ 5.3493160633460961e-06 0.15225892888996609
+ 5.3493160633609971e-06 0.15225893311330341
+ 5.3493160633907991e-06 0.15225893969979939
+ 5.3493160633982496e-06 0.15225892210788861
+ 5.3493160633984834e-06 0.15225962249898639
+ 5.3493160633989484e-06 0.1522606261702549
+ 8u 0.1522606261702549)
.control
set num_threads=1
set numdgt=15
set wr_singlescale
set wr_vecnames
tran 1n 8u 0 1n
wrdata /work/designs/g1-guardian/blocks/g1_gate/sim/campaigns/vendor_replay_20260921T165719Z_8ca954d2/wave.tsv v(gfet,source) v(dfet,source) i(vfet) i(Lload) i(vdrive)
quit
.endc
.end
