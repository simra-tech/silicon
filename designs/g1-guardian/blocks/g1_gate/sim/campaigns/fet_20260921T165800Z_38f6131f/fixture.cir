* G1_GATE functional + timing testbench with the sg13g2_IOPadOut30mA pad model and 5 nF external gate load
.param VDDA=3.3 VDD=1.2
.lib /foss/pdks/ihp-sg13g2/libs.tech/ngspice/models/cornerMOSlv.lib mos_tt
.lib /foss/pdks/ihp-sg13g2/libs.tech/ngspice/models/cornerMOShv.lib mos_tt
.lib /foss/pdks/ihp-sg13g2/libs.tech/ngspice/models/cornerRES.lib res_typ
.lib /foss/pdks/ihp-sg13g2/libs.tech/ngspice/models/cornerCAP.lib cap_typ
.lib /foss/pdks/ihp-sg13g2/libs.tech/ngspice/models/cornerDIO.lib dio_tt
.include /foss/pdks/ihp-sg13g2/libs.ref/sg13g2_io/spice/sg13g2_io.spi
.include /work/designs/g1-guardian/blocks/g1_gate/sim/postlayout/g1_gate_pex.spice
.temp 27
.global sub!
Vsub sub! 0 dc 0
* convergence with the IO pad model: supplies through 0.5 Ohm with 1 nF local decoupling, gear integration
.option method=gear reltol=0.005 itl4=100 abstol=1e-9 vntol=1e-5 chgtol=1e-13
Rsa vdda_s vdda 0.5
Cda vdda 0 1n
Rsd vdd_s vdd 0.5
Cdd vdd 0 1n
Vdda vdda_s 0 dc {VDDA}
Vdd vdd_s 0 dc {VDD}
* stimulus (1.2 V): en high at 0.2us; trip_d pulse at 2us; clr_d pulse at 4us; hard_cmp pulse at 6us (fast_en=0) and 8us (fast_en=1); en low at 10us
Ven en_core 0 pwl(0 0 0.2u 0 0.202u 1.2 12u 1.2)
Vtrip trip_d 0 pwl(0 0 5u 0 5.002u 1.2 12u 1.2)
Vclr clr_d 0 0
Vhard hard_cmp 0 0
Vfast fast_en 0 0
XG trip_d clr_d fast_en hard_cmp en_core gate_core fault_core tripped core_d core_a 0 g1_gate
* pads: pad c2p vdd vss iovdd iovss
XPG gate gate_core pad_d 0 pad_a 0 sg13g2_IOPadOut30mA
XPF fault_n fault_core pad_d 0 pad_a 0 sg13g2_IOPadOut4mA
* external gate network: 10 Ohm series (board gate resistor) + 5 nF
Rg gate_rg gfet 10
* Vendor model unchanged; D/G/S pin order. Board loads are engineering assumptions.
* Compatibility wrapper supplies the vendor's four unchanged constants because
* legacy PSpice .PARAM name value declarations are not resolved by this parser.
.param ptrc1=3.25e-3 ptrc2=9.0e-6 pwidth=1.3392864 perim=2.7
.incpslt /work/build/g1_gate/vendor/CSD16340Q3.lib
Vbus bus 0 5
Rload bus load 1.25
Lload load drain 1e-07
Vfet drain dfet 0
XFET dfet gfet source CSD16340Q3
Rshunt source kelvin 25m
Rreturn kelvin 0 10m
* Assumed flyback clamp across the R-L load, not a selected board diode.
Dfly drain bus fixture_clamp
.model fixture_clamp D(is=1n n=1 rs=0.05 tt=10n cjo=50p bv=60)
Rpulldown gfet source 10k
Vig gate gate_rg 0
Cfault fault_n 0 20p
Ctrip tripped 0 20f

Vcorea vdda core_a 0
Vcored vdd core_d 0
Vpada vdda pad_a 0
Vpadd vdd pad_d 0

.control
set num_threads=1
set numdgt=15
set wr_singlescale
set wr_vecnames
tran 1n 12u 0 1000p
wrdata /work/designs/g1-guardian/blocks/g1_gate/sim/campaigns/fet_20260921T165800Z_38f6131f/wave.tsv v(gate) v(gfet,source) i(vfet) i(Lload) v(dfet,source) i(vig) v(fault_n) v(tripped)
wrdata /work/designs/g1-guardian/blocks/g1_gate/sim/campaigns/fet_20260921T165800Z_38f6131f/power_wave.tsv v(vdd_s) v(vdda_s) v(vdd) v(vdda) i(vdd) i(vdda)
wrdata /work/designs/g1-guardian/blocks/g1_gate/sim/campaigns/fet_20260921T165800Z_38f6131f/split_power_wave.tsv v(vdd) v(vdda) i(vcored) i(vcorea) i(vpadd) i(vpada)
echo FET_END
quit 0
.endc
.end
