* G1_GATE power-up: supply ramps in both orders with EN pad low, then EN high; GATE pad with 5 nF
.lib /foss/pdks/ihp-sg13g2/libs.tech/ngspice/models/cornerMOSlv.lib mos_tt
.lib /foss/pdks/ihp-sg13g2/libs.tech/ngspice/models/cornerMOShv.lib mos_tt
.lib /foss/pdks/ihp-sg13g2/libs.tech/ngspice/models/cornerRES.lib res_typ
.lib /foss/pdks/ihp-sg13g2/libs.tech/ngspice/models/cornerCAP.lib cap_typ
.lib /foss/pdks/ihp-sg13g2/libs.tech/ngspice/models/cornerDIO.lib dio_tt
.include /foss/pdks/ihp-sg13g2/libs.ref/sg13g2_io/spice/sg13g2_io.spi
.include /work/designs/g1-guardian/blocks/g1_gate/sim/postlayout/g1_gate_pex.spice
.temp 27
.global sub!
Vsub sub! 0 dc 0
* convergence with the IO pad model: supplies through 0.5 Ohm with 1 nF local decoupling, gear integration
.option method=gear reltol=1e-5 itl4=100 abstol=1e-14 vntol=1e-7 chgtol=1e-14
Rsa vdda_s vdda 0.5
Cda vdda 0 1n
Rsd vdd_s vdd 0.5
Cdd vdd 0 1n
* simultaneous_tt_27_1.2_3.3_ramp1 : A = IOVDD ramps 1-3 us, VDD 5-7 us; B = VDD 1-3 us, IOVDD 5-7 us; EN pad high at 9 us
Vdda vdda_s 0 pwl(0u 0 1u 0 3u 3.3 16u 3.3)
Vdd vdd_s 0 pwl(0u 0 1u 0 3u 1.2 16u 1.2)
* EN pad: 0u 0 9u 0 9.1u 3.3 16u 3.3
Ven en_pad 0 pwl(0u 0 9u 0 9.1u 3.3 16u 3.3)
Vz trip_d 0 dc 0
Vc clr_d 0 dc 0
Vf fast_en 0 dc 0
Vh hard_cmp 0 dc 0
XPE en_pad en_core vdd 0 vdda 0 sg13g2_IOPadIn
XG trip_d clr_d fast_en hard_cmp en_core gate_core fault_core tripped vdd vdda 0 g1_gate
.include /work/designs/g1-guardian/blocks/g1_gate/sim/campaigns/20260921T171148Z_1bab10f8/candidate_source.spice
Xreceiver gate_core padres vdda 0 g1_io_buffer_candidate
XPG gate padres vdd 0 vdda 0 sg13g2_IOPadAnalog
* external gate network: 10 Ohm series (board gate resistor) + 5 nF
Rg gate gfet 10
Cgate gfet 0 5n
Rgate_ext gate 0 10k

.control
set num_threads=1
set numdgt=15
set wr_singlescale
set wr_vecnames
tran 5n 16u
wrdata /work/designs/g1-guardian/blocks/g1_gate/sim/campaigns/20260921T171148Z_1bab10f8/simultaneous_tt_27_1.2_3.3_ramp1.tsv v(gate) v(gfet) v(gate_core) v(en_core) v(vdd) v(vdda) i(vdda) i(vdd)
wrdata /work/designs/g1-guardian/blocks/g1_gate/sim/campaigns/20260921T171148Z_1bab10f8/simultaneous_tt_27_1.2_3.3_ramp1_candidate.tsv v(xreceiver.sense) v(padres) v(gate_core) v(vdda) v(vdd) i(vdda) i(vdd)
let endpoint=time[length(time)-1]
echo ENDPOINT $&endpoint
rusage all
.endc
.end
