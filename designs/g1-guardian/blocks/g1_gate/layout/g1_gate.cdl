* CDL for KLayout LVS, generated by layout/spice2cdl.py from g1_gate.spice (substrate net = vss)
.subckt g1_gate trip_d clr_d fast_en hard_cmp en_core gate_core fault_core tripped vdd vdda vss
XNA hard_cmp fast_en fast_n vdd vss g1_lv_nand2
XIA fast_n fast vdd vss g1_lv_inv
XU0 fast fast_h vdd vdda vss g1_lvlup
XU1 trip_d trip_h vdd vdda vss g1_lvlup
XU2 clr_d clr_h vdd vdda vss g1_lvlup
XU3 en_core en_h vdd vdda vss g1_lvlup
XN1 fast_h trip_h set_n vdda vss g1_hv_nor2
XI1 set_n set vdda vss g1_hv_inv
XI2 en_h en_hn vdda vss g1_hv_inv
XN2 en_hn clr_h rst_n vdda vss g1_hv_nor2
XI3 rst_n rst vdda vss g1_hv_inv
XL1 rst qb q vdda vss g1_hv_nor2
XL2 set q qb vdda vss g1_hv_nor2
XG en_hn q gate_h vdda vss g1_hv_nor2
XGI gate_h gate_hn vdda vss g1_hv_inv
XD1 gate_h gate_hn gate_core vdd vss g1_lvldn
XD2 qb q fault_core vdd vss g1_lvldn
XD3 q qb tripped vdd vss g1_lvldn
.ends
.subckt g1_lv_nand2 a b y vdd vss
MMP1 y a vdd vdd sg13_lv_pmos w=2u l=0.13u m=1
MMP2 y b vdd vdd sg13_lv_pmos w=2u l=0.13u m=1
MMN1 y a m vss sg13_lv_nmos w=2u l=0.13u m=1
MMN2 m b vss vss sg13_lv_nmos w=2u l=0.13u m=1
.ends
.subckt g1_lv_inv a y vdd vss
MMP y a vdd vdd sg13_lv_pmos w=2u l=0.13u m=1
MMN y a vss vss sg13_lv_nmos w=1u l=0.13u m=1
.ends
.subckt g1_lvlup a y vdd vdda vss
XI a ab vdd vss g1_lv_inv
MMN1 nb a vss vss sg13_hv_nmos w=1.9u l=0.45u m=1
MMN2 n ab vss vss sg13_hv_nmos w=1.9u l=0.45u m=1
MMP1 nb n vdda vdda sg13_hv_pmos w=0.3u l=0.45u m=1
MMP2 n nb vdda vdda sg13_hv_pmos w=0.3u l=0.45u m=1
XO nb y vdda vss g1_hv_inv
.ends
.subckt g1_hv_nor2 a b y vdda vss
MMP1 m a vdda vdda sg13_hv_pmos w=7.8u l=0.45u m=1
MMP2 y b m vdda sg13_hv_pmos w=7.8u l=0.45u m=1
MMN1 y a vss vss sg13_hv_nmos w=1.9u l=0.45u m=1
MMN2 y b vss vss sg13_hv_nmos w=1.9u l=0.45u m=1
.ends
.subckt g1_hv_inv a y vdda vss
MMP y a vdda vdda sg13_hv_pmos w=3.9u l=0.45u m=1
MMN y a vss vss sg13_hv_nmos w=1.9u l=0.45u m=1
.ends
.subckt g1_lvldn a ab y vdd vss
MMN1 yb a vss vss sg13_hv_nmos w=2u l=0.45u m=1
MMN2 y ab vss vss sg13_hv_nmos w=2u l=0.45u m=1
MMP1 y yb vdd vdd sg13_lv_pmos w=1u l=0.13u m=1
MMP2 yb y vdd vdd sg13_lv_pmos w=1u l=0.13u m=1
.ends
