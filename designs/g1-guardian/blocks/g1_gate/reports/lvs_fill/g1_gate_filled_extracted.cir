* Extracted by KLayout with SG13G2 LVS runset on : 19/09/2026 14:40

.SUBCKT g1_gate clr_d en_core fast_en fault_core gate_core hard_cmp trip_d
+ tripped vdd vdda vss
M$1 tripped \$12 vdd vdd sg13_lv_pmos L=0.13u W=1u AS=0.34p AD=0.19p PS=2.68u
+ PD=1.38u rfmode=0
M$2 vdd tripped \$12 vdd sg13_lv_pmos L=0.13u W=1u AS=0.19p AD=0.34p PS=1.38u
+ PD=2.68u rfmode=0
M$3 fault_core \$11 vdd vdd sg13_lv_pmos L=0.13u W=1u AS=0.34p AD=0.19p
+ PS=2.68u PD=1.38u rfmode=0
M$4 vdd fault_core \$11 vdd sg13_lv_pmos L=0.13u W=1u AS=0.19p AD=0.34p
+ PS=1.38u PD=2.68u rfmode=0
M$5 gate_core \$10 vdd vdd sg13_lv_pmos L=0.13u W=1u AS=0.34p AD=0.19p PS=2.68u
+ PD=1.38u rfmode=0
M$6 vdd gate_core \$10 vdd sg13_lv_pmos L=0.13u W=1u AS=0.19p AD=0.34p PS=1.38u
+ PD=2.68u rfmode=0
M$7 vss \$3 \$5 vss sg13_lv_nmos L=0.13u W=1u AS=0.34p AD=0.34p PS=2.68u
+ PD=2.68u rfmode=0
M$8 vss \$5 \$6 vss sg13_lv_nmos L=0.13u W=1u AS=0.34p AD=0.34p PS=2.68u
+ PD=2.68u rfmode=0
M$9 vss trip_d \$7 vss sg13_lv_nmos L=0.13u W=1u AS=0.34p AD=0.34p PS=2.68u
+ PD=2.68u rfmode=0
M$10 vss en_core \$9 vss sg13_lv_nmos L=0.13u W=1u AS=0.34p AD=0.34p PS=2.68u
+ PD=2.68u rfmode=0
M$11 vss clr_d \$8 vss sg13_lv_nmos L=0.13u W=1u AS=0.34p AD=0.34p PS=2.68u
+ PD=2.68u rfmode=0
M$12 vdd trip_d \$7 vdd sg13_lv_pmos L=0.13u W=2u AS=0.68p AD=0.68p PS=4.68u
+ PD=4.68u rfmode=0
M$13 vdd clr_d \$8 vdd sg13_lv_pmos L=0.13u W=2u AS=0.68p AD=0.68p PS=4.68u
+ PD=4.68u rfmode=0
M$14 vdd en_core \$9 vdd sg13_lv_pmos L=0.13u W=2u AS=0.68p AD=0.68p PS=4.68u
+ PD=4.68u rfmode=0
M$15 vdd \$5 \$6 vdd sg13_lv_pmos L=0.13u W=2u AS=0.68p AD=0.68p PS=4.68u
+ PD=4.68u rfmode=0
M$16 vdd \$3 \$5 vdd sg13_lv_pmos L=0.13u W=2u AS=0.68p AD=0.68p PS=4.68u
+ PD=4.68u rfmode=0
M$17 \$3 hard_cmp \$I1413 vss sg13_lv_nmos L=0.13u W=2u AS=0.68p AD=0.38p
+ PS=4.68u PD=2.38u rfmode=0
M$18 \$I1413 fast_en vss vss sg13_lv_nmos L=0.13u W=2u AS=0.38p AD=0.68p
+ PS=2.38u PD=4.68u rfmode=0
M$19 \$3 hard_cmp vdd vdd sg13_lv_pmos L=0.13u W=2u AS=0.68p AD=0.38p PS=4.68u
+ PD=2.38u rfmode=0
M$20 vdd fast_en \$3 vdd sg13_lv_pmos L=0.13u W=2u AS=0.38p AD=0.68p PS=2.38u
+ PD=4.68u rfmode=0
M$21 vdda \$39 \$33 vdda sg13_hv_pmos L=0.45u W=0.3u AS=0.102p AD=0.102p
+ PS=1.28u PD=1.28u rfmode=0
M$22 vdda \$33 \$39 vdda sg13_hv_pmos L=0.45u W=0.3u AS=0.102p AD=0.102p
+ PS=1.28u PD=1.28u rfmode=0
M$23 vdda \$22 \$17 vdda sg13_hv_pmos L=0.45u W=0.3u AS=0.102p AD=0.102p
+ PS=1.28u PD=1.28u rfmode=0
M$24 vdda \$23 \$24 vdda sg13_hv_pmos L=0.45u W=0.3u AS=0.102p AD=0.102p
+ PS=1.28u PD=1.28u rfmode=0
M$25 vdda \$32 \$26 vdda sg13_hv_pmos L=0.45u W=0.3u AS=0.102p AD=0.102p
+ PS=1.28u PD=1.28u rfmode=0
M$26 vdda \$26 \$32 vdda sg13_hv_pmos L=0.45u W=0.3u AS=0.102p AD=0.102p
+ PS=1.28u PD=1.28u rfmode=0
M$27 vdda \$24 \$23 vdda sg13_hv_pmos L=0.45u W=0.3u AS=0.102p AD=0.102p
+ PS=1.28u PD=1.28u rfmode=0
M$28 vdda \$17 \$22 vdda sg13_hv_pmos L=0.45u W=0.3u AS=0.102p AD=0.102p
+ PS=1.28u PD=1.28u rfmode=0
M$29 vss \$22 \$18 vss sg13_hv_nmos L=0.45u W=1.9u AS=0.646p AD=0.646p PS=4.48u
+ PD=4.48u rfmode=0
M$30 vss \$34 \$28 vss sg13_hv_nmos L=0.45u W=1.9u AS=0.646p AD=0.646p PS=4.48u
+ PD=4.48u rfmode=0
M$31 vss \$39 \$34 vss sg13_hv_nmos L=0.45u W=1.9u AS=0.646p AD=0.646p PS=4.48u
+ PD=4.48u rfmode=0
M$32 vss \$20 \$31 vss sg13_hv_nmos L=0.45u W=1.9u AS=0.646p AD=0.646p PS=4.48u
+ PD=4.48u rfmode=0
M$33 vss \$35 \$29 vss sg13_hv_nmos L=0.45u W=1.9u AS=0.646p AD=0.646p PS=4.48u
+ PD=4.48u rfmode=0
M$34 vss \$24 \$25 vss sg13_hv_nmos L=0.45u W=1.9u AS=0.646p AD=0.646p PS=4.48u
+ PD=4.48u rfmode=0
M$35 vss \$32 \$27 vss sg13_hv_nmos L=0.45u W=1.9u AS=0.646p AD=0.646p PS=4.48u
+ PD=4.48u rfmode=0
M$36 vss \$40 \$19 vss sg13_hv_nmos L=0.45u W=1.9u AS=0.646p AD=0.646p PS=4.48u
+ PD=4.48u rfmode=0
M$37 vdda \$20 \$31 vdda sg13_hv_pmos L=0.45u W=3.9u AS=1.326p AD=1.326p
+ PS=8.48u PD=8.48u rfmode=0
M$38 vdda \$35 \$29 vdda sg13_hv_pmos L=0.45u W=3.9u AS=1.326p AD=1.326p
+ PS=8.48u PD=8.48u rfmode=0
M$39 vdda \$24 \$25 vdda sg13_hv_pmos L=0.45u W=3.9u AS=1.326p AD=1.326p
+ PS=8.48u PD=8.48u rfmode=0
M$40 vdda \$34 \$28 vdda sg13_hv_pmos L=0.45u W=3.9u AS=1.326p AD=1.326p
+ PS=8.48u PD=8.48u rfmode=0
M$41 vdda \$39 \$34 vdda sg13_hv_pmos L=0.45u W=3.9u AS=1.326p AD=1.326p
+ PS=8.48u PD=8.48u rfmode=0
M$42 vdda \$40 \$19 vdda sg13_hv_pmos L=0.45u W=3.9u AS=1.326p AD=1.326p
+ PS=8.48u PD=8.48u rfmode=0
M$43 vdda \$32 \$27 vdda sg13_hv_pmos L=0.45u W=3.9u AS=1.326p AD=1.326p
+ PS=8.48u PD=8.48u rfmode=0
M$44 vdda \$22 \$18 vdda sg13_hv_pmos L=0.45u W=3.9u AS=1.326p AD=1.326p
+ PS=8.48u PD=8.48u rfmode=0
M$45 \$22 \$5 vss vss sg13_hv_nmos L=0.45u W=1.9u AS=0.646p AD=0.361p PS=4.48u
+ PD=2.28u rfmode=0
M$46 vss \$6 \$17 vss sg13_hv_nmos L=0.45u W=1.9u AS=0.361p AD=0.646p PS=2.28u
+ PD=4.48u rfmode=0
M$47 \$24 trip_d vss vss sg13_hv_nmos L=0.45u W=1.9u AS=0.646p AD=0.361p
+ PS=4.48u PD=2.28u rfmode=0
M$48 vss \$7 \$23 vss sg13_hv_nmos L=0.45u W=1.9u AS=0.361p AD=0.646p PS=2.28u
+ PD=4.48u rfmode=0
M$49 \$40 \$18 vss vss sg13_hv_nmos L=0.45u W=1.9u AS=0.646p AD=0.361p PS=4.48u
+ PD=2.28u rfmode=0
M$50 vss \$25 \$40 vss sg13_hv_nmos L=0.45u W=1.9u AS=0.361p AD=0.646p PS=2.28u
+ PD=4.48u rfmode=0
M$51 \$30 \$19 vss vss sg13_hv_nmos L=0.45u W=1.9u AS=0.646p AD=0.361p PS=4.48u
+ PD=2.28u rfmode=0
M$52 vss \$36 \$30 vss sg13_hv_nmos L=0.45u W=1.9u AS=0.361p AD=0.646p PS=2.28u
+ PD=4.48u rfmode=0
M$53 \$20 \$28 vss vss sg13_hv_nmos L=0.45u W=1.9u AS=0.646p AD=0.361p PS=4.48u
+ PD=2.28u rfmode=0
M$54 vss \$36 \$20 vss sg13_hv_nmos L=0.45u W=1.9u AS=0.361p AD=0.646p PS=2.28u
+ PD=4.48u rfmode=0
M$55 \$35 \$28 vss vss sg13_hv_nmos L=0.45u W=1.9u AS=0.646p AD=0.361p PS=4.48u
+ PD=2.28u rfmode=0
M$56 vss \$27 \$35 vss sg13_hv_nmos L=0.45u W=1.9u AS=0.361p AD=0.646p PS=2.28u
+ PD=4.48u rfmode=0
M$57 \$32 clr_d vss vss sg13_hv_nmos L=0.45u W=1.9u AS=0.646p AD=0.361p
+ PS=4.48u PD=2.28u rfmode=0
M$58 vss \$8 \$26 vss sg13_hv_nmos L=0.45u W=1.9u AS=0.361p AD=0.646p PS=2.28u
+ PD=4.48u rfmode=0
M$59 \$36 \$29 vss vss sg13_hv_nmos L=0.45u W=1.9u AS=0.646p AD=0.361p PS=4.48u
+ PD=2.28u rfmode=0
M$60 vss \$30 \$36 vss sg13_hv_nmos L=0.45u W=1.9u AS=0.361p AD=0.646p PS=2.28u
+ PD=4.48u rfmode=0
M$61 \$39 en_core vss vss sg13_hv_nmos L=0.45u W=1.9u AS=0.646p AD=0.361p
+ PS=4.48u PD=2.28u rfmode=0
M$62 vss \$9 \$33 vss sg13_hv_nmos L=0.45u W=1.9u AS=0.361p AD=0.646p PS=2.28u
+ PD=4.48u rfmode=0
M$63 vdda \$28 \$I1414 vdda sg13_hv_pmos L=0.45u W=7.8u AS=2.652p AD=1.482p
+ PS=16.28u PD=8.18u rfmode=0
M$64 \$I1414 \$27 \$35 vdda sg13_hv_pmos L=0.45u W=7.8u AS=1.482p AD=2.652p
+ PS=8.18u PD=16.28u rfmode=0
M$65 vdda \$19 \$I1415 vdda sg13_hv_pmos L=0.45u W=7.8u AS=2.652p AD=1.482p
+ PS=16.28u PD=8.18u rfmode=0
M$66 \$I1415 \$36 \$30 vdda sg13_hv_pmos L=0.45u W=7.8u AS=1.482p AD=2.652p
+ PS=8.18u PD=16.28u rfmode=0
M$67 vdda \$29 \$I1416 vdda sg13_hv_pmos L=0.45u W=7.8u AS=2.652p AD=1.482p
+ PS=16.28u PD=8.18u rfmode=0
M$68 \$I1416 \$30 \$36 vdda sg13_hv_pmos L=0.45u W=7.8u AS=1.482p AD=2.652p
+ PS=8.18u PD=16.28u rfmode=0
M$69 vdda \$28 \$I1417 vdda sg13_hv_pmos L=0.45u W=7.8u AS=2.652p AD=1.482p
+ PS=16.28u PD=8.18u rfmode=0
M$70 \$I1417 \$36 \$20 vdda sg13_hv_pmos L=0.45u W=7.8u AS=1.482p AD=2.652p
+ PS=8.18u PD=16.28u rfmode=0
M$71 vdda \$18 \$I1418 vdda sg13_hv_pmos L=0.45u W=7.8u AS=2.652p AD=1.482p
+ PS=16.28u PD=8.18u rfmode=0
M$72 \$I1418 \$25 \$40 vdda sg13_hv_pmos L=0.45u W=7.8u AS=1.482p AD=2.652p
+ PS=8.18u PD=16.28u rfmode=0
M$73 \$10 \$20 vss vss sg13_hv_nmos L=0.45u W=2u AS=0.68p AD=0.38p PS=4.68u
+ PD=2.38u rfmode=0
M$74 vss \$31 gate_core vss sg13_hv_nmos L=0.45u W=2u AS=0.38p AD=0.68p
+ PS=2.38u PD=4.68u rfmode=0
M$75 \$11 \$30 vss vss sg13_hv_nmos L=0.45u W=2u AS=0.68p AD=0.38p PS=4.68u
+ PD=2.38u rfmode=0
M$76 vss \$36 fault_core vss sg13_hv_nmos L=0.45u W=2u AS=0.38p AD=0.68p
+ PS=2.38u PD=4.68u rfmode=0
M$77 \$12 \$36 vss vss sg13_hv_nmos L=0.45u W=2u AS=0.68p AD=0.38p PS=4.68u
+ PD=2.38u rfmode=0
M$78 vss \$30 tripped vss sg13_hv_nmos L=0.45u W=2u AS=0.38p AD=0.68p PS=2.38u
+ PD=4.68u rfmode=0
.ENDS g1_gate
