* Extracted by KLayout with SG13G2 LVS runset on : 19/09/2026 09:34

.SUBCKT g1_gate clr_d en_core fast_en fault_core gate_core hard_cmp trip_d
+ tripped vdd vdda vss
M$1 gate_core \$11 vdd vdd sg13_lv_pmos L=0.13u W=1u AS=0.34p AD=0.19p PS=2.68u
+ PD=1.38u rfmode=0
M$2 vdd gate_core \$11 vdd sg13_lv_pmos L=0.13u W=1u AS=0.19p AD=0.34p PS=1.38u
+ PD=2.68u rfmode=0
M$3 tripped \$13 vdd vdd sg13_lv_pmos L=0.13u W=1u AS=0.34p AD=0.19p PS=2.68u
+ PD=1.38u rfmode=0
M$4 vdd tripped \$13 vdd sg13_lv_pmos L=0.13u W=1u AS=0.19p AD=0.34p PS=1.38u
+ PD=2.68u rfmode=0
M$5 fault_core \$12 vdd vdd sg13_lv_pmos L=0.13u W=1u AS=0.34p AD=0.19p
+ PS=2.68u PD=1.38u rfmode=0
M$6 vdd fault_core \$12 vdd sg13_lv_pmos L=0.13u W=1u AS=0.19p AD=0.34p
+ PS=1.38u PD=2.68u rfmode=0
M$7 vss \$4 \$6 vss sg13_lv_nmos L=0.13u W=1u AS=0.34p AD=0.34p PS=2.68u
+ PD=2.68u rfmode=0
M$8 vss en_core \$10 vss sg13_lv_nmos L=0.13u W=1u AS=0.34p AD=0.34p PS=2.68u
+ PD=2.68u rfmode=0
M$9 vss clr_d \$9 vss sg13_lv_nmos L=0.13u W=1u AS=0.34p AD=0.34p PS=2.68u
+ PD=2.68u rfmode=0
M$10 vss trip_d \$8 vss sg13_lv_nmos L=0.13u W=1u AS=0.34p AD=0.34p PS=2.68u
+ PD=2.68u rfmode=0
M$11 vss \$6 \$7 vss sg13_lv_nmos L=0.13u W=1u AS=0.34p AD=0.34p PS=2.68u
+ PD=2.68u rfmode=0
M$12 vdd \$4 \$6 vdd sg13_lv_pmos L=0.13u W=2u AS=0.68p AD=0.68p PS=4.68u
+ PD=4.68u rfmode=0
M$13 vdd en_core \$10 vdd sg13_lv_pmos L=0.13u W=2u AS=0.68p AD=0.68p PS=4.68u
+ PD=4.68u rfmode=0
M$14 vdd clr_d \$9 vdd sg13_lv_pmos L=0.13u W=2u AS=0.68p AD=0.68p PS=4.68u
+ PD=4.68u rfmode=0
M$15 vdd trip_d \$8 vdd sg13_lv_pmos L=0.13u W=2u AS=0.68p AD=0.68p PS=4.68u
+ PD=4.68u rfmode=0
M$16 vdd \$6 \$7 vdd sg13_lv_pmos L=0.13u W=2u AS=0.68p AD=0.68p PS=4.68u
+ PD=4.68u rfmode=0
M$17 \$4 hard_cmp \$I233 vss sg13_lv_nmos L=0.13u W=2u AS=0.68p AD=0.38p
+ PS=4.68u PD=2.38u rfmode=0
M$18 \$I233 fast_en vss vss sg13_lv_nmos L=0.13u W=2u AS=0.38p AD=0.68p
+ PS=2.38u PD=4.68u rfmode=0
M$19 \$4 hard_cmp vdd vdd sg13_lv_pmos L=0.13u W=2u AS=0.68p AD=0.38p PS=4.68u
+ PD=2.38u rfmode=0
M$20 vdd fast_en \$4 vdd sg13_lv_pmos L=0.13u W=2u AS=0.38p AD=0.68p PS=2.38u
+ PD=4.68u rfmode=0
M$21 \$11 \$36 vss vss sg13_hv_nmos L=0.45u W=2u AS=0.68p AD=0.38p PS=4.68u
+ PD=2.38u rfmode=0
M$22 vss \$37 gate_core vss sg13_hv_nmos L=0.45u W=2u AS=0.38p AD=0.68p
+ PS=2.38u PD=4.68u rfmode=0
M$23 \$12 \$35 vss vss sg13_hv_nmos L=0.45u W=2u AS=0.68p AD=0.38p PS=4.68u
+ PD=2.38u rfmode=0
M$24 vss \$34 fault_core vss sg13_hv_nmos L=0.45u W=2u AS=0.38p AD=0.68p
+ PS=2.38u PD=4.68u rfmode=0
M$25 \$13 \$34 vss vss sg13_hv_nmos L=0.45u W=2u AS=0.68p AD=0.38p PS=4.68u
+ PD=2.38u rfmode=0
M$26 vss \$35 tripped vss sg13_hv_nmos L=0.45u W=2u AS=0.38p AD=0.68p PS=2.38u
+ PD=4.68u rfmode=0
M$27 vdda \$19 \$I234 vdda sg13_hv_pmos L=0.45u W=7.8u AS=2.652p AD=1.482p
+ PS=16.28u PD=8.18u rfmode=0
M$28 \$I234 \$22 \$29 vdda sg13_hv_pmos L=0.45u W=7.8u AS=1.482p AD=2.652p
+ PS=8.18u PD=16.28u rfmode=0
M$29 vdda \$31 \$I235 vdda sg13_hv_pmos L=0.45u W=7.8u AS=2.652p AD=1.482p
+ PS=16.28u PD=8.18u rfmode=0
M$30 \$I235 \$25 \$32 vdda sg13_hv_pmos L=0.45u W=7.8u AS=1.482p AD=2.652p
+ PS=8.18u PD=16.28u rfmode=0
M$31 vdda \$30 \$I236 vdda sg13_hv_pmos L=0.45u W=7.8u AS=2.652p AD=1.482p
+ PS=16.28u PD=8.18u rfmode=0
M$32 \$I236 \$34 \$35 vdda sg13_hv_pmos L=0.45u W=7.8u AS=1.482p AD=2.652p
+ PS=8.18u PD=16.28u rfmode=0
M$33 vdda \$31 \$I237 vdda sg13_hv_pmos L=0.45u W=7.8u AS=2.652p AD=1.482p
+ PS=16.28u PD=8.18u rfmode=0
M$34 \$I237 \$34 \$36 vdda sg13_hv_pmos L=0.45u W=7.8u AS=1.482p AD=2.652p
+ PS=8.18u PD=16.28u rfmode=0
M$35 vdda \$33 \$I238 vdda sg13_hv_pmos L=0.45u W=7.8u AS=2.652p AD=1.482p
+ PS=16.28u PD=8.18u rfmode=0
M$36 \$I238 \$35 \$34 vdda sg13_hv_pmos L=0.45u W=7.8u AS=1.482p AD=2.652p
+ PS=8.18u PD=16.28u rfmode=0
M$37 vss \$18 \$19 vss sg13_hv_nmos L=0.45u W=1.9u AS=0.646p AD=0.646p PS=4.48u
+ PD=4.48u rfmode=0
M$38 vss \$21 \$22 vss sg13_hv_nmos L=0.45u W=1.9u AS=0.646p AD=0.646p PS=4.48u
+ PD=4.48u rfmode=0
M$39 vss \$36 \$37 vss sg13_hv_nmos L=0.45u W=1.9u AS=0.646p AD=0.646p PS=4.48u
+ PD=4.48u rfmode=0
M$40 vss \$32 \$33 vss sg13_hv_nmos L=0.45u W=1.9u AS=0.646p AD=0.646p PS=4.48u
+ PD=4.48u rfmode=0
M$41 vss \$24 \$25 vss sg13_hv_nmos L=0.45u W=1.9u AS=0.646p AD=0.646p PS=4.48u
+ PD=4.48u rfmode=0
M$42 vss \$28 \$31 vss sg13_hv_nmos L=0.45u W=1.9u AS=0.646p AD=0.646p PS=4.48u
+ PD=4.48u rfmode=0
M$43 vss \$29 \$30 vss sg13_hv_nmos L=0.45u W=1.9u AS=0.646p AD=0.646p PS=4.48u
+ PD=4.48u rfmode=0
M$44 vss \$27 \$28 vss sg13_hv_nmos L=0.45u W=1.9u AS=0.646p AD=0.646p PS=4.48u
+ PD=4.48u rfmode=0
M$45 vdda \$18 \$19 vdda sg13_hv_pmos L=0.45u W=3.9u AS=1.326p AD=1.326p
+ PS=8.48u PD=8.48u rfmode=0
M$46 vdda \$21 \$22 vdda sg13_hv_pmos L=0.45u W=3.9u AS=1.326p AD=1.326p
+ PS=8.48u PD=8.48u rfmode=0
M$47 vdda \$24 \$25 vdda sg13_hv_pmos L=0.45u W=3.9u AS=1.326p AD=1.326p
+ PS=8.48u PD=8.48u rfmode=0
M$48 vdda \$27 \$28 vdda sg13_hv_pmos L=0.45u W=3.9u AS=1.326p AD=1.326p
+ PS=8.48u PD=8.48u rfmode=0
M$49 vdda \$29 \$30 vdda sg13_hv_pmos L=0.45u W=3.9u AS=1.326p AD=1.326p
+ PS=8.48u PD=8.48u rfmode=0
M$50 vdda \$28 \$31 vdda sg13_hv_pmos L=0.45u W=3.9u AS=1.326p AD=1.326p
+ PS=8.48u PD=8.48u rfmode=0
M$51 vdda \$36 \$37 vdda sg13_hv_pmos L=0.45u W=3.9u AS=1.326p AD=1.326p
+ PS=8.48u PD=8.48u rfmode=0
M$52 vdda \$32 \$33 vdda sg13_hv_pmos L=0.45u W=3.9u AS=1.326p AD=1.326p
+ PS=8.48u PD=8.48u rfmode=0
M$53 vdda \$17 \$18 vdda sg13_hv_pmos L=0.45u W=0.3u AS=0.102p AD=0.102p
+ PS=1.28u PD=1.28u rfmode=0
M$54 vdda \$27 \$26 vdda sg13_hv_pmos L=0.45u W=0.3u AS=0.102p AD=0.102p
+ PS=1.28u PD=1.28u rfmode=0
M$55 vdda \$26 \$27 vdda sg13_hv_pmos L=0.45u W=0.3u AS=0.102p AD=0.102p
+ PS=1.28u PD=1.28u rfmode=0
M$56 vdda \$18 \$17 vdda sg13_hv_pmos L=0.45u W=0.3u AS=0.102p AD=0.102p
+ PS=1.28u PD=1.28u rfmode=0
M$57 vdda \$24 \$23 vdda sg13_hv_pmos L=0.45u W=0.3u AS=0.102p AD=0.102p
+ PS=1.28u PD=1.28u rfmode=0
M$58 vdda \$23 \$24 vdda sg13_hv_pmos L=0.45u W=0.3u AS=0.102p AD=0.102p
+ PS=1.28u PD=1.28u rfmode=0
M$59 vdda \$20 \$21 vdda sg13_hv_pmos L=0.45u W=0.3u AS=0.102p AD=0.102p
+ PS=1.28u PD=1.28u rfmode=0
M$60 vdda \$21 \$20 vdda sg13_hv_pmos L=0.45u W=0.3u AS=0.102p AD=0.102p
+ PS=1.28u PD=1.28u rfmode=0
M$61 \$18 \$6 vss vss sg13_hv_nmos L=0.45u W=1.9u AS=0.646p AD=0.361p PS=4.48u
+ PD=2.28u rfmode=0
M$62 vss \$7 \$17 vss sg13_hv_nmos L=0.45u W=1.9u AS=0.361p AD=0.646p PS=2.28u
+ PD=4.48u rfmode=0
M$63 \$36 \$31 vss vss sg13_hv_nmos L=0.45u W=1.9u AS=0.646p AD=0.361p PS=4.48u
+ PD=2.28u rfmode=0
M$64 vss \$34 \$36 vss sg13_hv_nmos L=0.45u W=1.9u AS=0.361p AD=0.646p PS=2.28u
+ PD=4.48u rfmode=0
M$65 \$21 trip_d vss vss sg13_hv_nmos L=0.45u W=1.9u AS=0.646p AD=0.361p
+ PS=4.48u PD=2.28u rfmode=0
M$66 vss \$8 \$20 vss sg13_hv_nmos L=0.45u W=1.9u AS=0.361p AD=0.646p PS=2.28u
+ PD=4.48u rfmode=0
M$67 \$35 \$30 vss vss sg13_hv_nmos L=0.45u W=1.9u AS=0.646p AD=0.361p PS=4.48u
+ PD=2.28u rfmode=0
M$68 vss \$34 \$35 vss sg13_hv_nmos L=0.45u W=1.9u AS=0.361p AD=0.646p PS=2.28u
+ PD=4.48u rfmode=0
M$69 \$34 \$33 vss vss sg13_hv_nmos L=0.45u W=1.9u AS=0.646p AD=0.361p PS=4.48u
+ PD=2.28u rfmode=0
M$70 vss \$35 \$34 vss sg13_hv_nmos L=0.45u W=1.9u AS=0.361p AD=0.646p PS=2.28u
+ PD=4.48u rfmode=0
M$71 \$32 \$31 vss vss sg13_hv_nmos L=0.45u W=1.9u AS=0.646p AD=0.361p PS=4.48u
+ PD=2.28u rfmode=0
M$72 vss \$25 \$32 vss sg13_hv_nmos L=0.45u W=1.9u AS=0.361p AD=0.646p PS=2.28u
+ PD=4.48u rfmode=0
M$73 \$27 en_core vss vss sg13_hv_nmos L=0.45u W=1.9u AS=0.646p AD=0.361p
+ PS=4.48u PD=2.28u rfmode=0
M$74 vss \$10 \$26 vss sg13_hv_nmos L=0.45u W=1.9u AS=0.361p AD=0.646p PS=2.28u
+ PD=4.48u rfmode=0
M$75 \$29 \$19 vss vss sg13_hv_nmos L=0.45u W=1.9u AS=0.646p AD=0.361p PS=4.48u
+ PD=2.28u rfmode=0
M$76 vss \$22 \$29 vss sg13_hv_nmos L=0.45u W=1.9u AS=0.361p AD=0.646p PS=2.28u
+ PD=4.48u rfmode=0
M$77 \$24 clr_d vss vss sg13_hv_nmos L=0.45u W=1.9u AS=0.646p AD=0.361p
+ PS=4.48u PD=2.28u rfmode=0
M$78 vss \$9 \$23 vss sg13_hv_nmos L=0.45u W=1.9u AS=0.361p AD=0.646p PS=2.28u
+ PD=4.48u rfmode=0
.ENDS g1_gate
