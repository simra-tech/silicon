* ADC bridge edge-count probe, ideal oscillator -> RTL divide by two
Vclk clk 0 pulse(0 1.2 0.1u 1n 1n 49.4083n 100.8166n)
.model adc adc_bridge(in_low=0.55 in_high=0.65 rise_delay=1e-12 fall_delay=1e-12)
.model dac dac_bridge(out_low=0 out_high=1.2 out_undef=0.6 t_rise=0.3n t_fall=0.3n)
.model rtl d_cosim simulation="ivlng" sim_args=["/work/build/g1_top/bridge_probe/divider.vvp"]
aadc [clk] [dclk] adc
adiv [dclk] [dq] rtl
adac [dq] [q] dac
.control
tran 0.02n 4u
meas tran t1 when v(q)=0.6 rise=1 from=1u
meas tran t2 when v(q)=0.6 rise=11 from=1u
let freq=10/(t2-t1)
print freq
meas tran qmax max v(q) from=1u to=4u
quit
.endc
.end
