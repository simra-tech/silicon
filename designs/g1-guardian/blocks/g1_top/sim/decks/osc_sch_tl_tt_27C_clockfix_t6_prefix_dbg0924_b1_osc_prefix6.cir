* G1_TOP breaker path, chip level: (osc) transistor-level G1_OSC clocking the digital macro on the chip VDD, with G1_BGR and G1_SENSE (no G1_TRIP, no G1_GATE, no pad models); cmp_soft tied high so SOFT_PEAK counts once INRUSH = 0 is written
* case osc | block netlists sch | front end tl | clock to the RTL tl | corner tt (mos_tt res_typ cap_typ hbt_typ) | 27 degC | run_top.py
.param VDDA=3.3 VDD=1.2 IOVDD=3.3 RSH=25m RGND=10m INOM=1 CVREF=1e-08
.lib /foss/pdks/ihp-sg13g2/libs.tech/ngspice/models/cornerMOSlv.lib mos_tt
.lib /foss/pdks/ihp-sg13g2/libs.tech/ngspice/models/cornerMOShv.lib mos_tt
.lib /foss/pdks/ihp-sg13g2/libs.tech/ngspice/models/cornerRES.lib res_typ
.lib /foss/pdks/ihp-sg13g2/libs.tech/ngspice/models/cornerCAP.lib cap_typ
.lib /foss/pdks/ihp-sg13g2/libs.tech/ngspice/models/cornerHBT.lib hbt_typ
.lib /foss/pdks/ihp-sg13g2/libs.tech/ngspice/models/cornerDIO.lib dio_tt
.include /foss/pdks/ihp-sg13g2/libs.ref/sg13g2_io/spice/sg13g2_io.spi
.include /work/designs/g1-guardian/blocks/g1_bgr/xschem/g1_bgr.spice
.include /work/designs/g1-guardian/blocks/g1_sense/sim/netlist/g1_sense.spice
.include /work/designs/g1-guardian/blocks/g1_osc/sim/netlist/g1_osc.spice
.include /work/designs/g1-guardian/blocks/g1_gate/sim/netlist/g1_gate.spice
.temp 27
.global sub!
Vsub sub! 0 dc 0
* solver (README, "Numerical notes"): gear integration and loose absolute tolerances are what the PDK IO-pad
* models need when XSPICE events fall on their switching edges (with abstol 1e-9 / vntol 1e-5 the diode
* internal nodes stop converging: "timestep too small"); the DAC mux-tree nodes need rshunt; XSPICE forces
* trtol = 1, which the comparator decisions need at this reltol; default gmin (1e-13 stalls the pads)
.option method=trap itl4=100 reltol=0.001 abstol=1e-10 vntol=1e-6 chgtol=1e-14 rshunt=1e12
.nodeset v(vref_buf)=1.04 v(vped)=1.0008 v(isense)=1.5 v(xsense.vp)=0.047 v(xsense.vn)=0.047 v(iptat)=0.76 v(xsense.xota.out1)=2.51 v(xsense.xota.mir)=2.51 v(xsense.xota.tail)=1.6 v(xsense.xota.fn)=0.2 v(xsense.xota.fp)=0.2 v(xsense.xbuf.out1)=2.51 v(xsense.xbuf.mir)=2.51 v(xsense.xbuf.tail)=1.6 v(xsense.xbuf.fn)=0.2 v(xsense.xbuf.fp)=0.2 v(xsense.xref.out1)=2.51 v(xsense.xref.mir)=2.51 v(xsense.xref.tail)=1.6 v(xsense.xref.fn)=0.2 v(xsense.xref.fp)=0.2
* ---- supplies: one 3.3 V board rail feeds VDDA (pin 7) and IOVDD (pin 3), PLAN D14; 1.2 V VDD (pin 1)
V33 rail33 0 dc 3.3
Vma rail33 vdda_s dc 0
Vmi rail33 iovdd_s dc 0
Rsa vdda_s vdda 0.5
Cda vdda 0 1n
Rsi iovdd_s iovdd 0.5
Cdi iovdd 0 1n
V12 vdd_s 0 dc 1.2
Rsd vdd_s vdd 0.5
Cdd vdd 0 1n
* ---- board: load current profile (1 V = 1 A) x switch on the FET gate node, shunt, Kelvin traces, FET gate
Vprof iprof 0 pwl(0 1 3e-05 1 3.002e-05 1)
Bload 0 ldi I = v(iprof) * (0.5 + 0.5*tanh((v(gfet) - 1.5)/0.15))
Vim ldi shp dc 0
Rsh shp shn {RSH}
Rgnd shn 0 {RGND}
Rkp shp sense_p 1
Rkn shn sense_n 1
Rg gate gfet 10
Cgate gfet 0 5n
Cfault fault_n 0 20p
* ---- minimal chip context (README, case osc): no pad models, no G1_GATE; the 3.3 V pad inputs are scaled to 1.2 V
Cvref_ext vref 0 1p
Ben_core en_core 0 V = v(en_pad)*1.2/3.3
Bsclk_core sclk_core 0 V = v(sclk_pad)*1.2/3.3
Bsdi_core sdi_core 0 V = v(sdi_pad)*1.2/3.3
Bgate gate 0 V = 3.3*(0.5 + 0.5*tanh((v(en_core) - 0.6)/0.05))
Vfault fault_n 0 dc 3.3
Vgc gate_core 0 dc 0
Vtr tripped 0 dc 0
Ven en_pad 0 pwl(0 0 3e-06 0 3.0009e-06 1.485 3.0011e-06 1.815 3.002e-06 3.3)
Vsclk sclk_pad 0 pwl(0 0 1.8e-05 0 1.8125e-05 0 1.8125e-05 0 1.81259e-05 1.485 1.81261e-05 1.815 1.8127e-05 3.3 1.825e-05 3.3 1.82509e-05 1.815 1.82511e-05 1.485 1.8252e-05 0 1.8375e-05 0 1.8375e-05 0 1.83759e-05 1.485 1.83761e-05 1.815 1.8377e-05 3.3 1.85e-05 3.3 1.85009e-05 1.815 1.85011e-05 1.485 1.8502e-05 0 1.8625e-05 0 1.8625e-05 0 1.86259e-05 1.485 1.86261e-05 1.815 1.8627e-05 3.3 1.875e-05 3.3 1.87509e-05 1.815 1.87511e-05 1.485 1.8752e-05 0 1.8875e-05 0 1.8875e-05 0 1.88759e-05 1.485 1.88761e-05 1.815 1.8877e-05 3.3 1.9e-05 3.3 1.90009e-05 1.815 1.90011e-05 1.485 1.9002e-05 0 1.9125e-05 0 1.9125e-05 0 1.91259e-05 1.485 1.91261e-05 1.815 1.9127e-05 3.3 1.925e-05 3.3 1.92509e-05 1.815 1.92511e-05 1.485 1.9252e-05 0 1.9375e-05 0 1.9375e-05 0 1.93759e-05 1.485 1.93761e-05 1.815 1.9377e-05 3.3 1.95e-05 3.3 1.95009e-05 1.815 1.95011e-05 1.485 1.9502e-05 0 1.9625e-05 0 1.9625e-05 0 1.96259e-05 1.485 1.96261e-05 1.815 1.9627e-05 3.3 1.975e-05 3.3 1.97509e-05 1.815 1.97511e-05 1.485 1.9752e-05 0 1.9875e-05 0 1.9875e-05 0 1.98759e-05 1.485 1.98761e-05 1.815 1.9877e-05 3.3 2e-05 3.3 2.00009e-05 1.815 2.00011e-05 1.485 2.0002e-05 0 2.0125e-05 0 2.0125e-05 0 2.01259e-05 1.485 2.01261e-05 1.815 2.0127e-05 3.3 2.025e-05 3.3 2.02509e-05 1.815 2.02511e-05 1.485 2.0252e-05 0 2.0375e-05 0 2.0375e-05 0 2.03759e-05 1.485 2.03761e-05 1.815 2.0377e-05 3.3 2.05e-05 3.3 2.05009e-05 1.815 2.05011e-05 1.485 2.0502e-05 0 2.0625e-05 0 2.0625e-05 0 2.06259e-05 1.485 2.06261e-05 1.815 2.0627e-05 3.3 2.075e-05 3.3 2.07509e-05 1.815 2.07511e-05 1.485 2.0752e-05 0 2.0875e-05 0 2.0875e-05 0 2.08759e-05 1.485 2.08761e-05 1.815 2.0877e-05 3.3 2.1e-05 3.3 2.10009e-05 1.815 2.10011e-05 1.485 2.1002e-05 0 2.1125e-05 0 2.1125e-05 0 2.11259e-05 1.485 2.11261e-05 1.815 2.1127e-05 3.3 2.125e-05 3.3 2.12509e-05 1.815 2.12511e-05 1.485 2.1252e-05 0 2.1375e-05 0 2.1375e-05 0 2.13759e-05 1.485 2.13761e-05 1.815 2.1377e-05 3.3 2.15e-05 3.3 2.15009e-05 1.815 2.15011e-05 1.485 2.1502e-05 0 2.1625e-05 0 2.1625e-05 0 2.16259e-05 1.485 2.16261e-05 1.815 2.1627e-05 3.3 2.175e-05 3.3 2.17509e-05 1.815 2.17511e-05 1.485 2.1752e-05 0 2.1875e-05 0 2.1875e-05 0 2.18759e-05 1.485 2.18761e-05 1.815 2.1877e-05 3.3 2.2e-05 3.3 2.20009e-05 1.815 2.20011e-05 1.485 2.2002e-05 0)
Vsdi sdi_pad 0 pwl(0 0 1.8e-05 0 1.9e-05 0 1.90009e-05 1.485 1.90011e-05 1.815 1.9002e-05 3.3 1.925e-05 3.3 1.92509e-05 1.815 1.92511e-05 1.485 1.9252e-05 0)
Cw_en en_core 0 20f
Cw_sclk sclk_core 0 20f
Cw_sdi sdi_core 0 20f
* the RTL reads EN / SCLK / SDI as a digital stimulus (XSPICE d_source) with the same edge times as the pad
* PWLs (event at the middle of each edge); the pad models still drive en_core for G1_GATE (README, "Numerical notes")
.model dsrc d_source(input_file="/work/build/g1_top/stim_osc_sch_tl_tt_27C_clockfix_t6_prefix_dbg0924_b1_osc_prefix6.txt")
adsrc [d_en d_sclk d_sdi] dsrc
* ---- oscillator enable gate (testbench): RTL osc_en, released at 0.1 us
Bosc osc_en_g 0 V = v(osc_en) * min(1, max(0, (time - 0.1u) / 50n))
* ---- analog chain at transistor level (per-block supply pins through 0 V sources for the current table)
Vr4 r4 0 dc 0
Vm_bgr vdda vdda_bgr dc 0
XBGR vdda_bgr 0 r4 vref iptat pbias pcasc vbe dvbe g1_bgr
Vm_sense vdda vdda_sense dc 0
XSENSE sense_p sense_n vref iptat isense vped vref_buf vdda_sense 0 g1_sense
Cw_isense isense 0 300f
Vm_tripa vdda vdda_trip dc 0
Vm_tripd vdd vdd_trip dc 0
* this case has no G1_TRIP (README): comparator outputs tied low, its supply pins left open
Vcs_tie cmp_soft 0 dc 1.2
Vch_tie cmp_hard 0 dc 0
Rtripa_dummy vdda_trip 0 1e12
Rtripd_dummy vdd_trip 0 1e12
Bicmp icmp 0 V = v(isense)/2
Vvths vth_soft 0 dc 0.800527
Vvthh vth_hard 0 dc 0.998696
Cw_soft cmp_soft 0 20f
Cw_hard cmp_hard 0 20f
Vm_osc vdd vdd_osc dc 0
XOSC osc_en_g trim0 trim1 trim2 trim3 osc_clk vdd_osc 0 g1_osc
Cw_clk osc_clk 0 100f
Vm_gatea vdda vdda_gate dc 0
Vm_gated vdd vdd_gate dc 0
Rgatea_dummy vdda_gate 0 1e12
Rgated_dummy vdd_gate 0 1e12
* ---- digital macro: the real RTL through XSPICE d_cosim (Icarus Verilog shim ivlng)
.model adc adc_bridge(in_low=0.55 in_high=0.65 rise_delay=1e-12 fall_delay=1e-12)
.model adc_clock adc_bridge(in_low=0.6 in_high=0.6 rise_delay=1e-12 fall_delay=1e-12)
.model dac dac_bridge(out_low=0 out_high=1.2 out_undef=0.6 t_rise=0.3n t_fall=0.3n)
.model rtl d_cosim simulation="ivlng" sim_args=["/work/build/g1_top/g1_dig_cosim.vvp"]
aclock [osc_clk] [d_osc_clk] adc_clock
aadc [cmp_soft cmp_hard tripped] [d_cmp_soft d_cmp_hard d_tripped] adc
adig [d_osc_clk d_en d_sclk d_sdi d_cmp_soft d_cmp_hard d_tripped] [d_cmp_clk d_s7 d_s6 d_s5 d_s4 d_s3 d_s2 d_s1 d_s0 d_h7 d_h6 d_h5 d_h4 d_h3 d_h2 d_h1 d_h0 d_trip_d d_clr_d d_fast_en d_osc_en d_t3 d_t2 d_t1 d_t0 d_trip d_gate_en d_cause1 d_cause0 d_sdo d_sp15 d_sp14 d_sp13 d_sp12 d_sp11 d_sp10 d_sp9 d_sp8 d_sp7 d_sp6 d_sp5 d_sp4 d_sp3 d_sp2 d_sp1 d_sp0 d_inrush d_softarmed] rtl
adac [d_cmp_clk d_s7 d_s6 d_s5 d_s4 d_s3 d_s2 d_s1 d_s0 d_h7 d_h6 d_h5 d_h4 d_h3 d_h2 d_h1 d_h0 d_trip_d d_clr_d d_fast_en d_osc_en d_t3 d_t2 d_t1 d_t0 d_trip d_gate_en d_cause1 d_cause0 d_sdo d_sp15 d_sp14 d_sp13 d_sp12 d_sp11 d_sp10 d_sp9 d_sp8 d_sp7 d_sp6 d_sp5 d_sp4 d_sp3 d_sp2 d_sp1 d_sp0 d_inrush d_softarmed] [cmp_clk soft7 soft6 soft5 soft4 soft3 soft2 soft1 soft0 hard7 hard6 hard5 hard4 hard3 hard2 hard1 hard0 trip_d clr_d fast_en osc_en trim3 trim2 trim1 trim0 dig_trip dig_gate_en cause1 cause0 sdo sp15 sp14 sp13 sp12 sp11 sp10 sp9 sp8 sp7 sp6 sp5 sp4 sp3 sp2 sp1 sp0 inrush_active soft_armed] dac
.save v(gate) v(gfet) v(tripped) v(isense) v(cmp_soft) v(cmp_hard) v(trip_d) v(clr_d) v(fast_en) v(osc_clk) v(cmp_clk)
+ v(vref) v(iptat) v(en_core) v(shp) v(shn) v(fault_n) v(gate_core) v(vdda) v(vdd) v(iovdd) v(iprof) v(osc_en_g)
+ v(icmp) v(vth_soft) v(vth_hard) v(dig_trip) v(cause1) v(cause0) v(sclk_pad) v(sdi_pad) v(sdo)
+ v(soft0) v(soft1) v(soft2) v(soft3) v(soft4) v(soft5) v(soft6) v(soft7) v(hard0) v(hard1) v(hard2) v(hard3) v(hard4) v(hard5) v(hard6) v(hard7)
+ v(sp0) v(sp1) v(sp2) v(sp3) v(sp4) v(sp5) v(sp6) v(sp7) v(sp8) v(sp9) v(sp10) v(sp11) v(sp12) v(sp13) v(sp14) v(sp15) v(inrush_active) v(soft_armed)
+ i(vim) i(vma) i(vmi) i(v12) i(vm_bgr) i(vm_sense) i(vm_tripa) i(vm_tripd) i(vm_osc) i(vm_gatea) i(vm_gated)
+ v(vref_buf) v(vped)
+ v(xosc.va) v(xosc.vb) v(xosc.vth) v(xosc.ca) v(xosc.cb) v(xosc.q) v(xosc.qb) v(xosc.vbn) v(vdd_osc) v(xbgr.vd1) v(xbgr.vd2) v(xbgr.vb2) v(xbgr.pbias) v(xbgr.pcasc) v(xbgr.vbe) v(xbgr.det) v(xbgr.kick) v(xbgr.c2) v(xbgr.dvbe)
.control
set filetype=ascii
set numdgt=15
set wr_singlescale
set wr_vecnames
tran 2e-08 6u 0 5e-09
wrdata /work/build/g1_top/diag_osc_sch_tl_tt_27C_clockfix_t6_prefix_dbg0924_b1_osc_prefix6.txt v(xosc.va) v(xosc.vb) v(xosc.vth) v(xosc.ca) v(xosc.cb) v(xosc.q) v(xosc.qb) v(xosc.vbn) v(vdd_osc) v(xbgr.vd1) v(xbgr.vd2) v(xbgr.vb2) v(xbgr.pbias) v(xbgr.pcasc) v(xbgr.vbe) v(xbgr.det) v(xbgr.kick) v(xbgr.c2) v(xbgr.dvbe)
let observed_end = time[length(time)-1]
echo DIAGNOSTIC_PREFIX_END_S $&observed_end
wrdata /work/build/g1_top/waves_osc_sch_tl_tt_27C_clockfix_t6_prefix_dbg0924_b1_osc_prefix6.txt v(vref) v(isense) v(gate) v(vdd) v(vdda) v(osc_clk) v(cmp_clk)
wrdata /work/build/g1_top/state_osc_sch_tl_tt_27C_clockfix_t6_prefix_dbg0924_b1_osc_prefix6.txt v(en_core) v(inrush_active) v(dig_trip) v(fast_en) v(soft0) v(soft1) v(soft2) v(soft3) v(soft4) v(soft5) v(soft6) v(soft7) v(hard0) v(hard1) v(hard2) v(hard3) v(hard4) v(hard5) v(hard6) v(hard7)
rusage all
.endc
.end
