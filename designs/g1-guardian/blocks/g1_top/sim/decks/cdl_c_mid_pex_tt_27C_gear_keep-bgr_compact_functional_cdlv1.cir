* G1_TOP breaker path, chip level: in-range hard trip: code 200 (~39.25mV), 1.8A/45mV fault in 20ns; HARD_N=4
* CDL-driven full chip (run_top_cdl.py): blocks/g1_padring/netlist/g1_chip_top_1414.cdl sha256 af5a4dbd0b17013b11d32f31221353a22b2676ea884e3487db3f14d9c5443a36, top g1_chip_top instantiated once
* case c_mid | block netlists pex (extracted: g1_gate, g1_sense, g1_t2f, g1_trip) | clock to the RTL ideal | corner tt | 27 degC | pads nodcn | method gear
* g1_gate <- blocks/g1_gate/sim/postlayout/g1_gate_pex.spice (sha256 e91617f5fcf6f5a0dc721a2ba53b507a05cc226d6dbf0bebaa858a1e7d876765; not hash-bound in run_top.py)
* g1_sense <- blocks/g1_sense/sim/postlayout/g1_sense_r100_partialc.spice (sha256 ffb14762659eaf02b6a62e9edea3caa0e143cbc7881378b329d6ab9945a6554b)
* g1_t2f <- blocks/g1_t2f/sim/postlayout/g1_t2f_pex.spice (sha256 441edabc0484c9de1e035d585369f37d460afe32370e73935044693bbfd0c78a)
* g1_trip <- blocks/g1_trip/sim/postlayout/g1_trip_nf4_pex.spice (sha256 ba86b7b2a530abae365d539297909e033b24a54597f9cc75d8dff273c30d401c)
* translated: 41 subckts; devices D dpantenna 7, M sg13_hv_nmos 292, M sg13_hv_pmos 253, M sg13_lv_nmos 8, M sg13_lv_pmos 7, Q npn13G2 302, R ptap1 42, R rhigh 15, R rppd 413, X 36, ptap1 R from sg13g2_io.spi 42, removed dantenna 8; replaced g1_digital, g1_osc; 4833 filler instances merged
* WARNING deviation --pads nodcn: every dantenna instance of the translated chip removed (IO cells and sg13g2_antennanp; 8 instances); reason: run_top.py PADS_NODCN_WARNING
* not in this deck (differences to run_top.py): the Cw_* wire capacitors (the CDL has none); the d_source RTL stimulus (the RTL reads the EN/SCLK/SDI IOPadIn outputs); fitted GATE/FAULT_N drivers
.param VDDA=3.3 VDD=1.2 IOVDD=3.3 RSH=25m RGND=10m INOM=1 CVREF=1e-08
.lib /foss/pdks/ihp-sg13g2/libs.tech/ngspice/models/cornerMOSlv.lib mos_tt
.lib /foss/pdks/ihp-sg13g2/libs.tech/ngspice/models/cornerMOShv.lib mos_tt
.lib /foss/pdks/ihp-sg13g2/libs.tech/ngspice/models/cornerRES.lib res_typ
.lib /foss/pdks/ihp-sg13g2/libs.tech/ngspice/models/cornerCAP.lib cap_typ
.lib /foss/pdks/ihp-sg13g2/libs.tech/ngspice/models/cornerHBT.lib hbt_typ
.lib /foss/pdks/ihp-sg13g2/libs.tech/ngspice/models/cornerDIO.lib dio_tt
.temp 27
.global sub!
Vsub sub! 0 dc 0
.option method=gear itl4=100 reltol=0.001 abstol=1e-10 vntol=1e-6 chgtol=1e-14 rshunt=1e12
.nodeset v(xchip.i_core_vref_buf)=1.04 v(xchip.i_core_unused_vped)=1.0008 v(xchip.i_core_isense)=1.5 v(xchip.xi_core_u_sense.vp)=0.047 v(xchip.xi_core_u_sense.vn)=0.047 v(xchip.i_core_iptat)=0.76 v(xchip.xi_core_u_sense.__pex_xota_out1)=2.51 v(xchip.xi_core_u_sense.__pex_xota_mir)=2.51 v(xchip.xi_core_u_sense.__pex_xota_tail)=1.6 v(xchip.xi_core_u_sense.__pex_xota_fn)=0.2 v(xchip.xi_core_u_sense.__pex_xota_fp)=0.2 v(xchip.xi_core_u_sense.__pex_xbuf_out1)=2.51 v(xchip.xi_core_u_sense.__pex_xbuf_mir)=2.51 v(xchip.xi_core_u_sense.__pex_xbuf_tail)=1.6 v(xchip.xi_core_u_sense.__pex_xbuf_fn)=0.2 v(xchip.xi_core_u_sense.__pex_xbuf_fp)=0.2 v(xchip.xi_core_u_sense.__pex_xref_out1)=2.51 v(xchip.xi_core_u_sense.__pex_xref_mir)=2.51 v(xchip.xi_core_u_sense.__pex_xref_tail)=1.6 v(xchip.xi_core_u_sense.__pex_xref_fn)=0.2 v(xchip.xi_core_u_sense.__pex_xref_fp)=0.2
.include /work/designs/g1-guardian/blocks/g1_sense/sim/postlayout/g1_sense_r100_partialc.spice
.include /work/designs/g1-guardian/blocks/g1_trip/sim/postlayout/g1_trip_nf4_pex.spice
.include /work/designs/g1-guardian/blocks/g1_gate/sim/postlayout/g1_gate_pex.spice
.include /work/designs/g1-guardian/blocks/g1_t2f/sim/postlayout/g1_t2f_pex.spice
* ---- supplies: one 3.3 V board rail feeds VDDA (pin 7) and IOVDD (pin 3), PLAN D14; 1.2 V VDD (pin 1)
V33 rail33 0 dc 3.3
Vma rail33 vdda_s dc 0
Vmi rail33 iovdd_s dc 0
Rsa vdda_s vdda 0.5
Cda vdda 0 1n
Rsi iovdd_s iovdd 0.5
Cdi iovdd 0 1n
V12 vdd_s 0 dc 1.2
Rsd vdd_s vdd 0.5
Cdd vdd 0 1n
* ---- board: load current profile (1 V = 1 A) x switch on the FET gate node, shunt, Kelvin traces, FET gate
Vprof iprof 0 pwl(0 1 1.6e-05 1 1.602e-05 1.8)
Bload 0 ldi I = v(iprof) * (0.5 + 0.5*tanh((v(gfet) - 1.5)/0.15))
Vim ldi shp dc 0
Rsh shp shn {RSH}
Rgnd shn 0 {RGND}
Rkp shp sense_p 1
Rkn shn sense_n 1
Rg gate gfet 10
Cgate gfet 0 5n
Cfault fault_n 0 20p
Ven en_pad 0 pwl(0 0 3.01431035636e-06 0 3.01521035636e-06 1.485 3.01541035636e-06 1.815 3.01631035636e-06 3.3)
Vsclk sclk_pad 0 pwl(0 0 4.07405957685e-06 0 4.1800344989e-06 0 4.1809344989e-06 1.485 4.1811344989e-06 1.815 4.1820344989e-06 3.3 4.28600942095e-06 3.3 4.28690942095e-06 1.815 4.28710942095e-06 1.485 4.28800942095e-06 0 4.391984343e-06 0 4.392884343e-06 1.485 4.393084343e-06 1.815 4.393984343e-06 3.3 4.49795926505e-06 3.3 4.49885926505e-06 1.815 4.49905926505e-06 1.485 4.49995926505e-06 0 4.6039341871e-06 0 4.6048341871e-06 1.485 4.6050341871e-06 1.815 4.6059341871e-06 3.3 4.70990910914e-06 3.3 4.71080910914e-06 1.815 4.71100910914e-06 1.485 4.71190910914e-06 0 4.81588403119e-06 0 4.81678403119e-06 1.485 4.81698403119e-06 1.815 4.81788403119e-06 3.3 4.92185895324e-06 3.3 4.92275895324e-06 1.815 4.92295895324e-06 1.485 4.92385895324e-06 0 5.02783387529e-06 0 5.02873387529e-06 1.485 5.02893387529e-06 1.815 5.02983387529e-06 3.3 5.13380879734e-06 3.3 5.13470879734e-06 1.815 5.13490879734e-06 1.485 5.13580879734e-06 0 5.23978371939e-06 0 5.24068371939e-06 1.485 5.24088371939e-06 1.815 5.24178371939e-06 3.3 5.34575864144e-06 3.3 5.34665864144e-06 1.815 5.34685864144e-06 1.485 5.34775864144e-06 0 5.45173356349e-06 0 5.45263356349e-06 1.485 5.45283356349e-06 1.815 5.45373356349e-06 3.3 5.55770848554e-06 3.3 5.55860848554e-06 1.815 5.55880848554e-06 1.485 5.55970848554e-06 0 5.66368340759e-06 0 5.66458340759e-06 1.485 5.66478340759e-06 1.815 5.66568340759e-06 3.3 5.76965832964e-06 3.3 5.77055832964e-06 1.815 5.77075832964e-06 1.485 5.77165832964e-06 0 5.87563325169e-06 0 5.87653325169e-06 1.485 5.87673325169e-06 1.815 5.87763325169e-06 3.3 5.98160817374e-06 3.3 5.98250817374e-06 1.815 5.98270817374e-06 1.485 5.98360817374e-06 0 6.08758309579e-06 0 6.08848309579e-06 1.485 6.08868309579e-06 1.815 6.08958309579e-06 3.3 6.19355801783e-06 3.3 6.19445801783e-06 1.815 6.19465801783e-06 1.485 6.19555801783e-06 0 6.29953293988e-06 0 6.30043293988e-06 1.485 6.30063293988e-06 1.815 6.30153293988e-06 3.3 6.40550786193e-06 3.3 6.40640786193e-06 1.815 6.40660786193e-06 1.485 6.40750786193e-06 0 6.51148278398e-06 0 6.51238278398e-06 1.485 6.51258278398e-06 1.815 6.51348278398e-06 3.3 6.61745770603e-06 3.3 6.61835770603e-06 1.815 6.61855770603e-06 1.485 6.61945770603e-06 0 6.72343262808e-06 0 6.72433262808e-06 1.485 6.72453262808e-06 1.815 6.72543262808e-06 3.3 6.82940755013e-06 3.3 6.83030755013e-06 1.815 6.83050755013e-06 1.485 6.83140755013e-06 0 6.93538247218e-06 0 6.93628247218e-06 1.485 6.93648247218e-06 1.815 6.93738247218e-06 3.3 7.04135739423e-06 3.3 7.04225739423e-06 1.815 7.04245739423e-06 1.485 7.04335739423e-06 0 7.14733231628e-06 0 7.14823231628e-06 1.485 7.14843231628e-06 1.815 7.14933231628e-06 3.3 7.25330723833e-06 3.3 7.25420723833e-06 1.815 7.25440723833e-06 1.485 7.25530723833e-06 0 7.35928216038e-06 0 7.36018216038e-06 1.485 7.36038216038e-06 1.815 7.36128216038e-06 3.3 7.46525708243e-06 3.3 7.46615708243e-06 1.815 7.46635708243e-06 1.485 7.46725708243e-06 0 7.57123200448e-06 0 7.57213200448e-06 1.485 7.57233200448e-06 1.815 7.57323200448e-06 3.3 7.67720692653e-06 3.3 7.67810692653e-06 1.815 7.67830692653e-06 1.485 7.67920692653e-06 0 7.78318184857e-06 0 7.78408184857e-06 1.485 7.78428184857e-06 1.815 7.78518184857e-06 3.3 7.88915677062e-06 3.3 7.89005677062e-06 1.815 7.89025677062e-06 1.485 7.89115677062e-06 0 7.99513169267e-06 0 7.99603169267e-06 1.485 7.99623169267e-06 1.815 7.99713169267e-06 3.3 8.10110661472e-06 3.3 8.10200661472e-06 1.815 8.10220661472e-06 1.485 8.10310661472e-06 0 8.20708153677e-06 0 8.20798153677e-06 1.485 8.20818153677e-06 1.815 8.20908153677e-06 3.3 8.31305645882e-06 3.3 8.31395645882e-06 1.815 8.31415645882e-06 1.485 8.31505645882e-06 0 8.41903138087e-06 0 8.41993138087e-06 1.485 8.42013138087e-06 1.815 8.42103138087e-06 3.3 8.52500630292e-06 3.3 8.52590630292e-06 1.815 8.52610630292e-06 1.485 8.52700630292e-06 0 8.63098122497e-06 0 8.63188122497e-06 1.485 8.63208122497e-06 1.815 8.63298122497e-06 3.3 8.73695614702e-06 3.3 8.73785614702e-06 1.815 8.73805614702e-06 1.485 8.73895614702e-06 0 8.84293106907e-06 0 8.84383106907e-06 1.485 8.84403106907e-06 1.815 8.84493106907e-06 3.3 8.94890599112e-06 3.3 8.94980599112e-06 1.815 8.95000599112e-06 1.485 8.95090599112e-06 0 9.05488091317e-06 0 9.05578091317e-06 1.485 9.05598091317e-06 1.815 9.05688091317e-06 3.3 9.16085583522e-06 3.3 9.16175583522e-06 1.815 9.16195583522e-06 1.485 9.16285583522e-06 0 9.26683075726e-06 0 9.26773075726e-06 1.485 9.26793075726e-06 1.815 9.26883075726e-06 3.3 9.37280567931e-06 3.3 9.37370567931e-06 1.815 9.37390567931e-06 1.485 9.37480567931e-06 0 9.47878060136e-06 0 9.47968060136e-06 1.485 9.47988060136e-06 1.815 9.48078060136e-06 3.3 9.58475552341e-06 3.3 9.58565552341e-06 1.815 9.58585552341e-06 1.485 9.58675552341e-06 0 9.69073044546e-06 0 9.69163044546e-06 1.485 9.69183044546e-06 1.815 9.69273044546e-06 3.3 9.79670536751e-06 3.3 9.79760536751e-06 1.815 9.79780536751e-06 1.485 9.79870536751e-06 0 9.90268028956e-06 0 9.90358028956e-06 1.485 9.90378028956e-06 1.815 9.90468028956e-06 3.3 1.00086552116e-05 3.3 1.00095552116e-05 1.815 1.00097552116e-05 1.485 1.00106552116e-05 0 1.01146301337e-05 0 1.01155301337e-05 1.485 1.01157301337e-05 1.815 1.01166301337e-05 3.3 1.02206050557e-05 3.3 1.02215050557e-05 1.815 1.02217050557e-05 1.485 1.02226050557e-05 0 1.03265799778e-05 0 1.03274799778e-05 1.485 1.03276799778e-05 1.815 1.03285799778e-05 3.3 1.04325548998e-05 3.3 1.04334548998e-05 1.815 1.04336548998e-05 1.485 1.04345548998e-05 0 1.05385298219e-05 0 1.05394298219e-05 1.485 1.05396298219e-05 1.815 1.05405298219e-05 3.3 1.06445047439e-05 3.3 1.06454047439e-05 1.815 1.06456047439e-05 1.485 1.06465047439e-05 0 1.0750479666e-05 0 1.0751379666e-05 1.485 1.0751579666e-05 1.815 1.0752479666e-05 3.3 1.0856454588e-05 3.3 1.0857354588e-05 1.815 1.0857554588e-05 1.485 1.0858454588e-05 0)
Vsdi sdi_pad 0 pwl(0 0 4.07405957685e-06 0 4.92185895324e-06 0 4.92275895324e-06 1.485 4.92295895324e-06 1.815 4.92385895324e-06 3.3 5.13380879734e-06 3.3 5.13470879734e-06 1.815 5.13490879734e-06 1.485 5.13580879734e-06 0 8.73695614702e-06 0 8.73785614702e-06 1.485 8.73805614702e-06 1.815 8.73895614702e-06 3.3 9.58475552341e-06 3.3 9.58565552341e-06 1.815 9.58585552341e-06 1.485 9.58675552341e-06 0 1.00086552116e-05 0 1.00095552116e-05 1.485 1.00097552116e-05 1.815 1.00106552116e-05 3.3 1.02206050557e-05 3.3 1.02215050557e-05 1.815 1.02217050557e-05 1.485 1.02226050557e-05 0)
.model adc adc_bridge(in_low=0.55 in_high=0.65 rise_delay=1e-12 fall_delay=1e-12)
.model adc_clock adc_bridge(in_low=0.6 in_high=0.6 rise_delay=1e-12 fall_delay=1e-12)
.model dac dac_bridge(out_low=0 out_high=1.2 out_undef=0.6 t_rise=0.3n t_fall=0.3n)
.model rtl d_cosim simulation="ivlng" sim_args=["/work/build/g1_top/cosim_3a7c9b80d2bf519fc3f864dd.vvp"]
* ---- the chip: g1_chip_top_1414.cdl, 22 pins on the board fixture
.subckt sg13g2_antennanp A VDD VSS
* removed (--pads nodcn): DD1 VSS A dantenna m=1 w=780n l=780n a=608.4f p=3.12u
XDD0 A VDD dpantenna m=1 w=1.05u l=1.34u
.ends sg13g2_antennanp
.subckt sg13g2_decap_8 VDD VSS
XMN0 VSS VDD VSS VSS sg13_lv_nmos m=1 w=840.00n l=1.000u ng=2
XMP0 VDD VSS VDD VDD sg13_lv_pmos m=1 w=2.000u l=1.000u ng=2
.ends sg13g2_decap_8
.subckt sg13g2_fill_2 VDD VSS
.ends sg13g2_fill_2
.subckt sg13g2_fill_1 VDD VSS
.ends sg13g2_fill_1
.subckt sg13g2_decap_4 VDD VSS
XMN0 VSS VDD VSS VSS sg13_lv_nmos m=1 w=420.00n l=1.000u ng=1
XMP0 VDD VSS VDD VDD sg13_lv_pmos m=1 w=1.000u l=1.000u ng=1
.ends sg13g2_decap_4
.subckt bondpad_70x70_tm1 pad
.ends bondpad_70x70_tm1
.subckt G1_VSS_DERIVATIVE__sg13g2_Corner vdd vss iovdd iovss G1_EXPLICIT_SUBSTRATE_VSS
XR_G1_TAP_SYNTAX_XR1 vss G1_EXPLICIT_SUBSTRATE_VSS ptap1 R=35.383
XR_G1_TAP_SYNTAX_XR0 iovss G1_EXPLICIT_SUBSTRATE_VSS ptap1 R=93.041m
.ends G1_VSS_DERIVATIVE__sg13g2_Corner
.subckt G1_VSS_DERIVATIVE__sg13g2_Filler4000 vdd vss iovdd iovss G1_EXPLICIT_SUBSTRATE_VSS
XR_G1_TAP_SYNTAX_XR1 vss G1_EXPLICIT_SUBSTRATE_VSS ptap1 R=63.078
XR_G1_TAP_SYNTAX_XR0 iovss G1_EXPLICIT_SUBSTRATE_VSS ptap1 R=625.742m
.ends G1_VSS_DERIVATIVE__sg13g2_Filler4000
.subckt G1_VSS_DERIVATIVE__sg13g2_Filler2000 vdd vss iovdd iovss G1_EXPLICIT_SUBSTRATE_VSS
XR_G1_TAP_SYNTAX_XR1 vss G1_EXPLICIT_SUBSTRATE_VSS ptap1 R=101.912
XR_G1_TAP_SYNTAX_XR0 iovss G1_EXPLICIT_SUBSTRATE_VSS ptap1 R=1.224
.ends G1_VSS_DERIVATIVE__sg13g2_Filler2000
.subckt G1_VSS_DERIVATIVE__sg13g2_Filler400 vdd vss iovdd iovss G1_EXPLICIT_SUBSTRATE_VSS
XR_G1_TAP_SYNTAX_XR1 vss G1_EXPLICIT_SUBSTRATE_VSS ptap1 R=246.192
XR_G1_TAP_SYNTAX_XR0 iovss G1_EXPLICIT_SUBSTRATE_VSS ptap1 R=6.246
.ends G1_VSS_DERIVATIVE__sg13g2_Filler400
.subckt g1_bgr vdd vss r4 vref iptat pbias pcasc vbe dvbe
XR1 vss n_23 vss rhigh w=0.5u l=49u b=0 m=1
XR2 n_12 det vss rhigh w=0.5u l=49u b=0 m=1
XR3 n_13 n_24 vss rhigh w=0.5u l=49u b=0 m=1
XR4 n_14 n_24 vss rhigh w=0.5u l=49u b=0 m=1
XR5 n_14 n_26 vss rhigh w=0.5u l=49u b=0 m=1
XR6 n_15 n_26 vss rhigh w=0.5u l=49u b=0 m=1
XR7 n_15 n_27 vss rhigh w=0.5u l=49u b=0 m=1
XR8 n_16 n_27 vss rhigh w=0.5u l=49u b=0 m=1
XR9 n_16 n_21 vss rhigh w=0.5u l=49u b=0 m=1
XR10 n_12 n_25 vss rhigh w=0.5u l=49u b=0 m=1
XR11 n_13 n_25 vss rhigh w=0.5u l=49u b=0 m=1
XR12 n_17 n_22 vss rhigh w=0.5u l=49u b=0 m=1
XR13 n_18 n_22 vss rhigh w=0.5u l=49u b=0 m=1
XR14 n_18 n_23 vss rhigh w=0.5u l=49u b=0 m=1
XR15 n_17 n_21 vss rhigh w=0.5u l=49u b=0 m=1
XR16 vss dvbe vss rppd w=1u l=51.5u b=0 m=1
XR17 n_7 vref vss rppd w=1u l=53.465u b=0 m=1
XR18 n_2 n_36 vss rppd w=1u l=53.465u b=0 m=1
XR19 n_7 n_36 vss rppd w=1u l=53.465u b=0 m=1
XR20 n_2 n_37 vss rppd w=1u l=53.465u b=0 m=1
XR21 n_8 n_37 vss rppd w=1u l=53.465u b=0 m=1
XR22 n_8 vbe3 vss rppd w=1u l=53.465u b=0 m=1
XR23 n_6 vb2 vss rppd w=1u l=48u b=0 m=1
XR24 n_9 vd1 vss rppd w=1u l=48u b=0 m=1
XR25 n_6 n_19 vss rppd w=1u l=48u b=0 m=1
XR26 n_9 n_19 vss rppd w=1u l=48u b=0 m=1
XM27 kick det vdd vdd sg13_hv_pmos l=0.5u w=2u as=0.68p ad=0.68p ps=4.68u pd=4.68u rfmode=0
XM28 r4n r4 vdd vdd sg13_hv_pmos l=0.5u w=2u as=0.68p ad=0.68p ps=4.68u pd=4.68u rfmode=0
XM29 vbe r4 b1b vss sg13_hv_nmos l=0.5u w=2u as=0.68p ad=0.68p ps=4.68u pd=4.68u rfmode=0
XM30 pbias kick vss vss sg13_hv_nmos l=4u w=1u as=0.34p ad=0.34p ps=2.68u pd=2.68u rfmode=0
XM31 kick det vss vss sg13_hv_nmos l=0.6u w=1u as=0.34p ad=0.34p ps=2.68u pd=2.68u rfmode=0
XM32 r4n r4 vss vss sg13_hv_nmos l=0.5u w=1u as=0.34p ad=0.34p ps=2.68u pd=2.68u rfmode=0
XM33 b1b r4n vss vss sg13_hv_nmos l=0.6u w=1u as=0.34p ad=0.34p ps=2.68u pd=2.68u rfmode=0
XM34 n1 vb2 vbe vss sg13_hv_nmos l=1u w=10u as=3.4p ad=3.4p ps=20.68u pd=20.68u rfmode=0
XM35 c2 vb2 pcasc vss sg13_hv_nmos l=1u w=10u as=3.4p ad=3.4p ps=20.68u pd=20.68u rfmode=0
XM36 vbe vb2 n1 vss sg13_hv_nmos l=1u w=10u as=3.4p ad=3.4p ps=20.68u pd=20.68u rfmode=0
XM37 pcasc vb2 c2 vss sg13_hv_nmos l=1u w=10u as=3.4p ad=3.4p ps=20.68u pd=20.68u rfmode=0
XM38 d1 pbias vdd vdd sg13_hv_pmos l=4u w=5u as=1.7p ad=1.7p ps=10.68u pd=10.68u rfmode=0
XM39 d2 pbias vdd vdd sg13_hv_pmos l=4u w=5u as=1.7p ad=1.7p ps=10.68u pd=10.68u rfmode=0
XM40 d4 pbias vdd vdd sg13_hv_pmos l=4u w=5u as=1.7p ad=1.7p ps=10.68u pd=10.68u rfmode=0
XM41 d5 pbias vdd vdd sg13_hv_pmos l=4u w=5u as=1.7p ad=1.7p ps=10.68u pd=10.68u rfmode=0
XM42 det pbias vdd vdd sg13_hv_pmos l=4u w=5u as=1.7p ad=1.7p ps=10.68u pd=10.68u rfmode=0
XM43 d3 pbias vdd vdd sg13_hv_pmos l=4u w=5u as=1.7p ad=1.7p ps=10.68u pd=10.68u rfmode=0
XM44 d3 pbias vdd vdd sg13_hv_pmos l=4u w=5u as=1.7p ad=1.7p ps=10.68u pd=10.68u rfmode=0
XM45 d5 pbias vdd vdd sg13_hv_pmos l=4u w=5u as=1.7p ad=1.7p ps=10.68u pd=10.68u rfmode=0
XM46 d4 pbias vdd vdd sg13_hv_pmos l=4u w=5u as=1.7p ad=1.7p ps=10.68u pd=10.68u rfmode=0
XM47 d2 pbias vdd vdd sg13_hv_pmos l=4u w=5u as=1.7p ad=1.7p ps=10.68u pd=10.68u rfmode=0
XM48 d1 pbias vdd vdd sg13_hv_pmos l=4u w=5u as=1.7p ad=1.7p ps=10.68u pd=10.68u rfmode=0
XM49 det pbias vdd vdd sg13_hv_pmos l=4u w=5u as=1.7p ad=1.7p ps=10.68u pd=10.68u rfmode=0
XM50 vb2 pcasc d5 d5 sg13_hv_pmos l=4u w=10u as=3.4p ad=3.4p ps=20.68u pd=20.68u rfmode=0
XM51 vref pcasc d3 d3 sg13_hv_pmos l=4u w=10u as=3.4p ad=3.4p ps=20.68u pd=20.68u rfmode=0
XM52 n1 pcasc d1 d1 sg13_hv_pmos l=4u w=10u as=3.4p ad=3.4p ps=20.68u pd=20.68u rfmode=0
XM53 iptat pcasc d4 d4 sg13_hv_pmos l=4u w=10u as=3.4p ad=3.4p ps=20.68u pd=20.68u rfmode=0
XM54 pbias pcasc d2 d2 sg13_hv_pmos l=4u w=10u as=3.4p ad=3.4p ps=20.68u pd=20.68u rfmode=0
XQ55 vss vss vss vss npn13G2 we=0.07u le=0.9u Nx=1 m=1
XQ56 vbe vbe vss vss npn13G2 we=0.07u le=0.9u Nx=1 m=1
XQ57 vss vss vss vss npn13G2 we=0.07u le=0.9u Nx=1 m=1
XQ58 vss vss vss vss npn13G2 we=0.07u le=0.9u Nx=1 m=1
XQ59 vss vss vss vss npn13G2 we=0.07u le=0.9u Nx=1 m=1
XQ60 vbe3 vbe3 vss vss npn13G2 we=0.07u le=0.9u Nx=1 m=1
XQ61 vss vss vss vss npn13G2 we=0.07u le=0.9u Nx=1 m=1
XQ62 vd2 vd2 vss vss npn13G2 we=0.07u le=0.9u Nx=1 m=1
XQ63 vss vss vss vss npn13G2 we=0.07u le=0.9u Nx=1 m=1
XQ64 vss vss vss vss npn13G2 we=0.07u le=0.9u Nx=1 m=1
XQ65 vss vss vss vss npn13G2 we=0.07u le=0.9u Nx=1 m=1
XQ66 vss vss vss vss npn13G2 we=0.07u le=0.9u Nx=1 m=1
XQ67 vbe b1b vss vss npn13G2 we=0.07u le=0.9u Nx=1 m=1
XQ68 c2 vbe dvbe vss npn13G2 we=0.07u le=0.9u Nx=1 m=1
XQ69 c2 vbe dvbe vss npn13G2 we=0.07u le=0.9u Nx=1 m=1
XQ70 c2 vbe dvbe vss npn13G2 we=0.07u le=0.9u Nx=1 m=1
XQ71 c2 vbe dvbe vss npn13G2 we=0.07u le=0.9u Nx=1 m=1
XQ72 c2 vbe dvbe vss npn13G2 we=0.07u le=0.9u Nx=1 m=1
XQ73 c2 vbe dvbe vss npn13G2 we=0.07u le=0.9u Nx=1 m=1
XQ74 c2 vbe dvbe vss npn13G2 we=0.07u le=0.9u Nx=1 m=1
XQ75 vd1 vd1 vd2 vss npn13G2 we=0.07u le=0.9u Nx=1 m=1
XQ76 c2 vbe dvbe vss npn13G2 we=0.07u le=0.9u Nx=1 m=1
XR77 n_4 pbias vss rppd w=1u l=50u b=0 m=1
XR78 n_11 n_34 vss rppd w=1u l=50u b=0 m=1
XR79 n_10 n_34 vss rppd w=1u l=50u b=0 m=1
XR80 n_3 n_31 vss rppd w=1u l=50u b=0 m=1
XR81 n_10 n_33 vss rppd w=1u l=50u b=0 m=1
XR82 n_5 n_31 vss rppd w=1u l=50u b=0 m=1
XR83 n_5 n_30 vss rppd w=1u l=50u b=0 m=1
XR84 n_4 n_30 vss rppd w=1u l=50u b=0 m=1
XR85 n_3 n_33 vss rppd w=1u l=50u b=0 m=1
XR86 n_11 pcasc vss rppd w=1u l=50u b=0 m=1
XR16_u2 vss dvbe vss rppd w=1u l=51.5u b=0 m=1
XR16_u3 vss dvbe vss rppd w=1u l=51.5u b=0 m=1
XR16_u4 vss dvbe vss rppd w=1u l=51.5u b=0 m=1
XR16_u5 vss dvbe vss rppd w=1u l=51.5u b=0 m=1
XR16_u6 vss dvbe vss rppd w=1u l=51.5u b=0 m=1
XR16_u7 vss dvbe vss rppd w=1u l=51.5u b=0 m=1
XR16_u8 vss dvbe vss rppd w=1u l=51.5u b=0 m=1
XR16_u9 vss dvbe vss rppd w=1u l=51.5u b=0 m=1
XR16_u10 vss dvbe vss rppd w=1u l=51.5u b=0 m=1
XR16_u11 vss dvbe vss rppd w=1u l=51.5u b=0 m=1
XR16_u12 vss dvbe vss rppd w=1u l=51.5u b=0 m=1
XR16_u13 vss dvbe vss rppd w=1u l=51.5u b=0 m=1
XR16_u14 vss dvbe vss rppd w=1u l=51.5u b=0 m=1
XR16_u15 vss dvbe vss rppd w=1u l=51.5u b=0 m=1
XR16_u16 vss dvbe vss rppd w=1u l=51.5u b=0 m=1
XR16_u17 vss dvbe vss rppd w=1u l=51.5u b=0 m=1
XR16_u18 vss dvbe vss rppd w=1u l=51.5u b=0 m=1
XR16_u19 vss dvbe vss rppd w=1u l=51.5u b=0 m=1
XR16_u20 vss dvbe vss rppd w=1u l=51.5u b=0 m=1
XR16_u21 vss dvbe vss rppd w=1u l=51.5u b=0 m=1
XR16_u22 vss dvbe vss rppd w=1u l=51.5u b=0 m=1
XR16_u23 vss dvbe vss rppd w=1u l=51.5u b=0 m=1
XR16_u24 vss dvbe vss rppd w=1u l=51.5u b=0 m=1
XR17_u2 n_7 vref vss rppd w=1u l=53.465u b=0 m=1
XR17_u3 n_7 vref vss rppd w=1u l=53.465u b=0 m=1
XR17_u4 n_7 vref vss rppd w=1u l=53.465u b=0 m=1
XR18_u2 n_2 n_36 vss rppd w=1u l=53.465u b=0 m=1
XR18_u3 n_2 n_36 vss rppd w=1u l=53.465u b=0 m=1
XR18_u4 n_2 n_36 vss rppd w=1u l=53.465u b=0 m=1
XR19_u2 n_7 n_36 vss rppd w=1u l=53.465u b=0 m=1
XR19_u3 n_7 n_36 vss rppd w=1u l=53.465u b=0 m=1
XR19_u4 n_7 n_36 vss rppd w=1u l=53.465u b=0 m=1
XR20_u2 n_2 n_37 vss rppd w=1u l=53.465u b=0 m=1
XR20_u3 n_2 n_37 vss rppd w=1u l=53.465u b=0 m=1
XR20_u4 n_2 n_37 vss rppd w=1u l=53.465u b=0 m=1
XR21_u2 n_8 n_37 vss rppd w=1u l=53.465u b=0 m=1
XR21_u3 n_8 n_37 vss rppd w=1u l=53.465u b=0 m=1
XR21_u4 n_8 n_37 vss rppd w=1u l=53.465u b=0 m=1
XR22_u2 n_8 vbe3 vss rppd w=1u l=53.465u b=0 m=1
XR22_u3 n_8 vbe3 vss rppd w=1u l=53.465u b=0 m=1
XR22_u4 n_8 vbe3 vss rppd w=1u l=53.465u b=0 m=1
XR23_u2 n_6 vb2 vss rppd w=1u l=48u b=0 m=1
XR23_u3 n_6 vb2 vss rppd w=1u l=48u b=0 m=1
XR23_u4 n_6 vb2 vss rppd w=1u l=48u b=0 m=1
XR23_u5 n_6 vb2 vss rppd w=1u l=48u b=0 m=1
XR23_u6 n_6 vb2 vss rppd w=1u l=48u b=0 m=1
XR23_u7 n_6 vb2 vss rppd w=1u l=48u b=0 m=1
XR23_u8 n_6 vb2 vss rppd w=1u l=48u b=0 m=1
XR23_u9 n_6 vb2 vss rppd w=1u l=48u b=0 m=1
XR23_u10 n_6 vb2 vss rppd w=1u l=48u b=0 m=1
XR23_u11 n_6 vb2 vss rppd w=1u l=48u b=0 m=1
XR23_u12 n_6 vb2 vss rppd w=1u l=48u b=0 m=1
XR23_u13 n_6 vb2 vss rppd w=1u l=48u b=0 m=1
XR23_u14 n_6 vb2 vss rppd w=1u l=48u b=0 m=1
XR23_u15 n_6 vb2 vss rppd w=1u l=48u b=0 m=1
XR23_u16 n_6 vb2 vss rppd w=1u l=48u b=0 m=1
XR23_u17 n_6 vb2 vss rppd w=1u l=48u b=0 m=1
XR23_u18 n_6 vb2 vss rppd w=1u l=48u b=0 m=1
XR23_u19 n_6 vb2 vss rppd w=1u l=48u b=0 m=1
XR23_u20 n_6 vb2 vss rppd w=1u l=48u b=0 m=1
XR23_u21 n_6 vb2 vss rppd w=1u l=48u b=0 m=1
XR23_u22 n_6 vb2 vss rppd w=1u l=48u b=0 m=1
XR23_u23 n_6 vb2 vss rppd w=1u l=48u b=0 m=1
XR23_u24 n_6 vb2 vss rppd w=1u l=48u b=0 m=1
XR24_u2 n_9 vd1 vss rppd w=1u l=48u b=0 m=1
XR24_u3 n_9 vd1 vss rppd w=1u l=48u b=0 m=1
XR24_u4 n_9 vd1 vss rppd w=1u l=48u b=0 m=1
XR24_u5 n_9 vd1 vss rppd w=1u l=48u b=0 m=1
XR24_u6 n_9 vd1 vss rppd w=1u l=48u b=0 m=1
XR24_u7 n_9 vd1 vss rppd w=1u l=48u b=0 m=1
XR24_u8 n_9 vd1 vss rppd w=1u l=48u b=0 m=1
XR24_u9 n_9 vd1 vss rppd w=1u l=48u b=0 m=1
XR24_u10 n_9 vd1 vss rppd w=1u l=48u b=0 m=1
XR24_u11 n_9 vd1 vss rppd w=1u l=48u b=0 m=1
XR24_u12 n_9 vd1 vss rppd w=1u l=48u b=0 m=1
XR24_u13 n_9 vd1 vss rppd w=1u l=48u b=0 m=1
XR24_u14 n_9 vd1 vss rppd w=1u l=48u b=0 m=1
XR24_u15 n_9 vd1 vss rppd w=1u l=48u b=0 m=1
XR24_u16 n_9 vd1 vss rppd w=1u l=48u b=0 m=1
XR24_u17 n_9 vd1 vss rppd w=1u l=48u b=0 m=1
XR24_u18 n_9 vd1 vss rppd w=1u l=48u b=0 m=1
XR24_u19 n_9 vd1 vss rppd w=1u l=48u b=0 m=1
XR24_u20 n_9 vd1 vss rppd w=1u l=48u b=0 m=1
XR24_u21 n_9 vd1 vss rppd w=1u l=48u b=0 m=1
XR24_u22 n_9 vd1 vss rppd w=1u l=48u b=0 m=1
XR24_u23 n_9 vd1 vss rppd w=1u l=48u b=0 m=1
XR24_u24 n_9 vd1 vss rppd w=1u l=48u b=0 m=1
XR25_u2 n_6 n_19 vss rppd w=1u l=48u b=0 m=1
XR25_u3 n_6 n_19 vss rppd w=1u l=48u b=0 m=1
XR25_u4 n_6 n_19 vss rppd w=1u l=48u b=0 m=1
XR25_u5 n_6 n_19 vss rppd w=1u l=48u b=0 m=1
XR25_u6 n_6 n_19 vss rppd w=1u l=48u b=0 m=1
XR25_u7 n_6 n_19 vss rppd w=1u l=48u b=0 m=1
XR25_u8 n_6 n_19 vss rppd w=1u l=48u b=0 m=1
XR25_u9 n_6 n_19 vss rppd w=1u l=48u b=0 m=1
XR25_u10 n_6 n_19 vss rppd w=1u l=48u b=0 m=1
XR25_u11 n_6 n_19 vss rppd w=1u l=48u b=0 m=1
XR25_u12 n_6 n_19 vss rppd w=1u l=48u b=0 m=1
XR25_u13 n_6 n_19 vss rppd w=1u l=48u b=0 m=1
XR25_u14 n_6 n_19 vss rppd w=1u l=48u b=0 m=1
XR25_u15 n_6 n_19 vss rppd w=1u l=48u b=0 m=1
XR25_u16 n_6 n_19 vss rppd w=1u l=48u b=0 m=1
XR25_u17 n_6 n_19 vss rppd w=1u l=48u b=0 m=1
XR25_u18 n_6 n_19 vss rppd w=1u l=48u b=0 m=1
XR25_u19 n_6 n_19 vss rppd w=1u l=48u b=0 m=1
XR25_u20 n_6 n_19 vss rppd w=1u l=48u b=0 m=1
XR25_u21 n_6 n_19 vss rppd w=1u l=48u b=0 m=1
XR25_u22 n_6 n_19 vss rppd w=1u l=48u b=0 m=1
XR25_u23 n_6 n_19 vss rppd w=1u l=48u b=0 m=1
XR25_u24 n_6 n_19 vss rppd w=1u l=48u b=0 m=1
XR26_u2 n_9 n_19 vss rppd w=1u l=48u b=0 m=1
XR26_u3 n_9 n_19 vss rppd w=1u l=48u b=0 m=1
XR26_u4 n_9 n_19 vss rppd w=1u l=48u b=0 m=1
XR26_u5 n_9 n_19 vss rppd w=1u l=48u b=0 m=1
XR26_u6 n_9 n_19 vss rppd w=1u l=48u b=0 m=1
XR26_u7 n_9 n_19 vss rppd w=1u l=48u b=0 m=1
XR26_u8 n_9 n_19 vss rppd w=1u l=48u b=0 m=1
XR26_u9 n_9 n_19 vss rppd w=1u l=48u b=0 m=1
XR26_u10 n_9 n_19 vss rppd w=1u l=48u b=0 m=1
XR26_u11 n_9 n_19 vss rppd w=1u l=48u b=0 m=1
XR26_u12 n_9 n_19 vss rppd w=1u l=48u b=0 m=1
XR26_u13 n_9 n_19 vss rppd w=1u l=48u b=0 m=1
XR26_u14 n_9 n_19 vss rppd w=1u l=48u b=0 m=1
XR26_u15 n_9 n_19 vss rppd w=1u l=48u b=0 m=1
XR26_u16 n_9 n_19 vss rppd w=1u l=48u b=0 m=1
XR26_u17 n_9 n_19 vss rppd w=1u l=48u b=0 m=1
XR26_u18 n_9 n_19 vss rppd w=1u l=48u b=0 m=1
XR26_u19 n_9 n_19 vss rppd w=1u l=48u b=0 m=1
XR26_u20 n_9 n_19 vss rppd w=1u l=48u b=0 m=1
XR26_u21 n_9 n_19 vss rppd w=1u l=48u b=0 m=1
XR26_u22 n_9 n_19 vss rppd w=1u l=48u b=0 m=1
XR26_u23 n_9 n_19 vss rppd w=1u l=48u b=0 m=1
XR26_u24 n_9 n_19 vss rppd w=1u l=48u b=0 m=1
XM34_u2 n1 vb2 vbe vss sg13_hv_nmos l=1u w=10u as=3.4p ad=3.4p ps=20.68u pd=20.68u rfmode=0
XM34_u3 n1 vb2 vbe vss sg13_hv_nmos l=1u w=10u as=3.4p ad=3.4p ps=20.68u pd=20.68u rfmode=0
XM34_u4 n1 vb2 vbe vss sg13_hv_nmos l=1u w=10u as=3.4p ad=3.4p ps=20.68u pd=20.68u rfmode=0
XM34_u5 n1 vb2 vbe vss sg13_hv_nmos l=1u w=10u as=3.4p ad=3.4p ps=20.68u pd=20.68u rfmode=0
XM34_u6 n1 vb2 vbe vss sg13_hv_nmos l=1u w=10u as=3.4p ad=3.4p ps=20.68u pd=20.68u rfmode=0
XM34_u7 n1 vb2 vbe vss sg13_hv_nmos l=1u w=10u as=3.4p ad=3.4p ps=20.68u pd=20.68u rfmode=0
XM34_u8 n1 vb2 vbe vss sg13_hv_nmos l=1u w=10u as=3.4p ad=3.4p ps=20.68u pd=20.68u rfmode=0
XM34_u9 n1 vb2 vbe vss sg13_hv_nmos l=1u w=10u as=3.4p ad=3.4p ps=20.68u pd=20.68u rfmode=0
XM34_u10 n1 vb2 vbe vss sg13_hv_nmos l=1u w=10u as=3.4p ad=3.4p ps=20.68u pd=20.68u rfmode=0
XM34_u11 n1 vb2 vbe vss sg13_hv_nmos l=1u w=10u as=3.4p ad=3.4p ps=20.68u pd=20.68u rfmode=0
XM34_u12 n1 vb2 vbe vss sg13_hv_nmos l=1u w=10u as=3.4p ad=3.4p ps=20.68u pd=20.68u rfmode=0
XM34_u13 n1 vb2 vbe vss sg13_hv_nmos l=1u w=10u as=3.4p ad=3.4p ps=20.68u pd=20.68u rfmode=0
XM34_u14 n1 vb2 vbe vss sg13_hv_nmos l=1u w=10u as=3.4p ad=3.4p ps=20.68u pd=20.68u rfmode=0
XM34_u15 n1 vb2 vbe vss sg13_hv_nmos l=1u w=10u as=3.4p ad=3.4p ps=20.68u pd=20.68u rfmode=0
XM34_u16 n1 vb2 vbe vss sg13_hv_nmos l=1u w=10u as=3.4p ad=3.4p ps=20.68u pd=20.68u rfmode=0
XM34_u17 n1 vb2 vbe vss sg13_hv_nmos l=1u w=10u as=3.4p ad=3.4p ps=20.68u pd=20.68u rfmode=0
XM34_u18 n1 vb2 vbe vss sg13_hv_nmos l=1u w=10u as=3.4p ad=3.4p ps=20.68u pd=20.68u rfmode=0
XM34_u19 n1 vb2 vbe vss sg13_hv_nmos l=1u w=10u as=3.4p ad=3.4p ps=20.68u pd=20.68u rfmode=0
XM34_u20 n1 vb2 vbe vss sg13_hv_nmos l=1u w=10u as=3.4p ad=3.4p ps=20.68u pd=20.68u rfmode=0
XM34_u21 n1 vb2 vbe vss sg13_hv_nmos l=1u w=10u as=3.4p ad=3.4p ps=20.68u pd=20.68u rfmode=0
XM34_u22 n1 vb2 vbe vss sg13_hv_nmos l=1u w=10u as=3.4p ad=3.4p ps=20.68u pd=20.68u rfmode=0
XM34_u23 n1 vb2 vbe vss sg13_hv_nmos l=1u w=10u as=3.4p ad=3.4p ps=20.68u pd=20.68u rfmode=0
XM34_u24 n1 vb2 vbe vss sg13_hv_nmos l=1u w=10u as=3.4p ad=3.4p ps=20.68u pd=20.68u rfmode=0
XM35_u2 c2 vb2 pcasc vss sg13_hv_nmos l=1u w=10u as=3.4p ad=3.4p ps=20.68u pd=20.68u rfmode=0
XM35_u3 c2 vb2 pcasc vss sg13_hv_nmos l=1u w=10u as=3.4p ad=3.4p ps=20.68u pd=20.68u rfmode=0
XM35_u4 c2 vb2 pcasc vss sg13_hv_nmos l=1u w=10u as=3.4p ad=3.4p ps=20.68u pd=20.68u rfmode=0
XM35_u5 c2 vb2 pcasc vss sg13_hv_nmos l=1u w=10u as=3.4p ad=3.4p ps=20.68u pd=20.68u rfmode=0
XM35_u6 c2 vb2 pcasc vss sg13_hv_nmos l=1u w=10u as=3.4p ad=3.4p ps=20.68u pd=20.68u rfmode=0
XM35_u7 c2 vb2 pcasc vss sg13_hv_nmos l=1u w=10u as=3.4p ad=3.4p ps=20.68u pd=20.68u rfmode=0
XM35_u8 c2 vb2 pcasc vss sg13_hv_nmos l=1u w=10u as=3.4p ad=3.4p ps=20.68u pd=20.68u rfmode=0
XM35_u9 c2 vb2 pcasc vss sg13_hv_nmos l=1u w=10u as=3.4p ad=3.4p ps=20.68u pd=20.68u rfmode=0
XM35_u10 c2 vb2 pcasc vss sg13_hv_nmos l=1u w=10u as=3.4p ad=3.4p ps=20.68u pd=20.68u rfmode=0
XM35_u11 c2 vb2 pcasc vss sg13_hv_nmos l=1u w=10u as=3.4p ad=3.4p ps=20.68u pd=20.68u rfmode=0
XM35_u12 c2 vb2 pcasc vss sg13_hv_nmos l=1u w=10u as=3.4p ad=3.4p ps=20.68u pd=20.68u rfmode=0
XM35_u13 c2 vb2 pcasc vss sg13_hv_nmos l=1u w=10u as=3.4p ad=3.4p ps=20.68u pd=20.68u rfmode=0
XM35_u14 c2 vb2 pcasc vss sg13_hv_nmos l=1u w=10u as=3.4p ad=3.4p ps=20.68u pd=20.68u rfmode=0
XM35_u15 c2 vb2 pcasc vss sg13_hv_nmos l=1u w=10u as=3.4p ad=3.4p ps=20.68u pd=20.68u rfmode=0
XM35_u16 c2 vb2 pcasc vss sg13_hv_nmos l=1u w=10u as=3.4p ad=3.4p ps=20.68u pd=20.68u rfmode=0
XM35_u17 c2 vb2 pcasc vss sg13_hv_nmos l=1u w=10u as=3.4p ad=3.4p ps=20.68u pd=20.68u rfmode=0
XM35_u18 c2 vb2 pcasc vss sg13_hv_nmos l=1u w=10u as=3.4p ad=3.4p ps=20.68u pd=20.68u rfmode=0
XM35_u19 c2 vb2 pcasc vss sg13_hv_nmos l=1u w=10u as=3.4p ad=3.4p ps=20.68u pd=20.68u rfmode=0
XM35_u20 c2 vb2 pcasc vss sg13_hv_nmos l=1u w=10u as=3.4p ad=3.4p ps=20.68u pd=20.68u rfmode=0
XM35_u21 c2 vb2 pcasc vss sg13_hv_nmos l=1u w=10u as=3.4p ad=3.4p ps=20.68u pd=20.68u rfmode=0
XM35_u22 c2 vb2 pcasc vss sg13_hv_nmos l=1u w=10u as=3.4p ad=3.4p ps=20.68u pd=20.68u rfmode=0
XM35_u23 c2 vb2 pcasc vss sg13_hv_nmos l=1u w=10u as=3.4p ad=3.4p ps=20.68u pd=20.68u rfmode=0
XM35_u24 c2 vb2 pcasc vss sg13_hv_nmos l=1u w=10u as=3.4p ad=3.4p ps=20.68u pd=20.68u rfmode=0
XM36_u2 vbe vb2 n1 vss sg13_hv_nmos l=1u w=10u as=3.4p ad=3.4p ps=20.68u pd=20.68u rfmode=0
XM36_u3 vbe vb2 n1 vss sg13_hv_nmos l=1u w=10u as=3.4p ad=3.4p ps=20.68u pd=20.68u rfmode=0
XM36_u4 vbe vb2 n1 vss sg13_hv_nmos l=1u w=10u as=3.4p ad=3.4p ps=20.68u pd=20.68u rfmode=0
XM36_u5 vbe vb2 n1 vss sg13_hv_nmos l=1u w=10u as=3.4p ad=3.4p ps=20.68u pd=20.68u rfmode=0
XM36_u6 vbe vb2 n1 vss sg13_hv_nmos l=1u w=10u as=3.4p ad=3.4p ps=20.68u pd=20.68u rfmode=0
XM36_u7 vbe vb2 n1 vss sg13_hv_nmos l=1u w=10u as=3.4p ad=3.4p ps=20.68u pd=20.68u rfmode=0
XM36_u8 vbe vb2 n1 vss sg13_hv_nmos l=1u w=10u as=3.4p ad=3.4p ps=20.68u pd=20.68u rfmode=0
XM36_u9 vbe vb2 n1 vss sg13_hv_nmos l=1u w=10u as=3.4p ad=3.4p ps=20.68u pd=20.68u rfmode=0
XM36_u10 vbe vb2 n1 vss sg13_hv_nmos l=1u w=10u as=3.4p ad=3.4p ps=20.68u pd=20.68u rfmode=0
XM36_u11 vbe vb2 n1 vss sg13_hv_nmos l=1u w=10u as=3.4p ad=3.4p ps=20.68u pd=20.68u rfmode=0
XM36_u12 vbe vb2 n1 vss sg13_hv_nmos l=1u w=10u as=3.4p ad=3.4p ps=20.68u pd=20.68u rfmode=0
XM36_u13 vbe vb2 n1 vss sg13_hv_nmos l=1u w=10u as=3.4p ad=3.4p ps=20.68u pd=20.68u rfmode=0
XM36_u14 vbe vb2 n1 vss sg13_hv_nmos l=1u w=10u as=3.4p ad=3.4p ps=20.68u pd=20.68u rfmode=0
XM36_u15 vbe vb2 n1 vss sg13_hv_nmos l=1u w=10u as=3.4p ad=3.4p ps=20.68u pd=20.68u rfmode=0
XM36_u16 vbe vb2 n1 vss sg13_hv_nmos l=1u w=10u as=3.4p ad=3.4p ps=20.68u pd=20.68u rfmode=0
XM36_u17 vbe vb2 n1 vss sg13_hv_nmos l=1u w=10u as=3.4p ad=3.4p ps=20.68u pd=20.68u rfmode=0
XM36_u18 vbe vb2 n1 vss sg13_hv_nmos l=1u w=10u as=3.4p ad=3.4p ps=20.68u pd=20.68u rfmode=0
XM36_u19 vbe vb2 n1 vss sg13_hv_nmos l=1u w=10u as=3.4p ad=3.4p ps=20.68u pd=20.68u rfmode=0
XM36_u20 vbe vb2 n1 vss sg13_hv_nmos l=1u w=10u as=3.4p ad=3.4p ps=20.68u pd=20.68u rfmode=0
XM36_u21 vbe vb2 n1 vss sg13_hv_nmos l=1u w=10u as=3.4p ad=3.4p ps=20.68u pd=20.68u rfmode=0
XM36_u22 vbe vb2 n1 vss sg13_hv_nmos l=1u w=10u as=3.4p ad=3.4p ps=20.68u pd=20.68u rfmode=0
XM36_u23 vbe vb2 n1 vss sg13_hv_nmos l=1u w=10u as=3.4p ad=3.4p ps=20.68u pd=20.68u rfmode=0
XM36_u24 vbe vb2 n1 vss sg13_hv_nmos l=1u w=10u as=3.4p ad=3.4p ps=20.68u pd=20.68u rfmode=0
XM37_u2 pcasc vb2 c2 vss sg13_hv_nmos l=1u w=10u as=3.4p ad=3.4p ps=20.68u pd=20.68u rfmode=0
XM37_u3 pcasc vb2 c2 vss sg13_hv_nmos l=1u w=10u as=3.4p ad=3.4p ps=20.68u pd=20.68u rfmode=0
XM37_u4 pcasc vb2 c2 vss sg13_hv_nmos l=1u w=10u as=3.4p ad=3.4p ps=20.68u pd=20.68u rfmode=0
XM37_u5 pcasc vb2 c2 vss sg13_hv_nmos l=1u w=10u as=3.4p ad=3.4p ps=20.68u pd=20.68u rfmode=0
XM37_u6 pcasc vb2 c2 vss sg13_hv_nmos l=1u w=10u as=3.4p ad=3.4p ps=20.68u pd=20.68u rfmode=0
XM37_u7 pcasc vb2 c2 vss sg13_hv_nmos l=1u w=10u as=3.4p ad=3.4p ps=20.68u pd=20.68u rfmode=0
XM37_u8 pcasc vb2 c2 vss sg13_hv_nmos l=1u w=10u as=3.4p ad=3.4p ps=20.68u pd=20.68u rfmode=0
XM37_u9 pcasc vb2 c2 vss sg13_hv_nmos l=1u w=10u as=3.4p ad=3.4p ps=20.68u pd=20.68u rfmode=0
XM37_u10 pcasc vb2 c2 vss sg13_hv_nmos l=1u w=10u as=3.4p ad=3.4p ps=20.68u pd=20.68u rfmode=0
XM37_u11 pcasc vb2 c2 vss sg13_hv_nmos l=1u w=10u as=3.4p ad=3.4p ps=20.68u pd=20.68u rfmode=0
XM37_u12 pcasc vb2 c2 vss sg13_hv_nmos l=1u w=10u as=3.4p ad=3.4p ps=20.68u pd=20.68u rfmode=0
XM37_u13 pcasc vb2 c2 vss sg13_hv_nmos l=1u w=10u as=3.4p ad=3.4p ps=20.68u pd=20.68u rfmode=0
XM37_u14 pcasc vb2 c2 vss sg13_hv_nmos l=1u w=10u as=3.4p ad=3.4p ps=20.68u pd=20.68u rfmode=0
XM37_u15 pcasc vb2 c2 vss sg13_hv_nmos l=1u w=10u as=3.4p ad=3.4p ps=20.68u pd=20.68u rfmode=0
XM37_u16 pcasc vb2 c2 vss sg13_hv_nmos l=1u w=10u as=3.4p ad=3.4p ps=20.68u pd=20.68u rfmode=0
XM37_u17 pcasc vb2 c2 vss sg13_hv_nmos l=1u w=10u as=3.4p ad=3.4p ps=20.68u pd=20.68u rfmode=0
XM37_u18 pcasc vb2 c2 vss sg13_hv_nmos l=1u w=10u as=3.4p ad=3.4p ps=20.68u pd=20.68u rfmode=0
XM37_u19 pcasc vb2 c2 vss sg13_hv_nmos l=1u w=10u as=3.4p ad=3.4p ps=20.68u pd=20.68u rfmode=0
XM37_u20 pcasc vb2 c2 vss sg13_hv_nmos l=1u w=10u as=3.4p ad=3.4p ps=20.68u pd=20.68u rfmode=0
XM37_u21 pcasc vb2 c2 vss sg13_hv_nmos l=1u w=10u as=3.4p ad=3.4p ps=20.68u pd=20.68u rfmode=0
XM37_u22 pcasc vb2 c2 vss sg13_hv_nmos l=1u w=10u as=3.4p ad=3.4p ps=20.68u pd=20.68u rfmode=0
XM37_u23 pcasc vb2 c2 vss sg13_hv_nmos l=1u w=10u as=3.4p ad=3.4p ps=20.68u pd=20.68u rfmode=0
XM37_u24 pcasc vb2 c2 vss sg13_hv_nmos l=1u w=10u as=3.4p ad=3.4p ps=20.68u pd=20.68u rfmode=0
XM38_u2 d1 pbias vdd vdd sg13_hv_pmos l=4u w=5u as=1.7p ad=1.7p ps=10.68u pd=10.68u rfmode=0
XM38_u3 d1 pbias vdd vdd sg13_hv_pmos l=4u w=5u as=1.7p ad=1.7p ps=10.68u pd=10.68u rfmode=0
XM38_u4 d1 pbias vdd vdd sg13_hv_pmos l=4u w=5u as=1.7p ad=1.7p ps=10.68u pd=10.68u rfmode=0
XM38_u5 d1 pbias vdd vdd sg13_hv_pmos l=4u w=5u as=1.7p ad=1.7p ps=10.68u pd=10.68u rfmode=0
XM38_u6 d1 pbias vdd vdd sg13_hv_pmos l=4u w=5u as=1.7p ad=1.7p ps=10.68u pd=10.68u rfmode=0
XM38_u7 d1 pbias vdd vdd sg13_hv_pmos l=4u w=5u as=1.7p ad=1.7p ps=10.68u pd=10.68u rfmode=0
XM38_u8 d1 pbias vdd vdd sg13_hv_pmos l=4u w=5u as=1.7p ad=1.7p ps=10.68u pd=10.68u rfmode=0
XM38_u9 d1 pbias vdd vdd sg13_hv_pmos l=4u w=5u as=1.7p ad=1.7p ps=10.68u pd=10.68u rfmode=0
XM38_u10 d1 pbias vdd vdd sg13_hv_pmos l=4u w=5u as=1.7p ad=1.7p ps=10.68u pd=10.68u rfmode=0
XM38_u11 d1 pbias vdd vdd sg13_hv_pmos l=4u w=5u as=1.7p ad=1.7p ps=10.68u pd=10.68u rfmode=0
XM38_u12 d1 pbias vdd vdd sg13_hv_pmos l=4u w=5u as=1.7p ad=1.7p ps=10.68u pd=10.68u rfmode=0
XM38_u13 d1 pbias vdd vdd sg13_hv_pmos l=4u w=5u as=1.7p ad=1.7p ps=10.68u pd=10.68u rfmode=0
XM38_u14 d1 pbias vdd vdd sg13_hv_pmos l=4u w=5u as=1.7p ad=1.7p ps=10.68u pd=10.68u rfmode=0
XM38_u15 d1 pbias vdd vdd sg13_hv_pmos l=4u w=5u as=1.7p ad=1.7p ps=10.68u pd=10.68u rfmode=0
XM38_u16 d1 pbias vdd vdd sg13_hv_pmos l=4u w=5u as=1.7p ad=1.7p ps=10.68u pd=10.68u rfmode=0
XM38_u17 d1 pbias vdd vdd sg13_hv_pmos l=4u w=5u as=1.7p ad=1.7p ps=10.68u pd=10.68u rfmode=0
XM38_u18 d1 pbias vdd vdd sg13_hv_pmos l=4u w=5u as=1.7p ad=1.7p ps=10.68u pd=10.68u rfmode=0
XM38_u19 d1 pbias vdd vdd sg13_hv_pmos l=4u w=5u as=1.7p ad=1.7p ps=10.68u pd=10.68u rfmode=0
XM38_u20 d1 pbias vdd vdd sg13_hv_pmos l=4u w=5u as=1.7p ad=1.7p ps=10.68u pd=10.68u rfmode=0
XM38_u21 d1 pbias vdd vdd sg13_hv_pmos l=4u w=5u as=1.7p ad=1.7p ps=10.68u pd=10.68u rfmode=0
XM38_u22 d1 pbias vdd vdd sg13_hv_pmos l=4u w=5u as=1.7p ad=1.7p ps=10.68u pd=10.68u rfmode=0
XM38_u23 d1 pbias vdd vdd sg13_hv_pmos l=4u w=5u as=1.7p ad=1.7p ps=10.68u pd=10.68u rfmode=0
XM38_u24 d1 pbias vdd vdd sg13_hv_pmos l=4u w=5u as=1.7p ad=1.7p ps=10.68u pd=10.68u rfmode=0
XM39_u2 d2 pbias vdd vdd sg13_hv_pmos l=4u w=5u as=1.7p ad=1.7p ps=10.68u pd=10.68u rfmode=0
XM39_u3 d2 pbias vdd vdd sg13_hv_pmos l=4u w=5u as=1.7p ad=1.7p ps=10.68u pd=10.68u rfmode=0
XM39_u4 d2 pbias vdd vdd sg13_hv_pmos l=4u w=5u as=1.7p ad=1.7p ps=10.68u pd=10.68u rfmode=0
XM39_u5 d2 pbias vdd vdd sg13_hv_pmos l=4u w=5u as=1.7p ad=1.7p ps=10.68u pd=10.68u rfmode=0
XM39_u6 d2 pbias vdd vdd sg13_hv_pmos l=4u w=5u as=1.7p ad=1.7p ps=10.68u pd=10.68u rfmode=0
XM39_u7 d2 pbias vdd vdd sg13_hv_pmos l=4u w=5u as=1.7p ad=1.7p ps=10.68u pd=10.68u rfmode=0
XM39_u8 d2 pbias vdd vdd sg13_hv_pmos l=4u w=5u as=1.7p ad=1.7p ps=10.68u pd=10.68u rfmode=0
XM39_u9 d2 pbias vdd vdd sg13_hv_pmos l=4u w=5u as=1.7p ad=1.7p ps=10.68u pd=10.68u rfmode=0
XM39_u10 d2 pbias vdd vdd sg13_hv_pmos l=4u w=5u as=1.7p ad=1.7p ps=10.68u pd=10.68u rfmode=0
XM39_u11 d2 pbias vdd vdd sg13_hv_pmos l=4u w=5u as=1.7p ad=1.7p ps=10.68u pd=10.68u rfmode=0
XM39_u12 d2 pbias vdd vdd sg13_hv_pmos l=4u w=5u as=1.7p ad=1.7p ps=10.68u pd=10.68u rfmode=0
XM39_u13 d2 pbias vdd vdd sg13_hv_pmos l=4u w=5u as=1.7p ad=1.7p ps=10.68u pd=10.68u rfmode=0
XM39_u14 d2 pbias vdd vdd sg13_hv_pmos l=4u w=5u as=1.7p ad=1.7p ps=10.68u pd=10.68u rfmode=0
XM39_u15 d2 pbias vdd vdd sg13_hv_pmos l=4u w=5u as=1.7p ad=1.7p ps=10.68u pd=10.68u rfmode=0
XM39_u16 d2 pbias vdd vdd sg13_hv_pmos l=4u w=5u as=1.7p ad=1.7p ps=10.68u pd=10.68u rfmode=0
XM39_u17 d2 pbias vdd vdd sg13_hv_pmos l=4u w=5u as=1.7p ad=1.7p ps=10.68u pd=10.68u rfmode=0
XM39_u18 d2 pbias vdd vdd sg13_hv_pmos l=4u w=5u as=1.7p ad=1.7p ps=10.68u pd=10.68u rfmode=0
XM39_u19 d2 pbias vdd vdd sg13_hv_pmos l=4u w=5u as=1.7p ad=1.7p ps=10.68u pd=10.68u rfmode=0
XM39_u20 d2 pbias vdd vdd sg13_hv_pmos l=4u w=5u as=1.7p ad=1.7p ps=10.68u pd=10.68u rfmode=0
XM39_u21 d2 pbias vdd vdd sg13_hv_pmos l=4u w=5u as=1.7p ad=1.7p ps=10.68u pd=10.68u rfmode=0
XM39_u22 d2 pbias vdd vdd sg13_hv_pmos l=4u w=5u as=1.7p ad=1.7p ps=10.68u pd=10.68u rfmode=0
XM39_u23 d2 pbias vdd vdd sg13_hv_pmos l=4u w=5u as=1.7p ad=1.7p ps=10.68u pd=10.68u rfmode=0
XM39_u24 d2 pbias vdd vdd sg13_hv_pmos l=4u w=5u as=1.7p ad=1.7p ps=10.68u pd=10.68u rfmode=0
XM41_u2 d5 pbias vdd vdd sg13_hv_pmos l=4u w=5u as=1.7p ad=1.7p ps=10.68u pd=10.68u rfmode=0
XM41_u3 d5 pbias vdd vdd sg13_hv_pmos l=4u w=5u as=1.7p ad=1.7p ps=10.68u pd=10.68u rfmode=0
XM41_u4 d5 pbias vdd vdd sg13_hv_pmos l=4u w=5u as=1.7p ad=1.7p ps=10.68u pd=10.68u rfmode=0
XM41_u5 d5 pbias vdd vdd sg13_hv_pmos l=4u w=5u as=1.7p ad=1.7p ps=10.68u pd=10.68u rfmode=0
XM41_u6 d5 pbias vdd vdd sg13_hv_pmos l=4u w=5u as=1.7p ad=1.7p ps=10.68u pd=10.68u rfmode=0
XM41_u7 d5 pbias vdd vdd sg13_hv_pmos l=4u w=5u as=1.7p ad=1.7p ps=10.68u pd=10.68u rfmode=0
XM41_u8 d5 pbias vdd vdd sg13_hv_pmos l=4u w=5u as=1.7p ad=1.7p ps=10.68u pd=10.68u rfmode=0
XM41_u9 d5 pbias vdd vdd sg13_hv_pmos l=4u w=5u as=1.7p ad=1.7p ps=10.68u pd=10.68u rfmode=0
XM41_u10 d5 pbias vdd vdd sg13_hv_pmos l=4u w=5u as=1.7p ad=1.7p ps=10.68u pd=10.68u rfmode=0
XM41_u11 d5 pbias vdd vdd sg13_hv_pmos l=4u w=5u as=1.7p ad=1.7p ps=10.68u pd=10.68u rfmode=0
XM41_u12 d5 pbias vdd vdd sg13_hv_pmos l=4u w=5u as=1.7p ad=1.7p ps=10.68u pd=10.68u rfmode=0
XM41_u13 d5 pbias vdd vdd sg13_hv_pmos l=4u w=5u as=1.7p ad=1.7p ps=10.68u pd=10.68u rfmode=0
XM41_u14 d5 pbias vdd vdd sg13_hv_pmos l=4u w=5u as=1.7p ad=1.7p ps=10.68u pd=10.68u rfmode=0
XM41_u15 d5 pbias vdd vdd sg13_hv_pmos l=4u w=5u as=1.7p ad=1.7p ps=10.68u pd=10.68u rfmode=0
XM41_u16 d5 pbias vdd vdd sg13_hv_pmos l=4u w=5u as=1.7p ad=1.7p ps=10.68u pd=10.68u rfmode=0
XM41_u17 d5 pbias vdd vdd sg13_hv_pmos l=4u w=5u as=1.7p ad=1.7p ps=10.68u pd=10.68u rfmode=0
XM41_u18 d5 pbias vdd vdd sg13_hv_pmos l=4u w=5u as=1.7p ad=1.7p ps=10.68u pd=10.68u rfmode=0
XM41_u19 d5 pbias vdd vdd sg13_hv_pmos l=4u w=5u as=1.7p ad=1.7p ps=10.68u pd=10.68u rfmode=0
XM41_u20 d5 pbias vdd vdd sg13_hv_pmos l=4u w=5u as=1.7p ad=1.7p ps=10.68u pd=10.68u rfmode=0
XM41_u21 d5 pbias vdd vdd sg13_hv_pmos l=4u w=5u as=1.7p ad=1.7p ps=10.68u pd=10.68u rfmode=0
XM41_u22 d5 pbias vdd vdd sg13_hv_pmos l=4u w=5u as=1.7p ad=1.7p ps=10.68u pd=10.68u rfmode=0
XM41_u23 d5 pbias vdd vdd sg13_hv_pmos l=4u w=5u as=1.7p ad=1.7p ps=10.68u pd=10.68u rfmode=0
XM41_u24 d5 pbias vdd vdd sg13_hv_pmos l=4u w=5u as=1.7p ad=1.7p ps=10.68u pd=10.68u rfmode=0
XM43_u2 d3 pbias vdd vdd sg13_hv_pmos l=4u w=5u as=1.7p ad=1.7p ps=10.68u pd=10.68u rfmode=0
XM43_u3 d3 pbias vdd vdd sg13_hv_pmos l=4u w=5u as=1.7p ad=1.7p ps=10.68u pd=10.68u rfmode=0
XM43_u4 d3 pbias vdd vdd sg13_hv_pmos l=4u w=5u as=1.7p ad=1.7p ps=10.68u pd=10.68u rfmode=0
XM44_u2 d3 pbias vdd vdd sg13_hv_pmos l=4u w=5u as=1.7p ad=1.7p ps=10.68u pd=10.68u rfmode=0
XM44_u3 d3 pbias vdd vdd sg13_hv_pmos l=4u w=5u as=1.7p ad=1.7p ps=10.68u pd=10.68u rfmode=0
XM44_u4 d3 pbias vdd vdd sg13_hv_pmos l=4u w=5u as=1.7p ad=1.7p ps=10.68u pd=10.68u rfmode=0
XM45_u2 d5 pbias vdd vdd sg13_hv_pmos l=4u w=5u as=1.7p ad=1.7p ps=10.68u pd=10.68u rfmode=0
XM45_u3 d5 pbias vdd vdd sg13_hv_pmos l=4u w=5u as=1.7p ad=1.7p ps=10.68u pd=10.68u rfmode=0
XM45_u4 d5 pbias vdd vdd sg13_hv_pmos l=4u w=5u as=1.7p ad=1.7p ps=10.68u pd=10.68u rfmode=0
XM45_u5 d5 pbias vdd vdd sg13_hv_pmos l=4u w=5u as=1.7p ad=1.7p ps=10.68u pd=10.68u rfmode=0
XM45_u6 d5 pbias vdd vdd sg13_hv_pmos l=4u w=5u as=1.7p ad=1.7p ps=10.68u pd=10.68u rfmode=0
XM45_u7 d5 pbias vdd vdd sg13_hv_pmos l=4u w=5u as=1.7p ad=1.7p ps=10.68u pd=10.68u rfmode=0
XM45_u8 d5 pbias vdd vdd sg13_hv_pmos l=4u w=5u as=1.7p ad=1.7p ps=10.68u pd=10.68u rfmode=0
XM45_u9 d5 pbias vdd vdd sg13_hv_pmos l=4u w=5u as=1.7p ad=1.7p ps=10.68u pd=10.68u rfmode=0
XM45_u10 d5 pbias vdd vdd sg13_hv_pmos l=4u w=5u as=1.7p ad=1.7p ps=10.68u pd=10.68u rfmode=0
XM45_u11 d5 pbias vdd vdd sg13_hv_pmos l=4u w=5u as=1.7p ad=1.7p ps=10.68u pd=10.68u rfmode=0
XM45_u12 d5 pbias vdd vdd sg13_hv_pmos l=4u w=5u as=1.7p ad=1.7p ps=10.68u pd=10.68u rfmode=0
XM45_u13 d5 pbias vdd vdd sg13_hv_pmos l=4u w=5u as=1.7p ad=1.7p ps=10.68u pd=10.68u rfmode=0
XM45_u14 d5 pbias vdd vdd sg13_hv_pmos l=4u w=5u as=1.7p ad=1.7p ps=10.68u pd=10.68u rfmode=0
XM45_u15 d5 pbias vdd vdd sg13_hv_pmos l=4u w=5u as=1.7p ad=1.7p ps=10.68u pd=10.68u rfmode=0
XM45_u16 d5 pbias vdd vdd sg13_hv_pmos l=4u w=5u as=1.7p ad=1.7p ps=10.68u pd=10.68u rfmode=0
XM45_u17 d5 pbias vdd vdd sg13_hv_pmos l=4u w=5u as=1.7p ad=1.7p ps=10.68u pd=10.68u rfmode=0
XM45_u18 d5 pbias vdd vdd sg13_hv_pmos l=4u w=5u as=1.7p ad=1.7p ps=10.68u pd=10.68u rfmode=0
XM45_u19 d5 pbias vdd vdd sg13_hv_pmos l=4u w=5u as=1.7p ad=1.7p ps=10.68u pd=10.68u rfmode=0
XM45_u20 d5 pbias vdd vdd sg13_hv_pmos l=4u w=5u as=1.7p ad=1.7p ps=10.68u pd=10.68u rfmode=0
XM45_u21 d5 pbias vdd vdd sg13_hv_pmos l=4u w=5u as=1.7p ad=1.7p ps=10.68u pd=10.68u rfmode=0
XM45_u22 d5 pbias vdd vdd sg13_hv_pmos l=4u w=5u as=1.7p ad=1.7p ps=10.68u pd=10.68u rfmode=0
XM45_u23 d5 pbias vdd vdd sg13_hv_pmos l=4u w=5u as=1.7p ad=1.7p ps=10.68u pd=10.68u rfmode=0
XM45_u24 d5 pbias vdd vdd sg13_hv_pmos l=4u w=5u as=1.7p ad=1.7p ps=10.68u pd=10.68u rfmode=0
XM47_u2 d2 pbias vdd vdd sg13_hv_pmos l=4u w=5u as=1.7p ad=1.7p ps=10.68u pd=10.68u rfmode=0
XM47_u3 d2 pbias vdd vdd sg13_hv_pmos l=4u w=5u as=1.7p ad=1.7p ps=10.68u pd=10.68u rfmode=0
XM47_u4 d2 pbias vdd vdd sg13_hv_pmos l=4u w=5u as=1.7p ad=1.7p ps=10.68u pd=10.68u rfmode=0
XM47_u5 d2 pbias vdd vdd sg13_hv_pmos l=4u w=5u as=1.7p ad=1.7p ps=10.68u pd=10.68u rfmode=0
XM47_u6 d2 pbias vdd vdd sg13_hv_pmos l=4u w=5u as=1.7p ad=1.7p ps=10.68u pd=10.68u rfmode=0
XM47_u7 d2 pbias vdd vdd sg13_hv_pmos l=4u w=5u as=1.7p ad=1.7p ps=10.68u pd=10.68u rfmode=0
XM47_u8 d2 pbias vdd vdd sg13_hv_pmos l=4u w=5u as=1.7p ad=1.7p ps=10.68u pd=10.68u rfmode=0
XM47_u9 d2 pbias vdd vdd sg13_hv_pmos l=4u w=5u as=1.7p ad=1.7p ps=10.68u pd=10.68u rfmode=0
XM47_u10 d2 pbias vdd vdd sg13_hv_pmos l=4u w=5u as=1.7p ad=1.7p ps=10.68u pd=10.68u rfmode=0
XM47_u11 d2 pbias vdd vdd sg13_hv_pmos l=4u w=5u as=1.7p ad=1.7p ps=10.68u pd=10.68u rfmode=0
XM47_u12 d2 pbias vdd vdd sg13_hv_pmos l=4u w=5u as=1.7p ad=1.7p ps=10.68u pd=10.68u rfmode=0
XM47_u13 d2 pbias vdd vdd sg13_hv_pmos l=4u w=5u as=1.7p ad=1.7p ps=10.68u pd=10.68u rfmode=0
XM47_u14 d2 pbias vdd vdd sg13_hv_pmos l=4u w=5u as=1.7p ad=1.7p ps=10.68u pd=10.68u rfmode=0
XM47_u15 d2 pbias vdd vdd sg13_hv_pmos l=4u w=5u as=1.7p ad=1.7p ps=10.68u pd=10.68u rfmode=0
XM47_u16 d2 pbias vdd vdd sg13_hv_pmos l=4u w=5u as=1.7p ad=1.7p ps=10.68u pd=10.68u rfmode=0
XM47_u17 d2 pbias vdd vdd sg13_hv_pmos l=4u w=5u as=1.7p ad=1.7p ps=10.68u pd=10.68u rfmode=0
XM47_u18 d2 pbias vdd vdd sg13_hv_pmos l=4u w=5u as=1.7p ad=1.7p ps=10.68u pd=10.68u rfmode=0
XM47_u19 d2 pbias vdd vdd sg13_hv_pmos l=4u w=5u as=1.7p ad=1.7p ps=10.68u pd=10.68u rfmode=0
XM47_u20 d2 pbias vdd vdd sg13_hv_pmos l=4u w=5u as=1.7p ad=1.7p ps=10.68u pd=10.68u rfmode=0
XM47_u21 d2 pbias vdd vdd sg13_hv_pmos l=4u w=5u as=1.7p ad=1.7p ps=10.68u pd=10.68u rfmode=0
XM47_u22 d2 pbias vdd vdd sg13_hv_pmos l=4u w=5u as=1.7p ad=1.7p ps=10.68u pd=10.68u rfmode=0
XM47_u23 d2 pbias vdd vdd sg13_hv_pmos l=4u w=5u as=1.7p ad=1.7p ps=10.68u pd=10.68u rfmode=0
XM47_u24 d2 pbias vdd vdd sg13_hv_pmos l=4u w=5u as=1.7p ad=1.7p ps=10.68u pd=10.68u rfmode=0
XM48_u2 d1 pbias vdd vdd sg13_hv_pmos l=4u w=5u as=1.7p ad=1.7p ps=10.68u pd=10.68u rfmode=0
XM48_u3 d1 pbias vdd vdd sg13_hv_pmos l=4u w=5u as=1.7p ad=1.7p ps=10.68u pd=10.68u rfmode=0
XM48_u4 d1 pbias vdd vdd sg13_hv_pmos l=4u w=5u as=1.7p ad=1.7p ps=10.68u pd=10.68u rfmode=0
XM48_u5 d1 pbias vdd vdd sg13_hv_pmos l=4u w=5u as=1.7p ad=1.7p ps=10.68u pd=10.68u rfmode=0
XM48_u6 d1 pbias vdd vdd sg13_hv_pmos l=4u w=5u as=1.7p ad=1.7p ps=10.68u pd=10.68u rfmode=0
XM48_u7 d1 pbias vdd vdd sg13_hv_pmos l=4u w=5u as=1.7p ad=1.7p ps=10.68u pd=10.68u rfmode=0
XM48_u8 d1 pbias vdd vdd sg13_hv_pmos l=4u w=5u as=1.7p ad=1.7p ps=10.68u pd=10.68u rfmode=0
XM48_u9 d1 pbias vdd vdd sg13_hv_pmos l=4u w=5u as=1.7p ad=1.7p ps=10.68u pd=10.68u rfmode=0
XM48_u10 d1 pbias vdd vdd sg13_hv_pmos l=4u w=5u as=1.7p ad=1.7p ps=10.68u pd=10.68u rfmode=0
XM48_u11 d1 pbias vdd vdd sg13_hv_pmos l=4u w=5u as=1.7p ad=1.7p ps=10.68u pd=10.68u rfmode=0
XM48_u12 d1 pbias vdd vdd sg13_hv_pmos l=4u w=5u as=1.7p ad=1.7p ps=10.68u pd=10.68u rfmode=0
XM48_u13 d1 pbias vdd vdd sg13_hv_pmos l=4u w=5u as=1.7p ad=1.7p ps=10.68u pd=10.68u rfmode=0
XM48_u14 d1 pbias vdd vdd sg13_hv_pmos l=4u w=5u as=1.7p ad=1.7p ps=10.68u pd=10.68u rfmode=0
XM48_u15 d1 pbias vdd vdd sg13_hv_pmos l=4u w=5u as=1.7p ad=1.7p ps=10.68u pd=10.68u rfmode=0
XM48_u16 d1 pbias vdd vdd sg13_hv_pmos l=4u w=5u as=1.7p ad=1.7p ps=10.68u pd=10.68u rfmode=0
XM48_u17 d1 pbias vdd vdd sg13_hv_pmos l=4u w=5u as=1.7p ad=1.7p ps=10.68u pd=10.68u rfmode=0
XM48_u18 d1 pbias vdd vdd sg13_hv_pmos l=4u w=5u as=1.7p ad=1.7p ps=10.68u pd=10.68u rfmode=0
XM48_u19 d1 pbias vdd vdd sg13_hv_pmos l=4u w=5u as=1.7p ad=1.7p ps=10.68u pd=10.68u rfmode=0
XM48_u20 d1 pbias vdd vdd sg13_hv_pmos l=4u w=5u as=1.7p ad=1.7p ps=10.68u pd=10.68u rfmode=0
XM48_u21 d1 pbias vdd vdd sg13_hv_pmos l=4u w=5u as=1.7p ad=1.7p ps=10.68u pd=10.68u rfmode=0
XM48_u22 d1 pbias vdd vdd sg13_hv_pmos l=4u w=5u as=1.7p ad=1.7p ps=10.68u pd=10.68u rfmode=0
XM48_u23 d1 pbias vdd vdd sg13_hv_pmos l=4u w=5u as=1.7p ad=1.7p ps=10.68u pd=10.68u rfmode=0
XM48_u24 d1 pbias vdd vdd sg13_hv_pmos l=4u w=5u as=1.7p ad=1.7p ps=10.68u pd=10.68u rfmode=0
XM50_u2 vb2 pcasc d5 d5 sg13_hv_pmos l=4u w=10u as=3.4p ad=3.4p ps=20.68u pd=20.68u rfmode=0
XM50_u3 vb2 pcasc d5 d5 sg13_hv_pmos l=4u w=10u as=3.4p ad=3.4p ps=20.68u pd=20.68u rfmode=0
XM50_u4 vb2 pcasc d5 d5 sg13_hv_pmos l=4u w=10u as=3.4p ad=3.4p ps=20.68u pd=20.68u rfmode=0
XM50_u5 vb2 pcasc d5 d5 sg13_hv_pmos l=4u w=10u as=3.4p ad=3.4p ps=20.68u pd=20.68u rfmode=0
XM50_u6 vb2 pcasc d5 d5 sg13_hv_pmos l=4u w=10u as=3.4p ad=3.4p ps=20.68u pd=20.68u rfmode=0
XM50_u7 vb2 pcasc d5 d5 sg13_hv_pmos l=4u w=10u as=3.4p ad=3.4p ps=20.68u pd=20.68u rfmode=0
XM50_u8 vb2 pcasc d5 d5 sg13_hv_pmos l=4u w=10u as=3.4p ad=3.4p ps=20.68u pd=20.68u rfmode=0
XM50_u9 vb2 pcasc d5 d5 sg13_hv_pmos l=4u w=10u as=3.4p ad=3.4p ps=20.68u pd=20.68u rfmode=0
XM50_u10 vb2 pcasc d5 d5 sg13_hv_pmos l=4u w=10u as=3.4p ad=3.4p ps=20.68u pd=20.68u rfmode=0
XM50_u11 vb2 pcasc d5 d5 sg13_hv_pmos l=4u w=10u as=3.4p ad=3.4p ps=20.68u pd=20.68u rfmode=0
XM50_u12 vb2 pcasc d5 d5 sg13_hv_pmos l=4u w=10u as=3.4p ad=3.4p ps=20.68u pd=20.68u rfmode=0
XM50_u13 vb2 pcasc d5 d5 sg13_hv_pmos l=4u w=10u as=3.4p ad=3.4p ps=20.68u pd=20.68u rfmode=0
XM50_u14 vb2 pcasc d5 d5 sg13_hv_pmos l=4u w=10u as=3.4p ad=3.4p ps=20.68u pd=20.68u rfmode=0
XM50_u15 vb2 pcasc d5 d5 sg13_hv_pmos l=4u w=10u as=3.4p ad=3.4p ps=20.68u pd=20.68u rfmode=0
XM50_u16 vb2 pcasc d5 d5 sg13_hv_pmos l=4u w=10u as=3.4p ad=3.4p ps=20.68u pd=20.68u rfmode=0
XM50_u17 vb2 pcasc d5 d5 sg13_hv_pmos l=4u w=10u as=3.4p ad=3.4p ps=20.68u pd=20.68u rfmode=0
XM50_u18 vb2 pcasc d5 d5 sg13_hv_pmos l=4u w=10u as=3.4p ad=3.4p ps=20.68u pd=20.68u rfmode=0
XM50_u19 vb2 pcasc d5 d5 sg13_hv_pmos l=4u w=10u as=3.4p ad=3.4p ps=20.68u pd=20.68u rfmode=0
XM50_u20 vb2 pcasc d5 d5 sg13_hv_pmos l=4u w=10u as=3.4p ad=3.4p ps=20.68u pd=20.68u rfmode=0
XM50_u21 vb2 pcasc d5 d5 sg13_hv_pmos l=4u w=10u as=3.4p ad=3.4p ps=20.68u pd=20.68u rfmode=0
XM50_u22 vb2 pcasc d5 d5 sg13_hv_pmos l=4u w=10u as=3.4p ad=3.4p ps=20.68u pd=20.68u rfmode=0
XM50_u23 vb2 pcasc d5 d5 sg13_hv_pmos l=4u w=10u as=3.4p ad=3.4p ps=20.68u pd=20.68u rfmode=0
XM50_u24 vb2 pcasc d5 d5 sg13_hv_pmos l=4u w=10u as=3.4p ad=3.4p ps=20.68u pd=20.68u rfmode=0
XM51_u2 vref pcasc d3 d3 sg13_hv_pmos l=4u w=10u as=3.4p ad=3.4p ps=20.68u pd=20.68u rfmode=0
XM51_u3 vref pcasc d3 d3 sg13_hv_pmos l=4u w=10u as=3.4p ad=3.4p ps=20.68u pd=20.68u rfmode=0
XM51_u4 vref pcasc d3 d3 sg13_hv_pmos l=4u w=10u as=3.4p ad=3.4p ps=20.68u pd=20.68u rfmode=0
XM52_u2 n1 pcasc d1 d1 sg13_hv_pmos l=4u w=10u as=3.4p ad=3.4p ps=20.68u pd=20.68u rfmode=0
XM52_u3 n1 pcasc d1 d1 sg13_hv_pmos l=4u w=10u as=3.4p ad=3.4p ps=20.68u pd=20.68u rfmode=0
XM52_u4 n1 pcasc d1 d1 sg13_hv_pmos l=4u w=10u as=3.4p ad=3.4p ps=20.68u pd=20.68u rfmode=0
XM52_u5 n1 pcasc d1 d1 sg13_hv_pmos l=4u w=10u as=3.4p ad=3.4p ps=20.68u pd=20.68u rfmode=0
XM52_u6 n1 pcasc d1 d1 sg13_hv_pmos l=4u w=10u as=3.4p ad=3.4p ps=20.68u pd=20.68u rfmode=0
XM52_u7 n1 pcasc d1 d1 sg13_hv_pmos l=4u w=10u as=3.4p ad=3.4p ps=20.68u pd=20.68u rfmode=0
XM52_u8 n1 pcasc d1 d1 sg13_hv_pmos l=4u w=10u as=3.4p ad=3.4p ps=20.68u pd=20.68u rfmode=0
XM52_u9 n1 pcasc d1 d1 sg13_hv_pmos l=4u w=10u as=3.4p ad=3.4p ps=20.68u pd=20.68u rfmode=0
XM52_u10 n1 pcasc d1 d1 sg13_hv_pmos l=4u w=10u as=3.4p ad=3.4p ps=20.68u pd=20.68u rfmode=0
XM52_u11 n1 pcasc d1 d1 sg13_hv_pmos l=4u w=10u as=3.4p ad=3.4p ps=20.68u pd=20.68u rfmode=0
XM52_u12 n1 pcasc d1 d1 sg13_hv_pmos l=4u w=10u as=3.4p ad=3.4p ps=20.68u pd=20.68u rfmode=0
XM52_u13 n1 pcasc d1 d1 sg13_hv_pmos l=4u w=10u as=3.4p ad=3.4p ps=20.68u pd=20.68u rfmode=0
XM52_u14 n1 pcasc d1 d1 sg13_hv_pmos l=4u w=10u as=3.4p ad=3.4p ps=20.68u pd=20.68u rfmode=0
XM52_u15 n1 pcasc d1 d1 sg13_hv_pmos l=4u w=10u as=3.4p ad=3.4p ps=20.68u pd=20.68u rfmode=0
XM52_u16 n1 pcasc d1 d1 sg13_hv_pmos l=4u w=10u as=3.4p ad=3.4p ps=20.68u pd=20.68u rfmode=0
XM52_u17 n1 pcasc d1 d1 sg13_hv_pmos l=4u w=10u as=3.4p ad=3.4p ps=20.68u pd=20.68u rfmode=0
XM52_u18 n1 pcasc d1 d1 sg13_hv_pmos l=4u w=10u as=3.4p ad=3.4p ps=20.68u pd=20.68u rfmode=0
XM52_u19 n1 pcasc d1 d1 sg13_hv_pmos l=4u w=10u as=3.4p ad=3.4p ps=20.68u pd=20.68u rfmode=0
XM52_u20 n1 pcasc d1 d1 sg13_hv_pmos l=4u w=10u as=3.4p ad=3.4p ps=20.68u pd=20.68u rfmode=0
XM52_u21 n1 pcasc d1 d1 sg13_hv_pmos l=4u w=10u as=3.4p ad=3.4p ps=20.68u pd=20.68u rfmode=0
XM52_u22 n1 pcasc d1 d1 sg13_hv_pmos l=4u w=10u as=3.4p ad=3.4p ps=20.68u pd=20.68u rfmode=0
XM52_u23 n1 pcasc d1 d1 sg13_hv_pmos l=4u w=10u as=3.4p ad=3.4p ps=20.68u pd=20.68u rfmode=0
XM52_u24 n1 pcasc d1 d1 sg13_hv_pmos l=4u w=10u as=3.4p ad=3.4p ps=20.68u pd=20.68u rfmode=0
XM54_u2 pbias pcasc d2 d2 sg13_hv_pmos l=4u w=10u as=3.4p ad=3.4p ps=20.68u pd=20.68u rfmode=0
XM54_u3 pbias pcasc d2 d2 sg13_hv_pmos l=4u w=10u as=3.4p ad=3.4p ps=20.68u pd=20.68u rfmode=0
XM54_u4 pbias pcasc d2 d2 sg13_hv_pmos l=4u w=10u as=3.4p ad=3.4p ps=20.68u pd=20.68u rfmode=0
XM54_u5 pbias pcasc d2 d2 sg13_hv_pmos l=4u w=10u as=3.4p ad=3.4p ps=20.68u pd=20.68u rfmode=0
XM54_u6 pbias pcasc d2 d2 sg13_hv_pmos l=4u w=10u as=3.4p ad=3.4p ps=20.68u pd=20.68u rfmode=0
XM54_u7 pbias pcasc d2 d2 sg13_hv_pmos l=4u w=10u as=3.4p ad=3.4p ps=20.68u pd=20.68u rfmode=0
XM54_u8 pbias pcasc d2 d2 sg13_hv_pmos l=4u w=10u as=3.4p ad=3.4p ps=20.68u pd=20.68u rfmode=0
XM54_u9 pbias pcasc d2 d2 sg13_hv_pmos l=4u w=10u as=3.4p ad=3.4p ps=20.68u pd=20.68u rfmode=0
XM54_u10 pbias pcasc d2 d2 sg13_hv_pmos l=4u w=10u as=3.4p ad=3.4p ps=20.68u pd=20.68u rfmode=0
XM54_u11 pbias pcasc d2 d2 sg13_hv_pmos l=4u w=10u as=3.4p ad=3.4p ps=20.68u pd=20.68u rfmode=0
XM54_u12 pbias pcasc d2 d2 sg13_hv_pmos l=4u w=10u as=3.4p ad=3.4p ps=20.68u pd=20.68u rfmode=0
XM54_u13 pbias pcasc d2 d2 sg13_hv_pmos l=4u w=10u as=3.4p ad=3.4p ps=20.68u pd=20.68u rfmode=0
XM54_u14 pbias pcasc d2 d2 sg13_hv_pmos l=4u w=10u as=3.4p ad=3.4p ps=20.68u pd=20.68u rfmode=0
XM54_u15 pbias pcasc d2 d2 sg13_hv_pmos l=4u w=10u as=3.4p ad=3.4p ps=20.68u pd=20.68u rfmode=0
XM54_u16 pbias pcasc d2 d2 sg13_hv_pmos l=4u w=10u as=3.4p ad=3.4p ps=20.68u pd=20.68u rfmode=0
XM54_u17 pbias pcasc d2 d2 sg13_hv_pmos l=4u w=10u as=3.4p ad=3.4p ps=20.68u pd=20.68u rfmode=0
XM54_u18 pbias pcasc d2 d2 sg13_hv_pmos l=4u w=10u as=3.4p ad=3.4p ps=20.68u pd=20.68u rfmode=0
XM54_u19 pbias pcasc d2 d2 sg13_hv_pmos l=4u w=10u as=3.4p ad=3.4p ps=20.68u pd=20.68u rfmode=0
XM54_u20 pbias pcasc d2 d2 sg13_hv_pmos l=4u w=10u as=3.4p ad=3.4p ps=20.68u pd=20.68u rfmode=0
XM54_u21 pbias pcasc d2 d2 sg13_hv_pmos l=4u w=10u as=3.4p ad=3.4p ps=20.68u pd=20.68u rfmode=0
XM54_u22 pbias pcasc d2 d2 sg13_hv_pmos l=4u w=10u as=3.4p ad=3.4p ps=20.68u pd=20.68u rfmode=0
XM54_u23 pbias pcasc d2 d2 sg13_hv_pmos l=4u w=10u as=3.4p ad=3.4p ps=20.68u pd=20.68u rfmode=0
XM54_u24 pbias pcasc d2 d2 sg13_hv_pmos l=4u w=10u as=3.4p ad=3.4p ps=20.68u pd=20.68u rfmode=0
XQ56_u2 vbe vbe vss vss npn13G2 we=0.07u le=0.9u Nx=1 m=1
XQ56_u3 vbe vbe vss vss npn13G2 we=0.07u le=0.9u Nx=1 m=1
XQ56_u4 vbe vbe vss vss npn13G2 we=0.07u le=0.9u Nx=1 m=1
XQ56_u5 vbe vbe vss vss npn13G2 we=0.07u le=0.9u Nx=1 m=1
XQ56_u6 vbe vbe vss vss npn13G2 we=0.07u le=0.9u Nx=1 m=1
XQ56_u7 vbe vbe vss vss npn13G2 we=0.07u le=0.9u Nx=1 m=1
XQ56_u8 vbe vbe vss vss npn13G2 we=0.07u le=0.9u Nx=1 m=1
XQ56_u9 vbe vbe vss vss npn13G2 we=0.07u le=0.9u Nx=1 m=1
XQ56_u10 vbe vbe vss vss npn13G2 we=0.07u le=0.9u Nx=1 m=1
XQ56_u11 vbe vbe vss vss npn13G2 we=0.07u le=0.9u Nx=1 m=1
XQ56_u12 vbe vbe vss vss npn13G2 we=0.07u le=0.9u Nx=1 m=1
XQ56_u13 vbe vbe vss vss npn13G2 we=0.07u le=0.9u Nx=1 m=1
XQ56_u14 vbe vbe vss vss npn13G2 we=0.07u le=0.9u Nx=1 m=1
XQ56_u15 vbe vbe vss vss npn13G2 we=0.07u le=0.9u Nx=1 m=1
XQ56_u16 vbe vbe vss vss npn13G2 we=0.07u le=0.9u Nx=1 m=1
XQ56_u17 vbe vbe vss vss npn13G2 we=0.07u le=0.9u Nx=1 m=1
XQ56_u18 vbe vbe vss vss npn13G2 we=0.07u le=0.9u Nx=1 m=1
XQ56_u19 vbe vbe vss vss npn13G2 we=0.07u le=0.9u Nx=1 m=1
XQ56_u20 vbe vbe vss vss npn13G2 we=0.07u le=0.9u Nx=1 m=1
XQ56_u21 vbe vbe vss vss npn13G2 we=0.07u le=0.9u Nx=1 m=1
XQ56_u22 vbe vbe vss vss npn13G2 we=0.07u le=0.9u Nx=1 m=1
XQ56_u23 vbe vbe vss vss npn13G2 we=0.07u le=0.9u Nx=1 m=1
XQ56_u24 vbe vbe vss vss npn13G2 we=0.07u le=0.9u Nx=1 m=1
XQ60_u2 vbe3 vbe3 vss vss npn13G2 we=0.07u le=0.9u Nx=1 m=1
XQ60_u3 vbe3 vbe3 vss vss npn13G2 we=0.07u le=0.9u Nx=1 m=1
XQ60_u4 vbe3 vbe3 vss vss npn13G2 we=0.07u le=0.9u Nx=1 m=1
XQ62_u2 vd2 vd2 vss vss npn13G2 we=0.07u le=0.9u Nx=1 m=1
XQ62_u3 vd2 vd2 vss vss npn13G2 we=0.07u le=0.9u Nx=1 m=1
XQ62_u4 vd2 vd2 vss vss npn13G2 we=0.07u le=0.9u Nx=1 m=1
XQ62_u5 vd2 vd2 vss vss npn13G2 we=0.07u le=0.9u Nx=1 m=1
XQ62_u6 vd2 vd2 vss vss npn13G2 we=0.07u le=0.9u Nx=1 m=1
XQ62_u7 vd2 vd2 vss vss npn13G2 we=0.07u le=0.9u Nx=1 m=1
XQ62_u8 vd2 vd2 vss vss npn13G2 we=0.07u le=0.9u Nx=1 m=1
XQ62_u9 vd2 vd2 vss vss npn13G2 we=0.07u le=0.9u Nx=1 m=1
XQ62_u10 vd2 vd2 vss vss npn13G2 we=0.07u le=0.9u Nx=1 m=1
XQ62_u11 vd2 vd2 vss vss npn13G2 we=0.07u le=0.9u Nx=1 m=1
XQ62_u12 vd2 vd2 vss vss npn13G2 we=0.07u le=0.9u Nx=1 m=1
XQ62_u13 vd2 vd2 vss vss npn13G2 we=0.07u le=0.9u Nx=1 m=1
XQ62_u14 vd2 vd2 vss vss npn13G2 we=0.07u le=0.9u Nx=1 m=1
XQ62_u15 vd2 vd2 vss vss npn13G2 we=0.07u le=0.9u Nx=1 m=1
XQ62_u16 vd2 vd2 vss vss npn13G2 we=0.07u le=0.9u Nx=1 m=1
XQ62_u17 vd2 vd2 vss vss npn13G2 we=0.07u le=0.9u Nx=1 m=1
XQ62_u18 vd2 vd2 vss vss npn13G2 we=0.07u le=0.9u Nx=1 m=1
XQ62_u19 vd2 vd2 vss vss npn13G2 we=0.07u le=0.9u Nx=1 m=1
XQ62_u20 vd2 vd2 vss vss npn13G2 we=0.07u le=0.9u Nx=1 m=1
XQ62_u21 vd2 vd2 vss vss npn13G2 we=0.07u le=0.9u Nx=1 m=1
XQ62_u22 vd2 vd2 vss vss npn13G2 we=0.07u le=0.9u Nx=1 m=1
XQ62_u23 vd2 vd2 vss vss npn13G2 we=0.07u le=0.9u Nx=1 m=1
XQ62_u24 vd2 vd2 vss vss npn13G2 we=0.07u le=0.9u Nx=1 m=1
XQ67_u2 vbe b1b vss vss npn13G2 we=0.07u le=0.9u Nx=1 m=1
XQ67_u3 vbe b1b vss vss npn13G2 we=0.07u le=0.9u Nx=1 m=1
XQ67_u4 vbe b1b vss vss npn13G2 we=0.07u le=0.9u Nx=1 m=1
XQ67_u5 vbe b1b vss vss npn13G2 we=0.07u le=0.9u Nx=1 m=1
XQ67_u6 vbe b1b vss vss npn13G2 we=0.07u le=0.9u Nx=1 m=1
XQ67_u7 vbe b1b vss vss npn13G2 we=0.07u le=0.9u Nx=1 m=1
XQ67_u8 vbe b1b vss vss npn13G2 we=0.07u le=0.9u Nx=1 m=1
XQ67_u9 vbe b1b vss vss npn13G2 we=0.07u le=0.9u Nx=1 m=1
XQ67_u10 vbe b1b vss vss npn13G2 we=0.07u le=0.9u Nx=1 m=1
XQ67_u11 vbe b1b vss vss npn13G2 we=0.07u le=0.9u Nx=1 m=1
XQ67_u12 vbe b1b vss vss npn13G2 we=0.07u le=0.9u Nx=1 m=1
XQ67_u13 vbe b1b vss vss npn13G2 we=0.07u le=0.9u Nx=1 m=1
XQ67_u14 vbe b1b vss vss npn13G2 we=0.07u le=0.9u Nx=1 m=1
XQ67_u15 vbe b1b vss vss npn13G2 we=0.07u le=0.9u Nx=1 m=1
XQ67_u16 vbe b1b vss vss npn13G2 we=0.07u le=0.9u Nx=1 m=1
XQ67_u17 vbe b1b vss vss npn13G2 we=0.07u le=0.9u Nx=1 m=1
XQ67_u18 vbe b1b vss vss npn13G2 we=0.07u le=0.9u Nx=1 m=1
XQ67_u19 vbe b1b vss vss npn13G2 we=0.07u le=0.9u Nx=1 m=1
XQ67_u20 vbe b1b vss vss npn13G2 we=0.07u le=0.9u Nx=1 m=1
XQ67_u21 vbe b1b vss vss npn13G2 we=0.07u le=0.9u Nx=1 m=1
XQ67_u22 vbe b1b vss vss npn13G2 we=0.07u le=0.9u Nx=1 m=1
XQ67_u23 vbe b1b vss vss npn13G2 we=0.07u le=0.9u Nx=1 m=1
XQ67_u24 vbe b1b vss vss npn13G2 we=0.07u le=0.9u Nx=1 m=1
XQ68_u2 c2 vbe dvbe vss npn13G2 we=0.07u le=0.9u Nx=1 m=1
XQ68_u3 c2 vbe dvbe vss npn13G2 we=0.07u le=0.9u Nx=1 m=1
XQ68_u4 c2 vbe dvbe vss npn13G2 we=0.07u le=0.9u Nx=1 m=1
XQ68_u5 c2 vbe dvbe vss npn13G2 we=0.07u le=0.9u Nx=1 m=1
XQ68_u6 c2 vbe dvbe vss npn13G2 we=0.07u le=0.9u Nx=1 m=1
XQ68_u7 c2 vbe dvbe vss npn13G2 we=0.07u le=0.9u Nx=1 m=1
XQ68_u8 c2 vbe dvbe vss npn13G2 we=0.07u le=0.9u Nx=1 m=1
XQ68_u9 c2 vbe dvbe vss npn13G2 we=0.07u le=0.9u Nx=1 m=1
XQ68_u10 c2 vbe dvbe vss npn13G2 we=0.07u le=0.9u Nx=1 m=1
XQ68_u11 c2 vbe dvbe vss npn13G2 we=0.07u le=0.9u Nx=1 m=1
XQ68_u12 c2 vbe dvbe vss npn13G2 we=0.07u le=0.9u Nx=1 m=1
XQ68_u13 c2 vbe dvbe vss npn13G2 we=0.07u le=0.9u Nx=1 m=1
XQ68_u14 c2 vbe dvbe vss npn13G2 we=0.07u le=0.9u Nx=1 m=1
XQ68_u15 c2 vbe dvbe vss npn13G2 we=0.07u le=0.9u Nx=1 m=1
XQ68_u16 c2 vbe dvbe vss npn13G2 we=0.07u le=0.9u Nx=1 m=1
XQ68_u17 c2 vbe dvbe vss npn13G2 we=0.07u le=0.9u Nx=1 m=1
XQ68_u18 c2 vbe dvbe vss npn13G2 we=0.07u le=0.9u Nx=1 m=1
XQ68_u19 c2 vbe dvbe vss npn13G2 we=0.07u le=0.9u Nx=1 m=1
XQ68_u20 c2 vbe dvbe vss npn13G2 we=0.07u le=0.9u Nx=1 m=1
XQ68_u21 c2 vbe dvbe vss npn13G2 we=0.07u le=0.9u Nx=1 m=1
XQ68_u22 c2 vbe dvbe vss npn13G2 we=0.07u le=0.9u Nx=1 m=1
XQ68_u23 c2 vbe dvbe vss npn13G2 we=0.07u le=0.9u Nx=1 m=1
XQ68_u24 c2 vbe dvbe vss npn13G2 we=0.07u le=0.9u Nx=1 m=1
XQ69_u2 c2 vbe dvbe vss npn13G2 we=0.07u le=0.9u Nx=1 m=1
XQ69_u3 c2 vbe dvbe vss npn13G2 we=0.07u le=0.9u Nx=1 m=1
XQ69_u4 c2 vbe dvbe vss npn13G2 we=0.07u le=0.9u Nx=1 m=1
XQ69_u5 c2 vbe dvbe vss npn13G2 we=0.07u le=0.9u Nx=1 m=1
XQ69_u6 c2 vbe dvbe vss npn13G2 we=0.07u le=0.9u Nx=1 m=1
XQ69_u7 c2 vbe dvbe vss npn13G2 we=0.07u le=0.9u Nx=1 m=1
XQ69_u8 c2 vbe dvbe vss npn13G2 we=0.07u le=0.9u Nx=1 m=1
XQ69_u9 c2 vbe dvbe vss npn13G2 we=0.07u le=0.9u Nx=1 m=1
XQ69_u10 c2 vbe dvbe vss npn13G2 we=0.07u le=0.9u Nx=1 m=1
XQ69_u11 c2 vbe dvbe vss npn13G2 we=0.07u le=0.9u Nx=1 m=1
XQ69_u12 c2 vbe dvbe vss npn13G2 we=0.07u le=0.9u Nx=1 m=1
XQ69_u13 c2 vbe dvbe vss npn13G2 we=0.07u le=0.9u Nx=1 m=1
XQ69_u14 c2 vbe dvbe vss npn13G2 we=0.07u le=0.9u Nx=1 m=1
XQ69_u15 c2 vbe dvbe vss npn13G2 we=0.07u le=0.9u Nx=1 m=1
XQ69_u16 c2 vbe dvbe vss npn13G2 we=0.07u le=0.9u Nx=1 m=1
XQ69_u17 c2 vbe dvbe vss npn13G2 we=0.07u le=0.9u Nx=1 m=1
XQ69_u18 c2 vbe dvbe vss npn13G2 we=0.07u le=0.9u Nx=1 m=1
XQ69_u19 c2 vbe dvbe vss npn13G2 we=0.07u le=0.9u Nx=1 m=1
XQ69_u20 c2 vbe dvbe vss npn13G2 we=0.07u le=0.9u Nx=1 m=1
XQ69_u21 c2 vbe dvbe vss npn13G2 we=0.07u le=0.9u Nx=1 m=1
XQ69_u22 c2 vbe dvbe vss npn13G2 we=0.07u le=0.9u Nx=1 m=1
XQ69_u23 c2 vbe dvbe vss npn13G2 we=0.07u le=0.9u Nx=1 m=1
XQ69_u24 c2 vbe dvbe vss npn13G2 we=0.07u le=0.9u Nx=1 m=1
XQ70_u2 c2 vbe dvbe vss npn13G2 we=0.07u le=0.9u Nx=1 m=1
XQ70_u3 c2 vbe dvbe vss npn13G2 we=0.07u le=0.9u Nx=1 m=1
XQ70_u4 c2 vbe dvbe vss npn13G2 we=0.07u le=0.9u Nx=1 m=1
XQ70_u5 c2 vbe dvbe vss npn13G2 we=0.07u le=0.9u Nx=1 m=1
XQ70_u6 c2 vbe dvbe vss npn13G2 we=0.07u le=0.9u Nx=1 m=1
XQ70_u7 c2 vbe dvbe vss npn13G2 we=0.07u le=0.9u Nx=1 m=1
XQ70_u8 c2 vbe dvbe vss npn13G2 we=0.07u le=0.9u Nx=1 m=1
XQ70_u9 c2 vbe dvbe vss npn13G2 we=0.07u le=0.9u Nx=1 m=1
XQ70_u10 c2 vbe dvbe vss npn13G2 we=0.07u le=0.9u Nx=1 m=1
XQ70_u11 c2 vbe dvbe vss npn13G2 we=0.07u le=0.9u Nx=1 m=1
XQ70_u12 c2 vbe dvbe vss npn13G2 we=0.07u le=0.9u Nx=1 m=1
XQ70_u13 c2 vbe dvbe vss npn13G2 we=0.07u le=0.9u Nx=1 m=1
XQ70_u14 c2 vbe dvbe vss npn13G2 we=0.07u le=0.9u Nx=1 m=1
XQ70_u15 c2 vbe dvbe vss npn13G2 we=0.07u le=0.9u Nx=1 m=1
XQ70_u16 c2 vbe dvbe vss npn13G2 we=0.07u le=0.9u Nx=1 m=1
XQ70_u17 c2 vbe dvbe vss npn13G2 we=0.07u le=0.9u Nx=1 m=1
XQ70_u18 c2 vbe dvbe vss npn13G2 we=0.07u le=0.9u Nx=1 m=1
XQ70_u19 c2 vbe dvbe vss npn13G2 we=0.07u le=0.9u Nx=1 m=1
XQ70_u20 c2 vbe dvbe vss npn13G2 we=0.07u le=0.9u Nx=1 m=1
XQ70_u21 c2 vbe dvbe vss npn13G2 we=0.07u le=0.9u Nx=1 m=1
XQ70_u22 c2 vbe dvbe vss npn13G2 we=0.07u le=0.9u Nx=1 m=1
XQ70_u23 c2 vbe dvbe vss npn13G2 we=0.07u le=0.9u Nx=1 m=1
XQ70_u24 c2 vbe dvbe vss npn13G2 we=0.07u le=0.9u Nx=1 m=1
XQ71_u2 c2 vbe dvbe vss npn13G2 we=0.07u le=0.9u Nx=1 m=1
XQ71_u3 c2 vbe dvbe vss npn13G2 we=0.07u le=0.9u Nx=1 m=1
XQ71_u4 c2 vbe dvbe vss npn13G2 we=0.07u le=0.9u Nx=1 m=1
XQ71_u5 c2 vbe dvbe vss npn13G2 we=0.07u le=0.9u Nx=1 m=1
XQ71_u6 c2 vbe dvbe vss npn13G2 we=0.07u le=0.9u Nx=1 m=1
XQ71_u7 c2 vbe dvbe vss npn13G2 we=0.07u le=0.9u Nx=1 m=1
XQ71_u8 c2 vbe dvbe vss npn13G2 we=0.07u le=0.9u Nx=1 m=1
XQ71_u9 c2 vbe dvbe vss npn13G2 we=0.07u le=0.9u Nx=1 m=1
XQ71_u10 c2 vbe dvbe vss npn13G2 we=0.07u le=0.9u Nx=1 m=1
XQ71_u11 c2 vbe dvbe vss npn13G2 we=0.07u le=0.9u Nx=1 m=1
XQ71_u12 c2 vbe dvbe vss npn13G2 we=0.07u le=0.9u Nx=1 m=1
XQ71_u13 c2 vbe dvbe vss npn13G2 we=0.07u le=0.9u Nx=1 m=1
XQ71_u14 c2 vbe dvbe vss npn13G2 we=0.07u le=0.9u Nx=1 m=1
XQ71_u15 c2 vbe dvbe vss npn13G2 we=0.07u le=0.9u Nx=1 m=1
XQ71_u16 c2 vbe dvbe vss npn13G2 we=0.07u le=0.9u Nx=1 m=1
XQ71_u17 c2 vbe dvbe vss npn13G2 we=0.07u le=0.9u Nx=1 m=1
XQ71_u18 c2 vbe dvbe vss npn13G2 we=0.07u le=0.9u Nx=1 m=1
XQ71_u19 c2 vbe dvbe vss npn13G2 we=0.07u le=0.9u Nx=1 m=1
XQ71_u20 c2 vbe dvbe vss npn13G2 we=0.07u le=0.9u Nx=1 m=1
XQ71_u21 c2 vbe dvbe vss npn13G2 we=0.07u le=0.9u Nx=1 m=1
XQ71_u22 c2 vbe dvbe vss npn13G2 we=0.07u le=0.9u Nx=1 m=1
XQ71_u23 c2 vbe dvbe vss npn13G2 we=0.07u le=0.9u Nx=1 m=1
XQ71_u24 c2 vbe dvbe vss npn13G2 we=0.07u le=0.9u Nx=1 m=1
XQ72_u2 c2 vbe dvbe vss npn13G2 we=0.07u le=0.9u Nx=1 m=1
XQ72_u3 c2 vbe dvbe vss npn13G2 we=0.07u le=0.9u Nx=1 m=1
XQ72_u4 c2 vbe dvbe vss npn13G2 we=0.07u le=0.9u Nx=1 m=1
XQ72_u5 c2 vbe dvbe vss npn13G2 we=0.07u le=0.9u Nx=1 m=1
XQ72_u6 c2 vbe dvbe vss npn13G2 we=0.07u le=0.9u Nx=1 m=1
XQ72_u7 c2 vbe dvbe vss npn13G2 we=0.07u le=0.9u Nx=1 m=1
XQ72_u8 c2 vbe dvbe vss npn13G2 we=0.07u le=0.9u Nx=1 m=1
XQ72_u9 c2 vbe dvbe vss npn13G2 we=0.07u le=0.9u Nx=1 m=1
XQ72_u10 c2 vbe dvbe vss npn13G2 we=0.07u le=0.9u Nx=1 m=1
XQ72_u11 c2 vbe dvbe vss npn13G2 we=0.07u le=0.9u Nx=1 m=1
XQ72_u12 c2 vbe dvbe vss npn13G2 we=0.07u le=0.9u Nx=1 m=1
XQ72_u13 c2 vbe dvbe vss npn13G2 we=0.07u le=0.9u Nx=1 m=1
XQ72_u14 c2 vbe dvbe vss npn13G2 we=0.07u le=0.9u Nx=1 m=1
XQ72_u15 c2 vbe dvbe vss npn13G2 we=0.07u le=0.9u Nx=1 m=1
XQ72_u16 c2 vbe dvbe vss npn13G2 we=0.07u le=0.9u Nx=1 m=1
XQ72_u17 c2 vbe dvbe vss npn13G2 we=0.07u le=0.9u Nx=1 m=1
XQ72_u18 c2 vbe dvbe vss npn13G2 we=0.07u le=0.9u Nx=1 m=1
XQ72_u19 c2 vbe dvbe vss npn13G2 we=0.07u le=0.9u Nx=1 m=1
XQ72_u20 c2 vbe dvbe vss npn13G2 we=0.07u le=0.9u Nx=1 m=1
XQ72_u21 c2 vbe dvbe vss npn13G2 we=0.07u le=0.9u Nx=1 m=1
XQ72_u22 c2 vbe dvbe vss npn13G2 we=0.07u le=0.9u Nx=1 m=1
XQ72_u23 c2 vbe dvbe vss npn13G2 we=0.07u le=0.9u Nx=1 m=1
XQ72_u24 c2 vbe dvbe vss npn13G2 we=0.07u le=0.9u Nx=1 m=1
XQ73_u2 c2 vbe dvbe vss npn13G2 we=0.07u le=0.9u Nx=1 m=1
XQ73_u3 c2 vbe dvbe vss npn13G2 we=0.07u le=0.9u Nx=1 m=1
XQ73_u4 c2 vbe dvbe vss npn13G2 we=0.07u le=0.9u Nx=1 m=1
XQ73_u5 c2 vbe dvbe vss npn13G2 we=0.07u le=0.9u Nx=1 m=1
XQ73_u6 c2 vbe dvbe vss npn13G2 we=0.07u le=0.9u Nx=1 m=1
XQ73_u7 c2 vbe dvbe vss npn13G2 we=0.07u le=0.9u Nx=1 m=1
XQ73_u8 c2 vbe dvbe vss npn13G2 we=0.07u le=0.9u Nx=1 m=1
XQ73_u9 c2 vbe dvbe vss npn13G2 we=0.07u le=0.9u Nx=1 m=1
XQ73_u10 c2 vbe dvbe vss npn13G2 we=0.07u le=0.9u Nx=1 m=1
XQ73_u11 c2 vbe dvbe vss npn13G2 we=0.07u le=0.9u Nx=1 m=1
XQ73_u12 c2 vbe dvbe vss npn13G2 we=0.07u le=0.9u Nx=1 m=1
XQ73_u13 c2 vbe dvbe vss npn13G2 we=0.07u le=0.9u Nx=1 m=1
XQ73_u14 c2 vbe dvbe vss npn13G2 we=0.07u le=0.9u Nx=1 m=1
XQ73_u15 c2 vbe dvbe vss npn13G2 we=0.07u le=0.9u Nx=1 m=1
XQ73_u16 c2 vbe dvbe vss npn13G2 we=0.07u le=0.9u Nx=1 m=1
XQ73_u17 c2 vbe dvbe vss npn13G2 we=0.07u le=0.9u Nx=1 m=1
XQ73_u18 c2 vbe dvbe vss npn13G2 we=0.07u le=0.9u Nx=1 m=1
XQ73_u19 c2 vbe dvbe vss npn13G2 we=0.07u le=0.9u Nx=1 m=1
XQ73_u20 c2 vbe dvbe vss npn13G2 we=0.07u le=0.9u Nx=1 m=1
XQ73_u21 c2 vbe dvbe vss npn13G2 we=0.07u le=0.9u Nx=1 m=1
XQ73_u22 c2 vbe dvbe vss npn13G2 we=0.07u le=0.9u Nx=1 m=1
XQ73_u23 c2 vbe dvbe vss npn13G2 we=0.07u le=0.9u Nx=1 m=1
XQ73_u24 c2 vbe dvbe vss npn13G2 we=0.07u le=0.9u Nx=1 m=1
XQ74_u2 c2 vbe dvbe vss npn13G2 we=0.07u le=0.9u Nx=1 m=1
XQ74_u3 c2 vbe dvbe vss npn13G2 we=0.07u le=0.9u Nx=1 m=1
XQ74_u4 c2 vbe dvbe vss npn13G2 we=0.07u le=0.9u Nx=1 m=1
XQ74_u5 c2 vbe dvbe vss npn13G2 we=0.07u le=0.9u Nx=1 m=1
XQ74_u6 c2 vbe dvbe vss npn13G2 we=0.07u le=0.9u Nx=1 m=1
XQ74_u7 c2 vbe dvbe vss npn13G2 we=0.07u le=0.9u Nx=1 m=1
XQ74_u8 c2 vbe dvbe vss npn13G2 we=0.07u le=0.9u Nx=1 m=1
XQ74_u9 c2 vbe dvbe vss npn13G2 we=0.07u le=0.9u Nx=1 m=1
XQ74_u10 c2 vbe dvbe vss npn13G2 we=0.07u le=0.9u Nx=1 m=1
XQ74_u11 c2 vbe dvbe vss npn13G2 we=0.07u le=0.9u Nx=1 m=1
XQ74_u12 c2 vbe dvbe vss npn13G2 we=0.07u le=0.9u Nx=1 m=1
XQ74_u13 c2 vbe dvbe vss npn13G2 we=0.07u le=0.9u Nx=1 m=1
XQ74_u14 c2 vbe dvbe vss npn13G2 we=0.07u le=0.9u Nx=1 m=1
XQ74_u15 c2 vbe dvbe vss npn13G2 we=0.07u le=0.9u Nx=1 m=1
XQ74_u16 c2 vbe dvbe vss npn13G2 we=0.07u le=0.9u Nx=1 m=1
XQ74_u17 c2 vbe dvbe vss npn13G2 we=0.07u le=0.9u Nx=1 m=1
XQ74_u18 c2 vbe dvbe vss npn13G2 we=0.07u le=0.9u Nx=1 m=1
XQ74_u19 c2 vbe dvbe vss npn13G2 we=0.07u le=0.9u Nx=1 m=1
XQ74_u20 c2 vbe dvbe vss npn13G2 we=0.07u le=0.9u Nx=1 m=1
XQ74_u21 c2 vbe dvbe vss npn13G2 we=0.07u le=0.9u Nx=1 m=1
XQ74_u22 c2 vbe dvbe vss npn13G2 we=0.07u le=0.9u Nx=1 m=1
XQ74_u23 c2 vbe dvbe vss npn13G2 we=0.07u le=0.9u Nx=1 m=1
XQ74_u24 c2 vbe dvbe vss npn13G2 we=0.07u le=0.9u Nx=1 m=1
XQ75_u2 vd1 vd1 vd2 vss npn13G2 we=0.07u le=0.9u Nx=1 m=1
XQ75_u3 vd1 vd1 vd2 vss npn13G2 we=0.07u le=0.9u Nx=1 m=1
XQ75_u4 vd1 vd1 vd2 vss npn13G2 we=0.07u le=0.9u Nx=1 m=1
XQ75_u5 vd1 vd1 vd2 vss npn13G2 we=0.07u le=0.9u Nx=1 m=1
XQ75_u6 vd1 vd1 vd2 vss npn13G2 we=0.07u le=0.9u Nx=1 m=1
XQ75_u7 vd1 vd1 vd2 vss npn13G2 we=0.07u le=0.9u Nx=1 m=1
XQ75_u8 vd1 vd1 vd2 vss npn13G2 we=0.07u le=0.9u Nx=1 m=1
XQ75_u9 vd1 vd1 vd2 vss npn13G2 we=0.07u le=0.9u Nx=1 m=1
XQ75_u10 vd1 vd1 vd2 vss npn13G2 we=0.07u le=0.9u Nx=1 m=1
XQ75_u11 vd1 vd1 vd2 vss npn13G2 we=0.07u le=0.9u Nx=1 m=1
XQ75_u12 vd1 vd1 vd2 vss npn13G2 we=0.07u le=0.9u Nx=1 m=1
XQ75_u13 vd1 vd1 vd2 vss npn13G2 we=0.07u le=0.9u Nx=1 m=1
XQ75_u14 vd1 vd1 vd2 vss npn13G2 we=0.07u le=0.9u Nx=1 m=1
XQ75_u15 vd1 vd1 vd2 vss npn13G2 we=0.07u le=0.9u Nx=1 m=1
XQ75_u16 vd1 vd1 vd2 vss npn13G2 we=0.07u le=0.9u Nx=1 m=1
XQ75_u17 vd1 vd1 vd2 vss npn13G2 we=0.07u le=0.9u Nx=1 m=1
XQ75_u18 vd1 vd1 vd2 vss npn13G2 we=0.07u le=0.9u Nx=1 m=1
XQ75_u19 vd1 vd1 vd2 vss npn13G2 we=0.07u le=0.9u Nx=1 m=1
XQ75_u20 vd1 vd1 vd2 vss npn13G2 we=0.07u le=0.9u Nx=1 m=1
XQ75_u21 vd1 vd1 vd2 vss npn13G2 we=0.07u le=0.9u Nx=1 m=1
XQ75_u22 vd1 vd1 vd2 vss npn13G2 we=0.07u le=0.9u Nx=1 m=1
XQ75_u23 vd1 vd1 vd2 vss npn13G2 we=0.07u le=0.9u Nx=1 m=1
XQ75_u24 vd1 vd1 vd2 vss npn13G2 we=0.07u le=0.9u Nx=1 m=1
XQ76_u2 c2 vbe dvbe vss npn13G2 we=0.07u le=0.9u Nx=1 m=1
XQ76_u3 c2 vbe dvbe vss npn13G2 we=0.07u le=0.9u Nx=1 m=1
XQ76_u4 c2 vbe dvbe vss npn13G2 we=0.07u le=0.9u Nx=1 m=1
XQ76_u5 c2 vbe dvbe vss npn13G2 we=0.07u le=0.9u Nx=1 m=1
XQ76_u6 c2 vbe dvbe vss npn13G2 we=0.07u le=0.9u Nx=1 m=1
XQ76_u7 c2 vbe dvbe vss npn13G2 we=0.07u le=0.9u Nx=1 m=1
XQ76_u8 c2 vbe dvbe vss npn13G2 we=0.07u le=0.9u Nx=1 m=1
XQ76_u9 c2 vbe dvbe vss npn13G2 we=0.07u le=0.9u Nx=1 m=1
XQ76_u10 c2 vbe dvbe vss npn13G2 we=0.07u le=0.9u Nx=1 m=1
XQ76_u11 c2 vbe dvbe vss npn13G2 we=0.07u le=0.9u Nx=1 m=1
XQ76_u12 c2 vbe dvbe vss npn13G2 we=0.07u le=0.9u Nx=1 m=1
XQ76_u13 c2 vbe dvbe vss npn13G2 we=0.07u le=0.9u Nx=1 m=1
XQ76_u14 c2 vbe dvbe vss npn13G2 we=0.07u le=0.9u Nx=1 m=1
XQ76_u15 c2 vbe dvbe vss npn13G2 we=0.07u le=0.9u Nx=1 m=1
XQ76_u16 c2 vbe dvbe vss npn13G2 we=0.07u le=0.9u Nx=1 m=1
XQ76_u17 c2 vbe dvbe vss npn13G2 we=0.07u le=0.9u Nx=1 m=1
XQ76_u18 c2 vbe dvbe vss npn13G2 we=0.07u le=0.9u Nx=1 m=1
XQ76_u19 c2 vbe dvbe vss npn13G2 we=0.07u le=0.9u Nx=1 m=1
XQ76_u20 c2 vbe dvbe vss npn13G2 we=0.07u le=0.9u Nx=1 m=1
XQ76_u21 c2 vbe dvbe vss npn13G2 we=0.07u le=0.9u Nx=1 m=1
XQ76_u22 c2 vbe dvbe vss npn13G2 we=0.07u le=0.9u Nx=1 m=1
XQ76_u23 c2 vbe dvbe vss npn13G2 we=0.07u le=0.9u Nx=1 m=1
XQ76_u24 c2 vbe dvbe vss npn13G2 we=0.07u le=0.9u Nx=1 m=1
XR77_u2 n_4 pbias vss rppd w=1u l=50u b=0 m=1
XR77_u3 n_4 pbias vss rppd w=1u l=50u b=0 m=1
XR77_u4 n_4 pbias vss rppd w=1u l=50u b=0 m=1
XR77_u5 n_4 pbias vss rppd w=1u l=50u b=0 m=1
XR77_u6 n_4 pbias vss rppd w=1u l=50u b=0 m=1
XR77_u7 n_4 pbias vss rppd w=1u l=50u b=0 m=1
XR77_u8 n_4 pbias vss rppd w=1u l=50u b=0 m=1
XR77_u9 n_4 pbias vss rppd w=1u l=50u b=0 m=1
XR77_u10 n_4 pbias vss rppd w=1u l=50u b=0 m=1
XR77_u11 n_4 pbias vss rppd w=1u l=50u b=0 m=1
XR77_u12 n_4 pbias vss rppd w=1u l=50u b=0 m=1
XR77_u13 n_4 pbias vss rppd w=1u l=50u b=0 m=1
XR77_u14 n_4 pbias vss rppd w=1u l=50u b=0 m=1
XR77_u15 n_4 pbias vss rppd w=1u l=50u b=0 m=1
XR77_u16 n_4 pbias vss rppd w=1u l=50u b=0 m=1
XR77_u17 n_4 pbias vss rppd w=1u l=50u b=0 m=1
XR77_u18 n_4 pbias vss rppd w=1u l=50u b=0 m=1
XR77_u19 n_4 pbias vss rppd w=1u l=50u b=0 m=1
XR77_u20 n_4 pbias vss rppd w=1u l=50u b=0 m=1
XR77_u21 n_4 pbias vss rppd w=1u l=50u b=0 m=1
XR77_u22 n_4 pbias vss rppd w=1u l=50u b=0 m=1
XR77_u23 n_4 pbias vss rppd w=1u l=50u b=0 m=1
XR77_u24 n_4 pbias vss rppd w=1u l=50u b=0 m=1
XR78_u2 n_11 n_34 vss rppd w=1u l=50u b=0 m=1
XR78_u3 n_11 n_34 vss rppd w=1u l=50u b=0 m=1
XR78_u4 n_11 n_34 vss rppd w=1u l=50u b=0 m=1
XR78_u5 n_11 n_34 vss rppd w=1u l=50u b=0 m=1
XR78_u6 n_11 n_34 vss rppd w=1u l=50u b=0 m=1
XR78_u7 n_11 n_34 vss rppd w=1u l=50u b=0 m=1
XR78_u8 n_11 n_34 vss rppd w=1u l=50u b=0 m=1
XR78_u9 n_11 n_34 vss rppd w=1u l=50u b=0 m=1
XR78_u10 n_11 n_34 vss rppd w=1u l=50u b=0 m=1
XR78_u11 n_11 n_34 vss rppd w=1u l=50u b=0 m=1
XR78_u12 n_11 n_34 vss rppd w=1u l=50u b=0 m=1
XR78_u13 n_11 n_34 vss rppd w=1u l=50u b=0 m=1
XR78_u14 n_11 n_34 vss rppd w=1u l=50u b=0 m=1
XR78_u15 n_11 n_34 vss rppd w=1u l=50u b=0 m=1
XR78_u16 n_11 n_34 vss rppd w=1u l=50u b=0 m=1
XR78_u17 n_11 n_34 vss rppd w=1u l=50u b=0 m=1
XR78_u18 n_11 n_34 vss rppd w=1u l=50u b=0 m=1
XR78_u19 n_11 n_34 vss rppd w=1u l=50u b=0 m=1
XR78_u20 n_11 n_34 vss rppd w=1u l=50u b=0 m=1
XR78_u21 n_11 n_34 vss rppd w=1u l=50u b=0 m=1
XR78_u22 n_11 n_34 vss rppd w=1u l=50u b=0 m=1
XR78_u23 n_11 n_34 vss rppd w=1u l=50u b=0 m=1
XR78_u24 n_11 n_34 vss rppd w=1u l=50u b=0 m=1
XR79_u2 n_10 n_34 vss rppd w=1u l=50u b=0 m=1
XR79_u3 n_10 n_34 vss rppd w=1u l=50u b=0 m=1
XR79_u4 n_10 n_34 vss rppd w=1u l=50u b=0 m=1
XR79_u5 n_10 n_34 vss rppd w=1u l=50u b=0 m=1
XR79_u6 n_10 n_34 vss rppd w=1u l=50u b=0 m=1
XR79_u7 n_10 n_34 vss rppd w=1u l=50u b=0 m=1
XR79_u8 n_10 n_34 vss rppd w=1u l=50u b=0 m=1
XR79_u9 n_10 n_34 vss rppd w=1u l=50u b=0 m=1
XR79_u10 n_10 n_34 vss rppd w=1u l=50u b=0 m=1
XR79_u11 n_10 n_34 vss rppd w=1u l=50u b=0 m=1
XR79_u12 n_10 n_34 vss rppd w=1u l=50u b=0 m=1
XR79_u13 n_10 n_34 vss rppd w=1u l=50u b=0 m=1
XR79_u14 n_10 n_34 vss rppd w=1u l=50u b=0 m=1
XR79_u15 n_10 n_34 vss rppd w=1u l=50u b=0 m=1
XR79_u16 n_10 n_34 vss rppd w=1u l=50u b=0 m=1
XR79_u17 n_10 n_34 vss rppd w=1u l=50u b=0 m=1
XR79_u18 n_10 n_34 vss rppd w=1u l=50u b=0 m=1
XR79_u19 n_10 n_34 vss rppd w=1u l=50u b=0 m=1
XR79_u20 n_10 n_34 vss rppd w=1u l=50u b=0 m=1
XR79_u21 n_10 n_34 vss rppd w=1u l=50u b=0 m=1
XR79_u22 n_10 n_34 vss rppd w=1u l=50u b=0 m=1
XR79_u23 n_10 n_34 vss rppd w=1u l=50u b=0 m=1
XR79_u24 n_10 n_34 vss rppd w=1u l=50u b=0 m=1
XR80_u2 n_3 n_31 vss rppd w=1u l=50u b=0 m=1
XR80_u3 n_3 n_31 vss rppd w=1u l=50u b=0 m=1
XR80_u4 n_3 n_31 vss rppd w=1u l=50u b=0 m=1
XR80_u5 n_3 n_31 vss rppd w=1u l=50u b=0 m=1
XR80_u6 n_3 n_31 vss rppd w=1u l=50u b=0 m=1
XR80_u7 n_3 n_31 vss rppd w=1u l=50u b=0 m=1
XR80_u8 n_3 n_31 vss rppd w=1u l=50u b=0 m=1
XR80_u9 n_3 n_31 vss rppd w=1u l=50u b=0 m=1
XR80_u10 n_3 n_31 vss rppd w=1u l=50u b=0 m=1
XR80_u11 n_3 n_31 vss rppd w=1u l=50u b=0 m=1
XR80_u12 n_3 n_31 vss rppd w=1u l=50u b=0 m=1
XR80_u13 n_3 n_31 vss rppd w=1u l=50u b=0 m=1
XR80_u14 n_3 n_31 vss rppd w=1u l=50u b=0 m=1
XR80_u15 n_3 n_31 vss rppd w=1u l=50u b=0 m=1
XR80_u16 n_3 n_31 vss rppd w=1u l=50u b=0 m=1
XR80_u17 n_3 n_31 vss rppd w=1u l=50u b=0 m=1
XR80_u18 n_3 n_31 vss rppd w=1u l=50u b=0 m=1
XR80_u19 n_3 n_31 vss rppd w=1u l=50u b=0 m=1
XR80_u20 n_3 n_31 vss rppd w=1u l=50u b=0 m=1
XR80_u21 n_3 n_31 vss rppd w=1u l=50u b=0 m=1
XR80_u22 n_3 n_31 vss rppd w=1u l=50u b=0 m=1
XR80_u23 n_3 n_31 vss rppd w=1u l=50u b=0 m=1
XR80_u24 n_3 n_31 vss rppd w=1u l=50u b=0 m=1
XR81_u2 n_10 n_33 vss rppd w=1u l=50u b=0 m=1
XR81_u3 n_10 n_33 vss rppd w=1u l=50u b=0 m=1
XR81_u4 n_10 n_33 vss rppd w=1u l=50u b=0 m=1
XR81_u5 n_10 n_33 vss rppd w=1u l=50u b=0 m=1
XR81_u6 n_10 n_33 vss rppd w=1u l=50u b=0 m=1
XR81_u7 n_10 n_33 vss rppd w=1u l=50u b=0 m=1
XR81_u8 n_10 n_33 vss rppd w=1u l=50u b=0 m=1
XR81_u9 n_10 n_33 vss rppd w=1u l=50u b=0 m=1
XR81_u10 n_10 n_33 vss rppd w=1u l=50u b=0 m=1
XR81_u11 n_10 n_33 vss rppd w=1u l=50u b=0 m=1
XR81_u12 n_10 n_33 vss rppd w=1u l=50u b=0 m=1
XR81_u13 n_10 n_33 vss rppd w=1u l=50u b=0 m=1
XR81_u14 n_10 n_33 vss rppd w=1u l=50u b=0 m=1
XR81_u15 n_10 n_33 vss rppd w=1u l=50u b=0 m=1
XR81_u16 n_10 n_33 vss rppd w=1u l=50u b=0 m=1
XR81_u17 n_10 n_33 vss rppd w=1u l=50u b=0 m=1
XR81_u18 n_10 n_33 vss rppd w=1u l=50u b=0 m=1
XR81_u19 n_10 n_33 vss rppd w=1u l=50u b=0 m=1
XR81_u20 n_10 n_33 vss rppd w=1u l=50u b=0 m=1
XR81_u21 n_10 n_33 vss rppd w=1u l=50u b=0 m=1
XR81_u22 n_10 n_33 vss rppd w=1u l=50u b=0 m=1
XR81_u23 n_10 n_33 vss rppd w=1u l=50u b=0 m=1
XR81_u24 n_10 n_33 vss rppd w=1u l=50u b=0 m=1
XR82_u2 n_5 n_31 vss rppd w=1u l=50u b=0 m=1
XR82_u3 n_5 n_31 vss rppd w=1u l=50u b=0 m=1
XR82_u4 n_5 n_31 vss rppd w=1u l=50u b=0 m=1
XR82_u5 n_5 n_31 vss rppd w=1u l=50u b=0 m=1
XR82_u6 n_5 n_31 vss rppd w=1u l=50u b=0 m=1
XR82_u7 n_5 n_31 vss rppd w=1u l=50u b=0 m=1
XR82_u8 n_5 n_31 vss rppd w=1u l=50u b=0 m=1
XR82_u9 n_5 n_31 vss rppd w=1u l=50u b=0 m=1
XR82_u10 n_5 n_31 vss rppd w=1u l=50u b=0 m=1
XR82_u11 n_5 n_31 vss rppd w=1u l=50u b=0 m=1
XR82_u12 n_5 n_31 vss rppd w=1u l=50u b=0 m=1
XR82_u13 n_5 n_31 vss rppd w=1u l=50u b=0 m=1
XR82_u14 n_5 n_31 vss rppd w=1u l=50u b=0 m=1
XR82_u15 n_5 n_31 vss rppd w=1u l=50u b=0 m=1
XR82_u16 n_5 n_31 vss rppd w=1u l=50u b=0 m=1
XR82_u17 n_5 n_31 vss rppd w=1u l=50u b=0 m=1
XR82_u18 n_5 n_31 vss rppd w=1u l=50u b=0 m=1
XR82_u19 n_5 n_31 vss rppd w=1u l=50u b=0 m=1
XR82_u20 n_5 n_31 vss rppd w=1u l=50u b=0 m=1
XR82_u21 n_5 n_31 vss rppd w=1u l=50u b=0 m=1
XR82_u22 n_5 n_31 vss rppd w=1u l=50u b=0 m=1
XR82_u23 n_5 n_31 vss rppd w=1u l=50u b=0 m=1
XR82_u24 n_5 n_31 vss rppd w=1u l=50u b=0 m=1
XR83_u2 n_5 n_30 vss rppd w=1u l=50u b=0 m=1
XR83_u3 n_5 n_30 vss rppd w=1u l=50u b=0 m=1
XR83_u4 n_5 n_30 vss rppd w=1u l=50u b=0 m=1
XR83_u5 n_5 n_30 vss rppd w=1u l=50u b=0 m=1
XR83_u6 n_5 n_30 vss rppd w=1u l=50u b=0 m=1
XR83_u7 n_5 n_30 vss rppd w=1u l=50u b=0 m=1
XR83_u8 n_5 n_30 vss rppd w=1u l=50u b=0 m=1
XR83_u9 n_5 n_30 vss rppd w=1u l=50u b=0 m=1
XR83_u10 n_5 n_30 vss rppd w=1u l=50u b=0 m=1
XR83_u11 n_5 n_30 vss rppd w=1u l=50u b=0 m=1
XR83_u12 n_5 n_30 vss rppd w=1u l=50u b=0 m=1
XR83_u13 n_5 n_30 vss rppd w=1u l=50u b=0 m=1
XR83_u14 n_5 n_30 vss rppd w=1u l=50u b=0 m=1
XR83_u15 n_5 n_30 vss rppd w=1u l=50u b=0 m=1
XR83_u16 n_5 n_30 vss rppd w=1u l=50u b=0 m=1
XR83_u17 n_5 n_30 vss rppd w=1u l=50u b=0 m=1
XR83_u18 n_5 n_30 vss rppd w=1u l=50u b=0 m=1
XR83_u19 n_5 n_30 vss rppd w=1u l=50u b=0 m=1
XR83_u20 n_5 n_30 vss rppd w=1u l=50u b=0 m=1
XR83_u21 n_5 n_30 vss rppd w=1u l=50u b=0 m=1
XR83_u22 n_5 n_30 vss rppd w=1u l=50u b=0 m=1
XR83_u23 n_5 n_30 vss rppd w=1u l=50u b=0 m=1
XR83_u24 n_5 n_30 vss rppd w=1u l=50u b=0 m=1
XR84_u2 n_4 n_30 vss rppd w=1u l=50u b=0 m=1
XR84_u3 n_4 n_30 vss rppd w=1u l=50u b=0 m=1
XR84_u4 n_4 n_30 vss rppd w=1u l=50u b=0 m=1
XR84_u5 n_4 n_30 vss rppd w=1u l=50u b=0 m=1
XR84_u6 n_4 n_30 vss rppd w=1u l=50u b=0 m=1
XR84_u7 n_4 n_30 vss rppd w=1u l=50u b=0 m=1
XR84_u8 n_4 n_30 vss rppd w=1u l=50u b=0 m=1
XR84_u9 n_4 n_30 vss rppd w=1u l=50u b=0 m=1
XR84_u10 n_4 n_30 vss rppd w=1u l=50u b=0 m=1
XR84_u11 n_4 n_30 vss rppd w=1u l=50u b=0 m=1
XR84_u12 n_4 n_30 vss rppd w=1u l=50u b=0 m=1
XR84_u13 n_4 n_30 vss rppd w=1u l=50u b=0 m=1
XR84_u14 n_4 n_30 vss rppd w=1u l=50u b=0 m=1
XR84_u15 n_4 n_30 vss rppd w=1u l=50u b=0 m=1
XR84_u16 n_4 n_30 vss rppd w=1u l=50u b=0 m=1
XR84_u17 n_4 n_30 vss rppd w=1u l=50u b=0 m=1
XR84_u18 n_4 n_30 vss rppd w=1u l=50u b=0 m=1
XR84_u19 n_4 n_30 vss rppd w=1u l=50u b=0 m=1
XR84_u20 n_4 n_30 vss rppd w=1u l=50u b=0 m=1
XR84_u21 n_4 n_30 vss rppd w=1u l=50u b=0 m=1
XR84_u22 n_4 n_30 vss rppd w=1u l=50u b=0 m=1
XR84_u23 n_4 n_30 vss rppd w=1u l=50u b=0 m=1
XR84_u24 n_4 n_30 vss rppd w=1u l=50u b=0 m=1
XR85_u2 n_3 n_33 vss rppd w=1u l=50u b=0 m=1
XR85_u3 n_3 n_33 vss rppd w=1u l=50u b=0 m=1
XR85_u4 n_3 n_33 vss rppd w=1u l=50u b=0 m=1
XR85_u5 n_3 n_33 vss rppd w=1u l=50u b=0 m=1
XR85_u6 n_3 n_33 vss rppd w=1u l=50u b=0 m=1
XR85_u7 n_3 n_33 vss rppd w=1u l=50u b=0 m=1
XR85_u8 n_3 n_33 vss rppd w=1u l=50u b=0 m=1
XR85_u9 n_3 n_33 vss rppd w=1u l=50u b=0 m=1
XR85_u10 n_3 n_33 vss rppd w=1u l=50u b=0 m=1
XR85_u11 n_3 n_33 vss rppd w=1u l=50u b=0 m=1
XR85_u12 n_3 n_33 vss rppd w=1u l=50u b=0 m=1
XR85_u13 n_3 n_33 vss rppd w=1u l=50u b=0 m=1
XR85_u14 n_3 n_33 vss rppd w=1u l=50u b=0 m=1
XR85_u15 n_3 n_33 vss rppd w=1u l=50u b=0 m=1
XR85_u16 n_3 n_33 vss rppd w=1u l=50u b=0 m=1
XR85_u17 n_3 n_33 vss rppd w=1u l=50u b=0 m=1
XR85_u18 n_3 n_33 vss rppd w=1u l=50u b=0 m=1
XR85_u19 n_3 n_33 vss rppd w=1u l=50u b=0 m=1
XR85_u20 n_3 n_33 vss rppd w=1u l=50u b=0 m=1
XR85_u21 n_3 n_33 vss rppd w=1u l=50u b=0 m=1
XR85_u22 n_3 n_33 vss rppd w=1u l=50u b=0 m=1
XR85_u23 n_3 n_33 vss rppd w=1u l=50u b=0 m=1
XR85_u24 n_3 n_33 vss rppd w=1u l=50u b=0 m=1
XR86_u2 n_11 pcasc vss rppd w=1u l=50u b=0 m=1
XR86_u3 n_11 pcasc vss rppd w=1u l=50u b=0 m=1
XR86_u4 n_11 pcasc vss rppd w=1u l=50u b=0 m=1
XR86_u5 n_11 pcasc vss rppd w=1u l=50u b=0 m=1
XR86_u6 n_11 pcasc vss rppd w=1u l=50u b=0 m=1
XR86_u7 n_11 pcasc vss rppd w=1u l=50u b=0 m=1
XR86_u8 n_11 pcasc vss rppd w=1u l=50u b=0 m=1
XR86_u9 n_11 pcasc vss rppd w=1u l=50u b=0 m=1
XR86_u10 n_11 pcasc vss rppd w=1u l=50u b=0 m=1
XR86_u11 n_11 pcasc vss rppd w=1u l=50u b=0 m=1
XR86_u12 n_11 pcasc vss rppd w=1u l=50u b=0 m=1
XR86_u13 n_11 pcasc vss rppd w=1u l=50u b=0 m=1
XR86_u14 n_11 pcasc vss rppd w=1u l=50u b=0 m=1
XR86_u15 n_11 pcasc vss rppd w=1u l=50u b=0 m=1
XR86_u16 n_11 pcasc vss rppd w=1u l=50u b=0 m=1
XR86_u17 n_11 pcasc vss rppd w=1u l=50u b=0 m=1
XR86_u18 n_11 pcasc vss rppd w=1u l=50u b=0 m=1
XR86_u19 n_11 pcasc vss rppd w=1u l=50u b=0 m=1
XR86_u20 n_11 pcasc vss rppd w=1u l=50u b=0 m=1
XR86_u21 n_11 pcasc vss rppd w=1u l=50u b=0 m=1
XR86_u22 n_11 pcasc vss rppd w=1u l=50u b=0 m=1
XR86_u23 n_11 pcasc vss rppd w=1u l=50u b=0 m=1
XR86_u24 n_11 pcasc vss rppd w=1u l=50u b=0 m=1
.ends g1_bgr
.subckt sg13g2_tiehi L_HI VDD VSS
XMN1 net3 net2 VSS VSS sg13_lv_nmos m=1 w=795.00n l=130.00n ng=1
XMN0 net1 net1 VSS VSS sg13_lv_nmos m=1 w=300n l=130.00n ng=1
XMP1 L_HI net3 VDD VDD sg13_lv_pmos m=1 w=1.155u l=130.00n ng=1
XMP0 net2 net1 VDD VDD sg13_lv_pmos m=1 w=660.0n l=130.00n ng=1
.ends sg13g2_tiehi
.subckt g1_dose_macro D_ELT D_STD G_SHARED vss
XMHV D_ELT G_SHARED vss vss sg13_hv_nmos w=3.98u l=0.45u ng=1 m=1
XMLV D_STD G_SHARED vss vss sg13_lv_nmos w=3.98u l=0.13u ng=1 m=1
.ends g1_dose_macro
.subckt g1_dut_macro HBT_C HBT_B HBT_E vss
XQ1 HBT_C HBT_B HBT_E vss npn13G2 le=900e-9 we=70.0n Nx=1
.ends g1_dut_macro
.subckt g1_ls_up in out vdd vdda vss
XMPI inb in vdd vdd sg13_lv_pmos w=2u l=0.13u ng=1 m=1
XMNI inb in vss vss sg13_lv_nmos w=1u l=0.13u ng=1 m=1
XMN1 nb in vss vss sg13_hv_nmos w=3.8u l=0.45u ng=1 m=1
XMN2 n inb vss vss sg13_hv_nmos w=3.8u l=0.45u ng=1 m=1
XMP1 nb n vdda vdda sg13_hv_pmos w=0.3u l=0.45u ng=1 m=1
XMP2 n nb vdda vdda sg13_hv_pmos w=0.3u l=0.45u ng=1 m=1
XMPO out nb vdda vdda sg13_hv_pmos w=3.9u l=0.45u ng=1 m=1
XMNO out nb vss vss sg13_hv_nmos w=1.9u l=0.45u ng=1 m=1
.ends g1_ls_up
.subckt G1_VSS_DERIVATIVE__sg13g2_Clamp_N43N43D4R gate iovss pad G1_EXPLICIT_SUBSTRATE_VSS
XMN0_1_ pad gate iovss G1_EXPLICIT_SUBSTRATE_VSS sg13_hv_nmos m=1 w=4.4u l=600.0n ng=1
XMN0_2_ pad gate iovss G1_EXPLICIT_SUBSTRATE_VSS sg13_hv_nmos m=1 w=4.4u l=600.0n ng=1
XMN0_3_ pad gate iovss G1_EXPLICIT_SUBSTRATE_VSS sg13_hv_nmos m=1 w=4.4u l=600.0n ng=1
XMN0_4_ pad gate iovss G1_EXPLICIT_SUBSTRATE_VSS sg13_hv_nmos m=1 w=4.4u l=600.0n ng=1
XMN0_5_ pad gate iovss G1_EXPLICIT_SUBSTRATE_VSS sg13_hv_nmos m=1 w=4.4u l=600.0n ng=1
XMN0_6_ pad gate iovss G1_EXPLICIT_SUBSTRATE_VSS sg13_hv_nmos m=1 w=4.4u l=600.0n ng=1
XMN0_7_ pad gate iovss G1_EXPLICIT_SUBSTRATE_VSS sg13_hv_nmos m=1 w=4.4u l=600.0n ng=1
XMN0_8_ pad gate iovss G1_EXPLICIT_SUBSTRATE_VSS sg13_hv_nmos m=1 w=4.4u l=600.0n ng=1
XMN0_9_ pad gate iovss G1_EXPLICIT_SUBSTRATE_VSS sg13_hv_nmos m=1 w=4.4u l=600.0n ng=1
XMN0_10_ pad gate iovss G1_EXPLICIT_SUBSTRATE_VSS sg13_hv_nmos m=1 w=4.4u l=600.0n ng=1
XMN0_11_ pad gate iovss G1_EXPLICIT_SUBSTRATE_VSS sg13_hv_nmos m=1 w=4.4u l=600.0n ng=1
XMN0_12_ pad gate iovss G1_EXPLICIT_SUBSTRATE_VSS sg13_hv_nmos m=1 w=4.4u l=600.0n ng=1
XMN0_13_ pad gate iovss G1_EXPLICIT_SUBSTRATE_VSS sg13_hv_nmos m=1 w=4.4u l=600.0n ng=1
XMN0_14_ pad gate iovss G1_EXPLICIT_SUBSTRATE_VSS sg13_hv_nmos m=1 w=4.4u l=600.0n ng=1
XMN0_15_ pad gate iovss G1_EXPLICIT_SUBSTRATE_VSS sg13_hv_nmos m=1 w=4.4u l=600.0n ng=1
XMN0_16_ pad gate iovss G1_EXPLICIT_SUBSTRATE_VSS sg13_hv_nmos m=1 w=4.4u l=600.0n ng=1
XMN0_17_ pad gate iovss G1_EXPLICIT_SUBSTRATE_VSS sg13_hv_nmos m=1 w=4.4u l=600.0n ng=1
XMN0_18_ pad gate iovss G1_EXPLICIT_SUBSTRATE_VSS sg13_hv_nmos m=1 w=4.4u l=600.0n ng=1
XMN0_19_ pad gate iovss G1_EXPLICIT_SUBSTRATE_VSS sg13_hv_nmos m=1 w=4.4u l=600.0n ng=1
XMN0_20_ pad gate iovss G1_EXPLICIT_SUBSTRATE_VSS sg13_hv_nmos m=1 w=4.4u l=600.0n ng=1
XMN0_21_ pad gate iovss G1_EXPLICIT_SUBSTRATE_VSS sg13_hv_nmos m=1 w=4.4u l=600.0n ng=1
XMN0_22_ pad gate iovss G1_EXPLICIT_SUBSTRATE_VSS sg13_hv_nmos m=1 w=4.4u l=600.0n ng=1
XMN0_23_ pad gate iovss G1_EXPLICIT_SUBSTRATE_VSS sg13_hv_nmos m=1 w=4.4u l=600.0n ng=1
XMN0_24_ pad gate iovss G1_EXPLICIT_SUBSTRATE_VSS sg13_hv_nmos m=1 w=4.4u l=600.0n ng=1
XMN0_25_ pad gate iovss G1_EXPLICIT_SUBSTRATE_VSS sg13_hv_nmos m=1 w=4.4u l=600.0n ng=1
XMN0_26_ pad gate iovss G1_EXPLICIT_SUBSTRATE_VSS sg13_hv_nmos m=1 w=4.4u l=600.0n ng=1
XMN0_27_ pad gate iovss G1_EXPLICIT_SUBSTRATE_VSS sg13_hv_nmos m=1 w=4.4u l=600.0n ng=1
XMN0_28_ pad gate iovss G1_EXPLICIT_SUBSTRATE_VSS sg13_hv_nmos m=1 w=4.4u l=600.0n ng=1
XMN0_29_ pad gate iovss G1_EXPLICIT_SUBSTRATE_VSS sg13_hv_nmos m=1 w=4.4u l=600.0n ng=1
XMN0_30_ pad gate iovss G1_EXPLICIT_SUBSTRATE_VSS sg13_hv_nmos m=1 w=4.4u l=600.0n ng=1
XMN0_31_ pad gate iovss G1_EXPLICIT_SUBSTRATE_VSS sg13_hv_nmos m=1 w=4.4u l=600.0n ng=1
XMN0_32_ pad gate iovss G1_EXPLICIT_SUBSTRATE_VSS sg13_hv_nmos m=1 w=4.4u l=600.0n ng=1
XMN0_33_ pad gate iovss G1_EXPLICIT_SUBSTRATE_VSS sg13_hv_nmos m=1 w=4.4u l=600.0n ng=1
XMN0_34_ pad gate iovss G1_EXPLICIT_SUBSTRATE_VSS sg13_hv_nmos m=1 w=4.4u l=600.0n ng=1
XMN0_35_ pad gate iovss G1_EXPLICIT_SUBSTRATE_VSS sg13_hv_nmos m=1 w=4.4u l=600.0n ng=1
XMN0_36_ pad gate iovss G1_EXPLICIT_SUBSTRATE_VSS sg13_hv_nmos m=1 w=4.4u l=600.0n ng=1
XMN0_37_ pad gate iovss G1_EXPLICIT_SUBSTRATE_VSS sg13_hv_nmos m=1 w=4.4u l=600.0n ng=1
XMN0_38_ pad gate iovss G1_EXPLICIT_SUBSTRATE_VSS sg13_hv_nmos m=1 w=4.4u l=600.0n ng=1
XMN0_39_ pad gate iovss G1_EXPLICIT_SUBSTRATE_VSS sg13_hv_nmos m=1 w=4.4u l=600.0n ng=1
XMN0_40_ pad gate iovss G1_EXPLICIT_SUBSTRATE_VSS sg13_hv_nmos m=1 w=4.4u l=600.0n ng=1
XMN0_41_ pad gate iovss G1_EXPLICIT_SUBSTRATE_VSS sg13_hv_nmos m=1 w=4.4u l=600.0n ng=1
XMN0_42_ pad gate iovss G1_EXPLICIT_SUBSTRATE_VSS sg13_hv_nmos m=1 w=4.4u l=600.0n ng=1
XMN0_43_ pad gate iovss G1_EXPLICIT_SUBSTRATE_VSS sg13_hv_nmos m=1 w=4.4u l=600.0n ng=1
XMN0_44_ pad gate iovss G1_EXPLICIT_SUBSTRATE_VSS sg13_hv_nmos m=1 w=4.4u l=600.0n ng=1
XMN0_45_ pad gate iovss G1_EXPLICIT_SUBSTRATE_VSS sg13_hv_nmos m=1 w=4.4u l=600.0n ng=1
XMN0_46_ pad gate iovss G1_EXPLICIT_SUBSTRATE_VSS sg13_hv_nmos m=1 w=4.4u l=600.0n ng=1
XMN0_47_ pad gate iovss G1_EXPLICIT_SUBSTRATE_VSS sg13_hv_nmos m=1 w=4.4u l=600.0n ng=1
XMN0_48_ pad gate iovss G1_EXPLICIT_SUBSTRATE_VSS sg13_hv_nmos m=1 w=4.4u l=600.0n ng=1
XMN0_49_ pad gate iovss G1_EXPLICIT_SUBSTRATE_VSS sg13_hv_nmos m=1 w=4.4u l=600.0n ng=1
XMN0_50_ pad gate iovss G1_EXPLICIT_SUBSTRATE_VSS sg13_hv_nmos m=1 w=4.4u l=600.0n ng=1
XMN0_51_ pad gate iovss G1_EXPLICIT_SUBSTRATE_VSS sg13_hv_nmos m=1 w=4.4u l=600.0n ng=1
XMN0_52_ pad gate iovss G1_EXPLICIT_SUBSTRATE_VSS sg13_hv_nmos m=1 w=4.4u l=600.0n ng=1
XMN0_53_ pad gate iovss G1_EXPLICIT_SUBSTRATE_VSS sg13_hv_nmos m=1 w=4.4u l=600.0n ng=1
XMN0_54_ pad gate iovss G1_EXPLICIT_SUBSTRATE_VSS sg13_hv_nmos m=1 w=4.4u l=600.0n ng=1
XMN0_55_ pad gate iovss G1_EXPLICIT_SUBSTRATE_VSS sg13_hv_nmos m=1 w=4.4u l=600.0n ng=1
XMN0_56_ pad gate iovss G1_EXPLICIT_SUBSTRATE_VSS sg13_hv_nmos m=1 w=4.4u l=600.0n ng=1
XMN0_57_ pad gate iovss G1_EXPLICIT_SUBSTRATE_VSS sg13_hv_nmos m=1 w=4.4u l=600.0n ng=1
XMN0_58_ pad gate iovss G1_EXPLICIT_SUBSTRATE_VSS sg13_hv_nmos m=1 w=4.4u l=600.0n ng=1
XMN0_59_ pad gate iovss G1_EXPLICIT_SUBSTRATE_VSS sg13_hv_nmos m=1 w=4.4u l=600.0n ng=1
XMN0_60_ pad gate iovss G1_EXPLICIT_SUBSTRATE_VSS sg13_hv_nmos m=1 w=4.4u l=600.0n ng=1
XMN0_61_ pad gate iovss G1_EXPLICIT_SUBSTRATE_VSS sg13_hv_nmos m=1 w=4.4u l=600.0n ng=1
XMN0_62_ pad gate iovss G1_EXPLICIT_SUBSTRATE_VSS sg13_hv_nmos m=1 w=4.4u l=600.0n ng=1
XMN0_63_ pad gate iovss G1_EXPLICIT_SUBSTRATE_VSS sg13_hv_nmos m=1 w=4.4u l=600.0n ng=1
XMN0_64_ pad gate iovss G1_EXPLICIT_SUBSTRATE_VSS sg13_hv_nmos m=1 w=4.4u l=600.0n ng=1
XMN0_65_ pad gate iovss G1_EXPLICIT_SUBSTRATE_VSS sg13_hv_nmos m=1 w=4.4u l=600.0n ng=1
XMN0_66_ pad gate iovss G1_EXPLICIT_SUBSTRATE_VSS sg13_hv_nmos m=1 w=4.4u l=600.0n ng=1
XMN0_67_ pad gate iovss G1_EXPLICIT_SUBSTRATE_VSS sg13_hv_nmos m=1 w=4.4u l=600.0n ng=1
XMN0_68_ pad gate iovss G1_EXPLICIT_SUBSTRATE_VSS sg13_hv_nmos m=1 w=4.4u l=600.0n ng=1
XMN0_69_ pad gate iovss G1_EXPLICIT_SUBSTRATE_VSS sg13_hv_nmos m=1 w=4.4u l=600.0n ng=1
XMN0_70_ pad gate iovss G1_EXPLICIT_SUBSTRATE_VSS sg13_hv_nmos m=1 w=4.4u l=600.0n ng=1
XMN0_71_ pad gate iovss G1_EXPLICIT_SUBSTRATE_VSS sg13_hv_nmos m=1 w=4.4u l=600.0n ng=1
XMN0_72_ pad gate iovss G1_EXPLICIT_SUBSTRATE_VSS sg13_hv_nmos m=1 w=4.4u l=600.0n ng=1
XMN0_73_ pad gate iovss G1_EXPLICIT_SUBSTRATE_VSS sg13_hv_nmos m=1 w=4.4u l=600.0n ng=1
XMN0_74_ pad gate iovss G1_EXPLICIT_SUBSTRATE_VSS sg13_hv_nmos m=1 w=4.4u l=600.0n ng=1
XMN0_75_ pad gate iovss G1_EXPLICIT_SUBSTRATE_VSS sg13_hv_nmos m=1 w=4.4u l=600.0n ng=1
XMN0_76_ pad gate iovss G1_EXPLICIT_SUBSTRATE_VSS sg13_hv_nmos m=1 w=4.4u l=600.0n ng=1
XMN0_77_ pad gate iovss G1_EXPLICIT_SUBSTRATE_VSS sg13_hv_nmos m=1 w=4.4u l=600.0n ng=1
XMN0_78_ pad gate iovss G1_EXPLICIT_SUBSTRATE_VSS sg13_hv_nmos m=1 w=4.4u l=600.0n ng=1
XMN0_79_ pad gate iovss G1_EXPLICIT_SUBSTRATE_VSS sg13_hv_nmos m=1 w=4.4u l=600.0n ng=1
XMN0_80_ pad gate iovss G1_EXPLICIT_SUBSTRATE_VSS sg13_hv_nmos m=1 w=4.4u l=600.0n ng=1
XMN0_81_ pad gate iovss G1_EXPLICIT_SUBSTRATE_VSS sg13_hv_nmos m=1 w=4.4u l=600.0n ng=1
XMN0_82_ pad gate iovss G1_EXPLICIT_SUBSTRATE_VSS sg13_hv_nmos m=1 w=4.4u l=600.0n ng=1
XMN0_83_ pad gate iovss G1_EXPLICIT_SUBSTRATE_VSS sg13_hv_nmos m=1 w=4.4u l=600.0n ng=1
XMN0_84_ pad gate iovss G1_EXPLICIT_SUBSTRATE_VSS sg13_hv_nmos m=1 w=4.4u l=600.0n ng=1
XMN0_85_ pad gate iovss G1_EXPLICIT_SUBSTRATE_VSS sg13_hv_nmos m=1 w=4.4u l=600.0n ng=1
XMN0_86_ pad gate iovss G1_EXPLICIT_SUBSTRATE_VSS sg13_hv_nmos m=1 w=4.4u l=600.0n ng=1
XMN0_87_ pad gate iovss G1_EXPLICIT_SUBSTRATE_VSS sg13_hv_nmos m=1 w=4.4u l=600.0n ng=1
XMN0_88_ pad gate iovss G1_EXPLICIT_SUBSTRATE_VSS sg13_hv_nmos m=1 w=4.4u l=600.0n ng=1
XMN0_89_ pad gate iovss G1_EXPLICIT_SUBSTRATE_VSS sg13_hv_nmos m=1 w=4.4u l=600.0n ng=1
XMN0_90_ pad gate iovss G1_EXPLICIT_SUBSTRATE_VSS sg13_hv_nmos m=1 w=4.4u l=600.0n ng=1
XMN0_91_ pad gate iovss G1_EXPLICIT_SUBSTRATE_VSS sg13_hv_nmos m=1 w=4.4u l=600.0n ng=1
XMN0_92_ pad gate iovss G1_EXPLICIT_SUBSTRATE_VSS sg13_hv_nmos m=1 w=4.4u l=600.0n ng=1
XMN0_93_ pad gate iovss G1_EXPLICIT_SUBSTRATE_VSS sg13_hv_nmos m=1 w=4.4u l=600.0n ng=1
XMN0_94_ pad gate iovss G1_EXPLICIT_SUBSTRATE_VSS sg13_hv_nmos m=1 w=4.4u l=600.0n ng=1
XMN0_95_ pad gate iovss G1_EXPLICIT_SUBSTRATE_VSS sg13_hv_nmos m=1 w=4.4u l=600.0n ng=1
XMN0_96_ pad gate iovss G1_EXPLICIT_SUBSTRATE_VSS sg13_hv_nmos m=1 w=4.4u l=600.0n ng=1
XMN0_97_ pad gate iovss G1_EXPLICIT_SUBSTRATE_VSS sg13_hv_nmos m=1 w=4.4u l=600.0n ng=1
XMN0_98_ pad gate iovss G1_EXPLICIT_SUBSTRATE_VSS sg13_hv_nmos m=1 w=4.4u l=600.0n ng=1
XMN0_99_ pad gate iovss G1_EXPLICIT_SUBSTRATE_VSS sg13_hv_nmos m=1 w=4.4u l=600.0n ng=1
XMN0_100_ pad gate iovss G1_EXPLICIT_SUBSTRATE_VSS sg13_hv_nmos m=1 w=4.4u l=600.0n ng=1
XMN0_101_ pad gate iovss G1_EXPLICIT_SUBSTRATE_VSS sg13_hv_nmos m=1 w=4.4u l=600.0n ng=1
XMN0_102_ pad gate iovss G1_EXPLICIT_SUBSTRATE_VSS sg13_hv_nmos m=1 w=4.4u l=600.0n ng=1
XMN0_103_ pad gate iovss G1_EXPLICIT_SUBSTRATE_VSS sg13_hv_nmos m=1 w=4.4u l=600.0n ng=1
XMN0_104_ pad gate iovss G1_EXPLICIT_SUBSTRATE_VSS sg13_hv_nmos m=1 w=4.4u l=600.0n ng=1
XMN0_105_ pad gate iovss G1_EXPLICIT_SUBSTRATE_VSS sg13_hv_nmos m=1 w=4.4u l=600.0n ng=1
XMN0_106_ pad gate iovss G1_EXPLICIT_SUBSTRATE_VSS sg13_hv_nmos m=1 w=4.4u l=600.0n ng=1
XMN0_107_ pad gate iovss G1_EXPLICIT_SUBSTRATE_VSS sg13_hv_nmos m=1 w=4.4u l=600.0n ng=1
XMN0_108_ pad gate iovss G1_EXPLICIT_SUBSTRATE_VSS sg13_hv_nmos m=1 w=4.4u l=600.0n ng=1
XMN0_109_ pad gate iovss G1_EXPLICIT_SUBSTRATE_VSS sg13_hv_nmos m=1 w=4.4u l=600.0n ng=1
XMN0_110_ pad gate iovss G1_EXPLICIT_SUBSTRATE_VSS sg13_hv_nmos m=1 w=4.4u l=600.0n ng=1
XMN0_111_ pad gate iovss G1_EXPLICIT_SUBSTRATE_VSS sg13_hv_nmos m=1 w=4.4u l=600.0n ng=1
XMN0_112_ pad gate iovss G1_EXPLICIT_SUBSTRATE_VSS sg13_hv_nmos m=1 w=4.4u l=600.0n ng=1
XMN0_113_ pad gate iovss G1_EXPLICIT_SUBSTRATE_VSS sg13_hv_nmos m=1 w=4.4u l=600.0n ng=1
XMN0_114_ pad gate iovss G1_EXPLICIT_SUBSTRATE_VSS sg13_hv_nmos m=1 w=4.4u l=600.0n ng=1
XMN0_115_ pad gate iovss G1_EXPLICIT_SUBSTRATE_VSS sg13_hv_nmos m=1 w=4.4u l=600.0n ng=1
XMN0_116_ pad gate iovss G1_EXPLICIT_SUBSTRATE_VSS sg13_hv_nmos m=1 w=4.4u l=600.0n ng=1
XMN0_117_ pad gate iovss G1_EXPLICIT_SUBSTRATE_VSS sg13_hv_nmos m=1 w=4.4u l=600.0n ng=1
XMN0_118_ pad gate iovss G1_EXPLICIT_SUBSTRATE_VSS sg13_hv_nmos m=1 w=4.4u l=600.0n ng=1
XMN0_119_ pad gate iovss G1_EXPLICIT_SUBSTRATE_VSS sg13_hv_nmos m=1 w=4.4u l=600.0n ng=1
XMN0_120_ pad gate iovss G1_EXPLICIT_SUBSTRATE_VSS sg13_hv_nmos m=1 w=4.4u l=600.0n ng=1
XMN0_121_ pad gate iovss G1_EXPLICIT_SUBSTRATE_VSS sg13_hv_nmos m=1 w=4.4u l=600.0n ng=1
XMN0_122_ pad gate iovss G1_EXPLICIT_SUBSTRATE_VSS sg13_hv_nmos m=1 w=4.4u l=600.0n ng=1
XMN0_123_ pad gate iovss G1_EXPLICIT_SUBSTRATE_VSS sg13_hv_nmos m=1 w=4.4u l=600.0n ng=1
XMN0_124_ pad gate iovss G1_EXPLICIT_SUBSTRATE_VSS sg13_hv_nmos m=1 w=4.4u l=600.0n ng=1
XMN0_125_ pad gate iovss G1_EXPLICIT_SUBSTRATE_VSS sg13_hv_nmos m=1 w=4.4u l=600.0n ng=1
XMN0_126_ pad gate iovss G1_EXPLICIT_SUBSTRATE_VSS sg13_hv_nmos m=1 w=4.4u l=600.0n ng=1
XMN0_127_ pad gate iovss G1_EXPLICIT_SUBSTRATE_VSS sg13_hv_nmos m=1 w=4.4u l=600.0n ng=1
XMN0_128_ pad gate iovss G1_EXPLICIT_SUBSTRATE_VSS sg13_hv_nmos m=1 w=4.4u l=600.0n ng=1
XMN0_129_ pad gate iovss G1_EXPLICIT_SUBSTRATE_VSS sg13_hv_nmos m=1 w=4.4u l=600.0n ng=1
XMN0_130_ pad gate iovss G1_EXPLICIT_SUBSTRATE_VSS sg13_hv_nmos m=1 w=4.4u l=600.0n ng=1
XMN0_131_ pad gate iovss G1_EXPLICIT_SUBSTRATE_VSS sg13_hv_nmos m=1 w=4.4u l=600.0n ng=1
XMN0_132_ pad gate iovss G1_EXPLICIT_SUBSTRATE_VSS sg13_hv_nmos m=1 w=4.4u l=600.0n ng=1
XMN0_133_ pad gate iovss G1_EXPLICIT_SUBSTRATE_VSS sg13_hv_nmos m=1 w=4.4u l=600.0n ng=1
XMN0_134_ pad gate iovss G1_EXPLICIT_SUBSTRATE_VSS sg13_hv_nmos m=1 w=4.4u l=600.0n ng=1
XMN0_135_ pad gate iovss G1_EXPLICIT_SUBSTRATE_VSS sg13_hv_nmos m=1 w=4.4u l=600.0n ng=1
XMN0_136_ pad gate iovss G1_EXPLICIT_SUBSTRATE_VSS sg13_hv_nmos m=1 w=4.4u l=600.0n ng=1
XMN0_137_ pad gate iovss G1_EXPLICIT_SUBSTRATE_VSS sg13_hv_nmos m=1 w=4.4u l=600.0n ng=1
XMN0_138_ pad gate iovss G1_EXPLICIT_SUBSTRATE_VSS sg13_hv_nmos m=1 w=4.4u l=600.0n ng=1
XMN0_139_ pad gate iovss G1_EXPLICIT_SUBSTRATE_VSS sg13_hv_nmos m=1 w=4.4u l=600.0n ng=1
XMN0_140_ pad gate iovss G1_EXPLICIT_SUBSTRATE_VSS sg13_hv_nmos m=1 w=4.4u l=600.0n ng=1
XMN0_141_ pad gate iovss G1_EXPLICIT_SUBSTRATE_VSS sg13_hv_nmos m=1 w=4.4u l=600.0n ng=1
XMN0_142_ pad gate iovss G1_EXPLICIT_SUBSTRATE_VSS sg13_hv_nmos m=1 w=4.4u l=600.0n ng=1
XMN0_143_ pad gate iovss G1_EXPLICIT_SUBSTRATE_VSS sg13_hv_nmos m=1 w=4.4u l=600.0n ng=1
XMN0_144_ pad gate iovss G1_EXPLICIT_SUBSTRATE_VSS sg13_hv_nmos m=1 w=4.4u l=600.0n ng=1
XMN0_145_ pad gate iovss G1_EXPLICIT_SUBSTRATE_VSS sg13_hv_nmos m=1 w=4.4u l=600.0n ng=1
XMN0_146_ pad gate iovss G1_EXPLICIT_SUBSTRATE_VSS sg13_hv_nmos m=1 w=4.4u l=600.0n ng=1
XMN0_147_ pad gate iovss G1_EXPLICIT_SUBSTRATE_VSS sg13_hv_nmos m=1 w=4.4u l=600.0n ng=1
XMN0_148_ pad gate iovss G1_EXPLICIT_SUBSTRATE_VSS sg13_hv_nmos m=1 w=4.4u l=600.0n ng=1
XMN0_149_ pad gate iovss G1_EXPLICIT_SUBSTRATE_VSS sg13_hv_nmos m=1 w=4.4u l=600.0n ng=1
XMN0_150_ pad gate iovss G1_EXPLICIT_SUBSTRATE_VSS sg13_hv_nmos m=1 w=4.4u l=600.0n ng=1
XMN0_151_ pad gate iovss G1_EXPLICIT_SUBSTRATE_VSS sg13_hv_nmos m=1 w=4.4u l=600.0n ng=1
XMN0_152_ pad gate iovss G1_EXPLICIT_SUBSTRATE_VSS sg13_hv_nmos m=1 w=4.4u l=600.0n ng=1
XMN0_153_ pad gate iovss G1_EXPLICIT_SUBSTRATE_VSS sg13_hv_nmos m=1 w=4.4u l=600.0n ng=1
XMN0_154_ pad gate iovss G1_EXPLICIT_SUBSTRATE_VSS sg13_hv_nmos m=1 w=4.4u l=600.0n ng=1
XMN0_155_ pad gate iovss G1_EXPLICIT_SUBSTRATE_VSS sg13_hv_nmos m=1 w=4.4u l=600.0n ng=1
XMN0_156_ pad gate iovss G1_EXPLICIT_SUBSTRATE_VSS sg13_hv_nmos m=1 w=4.4u l=600.0n ng=1
XMN0_157_ pad gate iovss G1_EXPLICIT_SUBSTRATE_VSS sg13_hv_nmos m=1 w=4.4u l=600.0n ng=1
XMN0_158_ pad gate iovss G1_EXPLICIT_SUBSTRATE_VSS sg13_hv_nmos m=1 w=4.4u l=600.0n ng=1
XMN0_159_ pad gate iovss G1_EXPLICIT_SUBSTRATE_VSS sg13_hv_nmos m=1 w=4.4u l=600.0n ng=1
XMN0_160_ pad gate iovss G1_EXPLICIT_SUBSTRATE_VSS sg13_hv_nmos m=1 w=4.4u l=600.0n ng=1
XMN0_161_ pad gate iovss G1_EXPLICIT_SUBSTRATE_VSS sg13_hv_nmos m=1 w=4.4u l=600.0n ng=1
XMN0_162_ pad gate iovss G1_EXPLICIT_SUBSTRATE_VSS sg13_hv_nmos m=1 w=4.4u l=600.0n ng=1
XMN0_163_ pad gate iovss G1_EXPLICIT_SUBSTRATE_VSS sg13_hv_nmos m=1 w=4.4u l=600.0n ng=1
XMN0_164_ pad gate iovss G1_EXPLICIT_SUBSTRATE_VSS sg13_hv_nmos m=1 w=4.4u l=600.0n ng=1
XMN0_165_ pad gate iovss G1_EXPLICIT_SUBSTRATE_VSS sg13_hv_nmos m=1 w=4.4u l=600.0n ng=1
XMN0_166_ pad gate iovss G1_EXPLICIT_SUBSTRATE_VSS sg13_hv_nmos m=1 w=4.4u l=600.0n ng=1
XMN0_167_ pad gate iovss G1_EXPLICIT_SUBSTRATE_VSS sg13_hv_nmos m=1 w=4.4u l=600.0n ng=1
XMN0_168_ pad gate iovss G1_EXPLICIT_SUBSTRATE_VSS sg13_hv_nmos m=1 w=4.4u l=600.0n ng=1
XMN0_169_ pad gate iovss G1_EXPLICIT_SUBSTRATE_VSS sg13_hv_nmos m=1 w=4.4u l=600.0n ng=1
XMN0_170_ pad gate iovss G1_EXPLICIT_SUBSTRATE_VSS sg13_hv_nmos m=1 w=4.4u l=600.0n ng=1
XMN0_171_ pad gate iovss G1_EXPLICIT_SUBSTRATE_VSS sg13_hv_nmos m=1 w=4.4u l=600.0n ng=1
XMN0_172_ pad gate iovss G1_EXPLICIT_SUBSTRATE_VSS sg13_hv_nmos m=1 w=4.4u l=600.0n ng=1
XR_G1_TAP_SYNTAX_XR0 iovss G1_EXPLICIT_SUBSTRATE_VSS ptap1 R=9.999
* removed (--pads nodcn): DD0 G1_EXPLICIT_SUBSTRATE_VSS gate dantenna m=1 w=480n l=480n a=230.4f p=1.92u
.ends G1_VSS_DERIVATIVE__sg13g2_Clamp_N43N43D4R
.subckt G1_VSS_DERIVATIVE__sg13g2_RCClampResistor pin1 pin2 G1_EXPLICIT_SUBSTRATE_VSS
XRR15 net15 net16 G1_EXPLICIT_SUBSTRATE_VSS rppd l=20u w=1u b=0 m=1
XRR20 net20 net21 G1_EXPLICIT_SUBSTRATE_VSS rppd l=20u w=1u b=0 m=1
XRR23 net23 net24 G1_EXPLICIT_SUBSTRATE_VSS rppd l=20u w=1u b=0 m=1
XRR17 net17 net18 G1_EXPLICIT_SUBSTRATE_VSS rppd l=20u w=1u b=0 m=1
XRR16 net16 net17 G1_EXPLICIT_SUBSTRATE_VSS rppd l=20u w=1u b=0 m=1
XRR25 net25 pin2 G1_EXPLICIT_SUBSTRATE_VSS rppd l=20u w=1u b=0 m=1
XRR22 net22 net23 G1_EXPLICIT_SUBSTRATE_VSS rppd l=20u w=1u b=0 m=1
XRR19 net19 net20 G1_EXPLICIT_SUBSTRATE_VSS rppd l=20u w=1u b=0 m=1
XRR24 net24 net25 G1_EXPLICIT_SUBSTRATE_VSS rppd l=20u w=1u b=0 m=1
XRR21 net21 net22 G1_EXPLICIT_SUBSTRATE_VSS rppd l=20u w=1u b=0 m=1
XRR18 net18 net19 G1_EXPLICIT_SUBSTRATE_VSS rppd l=20u w=1u b=0 m=1
XRR5 net5 net6 G1_EXPLICIT_SUBSTRATE_VSS rppd l=20u w=1u b=0 m=1
XRR8 net8 net9 G1_EXPLICIT_SUBSTRATE_VSS rppd l=20u w=1u b=0 m=1
XRR11 net11 net12 G1_EXPLICIT_SUBSTRATE_VSS rppd l=20u w=1u b=0 m=1
XRR14 net14 net15 G1_EXPLICIT_SUBSTRATE_VSS rppd l=20u w=1u b=0 m=1
XRR2 net2 net3 G1_EXPLICIT_SUBSTRATE_VSS rppd l=20u w=1u b=0 m=1
XRR1 net1 net2 G1_EXPLICIT_SUBSTRATE_VSS rppd l=20u w=1u b=0 m=1
XRR13 net13 net14 G1_EXPLICIT_SUBSTRATE_VSS rppd l=20u w=1u b=0 m=1
XRR10 net10 net11 G1_EXPLICIT_SUBSTRATE_VSS rppd l=20u w=1u b=0 m=1
XRR7 net7 net8 G1_EXPLICIT_SUBSTRATE_VSS rppd l=20u w=1u b=0 m=1
XRR4 net4 net5 G1_EXPLICIT_SUBSTRATE_VSS rppd l=20u w=1u b=0 m=1
XRR12 net12 net13 G1_EXPLICIT_SUBSTRATE_VSS rppd l=20u w=1u b=0 m=1
XRR9 net9 net10 G1_EXPLICIT_SUBSTRATE_VSS rppd l=20u w=1u b=0 m=1
XRR6 net6 net7 G1_EXPLICIT_SUBSTRATE_VSS rppd l=20u w=1u b=0 m=1
XRR3 net3 net4 G1_EXPLICIT_SUBSTRATE_VSS rppd l=20u w=1u b=0 m=1
XRR0 pin1 net1 G1_EXPLICIT_SUBSTRATE_VSS rppd l=20u w=1u b=0 m=1
.ends G1_VSS_DERIVATIVE__sg13g2_RCClampResistor
.subckt G1_VSS_DERIVATIVE__sg13g2_RCClampInverter out in iovss supply G1_EXPLICIT_SUBSTRATE_VSS
XMN1 iovss in iovss G1_EXPLICIT_SUBSTRATE_VSS sg13_hv_nmos m=1 w=63.000u l=9.5u ng=7
XMN3 out in iovss G1_EXPLICIT_SUBSTRATE_VSS sg13_hv_nmos m=1 w=54.000u l=500.0n ng=6
XMN0 iovss in iovss G1_EXPLICIT_SUBSTRATE_VSS sg13_hv_nmos m=1 w=63.000u l=9.5u ng=7
XMN2 out in iovss G1_EXPLICIT_SUBSTRATE_VSS sg13_hv_nmos m=1 w=54.000u l=500.0n ng=6
XR_G1_TAP_SYNTAX_XR0 iovss G1_EXPLICIT_SUBSTRATE_VSS ptap1 R=9.59
XMP0 out in supply supply sg13_hv_pmos m=1 w=350.000u l=500.0n ng=50
.ends G1_VSS_DERIVATIVE__sg13g2_RCClampInverter
.subckt G1_VSS_DERIVATIVE__sg13g2_IOPadVdd vdd vss iovdd iovss G1_EXPLICIT_SUBSTRATE_VSS
XI1 net3 iovss vdd G1_EXPLICIT_SUBSTRATE_VSS G1_VSS_DERIVATIVE__sg13g2_Clamp_N43N43D4R
XI4 vdd net1 G1_EXPLICIT_SUBSTRATE_VSS G1_VSS_DERIVATIVE__sg13g2_RCClampResistor
XR_G1_TAP_SYNTAX_XR1 iovss G1_EXPLICIT_SUBSTRATE_VSS ptap1 R=456.33m
XR_G1_TAP_SYNTAX_XR0 vss G1_EXPLICIT_SUBSTRATE_VSS ptap1 R=22.472
XI3 net3 net1 iovss vdd G1_EXPLICIT_SUBSTRATE_VSS G1_VSS_DERIVATIVE__sg13g2_RCClampInverter
.ends G1_VSS_DERIVATIVE__sg13g2_IOPadVdd
.subckt G1_VSS_DERIVATIVE__sg13g2_DCNDiode anode cathode guard G1_EXPLICIT_SUBSTRATE_VSS
* removed (--pads nodcn): DD1 G1_EXPLICIT_SUBSTRATE_VSS cathode dantenna m=1 w=1.26u l=27.78u a=35.003p p=58.08u
* removed (--pads nodcn): DD0 G1_EXPLICIT_SUBSTRATE_VSS cathode dantenna m=1 w=1.26u l=27.78u a=35.003p p=58.08u
XR_G1_TAP_SYNTAX_XR0 anode G1_EXPLICIT_SUBSTRATE_VSS ptap1 R=5.191
.ends G1_VSS_DERIVATIVE__sg13g2_DCNDiode
.subckt G1_VSS_DERIVATIVE__sg13g2_DCPDiode anode cathode guard G1_EXPLICIT_SUBSTRATE_VSS
XDD1 anode cathode dpantenna m=1 w=1.26u l=27.78u
XDD0 anode cathode dpantenna m=1 w=1.26u l=27.78u
XR_G1_TAP_SYNTAX_XR0 guard G1_EXPLICIT_SUBSTRATE_VSS ptap1 R=17.289
.ends G1_VSS_DERIVATIVE__sg13g2_DCPDiode
.subckt G1_VSS_DERIVATIVE__sg13g2_IOPadVss vdd vss iovdd iovss G1_EXPLICIT_SUBSTRATE_VSS
XI1 iovss vss iovdd G1_EXPLICIT_SUBSTRATE_VSS G1_VSS_DERIVATIVE__sg13g2_DCNDiode
XI2 vss iovdd iovss G1_EXPLICIT_SUBSTRATE_VSS G1_VSS_DERIVATIVE__sg13g2_DCPDiode
XR_G1_TAP_SYNTAX_XR1 iovss G1_EXPLICIT_SUBSTRATE_VSS ptap1 R=174.346m
XR_G1_TAP_SYNTAX_XR0 vss G1_EXPLICIT_SUBSTRATE_VSS ptap1 R=22.832
.ends G1_VSS_DERIVATIVE__sg13g2_IOPadVss
.subckt G1_VSS_DERIVATIVE__sg13g2_IOPadIOVdd vdd vss iovdd iovss G1_EXPLICIT_SUBSTRATE_VSS
XI1 net4 iovss iovdd G1_EXPLICIT_SUBSTRATE_VSS G1_VSS_DERIVATIVE__sg13g2_Clamp_N43N43D4R
XI3 iovdd net1 G1_EXPLICIT_SUBSTRATE_VSS G1_VSS_DERIVATIVE__sg13g2_RCClampResistor
XI2 net4 net1 iovss iovdd G1_EXPLICIT_SUBSTRATE_VSS G1_VSS_DERIVATIVE__sg13g2_RCClampInverter
XR_G1_TAP_SYNTAX_XR0 vss G1_EXPLICIT_SUBSTRATE_VSS ptap1 R=22.472
XR_G1_TAP_SYNTAX_XR1 iovss G1_EXPLICIT_SUBSTRATE_VSS ptap1 R=453.388m
.ends G1_VSS_DERIVATIVE__sg13g2_IOPadIOVdd
.subckt G1_VSS_DERIVATIVE__sg13g2_IOPadIOVss vdd vss iovdd iovss G1_EXPLICIT_SUBSTRATE_VSS
XI3 iovss iovss iovdd G1_EXPLICIT_SUBSTRATE_VSS G1_VSS_DERIVATIVE__sg13g2_DCNDiode
XI2 iovss iovdd iovss G1_EXPLICIT_SUBSTRATE_VSS G1_VSS_DERIVATIVE__sg13g2_DCPDiode
XR_G1_TAP_SYNTAX_XR1 vss G1_EXPLICIT_SUBSTRATE_VSS ptap1 R=22.472
XR_G1_TAP_SYNTAX_XR0 iovss G1_EXPLICIT_SUBSTRATE_VSS ptap1 R=169.45m
.ends G1_VSS_DERIVATIVE__sg13g2_IOPadIOVss
.subckt G1_VSS_DERIVATIVE__sg13g2_Clamp_P20N0D iovdd iovss pad G1_EXPLICIT_SUBSTRATE_VSS
XMP1 pad net2 iovdd iovdd sg13_hv_pmos m=1 w=133.2u l=600.0n ng=20
XMP0 pad net2 iovdd iovdd sg13_hv_pmos m=1 w=133.2u l=600.0n ng=20
XRR0 net2 iovdd iovdd rppd l=12.9u w=500n b=0 m=1
XR_G1_TAP_SYNTAX_XR1 iovss G1_EXPLICIT_SUBSTRATE_VSS ptap1 R=9.826
.ends G1_VSS_DERIVATIVE__sg13g2_Clamp_P20N0D
.subckt G1_VSS_DERIVATIVE__sg13g2_SecondaryProtection core minus pad plus G1_EXPLICIT_SUBSTRATE_VSS
XRR0 pad core G1_EXPLICIT_SUBSTRATE_VSS rppd m=1 l=2u w=1u b=0
* removed (--pads nodcn): DD1 G1_EXPLICIT_SUBSTRATE_VSS core dantenna m=1 w=640n l=3.1u a=1.984p p=7.48u
XR_G1_TAP_SYNTAX_XR1 minus G1_EXPLICIT_SUBSTRATE_VSS ptap1 R=46.556
XDD0 core plus dpantenna m=1 w=640n l=4.98u
.ends G1_VSS_DERIVATIVE__sg13g2_SecondaryProtection
.subckt G1_VSS_DERIVATIVE__sg13g2_Clamp_N20N0D iovss pad G1_EXPLICIT_SUBSTRATE_VSS
XMN0 pad net2 iovss G1_EXPLICIT_SUBSTRATE_VSS sg13_hv_nmos m=1 w=88.000u l=600.0n ng=20
XR_G1_TAP_SYNTAX_XR1 iovss G1_EXPLICIT_SUBSTRATE_VSS ptap1 R=11.438
XRR0 iovss net2 G1_EXPLICIT_SUBSTRATE_VSS rppd l=3.54u w=500n b=0 m=1
.ends G1_VSS_DERIVATIVE__sg13g2_Clamp_N20N0D
.subckt G1_VSS_DERIVATIVE__sg13g2_IOPadAnalog pad padres vdd vss iovdd iovss G1_EXPLICIT_SUBSTRATE_VSS
XI0 iovdd iovss pad G1_EXPLICIT_SUBSTRATE_VSS G1_VSS_DERIVATIVE__sg13g2_Clamp_P20N0D
XI5 iovss pad iovdd G1_EXPLICIT_SUBSTRATE_VSS G1_VSS_DERIVATIVE__sg13g2_DCNDiode
XI2 pad iovdd iovss G1_EXPLICIT_SUBSTRATE_VSS G1_VSS_DERIVATIVE__sg13g2_DCPDiode
XI3 padres iovss pad iovdd G1_EXPLICIT_SUBSTRATE_VSS G1_VSS_DERIVATIVE__sg13g2_SecondaryProtection
XI4 iovss pad G1_EXPLICIT_SUBSTRATE_VSS G1_VSS_DERIVATIVE__sg13g2_Clamp_N20N0D
XR_G1_TAP_SYNTAX_XR0 vss G1_EXPLICIT_SUBSTRATE_VSS ptap1 R=22.579
XR_G1_TAP_SYNTAX_XR1 iovss G1_EXPLICIT_SUBSTRATE_VSS ptap1 R=214.8m
.ends G1_VSS_DERIVATIVE__sg13g2_IOPadAnalog
.subckt G1_VSS_DERIVATIVE__sg13g2_LevelUpInv o i iovdd vdd vss G1_EXPLICIT_SUBSTRATE_VSS
XMN1 net2 i vss G1_EXPLICIT_SUBSTRATE_VSS sg13_lv_nmos m=1 w=2.75u l=130.00n ng=1
XMP3 net2 i vdd vdd sg13_lv_pmos m=1 w=4.75u l=130.00n ng=1
XMN0 o net4 vss G1_EXPLICIT_SUBSTRATE_VSS sg13_hv_nmos m=1 w=1.9u l=450.00n ng=1
XMN3 net4 net2 vss G1_EXPLICIT_SUBSTRATE_VSS sg13_hv_nmos m=1 w=1.9u l=450.00n ng=1
XMN2 net3 i vss G1_EXPLICIT_SUBSTRATE_VSS sg13_hv_nmos m=1 w=1.9u l=450.00n ng=1
XMP0 o net4 iovdd iovdd sg13_hv_pmos m=1 w=3.9u l=450.00n ng=1
XMP1 net3 net4 iovdd iovdd sg13_hv_pmos m=1 w=300.0n l=450.00n ng=1
XMP2 net4 net3 iovdd iovdd sg13_hv_pmos m=1 w=300.0n l=450.00n ng=1
XR_G1_TAP_SYNTAX_XR0 vss G1_EXPLICIT_SUBSTRATE_VSS ptap1 R=190.268
.ends G1_VSS_DERIVATIVE__sg13g2_LevelUpInv
.subckt G1_VSS_DERIVATIVE__sg13g2_GateLevelUpInv ngate pgate iovdd core vdd vss G1_EXPLICIT_SUBSTRATE_VSS
XI1 pgate core iovdd vdd vss G1_EXPLICIT_SUBSTRATE_VSS G1_VSS_DERIVATIVE__sg13g2_LevelUpInv
XI0 ngate core iovdd vdd vss G1_EXPLICIT_SUBSTRATE_VSS G1_VSS_DERIVATIVE__sg13g2_LevelUpInv
.ends G1_VSS_DERIVATIVE__sg13g2_GateLevelUpInv
.subckt G1_VSS_DERIVATIVE__sg13g2_Clamp_P15N15D gate iovdd iovss pad G1_EXPLICIT_SUBSTRATE_VSS
XDD0 gate iovdd dpantenna m=1 w=780.00n l=780.00n
XR_G1_TAP_SYNTAX_XR0 iovss G1_EXPLICIT_SUBSTRATE_VSS ptap1 R=9.826
XMP1 pad gate iovdd iovdd sg13_hv_pmos m=1 w=99.9u l=600.0n ng=15
XMP0 pad gate iovdd iovdd sg13_hv_pmos m=1 w=99.9u l=600.0n ng=15
.ends G1_VSS_DERIVATIVE__sg13g2_Clamp_P15N15D
.subckt G1_VSS_DERIVATIVE__sg13g2_Clamp_N15N15D gate iovss pad G1_EXPLICIT_SUBSTRATE_VSS
XR_G1_TAP_SYNTAX_XR0 iovss G1_EXPLICIT_SUBSTRATE_VSS ptap1 R=11.438
XMN0 pad gate iovss G1_EXPLICIT_SUBSTRATE_VSS sg13_hv_nmos m=1 w=66.000u l=600.0n ng=15
* removed (--pads nodcn): DD0 G1_EXPLICIT_SUBSTRATE_VSS gate dantenna m=1 w=780.00n l=780.00n a=608.400f p=3.12u
.ends G1_VSS_DERIVATIVE__sg13g2_Clamp_N15N15D
.subckt G1_VSS_DERIVATIVE__sg13g2_IOPadOut30mA pad c2p vdd vss iovdd iovss G1_EXPLICIT_SUBSTRATE_VSS
XI2 net2 net1 iovdd c2p vdd vss G1_EXPLICIT_SUBSTRATE_VSS G1_VSS_DERIVATIVE__sg13g2_GateLevelUpInv
XI1 net1 iovdd iovss pad G1_EXPLICIT_SUBSTRATE_VSS G1_VSS_DERIVATIVE__sg13g2_Clamp_P15N15D
XI3 net2 iovss pad G1_EXPLICIT_SUBSTRATE_VSS G1_VSS_DERIVATIVE__sg13g2_Clamp_N15N15D
XI4 iovss pad iovdd G1_EXPLICIT_SUBSTRATE_VSS G1_VSS_DERIVATIVE__sg13g2_DCNDiode
XI0 pad iovdd iovss G1_EXPLICIT_SUBSTRATE_VSS G1_VSS_DERIVATIVE__sg13g2_DCPDiode
XR_G1_TAP_SYNTAX_XR0 vss G1_EXPLICIT_SUBSTRATE_VSS ptap1 R=24.125
XR_G1_TAP_SYNTAX_XR1 iovss G1_EXPLICIT_SUBSTRATE_VSS ptap1 R=214.165m
.ends G1_VSS_DERIVATIVE__sg13g2_IOPadOut30mA
.subckt G1_VSS_DERIVATIVE__sg13g2_Clamp_P2N2D gate iovdd iovss pad G1_EXPLICIT_SUBSTRATE_VSS
XDD0 gate iovdd dpantenna m=1 w=480n l=480n
XMP1 pad gate iovdd iovdd sg13_hv_pmos m=1 w=13.32u l=600.0n ng=2
XMP0 pad gate iovdd iovdd sg13_hv_pmos m=1 w=13.32u l=600.0n ng=2
XR_G1_TAP_SYNTAX_XR0 iovss G1_EXPLICIT_SUBSTRATE_VSS ptap1 R=9.826
.ends G1_VSS_DERIVATIVE__sg13g2_Clamp_P2N2D
.subckt G1_VSS_DERIVATIVE__sg13g2_Clamp_N2N2D gate iovss pad G1_EXPLICIT_SUBSTRATE_VSS
XR_G1_TAP_SYNTAX_XR0 iovss G1_EXPLICIT_SUBSTRATE_VSS ptap1 R=11.438
XMN1 pad gate iovss G1_EXPLICIT_SUBSTRATE_VSS sg13_hv_nmos m=1 w=8.8u l=600.0n ng=2
* removed (--pads nodcn): DD0 G1_EXPLICIT_SUBSTRATE_VSS gate dantenna m=1 w=780.00n l=780.00n a=608.400f p=3.12u
.ends G1_VSS_DERIVATIVE__sg13g2_Clamp_N2N2D
.subckt G1_VSS_DERIVATIVE__sg13g2_IOPadOut4mA pad c2p vdd vss iovdd iovss G1_EXPLICIT_SUBSTRATE_VSS
XI2 net2 net1 iovdd c2p vdd vss G1_EXPLICIT_SUBSTRATE_VSS G1_VSS_DERIVATIVE__sg13g2_GateLevelUpInv
XI0 net1 iovdd iovss pad G1_EXPLICIT_SUBSTRATE_VSS G1_VSS_DERIVATIVE__sg13g2_Clamp_P2N2D
XI3 net2 iovss pad G1_EXPLICIT_SUBSTRATE_VSS G1_VSS_DERIVATIVE__sg13g2_Clamp_N2N2D
XI4 iovss pad iovdd G1_EXPLICIT_SUBSTRATE_VSS G1_VSS_DERIVATIVE__sg13g2_DCNDiode
XI1 pad iovdd iovss G1_EXPLICIT_SUBSTRATE_VSS G1_VSS_DERIVATIVE__sg13g2_DCPDiode
XR_G1_TAP_SYNTAX_XR1 iovss G1_EXPLICIT_SUBSTRATE_VSS ptap1 R=212.747m
XR_G1_TAP_SYNTAX_XR0 vss G1_EXPLICIT_SUBSTRATE_VSS ptap1 R=24.125
.ends G1_VSS_DERIVATIVE__sg13g2_IOPadOut4mA
.subckt G1_VSS_DERIVATIVE__sg13g2_LevelDown core pad iovdd iovss vdd vss G1_EXPLICIT_SUBSTRATE_VSS
XMP0 vdd vdd vdd vdd sg13_hv_pmos m=1 w=4.65u l=450.00n ng=1
XMP2 net4 net7 iovdd iovdd sg13_hv_pmos m=1 w=4.6u l=450.00n ng=2
XMP3 net7 net1 iovdd iovdd sg13_hv_pmos m=1 w=4.6u l=450.00n ng=2
XMN3 net4 net7 iovss G1_EXPLICIT_SUBSTRATE_VSS sg13_hv_nmos m=1 w=1.3u l=450.00n ng=1
XMN4 net7 net1 iovss G1_EXPLICIT_SUBSTRATE_VSS sg13_hv_nmos m=1 w=1.3u l=450.00n ng=1
XMN2 net2 net4 vss G1_EXPLICIT_SUBSTRATE_VSS sg13_hv_nmos m=1 w=2.65u l=450.00n ng=1
XMN0 vdd net7 net2 G1_EXPLICIT_SUBSTRATE_VSS sg13_hv_nmos m=1 w=2.65u l=450.00n ng=1
XMN1 core net2 vss G1_EXPLICIT_SUBSTRATE_VSS sg13_lv_nmos m=1 w=2.75u l=130.00n ng=1
XMP1 core net2 vdd vdd sg13_lv_pmos m=1 w=4.75u l=130.00n ng=1
XR_G1_TAP_SYNTAX_XR1 iovss G1_EXPLICIT_SUBSTRATE_VSS ptap1 R=199.584
XR_G1_TAP_SYNTAX_XR0 vss G1_EXPLICIT_SUBSTRATE_VSS ptap1 R=127.332
XI0 net1 iovss pad iovdd G1_EXPLICIT_SUBSTRATE_VSS G1_VSS_DERIVATIVE__sg13g2_SecondaryProtection
.ends G1_VSS_DERIVATIVE__sg13g2_LevelDown
.subckt G1_VSS_DERIVATIVE__sg13g2_IOPadIn pad p2c vdd vss iovdd iovss G1_EXPLICIT_SUBSTRATE_VSS
XI0 p2c pad iovdd iovss vdd vss G1_EXPLICIT_SUBSTRATE_VSS G1_VSS_DERIVATIVE__sg13g2_LevelDown
XI2 iovss pad iovdd G1_EXPLICIT_SUBSTRATE_VSS G1_VSS_DERIVATIVE__sg13g2_DCNDiode
XI1 pad iovdd iovss G1_EXPLICIT_SUBSTRATE_VSS G1_VSS_DERIVATIVE__sg13g2_DCPDiode
XR_G1_TAP_SYNTAX_XR0 vss G1_EXPLICIT_SUBSTRATE_VSS ptap1 R=24.69
XR_G1_TAP_SYNTAX_XR1 iovss G1_EXPLICIT_SUBSTRATE_VSS ptap1 R=173.674m
.ends G1_VSS_DERIVATIVE__sg13g2_IOPadIn
.subckt G1_VSS_DERIVATIVE__sg13g2_Clamp_P8N8D gate iovdd iovss pad G1_EXPLICIT_SUBSTRATE_VSS
XR_G1_TAP_SYNTAX_XR0 iovss G1_EXPLICIT_SUBSTRATE_VSS ptap1 R=9.826
XMP2 pad gate iovdd iovdd sg13_hv_pmos m=1 w=53.28u l=600.0n ng=8
XMP0 pad gate iovdd iovdd sg13_hv_pmos m=1 w=53.28u l=600.0n ng=8
XDD0 gate iovdd dpantenna m=1 w=480n l=480n
.ends G1_VSS_DERIVATIVE__sg13g2_Clamp_P8N8D
.subckt G1_VSS_DERIVATIVE__sg13g2_Clamp_N8N8D gate iovss pad G1_EXPLICIT_SUBSTRATE_VSS
XR_G1_TAP_SYNTAX_XR0 iovss G1_EXPLICIT_SUBSTRATE_VSS ptap1 R=11.438
XMN0 pad gate iovss G1_EXPLICIT_SUBSTRATE_VSS sg13_hv_nmos m=1 w=35.2u l=600.0n ng=8
* removed (--pads nodcn): DD0 G1_EXPLICIT_SUBSTRATE_VSS gate dantenna m=1 w=780.00n l=780.00n a=608.400f p=3.12u
.ends G1_VSS_DERIVATIVE__sg13g2_Clamp_N8N8D
.subckt G1_VSS_DERIVATIVE__sg13g2_IOPadOut16mA pad c2p vdd vss iovdd iovss G1_EXPLICIT_SUBSTRATE_VSS
XI2 net2 net1 iovdd c2p vdd vss G1_EXPLICIT_SUBSTRATE_VSS G1_VSS_DERIVATIVE__sg13g2_GateLevelUpInv
XI0 net1 iovdd iovss pad G1_EXPLICIT_SUBSTRATE_VSS G1_VSS_DERIVATIVE__sg13g2_Clamp_P8N8D
XI4 iovss pad iovdd G1_EXPLICIT_SUBSTRATE_VSS G1_VSS_DERIVATIVE__sg13g2_DCNDiode
XI3 net2 iovss pad G1_EXPLICIT_SUBSTRATE_VSS G1_VSS_DERIVATIVE__sg13g2_Clamp_N8N8D
XI1 pad iovdd iovss G1_EXPLICIT_SUBSTRATE_VSS G1_VSS_DERIVATIVE__sg13g2_DCPDiode
XR_G1_TAP_SYNTAX_XR0 vss G1_EXPLICIT_SUBSTRATE_VSS ptap1 R=23.888
XR_G1_TAP_SYNTAX_XR1 iovss G1_EXPLICIT_SUBSTRATE_VSS ptap1 R=208.667m
.ends G1_VSS_DERIVATIVE__sg13g2_IOPadOut16mA
* g1_digital replaced by the real RTL (XSPICE d_cosim, rtl/g1_dig_cosim_cdl.v); CDL port list kept; por_n: the wrapper ties
* por_n = 1 (the CDL drives it from sg13g2_tiehi); en/sclk/sdi/osc_clk through the single-threshold receiver
.subckt g1_digital bgr_r4 clk_div_out clr_d cmp_clk cmp_hard cmp_soft en fast_en fault_n gate_en osc_clk osc_en por_n sclk sdi sdo t2f_en t2f_mode trip trip_d trip_set_sel tripped VDD VSS dac_hard_7_ dac_hard_6_ dac_hard_5_ dac_hard_4_ dac_hard_3_ dac_hard_2_ dac_hard_1_ dac_hard_0_ dac_soft_7_ dac_soft_6_ dac_soft_5_ dac_soft_4_ dac_soft_3_ dac_soft_2_ dac_soft_1_ dac_soft_0_ osc_trim_3_ osc_trim_2_ osc_trim_1_ osc_trim_0_ trip_cause_1_ trip_cause_0_
aclock [osc_clk] [d_osc_clk] adc_clock
ain [en sclk sdi] [d_en d_sclk d_sdi] adc_clock
aadc [cmp_soft cmp_hard tripped] [d_cmp_soft d_cmp_hard d_tripped] adc
adig [d_osc_clk d_en d_sclk d_sdi d_cmp_soft d_cmp_hard d_tripped] [d_cmp_clk d_s7 d_s6 d_s5 d_s4 d_s3 d_s2 d_s1 d_s0 d_h7 d_h6 d_h5 d_h4 d_h3 d_h2 d_h1 d_h0 d_trip_d d_clr_d d_fast_en d_osc_en d_t3 d_t2 d_t1 d_t0 d_trip d_gate_en d_cause1 d_cause0 d_sdo d_sp15 d_sp14 d_sp13 d_sp12 d_sp11 d_sp10 d_sp9 d_sp8 d_sp7 d_sp6 d_sp5 d_sp4 d_sp3 d_sp2 d_sp1 d_sp0 d_inrush d_softarmed d_t2f_en d_t2f_mode d_bgr_r4 d_fault_n d_trip_set_sel d_clk_div_out] rtl
adac [d_cmp_clk d_s7 d_s6 d_s5 d_s4 d_s3 d_s2 d_s1 d_s0 d_h7 d_h6 d_h5 d_h4 d_h3 d_h2 d_h1 d_h0 d_trip_d d_clr_d d_fast_en d_osc_en d_t3 d_t2 d_t1 d_t0 d_trip d_gate_en d_cause1 d_cause0 d_sdo d_sp15 d_sp14 d_sp13 d_sp12 d_sp11 d_sp10 d_sp9 d_sp8 d_sp7 d_sp6 d_sp5 d_sp4 d_sp3 d_sp2 d_sp1 d_sp0 d_inrush d_softarmed d_t2f_en d_t2f_mode d_bgr_r4 d_fault_n d_trip_set_sel d_clk_div_out] [cmp_clk dac_soft_7_ dac_soft_6_ dac_soft_5_ dac_soft_4_ dac_soft_3_ dac_soft_2_ dac_soft_1_ dac_soft_0_ dac_hard_7_ dac_hard_6_ dac_hard_5_ dac_hard_4_ dac_hard_3_ dac_hard_2_ dac_hard_1_ dac_hard_0_ trip_d clr_d fast_en osc_en osc_trim_3_ osc_trim_2_ osc_trim_1_ osc_trim_0_ trip gate_en trip_cause_1_ trip_cause_0_ sdo sp15 sp14 sp13 sp12 sp11 sp10 sp9 sp8 sp7 sp6 sp5 sp4 sp3 sp2 sp1 sp0 inrush_active soft_armed t2f_en t2f_mode bgr_r4 fault_n trip_set_sel clk_div_out] dac
.ends
* g1_osc replaced (--osc ideal): ideal 9.436194721 MHz clock of run_top.py, gated by en; no supply current
.subckt g1_osc en trim_0_ trim_1_ trim_2_ trim_3_ osc_clk VDD VSS
Vosc_i osc_i VSS pulse(0 1.2 1e-07 1n 1n 5.19875e-08 1.05975e-07)
Ben_g en_g VSS V = v(en, VSS) * min(1, max(0, (time - 0.1u) / 50n))
Bosc_clk osc_clk VSS V = v(osc_i, VSS) * (0.5 + 0.5*tanh((v(en_g, VSS) - 0.6)/0.05))
Rosc_vdd VDD VSS 1e12
.ends
* g1_chip_top: deck-local copy of the CDL top; 4867 filler/decap/antenna instances merged into 34 (m=count);
* supply-pin ammeters vm_bgr on VDDA, vm_gatea on VDDA, vm_gated on VDD, vm_ls on VDDA, vm_lsd on VDD, vm_osc on VDD, vm_sense on VDDA, vm_t2f on VDDA, vm_t2fd on VDD, vm_tripa on VDDA, vm_tripd on VDD
.subckt g1_chip_top D_ELT D_STD EN FAULT_N GATE G_SHARED HBT_B HBT_C HBT_E SCLK SDI SDO SENSE_N SENSE_P TEMP_OUT TRIP_SET VDDA VREF VDD VSS IOVDD IOVSS
Xi_core_u_bgr VDDA__vm_bgr VSS i_core_bgr_r4_33 i_core_vref i_core_iptat i_core_pbias i_core_pcasc i_core_unused_vbe i_core_dvbe g1_bgr
Xi_core_u_digital i_core_bgr_r4_12 i_core_clk_div_out i_core_clr_d i_core_cmp_clk i_core_cmp_hard i_core_cmp_soft en_i i_core_fast_en i_core_fault_n_dig i_core_gate_en i_core_osc_clk i_core_osc_en net i_core_sclk_i i_core_sdi_i i_core_sdo_o i_core_t2f_en_12 i_core_t2f_mode_12 i_core_trip i_core_trip_d i_core_trip_set_sel i_core_tripped VDD VSS i_core_dac_hard_7_ i_core_dac_hard_6_ i_core_dac_hard_5_ i_core_dac_hard_4_ i_core_dac_hard_3_ i_core_dac_hard_2_ i_core_dac_hard_1_ i_core_dac_hard_0_ i_core_dac_soft_7_ i_core_dac_soft_6_ i_core_dac_soft_5_ i_core_dac_soft_4_ i_core_dac_soft_3_ i_core_dac_soft_2_ i_core_dac_soft_1_ i_core_dac_soft_0_ i_core_osc_trim_3_ i_core_osc_trim_2_ i_core_osc_trim_1_ i_core_osc_trim_0_ i_core_trip_cause_1_ i_core_trip_cause_0_ g1_digital
Xi_core_u_digital_1 net VDD VSS sg13g2_tiehi
Xi_core_u_dose D_ELT D_STD G_SHARED VSS g1_dose_macro
Xi_core_u_dut HBT_C HBT_B HBT_E VSS g1_dut_macro
Xi_core_u_gate i_core_trip_d i_core_clr_d i_core_fast_en i_core_cmp_hard en_i gate_o fault_n_o i_core_tripped VDD__vm_gated VDDA__vm_gatea VSS g1_gate
Xi_core_u_ls_en i_core_t2f_en_12 i_core_t2f_en_33 VDD__vm_lsd VDDA__vm_ls VSS g1_ls_up
Xi_core_u_ls_mode i_core_t2f_mode_12 i_core_t2f_mode_33 VDD__vm_lsd VDDA__vm_ls VSS g1_ls_up
Xi_core_u_ls_r4 i_core_bgr_r4_12 i_core_bgr_r4_33 VDD VDDA VSS g1_ls_up
Xi_core_u_osc i_core_osc_en i_core_osc_trim_0_ i_core_osc_trim_1_ i_core_osc_trim_2_ i_core_osc_trim_3_ i_core_osc_clk VDD__vm_osc VSS g1_osc
Xi_core_u_sense SENSE_P SENSE_N i_core_vref i_core_iptat i_core_isense i_core_unused_vped i_core_vref_buf VDDA__vm_sense VSS g1_sense
Xi_core_u_t2f VDDA__vm_t2f VDD__vm_t2fd VSS i_core_pbias i_core_pcasc i_core_vref i_core_t2f_en_33 i_core_t2f_mode_33 i_core_temp_out_o g1_t2f
Xi_core_u_trip i_core_isense i_core_vref_buf i_core_cmp_clk i_core_dac_soft_0_ i_core_dac_soft_1_ i_core_dac_soft_2_ i_core_dac_soft_3_ i_core_dac_soft_4_ i_core_dac_soft_5_ i_core_dac_soft_6_ i_core_dac_soft_7_ i_core_dac_hard_0_ i_core_dac_hard_1_ i_core_dac_hard_2_ i_core_dac_hard_3_ i_core_dac_hard_4_ i_core_dac_hard_5_ i_core_dac_hard_6_ i_core_dac_hard_7_ i_core_cmp_soft i_core_cmp_hard VDD__vm_tripd VDDA__vm_tripa VSS g1_trip
Xpad01_vdd VDD VSS IOVDD IOVSS VSS G1_VSS_DERIVATIVE__sg13g2_IOPadVdd
Xpad02_vss VDD VSS IOVDD IOVSS VSS G1_VSS_DERIVATIVE__sg13g2_IOPadVss
Xpad03_iovdd VDD VSS IOVDD IOVSS VSS G1_VSS_DERIVATIVE__sg13g2_IOPadIOVdd
Xpad04_iovss VDD VSS IOVDD IOVSS VSS G1_VSS_DERIVATIVE__sg13g2_IOPadIOVss
Xpad05_vss VDD VSS IOVDD IOVSS VSS G1_VSS_DERIVATIVE__sg13g2_IOPadVss
Xpad06_iovss VDD VSS IOVDD IOVSS VSS G1_VSS_DERIVATIVE__sg13g2_IOPadIOVss
Xpad07_vdda VDDA _nc1 VDD VSS IOVDD IOVSS VSS G1_VSS_DERIVATIVE__sg13g2_IOPadAnalog
Xpad08_sense_p SENSE_P _nc2 VDD VSS IOVDD IOVSS VSS G1_VSS_DERIVATIVE__sg13g2_IOPadAnalog
Xpad09_sense_n SENSE_N _nc3 VDD VSS IOVDD IOVSS VSS G1_VSS_DERIVATIVE__sg13g2_IOPadAnalog
Xpad10_gate GATE gate_o VDD VSS IOVDD IOVSS VSS G1_VSS_DERIVATIVE__sg13g2_IOPadOut30mA
Xpad11_fault_n FAULT_N fault_n_o VDD VSS IOVDD IOVSS VSS G1_VSS_DERIVATIVE__sg13g2_IOPadOut4mA
Xpad12_en EN en_i VDD VSS IOVDD IOVSS VSS G1_VSS_DERIVATIVE__sg13g2_IOPadIn
Xpad13_trip_set TRIP_SET i_core_trip_set VDD VSS IOVDD IOVSS VSS G1_VSS_DERIVATIVE__sg13g2_IOPadAnalog
Xpad14_sclk SCLK i_core_sclk_i VDD VSS IOVDD IOVSS VSS G1_VSS_DERIVATIVE__sg13g2_IOPadIn
Xpad15_sdi SDI i_core_sdi_i VDD VSS IOVDD IOVSS VSS G1_VSS_DERIVATIVE__sg13g2_IOPadIn
Xpad16_sdo SDO i_core_sdo_o VDD VSS IOVDD IOVSS VSS G1_VSS_DERIVATIVE__sg13g2_IOPadOut4mA
Xpad17_temp_out TEMP_OUT i_core_temp_out_o VDD VSS IOVDD IOVSS VSS G1_VSS_DERIVATIVE__sg13g2_IOPadOut16mA
Xpad18_vref VREF i_core_vref VDD VSS IOVDD IOVSS VSS G1_VSS_DERIVATIVE__sg13g2_IOPadAnalog
Xpad19_g_shared G_SHARED _nc4 VDD VSS IOVDD IOVSS VSS G1_VSS_DERIVATIVE__sg13g2_IOPadAnalog
Xpad20_d_std D_STD _nc5 VDD VSS IOVDD IOVSS VSS G1_VSS_DERIVATIVE__sg13g2_IOPadAnalog
Xpad21_d_elt D_ELT _nc6 VDD VSS IOVDD IOVSS VSS G1_VSS_DERIVATIVE__sg13g2_IOPadAnalog
Xpad22_hbt_e HBT_E _nc7 VDD VSS IOVDD IOVSS VSS G1_VSS_DERIVATIVE__sg13g2_IOPadAnalog
Xpad23_hbt_b HBT_B _nc8 VDD VSS IOVDD IOVSS VSS G1_VSS_DERIVATIVE__sg13g2_IOPadAnalog
Xpad24_hbt_c HBT_C _nc9 VDD VSS IOVDD IOVSS VSS G1_VSS_DERIVATIVE__sg13g2_IOPadAnalog
XANTENNA_1 en_i VDD VSS sg13g2_antennanp
XANTENNA_2 i_core_cmp_soft VDD VSS sg13g2_antennanp m=2
XANTENNA_4 i_core_sdi_i VDD VSS sg13g2_antennanp
XANTENNA_5 i_core_tripped VDD VSS sg13g2_antennanp m=2
XFILLER_0_1006 VDD VSS sg13g2_decap_8 m=4645
XFILLER_0_1293 VDD VSS sg13g2_fill_2 m=38
XFILLER_17_2 VDD VSS sg13g2_fill_1 m=21
XFILLER_17_740 VDD VSS sg13g2_decap_4 m=17
XIO_BOND_pad01_vdd VDD bondpad_70x70_tm1
XIO_BOND_pad02_vss VSS bondpad_70x70_tm1 m=2
XIO_BOND_pad03_iovdd IOVDD bondpad_70x70_tm1
XIO_BOND_pad04_iovss IOVSS bondpad_70x70_tm1 m=2
XIO_BOND_pad07_vdda VDDA bondpad_70x70_tm1
XIO_BOND_pad08_sense_p SENSE_P bondpad_70x70_tm1
XIO_BOND_pad09_sense_n SENSE_N bondpad_70x70_tm1
XIO_BOND_pad10_gate GATE bondpad_70x70_tm1
XIO_BOND_pad11_fault_n FAULT_N bondpad_70x70_tm1
XIO_BOND_pad12_en EN bondpad_70x70_tm1
XIO_BOND_pad13_trip_set TRIP_SET bondpad_70x70_tm1
XIO_BOND_pad14_sclk SCLK bondpad_70x70_tm1
XIO_BOND_pad15_sdi SDI bondpad_70x70_tm1
XIO_BOND_pad16_sdo SDO bondpad_70x70_tm1
XIO_BOND_pad17_temp_out TEMP_OUT bondpad_70x70_tm1
XIO_BOND_pad18_vref VREF bondpad_70x70_tm1
XIO_BOND_pad19_g_shared G_SHARED bondpad_70x70_tm1
XIO_BOND_pad20_d_std D_STD bondpad_70x70_tm1
XIO_BOND_pad21_d_elt D_ELT bondpad_70x70_tm1
XIO_BOND_pad22_hbt_e HBT_E bondpad_70x70_tm1
XIO_BOND_pad23_hbt_b HBT_B bondpad_70x70_tm1
XIO_BOND_pad24_hbt_c HBT_C bondpad_70x70_tm1
XIO_CORNER_NORTH_EAST_INST VDD VSS IOVDD IOVSS VSS G1_VSS_DERIVATIVE__sg13g2_Corner m=4
XIO_FILL_IO_EAST_0_0 VDD VSS IOVDD IOVSS VSS G1_VSS_DERIVATIVE__sg13g2_Filler4000 m=40
XIO_FILL_IO_EAST_0_20 VDD VSS IOVDD IOVSS VSS G1_VSS_DERIVATIVE__sg13g2_Filler2000 m=28
XIO_FILL_IO_EAST_0_30 VDD VSS IOVDD IOVSS VSS G1_VSS_DERIVATIVE__sg13g2_Filler400 m=44
Vm_bgr VDDA VDDA__vm_bgr dc 0
Vm_gatea VDDA VDDA__vm_gatea dc 0
Vm_gated VDD VDD__vm_gated dc 0
Vm_ls VDDA VDDA__vm_ls dc 0
Vm_lsd VDD VDD__vm_lsd dc 0
Vm_osc VDD VDD__vm_osc dc 0
Vm_sense VDDA VDDA__vm_sense dc 0
Vm_t2f VDDA VDDA__vm_t2f dc 0
Vm_t2fd VDD VDD__vm_t2fd dc 0
Vm_tripa VDDA VDDA__vm_tripa dc 0
Vm_tripd VDD VDD__vm_tripd dc 0
.ends g1_chip_top
Xchip d_elt d_std en_pad fault_n gate g_shared hbt_b hbt_c hbt_e sclk_pad sdi_pad sdo_pad sense_n sense_p temp_out_pad trip_set vdda vref_pad vdd 0 iovdd 0 g1_chip_top
Cvref_ext vref_pad 0 {CVREF}
Csdo sdo_pad 0 20p
Ctemp_out temp_out_pad 0 20p
Rpd_d_elt d_elt 0 1meg
Rpd_d_std d_std 0 1meg
Rpd_g_shared g_shared 0 1meg
Rpd_hbt_b hbt_b 0 1meg
Rpd_hbt_c hbt_c 0 1meg
Rpd_hbt_e hbt_e 0 1meg
Rpd_trip_set trip_set 0 1meg
.save v(gate) v(gfet) v(xchip.i_core_tripped) v(xchip.i_core_isense) v(xchip.i_core_cmp_soft) v(xchip.i_core_cmp_hard) v(xchip.i_core_trip_d) v(xchip.i_core_clr_d) v(xchip.i_core_fast_en) v(xchip.i_core_osc_clk) v(xchip.i_core_cmp_clk)
+ v(xchip.i_core_vref) v(xchip.i_core_iptat) v(xchip.en_i) v(shp) v(shn) v(fault_n) v(xchip.gate_o) v(vdda) v(vdd) v(iovdd) v(iprof) v(xchip.xi_core_u_osc.en_g)
+ v(xchip.xi_core_u_trip.icmp) v(xchip.xi_core_u_trip.vth_soft) v(xchip.xi_core_u_trip.vth_hard) v(xchip.i_core_trip) v(xchip.i_core_trip_cause_1_) v(xchip.i_core_trip_cause_0_) v(sclk_pad) v(sdi_pad) v(xchip.i_core_sdo_o)
+ v(xchip.i_core_dac_soft_0_) v(xchip.i_core_dac_soft_1_) v(xchip.i_core_dac_soft_2_) v(xchip.i_core_dac_soft_3_) v(xchip.i_core_dac_soft_4_) v(xchip.i_core_dac_soft_5_) v(xchip.i_core_dac_soft_6_) v(xchip.i_core_dac_soft_7_) v(xchip.i_core_dac_hard_0_) v(xchip.i_core_dac_hard_1_) v(xchip.i_core_dac_hard_2_) v(xchip.i_core_dac_hard_3_) v(xchip.i_core_dac_hard_4_) v(xchip.i_core_dac_hard_5_) v(xchip.i_core_dac_hard_6_) v(xchip.i_core_dac_hard_7_)
+ v(xchip.xi_core_u_digital.sp0) v(xchip.xi_core_u_digital.sp1) v(xchip.xi_core_u_digital.sp2) v(xchip.xi_core_u_digital.sp3) v(xchip.xi_core_u_digital.sp4) v(xchip.xi_core_u_digital.sp5) v(xchip.xi_core_u_digital.sp6) v(xchip.xi_core_u_digital.sp7) v(xchip.xi_core_u_digital.sp8) v(xchip.xi_core_u_digital.sp9) v(xchip.xi_core_u_digital.sp10) v(xchip.xi_core_u_digital.sp11) v(xchip.xi_core_u_digital.sp12) v(xchip.xi_core_u_digital.sp13) v(xchip.xi_core_u_digital.sp14) v(xchip.xi_core_u_digital.sp15) v(xchip.xi_core_u_digital.inrush_active) v(xchip.xi_core_u_digital.soft_armed)
+ i(vim) i(vma) i(vmi) i(v12) i(v.xchip.vm_bgr) i(v.xchip.vm_sense) i(v.xchip.vm_tripa) i(v.xchip.vm_tripd) i(v.xchip.vm_osc) i(v.xchip.vm_gatea) i(v.xchip.vm_gated)
+ v(xchip.i_core_temp_out_o) v(xchip.i_core_t2f_en_33) v(xchip.i_core_t2f_mode_33) v(xchip.i_core_pbias) v(xchip.i_core_pcasc) i(v.xchip.vm_t2f) i(v.xchip.vm_t2fd) i(v.xchip.vm_ls) i(v.xchip.vm_lsd)
+ v(xchip.i_core_vref_buf) v(xchip.i_core_unused_vped)
.control
set filetype=ascii
set wr_singlescale
set wr_vecnames
tran 2e-08 28u 0 5e-09
* quiet operating values after the register write(s): window averages over the last 2 us before the load
* event (comparator kickback averaged out); single-instant samples at t_cfg + 1 us kept as *_inst
meas tran vref_q avg v(xchip.i_core_vref) from=14u to=16u
meas tran isense_q avg v(xchip.i_core_isense) from=14u to=16u
meas tran icmp_q avg v(xchip.xi_core_u_trip.icmp) from=14u to=16u
meas tran vths_q avg v(xchip.xi_core_u_trip.vth_soft) from=14u to=16u
meas tran vthh_q avg v(xchip.xi_core_u_trip.vth_hard) from=14u to=16u
meas tran vref_i find v(xchip.i_core_vref) at=12.8565u
meas tran isense_i find v(xchip.i_core_isense) at=12.8565u
meas tran icmp_i find v(xchip.xi_core_u_trip.icmp) at=12.8565u
meas tran vths_i find v(xchip.xi_core_u_trip.vth_soft) at=12.8565u
meas tran vthh_i find v(xchip.xi_core_u_trip.vth_hard) at=12.8565u
meas tran iload_q find i(vim) at=12.8565u
meas tran gate_q find v(gate) at=12.8565u
meas tran fastq find v(xchip.i_core_fast_en) at=12.8565u
meas tran t_inrush_off when v(xchip.xi_core_u_digital.inrush_active)=0.6 fall=1 from=3u
meas tran inrush_q find v(xchip.xi_core_u_digital.inrush_active) at=12.8565u
meas tran softarmed_end find v(xchip.xi_core_u_digital.soft_armed) at=28u
let cs_v = 1*(v(xchip.i_core_dac_soft_0_) gt 0.6) + 2*(v(xchip.i_core_dac_soft_1_) gt 0.6) + 4*(v(xchip.i_core_dac_soft_2_) gt 0.6) + 8*(v(xchip.i_core_dac_soft_3_) gt 0.6) + 16*(v(xchip.i_core_dac_soft_4_) gt 0.6) + 32*(v(xchip.i_core_dac_soft_5_) gt 0.6) + 64*(v(xchip.i_core_dac_soft_6_) gt 0.6) + 128*(v(xchip.i_core_dac_soft_7_) gt 0.6)
let ch_v = 1*(v(xchip.i_core_dac_hard_0_) gt 0.6) + 2*(v(xchip.i_core_dac_hard_1_) gt 0.6) + 4*(v(xchip.i_core_dac_hard_2_) gt 0.6) + 8*(v(xchip.i_core_dac_hard_3_) gt 0.6) + 16*(v(xchip.i_core_dac_hard_4_) gt 0.6) + 32*(v(xchip.i_core_dac_hard_5_) gt 0.6) + 64*(v(xchip.i_core_dac_hard_6_) gt 0.6) + 128*(v(xchip.i_core_dac_hard_7_) gt 0.6)
meas tran code_soft find cs_v at=12.8565u
meas tran code_hard find ch_v at=12.8565u
let t_inrush_off_us = t_inrush_off*1e6
echo "QUIET window_us=14-16 vref=" $&vref_q " isense=" $&isense_q " icmp=" $&icmp_q " vth_soft=" $&vths_q " vth_hard=" $&vthh_q " vref_inst=" $&vref_i " isense_inst=" $&isense_i " icmp_inst=" $&icmp_i " vth_soft_inst=" $&vths_i " vth_hard_inst=" $&vthh_i " iload_A=" $&iload_q " gate=" $&gate_q " code_soft=" $&code_soft " code_hard=" $&code_hard " fast_en=" $&fastq " inrush_active=" $&inrush_q " t_inrush_off_us=" $&t_inrush_off_us " soft_armed_end=" $&softarmed_end
* clocks: 20 oscillator periods and 10 strobe periods after the configuration
meas tran tosc1 when v(xchip.i_core_osc_clk)=0.6 rise=1 from=11.8565u
meas tran tosc2 when v(xchip.i_core_osc_clk)=0.6 rise=21 from=11.8565u
let fosc_mhz = 20e-6/(tosc2 - tosc1)
meas tran tcc1 when v(xchip.i_core_cmp_clk)=0.6 rise=1 from=11.8565u
meas tran tcc2 when v(xchip.i_core_cmp_clk)=0.6 rise=11 from=11.8565u
let fcmp_mhz = 10e-6/(tcc2 - tcc1)
echo "CLOCK f_osc_MHz=" $&fosc_mhz " f_cmp_MHz=" $&fcmp_mhz " (RTL clock: ideal source at the block-simulated frequency)"
* supply currents averaged over the quiet armed window
let i_vdda = i(vma)
meas tran ia_vdda avg i_vdda from=13.8565u to=16u
let ua_vdda = ia_vdda*1e6
let i_iovdd = i(vmi)
meas tran ia_iovdd avg i_iovdd from=13.8565u to=16u
let ua_iovdd = ia_iovdd*1e6
let i_vdd = -i(v12)
meas tran ia_vdd avg i_vdd from=13.8565u to=16u
let ua_vdd = ia_vdd*1e6
let i_bgr = i(v.xchip.vm_bgr)
meas tran ia_bgr avg i_bgr from=13.8565u to=16u
let ua_bgr = ia_bgr*1e6
let i_sense = i(v.xchip.vm_sense)
meas tran ia_sense avg i_sense from=13.8565u to=16u
let ua_sense = ia_sense*1e6
let i_tripa = i(v.xchip.vm_tripa)
meas tran ia_tripa avg i_tripa from=13.8565u to=16u
let ua_tripa = ia_tripa*1e6
let i_tripd = i(v.xchip.vm_tripd)
meas tran ia_tripd avg i_tripd from=13.8565u to=16u
let ua_tripd = ia_tripd*1e6
let i_osc = i(v.xchip.vm_osc)
meas tran ia_osc avg i_osc from=13.8565u to=16u
let ua_osc = ia_osc*1e6
let i_gatea = i(v.xchip.vm_gatea)
meas tran ia_gatea avg i_gatea from=13.8565u to=16u
let ua_gatea = ia_gatea*1e6
let i_gated = i(v.xchip.vm_gated)
meas tran ia_gated avg i_gated from=13.8565u to=16u
let ua_gated = ia_gated*1e6
echo "SUPPLY_uA window=13.8565-16us VDDA=" $&ua_vdda " IOVDD=" $&ua_iovdd " VDD=" $&ua_vdd " | bgr=" $&ua_bgr " sense=" $&ua_sense " trip_3v3=" $&ua_tripa " trip_1v2=" $&ua_tripd " osc=" $&ua_osc " gate_3v3=" $&ua_gatea " gate_1v2=" $&ua_gated
* G1_T2F: output frequency (rising 0.6 V crossings) and supply currents over the quiet window
meas tran t2f_t1 when v(xchip.i_core_temp_out_o)=0.6 rise=1 from=13.8565u to=16u
meas tran t2f_t2 when v(xchip.i_core_temp_out_o)=0.6 rise=3 from=13.8565u to=16u
let t2f_mhz = 2e-6/(t2f_t2 - t2f_t1)
meas tran ia_t2f avg i(v.xchip.vm_t2f) from=13.8565u to=16u
let ua_t2f = ia_t2f*1e6
meas tran ia_t2fd avg i(v.xchip.vm_t2fd) from=13.8565u to=16u
let ua_t2fd = ia_t2fd*1e6
meas tran ia_ls avg i(v.xchip.vm_ls) from=13.8565u to=16u
let ua_ls = ia_ls*1e6
meas tran ia_lsd avg i(v.xchip.vm_lsd) from=13.8565u to=16u
let ua_lsd = ia_lsd*1e6
echo "T2F window=13.8565-16us f_MHz=" $&t2f_mhz " periods=2 vdda_t2f_uA=" $&ua_t2f " vdd12_t2f_uA=" $&ua_t2fd " vdda_ls_uA=" $&ua_ls " vdd_ls_uA=" $&ua_lsd
* trip evaluation after the load event at T_STEP
let tstep_s = 16u
meas tran tripped_max max v(xchip.i_core_tripped) from=11.8565u to=28u
meas tran tripped_pre max v(xchip.i_core_tripped) from=11.8565u to=16u
meas tran t_tripped when v(xchip.i_core_tripped)=0.6 rise=1 from=16u
meas tran t_trip_d when v(xchip.i_core_trip_d)=0.6 rise=1 from=16u
meas tran t_gate1v when v(gate)=1.0 fall=1 from=16u
meas tran t_gate03 when v(gate)=0.33 fall=1 from=16u
meas tran gate_min min v(gate) from=16u to=28u
meas tran gate_end find v(gate) at=28u
meas tran ipk max i(vim) from=16u to=28u
meas tran i_end find i(vim) at=28u
meas tran isense_pk max v(xchip.i_core_isense) from=16u to=28u
meas tran cause1e find v(xchip.i_core_trip_cause_1_) at=28u
meas tran cause0e find v(xchip.i_core_trip_cause_0_) at=28u
meas tran fault_end find v(fault_n) at=28u
let sp_v = 1*(v(xchip.xi_core_u_digital.sp0) gt 0.6) + 2*(v(xchip.xi_core_u_digital.sp1) gt 0.6) + 4*(v(xchip.xi_core_u_digital.sp2) gt 0.6) + 8*(v(xchip.xi_core_u_digital.sp3) gt 0.6) + 16*(v(xchip.xi_core_u_digital.sp4) gt 0.6) + 32*(v(xchip.xi_core_u_digital.sp5) gt 0.6) + 64*(v(xchip.xi_core_u_digital.sp6) gt 0.6) + 128*(v(xchip.xi_core_u_digital.sp7) gt 0.6) + 256*(v(xchip.xi_core_u_digital.sp8) gt 0.6) + 512*(v(xchip.xi_core_u_digital.sp9) gt 0.6) + 1024*(v(xchip.xi_core_u_digital.sp10) gt 0.6) + 2048*(v(xchip.xi_core_u_digital.sp11) gt 0.6) + 4096*(v(xchip.xi_core_u_digital.sp12) gt 0.6) + 8192*(v(xchip.xi_core_u_digital.sp13) gt 0.6) + 16384*(v(xchip.xi_core_u_digital.sp14) gt 0.6) + 32768*(v(xchip.xi_core_u_digital.sp15) gt 0.6)
meas tran soft_peak find sp_v at=28u
let cause = 2*(cause1e gt 0.6) + (cause0e gt 0.6)
let dt_gate1v_us = (t_gate1v - tstep_s)*1e6
let dt_gate03_us = (t_gate03 - tstep_s)*1e6
let dt_tripped_us = (t_tripped - tstep_s)*1e6
let dt_trip_d_us = (t_trip_d - tstep_s)*1e6
echo "TRIP tripped_max=" $&tripped_max " tripped_before_event=" $&tripped_pre " t_tripped_us=" $&dt_tripped_us " t_trip_d_us=" $&dt_trip_d_us " t_gate_1V_us=" $&dt_gate1v_us " t_gate_0.33V_us=" $&dt_gate03_us " gate_min=" $&gate_min " gate_end=" $&gate_end " ipk_A=" $&ipk " i_end_A=" $&i_end " isense_pk=" $&isense_pk " cause=" $&cause " fault_n_end=" $&fault_end " soft_peak=" $&soft_peak
let qi = integ(i(vim))
meas tran q_step find qi at=16u
meas tran q_end find qi at=28u
let q_passed = q_end - q_step
echo "CHARGE after_event_As=" $&q_passed
wrdata /work/build/g1_top/state_cdl_c_mid_pex_tt_27C_gear_keep-bgr_compact_functional_cdlv1.txt v(xchip.en_i) v(xchip.xi_core_u_digital.inrush_active) v(xchip.i_core_trip) v(xchip.i_core_fast_en) v(xchip.i_core_trip_cause_1_) v(xchip.i_core_trip_cause_0_) v(xchip.i_core_dac_soft_0_) v(xchip.i_core_dac_soft_1_) v(xchip.i_core_dac_soft_2_) v(xchip.i_core_dac_soft_3_) v(xchip.i_core_dac_soft_4_) v(xchip.i_core_dac_soft_5_) v(xchip.i_core_dac_soft_6_) v(xchip.i_core_dac_soft_7_) v(xchip.i_core_dac_hard_0_) v(xchip.i_core_dac_hard_1_) v(xchip.i_core_dac_hard_2_) v(xchip.i_core_dac_hard_3_) v(xchip.i_core_dac_hard_4_) v(xchip.i_core_dac_hard_5_) v(xchip.i_core_dac_hard_6_) v(xchip.i_core_dac_hard_7_) v(xchip.xi_core_u_digital.soft_armed) v(xchip.xi_core_u_digital.sp0) v(xchip.xi_core_u_digital.sp1) v(xchip.xi_core_u_digital.sp2) v(xchip.xi_core_u_digital.sp3) v(xchip.xi_core_u_digital.sp4) v(xchip.xi_core_u_digital.sp5) v(xchip.xi_core_u_digital.sp6) v(xchip.xi_core_u_digital.sp7) v(xchip.xi_core_u_digital.sp8) v(xchip.xi_core_u_digital.sp9) v(xchip.xi_core_u_digital.sp10) v(xchip.xi_core_u_digital.sp11) v(xchip.xi_core_u_digital.sp12) v(xchip.xi_core_u_digital.sp13) v(xchip.xi_core_u_digital.sp14) v(xchip.xi_core_u_digital.sp15) v(sclk_pad) v(sdi_pad) v(xchip.i_core_sdo_o) v(xchip.i_core_clr_d)
linearize v(gate) v(gfet) v(xchip.i_core_tripped) v(xchip.i_core_isense) v(xchip.i_core_cmp_soft) v(xchip.i_core_cmp_hard) v(xchip.i_core_cmp_clk) v(xchip.i_core_trip_d) v(xchip.i_core_osc_clk) v(xchip.i_core_vref) v(xchip.en_i) v(shp) v(fault_n) v(vdda) v(vdd) v(iprof) v(xchip.xi_core_u_trip.icmp) v(xchip.xi_core_u_trip.vth_soft) v(xchip.xi_core_u_trip.vth_hard) v(xchip.i_core_trip) v(xchip.xi_core_u_digital.inrush_active) i(vim) i(vma) i(vmi) i(v12)
wrdata /work/build/g1_top/waves_cdl_c_mid_pex_tt_27C_gear_keep-bgr_compact_functional_cdlv1.txt v(gate) v(gfet) v(xchip.i_core_tripped) v(xchip.i_core_isense) v(xchip.i_core_cmp_soft) v(xchip.i_core_cmp_hard) v(xchip.i_core_cmp_clk) v(xchip.i_core_trip_d) v(xchip.i_core_osc_clk) v(xchip.i_core_vref) v(xchip.en_i) v(shp) v(fault_n) v(vdda) v(vdd) v(iprof) v(xchip.xi_core_u_trip.icmp) v(xchip.xi_core_u_trip.vth_soft) v(xchip.xi_core_u_trip.vth_hard) v(xchip.i_core_trip) v(xchip.xi_core_u_digital.inrush_active) i(vim) i(vma) i(vmi) i(v12)
.endc
.end
