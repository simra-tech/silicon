* G1_TOP breaker path, chip level: held45mV fault40us, HOLD_TIME=0 means8192cycles, one automaticretry then giveup; serialSTATUS/STATUS2/TRIP_CNT
* case retry_read | block netlists pex | front end beh | clock to the RTL ideal | corner tt (mos_tt res_typ cap_typ hbt_typ) | 27 degC | run_top.py
.param VDDA=3.3 VDD=1.2 IOVDD=3.3 RSH=25m RGND=10m INOM=1 CVREF=1e-08
.lib /foss/pdks/ihp-sg13g2/libs.tech/ngspice/models/cornerMOSlv.lib mos_tt
.lib /foss/pdks/ihp-sg13g2/libs.tech/ngspice/models/cornerMOShv.lib mos_tt
.lib /foss/pdks/ihp-sg13g2/libs.tech/ngspice/models/cornerRES.lib res_typ
.lib /foss/pdks/ihp-sg13g2/libs.tech/ngspice/models/cornerCAP.lib cap_typ
.lib /foss/pdks/ihp-sg13g2/libs.tech/ngspice/models/cornerHBT.lib hbt_typ
.lib /foss/pdks/ihp-sg13g2/libs.tech/ngspice/models/cornerDIO.lib dio_tt
.include /foss/pdks/ihp-sg13g2/libs.ref/sg13g2_io/spice/sg13g2_io.spi
.include /work/designs/g1-guardian/blocks/g1_gate/sim/postlayout/g1_gate_pex.spice
.temp 27
.global sub!
Vsub sub! 0 dc 0
* solver (README, "Numerical notes"): gear integration and loose absolute tolerances are what the PDK IO-pad
* models need when XSPICE events fall on their switching edges (with abstol 1e-9 / vntol 1e-5 the diode
* internal nodes stop converging: "timestep too small"); the DAC mux-tree nodes need rshunt; XSPICE forces
* trtol = 1, which the comparator decisions need at this reltol; default gmin (1e-13 stalls the pads)
.option method=gear itl4=100 reltol=0.002 abstol=1e-8 vntol=1e-4 chgtol=1e-12 rshunt=1e12
* ---- supplies: one 3.3 V board rail feeds VDDA (pin 7) and IOVDD (pin 3), PLAN D14; 1.2 V VDD (pin 1)
V33 rail33 0 dc 3.3
Vma rail33 vdda_s dc 0
Vmi rail33 iovdd_s dc 0
Rsa vdda_s vdda 0.5
Cda vdda 0 1n
Rsi iovdd_s iovdd 0.5
Cdi iovdd 0 1n
V12 vdd_s 0 dc 1.2
Rsd vdd_s vdd 0.5
Cdd vdd 0 1n
* ---- board: load current profile (1 V = 1 A) x switch on the FET gate node, shunt, Kelvin traces, FET gate
Vprof iprof 0 pwl(0 1 4e-05 1 4.002e-05 1.8)
Bload 0 ldi I = v(iprof) * (0.5 + 0.5*tanh((v(gfet) - 1.5)/0.15))
Vim ldi shp dc 0
Rsh shp shn {RSH}
Rgnd shn 0 {RGND}
Rkp shp sense_p 1
Rkn shn sense_n 1
Rg gate gfet 10
Cgate gfet 0 5n
Cfault fault_n 0 20p
* ---- pads (PDK sg13g2_io SPICE models): SENSE_P/N on the bare pad terminal, VREF on the padres terminal
* (587 Ohm secondary protection, padframe/README.md); the VREF bond pad carries the board capacitor CVREF
XPSP sense_p sense_p_res vdd 0 iovdd 0 sg13g2_IOPadAnalog
XPSN sense_n sense_n_res vdd 0 iovdd 0 sg13g2_IOPadAnalog
XPVREF vref_pad vref vdd 0 iovdd 0 sg13g2_IOPadAnalog
Cvref_ext vref_pad 0 {CVREF}
* digital input pads (EN, SCLK, SDI) as ideal 3.3 V -> 1.2 V level copies: the sg13g2_IOPadIn SPICE
* models abort the event-driven solver at their input edges with the charge tolerance the comparators
* need (README, "Numerical notes"); the pads are functionally verified in blocks/g1_gate (EN pad)
Ben_core en_core 0 V = v(en_pad)*1.2/3.3
Bsclk_core sclk_core 0 V = v(sclk_pad)*1.2/3.3
Bsdi_core sdi_core 0 V = v(sdi_pad)*1.2/3.3
* GATE / FAULT_N output pads as behavioural drivers fitted to the g1_gate block results with the PDK pad
* models (30 mA pad: 5 nF + 10 Ohm, fall 90-10 % 606 ns, arming 0-90 % 677 ns -> 47 Ohm driver; 4 mA pad:
* 20 pF, ~500 Ohm). Reason: README, "Numerical notes" (pad models and the StrongARM comparators need
* incompatible integration settings). The driver switches within 1 ns of gate_core / fault_core and
* draws its current from IOVDD.
Bgate_drv gate_drv 0 V = v(iovdd)*(0.5 + 0.5*tanh((v(gate_core) - 0.6)/0.05))
Rgate_drv gate_drv gate 47
Bgate_i iovdd 0 I = max(0, (v(gate_drv) - v(gate))/47)
Bfault_drv fault_drv 0 V = v(iovdd)*(0.5 + 0.5*tanh((v(fault_core) - 0.6)/0.05))
Rfault_drv fault_drv fault_n 500
Ven en_pad 0 pwl(0 0 3.04640871692e-06 0 3.04730871692e-06 1.485 3.04750871692e-06 1.815 3.04840871692e-06 3.3)
Vsclk sclk_pad 0 pwl(0 0 1.8056415388e-05 0 1.81676006226e-05 0 1.81676006226e-05 0 1.81685006226e-05 1.485 1.81687006226e-05 1.815 1.81696006226e-05 3.3 1.82787858572e-05 3.3 1.82796858572e-05 1.815 1.82798858572e-05 1.485 1.82807858572e-05 0 1.83899710918e-05 0 1.83899710918e-05 0 1.83908710918e-05 1.485 1.83910710918e-05 1.815 1.83919710918e-05 3.3 1.85011563264e-05 3.3 1.85020563264e-05 1.815 1.85022563264e-05 1.485 1.85031563264e-05 0 1.8612341561e-05 0 1.8612341561e-05 0 1.8613241561e-05 1.485 1.8613441561e-05 1.815 1.8614341561e-05 3.3 1.87235267956e-05 3.3 1.87244267956e-05 1.815 1.87246267956e-05 1.485 1.87255267956e-05 0 1.88347120302e-05 0 1.88347120302e-05 0 1.88356120302e-05 1.485 1.88358120302e-05 1.815 1.88367120302e-05 3.3 1.89458972648e-05 3.3 1.89467972648e-05 1.815 1.89469972648e-05 1.485 1.89478972648e-05 0 1.90570824994e-05 0 1.90570824994e-05 0 1.90579824994e-05 1.485 1.90581824994e-05 1.815 1.90590824994e-05 3.3 1.9168267734e-05 3.3 1.9169167734e-05 1.815 1.9169367734e-05 1.485 1.9170267734e-05 0 1.92794529686e-05 0 1.92794529686e-05 0 1.92803529686e-05 1.485 1.92805529686e-05 1.815 1.92814529686e-05 3.3 1.93906382032e-05 3.3 1.93915382032e-05 1.815 1.93917382032e-05 1.485 1.93926382032e-05 0 1.95018234378e-05 0 1.95018234378e-05 0 1.95027234378e-05 1.485 1.95029234378e-05 1.815 1.95038234378e-05 3.3 1.96130086724e-05 3.3 1.96139086724e-05 1.815 1.96141086724e-05 1.485 1.96150086724e-05 0 1.9724193907e-05 0 1.9724193907e-05 0 1.9725093907e-05 1.485 1.9725293907e-05 1.815 1.9726193907e-05 3.3 1.98353791416e-05 3.3 1.98362791416e-05 1.815 1.98364791416e-05 1.485 1.98373791416e-05 0 1.99465643763e-05 0 1.99465643763e-05 0 1.99474643763e-05 1.485 1.99476643763e-05 1.815 1.99485643763e-05 3.3 2.00577496109e-05 3.3 2.00586496109e-05 1.815 2.00588496109e-05 1.485 2.00597496109e-05 0 2.01689348455e-05 0 2.01689348455e-05 0 2.01698348455e-05 1.485 2.01700348455e-05 1.815 2.01709348455e-05 3.3 2.02801200801e-05 3.3 2.02810200801e-05 1.815 2.02812200801e-05 1.485 2.02821200801e-05 0 2.03913053147e-05 0 2.03913053147e-05 0 2.03922053147e-05 1.485 2.03924053147e-05 1.815 2.03933053147e-05 3.3 2.05024905493e-05 3.3 2.05033905493e-05 1.815 2.05035905493e-05 1.485 2.05044905493e-05 0 2.06136757839e-05 0 2.06136757839e-05 0 2.06145757839e-05 1.485 2.06147757839e-05 1.815 2.06156757839e-05 3.3 2.07248610185e-05 3.3 2.07257610185e-05 1.815 2.07259610185e-05 1.485 2.07268610185e-05 0 2.08360462531e-05 0 2.08360462531e-05 0 2.08369462531e-05 1.485 2.08371462531e-05 1.815 2.08380462531e-05 3.3 2.09472314877e-05 3.3 2.09481314877e-05 1.815 2.09483314877e-05 1.485 2.09492314877e-05 0 2.10584167223e-05 0 2.10584167223e-05 0 2.10593167223e-05 1.485 2.10595167223e-05 1.815 2.10604167223e-05 3.3 2.11696019569e-05 3.3 2.11705019569e-05 1.815 2.11707019569e-05 1.485 2.11716019569e-05 0 2.12807871915e-05 0 2.12807871915e-05 0 2.12816871915e-05 1.485 2.12818871915e-05 1.815 2.12827871915e-05 3.3 2.13919724261e-05 3.3 2.13928724261e-05 1.815 2.13930724261e-05 1.485 2.13939724261e-05 0 2.15031576607e-05 0 2.15031576607e-05 0 2.15040576607e-05 1.485 2.15042576607e-05 1.815 2.15051576607e-05 3.3 2.16143428953e-05 3.3 2.16152428953e-05 1.815 2.16154428953e-05 1.485 2.16163428953e-05 0 2.17255281299e-05 0 2.17255281299e-05 0 2.17264281299e-05 1.485 2.17266281299e-05 1.815 2.17275281299e-05 3.3 2.18367133645e-05 3.3 2.18376133645e-05 1.815 2.18378133645e-05 1.485 2.18387133645e-05 0 2.19478985991e-05 0 2.19478985991e-05 0 2.19487985991e-05 1.485 2.19489985991e-05 1.815 2.19498985991e-05 3.3 2.20590838337e-05 3.3 2.20599838337e-05 1.815 2.20601838337e-05 1.485 2.20610838337e-05 0 2.21702690683e-05 0 2.21702690683e-05 0 2.21711690683e-05 1.485 2.21713690683e-05 1.815 2.21722690683e-05 3.3 2.22814543029e-05 3.3 2.22823543029e-05 1.815 2.22825543029e-05 1.485 2.22834543029e-05 0 2.23926395375e-05 0 2.23926395375e-05 0 2.23935395375e-05 1.485 2.23937395375e-05 1.815 2.23946395375e-05 3.3 2.25038247721e-05 3.3 2.25047247721e-05 1.815 2.25049247721e-05 1.485 2.25058247721e-05 0 2.26150100067e-05 0 2.26150100067e-05 0 2.26159100067e-05 1.485 2.26161100067e-05 1.815 2.26170100067e-05 3.3 2.27261952413e-05 3.3 2.27270952413e-05 1.815 2.27272952413e-05 1.485 2.27281952413e-05 0 2.28373804759e-05 0 2.28373804759e-05 0 2.28382804759e-05 1.485 2.28384804759e-05 1.815 2.28393804759e-05 3.3 2.29485657105e-05 3.3 2.29494657105e-05 1.815 2.29496657105e-05 1.485 2.29505657105e-05 0 2.30597509451e-05 0 2.30597509451e-05 0 2.30606509451e-05 1.485 2.30608509451e-05 1.815 2.30617509451e-05 3.3 2.31709361797e-05 3.3 2.31718361797e-05 1.815 2.31720361797e-05 1.485 2.31729361797e-05 0 2.32821214143e-05 0 2.32821214143e-05 0 2.32830214143e-05 1.485 2.32832214143e-05 1.815 2.32841214143e-05 3.3 2.33933066489e-05 3.3 2.33942066489e-05 1.815 2.33944066489e-05 1.485 2.33953066489e-05 0 2.35044918835e-05 0 2.35044918835e-05 0 2.35053918835e-05 1.485 2.35055918835e-05 1.815 2.35064918835e-05 3.3 2.36156771181e-05 3.3 2.36165771181e-05 1.815 2.36167771181e-05 1.485 2.36176771181e-05 0 2.37268623527e-05 0 2.37268623527e-05 0 2.37277623527e-05 1.485 2.37279623527e-05 1.815 2.37288623527e-05 3.3 2.38380475873e-05 3.3 2.38389475873e-05 1.815 2.38391475873e-05 1.485 2.38400475873e-05 0 2.39492328219e-05 0 2.39492328219e-05 0 2.39501328219e-05 1.485 2.39503328219e-05 1.815 2.39512328219e-05 3.3 2.40604180565e-05 3.3 2.40613180565e-05 1.815 2.40615180565e-05 1.485 2.40624180565e-05 0 2.41716032911e-05 0 2.41716032911e-05 0 2.41725032911e-05 1.485 2.41727032911e-05 1.815 2.41736032911e-05 3.3 2.42827885257e-05 3.3 2.42836885257e-05 1.815 2.42838885257e-05 1.485 2.42847885257e-05 0 2.43939737603e-05 0 2.43939737603e-05 0 2.43948737603e-05 1.485 2.43950737603e-05 1.815 2.43959737603e-05 3.3 2.45051589949e-05 3.3 2.45060589949e-05 1.815 2.45062589949e-05 1.485 2.45071589949e-05 0 2.46163442295e-05 0 2.46163442295e-05 0 2.46172442295e-05 1.485 2.46174442295e-05 1.815 2.46183442295e-05 3.3 2.47275294641e-05 3.3 2.47284294641e-05 1.815 2.47286294641e-05 1.485 2.47295294641e-05 0 2.48387146987e-05 0 2.48387146987e-05 0 2.48396146987e-05 1.485 2.48398146987e-05 1.815 2.48407146987e-05 3.3 2.49498999333e-05 3.3 2.49507999333e-05 1.815 2.49509999333e-05 1.485 2.49518999333e-05 0 2.50610851679e-05 0 2.50610851679e-05 0 2.50619851679e-05 1.485 2.50621851679e-05 1.815 2.50630851679e-05 3.3 2.51722704025e-05 3.3 2.51731704025e-05 1.815 2.51733704025e-05 1.485 2.51742704025e-05 0 2.52834556371e-05 0 2.52834556371e-05 0 2.52843556371e-05 1.485 2.52845556371e-05 1.815 2.52854556371e-05 3.3 2.53946408717e-05 3.3 2.53955408717e-05 1.815 2.53957408717e-05 1.485 2.53966408717e-05 0 2.55058261063e-05 0 2.55058261063e-05 0 2.55067261063e-05 1.485 2.55069261063e-05 1.815 2.55078261063e-05 3.3 2.56170113409e-05 3.3 2.56179113409e-05 1.815 2.56181113409e-05 1.485 2.56190113409e-05 0 2.57281965755e-05 0 2.57281965755e-05 0 2.57290965755e-05 1.485 2.57292965755e-05 1.815 2.57301965755e-05 3.3 2.58393818101e-05 3.3 2.58402818101e-05 1.815 2.58404818101e-05 1.485 2.58413818101e-05 0 2.59505670447e-05 0 2.59505670447e-05 0 2.59514670447e-05 1.485 2.59516670447e-05 1.815 2.59525670447e-05 3.3 2.60617522793e-05 3.3 2.60626522793e-05 1.815 2.60628522793e-05 1.485 2.60637522793e-05 0 2.61729375139e-05 0 2.61729375139e-05 0 2.61738375139e-05 1.485 2.61740375139e-05 1.815 2.61749375139e-05 3.3 2.62841227485e-05 3.3 2.62850227485e-05 1.815 2.62852227485e-05 1.485 2.62861227485e-05 0 2.63953079831e-05 0 2.63953079831e-05 0 2.63962079831e-05 1.485 2.63964079831e-05 1.815 2.63973079831e-05 3.3 2.65064932177e-05 3.3 2.65073932177e-05 1.815 2.65075932177e-05 1.485 2.65084932177e-05 0 2.66176784523e-05 0 2.66176784523e-05 0 2.66185784523e-05 1.485 2.66187784523e-05 1.815 2.66196784523e-05 3.3 2.67288636869e-05 3.3 2.67297636869e-05 1.815 2.67299636869e-05 1.485 2.67308636869e-05 0 2.68400489215e-05 0 2.68400489215e-05 0 2.68409489215e-05 1.485 2.68411489215e-05 1.815 2.68420489215e-05 3.3 2.69512341561e-05 3.3 2.69521341561e-05 1.815 2.69523341561e-05 1.485 2.69532341561e-05 0 2.70624193907e-05 0 2.70624193907e-05 0 2.70633193907e-05 1.485 2.70635193907e-05 1.815 2.70644193907e-05 3.3 2.71736046253e-05 3.3 2.71745046253e-05 1.815 2.71747046253e-05 1.485 2.71756046253e-05 0 2.72847898599e-05 0 2.72847898599e-05 0 2.72856898599e-05 1.485 2.72858898599e-05 1.815 2.72867898599e-05 3.3 2.73959750945e-05 3.3 2.73968750945e-05 1.815 2.73970750945e-05 1.485 2.73979750945e-05 0 2.75071603291e-05 0 2.75071603291e-05 0 2.75080603291e-05 1.485 2.75082603291e-05 1.815 2.75091603291e-05 3.3 2.76183455637e-05 3.3 2.76192455637e-05 1.815 2.76194455637e-05 1.485 2.76203455637e-05 0 2.77295307983e-05 0 2.77295307983e-05 0 2.77304307983e-05 1.485 2.77306307983e-05 1.815 2.77315307983e-05 3.3 2.78407160329e-05 3.3 2.78416160329e-05 1.815 2.78418160329e-05 1.485 2.78427160329e-05 0 2.79519012675e-05 0 2.79519012675e-05 0 2.79528012675e-05 1.485 2.79530012675e-05 1.815 2.79539012675e-05 3.3 2.80630865021e-05 3.3 2.80639865021e-05 1.815 2.80641865021e-05 1.485 2.80650865021e-05 0 2.81742717367e-05 0 2.81742717367e-05 0 2.81751717367e-05 1.485 2.81753717367e-05 1.815 2.81762717367e-05 3.3 2.82854569713e-05 3.3 2.82863569713e-05 1.815 2.82865569713e-05 1.485 2.82874569713e-05 0 2.83966422059e-05 0 2.83966422059e-05 0 2.83975422059e-05 1.485 2.83977422059e-05 1.815 2.83986422059e-05 3.3 2.85078274405e-05 3.3 2.85087274405e-05 1.815 2.85089274405e-05 1.485 2.85098274405e-05 0 2.86190126751e-05 0 2.86190126751e-05 0 2.86199126751e-05 1.485 2.86201126751e-05 1.815 2.86210126751e-05 3.3 2.87301979097e-05 3.3 2.87310979097e-05 1.815 2.87312979097e-05 1.485 2.87321979097e-05 0 2.88413831443e-05 0 2.88413831443e-05 0 2.88422831443e-05 1.485 2.88424831443e-05 1.815 2.88433831443e-05 3.3 2.89525683789e-05 3.3 2.89534683789e-05 1.815 2.89536683789e-05 1.485 2.89545683789e-05 0 2.90637536135e-05 0 2.90637536135e-05 0 2.90646536135e-05 1.485 2.90648536135e-05 1.815 2.90657536135e-05 3.3 2.91749388481e-05 3.3 2.91758388481e-05 1.815 2.91760388481e-05 1.485 2.91769388481e-05 0 2.92861240827e-05 0 2.92861240827e-05 0 2.92870240827e-05 1.485 2.92872240827e-05 1.815 2.92881240827e-05 3.3 2.93973093173e-05 3.3 2.93982093173e-05 1.815 2.93984093173e-05 1.485 2.93993093173e-05 0 2.95084945519e-05 0 2.95084945519e-05 0 2.95093945519e-05 1.485 2.95095945519e-05 1.815 2.95104945519e-05 3.3 2.96196797865e-05 3.3 2.96205797865e-05 1.815 2.96207797865e-05 1.485 2.96216797865e-05 0 2.97308650211e-05 0 2.97308650211e-05 0 2.97317650211e-05 1.485 2.97319650211e-05 1.815 2.97328650211e-05 3.3 2.98420502557e-05 3.3 2.98429502557e-05 1.815 2.98431502557e-05 1.485 2.98440502557e-05 0 2.99532354903e-05 0 2.99532354903e-05 0 2.99541354903e-05 1.485 2.99543354903e-05 1.815 2.99552354903e-05 3.3 3.00644207249e-05 3.3 3.00653207249e-05 1.815 3.00655207249e-05 1.485 3.00664207249e-05 0 3.01756059595e-05 0 3.01756059595e-05 0 3.01765059595e-05 1.485 3.01767059595e-05 1.815 3.01776059595e-05 3.3 3.02867911941e-05 3.3 3.02876911941e-05 1.815 3.02878911941e-05 1.485 3.02887911941e-05 0 3.03979764287e-05 0 3.03979764287e-05 0 3.03988764287e-05 1.485 3.03990764287e-05 1.815 3.03999764287e-05 3.3 3.05091616633e-05 3.3 3.05100616633e-05 1.815 3.05102616633e-05 1.485 3.05111616633e-05 0 3.06203468979e-05 0 3.06203468979e-05 0 3.06212468979e-05 1.485 3.06214468979e-05 1.815 3.06223468979e-05 3.3 3.07315321325e-05 3.3 3.07324321325e-05 1.815 3.07326321325e-05 1.485 3.07335321325e-05 0 3.08427173671e-05 0 3.08427173671e-05 0 3.08436173671e-05 1.485 3.08438173671e-05 1.815 3.08447173671e-05 3.3 3.09539026017e-05 3.3 3.09548026017e-05 1.815 3.09550026017e-05 1.485 3.09559026017e-05 0 3.10650878363e-05 0 3.10650878363e-05 0 3.10659878363e-05 1.485 3.10661878363e-05 1.815 3.10670878363e-05 3.3 3.11762730709e-05 3.3 3.11771730709e-05 1.815 3.11773730709e-05 1.485 3.11782730709e-05 0 3.12874583055e-05 0 3.12874583055e-05 0 3.12883583055e-05 1.485 3.12885583055e-05 1.815 3.12894583055e-05 3.3 3.13986435401e-05 3.3 3.13995435401e-05 1.815 3.13997435401e-05 1.485 3.14006435401e-05 0 3.15098287747e-05 0 3.15098287747e-05 0 3.15107287747e-05 1.485 3.15109287747e-05 1.815 3.15118287747e-05 3.3 3.16210140093e-05 3.3 3.16219140093e-05 1.815 3.16221140093e-05 1.485 3.16230140093e-05 0 3.17321992439e-05 0 3.17321992439e-05 0 3.17330992439e-05 1.485 3.17332992439e-05 1.815 3.17341992439e-05 3.3 3.18433844785e-05 3.3 3.18442844785e-05 1.815 3.18444844785e-05 1.485 3.18453844785e-05 0 3.19545697131e-05 0 3.19545697131e-05 0 3.19554697131e-05 1.485 3.19556697131e-05 1.815 3.19565697131e-05 3.3 3.20657549477e-05 3.3 3.20666549477e-05 1.815 3.20668549477e-05 1.485 3.20677549477e-05 0 3.21769401823e-05 0 3.21769401823e-05 0 3.21778401823e-05 1.485 3.21780401823e-05 1.815 3.21789401823e-05 3.3 3.22881254169e-05 3.3 3.22890254169e-05 1.815 3.22892254169e-05 1.485 3.22901254169e-05 0 3.23993106515e-05 0 3.23993106515e-05 0 3.24002106515e-05 1.485 3.24004106515e-05 1.815 3.24013106515e-05 3.3 3.25104958861e-05 3.3 3.25113958861e-05 1.815 3.25115958861e-05 1.485 3.25124958861e-05 0 3.26216811207e-05 0 3.26216811207e-05 0 3.26225811207e-05 1.485 3.26227811207e-05 1.815 3.26236811207e-05 3.3 3.27328663553e-05 3.3 3.27337663553e-05 1.815 3.27339663553e-05 1.485 3.27348663553e-05 0 3.28440515899e-05 0 3.28440515899e-05 0 3.28449515899e-05 1.485 3.28451515899e-05 1.815 3.28460515899e-05 3.3 3.29552368245e-05 3.3 3.29561368245e-05 1.815 3.29563368245e-05 1.485 3.29572368245e-05 0 3.30664220592e-05 0 3.30664220592e-05 0 3.30673220592e-05 1.485 3.30675220592e-05 1.815 3.30684220592e-05 3.3 3.31776072938e-05 3.3 3.31785072938e-05 1.815 3.31787072938e-05 1.485 3.31796072938e-05 0 3.32887925284e-05 0 3.32887925284e-05 0 3.32896925284e-05 1.485 3.32898925284e-05 1.815 3.32907925284e-05 3.3 3.3399977763e-05 3.3 3.3400877763e-05 1.815 3.3401077763e-05 1.485 3.3401977763e-05 0 3.35111629976e-05 0 3.35111629976e-05 0 3.35120629976e-05 1.485 3.35122629976e-05 1.815 3.35131629976e-05 3.3 3.36223482322e-05 3.3 3.36232482322e-05 1.815 3.36234482322e-05 1.485 3.36243482322e-05 0 3.37335334668e-05 0 3.37335334668e-05 0 3.37344334668e-05 1.485 3.37346334668e-05 1.815 3.37355334668e-05 3.3 3.38447187014e-05 3.3 3.38456187014e-05 1.815 3.38458187014e-05 1.485 3.38467187014e-05 0 3.3955903936e-05 0 3.3955903936e-05 0 3.3956803936e-05 1.485 3.3957003936e-05 1.815 3.3957903936e-05 3.3 3.40670891706e-05 3.3 3.40679891706e-05 1.815 3.40681891706e-05 1.485 3.40690891706e-05 0 3.41782744052e-05 0 3.41782744052e-05 0 3.41791744052e-05 1.485 3.41793744052e-05 1.815 3.41802744052e-05 3.3 3.42894596398e-05 3.3 3.42903596398e-05 1.815 3.42905596398e-05 1.485 3.42914596398e-05 0 3.44006448744e-05 0 3.44006448744e-05 0 3.44015448744e-05 1.485 3.44017448744e-05 1.815 3.44026448744e-05 3.3 3.4511830109e-05 3.3 3.4512730109e-05 1.815 3.4512930109e-05 1.485 3.4513830109e-05 0 3.46230153436e-05 0 3.46230153436e-05 0 3.46239153436e-05 1.485 3.46241153436e-05 1.815 3.46250153436e-05 3.3 3.47342005782e-05 3.3 3.47351005782e-05 1.815 3.47353005782e-05 1.485 3.47362005782e-05 0 3.48453858128e-05 0 3.48453858128e-05 0 3.48462858128e-05 1.485 3.48464858128e-05 1.815 3.48473858128e-05 3.3 3.49565710474e-05 3.3 3.49574710474e-05 1.815 3.49576710474e-05 1.485 3.49585710474e-05 0 3.5067756282e-05 0 3.5067756282e-05 0 3.5068656282e-05 1.485 3.5068856282e-05 1.815 3.5069756282e-05 3.3 3.51789415166e-05 3.3 3.51798415166e-05 1.815 3.51800415166e-05 1.485 3.51809415166e-05 0 3.52901267512e-05 0 3.52901267512e-05 0 3.52910267512e-05 1.485 3.52912267512e-05 1.815 3.52921267512e-05 3.3 3.54013119858e-05 3.3 3.54022119858e-05 1.815 3.54024119858e-05 1.485 3.54033119858e-05 0 3.55124972204e-05 0 3.55124972204e-05 0 3.55133972204e-05 1.485 3.55135972204e-05 1.815 3.55144972204e-05 3.3 3.5623682455e-05 3.3 3.5624582455e-05 1.815 3.5624782455e-05 1.485 3.5625682455e-05 0 3.57348676896e-05 0 3.57348676896e-05 0 3.57357676896e-05 1.485 3.57359676896e-05 1.815 3.57368676896e-05 3.3 3.58460529242e-05 3.3 3.58469529242e-05 1.815 3.58471529242e-05 1.485 3.58480529242e-05 0 0.00110011111852 0 0.00110022230376 0 0.00110022230376 0 0.00110022320376 1.485 0.00110022340376 1.815 0.00110022430376 3.3 0.00110033348899 3.3 0.00110033438899 1.815 0.00110033458899 1.485 0.00110033548899 0 0.00110044467423 0 0.00110044467423 0 0.00110044557423 1.485 0.00110044577423 1.815 0.00110044667423 3.3 0.00110055585946 3.3 0.00110055675946 1.815 0.00110055695946 1.485 0.00110055785946 0 0.0011006670447 0 0.0011006670447 0 0.0011006679447 1.485 0.0011006681447 1.815 0.0011006690447 3.3 0.00110077822993 3.3 0.00110077912993 1.815 0.00110077932993 1.485 0.00110078022993 0 0.00110088941517 0 0.00110088941517 0 0.00110089031517 1.485 0.00110089051517 1.815 0.00110089141517 3.3 0.0011010006004 3.3 0.0011010015004 1.815 0.0011010017004 1.485 0.0011010026004 0 0.00110111178563 0 0.00110111178563 0 0.00110111268563 1.485 0.00110111288563 1.815 0.00110111378563 3.3 0.00110122297087 3.3 0.00110122387087 1.815 0.00110122407087 1.485 0.00110122497087 0 0.0011013341561 0 0.0011013341561 0 0.0011013350561 1.485 0.0011013352561 1.815 0.0011013361561 3.3 0.00110144534134 3.3 0.00110144624134 1.815 0.00110144644134 1.485 0.00110144734134 0 0.00110155652657 0 0.00110155652657 0 0.00110155742657 1.485 0.00110155762657 1.815 0.00110155852657 3.3 0.00110166771181 3.3 0.00110166861181 1.815 0.00110166881181 1.485 0.00110166971181 0 0.00110177889704 0 0.00110177889704 0 0.00110177979704 1.485 0.00110177999704 1.815 0.00110178089704 3.3 0.00110189008228 3.3 0.00110189098228 1.815 0.00110189118228 1.485 0.00110189208228 0 0.00110200126751 0 0.00110200126751 0 0.00110200216751 1.485 0.00110200236751 1.815 0.00110200326751 3.3 0.00110211245275 3.3 0.00110211335275 1.815 0.00110211355275 1.485 0.00110211445275 0 0.00110222363798 0 0.00110222363798 0 0.00110222453798 1.485 0.00110222473798 1.815 0.00110222563798 3.3 0.00110233482322 3.3 0.00110233572322 1.815 0.00110233592322 1.485 0.00110233682322 0 0.00110244600845 0 0.00110244600845 0 0.00110244690845 1.485 0.00110244710845 1.815 0.00110244800845 3.3 0.00110255719368 3.3 0.00110255809368 1.815 0.00110255829368 1.485 0.00110255919368 0 0.00110266837892 0 0.00110266837892 0 0.00110266927892 1.485 0.00110266947892 1.815 0.00110267037892 3.3 0.00110277956415 3.3 0.00110278046415 1.815 0.00110278066415 1.485 0.00110278156415 0 0.00110289074939 0 0.00110289074939 0 0.00110289164939 1.485 0.00110289184939 1.815 0.00110289274939 3.3 0.00110300193462 3.3 0.00110300283462 1.815 0.00110300303462 1.485 0.00110300393462 0 0.00110311311986 0 0.00110311311986 0 0.00110311401986 1.485 0.00110311421986 1.815 0.00110311511986 3.3 0.00110322430509 3.3 0.00110322520509 1.815 0.00110322540509 1.485 0.00110322630509 0 0.00110333549033 0 0.00110333549033 0 0.00110333639033 1.485 0.00110333659033 1.815 0.00110333749033 3.3 0.00110344667556 3.3 0.00110344757556 1.815 0.00110344777556 1.485 0.00110344867556 0 0.0011035578608 0 0.0011035578608 0 0.0011035587608 1.485 0.0011035589608 1.815 0.0011035598608 3.3 0.00110366904603 3.3 0.00110366994603 1.815 0.00110367014603 1.485 0.00110367104603 0 0.00110378023127 0 0.00110378023127 0 0.00110378113127 1.485 0.00110378133127 1.815 0.00110378223127 3.3 0.0011038914165 3.3 0.0011038923165 1.815 0.0011038925165 1.485 0.0011038934165 0 0.00110400260173 0 0.00110400260173 0 0.00110400350173 1.485 0.00110400370173 1.815 0.00110400460173 3.3 0.00110411378697 3.3 0.00110411468697 1.815 0.00110411488697 1.485 0.00110411578697 0 0.0011042249722 0 0.0011042249722 0 0.0011042258722 1.485 0.0011042260722 1.815 0.0011042269722 3.3 0.00110433615744 3.3 0.00110433705744 1.815 0.00110433725744 1.485 0.00110433815744 0 0.00110444734267 0 0.00110444734267 0 0.00110444824267 1.485 0.00110444844267 1.815 0.00110444934267 3.3 0.00110455852791 3.3 0.00110455942791 1.815 0.00110455962791 1.485 0.00110456052791 0 0.00110466971314 0 0.00110466971314 0 0.00110467061314 1.485 0.00110467081314 1.815 0.00110467171314 3.3 0.00110478089838 3.3 0.00110478179838 1.815 0.00110478199838 1.485 0.00110478289838 0 0.00110489208361 0 0.00110489208361 0 0.00110489298361 1.485 0.00110489318361 1.815 0.00110489408361 3.3 0.00110500326885 3.3 0.00110500416885 1.815 0.00110500436885 1.485 0.00110500526885 0 0.00110511445408 0 0.00110511445408 0 0.00110511535408 1.485 0.00110511555408 1.815 0.00110511645408 3.3 0.00110522563932 3.3 0.00110522653932 1.815 0.00110522673932 1.485 0.00110522763932 0 0.00110533682455 0 0.00110533682455 0 0.00110533772455 1.485 0.00110533792455 1.815 0.00110533882455 3.3 0.00110544800978 3.3 0.00110544890978 1.815 0.00110544910978 1.485 0.00110545000978 0 0.00110555919502 0 0.00110555919502 0 0.00110556009502 1.485 0.00110556029502 1.815 0.00110556119502 3.3 0.00110567038025 3.3 0.00110567128025 1.815 0.00110567148025 1.485 0.00110567238025 0 0.00110578156549 0 0.00110578156549 0 0.00110578246549 1.485 0.00110578266549 1.815 0.00110578356549 3.3 0.00110589275072 3.3 0.00110589365072 1.815 0.00110589385072 1.485 0.00110589475072 0 0.00110600393596 0 0.00110600393596 0 0.00110600483596 1.485 0.00110600503596 1.815 0.00110600593596 3.3 0.00110611512119 3.3 0.00110611602119 1.815 0.00110611622119 1.485 0.00110611712119 0 0.00110622630643 0 0.00110622630643 0 0.00110622720643 1.485 0.00110622740643 1.815 0.00110622830643 3.3 0.00110633749166 3.3 0.00110633839166 1.815 0.00110633859166 1.485 0.00110633949166 0 0.0011064486769 0 0.0011064486769 0 0.0011064495769 1.485 0.0011064497769 1.815 0.0011064506769 3.3 0.00110655986213 3.3 0.00110656076213 1.815 0.00110656096213 1.485 0.00110656186213 0 0.00110667104736 0 0.00110667104736 0 0.00110667194736 1.485 0.00110667214736 1.815 0.00110667304736 3.3 0.0011067822326 3.3 0.0011067831326 1.815 0.0011067833326 1.485 0.0011067842326 0 0.00110689341783 0 0.00110689341783 0 0.00110689431783 1.485 0.00110689451783 1.815 0.00110689541783 3.3 0.00110700460307 3.3 0.00110700550307 1.815 0.00110700570307 1.485 0.00110700660307 0 0.0011071157883 0 0.0011071157883 0 0.0011071166883 1.485 0.0011071168883 1.815 0.0011071177883 3.3 0.00110722697354 3.3 0.00110722787354 1.815 0.00110722807354 1.485 0.00110722897354 0 0.00110733815877 0 0.00110733815877 0 0.00110733905877 1.485 0.00110733925877 1.815 0.00110734015877 3.3 0.00110744934401 3.3 0.00110745024401 1.815 0.00110745044401 1.485 0.00110745134401 0 0.00110756052924 0 0.00110756052924 0 0.00110756142924 1.485 0.00110756162924 1.815 0.00110756252924 3.3 0.00110767171448 3.3 0.00110767261448 1.815 0.00110767281448 1.485 0.00110767371448 0 0.00110778289971 0 0.00110778289971 0 0.00110778379971 1.485 0.00110778399971 1.815 0.00110778489971 3.3 0.00110789408495 3.3 0.00110789498495 1.815 0.00110789518495 1.485 0.00110789608495 0 0.00110800527018 0 0.00110800527018 0 0.00110800617018 1.485 0.00110800637018 1.815 0.00110800727018 3.3 0.00110811645541 3.3 0.00110811735541 1.815 0.00110811755541 1.485 0.00110811845541 0 0.00110822764065 0 0.00110822764065 0 0.00110822854065 1.485 0.00110822874065 1.815 0.00110822964065 3.3 0.00110833882588 3.3 0.00110833972588 1.815 0.00110833992588 1.485 0.00110834082588 0 0.00110845001112 0 0.00110845001112 0 0.00110845091112 1.485 0.00110845111112 1.815 0.00110845201112 3.3 0.00110856119635 3.3 0.00110856209635 1.815 0.00110856229635 1.485 0.00110856319635 0 0.00110867238159 0 0.00110867238159 0 0.00110867328159 1.485 0.00110867348159 1.815 0.00110867438159 3.3 0.00110878356682 3.3 0.00110878446682 1.815 0.00110878466682 1.485 0.00110878556682 0 0.00110889475206 0 0.00110889475206 0 0.00110889565206 1.485 0.00110889585206 1.815 0.00110889675206 3.3 0.00110900593729 3.3 0.00110900683729 1.815 0.00110900703729 1.485 0.00110900793729 0 0.00110911712253 0 0.00110911712253 0 0.00110911802253 1.485 0.00110911822253 1.815 0.00110911912253 3.3 0.00110922830776 3.3 0.00110922920776 1.815 0.00110922940776 1.485 0.00110923030776 0 0.001109339493 0 0.001109339493 0 0.001109340393 1.485 0.001109340593 1.815 0.001109341493 3.3 0.00110945067823 3.3 0.00110945157823 1.815 0.00110945177823 1.485 0.00110945267823 0 0.00110956186346 0 0.00110956186346 0 0.00110956276346 1.485 0.00110956296346 1.815 0.00110956386346 3.3 0.0011096730487 3.3 0.0011096739487 1.815 0.0011096741487 1.485 0.0011096750487 0 0.00110978423393 0 0.00110978423393 0 0.00110978513393 1.485 0.00110978533393 1.815 0.00110978623393 3.3 0.00110989541917 3.3 0.00110989631917 1.815 0.00110989651917 1.485 0.00110989741917 0 0.0011100066044 0 0.0011100066044 0 0.0011100075044 1.485 0.0011100077044 1.815 0.0011100086044 3.3 0.00111011778964 3.3 0.00111011868964 1.815 0.00111011888964 1.485 0.00111011978964 0 0.00111022897487 0 0.00111022897487 0 0.00111022987487 1.485 0.00111023007487 1.815 0.00111023097487 3.3 0.00111034016011 3.3 0.00111034106011 1.815 0.00111034126011 1.485 0.00111034216011 0 0.00111045134534 0 0.00111045134534 0 0.00111045224534 1.485 0.00111045244534 1.815 0.00111045334534 3.3 0.00111056253058 3.3 0.00111056343058 1.815 0.00111056363058 1.485 0.00111056453058 0 0.00111067371581 0 0.00111067371581 0 0.00111067461581 1.485 0.00111067481581 1.815 0.00111067571581 3.3 0.00111078490105 3.3 0.00111078580105 1.815 0.00111078600105 1.485 0.00111078690105 0 0.00111089608628 0 0.00111089608628 0 0.00111089698628 1.485 0.00111089718628 1.815 0.00111089808628 3.3 0.00111100727151 3.3 0.00111100817151 1.815 0.00111100837151 1.485 0.00111100927151 0 0.00111111845675 0 0.00111111845675 0 0.00111111935675 1.485 0.00111111955675 1.815 0.00111112045675 3.3 0.00111122964198 3.3 0.00111123054198 1.815 0.00111123074198 1.485 0.00111123164198 0 0.00111134082722 0 0.00111134082722 0 0.00111134172722 1.485 0.00111134192722 1.815 0.00111134282722 3.3 0.00111145201245 3.3 0.00111145291245 1.815 0.00111145311245 1.485 0.00111145401245 0 0.00111156319769 0 0.00111156319769 0 0.00111156409769 1.485 0.00111156429769 1.815 0.00111156519769 3.3 0.00111167438292 3.3 0.00111167528292 1.815 0.00111167548292 1.485 0.00111167638292 0 0.00111178556816 0 0.00111178556816 0 0.00111178646816 1.485 0.00111178666816 1.815 0.00111178756816 3.3 0.00111189675339 3.3 0.00111189765339 1.815 0.00111189785339 1.485 0.00111189875339 0 0.00111200793863 0 0.00111200793863 0 0.00111200883863 1.485 0.00111200903863 1.815 0.00111200993863 3.3 0.00111211912386 3.3 0.00111212002386 1.815 0.00111212022386 1.485 0.00111212112386 0 0.00111223030909 0 0.00111223030909 0 0.00111223120909 1.485 0.00111223140909 1.815 0.00111223230909 3.3 0.00111234149433 3.3 0.00111234239433 1.815 0.00111234259433 1.485 0.00111234349433 0 0.00111245267956 0 0.00111245267956 0 0.00111245357956 1.485 0.00111245377956 1.815 0.00111245467956 3.3 0.0011125638648 3.3 0.0011125647648 1.815 0.0011125649648 1.485 0.0011125658648 0 0.00111267505003 0 0.00111267505003 0 0.00111267595003 1.485 0.00111267615003 1.815 0.00111267705003 3.3 0.00111278623527 3.3 0.00111278713527 1.815 0.00111278733527 1.485 0.00111278823527 0 0.0011128974205 0 0.0011128974205 0 0.0011128983205 1.485 0.0011128985205 1.815 0.0011128994205 3.3 0.00111300860574 3.3 0.00111300950574 1.815 0.00111300970574 1.485 0.00111301060574 0 0.00111311979097 0 0.00111311979097 0 0.00111312069097 1.485 0.00111312089097 1.815 0.00111312179097 3.3 0.00111323097621 3.3 0.00111323187621 1.815 0.00111323207621 1.485 0.00111323297621 0 0.00111334216144 0 0.00111334216144 0 0.00111334306144 1.485 0.00111334326144 1.815 0.00111334416144 3.3 0.00111345334668 3.3 0.00111345424668 1.815 0.00111345444668 1.485 0.00111345534668 0 0.00111356453191 0 0.00111356453191 0 0.00111356543191 1.485 0.00111356563191 1.815 0.00111356653191 3.3 0.00111367571714 3.3 0.00111367661714 1.815 0.00111367681714 1.485 0.00111367771714 0 0.00111378690238 0 0.00111378690238 0 0.00111378780238 1.485 0.00111378800238 1.815 0.00111378890238 3.3 0.00111389808761 3.3 0.00111389898761 1.815 0.00111389918761 1.485 0.00111390008761 0 0.00111400927285 0 0.00111400927285 0 0.00111401017285 1.485 0.00111401037285 1.815 0.00111401127285 3.3 0.00111412045808 3.3 0.00111412135808 1.815 0.00111412155808 1.485 0.00111412245808 0 0.00111423164332 0 0.00111423164332 0 0.00111423254332 1.485 0.00111423274332 1.815 0.00111423364332 3.3 0.00111434282855 3.3 0.00111434372855 1.815 0.00111434392855 1.485 0.00111434482855 0 0.00111445401379 0 0.00111445401379 0 0.00111445491379 1.485 0.00111445511379 1.815 0.00111445601379 3.3 0.00111456519902 3.3 0.00111456609902 1.815 0.00111456629902 1.485 0.00111456719902 0 0.00111467638426 0 0.00111467638426 0 0.00111467728426 1.485 0.00111467748426 1.815 0.00111467838426 3.3 0.00111478756949 3.3 0.00111478846949 1.815 0.00111478866949 1.485 0.00111478956949 0 0.00111489875473 0 0.00111489875473 0 0.00111489965473 1.485 0.00111489985473 1.815 0.00111490075473 3.3 0.00111500993996 3.3 0.00111501083996 1.815 0.00111501103996 1.485 0.00111501193996 0 0.00111512112519 0 0.00111512112519 0 0.00111512202519 1.485 0.00111512222519 1.815 0.00111512312519 3.3 0.00111523231043 3.3 0.00111523321043 1.815 0.00111523341043 1.485 0.00111523431043 0 0.00111534349566 0 0.00111534349566 0 0.00111534439566 1.485 0.00111534459566 1.815 0.00111534549566 3.3 0.0011154546809 3.3 0.0011154555809 1.815 0.0011154557809 1.485 0.0011154566809 0 0.00111556586613 0 0.00111556586613 0 0.00111556676613 1.485 0.00111556696613 1.815 0.00111556786613 3.3 0.00111567705137 3.3 0.00111567795137 1.815 0.00111567815137 1.485 0.00111567905137 0 0.0011157882366 0 0.0011157882366 0 0.0011157891366 1.485 0.0011157893366 1.815 0.0011157902366 3.3 0.00111589942184 3.3 0.00111590032184 1.815 0.00111590052184 1.485 0.00111590142184 0 0.00111601060707 0 0.00111601060707 0 0.00111601150707 1.485 0.00111601170707 1.815 0.00111601260707 3.3 0.00111612179231 3.3 0.00111612269231 1.815 0.00111612289231 1.485 0.00111612379231 0 0.00111623297754 0 0.00111623297754 0 0.00111623387754 1.485 0.00111623407754 1.815 0.00111623497754 3.3 0.00111634416278 3.3 0.00111634506278 1.815 0.00111634526278 1.485 0.00111634616278 0 0.00111645534801 0 0.00111645534801 0 0.00111645624801 1.485 0.00111645644801 1.815 0.00111645734801 3.3 0.00111656653324 3.3 0.00111656743324 1.815 0.00111656763324 1.485 0.00111656853324 0 0.00111667771848 0 0.00111667771848 0 0.00111667861848 1.485 0.00111667881848 1.815 0.00111667971848 3.3 0.00111678890371 3.3 0.00111678980371 1.815 0.00111679000371 1.485 0.00111679090371 0 0.00111690008895 0 0.00111690008895 0 0.00111690098895 1.485 0.00111690118895 1.815 0.00111690208895 3.3 0.00111701127418 3.3 0.00111701217418 1.815 0.00111701237418 1.485 0.00111701327418 0 0.00111712245942 0 0.00111712245942 0 0.00111712335942 1.485 0.00111712355942 1.815 0.00111712445942 3.3 0.00111723364465 3.3 0.00111723454465 1.815 0.00111723474465 1.485 0.00111723564465 0 0.00111734482989 0 0.00111734482989 0 0.00111734572989 1.485 0.00111734592989 1.815 0.00111734682989 3.3 0.00111745601512 3.3 0.00111745691512 1.815 0.00111745711512 1.485 0.00111745801512 0 0.00111756720036 0 0.00111756720036 0 0.00111756810036 1.485 0.00111756830036 1.815 0.00111756920036 3.3 0.00111767838559 3.3 0.00111767928559 1.815 0.00111767948559 1.485 0.00111768038559 0 0.00111778957083 0 0.00111778957083 0 0.00111779047083 1.485 0.00111779067083 1.815 0.00111779157083 3.3 0.00111790075606 3.3 0.00111790165606 1.815 0.00111790185606 1.485 0.00111790275606 0 0.00111801194129 0 0.00111801194129 0 0.00111801284129 1.485 0.00111801304129 1.815 0.00111801394129 3.3 0.00111812312653 3.3 0.00111812402653 1.815 0.00111812422653 1.485 0.00111812512653 0 0.00111823431176 0 0.00111823431176 0 0.00111823521176 1.485 0.00111823541176 1.815 0.00111823631176 3.3 0.001118345497 3.3 0.001118346397 1.815 0.001118346597 1.485 0.001118347497 0 0.00111845668223 0 0.00111845668223 0 0.00111845758223 1.485 0.00111845778223 1.815 0.00111845868223 3.3 0.00111856786747 3.3 0.00111856876747 1.815 0.00111856896747 1.485 0.00111856986747 0 0.0011186790527 0 0.0011186790527 0 0.0011186799527 1.485 0.0011186801527 1.815 0.0011186810527 3.3 0.00111879023794 3.3 0.00111879113794 1.815 0.00111879133794 1.485 0.00111879223794 0 0.00111890142317 0 0.00111890142317 0 0.00111890232317 1.485 0.00111890252317 1.815 0.00111890342317 3.3 0.00111901260841 3.3 0.00111901350841 1.815 0.00111901370841 1.485 0.00111901460841 0 0.00111912379364 0 0.00111912379364 0 0.00111912469364 1.485 0.00111912489364 1.815 0.00111912579364 3.3 0.00111923497887 3.3 0.00111923587887 1.815 0.00111923607887 1.485 0.00111923697887 0 0.00111934616411 0 0.00111934616411 0 0.00111934706411 1.485 0.00111934726411 1.815 0.00111934816411 3.3 0.00111945734934 3.3 0.00111945824934 1.815 0.00111945844934 1.485 0.00111945934934 0 0.00111956853458 0 0.00111956853458 0 0.00111956943458 1.485 0.00111956963458 1.815 0.00111957053458 3.3 0.00111967971981 3.3 0.00111968061981 1.815 0.00111968081981 1.485 0.00111968171981 0 0.00111979090505 0 0.00111979090505 0 0.00111979180505 1.485 0.00111979200505 1.815 0.00111979290505 3.3 0.00111990209028 3.3 0.00111990299028 1.815 0.00111990319028 1.485 0.00111990409028 0 0.00112001327552 0 0.00112001327552 0 0.00112001417552 1.485 0.00112001437552 1.815 0.00112001527552 3.3 0.00112012446075 3.3 0.00112012536075 1.815 0.00112012556075 1.485 0.00112012646075 0 0.00112023564599 0 0.00112023564599 0 0.00112023654599 1.485 0.00112023674599 1.815 0.00112023764599 3.3 0.00112034683122 3.3 0.00112034773122 1.815 0.00112034793122 1.485 0.00112034883122 0 0.00112045801646 0 0.00112045801646 0 0.00112045891646 1.485 0.00112045911646 1.815 0.00112046001646 3.3 0.00112056920169 3.3 0.00112057010169 1.815 0.00112057030169 1.485 0.00112057120169 0 0.00112068038692 0 0.00112068038692 0 0.00112068128692 1.485 0.00112068148692 1.815 0.00112068238692 3.3 0.00112079157216 3.3 0.00112079247216 1.815 0.00112079267216 1.485 0.00112079357216 0 0.00112090275739 0 0.00112090275739 0 0.00112090365739 1.485 0.00112090385739 1.815 0.00112090475739 3.3 0.00112101394263 3.3 0.00112101484263 1.815 0.00112101504263 1.485 0.00112101594263 0 0.00112112512786 0 0.00112112512786 0 0.00112112602786 1.485 0.00112112622786 1.815 0.00112112712786 3.3 0.0011212363131 3.3 0.0011212372131 1.815 0.0011212374131 1.485 0.0011212383131 0 0.00112134749833 0 0.00112134749833 0 0.00112134839833 1.485 0.00112134859833 1.815 0.00112134949833 3.3 0.00112145868357 3.3 0.00112145958357 1.815 0.00112145978357 1.485 0.00112146068357 0)
Vsdi sdi_pad 0 pwl(0 0 1.8056415388e-05 0 1.89458972648e-05 0 1.89467972648e-05 1.485 1.89469972648e-05 1.815 1.89478972648e-05 3.3 1.9168267734e-05 3.3 1.9169167734e-05 1.815 1.9169367734e-05 1.485 1.9170267734e-05 0 2.29485657105e-05 0 2.29494657105e-05 1.485 2.29496657105e-05 1.815 2.29505657105e-05 3.3 2.38380475873e-05 3.3 2.38389475873e-05 1.815 2.38391475873e-05 1.485 2.38400475873e-05 0 2.42827885257e-05 0 2.42836885257e-05 1.485 2.42838885257e-05 1.815 2.42847885257e-05 3.3 2.45051589949e-05 3.3 2.45060589949e-05 1.815 2.45062589949e-05 1.485 2.45071589949e-05 0 2.60617522793e-05 0 2.60626522793e-05 1.485 2.60628522793e-05 1.815 2.60637522793e-05 3.3 2.62841227485e-05 3.3 2.62850227485e-05 1.815 2.62852227485e-05 1.485 2.62861227485e-05 0 2.65064932177e-05 0 2.65073932177e-05 1.485 2.65075932177e-05 1.815 2.65084932177e-05 3.3 2.69512341561e-05 3.3 2.69521341561e-05 1.815 2.69523341561e-05 1.485 2.69532341561e-05 0 2.80630865021e-05 0 2.80639865021e-05 1.485 2.80641865021e-05 1.815 2.80650865021e-05 3.3 2.87301979097e-05 3.3 2.87310979097e-05 1.815 2.87312979097e-05 1.485 2.87321979097e-05 0 2.96196797865e-05 0 2.96205797865e-05 1.485 2.96207797865e-05 1.815 2.96216797865e-05 3.3 2.98420502557e-05 3.3 2.98429502557e-05 1.815 2.98431502557e-05 1.485 2.98440502557e-05 0 3.02867911941e-05 0 3.02876911941e-05 1.485 3.02878911941e-05 1.815 3.02887911941e-05 3.3 3.05091616633e-05 3.3 3.05100616633e-05 1.815 3.05102616633e-05 1.485 3.05111616633e-05 0 3.31776072938e-05 0 3.31785072938e-05 1.485 3.31787072938e-05 1.815 3.31796072938e-05 3.3 3.3399977763e-05 3.3 3.3400877763e-05 1.815 3.3401077763e-05 1.485 3.3401977763e-05 0 3.36223482322e-05 0 3.36232482322e-05 1.485 3.36234482322e-05 1.815 3.36243482322e-05 3.3 3.38447187014e-05 3.3 3.38456187014e-05 1.815 3.38458187014e-05 1.485 3.38467187014e-05 0 3.5623682455e-05 0 3.5624582455e-05 1.485 3.5624782455e-05 1.815 3.5625682455e-05 3.3 3.58460529242e-05 3.3 3.58469529242e-05 1.815 3.58471529242e-05 1.485 3.58480529242e-05 0 0.00110011111852 0 0.00110011111852 0 0.00110011201852 1.485 0.00110011221852 1.815 0.00110011311852 3.3 0.00110033348899 3.3 0.00110033438899 1.815 0.00110033458899 1.485 0.00110033548899 0 0.0011010006004 0 0.0011010015004 1.485 0.0011010017004 1.815 0.0011010026004 3.3 0.00110144534134 3.3 0.00110144624134 1.815 0.00110144644134 1.485 0.00110144734134 0 0.00110166771181 0 0.00110166861181 1.485 0.00110166881181 1.815 0.00110166971181 3.3 0.00110189008228 3.3 0.00110189098228 1.815 0.00110189118228 1.485 0.00110189208228 0 0.00110544800978 0 0.00110544890978 1.485 0.00110544910978 1.815 0.00110545000978 3.3 0.00110567038025 3.3 0.00110567128025 1.815 0.00110567148025 1.485 0.00110567238025 0 0.00110633749166 0 0.00110633839166 1.485 0.00110633859166 1.815 0.00110633949166 3.3 0.00110700460307 3.3 0.00110700550307 1.815 0.00110700570307 1.485 0.00110700660307 0 0.00111078490105 0 0.00111078580105 1.485 0.00111078600105 1.815 0.00111078690105 3.3 0.00111100727151 3.3 0.00111100817151 1.815 0.00111100837151 1.485 0.00111100927151 0 0.00111167438292 0 0.00111167528292 1.485 0.00111167548292 1.815 0.00111167638292 3.3 0.0011125638648 3.3 0.0011125647648 1.815 0.0011125649648 1.485 0.0011125658648 0 0.00111612179231 0 0.00111612269231 1.485 0.00111612289231 1.815 0.00111612379231 3.3 0.00111634416278 3.3 0.00111634506278 1.815 0.00111634526278 1.485 0.00111634616278 0 0.00111678890371 0 0.00111678980371 1.485 0.00111679000371 1.815 0.00111679090371 3.3 0.00111701127418 3.3 0.00111701217418 1.815 0.00111701237418 1.485 0.00111701327418 0)
Cw_en en_core 0 20f
Cw_sclk sclk_core 0 20f
Cw_sdi sdi_core 0 20f
* the RTL reads EN / SCLK / SDI as a digital stimulus (XSPICE d_source) with the same edge times as the pad
* PWLs (event at the middle of each edge); the pad models still drive en_core for G1_GATE (README, "Numerical notes")
.model dsrc d_source(input_file="/work/build/g1_top/stim_retry_read_pex_beh_tt_27C_clockfix_threads1_functional_20260921T230629Z_7e8d5798.txt")
adsrc [d_en d_sclk d_sdi] dsrc
* ---- oscillator enable gate (testbench): RTL osc_en, released at 0.1 us
Bosc osc_en_g 0 V = v(osc_en) * min(1, max(0, (time - 0.1u) / 50n))
* ---- behavioural front end (README "Behavioural front end"): parameters from the pex block results
* VREF and the bandgap: fixed 1.04 V (the VREF pad model stays connected)
Vvref vref 0 dc 1.04
Vm_bgr vdda vdda_bgr dc 0
Rbgr_dummy vdda_bgr 0 1e12
* G1_SENSE: ISENSE = VPED + GAIN x (SENSE_P - SENSE_N), single pole at the simulated -3 dB bandwidth
Bis isense_b 0 V = 0.9992 + 19.99*(v(sense_p) - v(sense_n))
Ris isense_b isense 1k
Cis isense 0 3.79845e-11
Vm_sense vdda vdda_sense dc 0
Rsense_dummy vdda_sense 0 1e12
* G1_TRIP: conditioning divider (25 kOhm source, 1 pF hold), DAC taps VREF x (255 + code)/530, ideal clocked comparators
Bic icmp_b 0 V = v(isense)/2
Ric icmp_b icmp 25k
Cic icmp 0 1p
Bvths vth_soft 0 V = 1.04*(255 + v(cs))/530
Bvthh vth_hard 0 V = 1.04*(255 + v(ch))/530
Bcs cs 0 V = 1*(0.5 + 0.5*tanh((v(soft0) - 0.6)/0.05)) + 2*(0.5 + 0.5*tanh((v(soft1) - 0.6)/0.05)) + 4*(0.5 + 0.5*tanh((v(soft2) - 0.6)/0.05)) + 8*(0.5 + 0.5*tanh((v(soft3) - 0.6)/0.05)) + 16*(0.5 + 0.5*tanh((v(soft4) - 0.6)/0.05)) + 32*(0.5 + 0.5*tanh((v(soft5) - 0.6)/0.05)) + 64*(0.5 + 0.5*tanh((v(soft6) - 0.6)/0.05)) + 128*(0.5 + 0.5*tanh((v(soft7) - 0.6)/0.05))
Bch ch 0 V = 1*(0.5 + 0.5*tanh((v(hard0) - 0.6)/0.05)) + 2*(0.5 + 0.5*tanh((v(hard1) - 0.6)/0.05)) + 4*(0.5 + 0.5*tanh((v(hard2) - 0.6)/0.05)) + 8*(0.5 + 0.5*tanh((v(hard3) - 0.6)/0.05)) + 16*(0.5 + 0.5*tanh((v(hard4) - 0.6)/0.05)) + 32*(0.5 + 0.5*tanh((v(hard5) - 0.6)/0.05)) + 64*(0.5 + 0.5*tanh((v(hard6) - 0.6)/0.05)) + 128*(0.5 + 0.5*tanh((v(hard7) - 0.6)/0.05))
* comparator decisions as smooth (2 mV wide) functions of the input difference, sampled by ideal flip-flops
Bcmps cmps_a 0 V = 0.6 + 0.6*tanh((v(icmp) - v(vth_soft))/2m)
Bcmph cmph_a 0 V = 0.6 + 0.6*tanh((v(icmp) - v(vth_hard))/2m)
.model dffm d_dff(clk_delay=1n set_delay=1n reset_delay=1n ic=0 rise_delay=0.5n fall_delay=0.5n)
.model dinv d_inverter(rise_delay=0.2n fall_delay=0.2n)
Vzero zero_a 0 dc 0
acmpa [cmps_a cmph_a zero_a] [d_cmps_a d_cmph_a d_zero] adc
acinv d_cmp_clk d_cmp_clk_n dinv
* d_dff ports: data clk set reset out nout (set/reset tied to a digital 0: a null port reads as unknown)
acs d_cmps_a d_cmp_clk d_zero d_zero d_cmps_q null dffm
ach d_cmph_a d_cmp_clk_n d_zero d_zero d_cmph_q null dffm
acmpd [d_cmps_q d_cmph_q] [cmp_soft cmp_hard] dac
Vm_tripa vdda vdda_trip dc 0
Vm_tripd vdd vdd_trip dc 0
Rtripa_dummy vdda_trip 0 1e12
Rtripd_dummy vdd_trip 0 1e12
* G1_OSC: ideal square wave at the block-simulated frequency, gated by the enable
Vosc_i osc_i 0 pulse(0 1.2 1e-07 1n 1n 5.45926e-08 1.11185e-07)
Bosc_clk osc_clk 0 V = v(osc_i) * (0.5 + 0.5*tanh((v(osc_en_g) - 0.6)/0.05))
Vm_osc vdd vdd_osc dc 0
Rosc_dummy vdd_osc 0 1e12
Vm_gatea vdda vdda_gate dc 0
Vm_gated vdd vdd_gate dc 0
XGATE trip_d clr_d fast_en cmp_hard en_core gate_core fault_core tripped vdd_gate vdda_gate 0 g1_gate
Cw_tripped tripped 0 20f
* ---- digital macro: the real RTL through XSPICE d_cosim (Icarus Verilog shim ivlng)
.model adc adc_bridge(in_low=0.55 in_high=0.65 rise_delay=1e-12 fall_delay=1e-12)
.model adc_clock adc_bridge(in_low=0.6 in_high=0.6 rise_delay=1e-12 fall_delay=1e-12)
.model dac dac_bridge(out_low=0 out_high=1.2 out_undef=0.6 t_rise=0.3n t_fall=0.3n)
.model rtl d_cosim simulation="ivlng" sim_args=["/work/build/g1_top/g1_dig_cosim.vvp"]
aclock [osc_clk] [d_osc_clk] adc_clock
aadc [cmp_soft cmp_hard tripped] [d_cmp_soft d_cmp_hard d_tripped] adc
adig [d_osc_clk d_en d_sclk d_sdi d_cmp_soft d_cmp_hard d_tripped] [d_cmp_clk d_s7 d_s6 d_s5 d_s4 d_s3 d_s2 d_s1 d_s0 d_h7 d_h6 d_h5 d_h4 d_h3 d_h2 d_h1 d_h0 d_trip_d d_clr_d d_fast_en d_osc_en d_t3 d_t2 d_t1 d_t0 d_trip d_gate_en d_cause1 d_cause0 d_sdo d_sp15 d_sp14 d_sp13 d_sp12 d_sp11 d_sp10 d_sp9 d_sp8 d_sp7 d_sp6 d_sp5 d_sp4 d_sp3 d_sp2 d_sp1 d_sp0 d_inrush d_softarmed] rtl
adac [d_cmp_clk d_s7 d_s6 d_s5 d_s4 d_s3 d_s2 d_s1 d_s0 d_h7 d_h6 d_h5 d_h4 d_h3 d_h2 d_h1 d_h0 d_trip_d d_clr_d d_fast_en d_osc_en d_t3 d_t2 d_t1 d_t0 d_trip d_gate_en d_cause1 d_cause0 d_sdo d_sp15 d_sp14 d_sp13 d_sp12 d_sp11 d_sp10 d_sp9 d_sp8 d_sp7 d_sp6 d_sp5 d_sp4 d_sp3 d_sp2 d_sp1 d_sp0 d_inrush d_softarmed] [cmp_clk soft7 soft6 soft5 soft4 soft3 soft2 soft1 soft0 hard7 hard6 hard5 hard4 hard3 hard2 hard1 hard0 trip_d clr_d fast_en osc_en trim3 trim2 trim1 trim0 dig_trip dig_gate_en cause1 cause0 sdo sp15 sp14 sp13 sp12 sp11 sp10 sp9 sp8 sp7 sp6 sp5 sp4 sp3 sp2 sp1 sp0 inrush_active soft_armed] dac
.save v(gate) v(gfet) v(tripped) v(isense) v(cmp_soft) v(cmp_hard) v(trip_d) v(clr_d) v(fast_en) v(osc_clk) v(cmp_clk)
+ v(vref) v(iptat) v(en_core) v(shp) v(shn) v(fault_n) v(gate_core) v(vdda) v(vdd) v(iovdd) v(iprof) v(osc_en_g)
+ v(icmp) v(vth_soft) v(vth_hard) v(dig_trip) v(cause1) v(cause0) v(sclk_pad) v(sdi_pad) v(sdo)
+ v(soft0) v(soft1) v(soft2) v(soft3) v(soft4) v(soft5) v(soft6) v(soft7) v(hard0) v(hard1) v(hard2) v(hard3) v(hard4) v(hard5) v(hard6) v(hard7)
+ v(sp0) v(sp1) v(sp2) v(sp3) v(sp4) v(sp5) v(sp6) v(sp7) v(sp8) v(sp9) v(sp10) v(sp11) v(sp12) v(sp13) v(sp14) v(sp15) v(inrush_active) v(soft_armed)
+ i(vim) i(vma) i(vmi) i(v12) i(vm_bgr) i(vm_sense) i(vm_tripa) i(vm_tripd) i(vm_osc) i(vm_gatea) i(vm_gated)
.control
set num_threads=1
set filetype=ascii
set wr_singlescale
set wr_vecnames
tran 1e-07 1140u 0 5e-09
* quiet operating values after the register write(s)
meas tran vref_q find v(vref) at=37.8461u
meas tran isense_q find v(isense) at=37.8461u
meas tran icmp_q find v(icmp) at=37.8461u
meas tran vths_q find v(vth_soft) at=37.8461u
meas tran vthh_q find v(vth_hard) at=37.8461u
meas tran iload_q find i(vim) at=37.8461u
meas tran gate_q find v(gate) at=37.8461u
meas tran fastq find v(fast_en) at=37.8461u
meas tran t_inrush_off when v(inrush_active)=0.6 fall=1 from=3u
meas tran inrush_q find v(inrush_active) at=37.8461u
meas tran softarmed_end find v(soft_armed) at=1140u
let cs_v = 1*(v(soft0) gt 0.6) + 2*(v(soft1) gt 0.6) + 4*(v(soft2) gt 0.6) + 8*(v(soft3) gt 0.6) + 16*(v(soft4) gt 0.6) + 32*(v(soft5) gt 0.6) + 64*(v(soft6) gt 0.6) + 128*(v(soft7) gt 0.6)
let ch_v = 1*(v(hard0) gt 0.6) + 2*(v(hard1) gt 0.6) + 4*(v(hard2) gt 0.6) + 8*(v(hard3) gt 0.6) + 16*(v(hard4) gt 0.6) + 32*(v(hard5) gt 0.6) + 64*(v(hard6) gt 0.6) + 128*(v(hard7) gt 0.6)
meas tran code_soft find cs_v at=37.8461u
meas tran code_hard find ch_v at=37.8461u
let t_inrush_off_us = t_inrush_off*1e6
echo "QUIET vref=" $&vref_q " isense=" $&isense_q " icmp=" $&icmp_q " vth_soft=" $&vths_q " vth_hard=" $&vthh_q " iload_A=" $&iload_q " gate=" $&gate_q " code_soft=" $&code_soft " code_hard=" $&code_hard " fast_en=" $&fastq " inrush_active=" $&inrush_q " t_inrush_off_us=" $&t_inrush_off_us " soft_armed_end=" $&softarmed_end
* clocks: 20 oscillator periods and 10 strobe periods after the configuration
meas tran tosc1 when v(osc_clk)=0.6 rise=1 from=36.8461u
meas tran tosc2 when v(osc_clk)=0.6 rise=21 from=36.8461u
let fosc_mhz = 20e-6/(tosc2 - tosc1)
meas tran tcc1 when v(cmp_clk)=0.6 rise=1 from=36.8461u
meas tran tcc2 when v(cmp_clk)=0.6 rise=11 from=36.8461u
let fcmp_mhz = 10e-6/(tcc2 - tcc1)
echo "CLOCK f_osc_MHz=" $&fosc_mhz " f_cmp_MHz=" $&fcmp_mhz " (RTL clock: ideal source at the block-simulated frequency)"
* supply currents averaged over the quiet armed window
let i_vdda = i(vma)
meas tran ia_vdda avg i_vdda from=38.8461u to=40u
let ua_vdda = ia_vdda*1e6
let i_iovdd = i(vmi)
meas tran ia_iovdd avg i_iovdd from=38.8461u to=40u
let ua_iovdd = ia_iovdd*1e6
let i_vdd = -i(v12)
meas tran ia_vdd avg i_vdd from=38.8461u to=40u
let ua_vdd = ia_vdd*1e6
let i_bgr = i(vm_bgr)
meas tran ia_bgr avg i_bgr from=38.8461u to=40u
let ua_bgr = ia_bgr*1e6
let i_sense = i(vm_sense)
meas tran ia_sense avg i_sense from=38.8461u to=40u
let ua_sense = ia_sense*1e6
let i_tripa = i(vm_tripa)
meas tran ia_tripa avg i_tripa from=38.8461u to=40u
let ua_tripa = ia_tripa*1e6
let i_tripd = i(vm_tripd)
meas tran ia_tripd avg i_tripd from=38.8461u to=40u
let ua_tripd = ia_tripd*1e6
let i_osc = i(vm_osc)
meas tran ia_osc avg i_osc from=38.8461u to=40u
let ua_osc = ia_osc*1e6
let i_gatea = i(vm_gatea)
meas tran ia_gatea avg i_gatea from=38.8461u to=40u
let ua_gatea = ia_gatea*1e6
let i_gated = i(vm_gated)
meas tran ia_gated avg i_gated from=38.8461u to=40u
let ua_gated = ia_gated*1e6
echo "SUPPLY_uA window=38.8461-40us VDDA=" $&ua_vdda " IOVDD=" $&ua_iovdd " VDD=" $&ua_vdd " | bgr=" $&ua_bgr " sense=" $&ua_sense " trip_3v3=" $&ua_tripa " trip_1v2=" $&ua_tripd " osc=" $&ua_osc " gate_3v3=" $&ua_gatea " gate_1v2=" $&ua_gated
* trip evaluation after the load event at T_STEP
let tstep_s = 40u
meas tran tripped_max max v(tripped) from=36.8461u to=1140u
meas tran tripped_pre max v(tripped) from=36.8461u to=40u
meas tran t_tripped when v(tripped)=0.6 rise=1 from=40u
meas tran t_trip_d when v(trip_d)=0.6 rise=1 from=40u
meas tran t_gate1v when v(gate)=1.0 fall=1 from=40u
meas tran t_gate03 when v(gate)=0.33 fall=1 from=40u
meas tran gate_min min v(gate) from=40u to=1140u
meas tran gate_end find v(gate) at=1140u
meas tran ipk max i(vim) from=40u to=1140u
meas tran i_end find i(vim) at=1140u
meas tran isense_pk max v(isense) from=40u to=1140u
meas tran cause1e find v(cause1) at=1140u
meas tran cause0e find v(cause0) at=1140u
meas tran fault_end find v(fault_n) at=1140u
let sp_v = 1*(v(sp0) gt 0.6) + 2*(v(sp1) gt 0.6) + 4*(v(sp2) gt 0.6) + 8*(v(sp3) gt 0.6) + 16*(v(sp4) gt 0.6) + 32*(v(sp5) gt 0.6) + 64*(v(sp6) gt 0.6) + 128*(v(sp7) gt 0.6) + 256*(v(sp8) gt 0.6) + 512*(v(sp9) gt 0.6) + 1024*(v(sp10) gt 0.6) + 2048*(v(sp11) gt 0.6) + 4096*(v(sp12) gt 0.6) + 8192*(v(sp13) gt 0.6) + 16384*(v(sp14) gt 0.6) + 32768*(v(sp15) gt 0.6)
meas tran soft_peak find sp_v at=1140u
let cause = 2*(cause1e gt 0.6) + (cause0e gt 0.6)
let dt_gate1v_us = (t_gate1v - tstep_s)*1e6
let dt_gate03_us = (t_gate03 - tstep_s)*1e6
let dt_tripped_us = (t_tripped - tstep_s)*1e6
let dt_trip_d_us = (t_trip_d - tstep_s)*1e6
echo "TRIP tripped_max=" $&tripped_max " tripped_before_event=" $&tripped_pre " t_tripped_us=" $&dt_tripped_us " t_trip_d_us=" $&dt_trip_d_us " t_gate_1V_us=" $&dt_gate1v_us " t_gate_0.33V_us=" $&dt_gate03_us " gate_min=" $&gate_min " gate_end=" $&gate_end " ipk_A=" $&ipk " i_end_A=" $&i_end " isense_pk=" $&isense_pk " cause=" $&cause " fault_n_end=" $&fault_end " soft_peak=" $&soft_peak
let qi = integ(i(vim))
meas tran q_step find qi at=40u
meas tran q_end find qi at=1140u
let q_passed = q_end - q_step
echo "CHARGE after_event_As=" $&q_passed
wrdata /work/build/g1_top/state_retry_read_pex_beh_tt_27C_clockfix_threads1_functional_20260921T230629Z_7e8d5798.txt v(en_core) v(inrush_active) v(dig_trip) v(fast_en) v(cause1) v(cause0) v(soft0) v(soft1) v(soft2) v(soft3) v(soft4) v(soft5) v(soft6) v(soft7) v(hard0) v(hard1) v(hard2) v(hard3) v(hard4) v(hard5) v(hard6) v(hard7) v(soft_armed) v(sp0) v(sp1) v(sp2) v(sp3) v(sp4) v(sp5) v(sp6) v(sp7) v(sp8) v(sp9) v(sp10) v(sp11) v(sp12) v(sp13) v(sp14) v(sp15) v(sclk_pad) v(sdi_pad) v(sdo) v(clr_d)
linearize v(gate) v(gfet) v(tripped) v(isense) v(cmp_soft) v(cmp_hard) v(cmp_clk) v(trip_d) v(osc_clk) v(vref) v(en_core) v(shp) v(fault_n) v(vdda) v(vdd) v(iprof) v(icmp) v(vth_soft) v(vth_hard) v(dig_trip) v(inrush_active) i(vim) i(vma) i(vmi) i(v12)
wrdata /work/build/g1_top/waves_retry_read_pex_beh_tt_27C_clockfix_threads1_functional_20260921T230629Z_7e8d5798.txt v(gate) v(gfet) v(tripped) v(isense) v(cmp_soft) v(cmp_hard) v(cmp_clk) v(trip_d) v(osc_clk) v(vref) v(en_core) v(shp) v(fault_n) v(vdda) v(vdd) v(iprof) v(icmp) v(vth_soft) v(vth_hard) v(dig_trip) v(inrush_active) i(vim) i(vma) i(vmi) i(v12)
.endc
.end
