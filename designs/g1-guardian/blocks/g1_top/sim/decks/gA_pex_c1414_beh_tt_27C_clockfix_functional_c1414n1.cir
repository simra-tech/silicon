* G1_TOP breaker path, chip level: (g-A) power-up: IOVDD/VDDA ramp 1-3 us, VDD 5-7 us, EN low until 12 us; GATE loaded by 5 nF + 10 Ohm only
* case gA | block netlists pex | front end beh | clock to the RTL ideal | corner tt (mos_tt res_typ cap_typ hbt_typ) | 27 degC | run_top.py
* blockset c1414 (run_top.py BLOCKSETS); ideal-clock frequency 9.436194721 MHz
* netlist bgr: blocks/g1_bgr/sim/postlayout/g1_bgr586_pex.spice
* netlist sense: blocks/g1_sense/sim/postlayout/g1_sense_r100_partialc.spice
* netlist trip: blocks/g1_trip/sim/postlayout/g1_trip_nf4_pex.spice
* netlist osc: blocks/g1_osc/sim/qualification/fulltree_r095_load_20260924/common/osc.spice
* netlist gate: blocks/g1_gate/sim/postlayout/g1_gate_pex.spice
* NOTE bgr: BGR586 kpex 2.5D CC extraction of bank.gds (chip BGR layout), 978 capacitors
* NOTE sense: R100 own-native partial-field C (unbound VSUBS excluded; physical field acceptance not established)
.param VDDA=3.3 VDD=1.2 IOVDD=3.3 RSH=25m RGND=10m INOM=1 CVREF=1e-08
.lib /foss/pdks/ihp-sg13g2/libs.tech/ngspice/models/cornerMOSlv.lib mos_tt
.lib /foss/pdks/ihp-sg13g2/libs.tech/ngspice/models/cornerMOShv.lib mos_tt
.lib /foss/pdks/ihp-sg13g2/libs.tech/ngspice/models/cornerRES.lib res_typ
.lib /foss/pdks/ihp-sg13g2/libs.tech/ngspice/models/cornerCAP.lib cap_typ
.lib /foss/pdks/ihp-sg13g2/libs.tech/ngspice/models/cornerHBT.lib hbt_typ
.lib /foss/pdks/ihp-sg13g2/libs.tech/ngspice/models/cornerDIO.lib dio_tt
.include /foss/pdks/ihp-sg13g2/libs.ref/sg13g2_io/spice/sg13g2_io.spi
.include /work/designs/g1-guardian/blocks/g1_gate/sim/postlayout/g1_gate_pex.spice
.temp 27
.global sub!
Vsub sub! 0 dc 0
* solver (README, "Numerical notes"): gear integration and loose absolute tolerances are what the PDK IO-pad
* models need when XSPICE events fall on their switching edges (with abstol 1e-9 / vntol 1e-5 the diode
* internal nodes stop converging: "timestep too small"); the DAC mux-tree nodes need rshunt; XSPICE forces
* trtol = 1, which the comparator decisions need at this reltol; default gmin (1e-13 stalls the pads)
.option method=gear itl4=100 reltol=0.002 abstol=1e-8 vntol=1e-4 chgtol=1e-12 rshunt=1e12
* ---- supplies: one 3.3 V board rail feeds VDDA (pin 7) and IOVDD (pin 3), PLAN D14; 1.2 V VDD (pin 1)
V33 rail33 0 pwl(0 0 1e-06 0 3e-06 3.3)
Vma rail33 vdda_s dc 0
Vmi rail33 iovdd_s dc 0
Rsa vdda_s vdda 0.5
Cda vdda 0 1n
Rsi iovdd_s iovdd 0.5
Cdi iovdd 0 1n
V12 vdd_s 0 pwl(0 0 5e-06 0 7e-06 1.2)
Rsd vdd_s vdd 0.5
Cdd vdd 0 1n
* ---- board: load current profile (1 V = 1 A) x switch on the FET gate node, shunt, Kelvin traces, FET gate
Vprof iprof 0 pwl(0 1)
Bload 0 ldi I = v(iprof) * (0.5 + 0.5*tanh((v(gfet) - 1.5)/0.15))
Vim ldi shp dc 0
Rsh shp shn {RSH}
Rgnd shn 0 {RGND}
Rkp shp sense_p 1
Rkn shn sense_n 1
Rg gate gfet 10
Cgate gfet 0 5n
Cfault fault_n 0 20p
* ---- pads (PDK sg13g2_io SPICE models): SENSE_P/N on the bare pad terminal, VREF on the padres terminal
* (587 Ohm secondary protection, padframe/README.md); the VREF bond pad carries the board capacitor CVREF
XPSP sense_p sense_p_res vdd 0 iovdd 0 sg13g2_IOPadAnalog
XPSN sense_n sense_n_res vdd 0 iovdd 0 sg13g2_IOPadAnalog
XPVREF vref_pad vref vdd 0 iovdd 0 sg13g2_IOPadAnalog
Cvref_ext vref_pad 0 {CVREF}
XPEN en_pad en_core vdd 0 iovdd 0 sg13g2_IOPadIn
XPSCLK sclk_pad sclk_core vdd 0 iovdd 0 sg13g2_IOPadIn
XPSDI sdi_pad sdi_core vdd 0 iovdd 0 sg13g2_IOPadIn
XPG gate gate_core vdd 0 iovdd 0 sg13g2_IOPadOut30mA
XPF fault_n fault_core vdd 0 iovdd 0 sg13g2_IOPadOut4mA
Ven en_pad 0 pwl(0 0 1.20221787305e-05 0 1.20230787305e-05 1.485 1.20232787305e-05 1.815 1.20241787305e-05 3.3)
Vsclk sclk_pad 0 pwl(0 0)
Vsdi sdi_pad 0 pwl(0 0)
Cw_en en_core 0 20f
Cw_sclk sclk_core 0 20f
Cw_sdi sdi_core 0 20f
* the RTL reads EN / SCLK / SDI as a digital stimulus (XSPICE d_source) with the same edge times as the pad
* PWLs (event at the middle of each edge); the pad models still drive en_core for G1_GATE (README, "Numerical notes")
.model dsrc d_source(input_file="/work/build/g1_top/stim_gA_pex_c1414_beh_tt_27C_clockfix_functional_c1414n1.txt")
adsrc [d_en d_sclk d_sdi] dsrc
* ---- oscillator enable gate (testbench): RTL osc_en, released at 0.1 us
Bosc osc_en_g 0 V = v(osc_en) * min(1, max(0, (time - 0.1u) / 50n))
* ---- behavioural front end (README "Behavioural front end"): parameters from the pex block results
* VREF and the bandgap: fixed 1.04 V (the VREF pad model stays connected)
Vvref vref 0 dc 1.04
Vm_bgr vdda vdda_bgr dc 0
Rbgr_dummy vdda_bgr 0 1e12
* G1_SENSE: ISENSE = VPED + GAIN x (SENSE_P - SENSE_N), single pole at the simulated -3 dB bandwidth
Bis isense_b 0 V = 0.9992 + 19.99*(v(sense_p) - v(sense_n))
Ris isense_b isense 1k
Cis isense 0 3.79845e-11
Vm_sense vdda vdda_sense dc 0
Rsense_dummy vdda_sense 0 1e12
* G1_TRIP: conditioning divider (25 kOhm source, 1 pF hold), DAC taps VREF x (255 + code)/530, ideal clocked comparators
Bic icmp_b 0 V = v(isense)/2
Ric icmp_b icmp 25k
Cic icmp 0 1p
Bvths vth_soft 0 V = 1.04*(255 + v(cs))/530
Bvthh vth_hard 0 V = 1.04*(255 + v(ch))/530
Bcs cs 0 V = 1*(0.5 + 0.5*tanh((v(soft0) - 0.6)/0.05)) + 2*(0.5 + 0.5*tanh((v(soft1) - 0.6)/0.05)) + 4*(0.5 + 0.5*tanh((v(soft2) - 0.6)/0.05)) + 8*(0.5 + 0.5*tanh((v(soft3) - 0.6)/0.05)) + 16*(0.5 + 0.5*tanh((v(soft4) - 0.6)/0.05)) + 32*(0.5 + 0.5*tanh((v(soft5) - 0.6)/0.05)) + 64*(0.5 + 0.5*tanh((v(soft6) - 0.6)/0.05)) + 128*(0.5 + 0.5*tanh((v(soft7) - 0.6)/0.05))
Bch ch 0 V = 1*(0.5 + 0.5*tanh((v(hard0) - 0.6)/0.05)) + 2*(0.5 + 0.5*tanh((v(hard1) - 0.6)/0.05)) + 4*(0.5 + 0.5*tanh((v(hard2) - 0.6)/0.05)) + 8*(0.5 + 0.5*tanh((v(hard3) - 0.6)/0.05)) + 16*(0.5 + 0.5*tanh((v(hard4) - 0.6)/0.05)) + 32*(0.5 + 0.5*tanh((v(hard5) - 0.6)/0.05)) + 64*(0.5 + 0.5*tanh((v(hard6) - 0.6)/0.05)) + 128*(0.5 + 0.5*tanh((v(hard7) - 0.6)/0.05))
* comparator decisions as smooth (2 mV wide) functions of the input difference, sampled by ideal flip-flops
Bcmps cmps_a 0 V = 0.6 + 0.6*tanh((v(icmp) - v(vth_soft))/2m)
Bcmph cmph_a 0 V = 0.6 + 0.6*tanh((v(icmp) - v(vth_hard))/2m)
.model dffm d_dff(clk_delay=1n set_delay=1n reset_delay=1n ic=0 rise_delay=0.5n fall_delay=0.5n)
.model dinv d_inverter(rise_delay=0.2n fall_delay=0.2n)
Vzero zero_a 0 dc 0
acmpa [cmps_a cmph_a zero_a] [d_cmps_a d_cmph_a d_zero] adc
acinv d_cmp_clk d_cmp_clk_n dinv
* d_dff ports: data clk set reset out nout (set/reset tied to a digital 0: a null port reads as unknown)
acs d_cmps_a d_cmp_clk d_zero d_zero d_cmps_q null dffm
ach d_cmph_a d_cmp_clk_n d_zero d_zero d_cmph_q null dffm
acmpd [d_cmps_q d_cmph_q] [cmp_soft cmp_hard] dac
Vm_tripa vdda vdda_trip dc 0
Vm_tripd vdd vdd_trip dc 0
Rtripa_dummy vdda_trip 0 1e12
Rtripd_dummy vdd_trip 0 1e12
* G1_OSC: ideal square wave at the block-simulated frequency, gated by the enable
Vosc_i osc_i 0 pulse(0 1.2 1e-07 1n 1n 5.19875e-08 1.05975e-07)
Bosc_clk osc_clk 0 V = v(osc_i) * (0.5 + 0.5*tanh((v(osc_en_g) - 0.6)/0.05))
Vm_osc vdd vdd_osc dc 0
Rosc_dummy vdd_osc 0 1e12
Vm_gatea vdda vdda_gate dc 0
Vm_gated vdd vdd_gate dc 0
XGATE trip_d clr_d fast_en cmp_hard en_core gate_core fault_core tripped vdd_gate vdda_gate 0 g1_gate
Cw_tripped tripped 0 20f
* ---- digital macro: the real RTL through XSPICE d_cosim (Icarus Verilog shim ivlng)
.model adc adc_bridge(in_low=0.55 in_high=0.65 rise_delay=1e-12 fall_delay=1e-12)
.model adc_clock adc_bridge(in_low=0.6 in_high=0.6 rise_delay=1e-12 fall_delay=1e-12)
.model dac dac_bridge(out_low=0 out_high=1.2 out_undef=0.6 t_rise=0.3n t_fall=0.3n)
.model rtl d_cosim simulation="ivlng" sim_args=["/work/build/g1_top/g1_dig_cosim.vvp"]
aclock [osc_clk] [d_osc_clk] adc_clock
aadc [cmp_soft cmp_hard tripped] [d_cmp_soft d_cmp_hard d_tripped] adc
adig [d_osc_clk d_en d_sclk d_sdi d_cmp_soft d_cmp_hard d_tripped] [d_cmp_clk d_s7 d_s6 d_s5 d_s4 d_s3 d_s2 d_s1 d_s0 d_h7 d_h6 d_h5 d_h4 d_h3 d_h2 d_h1 d_h0 d_trip_d d_clr_d d_fast_en d_osc_en d_t3 d_t2 d_t1 d_t0 d_trip d_gate_en d_cause1 d_cause0 d_sdo d_sp15 d_sp14 d_sp13 d_sp12 d_sp11 d_sp10 d_sp9 d_sp8 d_sp7 d_sp6 d_sp5 d_sp4 d_sp3 d_sp2 d_sp1 d_sp0 d_inrush d_softarmed] rtl
adac [d_cmp_clk d_s7 d_s6 d_s5 d_s4 d_s3 d_s2 d_s1 d_s0 d_h7 d_h6 d_h5 d_h4 d_h3 d_h2 d_h1 d_h0 d_trip_d d_clr_d d_fast_en d_osc_en d_t3 d_t2 d_t1 d_t0 d_trip d_gate_en d_cause1 d_cause0 d_sdo d_sp15 d_sp14 d_sp13 d_sp12 d_sp11 d_sp10 d_sp9 d_sp8 d_sp7 d_sp6 d_sp5 d_sp4 d_sp3 d_sp2 d_sp1 d_sp0 d_inrush d_softarmed] [cmp_clk soft7 soft6 soft5 soft4 soft3 soft2 soft1 soft0 hard7 hard6 hard5 hard4 hard3 hard2 hard1 hard0 trip_d clr_d fast_en osc_en trim3 trim2 trim1 trim0 dig_trip dig_gate_en cause1 cause0 sdo sp15 sp14 sp13 sp12 sp11 sp10 sp9 sp8 sp7 sp6 sp5 sp4 sp3 sp2 sp1 sp0 inrush_active soft_armed] dac
.save v(gate) v(gfet) v(tripped) v(isense) v(cmp_soft) v(cmp_hard) v(trip_d) v(clr_d) v(fast_en) v(osc_clk) v(cmp_clk)
+ v(vref) v(iptat) v(en_core) v(shp) v(shn) v(fault_n) v(gate_core) v(vdda) v(vdd) v(iovdd) v(iprof) v(osc_en_g)
+ v(icmp) v(vth_soft) v(vth_hard) v(dig_trip) v(cause1) v(cause0) v(sclk_pad) v(sdi_pad) v(sdo)
+ v(soft0) v(soft1) v(soft2) v(soft3) v(soft4) v(soft5) v(soft6) v(soft7) v(hard0) v(hard1) v(hard2) v(hard3) v(hard4) v(hard5) v(hard6) v(hard7)
+ v(sp0) v(sp1) v(sp2) v(sp3) v(sp4) v(sp5) v(sp6) v(sp7) v(sp8) v(sp9) v(sp10) v(sp11) v(sp12) v(sp13) v(sp14) v(sp15) v(inrush_active) v(soft_armed)
+ i(vim) i(vma) i(vmi) i(v12) i(vm_bgr) i(vm_sense) i(vm_tripa) i(vm_tripd) i(vm_osc) i(vm_gatea) i(vm_gated)
.control
set filetype=ascii
set wr_singlescale
set wr_vecnames
tran 2e-08 16u 0 2e-08
meas tran gmax_ramps max v(gate) from=0 to=11.9222u
meas tran gc_max max v(gate_core) from=0 to=11.9222u
meas tran g_end find v(gate) at=16u
meas tran t_g1r when v(gate)=1.0 rise=1 from=0 to=11.9222u
meas tran t_g1f when v(gate)=1.0 fall=1 from=0 to=11.9222u
let t_high_us = (t_g1f - t_g1r)*1e6
meas tran ipk_ramps max i(vim) from=0 to=11.9222u
let qi = integ(i(vim))
meas tran q_ramps find qi at=11.9222u
meas tran tripped_ramps max v(tripped) from=0 to=11.9222u
meas tran en_core_max max v(en_core) from=0 to=11.9222u
echo "POWERUP GATE_max_EN_low=" $&gmax_ramps " gate_core_max=" $&gc_max " en_core_max=" $&en_core_max " GATE_above_1V_from_us=" $&t_g1r " to_us=" $&t_g1f " duration_us=" $&t_high_us " load_peak_A=" $&ipk_ramps " charge_As=" $&q_ramps " tripped_max=" $&tripped_ramps " GATE_after_EN=" $&g_end
wrdata /work/build/g1_top/state_gA_pex_c1414_beh_tt_27C_clockfix_functional_c1414n1.txt v(en_core) v(inrush_active) v(dig_trip) v(fast_en) v(cause1) v(cause0) v(soft0) v(soft1) v(soft2) v(soft3) v(soft4) v(soft5) v(soft6) v(soft7) v(hard0) v(hard1) v(hard2) v(hard3) v(hard4) v(hard5) v(hard6) v(hard7) v(soft_armed) v(sp0) v(sp1) v(sp2) v(sp3) v(sp4) v(sp5) v(sp6) v(sp7) v(sp8) v(sp9) v(sp10) v(sp11) v(sp12) v(sp13) v(sp14) v(sp15) v(sclk_pad) v(sdi_pad) v(sdo) v(clr_d)
linearize v(gate) v(gfet) v(tripped) v(isense) v(cmp_soft) v(cmp_hard) v(cmp_clk) v(trip_d) v(osc_clk) v(vref) v(en_core) v(shp) v(fault_n) v(vdda) v(vdd) v(iprof) v(icmp) v(vth_soft) v(vth_hard) v(dig_trip) v(inrush_active) i(vim) i(vma) i(vmi) i(v12)
wrdata /work/build/g1_top/waves_gA_pex_c1414_beh_tt_27C_clockfix_functional_c1414n1.txt v(gate) v(gfet) v(tripped) v(isense) v(cmp_soft) v(cmp_hard) v(cmp_clk) v(trip_d) v(osc_clk) v(vref) v(en_core) v(shp) v(fault_n) v(vdda) v(vdd) v(iprof) v(icmp) v(vth_soft) v(vth_hard) v(dig_trip) v(inrush_active) i(vim) i(vma) i(vmi) i(v12)
.endc
.end
