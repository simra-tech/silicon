* G1_TOP breaker path, chip level: in-range hard trip: code 200 (~39.25mV), 1.8A/45mV fault in 20ns; HARD_N=4
* CDL-driven full chip (run_top_cdl.py): blocks/g1_padring/netlist/g1_chip_top_1414.cdl sha256 af5a4dbd0b17013b11d32f31221353a22b2676ea884e3487db3f14d9c5443a36, top g1_chip_top instantiated once
* case c_mid | block netlists sch (CDL schematic subckts) | clock to the RTL ideal | corner tt | 27 degC | pads nodcn | method gear
* translated: 60 subckts; devices C cap_cmim 7, D dpantenna 7, M sg13_hv_nmos 861, M sg13_hv_pmos 312, M sg13_lv_nmos 40, M sg13_lv_pmos 41, Q npn13G2 308, R ptap1 42, R rhigh 15, R rppd 1060, X 76, ptap1 R from sg13g2_io.spi 42, removed dantenna 8; replaced g1_digital, g1_osc; 4833 filler instances merged
* WARNING deviation --pads nodcn: every dantenna instance of the translated chip removed (IO cells and sg13g2_antennanp; 8 instances); reason: run_top.py PADS_NODCN_WARNING
* not in this deck (differences to run_top.py): the Cw_* wire capacitors (the CDL has none); the d_source RTL stimulus (the RTL reads the EN/SCLK/SDI IOPadIn outputs); fitted GATE/FAULT_N drivers
.param VDDA=3.3 VDD=1.2 IOVDD=3.3 RSH=25m RGND=10m INOM=1 CVREF=1e-08
.lib /foss/pdks/ihp-sg13g2/libs.tech/ngspice/models/cornerMOSlv.lib mos_tt
.lib /foss/pdks/ihp-sg13g2/libs.tech/ngspice/models/cornerMOShv.lib mos_tt
.lib /foss/pdks/ihp-sg13g2/libs.tech/ngspice/models/cornerRES.lib res_typ
.lib /foss/pdks/ihp-sg13g2/libs.tech/ngspice/models/cornerCAP.lib cap_typ
.lib /foss/pdks/ihp-sg13g2/libs.tech/ngspice/models/cornerHBT.lib hbt_typ
.lib /foss/pdks/ihp-sg13g2/libs.tech/ngspice/models/cornerDIO.lib dio_tt
.temp 27
.global sub!
Vsub sub! 0 dc 0
.option method=gear itl4=100 reltol=0.001 abstol=1e-10 vntol=1e-6 chgtol=1e-14 rshunt=1e12
.option itl4=500
.nodeset v(xchip.i_core_vref_buf)=1.04 v(xchip.i_core_unused_vped)=1.0008 v(xchip.i_core_isense)=1.5 v(xchip.xi_core_u_sense.vp)=0.047 v(xchip.xi_core_u_sense.vn)=0.047 v(xchip.i_core_iptat)=0.76 v(xchip.xi_core_u_sense.xota.out1)=2.51 v(xchip.xi_core_u_sense.xota.mir)=2.51 v(xchip.xi_core_u_sense.xota.tail)=1.6 v(xchip.xi_core_u_sense.xota.fn)=0.2 v(xchip.xi_core_u_sense.xota.fp)=0.2 v(xchip.xi_core_u_sense.xbuf.out1)=2.51 v(xchip.xi_core_u_sense.xbuf.mir)=2.51 v(xchip.xi_core_u_sense.xbuf.tail)=1.6 v(xchip.xi_core_u_sense.xbuf.fn)=0.2 v(xchip.xi_core_u_sense.xbuf.fp)=0.2 v(xchip.xi_core_u_sense.xref.out1)=2.51 v(xchip.xi_core_u_sense.xref.mir)=2.51 v(xchip.xi_core_u_sense.xref.tail)=1.6 v(xchip.xi_core_u_sense.xref.fn)=0.2 v(xchip.xi_core_u_sense.xref.fp)=0.2
* ---- supplies: one 3.3 V board rail feeds VDDA (pin 7) and IOVDD (pin 3), PLAN D14; 1.2 V VDD (pin 1)
V33 rail33 0 dc 3.3
Vma rail33 vdda_s dc 0
Vmi rail33 iovdd_s dc 0
Rsa vdda_s vdda 0.5
Cda vdda 0 1n
Rsi iovdd_s iovdd 0.5
Cdi iovdd 0 1n
V12 vdd_s 0 dc 1.2
Rsd vdd_s vdd 0.5
Cdd vdd 0 1n
* ---- board: load current profile (1 V = 1 A) x switch on the FET gate node, shunt, Kelvin traces, FET gate
Vprof iprof 0 pwl(0 1 1.6e-05 1 1.602e-05 1.8)
Bload 0 ldi I = v(iprof) * (0.5 + 0.5*tanh((v(gfet) - 1.5)/0.15))
Vim ldi shp dc 0
Rsh shp shn {RSH}
Rgnd shn 0 {RGND}
Rkp shp sense_p 1
Rkn shn sense_n 1
Rg gate gfet 10
Cgate gfet 0 5n
Cfault fault_n 0 20p
Ven en_pad 0 pwl(0 0 3.01431035636e-06 0 3.01521035636e-06 1.485 3.01541035636e-06 1.815 3.01631035636e-06 3.3)
Vsclk sclk_pad 0 pwl(0 0 4.07405957685e-06 0 4.1800344989e-06 0 4.1809344989e-06 1.485 4.1811344989e-06 1.815 4.1820344989e-06 3.3 4.28600942095e-06 3.3 4.28690942095e-06 1.815 4.28710942095e-06 1.485 4.28800942095e-06 0 4.391984343e-06 0 4.392884343e-06 1.485 4.393084343e-06 1.815 4.393984343e-06 3.3 4.49795926505e-06 3.3 4.49885926505e-06 1.815 4.49905926505e-06 1.485 4.49995926505e-06 0 4.6039341871e-06 0 4.6048341871e-06 1.485 4.6050341871e-06 1.815 4.6059341871e-06 3.3 4.70990910914e-06 3.3 4.71080910914e-06 1.815 4.71100910914e-06 1.485 4.71190910914e-06 0 4.81588403119e-06 0 4.81678403119e-06 1.485 4.81698403119e-06 1.815 4.81788403119e-06 3.3 4.92185895324e-06 3.3 4.92275895324e-06 1.815 4.92295895324e-06 1.485 4.92385895324e-06 0 5.02783387529e-06 0 5.02873387529e-06 1.485 5.02893387529e-06 1.815 5.02983387529e-06 3.3 5.13380879734e-06 3.3 5.13470879734e-06 1.815 5.13490879734e-06 1.485 5.13580879734e-06 0 5.23978371939e-06 0 5.24068371939e-06 1.485 5.24088371939e-06 1.815 5.24178371939e-06 3.3 5.34575864144e-06 3.3 5.34665864144e-06 1.815 5.34685864144e-06 1.485 5.34775864144e-06 0 5.45173356349e-06 0 5.45263356349e-06 1.485 5.45283356349e-06 1.815 5.45373356349e-06 3.3 5.55770848554e-06 3.3 5.55860848554e-06 1.815 5.55880848554e-06 1.485 5.55970848554e-06 0 5.66368340759e-06 0 5.66458340759e-06 1.485 5.66478340759e-06 1.815 5.66568340759e-06 3.3 5.76965832964e-06 3.3 5.77055832964e-06 1.815 5.77075832964e-06 1.485 5.77165832964e-06 0 5.87563325169e-06 0 5.87653325169e-06 1.485 5.87673325169e-06 1.815 5.87763325169e-06 3.3 5.98160817374e-06 3.3 5.98250817374e-06 1.815 5.98270817374e-06 1.485 5.98360817374e-06 0 6.08758309579e-06 0 6.08848309579e-06 1.485 6.08868309579e-06 1.815 6.08958309579e-06 3.3 6.19355801783e-06 3.3 6.19445801783e-06 1.815 6.19465801783e-06 1.485 6.19555801783e-06 0 6.29953293988e-06 0 6.30043293988e-06 1.485 6.30063293988e-06 1.815 6.30153293988e-06 3.3 6.40550786193e-06 3.3 6.40640786193e-06 1.815 6.40660786193e-06 1.485 6.40750786193e-06 0 6.51148278398e-06 0 6.51238278398e-06 1.485 6.51258278398e-06 1.815 6.51348278398e-06 3.3 6.61745770603e-06 3.3 6.61835770603e-06 1.815 6.61855770603e-06 1.485 6.61945770603e-06 0 6.72343262808e-06 0 6.72433262808e-06 1.485 6.72453262808e-06 1.815 6.72543262808e-06 3.3 6.82940755013e-06 3.3 6.83030755013e-06 1.815 6.83050755013e-06 1.485 6.83140755013e-06 0 6.93538247218e-06 0 6.93628247218e-06 1.485 6.93648247218e-06 1.815 6.93738247218e-06 3.3 7.04135739423e-06 3.3 7.04225739423e-06 1.815 7.04245739423e-06 1.485 7.04335739423e-06 0 7.14733231628e-06 0 7.14823231628e-06 1.485 7.14843231628e-06 1.815 7.14933231628e-06 3.3 7.25330723833e-06 3.3 7.25420723833e-06 1.815 7.25440723833e-06 1.485 7.25530723833e-06 0 7.35928216038e-06 0 7.36018216038e-06 1.485 7.36038216038e-06 1.815 7.36128216038e-06 3.3 7.46525708243e-06 3.3 7.46615708243e-06 1.815 7.46635708243e-06 1.485 7.46725708243e-06 0 7.57123200448e-06 0 7.57213200448e-06 1.485 7.57233200448e-06 1.815 7.57323200448e-06 3.3 7.67720692653e-06 3.3 7.67810692653e-06 1.815 7.67830692653e-06 1.485 7.67920692653e-06 0 7.78318184857e-06 0 7.78408184857e-06 1.485 7.78428184857e-06 1.815 7.78518184857e-06 3.3 7.88915677062e-06 3.3 7.89005677062e-06 1.815 7.89025677062e-06 1.485 7.89115677062e-06 0 7.99513169267e-06 0 7.99603169267e-06 1.485 7.99623169267e-06 1.815 7.99713169267e-06 3.3 8.10110661472e-06 3.3 8.10200661472e-06 1.815 8.10220661472e-06 1.485 8.10310661472e-06 0 8.20708153677e-06 0 8.20798153677e-06 1.485 8.20818153677e-06 1.815 8.20908153677e-06 3.3 8.31305645882e-06 3.3 8.31395645882e-06 1.815 8.31415645882e-06 1.485 8.31505645882e-06 0 8.41903138087e-06 0 8.41993138087e-06 1.485 8.42013138087e-06 1.815 8.42103138087e-06 3.3 8.52500630292e-06 3.3 8.52590630292e-06 1.815 8.52610630292e-06 1.485 8.52700630292e-06 0 8.63098122497e-06 0 8.63188122497e-06 1.485 8.63208122497e-06 1.815 8.63298122497e-06 3.3 8.73695614702e-06 3.3 8.73785614702e-06 1.815 8.73805614702e-06 1.485 8.73895614702e-06 0 8.84293106907e-06 0 8.84383106907e-06 1.485 8.84403106907e-06 1.815 8.84493106907e-06 3.3 8.94890599112e-06 3.3 8.94980599112e-06 1.815 8.95000599112e-06 1.485 8.95090599112e-06 0 9.05488091317e-06 0 9.05578091317e-06 1.485 9.05598091317e-06 1.815 9.05688091317e-06 3.3 9.16085583522e-06 3.3 9.16175583522e-06 1.815 9.16195583522e-06 1.485 9.16285583522e-06 0 9.26683075726e-06 0 9.26773075726e-06 1.485 9.26793075726e-06 1.815 9.26883075726e-06 3.3 9.37280567931e-06 3.3 9.37370567931e-06 1.815 9.37390567931e-06 1.485 9.37480567931e-06 0 9.47878060136e-06 0 9.47968060136e-06 1.485 9.47988060136e-06 1.815 9.48078060136e-06 3.3 9.58475552341e-06 3.3 9.58565552341e-06 1.815 9.58585552341e-06 1.485 9.58675552341e-06 0 9.69073044546e-06 0 9.69163044546e-06 1.485 9.69183044546e-06 1.815 9.69273044546e-06 3.3 9.79670536751e-06 3.3 9.79760536751e-06 1.815 9.79780536751e-06 1.485 9.79870536751e-06 0 9.90268028956e-06 0 9.90358028956e-06 1.485 9.90378028956e-06 1.815 9.90468028956e-06 3.3 1.00086552116e-05 3.3 1.00095552116e-05 1.815 1.00097552116e-05 1.485 1.00106552116e-05 0 1.01146301337e-05 0 1.01155301337e-05 1.485 1.01157301337e-05 1.815 1.01166301337e-05 3.3 1.02206050557e-05 3.3 1.02215050557e-05 1.815 1.02217050557e-05 1.485 1.02226050557e-05 0 1.03265799778e-05 0 1.03274799778e-05 1.485 1.03276799778e-05 1.815 1.03285799778e-05 3.3 1.04325548998e-05 3.3 1.04334548998e-05 1.815 1.04336548998e-05 1.485 1.04345548998e-05 0 1.05385298219e-05 0 1.05394298219e-05 1.485 1.05396298219e-05 1.815 1.05405298219e-05 3.3 1.06445047439e-05 3.3 1.06454047439e-05 1.815 1.06456047439e-05 1.485 1.06465047439e-05 0 1.0750479666e-05 0 1.0751379666e-05 1.485 1.0751579666e-05 1.815 1.0752479666e-05 3.3 1.0856454588e-05 3.3 1.0857354588e-05 1.815 1.0857554588e-05 1.485 1.0858454588e-05 0)
Vsdi sdi_pad 0 pwl(0 0 4.07405957685e-06 0 4.92185895324e-06 0 4.92275895324e-06 1.485 4.92295895324e-06 1.815 4.92385895324e-06 3.3 5.13380879734e-06 3.3 5.13470879734e-06 1.815 5.13490879734e-06 1.485 5.13580879734e-06 0 8.73695614702e-06 0 8.73785614702e-06 1.485 8.73805614702e-06 1.815 8.73895614702e-06 3.3 9.58475552341e-06 3.3 9.58565552341e-06 1.815 9.58585552341e-06 1.485 9.58675552341e-06 0 1.00086552116e-05 0 1.00095552116e-05 1.485 1.00097552116e-05 1.815 1.00106552116e-05 3.3 1.02206050557e-05 3.3 1.02215050557e-05 1.815 1.02217050557e-05 1.485 1.02226050557e-05 0)
.model adc adc_bridge(in_low=0.55 in_high=0.65 rise_delay=1e-12 fall_delay=1e-12)
.model adc_clock adc_bridge(in_low=0.6 in_high=0.6 rise_delay=1e-12 fall_delay=1e-12)
.model dac dac_bridge(out_low=0 out_high=1.2 out_undef=0.6 t_rise=0.3n t_fall=0.3n)
.model rtl d_cosim simulation="ivlng" sim_args=["/work/build/g1_top/cosim_a2d1645b576964096096c874.vvp"]
* ---- the chip: g1_chip_top_1414.cdl, 22 pins on the board fixture
.subckt sg13g2_antennanp A VDD VSS
* removed (--pads nodcn): DD1 VSS A dantenna m=1 w=780n l=780n a=608.4f p=3.12u
XDD0 A VDD dpantenna m=1 w=1.05u l=1.34u
.ends sg13g2_antennanp
.subckt sg13g2_decap_8 VDD VSS
XMN0 VSS VDD VSS VSS sg13_lv_nmos m=1 w=840.00n l=1.000u ng=2
XMP0 VDD VSS VDD VDD sg13_lv_pmos m=1 w=2.000u l=1.000u ng=2
.ends sg13g2_decap_8
.subckt sg13g2_fill_2 VDD VSS
.ends sg13g2_fill_2
.subckt sg13g2_fill_1 VDD VSS
.ends sg13g2_fill_1
.subckt sg13g2_decap_4 VDD VSS
XMN0 VSS VDD VSS VSS sg13_lv_nmos m=1 w=420.00n l=1.000u ng=1
XMP0 VDD VSS VDD VDD sg13_lv_pmos m=1 w=1.000u l=1.000u ng=1
.ends sg13g2_decap_4
.subckt bondpad_70x70_tm1 pad
.ends bondpad_70x70_tm1
.subckt G1_VSS_DERIVATIVE__sg13g2_Corner vdd vss iovdd iovss G1_EXPLICIT_SUBSTRATE_VSS
XR_G1_TAP_SYNTAX_XR1 vss G1_EXPLICIT_SUBSTRATE_VSS ptap1 R=35.383
XR_G1_TAP_SYNTAX_XR0 iovss G1_EXPLICIT_SUBSTRATE_VSS ptap1 R=93.041m
.ends G1_VSS_DERIVATIVE__sg13g2_Corner
.subckt G1_VSS_DERIVATIVE__sg13g2_Filler4000 vdd vss iovdd iovss G1_EXPLICIT_SUBSTRATE_VSS
XR_G1_TAP_SYNTAX_XR1 vss G1_EXPLICIT_SUBSTRATE_VSS ptap1 R=63.078
XR_G1_TAP_SYNTAX_XR0 iovss G1_EXPLICIT_SUBSTRATE_VSS ptap1 R=625.742m
.ends G1_VSS_DERIVATIVE__sg13g2_Filler4000
.subckt G1_VSS_DERIVATIVE__sg13g2_Filler2000 vdd vss iovdd iovss G1_EXPLICIT_SUBSTRATE_VSS
XR_G1_TAP_SYNTAX_XR1 vss G1_EXPLICIT_SUBSTRATE_VSS ptap1 R=101.912
XR_G1_TAP_SYNTAX_XR0 iovss G1_EXPLICIT_SUBSTRATE_VSS ptap1 R=1.224
.ends G1_VSS_DERIVATIVE__sg13g2_Filler2000
.subckt G1_VSS_DERIVATIVE__sg13g2_Filler400 vdd vss iovdd iovss G1_EXPLICIT_SUBSTRATE_VSS
XR_G1_TAP_SYNTAX_XR1 vss G1_EXPLICIT_SUBSTRATE_VSS ptap1 R=246.192
XR_G1_TAP_SYNTAX_XR0 iovss G1_EXPLICIT_SUBSTRATE_VSS ptap1 R=6.246
.ends G1_VSS_DERIVATIVE__sg13g2_Filler400
.subckt g1_bgr vdd vss r4 vref iptat pbias pcasc vbe dvbe
XR1 vss n_23 vss rhigh w=0.5u l=49u b=0 m=1
XR2 n_12 det vss rhigh w=0.5u l=49u b=0 m=1
XR3 n_13 n_24 vss rhigh w=0.5u l=49u b=0 m=1
XR4 n_14 n_24 vss rhigh w=0.5u l=49u b=0 m=1
XR5 n_14 n_26 vss rhigh w=0.5u l=49u b=0 m=1
XR6 n_15 n_26 vss rhigh w=0.5u l=49u b=0 m=1
XR7 n_15 n_27 vss rhigh w=0.5u l=49u b=0 m=1
XR8 n_16 n_27 vss rhigh w=0.5u l=49u b=0 m=1
XR9 n_16 n_21 vss rhigh w=0.5u l=49u b=0 m=1
XR10 n_12 n_25 vss rhigh w=0.5u l=49u b=0 m=1
XR11 n_13 n_25 vss rhigh w=0.5u l=49u b=0 m=1
XR12 n_17 n_22 vss rhigh w=0.5u l=49u b=0 m=1
XR13 n_18 n_22 vss rhigh w=0.5u l=49u b=0 m=1
XR14 n_18 n_23 vss rhigh w=0.5u l=49u b=0 m=1
XR15 n_17 n_21 vss rhigh w=0.5u l=49u b=0 m=1
XR16 vss dvbe vss rppd w=1u l=51.5u b=0 m=1
XR17 n_7 vref vss rppd w=1u l=53.465u b=0 m=1
XR18 n_2 n_36 vss rppd w=1u l=53.465u b=0 m=1
XR19 n_7 n_36 vss rppd w=1u l=53.465u b=0 m=1
XR20 n_2 n_37 vss rppd w=1u l=53.465u b=0 m=1
XR21 n_8 n_37 vss rppd w=1u l=53.465u b=0 m=1
XR22 n_8 vbe3 vss rppd w=1u l=53.465u b=0 m=1
XR23 n_6 vb2 vss rppd w=1u l=48u b=0 m=1
XR24 n_9 vd1 vss rppd w=1u l=48u b=0 m=1
XR25 n_6 n_19 vss rppd w=1u l=48u b=0 m=1
XR26 n_9 n_19 vss rppd w=1u l=48u b=0 m=1
XM27 kick det vdd vdd sg13_hv_pmos l=0.5u w=2u as=0.68p ad=0.68p ps=4.68u pd=4.68u rfmode=0
XM28 r4n r4 vdd vdd sg13_hv_pmos l=0.5u w=2u as=0.68p ad=0.68p ps=4.68u pd=4.68u rfmode=0
XM29 vbe r4 b1b vss sg13_hv_nmos l=0.5u w=2u as=0.68p ad=0.68p ps=4.68u pd=4.68u rfmode=0
XM30 pbias kick vss vss sg13_hv_nmos l=4u w=1u as=0.34p ad=0.34p ps=2.68u pd=2.68u rfmode=0
XM31 kick det vss vss sg13_hv_nmos l=0.6u w=1u as=0.34p ad=0.34p ps=2.68u pd=2.68u rfmode=0
XM32 r4n r4 vss vss sg13_hv_nmos l=0.5u w=1u as=0.34p ad=0.34p ps=2.68u pd=2.68u rfmode=0
XM33 b1b r4n vss vss sg13_hv_nmos l=0.6u w=1u as=0.34p ad=0.34p ps=2.68u pd=2.68u rfmode=0
XM34 n1 vb2 vbe vss sg13_hv_nmos l=1u w=10u as=3.4p ad=3.4p ps=20.68u pd=20.68u rfmode=0
XM35 c2 vb2 pcasc vss sg13_hv_nmos l=1u w=10u as=3.4p ad=3.4p ps=20.68u pd=20.68u rfmode=0
XM36 vbe vb2 n1 vss sg13_hv_nmos l=1u w=10u as=3.4p ad=3.4p ps=20.68u pd=20.68u rfmode=0
XM37 pcasc vb2 c2 vss sg13_hv_nmos l=1u w=10u as=3.4p ad=3.4p ps=20.68u pd=20.68u rfmode=0
XM38 d1 pbias vdd vdd sg13_hv_pmos l=4u w=5u as=1.7p ad=1.7p ps=10.68u pd=10.68u rfmode=0
XM39 d2 pbias vdd vdd sg13_hv_pmos l=4u w=5u as=1.7p ad=1.7p ps=10.68u pd=10.68u rfmode=0
XM40 d4 pbias vdd vdd sg13_hv_pmos l=4u w=5u as=1.7p ad=1.7p ps=10.68u pd=10.68u rfmode=0
XM41 d5 pbias vdd vdd sg13_hv_pmos l=4u w=5u as=1.7p ad=1.7p ps=10.68u pd=10.68u rfmode=0
XM42 det pbias vdd vdd sg13_hv_pmos l=4u w=5u as=1.7p ad=1.7p ps=10.68u pd=10.68u rfmode=0
XM43 d3 pbias vdd vdd sg13_hv_pmos l=4u w=5u as=1.7p ad=1.7p ps=10.68u pd=10.68u rfmode=0
XM44 d3 pbias vdd vdd sg13_hv_pmos l=4u w=5u as=1.7p ad=1.7p ps=10.68u pd=10.68u rfmode=0
XM45 d5 pbias vdd vdd sg13_hv_pmos l=4u w=5u as=1.7p ad=1.7p ps=10.68u pd=10.68u rfmode=0
XM46 d4 pbias vdd vdd sg13_hv_pmos l=4u w=5u as=1.7p ad=1.7p ps=10.68u pd=10.68u rfmode=0
XM47 d2 pbias vdd vdd sg13_hv_pmos l=4u w=5u as=1.7p ad=1.7p ps=10.68u pd=10.68u rfmode=0
XM48 d1 pbias vdd vdd sg13_hv_pmos l=4u w=5u as=1.7p ad=1.7p ps=10.68u pd=10.68u rfmode=0
XM49 det pbias vdd vdd sg13_hv_pmos l=4u w=5u as=1.7p ad=1.7p ps=10.68u pd=10.68u rfmode=0
XM50 vb2 pcasc d5 d5 sg13_hv_pmos l=4u w=10u as=3.4p ad=3.4p ps=20.68u pd=20.68u rfmode=0
XM51 vref pcasc d3 d3 sg13_hv_pmos l=4u w=10u as=3.4p ad=3.4p ps=20.68u pd=20.68u rfmode=0
XM52 n1 pcasc d1 d1 sg13_hv_pmos l=4u w=10u as=3.4p ad=3.4p ps=20.68u pd=20.68u rfmode=0
XM53 iptat pcasc d4 d4 sg13_hv_pmos l=4u w=10u as=3.4p ad=3.4p ps=20.68u pd=20.68u rfmode=0
XM54 pbias pcasc d2 d2 sg13_hv_pmos l=4u w=10u as=3.4p ad=3.4p ps=20.68u pd=20.68u rfmode=0
XQ55 vss vss vss vss npn13G2 we=0.07u le=0.9u Nx=1 m=1
XQ56 vbe vbe vss vss npn13G2 we=0.07u le=0.9u Nx=1 m=1
XQ57 vss vss vss vss npn13G2 we=0.07u le=0.9u Nx=1 m=1
XQ58 vss vss vss vss npn13G2 we=0.07u le=0.9u Nx=1 m=1
XQ59 vss vss vss vss npn13G2 we=0.07u le=0.9u Nx=1 m=1
XQ60 vbe3 vbe3 vss vss npn13G2 we=0.07u le=0.9u Nx=1 m=1
XQ61 vss vss vss vss npn13G2 we=0.07u le=0.9u Nx=1 m=1
XQ62 vd2 vd2 vss vss npn13G2 we=0.07u le=0.9u Nx=1 m=1
XQ63 vss vss vss vss npn13G2 we=0.07u le=0.9u Nx=1 m=1
XQ64 vss vss vss vss npn13G2 we=0.07u le=0.9u Nx=1 m=1
XQ65 vss vss vss vss npn13G2 we=0.07u le=0.9u Nx=1 m=1
XQ66 vss vss vss vss npn13G2 we=0.07u le=0.9u Nx=1 m=1
XQ67 vbe b1b vss vss npn13G2 we=0.07u le=0.9u Nx=1 m=1
XQ68 c2 vbe dvbe vss npn13G2 we=0.07u le=0.9u Nx=1 m=1
XQ69 c2 vbe dvbe vss npn13G2 we=0.07u le=0.9u Nx=1 m=1
XQ70 c2 vbe dvbe vss npn13G2 we=0.07u le=0.9u Nx=1 m=1
XQ71 c2 vbe dvbe vss npn13G2 we=0.07u le=0.9u Nx=1 m=1
XQ72 c2 vbe dvbe vss npn13G2 we=0.07u le=0.9u Nx=1 m=1
XQ73 c2 vbe dvbe vss npn13G2 we=0.07u le=0.9u Nx=1 m=1
XQ74 c2 vbe dvbe vss npn13G2 we=0.07u le=0.9u Nx=1 m=1
XQ75 vd1 vd1 vd2 vss npn13G2 we=0.07u le=0.9u Nx=1 m=1
XQ76 c2 vbe dvbe vss npn13G2 we=0.07u le=0.9u Nx=1 m=1
XR77 n_4 pbias vss rppd w=1u l=50u b=0 m=1
XR78 n_11 n_34 vss rppd w=1u l=50u b=0 m=1
XR79 n_10 n_34 vss rppd w=1u l=50u b=0 m=1
XR80 n_3 n_31 vss rppd w=1u l=50u b=0 m=1
XR81 n_10 n_33 vss rppd w=1u l=50u b=0 m=1
XR82 n_5 n_31 vss rppd w=1u l=50u b=0 m=1
XR83 n_5 n_30 vss rppd w=1u l=50u b=0 m=1
XR84 n_4 n_30 vss rppd w=1u l=50u b=0 m=1
XR85 n_3 n_33 vss rppd w=1u l=50u b=0 m=1
XR86 n_11 pcasc vss rppd w=1u l=50u b=0 m=1
XR16_u2 vss dvbe vss rppd w=1u l=51.5u b=0 m=1
XR16_u3 vss dvbe vss rppd w=1u l=51.5u b=0 m=1
XR16_u4 vss dvbe vss rppd w=1u l=51.5u b=0 m=1
XR16_u5 vss dvbe vss rppd w=1u l=51.5u b=0 m=1
XR16_u6 vss dvbe vss rppd w=1u l=51.5u b=0 m=1
XR16_u7 vss dvbe vss rppd w=1u l=51.5u b=0 m=1
XR16_u8 vss dvbe vss rppd w=1u l=51.5u b=0 m=1
XR16_u9 vss dvbe vss rppd w=1u l=51.5u b=0 m=1
XR16_u10 vss dvbe vss rppd w=1u l=51.5u b=0 m=1
XR16_u11 vss dvbe vss rppd w=1u l=51.5u b=0 m=1
XR16_u12 vss dvbe vss rppd w=1u l=51.5u b=0 m=1
XR16_u13 vss dvbe vss rppd w=1u l=51.5u b=0 m=1
XR16_u14 vss dvbe vss rppd w=1u l=51.5u b=0 m=1
XR16_u15 vss dvbe vss rppd w=1u l=51.5u b=0 m=1
XR16_u16 vss dvbe vss rppd w=1u l=51.5u b=0 m=1
XR16_u17 vss dvbe vss rppd w=1u l=51.5u b=0 m=1
XR16_u18 vss dvbe vss rppd w=1u l=51.5u b=0 m=1
XR16_u19 vss dvbe vss rppd w=1u l=51.5u b=0 m=1
XR16_u20 vss dvbe vss rppd w=1u l=51.5u b=0 m=1
XR16_u21 vss dvbe vss rppd w=1u l=51.5u b=0 m=1
XR16_u22 vss dvbe vss rppd w=1u l=51.5u b=0 m=1
XR16_u23 vss dvbe vss rppd w=1u l=51.5u b=0 m=1
XR16_u24 vss dvbe vss rppd w=1u l=51.5u b=0 m=1
XR17_u2 n_7 vref vss rppd w=1u l=53.465u b=0 m=1
XR17_u3 n_7 vref vss rppd w=1u l=53.465u b=0 m=1
XR17_u4 n_7 vref vss rppd w=1u l=53.465u b=0 m=1
XR18_u2 n_2 n_36 vss rppd w=1u l=53.465u b=0 m=1
XR18_u3 n_2 n_36 vss rppd w=1u l=53.465u b=0 m=1
XR18_u4 n_2 n_36 vss rppd w=1u l=53.465u b=0 m=1
XR19_u2 n_7 n_36 vss rppd w=1u l=53.465u b=0 m=1
XR19_u3 n_7 n_36 vss rppd w=1u l=53.465u b=0 m=1
XR19_u4 n_7 n_36 vss rppd w=1u l=53.465u b=0 m=1
XR20_u2 n_2 n_37 vss rppd w=1u l=53.465u b=0 m=1
XR20_u3 n_2 n_37 vss rppd w=1u l=53.465u b=0 m=1
XR20_u4 n_2 n_37 vss rppd w=1u l=53.465u b=0 m=1
XR21_u2 n_8 n_37 vss rppd w=1u l=53.465u b=0 m=1
XR21_u3 n_8 n_37 vss rppd w=1u l=53.465u b=0 m=1
XR21_u4 n_8 n_37 vss rppd w=1u l=53.465u b=0 m=1
XR22_u2 n_8 vbe3 vss rppd w=1u l=53.465u b=0 m=1
XR22_u3 n_8 vbe3 vss rppd w=1u l=53.465u b=0 m=1
XR22_u4 n_8 vbe3 vss rppd w=1u l=53.465u b=0 m=1
XR23_u2 n_6 vb2 vss rppd w=1u l=48u b=0 m=1
XR23_u3 n_6 vb2 vss rppd w=1u l=48u b=0 m=1
XR23_u4 n_6 vb2 vss rppd w=1u l=48u b=0 m=1
XR23_u5 n_6 vb2 vss rppd w=1u l=48u b=0 m=1
XR23_u6 n_6 vb2 vss rppd w=1u l=48u b=0 m=1
XR23_u7 n_6 vb2 vss rppd w=1u l=48u b=0 m=1
XR23_u8 n_6 vb2 vss rppd w=1u l=48u b=0 m=1
XR23_u9 n_6 vb2 vss rppd w=1u l=48u b=0 m=1
XR23_u10 n_6 vb2 vss rppd w=1u l=48u b=0 m=1
XR23_u11 n_6 vb2 vss rppd w=1u l=48u b=0 m=1
XR23_u12 n_6 vb2 vss rppd w=1u l=48u b=0 m=1
XR23_u13 n_6 vb2 vss rppd w=1u l=48u b=0 m=1
XR23_u14 n_6 vb2 vss rppd w=1u l=48u b=0 m=1
XR23_u15 n_6 vb2 vss rppd w=1u l=48u b=0 m=1
XR23_u16 n_6 vb2 vss rppd w=1u l=48u b=0 m=1
XR23_u17 n_6 vb2 vss rppd w=1u l=48u b=0 m=1
XR23_u18 n_6 vb2 vss rppd w=1u l=48u b=0 m=1
XR23_u19 n_6 vb2 vss rppd w=1u l=48u b=0 m=1
XR23_u20 n_6 vb2 vss rppd w=1u l=48u b=0 m=1
XR23_u21 n_6 vb2 vss rppd w=1u l=48u b=0 m=1
XR23_u22 n_6 vb2 vss rppd w=1u l=48u b=0 m=1
XR23_u23 n_6 vb2 vss rppd w=1u l=48u b=0 m=1
XR23_u24 n_6 vb2 vss rppd w=1u l=48u b=0 m=1
XR24_u2 n_9 vd1 vss rppd w=1u l=48u b=0 m=1
XR24_u3 n_9 vd1 vss rppd w=1u l=48u b=0 m=1
XR24_u4 n_9 vd1 vss rppd w=1u l=48u b=0 m=1
XR24_u5 n_9 vd1 vss rppd w=1u l=48u b=0 m=1
XR24_u6 n_9 vd1 vss rppd w=1u l=48u b=0 m=1
XR24_u7 n_9 vd1 vss rppd w=1u l=48u b=0 m=1
XR24_u8 n_9 vd1 vss rppd w=1u l=48u b=0 m=1
XR24_u9 n_9 vd1 vss rppd w=1u l=48u b=0 m=1
XR24_u10 n_9 vd1 vss rppd w=1u l=48u b=0 m=1
XR24_u11 n_9 vd1 vss rppd w=1u l=48u b=0 m=1
XR24_u12 n_9 vd1 vss rppd w=1u l=48u b=0 m=1
XR24_u13 n_9 vd1 vss rppd w=1u l=48u b=0 m=1
XR24_u14 n_9 vd1 vss rppd w=1u l=48u b=0 m=1
XR24_u15 n_9 vd1 vss rppd w=1u l=48u b=0 m=1
XR24_u16 n_9 vd1 vss rppd w=1u l=48u b=0 m=1
XR24_u17 n_9 vd1 vss rppd w=1u l=48u b=0 m=1
XR24_u18 n_9 vd1 vss rppd w=1u l=48u b=0 m=1
XR24_u19 n_9 vd1 vss rppd w=1u l=48u b=0 m=1
XR24_u20 n_9 vd1 vss rppd w=1u l=48u b=0 m=1
XR24_u21 n_9 vd1 vss rppd w=1u l=48u b=0 m=1
XR24_u22 n_9 vd1 vss rppd w=1u l=48u b=0 m=1
XR24_u23 n_9 vd1 vss rppd w=1u l=48u b=0 m=1
XR24_u24 n_9 vd1 vss rppd w=1u l=48u b=0 m=1
XR25_u2 n_6 n_19 vss rppd w=1u l=48u b=0 m=1
XR25_u3 n_6 n_19 vss rppd w=1u l=48u b=0 m=1
XR25_u4 n_6 n_19 vss rppd w=1u l=48u b=0 m=1
XR25_u5 n_6 n_19 vss rppd w=1u l=48u b=0 m=1
XR25_u6 n_6 n_19 vss rppd w=1u l=48u b=0 m=1
XR25_u7 n_6 n_19 vss rppd w=1u l=48u b=0 m=1
XR25_u8 n_6 n_19 vss rppd w=1u l=48u b=0 m=1
XR25_u9 n_6 n_19 vss rppd w=1u l=48u b=0 m=1
XR25_u10 n_6 n_19 vss rppd w=1u l=48u b=0 m=1
XR25_u11 n_6 n_19 vss rppd w=1u l=48u b=0 m=1
XR25_u12 n_6 n_19 vss rppd w=1u l=48u b=0 m=1
XR25_u13 n_6 n_19 vss rppd w=1u l=48u b=0 m=1
XR25_u14 n_6 n_19 vss rppd w=1u l=48u b=0 m=1
XR25_u15 n_6 n_19 vss rppd w=1u l=48u b=0 m=1
XR25_u16 n_6 n_19 vss rppd w=1u l=48u b=0 m=1
XR25_u17 n_6 n_19 vss rppd w=1u l=48u b=0 m=1
XR25_u18 n_6 n_19 vss rppd w=1u l=48u b=0 m=1
XR25_u19 n_6 n_19 vss rppd w=1u l=48u b=0 m=1
XR25_u20 n_6 n_19 vss rppd w=1u l=48u b=0 m=1
XR25_u21 n_6 n_19 vss rppd w=1u l=48u b=0 m=1
XR25_u22 n_6 n_19 vss rppd w=1u l=48u b=0 m=1
XR25_u23 n_6 n_19 vss rppd w=1u l=48u b=0 m=1
XR25_u24 n_6 n_19 vss rppd w=1u l=48u b=0 m=1
XR26_u2 n_9 n_19 vss rppd w=1u l=48u b=0 m=1
XR26_u3 n_9 n_19 vss rppd w=1u l=48u b=0 m=1
XR26_u4 n_9 n_19 vss rppd w=1u l=48u b=0 m=1
XR26_u5 n_9 n_19 vss rppd w=1u l=48u b=0 m=1
XR26_u6 n_9 n_19 vss rppd w=1u l=48u b=0 m=1
XR26_u7 n_9 n_19 vss rppd w=1u l=48u b=0 m=1
XR26_u8 n_9 n_19 vss rppd w=1u l=48u b=0 m=1
XR26_u9 n_9 n_19 vss rppd w=1u l=48u b=0 m=1
XR26_u10 n_9 n_19 vss rppd w=1u l=48u b=0 m=1
XR26_u11 n_9 n_19 vss rppd w=1u l=48u b=0 m=1
XR26_u12 n_9 n_19 vss rppd w=1u l=48u b=0 m=1
XR26_u13 n_9 n_19 vss rppd w=1u l=48u b=0 m=1
XR26_u14 n_9 n_19 vss rppd w=1u l=48u b=0 m=1
XR26_u15 n_9 n_19 vss rppd w=1u l=48u b=0 m=1
XR26_u16 n_9 n_19 vss rppd w=1u l=48u b=0 m=1
XR26_u17 n_9 n_19 vss rppd w=1u l=48u b=0 m=1
XR26_u18 n_9 n_19 vss rppd w=1u l=48u b=0 m=1
XR26_u19 n_9 n_19 vss rppd w=1u l=48u b=0 m=1
XR26_u20 n_9 n_19 vss rppd w=1u l=48u b=0 m=1
XR26_u21 n_9 n_19 vss rppd w=1u l=48u b=0 m=1
XR26_u22 n_9 n_19 vss rppd w=1u l=48u b=0 m=1
XR26_u23 n_9 n_19 vss rppd w=1u l=48u b=0 m=1
XR26_u24 n_9 n_19 vss rppd w=1u l=48u b=0 m=1
XM34_u2 n1 vb2 vbe vss sg13_hv_nmos l=1u w=10u as=3.4p ad=3.4p ps=20.68u pd=20.68u rfmode=0
XM34_u3 n1 vb2 vbe vss sg13_hv_nmos l=1u w=10u as=3.4p ad=3.4p ps=20.68u pd=20.68u rfmode=0
XM34_u4 n1 vb2 vbe vss sg13_hv_nmos l=1u w=10u as=3.4p ad=3.4p ps=20.68u pd=20.68u rfmode=0
XM34_u5 n1 vb2 vbe vss sg13_hv_nmos l=1u w=10u as=3.4p ad=3.4p ps=20.68u pd=20.68u rfmode=0
XM34_u6 n1 vb2 vbe vss sg13_hv_nmos l=1u w=10u as=3.4p ad=3.4p ps=20.68u pd=20.68u rfmode=0
XM34_u7 n1 vb2 vbe vss sg13_hv_nmos l=1u w=10u as=3.4p ad=3.4p ps=20.68u pd=20.68u rfmode=0
XM34_u8 n1 vb2 vbe vss sg13_hv_nmos l=1u w=10u as=3.4p ad=3.4p ps=20.68u pd=20.68u rfmode=0
XM34_u9 n1 vb2 vbe vss sg13_hv_nmos l=1u w=10u as=3.4p ad=3.4p ps=20.68u pd=20.68u rfmode=0
XM34_u10 n1 vb2 vbe vss sg13_hv_nmos l=1u w=10u as=3.4p ad=3.4p ps=20.68u pd=20.68u rfmode=0
XM34_u11 n1 vb2 vbe vss sg13_hv_nmos l=1u w=10u as=3.4p ad=3.4p ps=20.68u pd=20.68u rfmode=0
XM34_u12 n1 vb2 vbe vss sg13_hv_nmos l=1u w=10u as=3.4p ad=3.4p ps=20.68u pd=20.68u rfmode=0
XM34_u13 n1 vb2 vbe vss sg13_hv_nmos l=1u w=10u as=3.4p ad=3.4p ps=20.68u pd=20.68u rfmode=0
XM34_u14 n1 vb2 vbe vss sg13_hv_nmos l=1u w=10u as=3.4p ad=3.4p ps=20.68u pd=20.68u rfmode=0
XM34_u15 n1 vb2 vbe vss sg13_hv_nmos l=1u w=10u as=3.4p ad=3.4p ps=20.68u pd=20.68u rfmode=0
XM34_u16 n1 vb2 vbe vss sg13_hv_nmos l=1u w=10u as=3.4p ad=3.4p ps=20.68u pd=20.68u rfmode=0
XM34_u17 n1 vb2 vbe vss sg13_hv_nmos l=1u w=10u as=3.4p ad=3.4p ps=20.68u pd=20.68u rfmode=0
XM34_u18 n1 vb2 vbe vss sg13_hv_nmos l=1u w=10u as=3.4p ad=3.4p ps=20.68u pd=20.68u rfmode=0
XM34_u19 n1 vb2 vbe vss sg13_hv_nmos l=1u w=10u as=3.4p ad=3.4p ps=20.68u pd=20.68u rfmode=0
XM34_u20 n1 vb2 vbe vss sg13_hv_nmos l=1u w=10u as=3.4p ad=3.4p ps=20.68u pd=20.68u rfmode=0
XM34_u21 n1 vb2 vbe vss sg13_hv_nmos l=1u w=10u as=3.4p ad=3.4p ps=20.68u pd=20.68u rfmode=0
XM34_u22 n1 vb2 vbe vss sg13_hv_nmos l=1u w=10u as=3.4p ad=3.4p ps=20.68u pd=20.68u rfmode=0
XM34_u23 n1 vb2 vbe vss sg13_hv_nmos l=1u w=10u as=3.4p ad=3.4p ps=20.68u pd=20.68u rfmode=0
XM34_u24 n1 vb2 vbe vss sg13_hv_nmos l=1u w=10u as=3.4p ad=3.4p ps=20.68u pd=20.68u rfmode=0
XM35_u2 c2 vb2 pcasc vss sg13_hv_nmos l=1u w=10u as=3.4p ad=3.4p ps=20.68u pd=20.68u rfmode=0
XM35_u3 c2 vb2 pcasc vss sg13_hv_nmos l=1u w=10u as=3.4p ad=3.4p ps=20.68u pd=20.68u rfmode=0
XM35_u4 c2 vb2 pcasc vss sg13_hv_nmos l=1u w=10u as=3.4p ad=3.4p ps=20.68u pd=20.68u rfmode=0
XM35_u5 c2 vb2 pcasc vss sg13_hv_nmos l=1u w=10u as=3.4p ad=3.4p ps=20.68u pd=20.68u rfmode=0
XM35_u6 c2 vb2 pcasc vss sg13_hv_nmos l=1u w=10u as=3.4p ad=3.4p ps=20.68u pd=20.68u rfmode=0
XM35_u7 c2 vb2 pcasc vss sg13_hv_nmos l=1u w=10u as=3.4p ad=3.4p ps=20.68u pd=20.68u rfmode=0
XM35_u8 c2 vb2 pcasc vss sg13_hv_nmos l=1u w=10u as=3.4p ad=3.4p ps=20.68u pd=20.68u rfmode=0
XM35_u9 c2 vb2 pcasc vss sg13_hv_nmos l=1u w=10u as=3.4p ad=3.4p ps=20.68u pd=20.68u rfmode=0
XM35_u10 c2 vb2 pcasc vss sg13_hv_nmos l=1u w=10u as=3.4p ad=3.4p ps=20.68u pd=20.68u rfmode=0
XM35_u11 c2 vb2 pcasc vss sg13_hv_nmos l=1u w=10u as=3.4p ad=3.4p ps=20.68u pd=20.68u rfmode=0
XM35_u12 c2 vb2 pcasc vss sg13_hv_nmos l=1u w=10u as=3.4p ad=3.4p ps=20.68u pd=20.68u rfmode=0
XM35_u13 c2 vb2 pcasc vss sg13_hv_nmos l=1u w=10u as=3.4p ad=3.4p ps=20.68u pd=20.68u rfmode=0
XM35_u14 c2 vb2 pcasc vss sg13_hv_nmos l=1u w=10u as=3.4p ad=3.4p ps=20.68u pd=20.68u rfmode=0
XM35_u15 c2 vb2 pcasc vss sg13_hv_nmos l=1u w=10u as=3.4p ad=3.4p ps=20.68u pd=20.68u rfmode=0
XM35_u16 c2 vb2 pcasc vss sg13_hv_nmos l=1u w=10u as=3.4p ad=3.4p ps=20.68u pd=20.68u rfmode=0
XM35_u17 c2 vb2 pcasc vss sg13_hv_nmos l=1u w=10u as=3.4p ad=3.4p ps=20.68u pd=20.68u rfmode=0
XM35_u18 c2 vb2 pcasc vss sg13_hv_nmos l=1u w=10u as=3.4p ad=3.4p ps=20.68u pd=20.68u rfmode=0
XM35_u19 c2 vb2 pcasc vss sg13_hv_nmos l=1u w=10u as=3.4p ad=3.4p ps=20.68u pd=20.68u rfmode=0
XM35_u20 c2 vb2 pcasc vss sg13_hv_nmos l=1u w=10u as=3.4p ad=3.4p ps=20.68u pd=20.68u rfmode=0
XM35_u21 c2 vb2 pcasc vss sg13_hv_nmos l=1u w=10u as=3.4p ad=3.4p ps=20.68u pd=20.68u rfmode=0
XM35_u22 c2 vb2 pcasc vss sg13_hv_nmos l=1u w=10u as=3.4p ad=3.4p ps=20.68u pd=20.68u rfmode=0
XM35_u23 c2 vb2 pcasc vss sg13_hv_nmos l=1u w=10u as=3.4p ad=3.4p ps=20.68u pd=20.68u rfmode=0
XM35_u24 c2 vb2 pcasc vss sg13_hv_nmos l=1u w=10u as=3.4p ad=3.4p ps=20.68u pd=20.68u rfmode=0
XM36_u2 vbe vb2 n1 vss sg13_hv_nmos l=1u w=10u as=3.4p ad=3.4p ps=20.68u pd=20.68u rfmode=0
XM36_u3 vbe vb2 n1 vss sg13_hv_nmos l=1u w=10u as=3.4p ad=3.4p ps=20.68u pd=20.68u rfmode=0
XM36_u4 vbe vb2 n1 vss sg13_hv_nmos l=1u w=10u as=3.4p ad=3.4p ps=20.68u pd=20.68u rfmode=0
XM36_u5 vbe vb2 n1 vss sg13_hv_nmos l=1u w=10u as=3.4p ad=3.4p ps=20.68u pd=20.68u rfmode=0
XM36_u6 vbe vb2 n1 vss sg13_hv_nmos l=1u w=10u as=3.4p ad=3.4p ps=20.68u pd=20.68u rfmode=0
XM36_u7 vbe vb2 n1 vss sg13_hv_nmos l=1u w=10u as=3.4p ad=3.4p ps=20.68u pd=20.68u rfmode=0
XM36_u8 vbe vb2 n1 vss sg13_hv_nmos l=1u w=10u as=3.4p ad=3.4p ps=20.68u pd=20.68u rfmode=0
XM36_u9 vbe vb2 n1 vss sg13_hv_nmos l=1u w=10u as=3.4p ad=3.4p ps=20.68u pd=20.68u rfmode=0
XM36_u10 vbe vb2 n1 vss sg13_hv_nmos l=1u w=10u as=3.4p ad=3.4p ps=20.68u pd=20.68u rfmode=0
XM36_u11 vbe vb2 n1 vss sg13_hv_nmos l=1u w=10u as=3.4p ad=3.4p ps=20.68u pd=20.68u rfmode=0
XM36_u12 vbe vb2 n1 vss sg13_hv_nmos l=1u w=10u as=3.4p ad=3.4p ps=20.68u pd=20.68u rfmode=0
XM36_u13 vbe vb2 n1 vss sg13_hv_nmos l=1u w=10u as=3.4p ad=3.4p ps=20.68u pd=20.68u rfmode=0
XM36_u14 vbe vb2 n1 vss sg13_hv_nmos l=1u w=10u as=3.4p ad=3.4p ps=20.68u pd=20.68u rfmode=0
XM36_u15 vbe vb2 n1 vss sg13_hv_nmos l=1u w=10u as=3.4p ad=3.4p ps=20.68u pd=20.68u rfmode=0
XM36_u16 vbe vb2 n1 vss sg13_hv_nmos l=1u w=10u as=3.4p ad=3.4p ps=20.68u pd=20.68u rfmode=0
XM36_u17 vbe vb2 n1 vss sg13_hv_nmos l=1u w=10u as=3.4p ad=3.4p ps=20.68u pd=20.68u rfmode=0
XM36_u18 vbe vb2 n1 vss sg13_hv_nmos l=1u w=10u as=3.4p ad=3.4p ps=20.68u pd=20.68u rfmode=0
XM36_u19 vbe vb2 n1 vss sg13_hv_nmos l=1u w=10u as=3.4p ad=3.4p ps=20.68u pd=20.68u rfmode=0
XM36_u20 vbe vb2 n1 vss sg13_hv_nmos l=1u w=10u as=3.4p ad=3.4p ps=20.68u pd=20.68u rfmode=0
XM36_u21 vbe vb2 n1 vss sg13_hv_nmos l=1u w=10u as=3.4p ad=3.4p ps=20.68u pd=20.68u rfmode=0
XM36_u22 vbe vb2 n1 vss sg13_hv_nmos l=1u w=10u as=3.4p ad=3.4p ps=20.68u pd=20.68u rfmode=0
XM36_u23 vbe vb2 n1 vss sg13_hv_nmos l=1u w=10u as=3.4p ad=3.4p ps=20.68u pd=20.68u rfmode=0
XM36_u24 vbe vb2 n1 vss sg13_hv_nmos l=1u w=10u as=3.4p ad=3.4p ps=20.68u pd=20.68u rfmode=0
XM37_u2 pcasc vb2 c2 vss sg13_hv_nmos l=1u w=10u as=3.4p ad=3.4p ps=20.68u pd=20.68u rfmode=0
XM37_u3 pcasc vb2 c2 vss sg13_hv_nmos l=1u w=10u as=3.4p ad=3.4p ps=20.68u pd=20.68u rfmode=0
XM37_u4 pcasc vb2 c2 vss sg13_hv_nmos l=1u w=10u as=3.4p ad=3.4p ps=20.68u pd=20.68u rfmode=0
XM37_u5 pcasc vb2 c2 vss sg13_hv_nmos l=1u w=10u as=3.4p ad=3.4p ps=20.68u pd=20.68u rfmode=0
XM37_u6 pcasc vb2 c2 vss sg13_hv_nmos l=1u w=10u as=3.4p ad=3.4p ps=20.68u pd=20.68u rfmode=0
XM37_u7 pcasc vb2 c2 vss sg13_hv_nmos l=1u w=10u as=3.4p ad=3.4p ps=20.68u pd=20.68u rfmode=0
XM37_u8 pcasc vb2 c2 vss sg13_hv_nmos l=1u w=10u as=3.4p ad=3.4p ps=20.68u pd=20.68u rfmode=0
XM37_u9 pcasc vb2 c2 vss sg13_hv_nmos l=1u w=10u as=3.4p ad=3.4p ps=20.68u pd=20.68u rfmode=0
XM37_u10 pcasc vb2 c2 vss sg13_hv_nmos l=1u w=10u as=3.4p ad=3.4p ps=20.68u pd=20.68u rfmode=0
XM37_u11 pcasc vb2 c2 vss sg13_hv_nmos l=1u w=10u as=3.4p ad=3.4p ps=20.68u pd=20.68u rfmode=0
XM37_u12 pcasc vb2 c2 vss sg13_hv_nmos l=1u w=10u as=3.4p ad=3.4p ps=20.68u pd=20.68u rfmode=0
XM37_u13 pcasc vb2 c2 vss sg13_hv_nmos l=1u w=10u as=3.4p ad=3.4p ps=20.68u pd=20.68u rfmode=0
XM37_u14 pcasc vb2 c2 vss sg13_hv_nmos l=1u w=10u as=3.4p ad=3.4p ps=20.68u pd=20.68u rfmode=0
XM37_u15 pcasc vb2 c2 vss sg13_hv_nmos l=1u w=10u as=3.4p ad=3.4p ps=20.68u pd=20.68u rfmode=0
XM37_u16 pcasc vb2 c2 vss sg13_hv_nmos l=1u w=10u as=3.4p ad=3.4p ps=20.68u pd=20.68u rfmode=0
XM37_u17 pcasc vb2 c2 vss sg13_hv_nmos l=1u w=10u as=3.4p ad=3.4p ps=20.68u pd=20.68u rfmode=0
XM37_u18 pcasc vb2 c2 vss sg13_hv_nmos l=1u w=10u as=3.4p ad=3.4p ps=20.68u pd=20.68u rfmode=0
XM37_u19 pcasc vb2 c2 vss sg13_hv_nmos l=1u w=10u as=3.4p ad=3.4p ps=20.68u pd=20.68u rfmode=0
XM37_u20 pcasc vb2 c2 vss sg13_hv_nmos l=1u w=10u as=3.4p ad=3.4p ps=20.68u pd=20.68u rfmode=0
XM37_u21 pcasc vb2 c2 vss sg13_hv_nmos l=1u w=10u as=3.4p ad=3.4p ps=20.68u pd=20.68u rfmode=0
XM37_u22 pcasc vb2 c2 vss sg13_hv_nmos l=1u w=10u as=3.4p ad=3.4p ps=20.68u pd=20.68u rfmode=0
XM37_u23 pcasc vb2 c2 vss sg13_hv_nmos l=1u w=10u as=3.4p ad=3.4p ps=20.68u pd=20.68u rfmode=0
XM37_u24 pcasc vb2 c2 vss sg13_hv_nmos l=1u w=10u as=3.4p ad=3.4p ps=20.68u pd=20.68u rfmode=0
XM38_u2 d1 pbias vdd vdd sg13_hv_pmos l=4u w=5u as=1.7p ad=1.7p ps=10.68u pd=10.68u rfmode=0
XM38_u3 d1 pbias vdd vdd sg13_hv_pmos l=4u w=5u as=1.7p ad=1.7p ps=10.68u pd=10.68u rfmode=0
XM38_u4 d1 pbias vdd vdd sg13_hv_pmos l=4u w=5u as=1.7p ad=1.7p ps=10.68u pd=10.68u rfmode=0
XM38_u5 d1 pbias vdd vdd sg13_hv_pmos l=4u w=5u as=1.7p ad=1.7p ps=10.68u pd=10.68u rfmode=0
XM38_u6 d1 pbias vdd vdd sg13_hv_pmos l=4u w=5u as=1.7p ad=1.7p ps=10.68u pd=10.68u rfmode=0
XM38_u7 d1 pbias vdd vdd sg13_hv_pmos l=4u w=5u as=1.7p ad=1.7p ps=10.68u pd=10.68u rfmode=0
XM38_u8 d1 pbias vdd vdd sg13_hv_pmos l=4u w=5u as=1.7p ad=1.7p ps=10.68u pd=10.68u rfmode=0
XM38_u9 d1 pbias vdd vdd sg13_hv_pmos l=4u w=5u as=1.7p ad=1.7p ps=10.68u pd=10.68u rfmode=0
XM38_u10 d1 pbias vdd vdd sg13_hv_pmos l=4u w=5u as=1.7p ad=1.7p ps=10.68u pd=10.68u rfmode=0
XM38_u11 d1 pbias vdd vdd sg13_hv_pmos l=4u w=5u as=1.7p ad=1.7p ps=10.68u pd=10.68u rfmode=0
XM38_u12 d1 pbias vdd vdd sg13_hv_pmos l=4u w=5u as=1.7p ad=1.7p ps=10.68u pd=10.68u rfmode=0
XM38_u13 d1 pbias vdd vdd sg13_hv_pmos l=4u w=5u as=1.7p ad=1.7p ps=10.68u pd=10.68u rfmode=0
XM38_u14 d1 pbias vdd vdd sg13_hv_pmos l=4u w=5u as=1.7p ad=1.7p ps=10.68u pd=10.68u rfmode=0
XM38_u15 d1 pbias vdd vdd sg13_hv_pmos l=4u w=5u as=1.7p ad=1.7p ps=10.68u pd=10.68u rfmode=0
XM38_u16 d1 pbias vdd vdd sg13_hv_pmos l=4u w=5u as=1.7p ad=1.7p ps=10.68u pd=10.68u rfmode=0
XM38_u17 d1 pbias vdd vdd sg13_hv_pmos l=4u w=5u as=1.7p ad=1.7p ps=10.68u pd=10.68u rfmode=0
XM38_u18 d1 pbias vdd vdd sg13_hv_pmos l=4u w=5u as=1.7p ad=1.7p ps=10.68u pd=10.68u rfmode=0
XM38_u19 d1 pbias vdd vdd sg13_hv_pmos l=4u w=5u as=1.7p ad=1.7p ps=10.68u pd=10.68u rfmode=0
XM38_u20 d1 pbias vdd vdd sg13_hv_pmos l=4u w=5u as=1.7p ad=1.7p ps=10.68u pd=10.68u rfmode=0
XM38_u21 d1 pbias vdd vdd sg13_hv_pmos l=4u w=5u as=1.7p ad=1.7p ps=10.68u pd=10.68u rfmode=0
XM38_u22 d1 pbias vdd vdd sg13_hv_pmos l=4u w=5u as=1.7p ad=1.7p ps=10.68u pd=10.68u rfmode=0
XM38_u23 d1 pbias vdd vdd sg13_hv_pmos l=4u w=5u as=1.7p ad=1.7p ps=10.68u pd=10.68u rfmode=0
XM38_u24 d1 pbias vdd vdd sg13_hv_pmos l=4u w=5u as=1.7p ad=1.7p ps=10.68u pd=10.68u rfmode=0
XM39_u2 d2 pbias vdd vdd sg13_hv_pmos l=4u w=5u as=1.7p ad=1.7p ps=10.68u pd=10.68u rfmode=0
XM39_u3 d2 pbias vdd vdd sg13_hv_pmos l=4u w=5u as=1.7p ad=1.7p ps=10.68u pd=10.68u rfmode=0
XM39_u4 d2 pbias vdd vdd sg13_hv_pmos l=4u w=5u as=1.7p ad=1.7p ps=10.68u pd=10.68u rfmode=0
XM39_u5 d2 pbias vdd vdd sg13_hv_pmos l=4u w=5u as=1.7p ad=1.7p ps=10.68u pd=10.68u rfmode=0
XM39_u6 d2 pbias vdd vdd sg13_hv_pmos l=4u w=5u as=1.7p ad=1.7p ps=10.68u pd=10.68u rfmode=0
XM39_u7 d2 pbias vdd vdd sg13_hv_pmos l=4u w=5u as=1.7p ad=1.7p ps=10.68u pd=10.68u rfmode=0
XM39_u8 d2 pbias vdd vdd sg13_hv_pmos l=4u w=5u as=1.7p ad=1.7p ps=10.68u pd=10.68u rfmode=0
XM39_u9 d2 pbias vdd vdd sg13_hv_pmos l=4u w=5u as=1.7p ad=1.7p ps=10.68u pd=10.68u rfmode=0
XM39_u10 d2 pbias vdd vdd sg13_hv_pmos l=4u w=5u as=1.7p ad=1.7p ps=10.68u pd=10.68u rfmode=0
XM39_u11 d2 pbias vdd vdd sg13_hv_pmos l=4u w=5u as=1.7p ad=1.7p ps=10.68u pd=10.68u rfmode=0
XM39_u12 d2 pbias vdd vdd sg13_hv_pmos l=4u w=5u as=1.7p ad=1.7p ps=10.68u pd=10.68u rfmode=0
XM39_u13 d2 pbias vdd vdd sg13_hv_pmos l=4u w=5u as=1.7p ad=1.7p ps=10.68u pd=10.68u rfmode=0
XM39_u14 d2 pbias vdd vdd sg13_hv_pmos l=4u w=5u as=1.7p ad=1.7p ps=10.68u pd=10.68u rfmode=0
XM39_u15 d2 pbias vdd vdd sg13_hv_pmos l=4u w=5u as=1.7p ad=1.7p ps=10.68u pd=10.68u rfmode=0
XM39_u16 d2 pbias vdd vdd sg13_hv_pmos l=4u w=5u as=1.7p ad=1.7p ps=10.68u pd=10.68u rfmode=0
XM39_u17 d2 pbias vdd vdd sg13_hv_pmos l=4u w=5u as=1.7p ad=1.7p ps=10.68u pd=10.68u rfmode=0
XM39_u18 d2 pbias vdd vdd sg13_hv_pmos l=4u w=5u as=1.7p ad=1.7p ps=10.68u pd=10.68u rfmode=0
XM39_u19 d2 pbias vdd vdd sg13_hv_pmos l=4u w=5u as=1.7p ad=1.7p ps=10.68u pd=10.68u rfmode=0
XM39_u20 d2 pbias vdd vdd sg13_hv_pmos l=4u w=5u as=1.7p ad=1.7p ps=10.68u pd=10.68u rfmode=0
XM39_u21 d2 pbias vdd vdd sg13_hv_pmos l=4u w=5u as=1.7p ad=1.7p ps=10.68u pd=10.68u rfmode=0
XM39_u22 d2 pbias vdd vdd sg13_hv_pmos l=4u w=5u as=1.7p ad=1.7p ps=10.68u pd=10.68u rfmode=0
XM39_u23 d2 pbias vdd vdd sg13_hv_pmos l=4u w=5u as=1.7p ad=1.7p ps=10.68u pd=10.68u rfmode=0
XM39_u24 d2 pbias vdd vdd sg13_hv_pmos l=4u w=5u as=1.7p ad=1.7p ps=10.68u pd=10.68u rfmode=0
XM41_u2 d5 pbias vdd vdd sg13_hv_pmos l=4u w=5u as=1.7p ad=1.7p ps=10.68u pd=10.68u rfmode=0
XM41_u3 d5 pbias vdd vdd sg13_hv_pmos l=4u w=5u as=1.7p ad=1.7p ps=10.68u pd=10.68u rfmode=0
XM41_u4 d5 pbias vdd vdd sg13_hv_pmos l=4u w=5u as=1.7p ad=1.7p ps=10.68u pd=10.68u rfmode=0
XM41_u5 d5 pbias vdd vdd sg13_hv_pmos l=4u w=5u as=1.7p ad=1.7p ps=10.68u pd=10.68u rfmode=0
XM41_u6 d5 pbias vdd vdd sg13_hv_pmos l=4u w=5u as=1.7p ad=1.7p ps=10.68u pd=10.68u rfmode=0
XM41_u7 d5 pbias vdd vdd sg13_hv_pmos l=4u w=5u as=1.7p ad=1.7p ps=10.68u pd=10.68u rfmode=0
XM41_u8 d5 pbias vdd vdd sg13_hv_pmos l=4u w=5u as=1.7p ad=1.7p ps=10.68u pd=10.68u rfmode=0
XM41_u9 d5 pbias vdd vdd sg13_hv_pmos l=4u w=5u as=1.7p ad=1.7p ps=10.68u pd=10.68u rfmode=0
XM41_u10 d5 pbias vdd vdd sg13_hv_pmos l=4u w=5u as=1.7p ad=1.7p ps=10.68u pd=10.68u rfmode=0
XM41_u11 d5 pbias vdd vdd sg13_hv_pmos l=4u w=5u as=1.7p ad=1.7p ps=10.68u pd=10.68u rfmode=0
XM41_u12 d5 pbias vdd vdd sg13_hv_pmos l=4u w=5u as=1.7p ad=1.7p ps=10.68u pd=10.68u rfmode=0
XM41_u13 d5 pbias vdd vdd sg13_hv_pmos l=4u w=5u as=1.7p ad=1.7p ps=10.68u pd=10.68u rfmode=0
XM41_u14 d5 pbias vdd vdd sg13_hv_pmos l=4u w=5u as=1.7p ad=1.7p ps=10.68u pd=10.68u rfmode=0
XM41_u15 d5 pbias vdd vdd sg13_hv_pmos l=4u w=5u as=1.7p ad=1.7p ps=10.68u pd=10.68u rfmode=0
XM41_u16 d5 pbias vdd vdd sg13_hv_pmos l=4u w=5u as=1.7p ad=1.7p ps=10.68u pd=10.68u rfmode=0
XM41_u17 d5 pbias vdd vdd sg13_hv_pmos l=4u w=5u as=1.7p ad=1.7p ps=10.68u pd=10.68u rfmode=0
XM41_u18 d5 pbias vdd vdd sg13_hv_pmos l=4u w=5u as=1.7p ad=1.7p ps=10.68u pd=10.68u rfmode=0
XM41_u19 d5 pbias vdd vdd sg13_hv_pmos l=4u w=5u as=1.7p ad=1.7p ps=10.68u pd=10.68u rfmode=0
XM41_u20 d5 pbias vdd vdd sg13_hv_pmos l=4u w=5u as=1.7p ad=1.7p ps=10.68u pd=10.68u rfmode=0
XM41_u21 d5 pbias vdd vdd sg13_hv_pmos l=4u w=5u as=1.7p ad=1.7p ps=10.68u pd=10.68u rfmode=0
XM41_u22 d5 pbias vdd vdd sg13_hv_pmos l=4u w=5u as=1.7p ad=1.7p ps=10.68u pd=10.68u rfmode=0
XM41_u23 d5 pbias vdd vdd sg13_hv_pmos l=4u w=5u as=1.7p ad=1.7p ps=10.68u pd=10.68u rfmode=0
XM41_u24 d5 pbias vdd vdd sg13_hv_pmos l=4u w=5u as=1.7p ad=1.7p ps=10.68u pd=10.68u rfmode=0
XM43_u2 d3 pbias vdd vdd sg13_hv_pmos l=4u w=5u as=1.7p ad=1.7p ps=10.68u pd=10.68u rfmode=0
XM43_u3 d3 pbias vdd vdd sg13_hv_pmos l=4u w=5u as=1.7p ad=1.7p ps=10.68u pd=10.68u rfmode=0
XM43_u4 d3 pbias vdd vdd sg13_hv_pmos l=4u w=5u as=1.7p ad=1.7p ps=10.68u pd=10.68u rfmode=0
XM44_u2 d3 pbias vdd vdd sg13_hv_pmos l=4u w=5u as=1.7p ad=1.7p ps=10.68u pd=10.68u rfmode=0
XM44_u3 d3 pbias vdd vdd sg13_hv_pmos l=4u w=5u as=1.7p ad=1.7p ps=10.68u pd=10.68u rfmode=0
XM44_u4 d3 pbias vdd vdd sg13_hv_pmos l=4u w=5u as=1.7p ad=1.7p ps=10.68u pd=10.68u rfmode=0
XM45_u2 d5 pbias vdd vdd sg13_hv_pmos l=4u w=5u as=1.7p ad=1.7p ps=10.68u pd=10.68u rfmode=0
XM45_u3 d5 pbias vdd vdd sg13_hv_pmos l=4u w=5u as=1.7p ad=1.7p ps=10.68u pd=10.68u rfmode=0
XM45_u4 d5 pbias vdd vdd sg13_hv_pmos l=4u w=5u as=1.7p ad=1.7p ps=10.68u pd=10.68u rfmode=0
XM45_u5 d5 pbias vdd vdd sg13_hv_pmos l=4u w=5u as=1.7p ad=1.7p ps=10.68u pd=10.68u rfmode=0
XM45_u6 d5 pbias vdd vdd sg13_hv_pmos l=4u w=5u as=1.7p ad=1.7p ps=10.68u pd=10.68u rfmode=0
XM45_u7 d5 pbias vdd vdd sg13_hv_pmos l=4u w=5u as=1.7p ad=1.7p ps=10.68u pd=10.68u rfmode=0
XM45_u8 d5 pbias vdd vdd sg13_hv_pmos l=4u w=5u as=1.7p ad=1.7p ps=10.68u pd=10.68u rfmode=0
XM45_u9 d5 pbias vdd vdd sg13_hv_pmos l=4u w=5u as=1.7p ad=1.7p ps=10.68u pd=10.68u rfmode=0
XM45_u10 d5 pbias vdd vdd sg13_hv_pmos l=4u w=5u as=1.7p ad=1.7p ps=10.68u pd=10.68u rfmode=0
XM45_u11 d5 pbias vdd vdd sg13_hv_pmos l=4u w=5u as=1.7p ad=1.7p ps=10.68u pd=10.68u rfmode=0
XM45_u12 d5 pbias vdd vdd sg13_hv_pmos l=4u w=5u as=1.7p ad=1.7p ps=10.68u pd=10.68u rfmode=0
XM45_u13 d5 pbias vdd vdd sg13_hv_pmos l=4u w=5u as=1.7p ad=1.7p ps=10.68u pd=10.68u rfmode=0
XM45_u14 d5 pbias vdd vdd sg13_hv_pmos l=4u w=5u as=1.7p ad=1.7p ps=10.68u pd=10.68u rfmode=0
XM45_u15 d5 pbias vdd vdd sg13_hv_pmos l=4u w=5u as=1.7p ad=1.7p ps=10.68u pd=10.68u rfmode=0
XM45_u16 d5 pbias vdd vdd sg13_hv_pmos l=4u w=5u as=1.7p ad=1.7p ps=10.68u pd=10.68u rfmode=0
XM45_u17 d5 pbias vdd vdd sg13_hv_pmos l=4u w=5u as=1.7p ad=1.7p ps=10.68u pd=10.68u rfmode=0
XM45_u18 d5 pbias vdd vdd sg13_hv_pmos l=4u w=5u as=1.7p ad=1.7p ps=10.68u pd=10.68u rfmode=0
XM45_u19 d5 pbias vdd vdd sg13_hv_pmos l=4u w=5u as=1.7p ad=1.7p ps=10.68u pd=10.68u rfmode=0
XM45_u20 d5 pbias vdd vdd sg13_hv_pmos l=4u w=5u as=1.7p ad=1.7p ps=10.68u pd=10.68u rfmode=0
XM45_u21 d5 pbias vdd vdd sg13_hv_pmos l=4u w=5u as=1.7p ad=1.7p ps=10.68u pd=10.68u rfmode=0
XM45_u22 d5 pbias vdd vdd sg13_hv_pmos l=4u w=5u as=1.7p ad=1.7p ps=10.68u pd=10.68u rfmode=0
XM45_u23 d5 pbias vdd vdd sg13_hv_pmos l=4u w=5u as=1.7p ad=1.7p ps=10.68u pd=10.68u rfmode=0
XM45_u24 d5 pbias vdd vdd sg13_hv_pmos l=4u w=5u as=1.7p ad=1.7p ps=10.68u pd=10.68u rfmode=0
XM47_u2 d2 pbias vdd vdd sg13_hv_pmos l=4u w=5u as=1.7p ad=1.7p ps=10.68u pd=10.68u rfmode=0
XM47_u3 d2 pbias vdd vdd sg13_hv_pmos l=4u w=5u as=1.7p ad=1.7p ps=10.68u pd=10.68u rfmode=0
XM47_u4 d2 pbias vdd vdd sg13_hv_pmos l=4u w=5u as=1.7p ad=1.7p ps=10.68u pd=10.68u rfmode=0
XM47_u5 d2 pbias vdd vdd sg13_hv_pmos l=4u w=5u as=1.7p ad=1.7p ps=10.68u pd=10.68u rfmode=0
XM47_u6 d2 pbias vdd vdd sg13_hv_pmos l=4u w=5u as=1.7p ad=1.7p ps=10.68u pd=10.68u rfmode=0
XM47_u7 d2 pbias vdd vdd sg13_hv_pmos l=4u w=5u as=1.7p ad=1.7p ps=10.68u pd=10.68u rfmode=0
XM47_u8 d2 pbias vdd vdd sg13_hv_pmos l=4u w=5u as=1.7p ad=1.7p ps=10.68u pd=10.68u rfmode=0
XM47_u9 d2 pbias vdd vdd sg13_hv_pmos l=4u w=5u as=1.7p ad=1.7p ps=10.68u pd=10.68u rfmode=0
XM47_u10 d2 pbias vdd vdd sg13_hv_pmos l=4u w=5u as=1.7p ad=1.7p ps=10.68u pd=10.68u rfmode=0
XM47_u11 d2 pbias vdd vdd sg13_hv_pmos l=4u w=5u as=1.7p ad=1.7p ps=10.68u pd=10.68u rfmode=0
XM47_u12 d2 pbias vdd vdd sg13_hv_pmos l=4u w=5u as=1.7p ad=1.7p ps=10.68u pd=10.68u rfmode=0
XM47_u13 d2 pbias vdd vdd sg13_hv_pmos l=4u w=5u as=1.7p ad=1.7p ps=10.68u pd=10.68u rfmode=0
XM47_u14 d2 pbias vdd vdd sg13_hv_pmos l=4u w=5u as=1.7p ad=1.7p ps=10.68u pd=10.68u rfmode=0
XM47_u15 d2 pbias vdd vdd sg13_hv_pmos l=4u w=5u as=1.7p ad=1.7p ps=10.68u pd=10.68u rfmode=0
XM47_u16 d2 pbias vdd vdd sg13_hv_pmos l=4u w=5u as=1.7p ad=1.7p ps=10.68u pd=10.68u rfmode=0
XM47_u17 d2 pbias vdd vdd sg13_hv_pmos l=4u w=5u as=1.7p ad=1.7p ps=10.68u pd=10.68u rfmode=0
XM47_u18 d2 pbias vdd vdd sg13_hv_pmos l=4u w=5u as=1.7p ad=1.7p ps=10.68u pd=10.68u rfmode=0
XM47_u19 d2 pbias vdd vdd sg13_hv_pmos l=4u w=5u as=1.7p ad=1.7p ps=10.68u pd=10.68u rfmode=0
XM47_u20 d2 pbias vdd vdd sg13_hv_pmos l=4u w=5u as=1.7p ad=1.7p ps=10.68u pd=10.68u rfmode=0
XM47_u21 d2 pbias vdd vdd sg13_hv_pmos l=4u w=5u as=1.7p ad=1.7p ps=10.68u pd=10.68u rfmode=0
XM47_u22 d2 pbias vdd vdd sg13_hv_pmos l=4u w=5u as=1.7p ad=1.7p ps=10.68u pd=10.68u rfmode=0
XM47_u23 d2 pbias vdd vdd sg13_hv_pmos l=4u w=5u as=1.7p ad=1.7p ps=10.68u pd=10.68u rfmode=0
XM47_u24 d2 pbias vdd vdd sg13_hv_pmos l=4u w=5u as=1.7p ad=1.7p ps=10.68u pd=10.68u rfmode=0
XM48_u2 d1 pbias vdd vdd sg13_hv_pmos l=4u w=5u as=1.7p ad=1.7p ps=10.68u pd=10.68u rfmode=0
XM48_u3 d1 pbias vdd vdd sg13_hv_pmos l=4u w=5u as=1.7p ad=1.7p ps=10.68u pd=10.68u rfmode=0
XM48_u4 d1 pbias vdd vdd sg13_hv_pmos l=4u w=5u as=1.7p ad=1.7p ps=10.68u pd=10.68u rfmode=0
XM48_u5 d1 pbias vdd vdd sg13_hv_pmos l=4u w=5u as=1.7p ad=1.7p ps=10.68u pd=10.68u rfmode=0
XM48_u6 d1 pbias vdd vdd sg13_hv_pmos l=4u w=5u as=1.7p ad=1.7p ps=10.68u pd=10.68u rfmode=0
XM48_u7 d1 pbias vdd vdd sg13_hv_pmos l=4u w=5u as=1.7p ad=1.7p ps=10.68u pd=10.68u rfmode=0
XM48_u8 d1 pbias vdd vdd sg13_hv_pmos l=4u w=5u as=1.7p ad=1.7p ps=10.68u pd=10.68u rfmode=0
XM48_u9 d1 pbias vdd vdd sg13_hv_pmos l=4u w=5u as=1.7p ad=1.7p ps=10.68u pd=10.68u rfmode=0
XM48_u10 d1 pbias vdd vdd sg13_hv_pmos l=4u w=5u as=1.7p ad=1.7p ps=10.68u pd=10.68u rfmode=0
XM48_u11 d1 pbias vdd vdd sg13_hv_pmos l=4u w=5u as=1.7p ad=1.7p ps=10.68u pd=10.68u rfmode=0
XM48_u12 d1 pbias vdd vdd sg13_hv_pmos l=4u w=5u as=1.7p ad=1.7p ps=10.68u pd=10.68u rfmode=0
XM48_u13 d1 pbias vdd vdd sg13_hv_pmos l=4u w=5u as=1.7p ad=1.7p ps=10.68u pd=10.68u rfmode=0
XM48_u14 d1 pbias vdd vdd sg13_hv_pmos l=4u w=5u as=1.7p ad=1.7p ps=10.68u pd=10.68u rfmode=0
XM48_u15 d1 pbias vdd vdd sg13_hv_pmos l=4u w=5u as=1.7p ad=1.7p ps=10.68u pd=10.68u rfmode=0
XM48_u16 d1 pbias vdd vdd sg13_hv_pmos l=4u w=5u as=1.7p ad=1.7p ps=10.68u pd=10.68u rfmode=0
XM48_u17 d1 pbias vdd vdd sg13_hv_pmos l=4u w=5u as=1.7p ad=1.7p ps=10.68u pd=10.68u rfmode=0
XM48_u18 d1 pbias vdd vdd sg13_hv_pmos l=4u w=5u as=1.7p ad=1.7p ps=10.68u pd=10.68u rfmode=0
XM48_u19 d1 pbias vdd vdd sg13_hv_pmos l=4u w=5u as=1.7p ad=1.7p ps=10.68u pd=10.68u rfmode=0
XM48_u20 d1 pbias vdd vdd sg13_hv_pmos l=4u w=5u as=1.7p ad=1.7p ps=10.68u pd=10.68u rfmode=0
XM48_u21 d1 pbias vdd vdd sg13_hv_pmos l=4u w=5u as=1.7p ad=1.7p ps=10.68u pd=10.68u rfmode=0
XM48_u22 d1 pbias vdd vdd sg13_hv_pmos l=4u w=5u as=1.7p ad=1.7p ps=10.68u pd=10.68u rfmode=0
XM48_u23 d1 pbias vdd vdd sg13_hv_pmos l=4u w=5u as=1.7p ad=1.7p ps=10.68u pd=10.68u rfmode=0
XM48_u24 d1 pbias vdd vdd sg13_hv_pmos l=4u w=5u as=1.7p ad=1.7p ps=10.68u pd=10.68u rfmode=0
XM50_u2 vb2 pcasc d5 d5 sg13_hv_pmos l=4u w=10u as=3.4p ad=3.4p ps=20.68u pd=20.68u rfmode=0
XM50_u3 vb2 pcasc d5 d5 sg13_hv_pmos l=4u w=10u as=3.4p ad=3.4p ps=20.68u pd=20.68u rfmode=0
XM50_u4 vb2 pcasc d5 d5 sg13_hv_pmos l=4u w=10u as=3.4p ad=3.4p ps=20.68u pd=20.68u rfmode=0
XM50_u5 vb2 pcasc d5 d5 sg13_hv_pmos l=4u w=10u as=3.4p ad=3.4p ps=20.68u pd=20.68u rfmode=0
XM50_u6 vb2 pcasc d5 d5 sg13_hv_pmos l=4u w=10u as=3.4p ad=3.4p ps=20.68u pd=20.68u rfmode=0
XM50_u7 vb2 pcasc d5 d5 sg13_hv_pmos l=4u w=10u as=3.4p ad=3.4p ps=20.68u pd=20.68u rfmode=0
XM50_u8 vb2 pcasc d5 d5 sg13_hv_pmos l=4u w=10u as=3.4p ad=3.4p ps=20.68u pd=20.68u rfmode=0
XM50_u9 vb2 pcasc d5 d5 sg13_hv_pmos l=4u w=10u as=3.4p ad=3.4p ps=20.68u pd=20.68u rfmode=0
XM50_u10 vb2 pcasc d5 d5 sg13_hv_pmos l=4u w=10u as=3.4p ad=3.4p ps=20.68u pd=20.68u rfmode=0
XM50_u11 vb2 pcasc d5 d5 sg13_hv_pmos l=4u w=10u as=3.4p ad=3.4p ps=20.68u pd=20.68u rfmode=0
XM50_u12 vb2 pcasc d5 d5 sg13_hv_pmos l=4u w=10u as=3.4p ad=3.4p ps=20.68u pd=20.68u rfmode=0
XM50_u13 vb2 pcasc d5 d5 sg13_hv_pmos l=4u w=10u as=3.4p ad=3.4p ps=20.68u pd=20.68u rfmode=0
XM50_u14 vb2 pcasc d5 d5 sg13_hv_pmos l=4u w=10u as=3.4p ad=3.4p ps=20.68u pd=20.68u rfmode=0
XM50_u15 vb2 pcasc d5 d5 sg13_hv_pmos l=4u w=10u as=3.4p ad=3.4p ps=20.68u pd=20.68u rfmode=0
XM50_u16 vb2 pcasc d5 d5 sg13_hv_pmos l=4u w=10u as=3.4p ad=3.4p ps=20.68u pd=20.68u rfmode=0
XM50_u17 vb2 pcasc d5 d5 sg13_hv_pmos l=4u w=10u as=3.4p ad=3.4p ps=20.68u pd=20.68u rfmode=0
XM50_u18 vb2 pcasc d5 d5 sg13_hv_pmos l=4u w=10u as=3.4p ad=3.4p ps=20.68u pd=20.68u rfmode=0
XM50_u19 vb2 pcasc d5 d5 sg13_hv_pmos l=4u w=10u as=3.4p ad=3.4p ps=20.68u pd=20.68u rfmode=0
XM50_u20 vb2 pcasc d5 d5 sg13_hv_pmos l=4u w=10u as=3.4p ad=3.4p ps=20.68u pd=20.68u rfmode=0
XM50_u21 vb2 pcasc d5 d5 sg13_hv_pmos l=4u w=10u as=3.4p ad=3.4p ps=20.68u pd=20.68u rfmode=0
XM50_u22 vb2 pcasc d5 d5 sg13_hv_pmos l=4u w=10u as=3.4p ad=3.4p ps=20.68u pd=20.68u rfmode=0
XM50_u23 vb2 pcasc d5 d5 sg13_hv_pmos l=4u w=10u as=3.4p ad=3.4p ps=20.68u pd=20.68u rfmode=0
XM50_u24 vb2 pcasc d5 d5 sg13_hv_pmos l=4u w=10u as=3.4p ad=3.4p ps=20.68u pd=20.68u rfmode=0
XM51_u2 vref pcasc d3 d3 sg13_hv_pmos l=4u w=10u as=3.4p ad=3.4p ps=20.68u pd=20.68u rfmode=0
XM51_u3 vref pcasc d3 d3 sg13_hv_pmos l=4u w=10u as=3.4p ad=3.4p ps=20.68u pd=20.68u rfmode=0
XM51_u4 vref pcasc d3 d3 sg13_hv_pmos l=4u w=10u as=3.4p ad=3.4p ps=20.68u pd=20.68u rfmode=0
XM52_u2 n1 pcasc d1 d1 sg13_hv_pmos l=4u w=10u as=3.4p ad=3.4p ps=20.68u pd=20.68u rfmode=0
XM52_u3 n1 pcasc d1 d1 sg13_hv_pmos l=4u w=10u as=3.4p ad=3.4p ps=20.68u pd=20.68u rfmode=0
XM52_u4 n1 pcasc d1 d1 sg13_hv_pmos l=4u w=10u as=3.4p ad=3.4p ps=20.68u pd=20.68u rfmode=0
XM52_u5 n1 pcasc d1 d1 sg13_hv_pmos l=4u w=10u as=3.4p ad=3.4p ps=20.68u pd=20.68u rfmode=0
XM52_u6 n1 pcasc d1 d1 sg13_hv_pmos l=4u w=10u as=3.4p ad=3.4p ps=20.68u pd=20.68u rfmode=0
XM52_u7 n1 pcasc d1 d1 sg13_hv_pmos l=4u w=10u as=3.4p ad=3.4p ps=20.68u pd=20.68u rfmode=0
XM52_u8 n1 pcasc d1 d1 sg13_hv_pmos l=4u w=10u as=3.4p ad=3.4p ps=20.68u pd=20.68u rfmode=0
XM52_u9 n1 pcasc d1 d1 sg13_hv_pmos l=4u w=10u as=3.4p ad=3.4p ps=20.68u pd=20.68u rfmode=0
XM52_u10 n1 pcasc d1 d1 sg13_hv_pmos l=4u w=10u as=3.4p ad=3.4p ps=20.68u pd=20.68u rfmode=0
XM52_u11 n1 pcasc d1 d1 sg13_hv_pmos l=4u w=10u as=3.4p ad=3.4p ps=20.68u pd=20.68u rfmode=0
XM52_u12 n1 pcasc d1 d1 sg13_hv_pmos l=4u w=10u as=3.4p ad=3.4p ps=20.68u pd=20.68u rfmode=0
XM52_u13 n1 pcasc d1 d1 sg13_hv_pmos l=4u w=10u as=3.4p ad=3.4p ps=20.68u pd=20.68u rfmode=0
XM52_u14 n1 pcasc d1 d1 sg13_hv_pmos l=4u w=10u as=3.4p ad=3.4p ps=20.68u pd=20.68u rfmode=0
XM52_u15 n1 pcasc d1 d1 sg13_hv_pmos l=4u w=10u as=3.4p ad=3.4p ps=20.68u pd=20.68u rfmode=0
XM52_u16 n1 pcasc d1 d1 sg13_hv_pmos l=4u w=10u as=3.4p ad=3.4p ps=20.68u pd=20.68u rfmode=0
XM52_u17 n1 pcasc d1 d1 sg13_hv_pmos l=4u w=10u as=3.4p ad=3.4p ps=20.68u pd=20.68u rfmode=0
XM52_u18 n1 pcasc d1 d1 sg13_hv_pmos l=4u w=10u as=3.4p ad=3.4p ps=20.68u pd=20.68u rfmode=0
XM52_u19 n1 pcasc d1 d1 sg13_hv_pmos l=4u w=10u as=3.4p ad=3.4p ps=20.68u pd=20.68u rfmode=0
XM52_u20 n1 pcasc d1 d1 sg13_hv_pmos l=4u w=10u as=3.4p ad=3.4p ps=20.68u pd=20.68u rfmode=0
XM52_u21 n1 pcasc d1 d1 sg13_hv_pmos l=4u w=10u as=3.4p ad=3.4p ps=20.68u pd=20.68u rfmode=0
XM52_u22 n1 pcasc d1 d1 sg13_hv_pmos l=4u w=10u as=3.4p ad=3.4p ps=20.68u pd=20.68u rfmode=0
XM52_u23 n1 pcasc d1 d1 sg13_hv_pmos l=4u w=10u as=3.4p ad=3.4p ps=20.68u pd=20.68u rfmode=0
XM52_u24 n1 pcasc d1 d1 sg13_hv_pmos l=4u w=10u as=3.4p ad=3.4p ps=20.68u pd=20.68u rfmode=0
XM54_u2 pbias pcasc d2 d2 sg13_hv_pmos l=4u w=10u as=3.4p ad=3.4p ps=20.68u pd=20.68u rfmode=0
XM54_u3 pbias pcasc d2 d2 sg13_hv_pmos l=4u w=10u as=3.4p ad=3.4p ps=20.68u pd=20.68u rfmode=0
XM54_u4 pbias pcasc d2 d2 sg13_hv_pmos l=4u w=10u as=3.4p ad=3.4p ps=20.68u pd=20.68u rfmode=0
XM54_u5 pbias pcasc d2 d2 sg13_hv_pmos l=4u w=10u as=3.4p ad=3.4p ps=20.68u pd=20.68u rfmode=0
XM54_u6 pbias pcasc d2 d2 sg13_hv_pmos l=4u w=10u as=3.4p ad=3.4p ps=20.68u pd=20.68u rfmode=0
XM54_u7 pbias pcasc d2 d2 sg13_hv_pmos l=4u w=10u as=3.4p ad=3.4p ps=20.68u pd=20.68u rfmode=0
XM54_u8 pbias pcasc d2 d2 sg13_hv_pmos l=4u w=10u as=3.4p ad=3.4p ps=20.68u pd=20.68u rfmode=0
XM54_u9 pbias pcasc d2 d2 sg13_hv_pmos l=4u w=10u as=3.4p ad=3.4p ps=20.68u pd=20.68u rfmode=0
XM54_u10 pbias pcasc d2 d2 sg13_hv_pmos l=4u w=10u as=3.4p ad=3.4p ps=20.68u pd=20.68u rfmode=0
XM54_u11 pbias pcasc d2 d2 sg13_hv_pmos l=4u w=10u as=3.4p ad=3.4p ps=20.68u pd=20.68u rfmode=0
XM54_u12 pbias pcasc d2 d2 sg13_hv_pmos l=4u w=10u as=3.4p ad=3.4p ps=20.68u pd=20.68u rfmode=0
XM54_u13 pbias pcasc d2 d2 sg13_hv_pmos l=4u w=10u as=3.4p ad=3.4p ps=20.68u pd=20.68u rfmode=0
XM54_u14 pbias pcasc d2 d2 sg13_hv_pmos l=4u w=10u as=3.4p ad=3.4p ps=20.68u pd=20.68u rfmode=0
XM54_u15 pbias pcasc d2 d2 sg13_hv_pmos l=4u w=10u as=3.4p ad=3.4p ps=20.68u pd=20.68u rfmode=0
XM54_u16 pbias pcasc d2 d2 sg13_hv_pmos l=4u w=10u as=3.4p ad=3.4p ps=20.68u pd=20.68u rfmode=0
XM54_u17 pbias pcasc d2 d2 sg13_hv_pmos l=4u w=10u as=3.4p ad=3.4p ps=20.68u pd=20.68u rfmode=0
XM54_u18 pbias pcasc d2 d2 sg13_hv_pmos l=4u w=10u as=3.4p ad=3.4p ps=20.68u pd=20.68u rfmode=0
XM54_u19 pbias pcasc d2 d2 sg13_hv_pmos l=4u w=10u as=3.4p ad=3.4p ps=20.68u pd=20.68u rfmode=0
XM54_u20 pbias pcasc d2 d2 sg13_hv_pmos l=4u w=10u as=3.4p ad=3.4p ps=20.68u pd=20.68u rfmode=0
XM54_u21 pbias pcasc d2 d2 sg13_hv_pmos l=4u w=10u as=3.4p ad=3.4p ps=20.68u pd=20.68u rfmode=0
XM54_u22 pbias pcasc d2 d2 sg13_hv_pmos l=4u w=10u as=3.4p ad=3.4p ps=20.68u pd=20.68u rfmode=0
XM54_u23 pbias pcasc d2 d2 sg13_hv_pmos l=4u w=10u as=3.4p ad=3.4p ps=20.68u pd=20.68u rfmode=0
XM54_u24 pbias pcasc d2 d2 sg13_hv_pmos l=4u w=10u as=3.4p ad=3.4p ps=20.68u pd=20.68u rfmode=0
XQ56_u2 vbe vbe vss vss npn13G2 we=0.07u le=0.9u Nx=1 m=1
XQ56_u3 vbe vbe vss vss npn13G2 we=0.07u le=0.9u Nx=1 m=1
XQ56_u4 vbe vbe vss vss npn13G2 we=0.07u le=0.9u Nx=1 m=1
XQ56_u5 vbe vbe vss vss npn13G2 we=0.07u le=0.9u Nx=1 m=1
XQ56_u6 vbe vbe vss vss npn13G2 we=0.07u le=0.9u Nx=1 m=1
XQ56_u7 vbe vbe vss vss npn13G2 we=0.07u le=0.9u Nx=1 m=1
XQ56_u8 vbe vbe vss vss npn13G2 we=0.07u le=0.9u Nx=1 m=1
XQ56_u9 vbe vbe vss vss npn13G2 we=0.07u le=0.9u Nx=1 m=1
XQ56_u10 vbe vbe vss vss npn13G2 we=0.07u le=0.9u Nx=1 m=1
XQ56_u11 vbe vbe vss vss npn13G2 we=0.07u le=0.9u Nx=1 m=1
XQ56_u12 vbe vbe vss vss npn13G2 we=0.07u le=0.9u Nx=1 m=1
XQ56_u13 vbe vbe vss vss npn13G2 we=0.07u le=0.9u Nx=1 m=1
XQ56_u14 vbe vbe vss vss npn13G2 we=0.07u le=0.9u Nx=1 m=1
XQ56_u15 vbe vbe vss vss npn13G2 we=0.07u le=0.9u Nx=1 m=1
XQ56_u16 vbe vbe vss vss npn13G2 we=0.07u le=0.9u Nx=1 m=1
XQ56_u17 vbe vbe vss vss npn13G2 we=0.07u le=0.9u Nx=1 m=1
XQ56_u18 vbe vbe vss vss npn13G2 we=0.07u le=0.9u Nx=1 m=1
XQ56_u19 vbe vbe vss vss npn13G2 we=0.07u le=0.9u Nx=1 m=1
XQ56_u20 vbe vbe vss vss npn13G2 we=0.07u le=0.9u Nx=1 m=1
XQ56_u21 vbe vbe vss vss npn13G2 we=0.07u le=0.9u Nx=1 m=1
XQ56_u22 vbe vbe vss vss npn13G2 we=0.07u le=0.9u Nx=1 m=1
XQ56_u23 vbe vbe vss vss npn13G2 we=0.07u le=0.9u Nx=1 m=1
XQ56_u24 vbe vbe vss vss npn13G2 we=0.07u le=0.9u Nx=1 m=1
XQ60_u2 vbe3 vbe3 vss vss npn13G2 we=0.07u le=0.9u Nx=1 m=1
XQ60_u3 vbe3 vbe3 vss vss npn13G2 we=0.07u le=0.9u Nx=1 m=1
XQ60_u4 vbe3 vbe3 vss vss npn13G2 we=0.07u le=0.9u Nx=1 m=1
XQ62_u2 vd2 vd2 vss vss npn13G2 we=0.07u le=0.9u Nx=1 m=1
XQ62_u3 vd2 vd2 vss vss npn13G2 we=0.07u le=0.9u Nx=1 m=1
XQ62_u4 vd2 vd2 vss vss npn13G2 we=0.07u le=0.9u Nx=1 m=1
XQ62_u5 vd2 vd2 vss vss npn13G2 we=0.07u le=0.9u Nx=1 m=1
XQ62_u6 vd2 vd2 vss vss npn13G2 we=0.07u le=0.9u Nx=1 m=1
XQ62_u7 vd2 vd2 vss vss npn13G2 we=0.07u le=0.9u Nx=1 m=1
XQ62_u8 vd2 vd2 vss vss npn13G2 we=0.07u le=0.9u Nx=1 m=1
XQ62_u9 vd2 vd2 vss vss npn13G2 we=0.07u le=0.9u Nx=1 m=1
XQ62_u10 vd2 vd2 vss vss npn13G2 we=0.07u le=0.9u Nx=1 m=1
XQ62_u11 vd2 vd2 vss vss npn13G2 we=0.07u le=0.9u Nx=1 m=1
XQ62_u12 vd2 vd2 vss vss npn13G2 we=0.07u le=0.9u Nx=1 m=1
XQ62_u13 vd2 vd2 vss vss npn13G2 we=0.07u le=0.9u Nx=1 m=1
XQ62_u14 vd2 vd2 vss vss npn13G2 we=0.07u le=0.9u Nx=1 m=1
XQ62_u15 vd2 vd2 vss vss npn13G2 we=0.07u le=0.9u Nx=1 m=1
XQ62_u16 vd2 vd2 vss vss npn13G2 we=0.07u le=0.9u Nx=1 m=1
XQ62_u17 vd2 vd2 vss vss npn13G2 we=0.07u le=0.9u Nx=1 m=1
XQ62_u18 vd2 vd2 vss vss npn13G2 we=0.07u le=0.9u Nx=1 m=1
XQ62_u19 vd2 vd2 vss vss npn13G2 we=0.07u le=0.9u Nx=1 m=1
XQ62_u20 vd2 vd2 vss vss npn13G2 we=0.07u le=0.9u Nx=1 m=1
XQ62_u21 vd2 vd2 vss vss npn13G2 we=0.07u le=0.9u Nx=1 m=1
XQ62_u22 vd2 vd2 vss vss npn13G2 we=0.07u le=0.9u Nx=1 m=1
XQ62_u23 vd2 vd2 vss vss npn13G2 we=0.07u le=0.9u Nx=1 m=1
XQ62_u24 vd2 vd2 vss vss npn13G2 we=0.07u le=0.9u Nx=1 m=1
XQ67_u2 vbe b1b vss vss npn13G2 we=0.07u le=0.9u Nx=1 m=1
XQ67_u3 vbe b1b vss vss npn13G2 we=0.07u le=0.9u Nx=1 m=1
XQ67_u4 vbe b1b vss vss npn13G2 we=0.07u le=0.9u Nx=1 m=1
XQ67_u5 vbe b1b vss vss npn13G2 we=0.07u le=0.9u Nx=1 m=1
XQ67_u6 vbe b1b vss vss npn13G2 we=0.07u le=0.9u Nx=1 m=1
XQ67_u7 vbe b1b vss vss npn13G2 we=0.07u le=0.9u Nx=1 m=1
XQ67_u8 vbe b1b vss vss npn13G2 we=0.07u le=0.9u Nx=1 m=1
XQ67_u9 vbe b1b vss vss npn13G2 we=0.07u le=0.9u Nx=1 m=1
XQ67_u10 vbe b1b vss vss npn13G2 we=0.07u le=0.9u Nx=1 m=1
XQ67_u11 vbe b1b vss vss npn13G2 we=0.07u le=0.9u Nx=1 m=1
XQ67_u12 vbe b1b vss vss npn13G2 we=0.07u le=0.9u Nx=1 m=1
XQ67_u13 vbe b1b vss vss npn13G2 we=0.07u le=0.9u Nx=1 m=1
XQ67_u14 vbe b1b vss vss npn13G2 we=0.07u le=0.9u Nx=1 m=1
XQ67_u15 vbe b1b vss vss npn13G2 we=0.07u le=0.9u Nx=1 m=1
XQ67_u16 vbe b1b vss vss npn13G2 we=0.07u le=0.9u Nx=1 m=1
XQ67_u17 vbe b1b vss vss npn13G2 we=0.07u le=0.9u Nx=1 m=1
XQ67_u18 vbe b1b vss vss npn13G2 we=0.07u le=0.9u Nx=1 m=1
XQ67_u19 vbe b1b vss vss npn13G2 we=0.07u le=0.9u Nx=1 m=1
XQ67_u20 vbe b1b vss vss npn13G2 we=0.07u le=0.9u Nx=1 m=1
XQ67_u21 vbe b1b vss vss npn13G2 we=0.07u le=0.9u Nx=1 m=1
XQ67_u22 vbe b1b vss vss npn13G2 we=0.07u le=0.9u Nx=1 m=1
XQ67_u23 vbe b1b vss vss npn13G2 we=0.07u le=0.9u Nx=1 m=1
XQ67_u24 vbe b1b vss vss npn13G2 we=0.07u le=0.9u Nx=1 m=1
XQ68_u2 c2 vbe dvbe vss npn13G2 we=0.07u le=0.9u Nx=1 m=1
XQ68_u3 c2 vbe dvbe vss npn13G2 we=0.07u le=0.9u Nx=1 m=1
XQ68_u4 c2 vbe dvbe vss npn13G2 we=0.07u le=0.9u Nx=1 m=1
XQ68_u5 c2 vbe dvbe vss npn13G2 we=0.07u le=0.9u Nx=1 m=1
XQ68_u6 c2 vbe dvbe vss npn13G2 we=0.07u le=0.9u Nx=1 m=1
XQ68_u7 c2 vbe dvbe vss npn13G2 we=0.07u le=0.9u Nx=1 m=1
XQ68_u8 c2 vbe dvbe vss npn13G2 we=0.07u le=0.9u Nx=1 m=1
XQ68_u9 c2 vbe dvbe vss npn13G2 we=0.07u le=0.9u Nx=1 m=1
XQ68_u10 c2 vbe dvbe vss npn13G2 we=0.07u le=0.9u Nx=1 m=1
XQ68_u11 c2 vbe dvbe vss npn13G2 we=0.07u le=0.9u Nx=1 m=1
XQ68_u12 c2 vbe dvbe vss npn13G2 we=0.07u le=0.9u Nx=1 m=1
XQ68_u13 c2 vbe dvbe vss npn13G2 we=0.07u le=0.9u Nx=1 m=1
XQ68_u14 c2 vbe dvbe vss npn13G2 we=0.07u le=0.9u Nx=1 m=1
XQ68_u15 c2 vbe dvbe vss npn13G2 we=0.07u le=0.9u Nx=1 m=1
XQ68_u16 c2 vbe dvbe vss npn13G2 we=0.07u le=0.9u Nx=1 m=1
XQ68_u17 c2 vbe dvbe vss npn13G2 we=0.07u le=0.9u Nx=1 m=1
XQ68_u18 c2 vbe dvbe vss npn13G2 we=0.07u le=0.9u Nx=1 m=1
XQ68_u19 c2 vbe dvbe vss npn13G2 we=0.07u le=0.9u Nx=1 m=1
XQ68_u20 c2 vbe dvbe vss npn13G2 we=0.07u le=0.9u Nx=1 m=1
XQ68_u21 c2 vbe dvbe vss npn13G2 we=0.07u le=0.9u Nx=1 m=1
XQ68_u22 c2 vbe dvbe vss npn13G2 we=0.07u le=0.9u Nx=1 m=1
XQ68_u23 c2 vbe dvbe vss npn13G2 we=0.07u le=0.9u Nx=1 m=1
XQ68_u24 c2 vbe dvbe vss npn13G2 we=0.07u le=0.9u Nx=1 m=1
XQ69_u2 c2 vbe dvbe vss npn13G2 we=0.07u le=0.9u Nx=1 m=1
XQ69_u3 c2 vbe dvbe vss npn13G2 we=0.07u le=0.9u Nx=1 m=1
XQ69_u4 c2 vbe dvbe vss npn13G2 we=0.07u le=0.9u Nx=1 m=1
XQ69_u5 c2 vbe dvbe vss npn13G2 we=0.07u le=0.9u Nx=1 m=1
XQ69_u6 c2 vbe dvbe vss npn13G2 we=0.07u le=0.9u Nx=1 m=1
XQ69_u7 c2 vbe dvbe vss npn13G2 we=0.07u le=0.9u Nx=1 m=1
XQ69_u8 c2 vbe dvbe vss npn13G2 we=0.07u le=0.9u Nx=1 m=1
XQ69_u9 c2 vbe dvbe vss npn13G2 we=0.07u le=0.9u Nx=1 m=1
XQ69_u10 c2 vbe dvbe vss npn13G2 we=0.07u le=0.9u Nx=1 m=1
XQ69_u11 c2 vbe dvbe vss npn13G2 we=0.07u le=0.9u Nx=1 m=1
XQ69_u12 c2 vbe dvbe vss npn13G2 we=0.07u le=0.9u Nx=1 m=1
XQ69_u13 c2 vbe dvbe vss npn13G2 we=0.07u le=0.9u Nx=1 m=1
XQ69_u14 c2 vbe dvbe vss npn13G2 we=0.07u le=0.9u Nx=1 m=1
XQ69_u15 c2 vbe dvbe vss npn13G2 we=0.07u le=0.9u Nx=1 m=1
XQ69_u16 c2 vbe dvbe vss npn13G2 we=0.07u le=0.9u Nx=1 m=1
XQ69_u17 c2 vbe dvbe vss npn13G2 we=0.07u le=0.9u Nx=1 m=1
XQ69_u18 c2 vbe dvbe vss npn13G2 we=0.07u le=0.9u Nx=1 m=1
XQ69_u19 c2 vbe dvbe vss npn13G2 we=0.07u le=0.9u Nx=1 m=1
XQ69_u20 c2 vbe dvbe vss npn13G2 we=0.07u le=0.9u Nx=1 m=1
XQ69_u21 c2 vbe dvbe vss npn13G2 we=0.07u le=0.9u Nx=1 m=1
XQ69_u22 c2 vbe dvbe vss npn13G2 we=0.07u le=0.9u Nx=1 m=1
XQ69_u23 c2 vbe dvbe vss npn13G2 we=0.07u le=0.9u Nx=1 m=1
XQ69_u24 c2 vbe dvbe vss npn13G2 we=0.07u le=0.9u Nx=1 m=1
XQ70_u2 c2 vbe dvbe vss npn13G2 we=0.07u le=0.9u Nx=1 m=1
XQ70_u3 c2 vbe dvbe vss npn13G2 we=0.07u le=0.9u Nx=1 m=1
XQ70_u4 c2 vbe dvbe vss npn13G2 we=0.07u le=0.9u Nx=1 m=1
XQ70_u5 c2 vbe dvbe vss npn13G2 we=0.07u le=0.9u Nx=1 m=1
XQ70_u6 c2 vbe dvbe vss npn13G2 we=0.07u le=0.9u Nx=1 m=1
XQ70_u7 c2 vbe dvbe vss npn13G2 we=0.07u le=0.9u Nx=1 m=1
XQ70_u8 c2 vbe dvbe vss npn13G2 we=0.07u le=0.9u Nx=1 m=1
XQ70_u9 c2 vbe dvbe vss npn13G2 we=0.07u le=0.9u Nx=1 m=1
XQ70_u10 c2 vbe dvbe vss npn13G2 we=0.07u le=0.9u Nx=1 m=1
XQ70_u11 c2 vbe dvbe vss npn13G2 we=0.07u le=0.9u Nx=1 m=1
XQ70_u12 c2 vbe dvbe vss npn13G2 we=0.07u le=0.9u Nx=1 m=1
XQ70_u13 c2 vbe dvbe vss npn13G2 we=0.07u le=0.9u Nx=1 m=1
XQ70_u14 c2 vbe dvbe vss npn13G2 we=0.07u le=0.9u Nx=1 m=1
XQ70_u15 c2 vbe dvbe vss npn13G2 we=0.07u le=0.9u Nx=1 m=1
XQ70_u16 c2 vbe dvbe vss npn13G2 we=0.07u le=0.9u Nx=1 m=1
XQ70_u17 c2 vbe dvbe vss npn13G2 we=0.07u le=0.9u Nx=1 m=1
XQ70_u18 c2 vbe dvbe vss npn13G2 we=0.07u le=0.9u Nx=1 m=1
XQ70_u19 c2 vbe dvbe vss npn13G2 we=0.07u le=0.9u Nx=1 m=1
XQ70_u20 c2 vbe dvbe vss npn13G2 we=0.07u le=0.9u Nx=1 m=1
XQ70_u21 c2 vbe dvbe vss npn13G2 we=0.07u le=0.9u Nx=1 m=1
XQ70_u22 c2 vbe dvbe vss npn13G2 we=0.07u le=0.9u Nx=1 m=1
XQ70_u23 c2 vbe dvbe vss npn13G2 we=0.07u le=0.9u Nx=1 m=1
XQ70_u24 c2 vbe dvbe vss npn13G2 we=0.07u le=0.9u Nx=1 m=1
XQ71_u2 c2 vbe dvbe vss npn13G2 we=0.07u le=0.9u Nx=1 m=1
XQ71_u3 c2 vbe dvbe vss npn13G2 we=0.07u le=0.9u Nx=1 m=1
XQ71_u4 c2 vbe dvbe vss npn13G2 we=0.07u le=0.9u Nx=1 m=1
XQ71_u5 c2 vbe dvbe vss npn13G2 we=0.07u le=0.9u Nx=1 m=1
XQ71_u6 c2 vbe dvbe vss npn13G2 we=0.07u le=0.9u Nx=1 m=1
XQ71_u7 c2 vbe dvbe vss npn13G2 we=0.07u le=0.9u Nx=1 m=1
XQ71_u8 c2 vbe dvbe vss npn13G2 we=0.07u le=0.9u Nx=1 m=1
XQ71_u9 c2 vbe dvbe vss npn13G2 we=0.07u le=0.9u Nx=1 m=1
XQ71_u10 c2 vbe dvbe vss npn13G2 we=0.07u le=0.9u Nx=1 m=1
XQ71_u11 c2 vbe dvbe vss npn13G2 we=0.07u le=0.9u Nx=1 m=1
XQ71_u12 c2 vbe dvbe vss npn13G2 we=0.07u le=0.9u Nx=1 m=1
XQ71_u13 c2 vbe dvbe vss npn13G2 we=0.07u le=0.9u Nx=1 m=1
XQ71_u14 c2 vbe dvbe vss npn13G2 we=0.07u le=0.9u Nx=1 m=1
XQ71_u15 c2 vbe dvbe vss npn13G2 we=0.07u le=0.9u Nx=1 m=1
XQ71_u16 c2 vbe dvbe vss npn13G2 we=0.07u le=0.9u Nx=1 m=1
XQ71_u17 c2 vbe dvbe vss npn13G2 we=0.07u le=0.9u Nx=1 m=1
XQ71_u18 c2 vbe dvbe vss npn13G2 we=0.07u le=0.9u Nx=1 m=1
XQ71_u19 c2 vbe dvbe vss npn13G2 we=0.07u le=0.9u Nx=1 m=1
XQ71_u20 c2 vbe dvbe vss npn13G2 we=0.07u le=0.9u Nx=1 m=1
XQ71_u21 c2 vbe dvbe vss npn13G2 we=0.07u le=0.9u Nx=1 m=1
XQ71_u22 c2 vbe dvbe vss npn13G2 we=0.07u le=0.9u Nx=1 m=1
XQ71_u23 c2 vbe dvbe vss npn13G2 we=0.07u le=0.9u Nx=1 m=1
XQ71_u24 c2 vbe dvbe vss npn13G2 we=0.07u le=0.9u Nx=1 m=1
XQ72_u2 c2 vbe dvbe vss npn13G2 we=0.07u le=0.9u Nx=1 m=1
XQ72_u3 c2 vbe dvbe vss npn13G2 we=0.07u le=0.9u Nx=1 m=1
XQ72_u4 c2 vbe dvbe vss npn13G2 we=0.07u le=0.9u Nx=1 m=1
XQ72_u5 c2 vbe dvbe vss npn13G2 we=0.07u le=0.9u Nx=1 m=1
XQ72_u6 c2 vbe dvbe vss npn13G2 we=0.07u le=0.9u Nx=1 m=1
XQ72_u7 c2 vbe dvbe vss npn13G2 we=0.07u le=0.9u Nx=1 m=1
XQ72_u8 c2 vbe dvbe vss npn13G2 we=0.07u le=0.9u Nx=1 m=1
XQ72_u9 c2 vbe dvbe vss npn13G2 we=0.07u le=0.9u Nx=1 m=1
XQ72_u10 c2 vbe dvbe vss npn13G2 we=0.07u le=0.9u Nx=1 m=1
XQ72_u11 c2 vbe dvbe vss npn13G2 we=0.07u le=0.9u Nx=1 m=1
XQ72_u12 c2 vbe dvbe vss npn13G2 we=0.07u le=0.9u Nx=1 m=1
XQ72_u13 c2 vbe dvbe vss npn13G2 we=0.07u le=0.9u Nx=1 m=1
XQ72_u14 c2 vbe dvbe vss npn13G2 we=0.07u le=0.9u Nx=1 m=1
XQ72_u15 c2 vbe dvbe vss npn13G2 we=0.07u le=0.9u Nx=1 m=1
XQ72_u16 c2 vbe dvbe vss npn13G2 we=0.07u le=0.9u Nx=1 m=1
XQ72_u17 c2 vbe dvbe vss npn13G2 we=0.07u le=0.9u Nx=1 m=1
XQ72_u18 c2 vbe dvbe vss npn13G2 we=0.07u le=0.9u Nx=1 m=1
XQ72_u19 c2 vbe dvbe vss npn13G2 we=0.07u le=0.9u Nx=1 m=1
XQ72_u20 c2 vbe dvbe vss npn13G2 we=0.07u le=0.9u Nx=1 m=1
XQ72_u21 c2 vbe dvbe vss npn13G2 we=0.07u le=0.9u Nx=1 m=1
XQ72_u22 c2 vbe dvbe vss npn13G2 we=0.07u le=0.9u Nx=1 m=1
XQ72_u23 c2 vbe dvbe vss npn13G2 we=0.07u le=0.9u Nx=1 m=1
XQ72_u24 c2 vbe dvbe vss npn13G2 we=0.07u le=0.9u Nx=1 m=1
XQ73_u2 c2 vbe dvbe vss npn13G2 we=0.07u le=0.9u Nx=1 m=1
XQ73_u3 c2 vbe dvbe vss npn13G2 we=0.07u le=0.9u Nx=1 m=1
XQ73_u4 c2 vbe dvbe vss npn13G2 we=0.07u le=0.9u Nx=1 m=1
XQ73_u5 c2 vbe dvbe vss npn13G2 we=0.07u le=0.9u Nx=1 m=1
XQ73_u6 c2 vbe dvbe vss npn13G2 we=0.07u le=0.9u Nx=1 m=1
XQ73_u7 c2 vbe dvbe vss npn13G2 we=0.07u le=0.9u Nx=1 m=1
XQ73_u8 c2 vbe dvbe vss npn13G2 we=0.07u le=0.9u Nx=1 m=1
XQ73_u9 c2 vbe dvbe vss npn13G2 we=0.07u le=0.9u Nx=1 m=1
XQ73_u10 c2 vbe dvbe vss npn13G2 we=0.07u le=0.9u Nx=1 m=1
XQ73_u11 c2 vbe dvbe vss npn13G2 we=0.07u le=0.9u Nx=1 m=1
XQ73_u12 c2 vbe dvbe vss npn13G2 we=0.07u le=0.9u Nx=1 m=1
XQ73_u13 c2 vbe dvbe vss npn13G2 we=0.07u le=0.9u Nx=1 m=1
XQ73_u14 c2 vbe dvbe vss npn13G2 we=0.07u le=0.9u Nx=1 m=1
XQ73_u15 c2 vbe dvbe vss npn13G2 we=0.07u le=0.9u Nx=1 m=1
XQ73_u16 c2 vbe dvbe vss npn13G2 we=0.07u le=0.9u Nx=1 m=1
XQ73_u17 c2 vbe dvbe vss npn13G2 we=0.07u le=0.9u Nx=1 m=1
XQ73_u18 c2 vbe dvbe vss npn13G2 we=0.07u le=0.9u Nx=1 m=1
XQ73_u19 c2 vbe dvbe vss npn13G2 we=0.07u le=0.9u Nx=1 m=1
XQ73_u20 c2 vbe dvbe vss npn13G2 we=0.07u le=0.9u Nx=1 m=1
XQ73_u21 c2 vbe dvbe vss npn13G2 we=0.07u le=0.9u Nx=1 m=1
XQ73_u22 c2 vbe dvbe vss npn13G2 we=0.07u le=0.9u Nx=1 m=1
XQ73_u23 c2 vbe dvbe vss npn13G2 we=0.07u le=0.9u Nx=1 m=1
XQ73_u24 c2 vbe dvbe vss npn13G2 we=0.07u le=0.9u Nx=1 m=1
XQ74_u2 c2 vbe dvbe vss npn13G2 we=0.07u le=0.9u Nx=1 m=1
XQ74_u3 c2 vbe dvbe vss npn13G2 we=0.07u le=0.9u Nx=1 m=1
XQ74_u4 c2 vbe dvbe vss npn13G2 we=0.07u le=0.9u Nx=1 m=1
XQ74_u5 c2 vbe dvbe vss npn13G2 we=0.07u le=0.9u Nx=1 m=1
XQ74_u6 c2 vbe dvbe vss npn13G2 we=0.07u le=0.9u Nx=1 m=1
XQ74_u7 c2 vbe dvbe vss npn13G2 we=0.07u le=0.9u Nx=1 m=1
XQ74_u8 c2 vbe dvbe vss npn13G2 we=0.07u le=0.9u Nx=1 m=1
XQ74_u9 c2 vbe dvbe vss npn13G2 we=0.07u le=0.9u Nx=1 m=1
XQ74_u10 c2 vbe dvbe vss npn13G2 we=0.07u le=0.9u Nx=1 m=1
XQ74_u11 c2 vbe dvbe vss npn13G2 we=0.07u le=0.9u Nx=1 m=1
XQ74_u12 c2 vbe dvbe vss npn13G2 we=0.07u le=0.9u Nx=1 m=1
XQ74_u13 c2 vbe dvbe vss npn13G2 we=0.07u le=0.9u Nx=1 m=1
XQ74_u14 c2 vbe dvbe vss npn13G2 we=0.07u le=0.9u Nx=1 m=1
XQ74_u15 c2 vbe dvbe vss npn13G2 we=0.07u le=0.9u Nx=1 m=1
XQ74_u16 c2 vbe dvbe vss npn13G2 we=0.07u le=0.9u Nx=1 m=1
XQ74_u17 c2 vbe dvbe vss npn13G2 we=0.07u le=0.9u Nx=1 m=1
XQ74_u18 c2 vbe dvbe vss npn13G2 we=0.07u le=0.9u Nx=1 m=1
XQ74_u19 c2 vbe dvbe vss npn13G2 we=0.07u le=0.9u Nx=1 m=1
XQ74_u20 c2 vbe dvbe vss npn13G2 we=0.07u le=0.9u Nx=1 m=1
XQ74_u21 c2 vbe dvbe vss npn13G2 we=0.07u le=0.9u Nx=1 m=1
XQ74_u22 c2 vbe dvbe vss npn13G2 we=0.07u le=0.9u Nx=1 m=1
XQ74_u23 c2 vbe dvbe vss npn13G2 we=0.07u le=0.9u Nx=1 m=1
XQ74_u24 c2 vbe dvbe vss npn13G2 we=0.07u le=0.9u Nx=1 m=1
XQ75_u2 vd1 vd1 vd2 vss npn13G2 we=0.07u le=0.9u Nx=1 m=1
XQ75_u3 vd1 vd1 vd2 vss npn13G2 we=0.07u le=0.9u Nx=1 m=1
XQ75_u4 vd1 vd1 vd2 vss npn13G2 we=0.07u le=0.9u Nx=1 m=1
XQ75_u5 vd1 vd1 vd2 vss npn13G2 we=0.07u le=0.9u Nx=1 m=1
XQ75_u6 vd1 vd1 vd2 vss npn13G2 we=0.07u le=0.9u Nx=1 m=1
XQ75_u7 vd1 vd1 vd2 vss npn13G2 we=0.07u le=0.9u Nx=1 m=1
XQ75_u8 vd1 vd1 vd2 vss npn13G2 we=0.07u le=0.9u Nx=1 m=1
XQ75_u9 vd1 vd1 vd2 vss npn13G2 we=0.07u le=0.9u Nx=1 m=1
XQ75_u10 vd1 vd1 vd2 vss npn13G2 we=0.07u le=0.9u Nx=1 m=1
XQ75_u11 vd1 vd1 vd2 vss npn13G2 we=0.07u le=0.9u Nx=1 m=1
XQ75_u12 vd1 vd1 vd2 vss npn13G2 we=0.07u le=0.9u Nx=1 m=1
XQ75_u13 vd1 vd1 vd2 vss npn13G2 we=0.07u le=0.9u Nx=1 m=1
XQ75_u14 vd1 vd1 vd2 vss npn13G2 we=0.07u le=0.9u Nx=1 m=1
XQ75_u15 vd1 vd1 vd2 vss npn13G2 we=0.07u le=0.9u Nx=1 m=1
XQ75_u16 vd1 vd1 vd2 vss npn13G2 we=0.07u le=0.9u Nx=1 m=1
XQ75_u17 vd1 vd1 vd2 vss npn13G2 we=0.07u le=0.9u Nx=1 m=1
XQ75_u18 vd1 vd1 vd2 vss npn13G2 we=0.07u le=0.9u Nx=1 m=1
XQ75_u19 vd1 vd1 vd2 vss npn13G2 we=0.07u le=0.9u Nx=1 m=1
XQ75_u20 vd1 vd1 vd2 vss npn13G2 we=0.07u le=0.9u Nx=1 m=1
XQ75_u21 vd1 vd1 vd2 vss npn13G2 we=0.07u le=0.9u Nx=1 m=1
XQ75_u22 vd1 vd1 vd2 vss npn13G2 we=0.07u le=0.9u Nx=1 m=1
XQ75_u23 vd1 vd1 vd2 vss npn13G2 we=0.07u le=0.9u Nx=1 m=1
XQ75_u24 vd1 vd1 vd2 vss npn13G2 we=0.07u le=0.9u Nx=1 m=1
XQ76_u2 c2 vbe dvbe vss npn13G2 we=0.07u le=0.9u Nx=1 m=1
XQ76_u3 c2 vbe dvbe vss npn13G2 we=0.07u le=0.9u Nx=1 m=1
XQ76_u4 c2 vbe dvbe vss npn13G2 we=0.07u le=0.9u Nx=1 m=1
XQ76_u5 c2 vbe dvbe vss npn13G2 we=0.07u le=0.9u Nx=1 m=1
XQ76_u6 c2 vbe dvbe vss npn13G2 we=0.07u le=0.9u Nx=1 m=1
XQ76_u7 c2 vbe dvbe vss npn13G2 we=0.07u le=0.9u Nx=1 m=1
XQ76_u8 c2 vbe dvbe vss npn13G2 we=0.07u le=0.9u Nx=1 m=1
XQ76_u9 c2 vbe dvbe vss npn13G2 we=0.07u le=0.9u Nx=1 m=1
XQ76_u10 c2 vbe dvbe vss npn13G2 we=0.07u le=0.9u Nx=1 m=1
XQ76_u11 c2 vbe dvbe vss npn13G2 we=0.07u le=0.9u Nx=1 m=1
XQ76_u12 c2 vbe dvbe vss npn13G2 we=0.07u le=0.9u Nx=1 m=1
XQ76_u13 c2 vbe dvbe vss npn13G2 we=0.07u le=0.9u Nx=1 m=1
XQ76_u14 c2 vbe dvbe vss npn13G2 we=0.07u le=0.9u Nx=1 m=1
XQ76_u15 c2 vbe dvbe vss npn13G2 we=0.07u le=0.9u Nx=1 m=1
XQ76_u16 c2 vbe dvbe vss npn13G2 we=0.07u le=0.9u Nx=1 m=1
XQ76_u17 c2 vbe dvbe vss npn13G2 we=0.07u le=0.9u Nx=1 m=1
XQ76_u18 c2 vbe dvbe vss npn13G2 we=0.07u le=0.9u Nx=1 m=1
XQ76_u19 c2 vbe dvbe vss npn13G2 we=0.07u le=0.9u Nx=1 m=1
XQ76_u20 c2 vbe dvbe vss npn13G2 we=0.07u le=0.9u Nx=1 m=1
XQ76_u21 c2 vbe dvbe vss npn13G2 we=0.07u le=0.9u Nx=1 m=1
XQ76_u22 c2 vbe dvbe vss npn13G2 we=0.07u le=0.9u Nx=1 m=1
XQ76_u23 c2 vbe dvbe vss npn13G2 we=0.07u le=0.9u Nx=1 m=1
XQ76_u24 c2 vbe dvbe vss npn13G2 we=0.07u le=0.9u Nx=1 m=1
XR77_u2 n_4 pbias vss rppd w=1u l=50u b=0 m=1
XR77_u3 n_4 pbias vss rppd w=1u l=50u b=0 m=1
XR77_u4 n_4 pbias vss rppd w=1u l=50u b=0 m=1
XR77_u5 n_4 pbias vss rppd w=1u l=50u b=0 m=1
XR77_u6 n_4 pbias vss rppd w=1u l=50u b=0 m=1
XR77_u7 n_4 pbias vss rppd w=1u l=50u b=0 m=1
XR77_u8 n_4 pbias vss rppd w=1u l=50u b=0 m=1
XR77_u9 n_4 pbias vss rppd w=1u l=50u b=0 m=1
XR77_u10 n_4 pbias vss rppd w=1u l=50u b=0 m=1
XR77_u11 n_4 pbias vss rppd w=1u l=50u b=0 m=1
XR77_u12 n_4 pbias vss rppd w=1u l=50u b=0 m=1
XR77_u13 n_4 pbias vss rppd w=1u l=50u b=0 m=1
XR77_u14 n_4 pbias vss rppd w=1u l=50u b=0 m=1
XR77_u15 n_4 pbias vss rppd w=1u l=50u b=0 m=1
XR77_u16 n_4 pbias vss rppd w=1u l=50u b=0 m=1
XR77_u17 n_4 pbias vss rppd w=1u l=50u b=0 m=1
XR77_u18 n_4 pbias vss rppd w=1u l=50u b=0 m=1
XR77_u19 n_4 pbias vss rppd w=1u l=50u b=0 m=1
XR77_u20 n_4 pbias vss rppd w=1u l=50u b=0 m=1
XR77_u21 n_4 pbias vss rppd w=1u l=50u b=0 m=1
XR77_u22 n_4 pbias vss rppd w=1u l=50u b=0 m=1
XR77_u23 n_4 pbias vss rppd w=1u l=50u b=0 m=1
XR77_u24 n_4 pbias vss rppd w=1u l=50u b=0 m=1
XR78_u2 n_11 n_34 vss rppd w=1u l=50u b=0 m=1
XR78_u3 n_11 n_34 vss rppd w=1u l=50u b=0 m=1
XR78_u4 n_11 n_34 vss rppd w=1u l=50u b=0 m=1
XR78_u5 n_11 n_34 vss rppd w=1u l=50u b=0 m=1
XR78_u6 n_11 n_34 vss rppd w=1u l=50u b=0 m=1
XR78_u7 n_11 n_34 vss rppd w=1u l=50u b=0 m=1
XR78_u8 n_11 n_34 vss rppd w=1u l=50u b=0 m=1
XR78_u9 n_11 n_34 vss rppd w=1u l=50u b=0 m=1
XR78_u10 n_11 n_34 vss rppd w=1u l=50u b=0 m=1
XR78_u11 n_11 n_34 vss rppd w=1u l=50u b=0 m=1
XR78_u12 n_11 n_34 vss rppd w=1u l=50u b=0 m=1
XR78_u13 n_11 n_34 vss rppd w=1u l=50u b=0 m=1
XR78_u14 n_11 n_34 vss rppd w=1u l=50u b=0 m=1
XR78_u15 n_11 n_34 vss rppd w=1u l=50u b=0 m=1
XR78_u16 n_11 n_34 vss rppd w=1u l=50u b=0 m=1
XR78_u17 n_11 n_34 vss rppd w=1u l=50u b=0 m=1
XR78_u18 n_11 n_34 vss rppd w=1u l=50u b=0 m=1
XR78_u19 n_11 n_34 vss rppd w=1u l=50u b=0 m=1
XR78_u20 n_11 n_34 vss rppd w=1u l=50u b=0 m=1
XR78_u21 n_11 n_34 vss rppd w=1u l=50u b=0 m=1
XR78_u22 n_11 n_34 vss rppd w=1u l=50u b=0 m=1
XR78_u23 n_11 n_34 vss rppd w=1u l=50u b=0 m=1
XR78_u24 n_11 n_34 vss rppd w=1u l=50u b=0 m=1
XR79_u2 n_10 n_34 vss rppd w=1u l=50u b=0 m=1
XR79_u3 n_10 n_34 vss rppd w=1u l=50u b=0 m=1
XR79_u4 n_10 n_34 vss rppd w=1u l=50u b=0 m=1
XR79_u5 n_10 n_34 vss rppd w=1u l=50u b=0 m=1
XR79_u6 n_10 n_34 vss rppd w=1u l=50u b=0 m=1
XR79_u7 n_10 n_34 vss rppd w=1u l=50u b=0 m=1
XR79_u8 n_10 n_34 vss rppd w=1u l=50u b=0 m=1
XR79_u9 n_10 n_34 vss rppd w=1u l=50u b=0 m=1
XR79_u10 n_10 n_34 vss rppd w=1u l=50u b=0 m=1
XR79_u11 n_10 n_34 vss rppd w=1u l=50u b=0 m=1
XR79_u12 n_10 n_34 vss rppd w=1u l=50u b=0 m=1
XR79_u13 n_10 n_34 vss rppd w=1u l=50u b=0 m=1
XR79_u14 n_10 n_34 vss rppd w=1u l=50u b=0 m=1
XR79_u15 n_10 n_34 vss rppd w=1u l=50u b=0 m=1
XR79_u16 n_10 n_34 vss rppd w=1u l=50u b=0 m=1
XR79_u17 n_10 n_34 vss rppd w=1u l=50u b=0 m=1
XR79_u18 n_10 n_34 vss rppd w=1u l=50u b=0 m=1
XR79_u19 n_10 n_34 vss rppd w=1u l=50u b=0 m=1
XR79_u20 n_10 n_34 vss rppd w=1u l=50u b=0 m=1
XR79_u21 n_10 n_34 vss rppd w=1u l=50u b=0 m=1
XR79_u22 n_10 n_34 vss rppd w=1u l=50u b=0 m=1
XR79_u23 n_10 n_34 vss rppd w=1u l=50u b=0 m=1
XR79_u24 n_10 n_34 vss rppd w=1u l=50u b=0 m=1
XR80_u2 n_3 n_31 vss rppd w=1u l=50u b=0 m=1
XR80_u3 n_3 n_31 vss rppd w=1u l=50u b=0 m=1
XR80_u4 n_3 n_31 vss rppd w=1u l=50u b=0 m=1
XR80_u5 n_3 n_31 vss rppd w=1u l=50u b=0 m=1
XR80_u6 n_3 n_31 vss rppd w=1u l=50u b=0 m=1
XR80_u7 n_3 n_31 vss rppd w=1u l=50u b=0 m=1
XR80_u8 n_3 n_31 vss rppd w=1u l=50u b=0 m=1
XR80_u9 n_3 n_31 vss rppd w=1u l=50u b=0 m=1
XR80_u10 n_3 n_31 vss rppd w=1u l=50u b=0 m=1
XR80_u11 n_3 n_31 vss rppd w=1u l=50u b=0 m=1
XR80_u12 n_3 n_31 vss rppd w=1u l=50u b=0 m=1
XR80_u13 n_3 n_31 vss rppd w=1u l=50u b=0 m=1
XR80_u14 n_3 n_31 vss rppd w=1u l=50u b=0 m=1
XR80_u15 n_3 n_31 vss rppd w=1u l=50u b=0 m=1
XR80_u16 n_3 n_31 vss rppd w=1u l=50u b=0 m=1
XR80_u17 n_3 n_31 vss rppd w=1u l=50u b=0 m=1
XR80_u18 n_3 n_31 vss rppd w=1u l=50u b=0 m=1
XR80_u19 n_3 n_31 vss rppd w=1u l=50u b=0 m=1
XR80_u20 n_3 n_31 vss rppd w=1u l=50u b=0 m=1
XR80_u21 n_3 n_31 vss rppd w=1u l=50u b=0 m=1
XR80_u22 n_3 n_31 vss rppd w=1u l=50u b=0 m=1
XR80_u23 n_3 n_31 vss rppd w=1u l=50u b=0 m=1
XR80_u24 n_3 n_31 vss rppd w=1u l=50u b=0 m=1
XR81_u2 n_10 n_33 vss rppd w=1u l=50u b=0 m=1
XR81_u3 n_10 n_33 vss rppd w=1u l=50u b=0 m=1
XR81_u4 n_10 n_33 vss rppd w=1u l=50u b=0 m=1
XR81_u5 n_10 n_33 vss rppd w=1u l=50u b=0 m=1
XR81_u6 n_10 n_33 vss rppd w=1u l=50u b=0 m=1
XR81_u7 n_10 n_33 vss rppd w=1u l=50u b=0 m=1
XR81_u8 n_10 n_33 vss rppd w=1u l=50u b=0 m=1
XR81_u9 n_10 n_33 vss rppd w=1u l=50u b=0 m=1
XR81_u10 n_10 n_33 vss rppd w=1u l=50u b=0 m=1
XR81_u11 n_10 n_33 vss rppd w=1u l=50u b=0 m=1
XR81_u12 n_10 n_33 vss rppd w=1u l=50u b=0 m=1
XR81_u13 n_10 n_33 vss rppd w=1u l=50u b=0 m=1
XR81_u14 n_10 n_33 vss rppd w=1u l=50u b=0 m=1
XR81_u15 n_10 n_33 vss rppd w=1u l=50u b=0 m=1
XR81_u16 n_10 n_33 vss rppd w=1u l=50u b=0 m=1
XR81_u17 n_10 n_33 vss rppd w=1u l=50u b=0 m=1
XR81_u18 n_10 n_33 vss rppd w=1u l=50u b=0 m=1
XR81_u19 n_10 n_33 vss rppd w=1u l=50u b=0 m=1
XR81_u20 n_10 n_33 vss rppd w=1u l=50u b=0 m=1
XR81_u21 n_10 n_33 vss rppd w=1u l=50u b=0 m=1
XR81_u22 n_10 n_33 vss rppd w=1u l=50u b=0 m=1
XR81_u23 n_10 n_33 vss rppd w=1u l=50u b=0 m=1
XR81_u24 n_10 n_33 vss rppd w=1u l=50u b=0 m=1
XR82_u2 n_5 n_31 vss rppd w=1u l=50u b=0 m=1
XR82_u3 n_5 n_31 vss rppd w=1u l=50u b=0 m=1
XR82_u4 n_5 n_31 vss rppd w=1u l=50u b=0 m=1
XR82_u5 n_5 n_31 vss rppd w=1u l=50u b=0 m=1
XR82_u6 n_5 n_31 vss rppd w=1u l=50u b=0 m=1
XR82_u7 n_5 n_31 vss rppd w=1u l=50u b=0 m=1
XR82_u8 n_5 n_31 vss rppd w=1u l=50u b=0 m=1
XR82_u9 n_5 n_31 vss rppd w=1u l=50u b=0 m=1
XR82_u10 n_5 n_31 vss rppd w=1u l=50u b=0 m=1
XR82_u11 n_5 n_31 vss rppd w=1u l=50u b=0 m=1
XR82_u12 n_5 n_31 vss rppd w=1u l=50u b=0 m=1
XR82_u13 n_5 n_31 vss rppd w=1u l=50u b=0 m=1
XR82_u14 n_5 n_31 vss rppd w=1u l=50u b=0 m=1
XR82_u15 n_5 n_31 vss rppd w=1u l=50u b=0 m=1
XR82_u16 n_5 n_31 vss rppd w=1u l=50u b=0 m=1
XR82_u17 n_5 n_31 vss rppd w=1u l=50u b=0 m=1
XR82_u18 n_5 n_31 vss rppd w=1u l=50u b=0 m=1
XR82_u19 n_5 n_31 vss rppd w=1u l=50u b=0 m=1
XR82_u20 n_5 n_31 vss rppd w=1u l=50u b=0 m=1
XR82_u21 n_5 n_31 vss rppd w=1u l=50u b=0 m=1
XR82_u22 n_5 n_31 vss rppd w=1u l=50u b=0 m=1
XR82_u23 n_5 n_31 vss rppd w=1u l=50u b=0 m=1
XR82_u24 n_5 n_31 vss rppd w=1u l=50u b=0 m=1
XR83_u2 n_5 n_30 vss rppd w=1u l=50u b=0 m=1
XR83_u3 n_5 n_30 vss rppd w=1u l=50u b=0 m=1
XR83_u4 n_5 n_30 vss rppd w=1u l=50u b=0 m=1
XR83_u5 n_5 n_30 vss rppd w=1u l=50u b=0 m=1
XR83_u6 n_5 n_30 vss rppd w=1u l=50u b=0 m=1
XR83_u7 n_5 n_30 vss rppd w=1u l=50u b=0 m=1
XR83_u8 n_5 n_30 vss rppd w=1u l=50u b=0 m=1
XR83_u9 n_5 n_30 vss rppd w=1u l=50u b=0 m=1
XR83_u10 n_5 n_30 vss rppd w=1u l=50u b=0 m=1
XR83_u11 n_5 n_30 vss rppd w=1u l=50u b=0 m=1
XR83_u12 n_5 n_30 vss rppd w=1u l=50u b=0 m=1
XR83_u13 n_5 n_30 vss rppd w=1u l=50u b=0 m=1
XR83_u14 n_5 n_30 vss rppd w=1u l=50u b=0 m=1
XR83_u15 n_5 n_30 vss rppd w=1u l=50u b=0 m=1
XR83_u16 n_5 n_30 vss rppd w=1u l=50u b=0 m=1
XR83_u17 n_5 n_30 vss rppd w=1u l=50u b=0 m=1
XR83_u18 n_5 n_30 vss rppd w=1u l=50u b=0 m=1
XR83_u19 n_5 n_30 vss rppd w=1u l=50u b=0 m=1
XR83_u20 n_5 n_30 vss rppd w=1u l=50u b=0 m=1
XR83_u21 n_5 n_30 vss rppd w=1u l=50u b=0 m=1
XR83_u22 n_5 n_30 vss rppd w=1u l=50u b=0 m=1
XR83_u23 n_5 n_30 vss rppd w=1u l=50u b=0 m=1
XR83_u24 n_5 n_30 vss rppd w=1u l=50u b=0 m=1
XR84_u2 n_4 n_30 vss rppd w=1u l=50u b=0 m=1
XR84_u3 n_4 n_30 vss rppd w=1u l=50u b=0 m=1
XR84_u4 n_4 n_30 vss rppd w=1u l=50u b=0 m=1
XR84_u5 n_4 n_30 vss rppd w=1u l=50u b=0 m=1
XR84_u6 n_4 n_30 vss rppd w=1u l=50u b=0 m=1
XR84_u7 n_4 n_30 vss rppd w=1u l=50u b=0 m=1
XR84_u8 n_4 n_30 vss rppd w=1u l=50u b=0 m=1
XR84_u9 n_4 n_30 vss rppd w=1u l=50u b=0 m=1
XR84_u10 n_4 n_30 vss rppd w=1u l=50u b=0 m=1
XR84_u11 n_4 n_30 vss rppd w=1u l=50u b=0 m=1
XR84_u12 n_4 n_30 vss rppd w=1u l=50u b=0 m=1
XR84_u13 n_4 n_30 vss rppd w=1u l=50u b=0 m=1
XR84_u14 n_4 n_30 vss rppd w=1u l=50u b=0 m=1
XR84_u15 n_4 n_30 vss rppd w=1u l=50u b=0 m=1
XR84_u16 n_4 n_30 vss rppd w=1u l=50u b=0 m=1
XR84_u17 n_4 n_30 vss rppd w=1u l=50u b=0 m=1
XR84_u18 n_4 n_30 vss rppd w=1u l=50u b=0 m=1
XR84_u19 n_4 n_30 vss rppd w=1u l=50u b=0 m=1
XR84_u20 n_4 n_30 vss rppd w=1u l=50u b=0 m=1
XR84_u21 n_4 n_30 vss rppd w=1u l=50u b=0 m=1
XR84_u22 n_4 n_30 vss rppd w=1u l=50u b=0 m=1
XR84_u23 n_4 n_30 vss rppd w=1u l=50u b=0 m=1
XR84_u24 n_4 n_30 vss rppd w=1u l=50u b=0 m=1
XR85_u2 n_3 n_33 vss rppd w=1u l=50u b=0 m=1
XR85_u3 n_3 n_33 vss rppd w=1u l=50u b=0 m=1
XR85_u4 n_3 n_33 vss rppd w=1u l=50u b=0 m=1
XR85_u5 n_3 n_33 vss rppd w=1u l=50u b=0 m=1
XR85_u6 n_3 n_33 vss rppd w=1u l=50u b=0 m=1
XR85_u7 n_3 n_33 vss rppd w=1u l=50u b=0 m=1
XR85_u8 n_3 n_33 vss rppd w=1u l=50u b=0 m=1
XR85_u9 n_3 n_33 vss rppd w=1u l=50u b=0 m=1
XR85_u10 n_3 n_33 vss rppd w=1u l=50u b=0 m=1
XR85_u11 n_3 n_33 vss rppd w=1u l=50u b=0 m=1
XR85_u12 n_3 n_33 vss rppd w=1u l=50u b=0 m=1
XR85_u13 n_3 n_33 vss rppd w=1u l=50u b=0 m=1
XR85_u14 n_3 n_33 vss rppd w=1u l=50u b=0 m=1
XR85_u15 n_3 n_33 vss rppd w=1u l=50u b=0 m=1
XR85_u16 n_3 n_33 vss rppd w=1u l=50u b=0 m=1
XR85_u17 n_3 n_33 vss rppd w=1u l=50u b=0 m=1
XR85_u18 n_3 n_33 vss rppd w=1u l=50u b=0 m=1
XR85_u19 n_3 n_33 vss rppd w=1u l=50u b=0 m=1
XR85_u20 n_3 n_33 vss rppd w=1u l=50u b=0 m=1
XR85_u21 n_3 n_33 vss rppd w=1u l=50u b=0 m=1
XR85_u22 n_3 n_33 vss rppd w=1u l=50u b=0 m=1
XR85_u23 n_3 n_33 vss rppd w=1u l=50u b=0 m=1
XR85_u24 n_3 n_33 vss rppd w=1u l=50u b=0 m=1
XR86_u2 n_11 pcasc vss rppd w=1u l=50u b=0 m=1
XR86_u3 n_11 pcasc vss rppd w=1u l=50u b=0 m=1
XR86_u4 n_11 pcasc vss rppd w=1u l=50u b=0 m=1
XR86_u5 n_11 pcasc vss rppd w=1u l=50u b=0 m=1
XR86_u6 n_11 pcasc vss rppd w=1u l=50u b=0 m=1
XR86_u7 n_11 pcasc vss rppd w=1u l=50u b=0 m=1
XR86_u8 n_11 pcasc vss rppd w=1u l=50u b=0 m=1
XR86_u9 n_11 pcasc vss rppd w=1u l=50u b=0 m=1
XR86_u10 n_11 pcasc vss rppd w=1u l=50u b=0 m=1
XR86_u11 n_11 pcasc vss rppd w=1u l=50u b=0 m=1
XR86_u12 n_11 pcasc vss rppd w=1u l=50u b=0 m=1
XR86_u13 n_11 pcasc vss rppd w=1u l=50u b=0 m=1
XR86_u14 n_11 pcasc vss rppd w=1u l=50u b=0 m=1
XR86_u15 n_11 pcasc vss rppd w=1u l=50u b=0 m=1
XR86_u16 n_11 pcasc vss rppd w=1u l=50u b=0 m=1
XR86_u17 n_11 pcasc vss rppd w=1u l=50u b=0 m=1
XR86_u18 n_11 pcasc vss rppd w=1u l=50u b=0 m=1
XR86_u19 n_11 pcasc vss rppd w=1u l=50u b=0 m=1
XR86_u20 n_11 pcasc vss rppd w=1u l=50u b=0 m=1
XR86_u21 n_11 pcasc vss rppd w=1u l=50u b=0 m=1
XR86_u22 n_11 pcasc vss rppd w=1u l=50u b=0 m=1
XR86_u23 n_11 pcasc vss rppd w=1u l=50u b=0 m=1
XR86_u24 n_11 pcasc vss rppd w=1u l=50u b=0 m=1
.ends g1_bgr
.subckt sg13g2_tiehi L_HI VDD VSS
XMN1 net3 net2 VSS VSS sg13_lv_nmos m=1 w=795.00n l=130.00n ng=1
XMN0 net1 net1 VSS VSS sg13_lv_nmos m=1 w=300n l=130.00n ng=1
XMP1 L_HI net3 VDD VDD sg13_lv_pmos m=1 w=1.155u l=130.00n ng=1
XMP0 net2 net1 VDD VDD sg13_lv_pmos m=1 w=660.0n l=130.00n ng=1
.ends sg13g2_tiehi
.subckt g1_dose_macro D_ELT D_STD G_SHARED vss
XMHV D_ELT G_SHARED vss vss sg13_hv_nmos w=3.98u l=0.45u ng=1 m=1
XMLV D_STD G_SHARED vss vss sg13_lv_nmos w=3.98u l=0.13u ng=1 m=1
.ends g1_dose_macro
.subckt g1_dut_macro HBT_C HBT_B HBT_E vss
XQ1 HBT_C HBT_B HBT_E vss npn13G2 le=900e-9 we=70.0n Nx=1
.ends g1_dut_macro
.subckt g1_lv_nand2 a b y vdd vss
XMMP1 y a vdd vdd sg13_lv_pmos w=2u l=0.13u m=1
XMMP2 y b vdd vdd sg13_lv_pmos w=2u l=0.13u m=1
XMMN1 y a m vss sg13_lv_nmos w=2u l=0.13u m=1
XMMN2 m b vss vss sg13_lv_nmos w=2u l=0.13u m=1
.ends g1_lv_nand2
.subckt g1_lv_inv a y vdd vss
XMMP y a vdd vdd sg13_lv_pmos w=2u l=0.13u m=1
XMMN y a vss vss sg13_lv_nmos w=1u l=0.13u m=1
.ends g1_lv_inv
.subckt g1_hv_inv a y vdda vss
XMMP y a vdda vdda sg13_hv_pmos w=3.9u l=0.45u m=1
XMMN y a vss vss sg13_hv_nmos w=1.9u l=0.45u m=1
.ends g1_hv_inv
.subckt g1_lvlup a y vdd vdda vss
XI a ab vdd vss g1_lv_inv
XMMN1 nb a vss vss sg13_hv_nmos w=1.9u l=0.45u m=1
XMMN2 n ab vss vss sg13_hv_nmos w=1.9u l=0.45u m=1
XMMP1 nb n vdda vdda sg13_hv_pmos w=0.3u l=0.45u m=1
XMMP2 n nb vdda vdda sg13_hv_pmos w=0.3u l=0.45u m=1
XO nb y vdda vss g1_hv_inv
.ends g1_lvlup
.subckt g1_hv_nor2 a b y vdda vss
XMMP1 m a vdda vdda sg13_hv_pmos w=7.8u l=0.45u m=1
XMMP2 y b m vdda sg13_hv_pmos w=7.8u l=0.45u m=1
XMMN1 y a vss vss sg13_hv_nmos w=1.9u l=0.45u m=1
XMMN2 y b vss vss sg13_hv_nmos w=1.9u l=0.45u m=1
.ends g1_hv_nor2
.subckt g1_lvldn a ab y vdd vss
XMMN1 yb a vss vss sg13_hv_nmos w=2u l=0.45u m=1
XMMN2 y ab vss vss sg13_hv_nmos w=2u l=0.45u m=1
XMMP1 y yb vdd vdd sg13_lv_pmos w=1u l=0.13u m=1
XMMP2 yb y vdd vdd sg13_lv_pmos w=1u l=0.13u m=1
.ends g1_lvldn
.subckt g1_gate trip_d clr_d fast_en hard_cmp en_core gate_core fault_core tripped vdd vdda vss
XNA hard_cmp fast_en fast_n vdd vss g1_lv_nand2
XIA fast_n fast vdd vss g1_lv_inv
XU0 fast fast_h vdd vdda vss g1_lvlup
XU1 trip_d trip_h vdd vdda vss g1_lvlup
XU2 clr_d clr_h vdd vdda vss g1_lvlup
XU3 en_core en_h vdd vdda vss g1_lvlup
XN1 fast_h trip_h set_n vdda vss g1_hv_nor2
XI1 set_n set vdda vss g1_hv_inv
XI2 en_h en_hn vdda vss g1_hv_inv
XN2 en_hn clr_h rst_n vdda vss g1_hv_nor2
XI3 rst_n rst vdda vss g1_hv_inv
XL1 rst qb q vdda vss g1_hv_nor2
XL2 set q qb vdda vss g1_hv_nor2
XG en_hn q gate_h vdda vss g1_hv_nor2
XGI gate_h gate_hn vdda vss g1_hv_inv
XD1 gate_h gate_hn gate_core vdd vss g1_lvldn
XD2 qb q fault_core vdd vss g1_lvldn
XD3 q qb tripped vdd vss g1_lvldn
.ends g1_gate
.subckt g1_ls_up in out vdd vdda vss
XMPI inb in vdd vdd sg13_lv_pmos w=2u l=0.13u ng=1 m=1
XMNI inb in vss vss sg13_lv_nmos w=1u l=0.13u ng=1 m=1
XMN1 nb in vss vss sg13_hv_nmos w=3.8u l=0.45u ng=1 m=1
XMN2 n inb vss vss sg13_hv_nmos w=3.8u l=0.45u ng=1 m=1
XMP1 nb n vdda vdda sg13_hv_pmos w=0.3u l=0.45u ng=1 m=1
XMP2 n nb vdda vdda sg13_hv_pmos w=0.3u l=0.45u ng=1 m=1
XMPO out nb vdda vdda sg13_hv_pmos w=3.9u l=0.45u ng=1 m=1
XMNO out nb vss vss sg13_hv_nmos w=1.9u l=0.45u ng=1 m=1
.ends g1_ls_up
.subckt g1_ota_main_candidate inp inn vbn out vdd vss
XMMB2 vbp vbn vss vss sg13_hv_nmos w=8u l=1u m=1
XMMB3 vbp vbp vdd vdd sg13_hv_pmos w=16u l=1u m=1
XMMB5 vbnc vbp vdd vdd sg13_hv_pmos w=16u l=1u m=1
XMMB4 vbnc vbnc vss vss sg13_hv_nmos w=1.6u l=1u m=1
XMMB6 vbpc vbn vss vss sg13_hv_nmos w=8u l=1u m=1
XMMB7 vbpc vbpc vdd vdd sg13_hv_pmos w=3.2u l=1u m=1
XMMT tail vbp vdd vdd sg13_hv_pmos w=128u l=1u m=1
XMM1 fn inn tail vdd sg13_hv_pmos w=384u l=2u m=1
XMM2 fp inp tail vdd sg13_hv_pmos w=384u l=2u m=1
XMM3 fn vbn vss vss sg13_hv_nmos w=320u l=4u m=1
XMM4 fp vbn vss vss sg13_hv_nmos w=320u l=4u m=1
XMM13 mir vbnc fn vss sg13_hv_nmos w=48u l=1u m=1
XMM16 out1 vbnc fp vss sg13_hv_nmos w=48u l=1u m=1
XMM14 pc1 mir vdd vdd sg13_hv_pmos w=384u l=4u m=1
XMM11 pc2 mir vdd vdd sg13_hv_pmos w=384u l=4u m=1
XMM15 mir vbpc pc1 vdd sg13_hv_pmos w=384u l=4u m=1
XMM12 out1 vbpc pc2 vdd sg13_hv_pmos w=384u l=4u m=1
XMM20 out out1 vdd vdd sg13_hv_pmos w=192u l=1u m=1
XMM21 out vbn vss vss sg13_hv_nmos w=96u l=1u m=1
XRRZ out1 cz vss rppd w=1u l=100u m=1 b=0
XCCC cz out cap_cmim w=45u l=23u m=1
.ends g1_ota_main_candidate
.subckt g1_ota inp inn vbn out vdd vss
XMMB2 vbp vbn vss vss sg13_hv_nmos w=8u l=1u m=1
XMMB3 vbp vbp vdd vdd sg13_hv_pmos w=16u l=1u m=1
XMMB5 vbnc vbp vdd vdd sg13_hv_pmos w=16u l=1u m=1
XMMB4 vbnc vbnc vss vss sg13_hv_nmos w=1.6u l=1u m=1
XMMB6 vbpc vbn vss vss sg13_hv_nmos w=8u l=1u m=1
XMMB7 vbpc vbpc vdd vdd sg13_hv_pmos w=3.2u l=1u m=1
XMMT tail vbp vdd vdd sg13_hv_pmos w=128u l=1u m=1
XMM1 fn inn tail vdd sg13_hv_pmos w=96u l=2u m=1
XMM2 fp inp tail vdd sg13_hv_pmos w=96u l=2u m=1
XMM3 fn vbn vss vss sg13_hv_nmos w=80u l=1u m=1
XMM4 fp vbn vss vss sg13_hv_nmos w=80u l=1u m=1
XMM13 mir vbnc fn vss sg13_hv_nmos w=48u l=1u m=1
XMM16 out1 vbnc fp vss sg13_hv_nmos w=48u l=1u m=1
XMM14 pc1 mir vdd vdd sg13_hv_pmos w=96u l=1u m=1
XMM11 pc2 mir vdd vdd sg13_hv_pmos w=96u l=1u m=1
XMM15 mir vbpc pc1 vdd sg13_hv_pmos w=96u l=1u m=1
XMM12 out1 vbpc pc2 vdd sg13_hv_pmos w=96u l=1u m=1
XMM20 out out1 vdd vdd sg13_hv_pmos w=192u l=1u m=1
XMM21 out vbn vss vss sg13_hv_nmos w=96u l=1u m=1
XRRZ out1 cz vss rppd w=1u l=6.2u m=1 b=0
XCCC cz out cap_cmim w=23u l=23u m=1
.ends g1_ota
.subckt g1_sense sense_p sense_n vref iptat isense vped vref_buf vdd vss
XRR1N0 sense_n vn vss rppd w=2u l=76.7u m=1 b=0
XRR2N0 vn R2N_0 vss rppd w=2u l=76.7u m=1 b=0
XRR2N1 R2N_0 R2N_1 vss rppd w=2u l=76.7u m=1 b=0
XRR2N2 R2N_1 R2N_2 vss rppd w=2u l=76.7u m=1 b=0
XRR2N3 R2N_2 R2N_3 vss rppd w=2u l=76.7u m=1 b=0
XRR2N4 R2N_3 R2N_4 vss rppd w=2u l=76.7u m=1 b=0
XRR2N5 R2N_4 R2N_5 vss rppd w=2u l=76.7u m=1 b=0
XRR2N6 R2N_5 R2N_6 vss rppd w=2u l=76.7u m=1 b=0
XRR2N7 R2N_6 R2N_7 vss rppd w=2u l=76.7u m=1 b=0
XRR2N8 R2N_7 R2N_8 vss rppd w=2u l=76.7u m=1 b=0
XRR2N9 R2N_8 R2N_9 vss rppd w=2u l=76.7u m=1 b=0
XRR2N10 R2N_9 R2N_10 vss rppd w=2u l=76.7u m=1 b=0
XRR2N11 R2N_10 R2N_11 vss rppd w=2u l=76.7u m=1 b=0
XRR2N12 R2N_11 R2N_12 vss rppd w=2u l=76.7u m=1 b=0
XRR2N13 R2N_12 R2N_13 vss rppd w=2u l=76.7u m=1 b=0
XRR2N14 R2N_13 R2N_14 vss rppd w=2u l=76.7u m=1 b=0
XRR2N15 R2N_14 R2N_15 vss rppd w=2u l=76.7u m=1 b=0
XRR2N16 R2N_15 R2N_16 vss rppd w=2u l=76.7u m=1 b=0
XRR2N17 R2N_16 R2N_17 vss rppd w=2u l=76.7u m=1 b=0
XRR2N18 R2N_17 R2N_18 vss rppd w=2u l=76.7u m=1 b=0
XRR2N19 R2N_18 isense vss rppd w=2u l=76.7u m=1 b=0
XRR1P0 sense_p vp vss rppd w=2u l=76.7u m=1 b=0
XRR2P0 vp R2P_0 vss rppd w=2u l=76.7u m=1 b=0
XRR2P1 R2P_0 R2P_1 vss rppd w=2u l=76.7u m=1 b=0
XRR2P2 R2P_1 R2P_2 vss rppd w=2u l=76.7u m=1 b=0
XRR2P3 R2P_2 R2P_3 vss rppd w=2u l=76.7u m=1 b=0
XRR2P4 R2P_3 R2P_4 vss rppd w=2u l=76.7u m=1 b=0
XRR2P5 R2P_4 R2P_5 vss rppd w=2u l=76.7u m=1 b=0
XRR2P6 R2P_5 R2P_6 vss rppd w=2u l=76.7u m=1 b=0
XRR2P7 R2P_6 R2P_7 vss rppd w=2u l=76.7u m=1 b=0
XRR2P8 R2P_7 R2P_8 vss rppd w=2u l=76.7u m=1 b=0
XRR2P9 R2P_8 R2P_9 vss rppd w=2u l=76.7u m=1 b=0
XRR2P10 R2P_9 R2P_10 vss rppd w=2u l=76.7u m=1 b=0
XRR2P11 R2P_10 R2P_11 vss rppd w=2u l=76.7u m=1 b=0
XRR2P12 R2P_11 R2P_12 vss rppd w=2u l=76.7u m=1 b=0
XRR2P13 R2P_12 R2P_13 vss rppd w=2u l=76.7u m=1 b=0
XRR2P14 R2P_13 R2P_14 vss rppd w=2u l=76.7u m=1 b=0
XRR2P15 R2P_14 R2P_15 vss rppd w=2u l=76.7u m=1 b=0
XRR2P16 R2P_15 R2P_16 vss rppd w=2u l=76.7u m=1 b=0
XRR2P17 R2P_16 R2P_17 vss rppd w=2u l=76.7u m=1 b=0
XRR2P18 R2P_17 R2P_18 vss rppd w=2u l=76.7u m=1 b=0
XRR2P19 R2P_18 vped vss rppd w=2u l=76.7u m=1 b=0
XRRD10 vref_buf RD1_0 vss rppd w=2u l=76.7u m=1 b=0
XRRD11 RD1_0 vped_ref vss rppd w=2u l=76.7u m=1 b=0
XRRD20 vped_ref RD2_0 vss rppd w=2u l=76.7u m=1 b=0
XRRD21 RD2_0 RD2_1 vss rppd w=2u l=76.7u m=1 b=0
XRRD22 RD2_1 RD2_2 vss rppd w=2u l=76.7u m=1 b=0
XRRD23 RD2_2 RD2_3 vss rppd w=2u l=76.7u m=1 b=0
XRRD24 RD2_3 RD2_4 vss rppd w=2u l=76.7u m=1 b=0
XRRD25 RD2_4 RD2_5 vss rppd w=2u l=76.7u m=1 b=0
XRRD26 RD2_5 RD2_6 vss rppd w=2u l=76.7u m=1 b=0
XRRD27 RD2_6 RD2_7 vss rppd w=2u l=76.7u m=1 b=0
XRRD28 RD2_7 RD2_8 vss rppd w=2u l=76.7u m=1 b=0
XRRD29 RD2_8 RD2_9 vss rppd w=2u l=76.7u m=1 b=0
XRRD210 RD2_9 RD2_10 vss rppd w=2u l=76.7u m=1 b=0
XRRD211 RD2_10 RD2_11 vss rppd w=2u l=76.7u m=1 b=0
XRRD212 RD2_11 RD2_12 vss rppd w=2u l=76.7u m=1 b=0
XRRD213 RD2_12 RD2_13 vss rppd w=2u l=76.7u m=1 b=0
XRRD214 RD2_13 RD2_14 vss rppd w=2u l=76.7u m=1 b=0
XRRD215 RD2_14 RD2_15 vss rppd w=2u l=76.7u m=1 b=0
XRRD216 RD2_15 RD2_16 vss rppd w=2u l=76.7u m=1 b=0
XRRD217 RD2_16 RD2_17 vss rppd w=2u l=76.7u m=1 b=0
XRRD218 RD2_17 RD2_18 vss rppd w=2u l=76.7u m=1 b=0
XRRD219 RD2_18 RD2_19 vss rppd w=2u l=76.7u m=1 b=0
XRRD220 RD2_19 RD2_20 vss rppd w=2u l=76.7u m=1 b=0
XRRD221 RD2_20 RD2_21 vss rppd w=2u l=76.7u m=1 b=0
XRRD222 RD2_21 RD2_22 vss rppd w=2u l=76.7u m=1 b=0
XRRD223 RD2_22 RD2_23 vss rppd w=2u l=76.7u m=1 b=0
XRRD224 RD2_23 RD2_24 vss rppd w=2u l=76.7u m=1 b=0
XRRD225 RD2_24 RD2_25 vss rppd w=2u l=76.7u m=1 b=0
XRRD226 RD2_25 RD2_26 vss rppd w=2u l=76.7u m=1 b=0
XRRD227 RD2_26 RD2_27 vss rppd w=2u l=76.7u m=1 b=0
XRRD228 RD2_27 RD2_28 vss rppd w=2u l=76.7u m=1 b=0
XRRD229 RD2_28 RD2_29 vss rppd w=2u l=76.7u m=1 b=0
XRRD230 RD2_29 RD2_30 vss rppd w=2u l=76.7u m=1 b=0
XRRD231 RD2_30 RD2_31 vss rppd w=2u l=76.7u m=1 b=0
XRRD232 RD2_31 RD2_32 vss rppd w=2u l=76.7u m=1 b=0
XRRD233 RD2_32 RD2_33 vss rppd w=2u l=76.7u m=1 b=0
XRRD234 RD2_33 RD2_34 vss rppd w=2u l=76.7u m=1 b=0
XRRD235 RD2_34 RD2_35 vss rppd w=2u l=76.7u m=1 b=0
XRRD236 RD2_35 RD2_36 vss rppd w=2u l=76.7u m=1 b=0
XRRD237 RD2_36 RD2_37 vss rppd w=2u l=76.7u m=1 b=0
XRRD238 RD2_37 RD2_38 vss rppd w=2u l=76.7u m=1 b=0
XRRD239 RD2_38 RD2_39 vss rppd w=2u l=76.7u m=1 b=0
XRRD240 RD2_39 RD2_40 vss rppd w=2u l=76.7u m=1 b=0
XRRD241 RD2_40 RD2_41 vss rppd w=2u l=76.7u m=1 b=0
XRRD242 RD2_41 RD2_42 vss rppd w=2u l=76.7u m=1 b=0
XRRD243 RD2_42 RD2_43 vss rppd w=2u l=76.7u m=1 b=0
XRRD244 RD2_43 RD2_44 vss rppd w=2u l=76.7u m=1 b=0
XRRD245 RD2_44 RD2_45 vss rppd w=2u l=76.7u m=1 b=0
XRRD246 RD2_45 RD2_46 vss rppd w=2u l=76.7u m=1 b=0
XRRD247 RD2_46 RD2_47 vss rppd w=2u l=76.7u m=1 b=0
XRRD248 RD2_47 RD2_48 vss rppd w=2u l=76.7u m=1 b=0
XRRD249 RD2_48 RD2_49 vss rppd w=2u l=76.7u m=1 b=0
XRRD250 RD2_49 vss vss rppd w=2u l=76.7u m=1 b=0
XMMBI iptat iptat vss vss sg13_hv_nmos w=3.3u l=1u m=1
XOTA vp vn iptat isense vdd vss g1_ota_main_candidate
XBUF vped_ref vped iptat vped vdd vss g1_ota
XREF vref vref_buf iptat vref_buf vdd vss g1_ota
.ends g1_sense
.subckt g1_t2f vdd vdd12 vss pbias pcasc vref en mode fout
XMMPO do pbias vdd vdd sg13_hv_pmos w=10u l=4u ng=1 m=1
XMMCO isrc pcasc do do sg13_hv_pmos w=10u l=4u ng=1 m=1
XMMPR dr pbias vdd vdd sg13_hv_pmos w=10u l=4u ng=1 m=2
XMMCR vr pcasc dr dr sg13_hv_pmos w=10u l=4u ng=1 m=2
XRRREF1 vr vr_1 vss rppd w=0.5u l=24.5u m=1 b=0
XRRREF2 vr_1 vr_2 vss rppd w=0.5u l=24.5u m=1 b=0
XRRREF3 vr_2 vr_3 vss rppd w=0.5u l=24.5u m=1 b=0
XRRREF4 vr_3 vr_4 vss rppd w=0.5u l=24.5u m=1 b=0
XRRREF5 vr_4 vr_5 vss rppd w=0.5u l=24.5u m=1 b=0
XRRREF6 vr_5 vr_6 vss rppd w=0.5u l=24.5u m=1 b=0
XRRREF7 vr_6 vr_7 vss rppd w=0.5u l=24.5u m=1 b=0
XRRREF8 vr_7 vr_8 vss rppd w=0.5u l=24.5u m=1 b=0
XRRREF9 vr_8 vr_9 vss rppd w=0.5u l=24.5u m=1 b=0
XRRREF10 vr_9 vss vss rppd w=0.5u l=24.5u m=1 b=0
XMMPB db pbias vdd vdd sg13_hv_pmos w=10u l=4u ng=1 m=1
XMMCB nbias pcasc db db sg13_hv_pmos w=10u l=4u ng=1 m=1
XMMNB nbias nbias vss vss sg13_hv_nmos w=10u l=2u ng=1 m=1
XMMPF vcg pbias vdd vdd sg13_hv_pmos w=10u l=4u ng=1 m=1
XMMSF vss vth vcg vcg sg13_hv_pmos w=2u l=2u ng=1 m=1
XMMX1 vref moden vth vss sg13_hv_nmos w=4u l=0.5u ng=1 m=1
XMMX2 vr mode vth vss sg13_hv_nmos w=4u l=0.5u ng=1 m=1
XMIMN moden mode vss vss sg13_hv_nmos w=1u l=0.5u ng=1 m=1
XMIMP moden mode vdd vdd sg13_hv_pmos w=2u l=0.5u ng=1 m=1
XQQA1 ca1 vth tail1 vss npn13G2 le=900n we=70n Nx=1
XQQB1 cb1 cap1 tail1 vss npn13G2 le=900n we=70n Nx=1
XMMCA1 oa1 vcg ca1 vss sg13_hv_nmos w=4u l=1u ng=1 m=1
XMMCB1 ob1 vcg cb1 vss sg13_hv_nmos w=4u l=1u ng=1 m=1
XMMBA1 ca1 nbias vss vss sg13_hv_nmos w=0.5u l=2u ng=1 m=1
XMMBB1 cb1 nbias vss vss sg13_hv_nmos w=0.5u l=2u ng=1 m=1
XMMLA1 oa1 oa1 vdd vdd sg13_hv_pmos w=4u l=1u ng=1 m=1
XMMLB1 ob1 oa1 vdd vdd sg13_hv_pmos w=4u l=1u ng=1 m=1
XMMT1 tail1 nbias vss vss sg13_hv_nmos w=20u l=2u ng=1 m=1
XMIC1AN c1 ob1 vss vss sg13_hv_nmos w=1u l=0.5u ng=1 m=1
XMIC1AP c1 ob1 vdd vdd sg13_hv_pmos w=2u l=0.5u ng=1 m=1
XMIC1BN sn c1 vss vss sg13_hv_nmos w=2u l=0.5u ng=1 m=1
XMIC1BP sn c1 vdd vdd sg13_hv_pmos w=4u l=0.5u ng=1 m=1
XQQA2 ca2 vth tail2 vss npn13G2 le=900n we=70n Nx=1
XQQB2 cb2 cap2 tail2 vss npn13G2 le=900n we=70n Nx=1
XMMCA2 oa2 vcg ca2 vss sg13_hv_nmos w=4u l=1u ng=1 m=1
XMMCB2 ob2 vcg cb2 vss sg13_hv_nmos w=4u l=1u ng=1 m=1
XMMBA2 ca2 nbias vss vss sg13_hv_nmos w=0.5u l=2u ng=1 m=1
XMMBB2 cb2 nbias vss vss sg13_hv_nmos w=0.5u l=2u ng=1 m=1
XMMLA2 oa2 oa2 vdd vdd sg13_hv_pmos w=4u l=1u ng=1 m=1
XMMLB2 ob2 oa2 vdd vdd sg13_hv_pmos w=4u l=1u ng=1 m=1
XMMT2 tail2 nbias vss vss sg13_hv_nmos w=20u l=2u ng=1 m=1
XMIC2AN c2 ob2 vss vss sg13_hv_nmos w=1u l=0.5u ng=1 m=1
XMIC2AP c2 ob2 vdd vdd sg13_hv_pmos w=2u l=0.5u ng=1 m=1
XMIC2BN rn c2 vss vss sg13_hv_nmos w=2u l=0.5u ng=1 m=1
XMIC2BP rn c2 vdd vdd sg13_hv_pmos w=4u l=0.5u ng=1 m=1
XMNQPA q sn vdd vdd sg13_hv_pmos w=2u l=0.5u ng=1 m=1
XMNQPB q qn vdd vdd sg13_hv_pmos w=2u l=0.5u ng=1 m=1
XMNQNA q sn NQ_i vss sg13_hv_nmos w=2u l=0.5u ng=1 m=1
XMNQNB NQ_i qn vss vss sg13_hv_nmos w=2u l=0.5u ng=1 m=1
XMNQNPA qn rn vdd vdd sg13_hv_pmos w=2u l=0.5u ng=1 m=1
XMNQNPB qn q vdd vdd sg13_hv_pmos w=2u l=0.5u ng=1 m=1
XMNQNPC qn en vdd vdd sg13_hv_pmos w=2u l=0.5u ng=1 m=1
XMNQNNA qn rn NQN_i vss sg13_hv_nmos w=3u l=0.5u ng=1 m=1
XMNQNNB NQN_i q NQN_j vss sg13_hv_nmos w=3u l=0.5u ng=1 m=1
XMNQNNC NQN_j en vss vss sg13_hv_nmos w=3u l=0.5u ng=1 m=1
XMND1PA d1g qn vdd vdd sg13_hv_pmos w=2u l=0.5u ng=1 m=1
XMND1PB d1g en vdd vdd sg13_hv_pmos w=2u l=0.5u ng=1 m=1
XMND1NA d1g qn ND1_i vss sg13_hv_nmos w=2u l=0.5u ng=1 m=1
XMND1NB ND1_i en vss vss sg13_hv_nmos w=2u l=0.5u ng=1 m=1
XMND2PA d2g q vdd vdd sg13_hv_pmos w=2u l=0.5u ng=1 m=1
XMND2PB d2g en vdd vdd sg13_hv_pmos w=2u l=0.5u ng=1 m=1
XMND2NA d2g q ND2_i vss sg13_hv_nmos w=2u l=0.5u ng=1 m=1
XMND2NB ND2_i en vss vss sg13_hv_nmos w=2u l=0.5u ng=1 m=1
XMSW1 cap1 d1g isrc vdd sg13_hv_pmos w=4u l=0.5u ng=1 m=1
XMD1 cap1 d1g vss vss sg13_hv_nmos w=4u l=0.5u ng=1 m=1
XMSW2 cap2 d2g isrc vdd sg13_hv_pmos w=4u l=0.5u ng=1 m=1
XMD2 cap2 d2g vss vss sg13_hv_nmos w=4u l=0.5u ng=1 m=1
XCC1 cap1 vss cap_cmim w=28u l=28u m=1
XCC2 cap2 vss cap_cmim w=28u l=28u m=1
XMIAN a d2g vss vss sg13_hv_nmos w=1u l=0.5u ng=1 m=1
XMIAP a d2g vdd vdd sg13_hv_pmos w=2u l=0.5u ng=1 m=1
XMMLSA lsa a vss vss sg13_hv_nmos w=2u l=0.5u ng=1 m=1
XMMLSB lsb d2g vss vss sg13_hv_nmos w=2u l=0.5u ng=1 m=1
XMMLPA lsa lsb vdd12 vdd12 sg13_lv_pmos w=0.5u l=0.3u ng=1 m=1
XMMLPB lsb lsa vdd12 vdd12 sg13_lv_pmos w=0.5u l=0.3u ng=1 m=1
XMIO1N fon lsb vss vss sg13_lv_nmos w=0.5u l=0.13u ng=1 m=1
XMIO1P fon lsb vdd12 vdd12 sg13_lv_pmos w=1u l=0.13u ng=1 m=1
XMIO2N fout fon vss vss sg13_lv_nmos w=1u l=0.13u ng=1 m=1
XMIO2P fout fon vdd12 vdd12 sg13_lv_pmos w=2u l=0.13u ng=1 m=1
XQQD1 vss vss vss vss npn13G2 le=900n we=70n Nx=1
XQQD2 vss vss vss vss npn13G2 le=900n we=70n Nx=1
.ends g1_t2f
.subckt g1_cond isense icmp vss
XRRC0 isense c0 vss rppd w=2u l=76.7u b=0 m=1
XRRC1 c0 c1 vss rppd w=2u l=76.7u b=0 m=1
XRRC2 c1 c2 vss rppd w=2u l=76.7u b=0 m=1
XRRC3 c2 c3 vss rppd w=2u l=76.7u b=0 m=1
XRRC4 c3 icmp vss rppd w=2u l=76.7u b=0 m=1
XRRC5 icmp c5 vss rppd w=2u l=76.7u b=0 m=1
XRRC6 c5 c6 vss rppd w=2u l=76.7u b=0 m=1
XRRC7 c6 c7 vss rppd w=2u l=76.7u b=0 m=1
XRRC8 c7 c8 vss rppd w=2u l=76.7u b=0 m=1
XRRC9 c8 vss vss rppd w=2u l=76.7u b=0 m=1
XCCH icmp vss cap_cmim w=26u l=26u m=1
.ends g1_cond
.subckt g1_inv a y vdd vss
XMMP y a vdd vdd sg13_lv_pmos w=1u l=0.13u m=1
XMMN y a vss vss sg13_lv_nmos w=0.5u l=0.13u m=1
.ends g1_inv
.subckt g1_thv_inv a y vdda vss
XMMP y a vdda vdda sg13_hv_pmos w=3.9u l=0.45u m=1
XMMN y a vss vss sg13_hv_nmos w=1.9u l=0.45u m=1
.ends g1_thv_inv
.subckt g1_tlvlup a y yb vdd vdda vss
XI a ab vdd vss g1_inv
XMMN1 nb a vss vss sg13_hv_nmos w=1.9u l=0.45u m=1
XMMN2 n ab vss vss sg13_hv_nmos w=1.9u l=0.45u m=1
XMMP1 nb n vdda vdda sg13_hv_pmos w=0.3u l=0.45u m=1
XMMP2 n nb vdda vdda sg13_hv_pmos w=0.3u l=0.45u m=1
XO nb y vdda vss g1_thv_inv
XOB y yb vdda vss g1_thv_inv
.ends g1_tlvlup
.subckt g1_dac8 vref d0 d1 d2 d3 d4 d5 d6 d7 out vdd vdda vss
XRRU0 s0 vss vss rppd w=4u l=1.2u b=0 m=1
XRRU1 s1 s0 vss rppd w=4u l=1.2u b=0 m=1
XRRU2 s2 s1 vss rppd w=4u l=1.2u b=0 m=1
XRRU3 s3 s2 vss rppd w=4u l=1.2u b=0 m=1
XRRU4 s4 s3 vss rppd w=4u l=1.2u b=0 m=1
XRRU5 s5 s4 vss rppd w=4u l=1.2u b=0 m=1
XRRU6 s6 s5 vss rppd w=4u l=1.2u b=0 m=1
XRRU7 s7 s6 vss rppd w=4u l=1.2u b=0 m=1
XRRU8 s8 s7 vss rppd w=4u l=1.2u b=0 m=1
XRRU9 s9 s8 vss rppd w=4u l=1.2u b=0 m=1
XRRU10 s10 s9 vss rppd w=4u l=1.2u b=0 m=1
XRRU11 s11 s10 vss rppd w=4u l=1.2u b=0 m=1
XRRU12 s12 s11 vss rppd w=4u l=1.2u b=0 m=1
XRRU13 s13 s12 vss rppd w=4u l=1.2u b=0 m=1
XRRU14 s14 s13 vss rppd w=4u l=1.2u b=0 m=1
XRRU15 s15 s14 vss rppd w=4u l=1.2u b=0 m=1
XRRU16 s16 s15 vss rppd w=4u l=1.2u b=0 m=1
XRRU17 s17 s16 vss rppd w=4u l=1.2u b=0 m=1
XRRU18 s18 s17 vss rppd w=4u l=1.2u b=0 m=1
XRRU19 s19 s18 vss rppd w=4u l=1.2u b=0 m=1
XRRU20 s20 s19 vss rppd w=4u l=1.2u b=0 m=1
XRRU21 s21 s20 vss rppd w=4u l=1.2u b=0 m=1
XRRU22 s22 s21 vss rppd w=4u l=1.2u b=0 m=1
XRRU23 s23 s22 vss rppd w=4u l=1.2u b=0 m=1
XRRU24 s24 s23 vss rppd w=4u l=1.2u b=0 m=1
XRRU25 s25 s24 vss rppd w=4u l=1.2u b=0 m=1
XRRU26 s26 s25 vss rppd w=4u l=1.2u b=0 m=1
XRRU27 s27 s26 vss rppd w=4u l=1.2u b=0 m=1
XRRU28 s28 s27 vss rppd w=4u l=1.2u b=0 m=1
XRRU29 s29 s28 vss rppd w=4u l=1.2u b=0 m=1
XRRU30 s30 s29 vss rppd w=4u l=1.2u b=0 m=1
XRRU31 s31 s30 vss rppd w=4u l=1.2u b=0 m=1
XRRU32 s32 s31 vss rppd w=4u l=1.2u b=0 m=1
XRRU33 s33 s32 vss rppd w=4u l=1.2u b=0 m=1
XRRU34 s34 s33 vss rppd w=4u l=1.2u b=0 m=1
XRRU35 s35 s34 vss rppd w=4u l=1.2u b=0 m=1
XRRU36 s36 s35 vss rppd w=4u l=1.2u b=0 m=1
XRRU37 s37 s36 vss rppd w=4u l=1.2u b=0 m=1
XRRU38 s38 s37 vss rppd w=4u l=1.2u b=0 m=1
XRRU39 s39 s38 vss rppd w=4u l=1.2u b=0 m=1
XRRU40 s40 s39 vss rppd w=4u l=1.2u b=0 m=1
XRRU41 s41 s40 vss rppd w=4u l=1.2u b=0 m=1
XRRU42 s42 s41 vss rppd w=4u l=1.2u b=0 m=1
XRRU43 s43 s42 vss rppd w=4u l=1.2u b=0 m=1
XRRU44 s44 s43 vss rppd w=4u l=1.2u b=0 m=1
XRRU45 s45 s44 vss rppd w=4u l=1.2u b=0 m=1
XRRU46 s46 s45 vss rppd w=4u l=1.2u b=0 m=1
XRRU47 s47 s46 vss rppd w=4u l=1.2u b=0 m=1
XRRU48 s48 s47 vss rppd w=4u l=1.2u b=0 m=1
XRRU49 s49 s48 vss rppd w=4u l=1.2u b=0 m=1
XRRU50 s50 s49 vss rppd w=4u l=1.2u b=0 m=1
XRRU51 s51 s50 vss rppd w=4u l=1.2u b=0 m=1
XRRU52 s52 s51 vss rppd w=4u l=1.2u b=0 m=1
XRRU53 s53 s52 vss rppd w=4u l=1.2u b=0 m=1
XRRU54 s54 s53 vss rppd w=4u l=1.2u b=0 m=1
XRRU55 s55 s54 vss rppd w=4u l=1.2u b=0 m=1
XRRU56 s56 s55 vss rppd w=4u l=1.2u b=0 m=1
XRRU57 s57 s56 vss rppd w=4u l=1.2u b=0 m=1
XRRU58 s58 s57 vss rppd w=4u l=1.2u b=0 m=1
XRRU59 s59 s58 vss rppd w=4u l=1.2u b=0 m=1
XRRU60 s60 s59 vss rppd w=4u l=1.2u b=0 m=1
XRRU61 s61 s60 vss rppd w=4u l=1.2u b=0 m=1
XRRU62 s62 s61 vss rppd w=4u l=1.2u b=0 m=1
XRRU63 s63 s62 vss rppd w=4u l=1.2u b=0 m=1
XRRU64 s64 s63 vss rppd w=4u l=1.2u b=0 m=1
XRRU65 s65 s64 vss rppd w=4u l=1.2u b=0 m=1
XRRU66 s66 s65 vss rppd w=4u l=1.2u b=0 m=1
XRRU67 s67 s66 vss rppd w=4u l=1.2u b=0 m=1
XRRU68 s68 s67 vss rppd w=4u l=1.2u b=0 m=1
XRRU69 s69 s68 vss rppd w=4u l=1.2u b=0 m=1
XRRU70 s70 s69 vss rppd w=4u l=1.2u b=0 m=1
XRRU71 s71 s70 vss rppd w=4u l=1.2u b=0 m=1
XRRU72 s72 s71 vss rppd w=4u l=1.2u b=0 m=1
XRRU73 s73 s72 vss rppd w=4u l=1.2u b=0 m=1
XRRU74 s74 s73 vss rppd w=4u l=1.2u b=0 m=1
XRRU75 s75 s74 vss rppd w=4u l=1.2u b=0 m=1
XRRU76 s76 s75 vss rppd w=4u l=1.2u b=0 m=1
XRRU77 s77 s76 vss rppd w=4u l=1.2u b=0 m=1
XRRU78 s78 s77 vss rppd w=4u l=1.2u b=0 m=1
XRRU79 s79 s78 vss rppd w=4u l=1.2u b=0 m=1
XRRU80 s80 s79 vss rppd w=4u l=1.2u b=0 m=1
XRRU81 s81 s80 vss rppd w=4u l=1.2u b=0 m=1
XRRU82 s82 s81 vss rppd w=4u l=1.2u b=0 m=1
XRRU83 s83 s82 vss rppd w=4u l=1.2u b=0 m=1
XRRU84 s84 s83 vss rppd w=4u l=1.2u b=0 m=1
XRRU85 s85 s84 vss rppd w=4u l=1.2u b=0 m=1
XRRU86 s86 s85 vss rppd w=4u l=1.2u b=0 m=1
XRRU87 s87 s86 vss rppd w=4u l=1.2u b=0 m=1
XRRU88 s88 s87 vss rppd w=4u l=1.2u b=0 m=1
XRRU89 s89 s88 vss rppd w=4u l=1.2u b=0 m=1
XRRU90 s90 s89 vss rppd w=4u l=1.2u b=0 m=1
XRRU91 s91 s90 vss rppd w=4u l=1.2u b=0 m=1
XRRU92 s92 s91 vss rppd w=4u l=1.2u b=0 m=1
XRRU93 s93 s92 vss rppd w=4u l=1.2u b=0 m=1
XRRU94 s94 s93 vss rppd w=4u l=1.2u b=0 m=1
XRRU95 s95 s94 vss rppd w=4u l=1.2u b=0 m=1
XRRU96 s96 s95 vss rppd w=4u l=1.2u b=0 m=1
XRRU97 s97 s96 vss rppd w=4u l=1.2u b=0 m=1
XRRU98 s98 s97 vss rppd w=4u l=1.2u b=0 m=1
XRRU99 s99 s98 vss rppd w=4u l=1.2u b=0 m=1
XRRU100 s100 s99 vss rppd w=4u l=1.2u b=0 m=1
XRRU101 s101 s100 vss rppd w=4u l=1.2u b=0 m=1
XRRU102 s102 s101 vss rppd w=4u l=1.2u b=0 m=1
XRRU103 s103 s102 vss rppd w=4u l=1.2u b=0 m=1
XRRU104 s104 s103 vss rppd w=4u l=1.2u b=0 m=1
XRRU105 s105 s104 vss rppd w=4u l=1.2u b=0 m=1
XRRU106 s106 s105 vss rppd w=4u l=1.2u b=0 m=1
XRRU107 s107 s106 vss rppd w=4u l=1.2u b=0 m=1
XRRU108 s108 s107 vss rppd w=4u l=1.2u b=0 m=1
XRRU109 s109 s108 vss rppd w=4u l=1.2u b=0 m=1
XRRU110 s110 s109 vss rppd w=4u l=1.2u b=0 m=1
XRRU111 s111 s110 vss rppd w=4u l=1.2u b=0 m=1
XRRU112 s112 s111 vss rppd w=4u l=1.2u b=0 m=1
XRRU113 s113 s112 vss rppd w=4u l=1.2u b=0 m=1
XRRU114 s114 s113 vss rppd w=4u l=1.2u b=0 m=1
XRRU115 s115 s114 vss rppd w=4u l=1.2u b=0 m=1
XRRU116 s116 s115 vss rppd w=4u l=1.2u b=0 m=1
XRRU117 s117 s116 vss rppd w=4u l=1.2u b=0 m=1
XRRU118 s118 s117 vss rppd w=4u l=1.2u b=0 m=1
XRRU119 s119 s118 vss rppd w=4u l=1.2u b=0 m=1
XRRU120 s120 s119 vss rppd w=4u l=1.2u b=0 m=1
XRRU121 s121 s120 vss rppd w=4u l=1.2u b=0 m=1
XRRU122 s122 s121 vss rppd w=4u l=1.2u b=0 m=1
XRRU123 s123 s122 vss rppd w=4u l=1.2u b=0 m=1
XRRU124 s124 s123 vss rppd w=4u l=1.2u b=0 m=1
XRRU125 s125 s124 vss rppd w=4u l=1.2u b=0 m=1
XRRU126 s126 s125 vss rppd w=4u l=1.2u b=0 m=1
XRRU127 s127 s126 vss rppd w=4u l=1.2u b=0 m=1
XRRU128 s128 s127 vss rppd w=4u l=1.2u b=0 m=1
XRRU129 s129 s128 vss rppd w=4u l=1.2u b=0 m=1
XRRU130 s130 s129 vss rppd w=4u l=1.2u b=0 m=1
XRRU131 s131 s130 vss rppd w=4u l=1.2u b=0 m=1
XRRU132 s132 s131 vss rppd w=4u l=1.2u b=0 m=1
XRRU133 s133 s132 vss rppd w=4u l=1.2u b=0 m=1
XRRU134 s134 s133 vss rppd w=4u l=1.2u b=0 m=1
XRRU135 s135 s134 vss rppd w=4u l=1.2u b=0 m=1
XRRU136 s136 s135 vss rppd w=4u l=1.2u b=0 m=1
XRRU137 s137 s136 vss rppd w=4u l=1.2u b=0 m=1
XRRU138 s138 s137 vss rppd w=4u l=1.2u b=0 m=1
XRRU139 s139 s138 vss rppd w=4u l=1.2u b=0 m=1
XRRU140 s140 s139 vss rppd w=4u l=1.2u b=0 m=1
XRRU141 s141 s140 vss rppd w=4u l=1.2u b=0 m=1
XRRU142 s142 s141 vss rppd w=4u l=1.2u b=0 m=1
XRRU143 s143 s142 vss rppd w=4u l=1.2u b=0 m=1
XRRU144 s144 s143 vss rppd w=4u l=1.2u b=0 m=1
XRRU145 s145 s144 vss rppd w=4u l=1.2u b=0 m=1
XRRU146 s146 s145 vss rppd w=4u l=1.2u b=0 m=1
XRRU147 s147 s146 vss rppd w=4u l=1.2u b=0 m=1
XRRU148 s148 s147 vss rppd w=4u l=1.2u b=0 m=1
XRRU149 s149 s148 vss rppd w=4u l=1.2u b=0 m=1
XRRU150 s150 s149 vss rppd w=4u l=1.2u b=0 m=1
XRRU151 s151 s150 vss rppd w=4u l=1.2u b=0 m=1
XRRU152 s152 s151 vss rppd w=4u l=1.2u b=0 m=1
XRRU153 s153 s152 vss rppd w=4u l=1.2u b=0 m=1
XRRU154 s154 s153 vss rppd w=4u l=1.2u b=0 m=1
XRRU155 s155 s154 vss rppd w=4u l=1.2u b=0 m=1
XRRU156 s156 s155 vss rppd w=4u l=1.2u b=0 m=1
XRRU157 s157 s156 vss rppd w=4u l=1.2u b=0 m=1
XRRU158 s158 s157 vss rppd w=4u l=1.2u b=0 m=1
XRRU159 s159 s158 vss rppd w=4u l=1.2u b=0 m=1
XRRU160 s160 s159 vss rppd w=4u l=1.2u b=0 m=1
XRRU161 s161 s160 vss rppd w=4u l=1.2u b=0 m=1
XRRU162 s162 s161 vss rppd w=4u l=1.2u b=0 m=1
XRRU163 s163 s162 vss rppd w=4u l=1.2u b=0 m=1
XRRU164 s164 s163 vss rppd w=4u l=1.2u b=0 m=1
XRRU165 s165 s164 vss rppd w=4u l=1.2u b=0 m=1
XRRU166 s166 s165 vss rppd w=4u l=1.2u b=0 m=1
XRRU167 s167 s166 vss rppd w=4u l=1.2u b=0 m=1
XRRU168 s168 s167 vss rppd w=4u l=1.2u b=0 m=1
XRRU169 s169 s168 vss rppd w=4u l=1.2u b=0 m=1
XRRU170 s170 s169 vss rppd w=4u l=1.2u b=0 m=1
XRRU171 s171 s170 vss rppd w=4u l=1.2u b=0 m=1
XRRU172 s172 s171 vss rppd w=4u l=1.2u b=0 m=1
XRRU173 s173 s172 vss rppd w=4u l=1.2u b=0 m=1
XRRU174 s174 s173 vss rppd w=4u l=1.2u b=0 m=1
XRRU175 s175 s174 vss rppd w=4u l=1.2u b=0 m=1
XRRU176 s176 s175 vss rppd w=4u l=1.2u b=0 m=1
XRRU177 s177 s176 vss rppd w=4u l=1.2u b=0 m=1
XRRU178 s178 s177 vss rppd w=4u l=1.2u b=0 m=1
XRRU179 s179 s178 vss rppd w=4u l=1.2u b=0 m=1
XRRU180 s180 s179 vss rppd w=4u l=1.2u b=0 m=1
XRRU181 s181 s180 vss rppd w=4u l=1.2u b=0 m=1
XRRU182 s182 s181 vss rppd w=4u l=1.2u b=0 m=1
XRRU183 s183 s182 vss rppd w=4u l=1.2u b=0 m=1
XRRU184 s184 s183 vss rppd w=4u l=1.2u b=0 m=1
XRRU185 s185 s184 vss rppd w=4u l=1.2u b=0 m=1
XRRU186 s186 s185 vss rppd w=4u l=1.2u b=0 m=1
XRRU187 s187 s186 vss rppd w=4u l=1.2u b=0 m=1
XRRU188 s188 s187 vss rppd w=4u l=1.2u b=0 m=1
XRRU189 s189 s188 vss rppd w=4u l=1.2u b=0 m=1
XRRU190 s190 s189 vss rppd w=4u l=1.2u b=0 m=1
XRRU191 s191 s190 vss rppd w=4u l=1.2u b=0 m=1
XRRU192 s192 s191 vss rppd w=4u l=1.2u b=0 m=1
XRRU193 s193 s192 vss rppd w=4u l=1.2u b=0 m=1
XRRU194 s194 s193 vss rppd w=4u l=1.2u b=0 m=1
XRRU195 s195 s194 vss rppd w=4u l=1.2u b=0 m=1
XRRU196 s196 s195 vss rppd w=4u l=1.2u b=0 m=1
XRRU197 s197 s196 vss rppd w=4u l=1.2u b=0 m=1
XRRU198 s198 s197 vss rppd w=4u l=1.2u b=0 m=1
XRRU199 s199 s198 vss rppd w=4u l=1.2u b=0 m=1
XRRU200 s200 s199 vss rppd w=4u l=1.2u b=0 m=1
XRRU201 s201 s200 vss rppd w=4u l=1.2u b=0 m=1
XRRU202 s202 s201 vss rppd w=4u l=1.2u b=0 m=1
XRRU203 s203 s202 vss rppd w=4u l=1.2u b=0 m=1
XRRU204 s204 s203 vss rppd w=4u l=1.2u b=0 m=1
XRRU205 s205 s204 vss rppd w=4u l=1.2u b=0 m=1
XRRU206 s206 s205 vss rppd w=4u l=1.2u b=0 m=1
XRRU207 s207 s206 vss rppd w=4u l=1.2u b=0 m=1
XRRU208 s208 s207 vss rppd w=4u l=1.2u b=0 m=1
XRRU209 s209 s208 vss rppd w=4u l=1.2u b=0 m=1
XRRU210 s210 s209 vss rppd w=4u l=1.2u b=0 m=1
XRRU211 s211 s210 vss rppd w=4u l=1.2u b=0 m=1
XRRU212 s212 s211 vss rppd w=4u l=1.2u b=0 m=1
XRRU213 s213 s212 vss rppd w=4u l=1.2u b=0 m=1
XRRU214 s214 s213 vss rppd w=4u l=1.2u b=0 m=1
XRRU215 s215 s214 vss rppd w=4u l=1.2u b=0 m=1
XRRU216 s216 s215 vss rppd w=4u l=1.2u b=0 m=1
XRRU217 s217 s216 vss rppd w=4u l=1.2u b=0 m=1
XRRU218 s218 s217 vss rppd w=4u l=1.2u b=0 m=1
XRRU219 s219 s218 vss rppd w=4u l=1.2u b=0 m=1
XRRU220 s220 s219 vss rppd w=4u l=1.2u b=0 m=1
XRRU221 s221 s220 vss rppd w=4u l=1.2u b=0 m=1
XRRU222 s222 s221 vss rppd w=4u l=1.2u b=0 m=1
XRRU223 s223 s222 vss rppd w=4u l=1.2u b=0 m=1
XRRU224 s224 s223 vss rppd w=4u l=1.2u b=0 m=1
XRRU225 s225 s224 vss rppd w=4u l=1.2u b=0 m=1
XRRU226 s226 s225 vss rppd w=4u l=1.2u b=0 m=1
XRRU227 s227 s226 vss rppd w=4u l=1.2u b=0 m=1
XRRU228 s228 s227 vss rppd w=4u l=1.2u b=0 m=1
XRRU229 s229 s228 vss rppd w=4u l=1.2u b=0 m=1
XRRU230 s230 s229 vss rppd w=4u l=1.2u b=0 m=1
XRRU231 s231 s230 vss rppd w=4u l=1.2u b=0 m=1
XRRU232 s232 s231 vss rppd w=4u l=1.2u b=0 m=1
XRRU233 s233 s232 vss rppd w=4u l=1.2u b=0 m=1
XRRU234 s234 s233 vss rppd w=4u l=1.2u b=0 m=1
XRRU235 s235 s234 vss rppd w=4u l=1.2u b=0 m=1
XRRU236 s236 s235 vss rppd w=4u l=1.2u b=0 m=1
XRRU237 s237 s236 vss rppd w=4u l=1.2u b=0 m=1
XRRU238 s238 s237 vss rppd w=4u l=1.2u b=0 m=1
XRRU239 s239 s238 vss rppd w=4u l=1.2u b=0 m=1
XRRU240 s240 s239 vss rppd w=4u l=1.2u b=0 m=1
XRRU241 s241 s240 vss rppd w=4u l=1.2u b=0 m=1
XRRU242 s242 s241 vss rppd w=4u l=1.2u b=0 m=1
XRRU243 s243 s242 vss rppd w=4u l=1.2u b=0 m=1
XRRU244 s244 s243 vss rppd w=4u l=1.2u b=0 m=1
XRRU245 s245 s244 vss rppd w=4u l=1.2u b=0 m=1
XRRU246 s246 s245 vss rppd w=4u l=1.2u b=0 m=1
XRRU247 s247 s246 vss rppd w=4u l=1.2u b=0 m=1
XRRU248 s248 s247 vss rppd w=4u l=1.2u b=0 m=1
XRRU249 s249 s248 vss rppd w=4u l=1.2u b=0 m=1
XRRU250 s250 s249 vss rppd w=4u l=1.2u b=0 m=1
XRRU251 s251 s250 vss rppd w=4u l=1.2u b=0 m=1
XRRU252 s252 s251 vss rppd w=4u l=1.2u b=0 m=1
XRRU253 s253 s252 vss rppd w=4u l=1.2u b=0 m=1
XRRU254 t0 s253 vss rppd w=4u l=1.2u b=0 m=1
XRRU255 t1 t0 vss rppd w=4u l=1.2u b=0 m=1
XRRU256 t2 t1 vss rppd w=4u l=1.2u b=0 m=1
XRRU257 t3 t2 vss rppd w=4u l=1.2u b=0 m=1
XRRU258 t4 t3 vss rppd w=4u l=1.2u b=0 m=1
XRRU259 t5 t4 vss rppd w=4u l=1.2u b=0 m=1
XRRU260 t6 t5 vss rppd w=4u l=1.2u b=0 m=1
XRRU261 t7 t6 vss rppd w=4u l=1.2u b=0 m=1
XRRU262 t8 t7 vss rppd w=4u l=1.2u b=0 m=1
XRRU263 t9 t8 vss rppd w=4u l=1.2u b=0 m=1
XRRU264 t10 t9 vss rppd w=4u l=1.2u b=0 m=1
XRRU265 t11 t10 vss rppd w=4u l=1.2u b=0 m=1
XRRU266 t12 t11 vss rppd w=4u l=1.2u b=0 m=1
XRRU267 t13 t12 vss rppd w=4u l=1.2u b=0 m=1
XRRU268 t14 t13 vss rppd w=4u l=1.2u b=0 m=1
XRRU269 t15 t14 vss rppd w=4u l=1.2u b=0 m=1
XRRU270 t16 t15 vss rppd w=4u l=1.2u b=0 m=1
XRRU271 t17 t16 vss rppd w=4u l=1.2u b=0 m=1
XRRU272 t18 t17 vss rppd w=4u l=1.2u b=0 m=1
XRRU273 t19 t18 vss rppd w=4u l=1.2u b=0 m=1
XRRU274 t20 t19 vss rppd w=4u l=1.2u b=0 m=1
XRRU275 t21 t20 vss rppd w=4u l=1.2u b=0 m=1
XRRU276 t22 t21 vss rppd w=4u l=1.2u b=0 m=1
XRRU277 t23 t22 vss rppd w=4u l=1.2u b=0 m=1
XRRU278 t24 t23 vss rppd w=4u l=1.2u b=0 m=1
XRRU279 t25 t24 vss rppd w=4u l=1.2u b=0 m=1
XRRU280 t26 t25 vss rppd w=4u l=1.2u b=0 m=1
XRRU281 t27 t26 vss rppd w=4u l=1.2u b=0 m=1
XRRU282 t28 t27 vss rppd w=4u l=1.2u b=0 m=1
XRRU283 t29 t28 vss rppd w=4u l=1.2u b=0 m=1
XRRU284 t30 t29 vss rppd w=4u l=1.2u b=0 m=1
XRRU285 t31 t30 vss rppd w=4u l=1.2u b=0 m=1
XRRU286 t32 t31 vss rppd w=4u l=1.2u b=0 m=1
XRRU287 t33 t32 vss rppd w=4u l=1.2u b=0 m=1
XRRU288 t34 t33 vss rppd w=4u l=1.2u b=0 m=1
XRRU289 t35 t34 vss rppd w=4u l=1.2u b=0 m=1
XRRU290 t36 t35 vss rppd w=4u l=1.2u b=0 m=1
XRRU291 t37 t36 vss rppd w=4u l=1.2u b=0 m=1
XRRU292 t38 t37 vss rppd w=4u l=1.2u b=0 m=1
XRRU293 t39 t38 vss rppd w=4u l=1.2u b=0 m=1
XRRU294 t40 t39 vss rppd w=4u l=1.2u b=0 m=1
XRRU295 t41 t40 vss rppd w=4u l=1.2u b=0 m=1
XRRU296 t42 t41 vss rppd w=4u l=1.2u b=0 m=1
XRRU297 t43 t42 vss rppd w=4u l=1.2u b=0 m=1
XRRU298 t44 t43 vss rppd w=4u l=1.2u b=0 m=1
XRRU299 t45 t44 vss rppd w=4u l=1.2u b=0 m=1
XRRU300 t46 t45 vss rppd w=4u l=1.2u b=0 m=1
XRRU301 t47 t46 vss rppd w=4u l=1.2u b=0 m=1
XRRU302 t48 t47 vss rppd w=4u l=1.2u b=0 m=1
XRRU303 t49 t48 vss rppd w=4u l=1.2u b=0 m=1
XRRU304 t50 t49 vss rppd w=4u l=1.2u b=0 m=1
XRRU305 t51 t50 vss rppd w=4u l=1.2u b=0 m=1
XRRU306 t52 t51 vss rppd w=4u l=1.2u b=0 m=1
XRRU307 t53 t52 vss rppd w=4u l=1.2u b=0 m=1
XRRU308 t54 t53 vss rppd w=4u l=1.2u b=0 m=1
XRRU309 t55 t54 vss rppd w=4u l=1.2u b=0 m=1
XRRU310 t56 t55 vss rppd w=4u l=1.2u b=0 m=1
XRRU311 t57 t56 vss rppd w=4u l=1.2u b=0 m=1
XRRU312 t58 t57 vss rppd w=4u l=1.2u b=0 m=1
XRRU313 t59 t58 vss rppd w=4u l=1.2u b=0 m=1
XRRU314 t60 t59 vss rppd w=4u l=1.2u b=0 m=1
XRRU315 t61 t60 vss rppd w=4u l=1.2u b=0 m=1
XRRU316 t62 t61 vss rppd w=4u l=1.2u b=0 m=1
XRRU317 t63 t62 vss rppd w=4u l=1.2u b=0 m=1
XRRU318 t64 t63 vss rppd w=4u l=1.2u b=0 m=1
XRRU319 t65 t64 vss rppd w=4u l=1.2u b=0 m=1
XRRU320 t66 t65 vss rppd w=4u l=1.2u b=0 m=1
XRRU321 t67 t66 vss rppd w=4u l=1.2u b=0 m=1
XRRU322 t68 t67 vss rppd w=4u l=1.2u b=0 m=1
XRRU323 t69 t68 vss rppd w=4u l=1.2u b=0 m=1
XRRU324 t70 t69 vss rppd w=4u l=1.2u b=0 m=1
XRRU325 t71 t70 vss rppd w=4u l=1.2u b=0 m=1
XRRU326 t72 t71 vss rppd w=4u l=1.2u b=0 m=1
XRRU327 t73 t72 vss rppd w=4u l=1.2u b=0 m=1
XRRU328 t74 t73 vss rppd w=4u l=1.2u b=0 m=1
XRRU329 t75 t74 vss rppd w=4u l=1.2u b=0 m=1
XRRU330 t76 t75 vss rppd w=4u l=1.2u b=0 m=1
XRRU331 t77 t76 vss rppd w=4u l=1.2u b=0 m=1
XRRU332 t78 t77 vss rppd w=4u l=1.2u b=0 m=1
XRRU333 t79 t78 vss rppd w=4u l=1.2u b=0 m=1
XRRU334 t80 t79 vss rppd w=4u l=1.2u b=0 m=1
XRRU335 t81 t80 vss rppd w=4u l=1.2u b=0 m=1
XRRU336 t82 t81 vss rppd w=4u l=1.2u b=0 m=1
XRRU337 t83 t82 vss rppd w=4u l=1.2u b=0 m=1
XRRU338 t84 t83 vss rppd w=4u l=1.2u b=0 m=1
XRRU339 t85 t84 vss rppd w=4u l=1.2u b=0 m=1
XRRU340 t86 t85 vss rppd w=4u l=1.2u b=0 m=1
XRRU341 t87 t86 vss rppd w=4u l=1.2u b=0 m=1
XRRU342 t88 t87 vss rppd w=4u l=1.2u b=0 m=1
XRRU343 t89 t88 vss rppd w=4u l=1.2u b=0 m=1
XRRU344 t90 t89 vss rppd w=4u l=1.2u b=0 m=1
XRRU345 t91 t90 vss rppd w=4u l=1.2u b=0 m=1
XRRU346 t92 t91 vss rppd w=4u l=1.2u b=0 m=1
XRRU347 t93 t92 vss rppd w=4u l=1.2u b=0 m=1
XRRU348 t94 t93 vss rppd w=4u l=1.2u b=0 m=1
XRRU349 t95 t94 vss rppd w=4u l=1.2u b=0 m=1
XRRU350 t96 t95 vss rppd w=4u l=1.2u b=0 m=1
XRRU351 t97 t96 vss rppd w=4u l=1.2u b=0 m=1
XRRU352 t98 t97 vss rppd w=4u l=1.2u b=0 m=1
XRRU353 t99 t98 vss rppd w=4u l=1.2u b=0 m=1
XRRU354 t100 t99 vss rppd w=4u l=1.2u b=0 m=1
XRRU355 t101 t100 vss rppd w=4u l=1.2u b=0 m=1
XRRU356 t102 t101 vss rppd w=4u l=1.2u b=0 m=1
XRRU357 t103 t102 vss rppd w=4u l=1.2u b=0 m=1
XRRU358 t104 t103 vss rppd w=4u l=1.2u b=0 m=1
XRRU359 t105 t104 vss rppd w=4u l=1.2u b=0 m=1
XRRU360 t106 t105 vss rppd w=4u l=1.2u b=0 m=1
XRRU361 t107 t106 vss rppd w=4u l=1.2u b=0 m=1
XRRU362 t108 t107 vss rppd w=4u l=1.2u b=0 m=1
XRRU363 t109 t108 vss rppd w=4u l=1.2u b=0 m=1
XRRU364 t110 t109 vss rppd w=4u l=1.2u b=0 m=1
XRRU365 t111 t110 vss rppd w=4u l=1.2u b=0 m=1
XRRU366 t112 t111 vss rppd w=4u l=1.2u b=0 m=1
XRRU367 t113 t112 vss rppd w=4u l=1.2u b=0 m=1
XRRU368 t114 t113 vss rppd w=4u l=1.2u b=0 m=1
XRRU369 t115 t114 vss rppd w=4u l=1.2u b=0 m=1
XRRU370 t116 t115 vss rppd w=4u l=1.2u b=0 m=1
XRRU371 t117 t116 vss rppd w=4u l=1.2u b=0 m=1
XRRU372 t118 t117 vss rppd w=4u l=1.2u b=0 m=1
XRRU373 t119 t118 vss rppd w=4u l=1.2u b=0 m=1
XRRU374 t120 t119 vss rppd w=4u l=1.2u b=0 m=1
XRRU375 t121 t120 vss rppd w=4u l=1.2u b=0 m=1
XRRU376 t122 t121 vss rppd w=4u l=1.2u b=0 m=1
XRRU377 t123 t122 vss rppd w=4u l=1.2u b=0 m=1
XRRU378 t124 t123 vss rppd w=4u l=1.2u b=0 m=1
XRRU379 t125 t124 vss rppd w=4u l=1.2u b=0 m=1
XRRU380 t126 t125 vss rppd w=4u l=1.2u b=0 m=1
XRRU381 t127 t126 vss rppd w=4u l=1.2u b=0 m=1
XRRU382 t128 t127 vss rppd w=4u l=1.2u b=0 m=1
XRRU383 t129 t128 vss rppd w=4u l=1.2u b=0 m=1
XRRU384 t130 t129 vss rppd w=4u l=1.2u b=0 m=1
XRRU385 t131 t130 vss rppd w=4u l=1.2u b=0 m=1
XRRU386 t132 t131 vss rppd w=4u l=1.2u b=0 m=1
XRRU387 t133 t132 vss rppd w=4u l=1.2u b=0 m=1
XRRU388 t134 t133 vss rppd w=4u l=1.2u b=0 m=1
XRRU389 t135 t134 vss rppd w=4u l=1.2u b=0 m=1
XRRU390 t136 t135 vss rppd w=4u l=1.2u b=0 m=1
XRRU391 t137 t136 vss rppd w=4u l=1.2u b=0 m=1
XRRU392 t138 t137 vss rppd w=4u l=1.2u b=0 m=1
XRRU393 t139 t138 vss rppd w=4u l=1.2u b=0 m=1
XRRU394 t140 t139 vss rppd w=4u l=1.2u b=0 m=1
XRRU395 t141 t140 vss rppd w=4u l=1.2u b=0 m=1
XRRU396 t142 t141 vss rppd w=4u l=1.2u b=0 m=1
XRRU397 t143 t142 vss rppd w=4u l=1.2u b=0 m=1
XRRU398 t144 t143 vss rppd w=4u l=1.2u b=0 m=1
XRRU399 t145 t144 vss rppd w=4u l=1.2u b=0 m=1
XRRU400 t146 t145 vss rppd w=4u l=1.2u b=0 m=1
XRRU401 t147 t146 vss rppd w=4u l=1.2u b=0 m=1
XRRU402 t148 t147 vss rppd w=4u l=1.2u b=0 m=1
XRRU403 t149 t148 vss rppd w=4u l=1.2u b=0 m=1
XRRU404 t150 t149 vss rppd w=4u l=1.2u b=0 m=1
XRRU405 t151 t150 vss rppd w=4u l=1.2u b=0 m=1
XRRU406 t152 t151 vss rppd w=4u l=1.2u b=0 m=1
XRRU407 t153 t152 vss rppd w=4u l=1.2u b=0 m=1
XRRU408 t154 t153 vss rppd w=4u l=1.2u b=0 m=1
XRRU409 t155 t154 vss rppd w=4u l=1.2u b=0 m=1
XRRU410 t156 t155 vss rppd w=4u l=1.2u b=0 m=1
XRRU411 t157 t156 vss rppd w=4u l=1.2u b=0 m=1
XRRU412 t158 t157 vss rppd w=4u l=1.2u b=0 m=1
XRRU413 t159 t158 vss rppd w=4u l=1.2u b=0 m=1
XRRU414 t160 t159 vss rppd w=4u l=1.2u b=0 m=1
XRRU415 t161 t160 vss rppd w=4u l=1.2u b=0 m=1
XRRU416 t162 t161 vss rppd w=4u l=1.2u b=0 m=1
XRRU417 t163 t162 vss rppd w=4u l=1.2u b=0 m=1
XRRU418 t164 t163 vss rppd w=4u l=1.2u b=0 m=1
XRRU419 t165 t164 vss rppd w=4u l=1.2u b=0 m=1
XRRU420 t166 t165 vss rppd w=4u l=1.2u b=0 m=1
XRRU421 t167 t166 vss rppd w=4u l=1.2u b=0 m=1
XRRU422 t168 t167 vss rppd w=4u l=1.2u b=0 m=1
XRRU423 t169 t168 vss rppd w=4u l=1.2u b=0 m=1
XRRU424 t170 t169 vss rppd w=4u l=1.2u b=0 m=1
XRRU425 t171 t170 vss rppd w=4u l=1.2u b=0 m=1
XRRU426 t172 t171 vss rppd w=4u l=1.2u b=0 m=1
XRRU427 t173 t172 vss rppd w=4u l=1.2u b=0 m=1
XRRU428 t174 t173 vss rppd w=4u l=1.2u b=0 m=1
XRRU429 t175 t174 vss rppd w=4u l=1.2u b=0 m=1
XRRU430 t176 t175 vss rppd w=4u l=1.2u b=0 m=1
XRRU431 t177 t176 vss rppd w=4u l=1.2u b=0 m=1
XRRU432 t178 t177 vss rppd w=4u l=1.2u b=0 m=1
XRRU433 t179 t178 vss rppd w=4u l=1.2u b=0 m=1
XRRU434 t180 t179 vss rppd w=4u l=1.2u b=0 m=1
XRRU435 t181 t180 vss rppd w=4u l=1.2u b=0 m=1
XRRU436 t182 t181 vss rppd w=4u l=1.2u b=0 m=1
XRRU437 t183 t182 vss rppd w=4u l=1.2u b=0 m=1
XRRU438 t184 t183 vss rppd w=4u l=1.2u b=0 m=1
XRRU439 t185 t184 vss rppd w=4u l=1.2u b=0 m=1
XRRU440 t186 t185 vss rppd w=4u l=1.2u b=0 m=1
XRRU441 t187 t186 vss rppd w=4u l=1.2u b=0 m=1
XRRU442 t188 t187 vss rppd w=4u l=1.2u b=0 m=1
XRRU443 t189 t188 vss rppd w=4u l=1.2u b=0 m=1
XRRU444 t190 t189 vss rppd w=4u l=1.2u b=0 m=1
XRRU445 t191 t190 vss rppd w=4u l=1.2u b=0 m=1
XRRU446 t192 t191 vss rppd w=4u l=1.2u b=0 m=1
XRRU447 t193 t192 vss rppd w=4u l=1.2u b=0 m=1
XRRU448 t194 t193 vss rppd w=4u l=1.2u b=0 m=1
XRRU449 t195 t194 vss rppd w=4u l=1.2u b=0 m=1
XRRU450 t196 t195 vss rppd w=4u l=1.2u b=0 m=1
XRRU451 t197 t196 vss rppd w=4u l=1.2u b=0 m=1
XRRU452 t198 t197 vss rppd w=4u l=1.2u b=0 m=1
XRRU453 t199 t198 vss rppd w=4u l=1.2u b=0 m=1
XRRU454 t200 t199 vss rppd w=4u l=1.2u b=0 m=1
XRRU455 t201 t200 vss rppd w=4u l=1.2u b=0 m=1
XRRU456 t202 t201 vss rppd w=4u l=1.2u b=0 m=1
XRRU457 t203 t202 vss rppd w=4u l=1.2u b=0 m=1
XRRU458 t204 t203 vss rppd w=4u l=1.2u b=0 m=1
XRRU459 t205 t204 vss rppd w=4u l=1.2u b=0 m=1
XRRU460 t206 t205 vss rppd w=4u l=1.2u b=0 m=1
XRRU461 t207 t206 vss rppd w=4u l=1.2u b=0 m=1
XRRU462 t208 t207 vss rppd w=4u l=1.2u b=0 m=1
XRRU463 t209 t208 vss rppd w=4u l=1.2u b=0 m=1
XRRU464 t210 t209 vss rppd w=4u l=1.2u b=0 m=1
XRRU465 t211 t210 vss rppd w=4u l=1.2u b=0 m=1
XRRU466 t212 t211 vss rppd w=4u l=1.2u b=0 m=1
XRRU467 t213 t212 vss rppd w=4u l=1.2u b=0 m=1
XRRU468 t214 t213 vss rppd w=4u l=1.2u b=0 m=1
XRRU469 t215 t214 vss rppd w=4u l=1.2u b=0 m=1
XRRU470 t216 t215 vss rppd w=4u l=1.2u b=0 m=1
XRRU471 t217 t216 vss rppd w=4u l=1.2u b=0 m=1
XRRU472 t218 t217 vss rppd w=4u l=1.2u b=0 m=1
XRRU473 t219 t218 vss rppd w=4u l=1.2u b=0 m=1
XRRU474 t220 t219 vss rppd w=4u l=1.2u b=0 m=1
XRRU475 t221 t220 vss rppd w=4u l=1.2u b=0 m=1
XRRU476 t222 t221 vss rppd w=4u l=1.2u b=0 m=1
XRRU477 t223 t222 vss rppd w=4u l=1.2u b=0 m=1
XRRU478 t224 t223 vss rppd w=4u l=1.2u b=0 m=1
XRRU479 t225 t224 vss rppd w=4u l=1.2u b=0 m=1
XRRU480 t226 t225 vss rppd w=4u l=1.2u b=0 m=1
XRRU481 t227 t226 vss rppd w=4u l=1.2u b=0 m=1
XRRU482 t228 t227 vss rppd w=4u l=1.2u b=0 m=1
XRRU483 t229 t228 vss rppd w=4u l=1.2u b=0 m=1
XRRU484 t230 t229 vss rppd w=4u l=1.2u b=0 m=1
XRRU485 t231 t230 vss rppd w=4u l=1.2u b=0 m=1
XRRU486 t232 t231 vss rppd w=4u l=1.2u b=0 m=1
XRRU487 t233 t232 vss rppd w=4u l=1.2u b=0 m=1
XRRU488 t234 t233 vss rppd w=4u l=1.2u b=0 m=1
XRRU489 t235 t234 vss rppd w=4u l=1.2u b=0 m=1
XRRU490 t236 t235 vss rppd w=4u l=1.2u b=0 m=1
XRRU491 t237 t236 vss rppd w=4u l=1.2u b=0 m=1
XRRU492 t238 t237 vss rppd w=4u l=1.2u b=0 m=1
XRRU493 t239 t238 vss rppd w=4u l=1.2u b=0 m=1
XRRU494 t240 t239 vss rppd w=4u l=1.2u b=0 m=1
XRRU495 t241 t240 vss rppd w=4u l=1.2u b=0 m=1
XRRU496 t242 t241 vss rppd w=4u l=1.2u b=0 m=1
XRRU497 t243 t242 vss rppd w=4u l=1.2u b=0 m=1
XRRU498 t244 t243 vss rppd w=4u l=1.2u b=0 m=1
XRRU499 t245 t244 vss rppd w=4u l=1.2u b=0 m=1
XRRU500 t246 t245 vss rppd w=4u l=1.2u b=0 m=1
XRRU501 t247 t246 vss rppd w=4u l=1.2u b=0 m=1
XRRU502 t248 t247 vss rppd w=4u l=1.2u b=0 m=1
XRRU503 t249 t248 vss rppd w=4u l=1.2u b=0 m=1
XRRU504 t250 t249 vss rppd w=4u l=1.2u b=0 m=1
XRRU505 t251 t250 vss rppd w=4u l=1.2u b=0 m=1
XRRU506 t252 t251 vss rppd w=4u l=1.2u b=0 m=1
XRRU507 t253 t252 vss rppd w=4u l=1.2u b=0 m=1
XRRU508 t254 t253 vss rppd w=4u l=1.2u b=0 m=1
XRRU509 t255 t254 vss rppd w=4u l=1.2u b=0 m=1
XRRU510 s510 t255 vss rppd w=4u l=1.2u b=0 m=1
XRRU511 s511 s510 vss rppd w=4u l=1.2u b=0 m=1
XRRU512 s512 s511 vss rppd w=4u l=1.2u b=0 m=1
XRRU513 s513 s512 vss rppd w=4u l=1.2u b=0 m=1
XRRU514 s514 s513 vss rppd w=4u l=1.2u b=0 m=1
XRRU515 s515 s514 vss rppd w=4u l=1.2u b=0 m=1
XRRU516 s516 s515 vss rppd w=4u l=1.2u b=0 m=1
XRRU517 s517 s516 vss rppd w=4u l=1.2u b=0 m=1
XRRU518 s518 s517 vss rppd w=4u l=1.2u b=0 m=1
XRRU519 s519 s518 vss rppd w=4u l=1.2u b=0 m=1
XRRU520 s520 s519 vss rppd w=4u l=1.2u b=0 m=1
XRRU521 s521 s520 vss rppd w=4u l=1.2u b=0 m=1
XRRU522 s522 s521 vss rppd w=4u l=1.2u b=0 m=1
XRRU523 s523 s522 vss rppd w=4u l=1.2u b=0 m=1
XRRU524 s524 s523 vss rppd w=4u l=1.2u b=0 m=1
XRRU525 s525 s524 vss rppd w=4u l=1.2u b=0 m=1
XRRU526 s526 s525 vss rppd w=4u l=1.2u b=0 m=1
XRRU527 s527 s526 vss rppd w=4u l=1.2u b=0 m=1
XRRU528 s528 s527 vss rppd w=4u l=1.2u b=0 m=1
XRRU529 vref s528 vss rppd w=4u l=1.2u b=0 m=1
XLU0 d0 dh0 dhn0 vdd vdda vss g1_tlvlup
XLU1 d1 dh1 dhn1 vdd vdda vss g1_tlvlup
XLU2 d2 dh2 dhn2 vdd vdda vss g1_tlvlup
XLU3 d3 dh3 dhn3 vdd vdda vss g1_tlvlup
XLU4 d4 dh4 dhn4 vdd vdda vss g1_tlvlup
XLU5 d5 dh5 dhn5 vdd vdda vss g1_tlvlup
XLU6 d6 dh6 dhn6 vdd vdda vss g1_tlvlup
XLU7 d7 dh7 dhn7 vdd vdda vss g1_tlvlup
XMMS0_0a t0 dhn0 m0_0 vss sg13_hv_nmos w=2u l=0.45u m=1
XMMS0_0b t1 dh0 m0_0 vss sg13_hv_nmos w=2u l=0.45u m=1
XMMS0_1a t2 dhn0 m0_1 vss sg13_hv_nmos w=2u l=0.45u m=1
XMMS0_1b t3 dh0 m0_1 vss sg13_hv_nmos w=2u l=0.45u m=1
XMMS0_2a t4 dhn0 m0_2 vss sg13_hv_nmos w=2u l=0.45u m=1
XMMS0_2b t5 dh0 m0_2 vss sg13_hv_nmos w=2u l=0.45u m=1
XMMS0_3a t6 dhn0 m0_3 vss sg13_hv_nmos w=2u l=0.45u m=1
XMMS0_3b t7 dh0 m0_3 vss sg13_hv_nmos w=2u l=0.45u m=1
XMMS0_4a t8 dhn0 m0_4 vss sg13_hv_nmos w=2u l=0.45u m=1
XMMS0_4b t9 dh0 m0_4 vss sg13_hv_nmos w=2u l=0.45u m=1
XMMS0_5a t10 dhn0 m0_5 vss sg13_hv_nmos w=2u l=0.45u m=1
XMMS0_5b t11 dh0 m0_5 vss sg13_hv_nmos w=2u l=0.45u m=1
XMMS0_6a t12 dhn0 m0_6 vss sg13_hv_nmos w=2u l=0.45u m=1
XMMS0_6b t13 dh0 m0_6 vss sg13_hv_nmos w=2u l=0.45u m=1
XMMS0_7a t14 dhn0 m0_7 vss sg13_hv_nmos w=2u l=0.45u m=1
XMMS0_7b t15 dh0 m0_7 vss sg13_hv_nmos w=2u l=0.45u m=1
XMMS0_8a t16 dhn0 m0_8 vss sg13_hv_nmos w=2u l=0.45u m=1
XMMS0_8b t17 dh0 m0_8 vss sg13_hv_nmos w=2u l=0.45u m=1
XMMS0_9a t18 dhn0 m0_9 vss sg13_hv_nmos w=2u l=0.45u m=1
XMMS0_9b t19 dh0 m0_9 vss sg13_hv_nmos w=2u l=0.45u m=1
XMMS0_10a t20 dhn0 m0_10 vss sg13_hv_nmos w=2u l=0.45u m=1
XMMS0_10b t21 dh0 m0_10 vss sg13_hv_nmos w=2u l=0.45u m=1
XMMS0_11a t22 dhn0 m0_11 vss sg13_hv_nmos w=2u l=0.45u m=1
XMMS0_11b t23 dh0 m0_11 vss sg13_hv_nmos w=2u l=0.45u m=1
XMMS0_12a t24 dhn0 m0_12 vss sg13_hv_nmos w=2u l=0.45u m=1
XMMS0_12b t25 dh0 m0_12 vss sg13_hv_nmos w=2u l=0.45u m=1
XMMS0_13a t26 dhn0 m0_13 vss sg13_hv_nmos w=2u l=0.45u m=1
XMMS0_13b t27 dh0 m0_13 vss sg13_hv_nmos w=2u l=0.45u m=1
XMMS0_14a t28 dhn0 m0_14 vss sg13_hv_nmos w=2u l=0.45u m=1
XMMS0_14b t29 dh0 m0_14 vss sg13_hv_nmos w=2u l=0.45u m=1
XMMS0_15a t30 dhn0 m0_15 vss sg13_hv_nmos w=2u l=0.45u m=1
XMMS0_15b t31 dh0 m0_15 vss sg13_hv_nmos w=2u l=0.45u m=1
XMMS0_16a t32 dhn0 m0_16 vss sg13_hv_nmos w=2u l=0.45u m=1
XMMS0_16b t33 dh0 m0_16 vss sg13_hv_nmos w=2u l=0.45u m=1
XMMS0_17a t34 dhn0 m0_17 vss sg13_hv_nmos w=2u l=0.45u m=1
XMMS0_17b t35 dh0 m0_17 vss sg13_hv_nmos w=2u l=0.45u m=1
XMMS0_18a t36 dhn0 m0_18 vss sg13_hv_nmos w=2u l=0.45u m=1
XMMS0_18b t37 dh0 m0_18 vss sg13_hv_nmos w=2u l=0.45u m=1
XMMS0_19a t38 dhn0 m0_19 vss sg13_hv_nmos w=2u l=0.45u m=1
XMMS0_19b t39 dh0 m0_19 vss sg13_hv_nmos w=2u l=0.45u m=1
XMMS0_20a t40 dhn0 m0_20 vss sg13_hv_nmos w=2u l=0.45u m=1
XMMS0_20b t41 dh0 m0_20 vss sg13_hv_nmos w=2u l=0.45u m=1
XMMS0_21a t42 dhn0 m0_21 vss sg13_hv_nmos w=2u l=0.45u m=1
XMMS0_21b t43 dh0 m0_21 vss sg13_hv_nmos w=2u l=0.45u m=1
XMMS0_22a t44 dhn0 m0_22 vss sg13_hv_nmos w=2u l=0.45u m=1
XMMS0_22b t45 dh0 m0_22 vss sg13_hv_nmos w=2u l=0.45u m=1
XMMS0_23a t46 dhn0 m0_23 vss sg13_hv_nmos w=2u l=0.45u m=1
XMMS0_23b t47 dh0 m0_23 vss sg13_hv_nmos w=2u l=0.45u m=1
XMMS0_24a t48 dhn0 m0_24 vss sg13_hv_nmos w=2u l=0.45u m=1
XMMS0_24b t49 dh0 m0_24 vss sg13_hv_nmos w=2u l=0.45u m=1
XMMS0_25a t50 dhn0 m0_25 vss sg13_hv_nmos w=2u l=0.45u m=1
XMMS0_25b t51 dh0 m0_25 vss sg13_hv_nmos w=2u l=0.45u m=1
XMMS0_26a t52 dhn0 m0_26 vss sg13_hv_nmos w=2u l=0.45u m=1
XMMS0_26b t53 dh0 m0_26 vss sg13_hv_nmos w=2u l=0.45u m=1
XMMS0_27a t54 dhn0 m0_27 vss sg13_hv_nmos w=2u l=0.45u m=1
XMMS0_27b t55 dh0 m0_27 vss sg13_hv_nmos w=2u l=0.45u m=1
XMMS0_28a t56 dhn0 m0_28 vss sg13_hv_nmos w=2u l=0.45u m=1
XMMS0_28b t57 dh0 m0_28 vss sg13_hv_nmos w=2u l=0.45u m=1
XMMS0_29a t58 dhn0 m0_29 vss sg13_hv_nmos w=2u l=0.45u m=1
XMMS0_29b t59 dh0 m0_29 vss sg13_hv_nmos w=2u l=0.45u m=1
XMMS0_30a t60 dhn0 m0_30 vss sg13_hv_nmos w=2u l=0.45u m=1
XMMS0_30b t61 dh0 m0_30 vss sg13_hv_nmos w=2u l=0.45u m=1
XMMS0_31a t62 dhn0 m0_31 vss sg13_hv_nmos w=2u l=0.45u m=1
XMMS0_31b t63 dh0 m0_31 vss sg13_hv_nmos w=2u l=0.45u m=1
XMMS0_32a t64 dhn0 m0_32 vss sg13_hv_nmos w=2u l=0.45u m=1
XMMS0_32b t65 dh0 m0_32 vss sg13_hv_nmos w=2u l=0.45u m=1
XMMS0_33a t66 dhn0 m0_33 vss sg13_hv_nmos w=2u l=0.45u m=1
XMMS0_33b t67 dh0 m0_33 vss sg13_hv_nmos w=2u l=0.45u m=1
XMMS0_34a t68 dhn0 m0_34 vss sg13_hv_nmos w=2u l=0.45u m=1
XMMS0_34b t69 dh0 m0_34 vss sg13_hv_nmos w=2u l=0.45u m=1
XMMS0_35a t70 dhn0 m0_35 vss sg13_hv_nmos w=2u l=0.45u m=1
XMMS0_35b t71 dh0 m0_35 vss sg13_hv_nmos w=2u l=0.45u m=1
XMMS0_36a t72 dhn0 m0_36 vss sg13_hv_nmos w=2u l=0.45u m=1
XMMS0_36b t73 dh0 m0_36 vss sg13_hv_nmos w=2u l=0.45u m=1
XMMS0_37a t74 dhn0 m0_37 vss sg13_hv_nmos w=2u l=0.45u m=1
XMMS0_37b t75 dh0 m0_37 vss sg13_hv_nmos w=2u l=0.45u m=1
XMMS0_38a t76 dhn0 m0_38 vss sg13_hv_nmos w=2u l=0.45u m=1
XMMS0_38b t77 dh0 m0_38 vss sg13_hv_nmos w=2u l=0.45u m=1
XMMS0_39a t78 dhn0 m0_39 vss sg13_hv_nmos w=2u l=0.45u m=1
XMMS0_39b t79 dh0 m0_39 vss sg13_hv_nmos w=2u l=0.45u m=1
XMMS0_40a t80 dhn0 m0_40 vss sg13_hv_nmos w=2u l=0.45u m=1
XMMS0_40b t81 dh0 m0_40 vss sg13_hv_nmos w=2u l=0.45u m=1
XMMS0_41a t82 dhn0 m0_41 vss sg13_hv_nmos w=2u l=0.45u m=1
XMMS0_41b t83 dh0 m0_41 vss sg13_hv_nmos w=2u l=0.45u m=1
XMMS0_42a t84 dhn0 m0_42 vss sg13_hv_nmos w=2u l=0.45u m=1
XMMS0_42b t85 dh0 m0_42 vss sg13_hv_nmos w=2u l=0.45u m=1
XMMS0_43a t86 dhn0 m0_43 vss sg13_hv_nmos w=2u l=0.45u m=1
XMMS0_43b t87 dh0 m0_43 vss sg13_hv_nmos w=2u l=0.45u m=1
XMMS0_44a t88 dhn0 m0_44 vss sg13_hv_nmos w=2u l=0.45u m=1
XMMS0_44b t89 dh0 m0_44 vss sg13_hv_nmos w=2u l=0.45u m=1
XMMS0_45a t90 dhn0 m0_45 vss sg13_hv_nmos w=2u l=0.45u m=1
XMMS0_45b t91 dh0 m0_45 vss sg13_hv_nmos w=2u l=0.45u m=1
XMMS0_46a t92 dhn0 m0_46 vss sg13_hv_nmos w=2u l=0.45u m=1
XMMS0_46b t93 dh0 m0_46 vss sg13_hv_nmos w=2u l=0.45u m=1
XMMS0_47a t94 dhn0 m0_47 vss sg13_hv_nmos w=2u l=0.45u m=1
XMMS0_47b t95 dh0 m0_47 vss sg13_hv_nmos w=2u l=0.45u m=1
XMMS0_48a t96 dhn0 m0_48 vss sg13_hv_nmos w=2u l=0.45u m=1
XMMS0_48b t97 dh0 m0_48 vss sg13_hv_nmos w=2u l=0.45u m=1
XMMS0_49a t98 dhn0 m0_49 vss sg13_hv_nmos w=2u l=0.45u m=1
XMMS0_49b t99 dh0 m0_49 vss sg13_hv_nmos w=2u l=0.45u m=1
XMMS0_50a t100 dhn0 m0_50 vss sg13_hv_nmos w=2u l=0.45u m=1
XMMS0_50b t101 dh0 m0_50 vss sg13_hv_nmos w=2u l=0.45u m=1
XMMS0_51a t102 dhn0 m0_51 vss sg13_hv_nmos w=2u l=0.45u m=1
XMMS0_51b t103 dh0 m0_51 vss sg13_hv_nmos w=2u l=0.45u m=1
XMMS0_52a t104 dhn0 m0_52 vss sg13_hv_nmos w=2u l=0.45u m=1
XMMS0_52b t105 dh0 m0_52 vss sg13_hv_nmos w=2u l=0.45u m=1
XMMS0_53a t106 dhn0 m0_53 vss sg13_hv_nmos w=2u l=0.45u m=1
XMMS0_53b t107 dh0 m0_53 vss sg13_hv_nmos w=2u l=0.45u m=1
XMMS0_54a t108 dhn0 m0_54 vss sg13_hv_nmos w=2u l=0.45u m=1
XMMS0_54b t109 dh0 m0_54 vss sg13_hv_nmos w=2u l=0.45u m=1
XMMS0_55a t110 dhn0 m0_55 vss sg13_hv_nmos w=2u l=0.45u m=1
XMMS0_55b t111 dh0 m0_55 vss sg13_hv_nmos w=2u l=0.45u m=1
XMMS0_56a t112 dhn0 m0_56 vss sg13_hv_nmos w=2u l=0.45u m=1
XMMS0_56b t113 dh0 m0_56 vss sg13_hv_nmos w=2u l=0.45u m=1
XMMS0_57a t114 dhn0 m0_57 vss sg13_hv_nmos w=2u l=0.45u m=1
XMMS0_57b t115 dh0 m0_57 vss sg13_hv_nmos w=2u l=0.45u m=1
XMMS0_58a t116 dhn0 m0_58 vss sg13_hv_nmos w=2u l=0.45u m=1
XMMS0_58b t117 dh0 m0_58 vss sg13_hv_nmos w=2u l=0.45u m=1
XMMS0_59a t118 dhn0 m0_59 vss sg13_hv_nmos w=2u l=0.45u m=1
XMMS0_59b t119 dh0 m0_59 vss sg13_hv_nmos w=2u l=0.45u m=1
XMMS0_60a t120 dhn0 m0_60 vss sg13_hv_nmos w=2u l=0.45u m=1
XMMS0_60b t121 dh0 m0_60 vss sg13_hv_nmos w=2u l=0.45u m=1
XMMS0_61a t122 dhn0 m0_61 vss sg13_hv_nmos w=2u l=0.45u m=1
XMMS0_61b t123 dh0 m0_61 vss sg13_hv_nmos w=2u l=0.45u m=1
XMMS0_62a t124 dhn0 m0_62 vss sg13_hv_nmos w=2u l=0.45u m=1
XMMS0_62b t125 dh0 m0_62 vss sg13_hv_nmos w=2u l=0.45u m=1
XMMS0_63a t126 dhn0 m0_63 vss sg13_hv_nmos w=2u l=0.45u m=1
XMMS0_63b t127 dh0 m0_63 vss sg13_hv_nmos w=2u l=0.45u m=1
XMMS0_64a t128 dhn0 m0_64 vss sg13_hv_nmos w=2u l=0.45u m=1
XMMS0_64b t129 dh0 m0_64 vss sg13_hv_nmos w=2u l=0.45u m=1
XMMS0_65a t130 dhn0 m0_65 vss sg13_hv_nmos w=2u l=0.45u m=1
XMMS0_65b t131 dh0 m0_65 vss sg13_hv_nmos w=2u l=0.45u m=1
XMMS0_66a t132 dhn0 m0_66 vss sg13_hv_nmos w=2u l=0.45u m=1
XMMS0_66b t133 dh0 m0_66 vss sg13_hv_nmos w=2u l=0.45u m=1
XMMS0_67a t134 dhn0 m0_67 vss sg13_hv_nmos w=2u l=0.45u m=1
XMMS0_67b t135 dh0 m0_67 vss sg13_hv_nmos w=2u l=0.45u m=1
XMMS0_68a t136 dhn0 m0_68 vss sg13_hv_nmos w=2u l=0.45u m=1
XMMS0_68b t137 dh0 m0_68 vss sg13_hv_nmos w=2u l=0.45u m=1
XMMS0_69a t138 dhn0 m0_69 vss sg13_hv_nmos w=2u l=0.45u m=1
XMMS0_69b t139 dh0 m0_69 vss sg13_hv_nmos w=2u l=0.45u m=1
XMMS0_70a t140 dhn0 m0_70 vss sg13_hv_nmos w=2u l=0.45u m=1
XMMS0_70b t141 dh0 m0_70 vss sg13_hv_nmos w=2u l=0.45u m=1
XMMS0_71a t142 dhn0 m0_71 vss sg13_hv_nmos w=2u l=0.45u m=1
XMMS0_71b t143 dh0 m0_71 vss sg13_hv_nmos w=2u l=0.45u m=1
XMMS0_72a t144 dhn0 m0_72 vss sg13_hv_nmos w=2u l=0.45u m=1
XMMS0_72b t145 dh0 m0_72 vss sg13_hv_nmos w=2u l=0.45u m=1
XMMS0_73a t146 dhn0 m0_73 vss sg13_hv_nmos w=2u l=0.45u m=1
XMMS0_73b t147 dh0 m0_73 vss sg13_hv_nmos w=2u l=0.45u m=1
XMMS0_74a t148 dhn0 m0_74 vss sg13_hv_nmos w=2u l=0.45u m=1
XMMS0_74b t149 dh0 m0_74 vss sg13_hv_nmos w=2u l=0.45u m=1
XMMS0_75a t150 dhn0 m0_75 vss sg13_hv_nmos w=2u l=0.45u m=1
XMMS0_75b t151 dh0 m0_75 vss sg13_hv_nmos w=2u l=0.45u m=1
XMMS0_76a t152 dhn0 m0_76 vss sg13_hv_nmos w=2u l=0.45u m=1
XMMS0_76b t153 dh0 m0_76 vss sg13_hv_nmos w=2u l=0.45u m=1
XMMS0_77a t154 dhn0 m0_77 vss sg13_hv_nmos w=2u l=0.45u m=1
XMMS0_77b t155 dh0 m0_77 vss sg13_hv_nmos w=2u l=0.45u m=1
XMMS0_78a t156 dhn0 m0_78 vss sg13_hv_nmos w=2u l=0.45u m=1
XMMS0_78b t157 dh0 m0_78 vss sg13_hv_nmos w=2u l=0.45u m=1
XMMS0_79a t158 dhn0 m0_79 vss sg13_hv_nmos w=2u l=0.45u m=1
XMMS0_79b t159 dh0 m0_79 vss sg13_hv_nmos w=2u l=0.45u m=1
XMMS0_80a t160 dhn0 m0_80 vss sg13_hv_nmos w=2u l=0.45u m=1
XMMS0_80b t161 dh0 m0_80 vss sg13_hv_nmos w=2u l=0.45u m=1
XMMS0_81a t162 dhn0 m0_81 vss sg13_hv_nmos w=2u l=0.45u m=1
XMMS0_81b t163 dh0 m0_81 vss sg13_hv_nmos w=2u l=0.45u m=1
XMMS0_82a t164 dhn0 m0_82 vss sg13_hv_nmos w=2u l=0.45u m=1
XMMS0_82b t165 dh0 m0_82 vss sg13_hv_nmos w=2u l=0.45u m=1
XMMS0_83a t166 dhn0 m0_83 vss sg13_hv_nmos w=2u l=0.45u m=1
XMMS0_83b t167 dh0 m0_83 vss sg13_hv_nmos w=2u l=0.45u m=1
XMMS0_84a t168 dhn0 m0_84 vss sg13_hv_nmos w=2u l=0.45u m=1
XMMS0_84b t169 dh0 m0_84 vss sg13_hv_nmos w=2u l=0.45u m=1
XMMS0_85a t170 dhn0 m0_85 vss sg13_hv_nmos w=2u l=0.45u m=1
XMMS0_85b t171 dh0 m0_85 vss sg13_hv_nmos w=2u l=0.45u m=1
XMMS0_86a t172 dhn0 m0_86 vss sg13_hv_nmos w=2u l=0.45u m=1
XMMS0_86b t173 dh0 m0_86 vss sg13_hv_nmos w=2u l=0.45u m=1
XMMS0_87a t174 dhn0 m0_87 vss sg13_hv_nmos w=2u l=0.45u m=1
XMMS0_87b t175 dh0 m0_87 vss sg13_hv_nmos w=2u l=0.45u m=1
XMMS0_88a t176 dhn0 m0_88 vss sg13_hv_nmos w=2u l=0.45u m=1
XMMS0_88b t177 dh0 m0_88 vss sg13_hv_nmos w=2u l=0.45u m=1
XMMS0_89a t178 dhn0 m0_89 vss sg13_hv_nmos w=2u l=0.45u m=1
XMMS0_89b t179 dh0 m0_89 vss sg13_hv_nmos w=2u l=0.45u m=1
XMMS0_90a t180 dhn0 m0_90 vss sg13_hv_nmos w=2u l=0.45u m=1
XMMS0_90b t181 dh0 m0_90 vss sg13_hv_nmos w=2u l=0.45u m=1
XMMS0_91a t182 dhn0 m0_91 vss sg13_hv_nmos w=2u l=0.45u m=1
XMMS0_91b t183 dh0 m0_91 vss sg13_hv_nmos w=2u l=0.45u m=1
XMMS0_92a t184 dhn0 m0_92 vss sg13_hv_nmos w=2u l=0.45u m=1
XMMS0_92b t185 dh0 m0_92 vss sg13_hv_nmos w=2u l=0.45u m=1
XMMS0_93a t186 dhn0 m0_93 vss sg13_hv_nmos w=2u l=0.45u m=1
XMMS0_93b t187 dh0 m0_93 vss sg13_hv_nmos w=2u l=0.45u m=1
XMMS0_94a t188 dhn0 m0_94 vss sg13_hv_nmos w=2u l=0.45u m=1
XMMS0_94b t189 dh0 m0_94 vss sg13_hv_nmos w=2u l=0.45u m=1
XMMS0_95a t190 dhn0 m0_95 vss sg13_hv_nmos w=2u l=0.45u m=1
XMMS0_95b t191 dh0 m0_95 vss sg13_hv_nmos w=2u l=0.45u m=1
XMMS0_96a t192 dhn0 m0_96 vss sg13_hv_nmos w=2u l=0.45u m=1
XMMS0_96b t193 dh0 m0_96 vss sg13_hv_nmos w=2u l=0.45u m=1
XMMS0_97a t194 dhn0 m0_97 vss sg13_hv_nmos w=2u l=0.45u m=1
XMMS0_97b t195 dh0 m0_97 vss sg13_hv_nmos w=2u l=0.45u m=1
XMMS0_98a t196 dhn0 m0_98 vss sg13_hv_nmos w=2u l=0.45u m=1
XMMS0_98b t197 dh0 m0_98 vss sg13_hv_nmos w=2u l=0.45u m=1
XMMS0_99a t198 dhn0 m0_99 vss sg13_hv_nmos w=2u l=0.45u m=1
XMMS0_99b t199 dh0 m0_99 vss sg13_hv_nmos w=2u l=0.45u m=1
XMMS0_100a t200 dhn0 m0_100 vss sg13_hv_nmos w=2u l=0.45u m=1
XMMS0_100b t201 dh0 m0_100 vss sg13_hv_nmos w=2u l=0.45u m=1
XMMS0_101a t202 dhn0 m0_101 vss sg13_hv_nmos w=2u l=0.45u m=1
XMMS0_101b t203 dh0 m0_101 vss sg13_hv_nmos w=2u l=0.45u m=1
XMMS0_102a t204 dhn0 m0_102 vss sg13_hv_nmos w=2u l=0.45u m=1
XMMS0_102b t205 dh0 m0_102 vss sg13_hv_nmos w=2u l=0.45u m=1
XMMS0_103a t206 dhn0 m0_103 vss sg13_hv_nmos w=2u l=0.45u m=1
XMMS0_103b t207 dh0 m0_103 vss sg13_hv_nmos w=2u l=0.45u m=1
XMMS0_104a t208 dhn0 m0_104 vss sg13_hv_nmos w=2u l=0.45u m=1
XMMS0_104b t209 dh0 m0_104 vss sg13_hv_nmos w=2u l=0.45u m=1
XMMS0_105a t210 dhn0 m0_105 vss sg13_hv_nmos w=2u l=0.45u m=1
XMMS0_105b t211 dh0 m0_105 vss sg13_hv_nmos w=2u l=0.45u m=1
XMMS0_106a t212 dhn0 m0_106 vss sg13_hv_nmos w=2u l=0.45u m=1
XMMS0_106b t213 dh0 m0_106 vss sg13_hv_nmos w=2u l=0.45u m=1
XMMS0_107a t214 dhn0 m0_107 vss sg13_hv_nmos w=2u l=0.45u m=1
XMMS0_107b t215 dh0 m0_107 vss sg13_hv_nmos w=2u l=0.45u m=1
XMMS0_108a t216 dhn0 m0_108 vss sg13_hv_nmos w=2u l=0.45u m=1
XMMS0_108b t217 dh0 m0_108 vss sg13_hv_nmos w=2u l=0.45u m=1
XMMS0_109a t218 dhn0 m0_109 vss sg13_hv_nmos w=2u l=0.45u m=1
XMMS0_109b t219 dh0 m0_109 vss sg13_hv_nmos w=2u l=0.45u m=1
XMMS0_110a t220 dhn0 m0_110 vss sg13_hv_nmos w=2u l=0.45u m=1
XMMS0_110b t221 dh0 m0_110 vss sg13_hv_nmos w=2u l=0.45u m=1
XMMS0_111a t222 dhn0 m0_111 vss sg13_hv_nmos w=2u l=0.45u m=1
XMMS0_111b t223 dh0 m0_111 vss sg13_hv_nmos w=2u l=0.45u m=1
XMMS0_112a t224 dhn0 m0_112 vss sg13_hv_nmos w=2u l=0.45u m=1
XMMS0_112b t225 dh0 m0_112 vss sg13_hv_nmos w=2u l=0.45u m=1
XMMS0_113a t226 dhn0 m0_113 vss sg13_hv_nmos w=2u l=0.45u m=1
XMMS0_113b t227 dh0 m0_113 vss sg13_hv_nmos w=2u l=0.45u m=1
XMMS0_114a t228 dhn0 m0_114 vss sg13_hv_nmos w=2u l=0.45u m=1
XMMS0_114b t229 dh0 m0_114 vss sg13_hv_nmos w=2u l=0.45u m=1
XMMS0_115a t230 dhn0 m0_115 vss sg13_hv_nmos w=2u l=0.45u m=1
XMMS0_115b t231 dh0 m0_115 vss sg13_hv_nmos w=2u l=0.45u m=1
XMMS0_116a t232 dhn0 m0_116 vss sg13_hv_nmos w=2u l=0.45u m=1
XMMS0_116b t233 dh0 m0_116 vss sg13_hv_nmos w=2u l=0.45u m=1
XMMS0_117a t234 dhn0 m0_117 vss sg13_hv_nmos w=2u l=0.45u m=1
XMMS0_117b t235 dh0 m0_117 vss sg13_hv_nmos w=2u l=0.45u m=1
XMMS0_118a t236 dhn0 m0_118 vss sg13_hv_nmos w=2u l=0.45u m=1
XMMS0_118b t237 dh0 m0_118 vss sg13_hv_nmos w=2u l=0.45u m=1
XMMS0_119a t238 dhn0 m0_119 vss sg13_hv_nmos w=2u l=0.45u m=1
XMMS0_119b t239 dh0 m0_119 vss sg13_hv_nmos w=2u l=0.45u m=1
XMMS0_120a t240 dhn0 m0_120 vss sg13_hv_nmos w=2u l=0.45u m=1
XMMS0_120b t241 dh0 m0_120 vss sg13_hv_nmos w=2u l=0.45u m=1
XMMS0_121a t242 dhn0 m0_121 vss sg13_hv_nmos w=2u l=0.45u m=1
XMMS0_121b t243 dh0 m0_121 vss sg13_hv_nmos w=2u l=0.45u m=1
XMMS0_122a t244 dhn0 m0_122 vss sg13_hv_nmos w=2u l=0.45u m=1
XMMS0_122b t245 dh0 m0_122 vss sg13_hv_nmos w=2u l=0.45u m=1
XMMS0_123a t246 dhn0 m0_123 vss sg13_hv_nmos w=2u l=0.45u m=1
XMMS0_123b t247 dh0 m0_123 vss sg13_hv_nmos w=2u l=0.45u m=1
XMMS0_124a t248 dhn0 m0_124 vss sg13_hv_nmos w=2u l=0.45u m=1
XMMS0_124b t249 dh0 m0_124 vss sg13_hv_nmos w=2u l=0.45u m=1
XMMS0_125a t250 dhn0 m0_125 vss sg13_hv_nmos w=2u l=0.45u m=1
XMMS0_125b t251 dh0 m0_125 vss sg13_hv_nmos w=2u l=0.45u m=1
XMMS0_126a t252 dhn0 m0_126 vss sg13_hv_nmos w=2u l=0.45u m=1
XMMS0_126b t253 dh0 m0_126 vss sg13_hv_nmos w=2u l=0.45u m=1
XMMS0_127a t254 dhn0 m0_127 vss sg13_hv_nmos w=2u l=0.45u m=1
XMMS0_127b t255 dh0 m0_127 vss sg13_hv_nmos w=2u l=0.45u m=1
XMMS1_0a m0_0 dhn1 m1_0 vss sg13_hv_nmos w=2u l=0.45u m=1
XMMS1_0b m0_1 dh1 m1_0 vss sg13_hv_nmos w=2u l=0.45u m=1
XMMS1_1a m0_2 dhn1 m1_1 vss sg13_hv_nmos w=2u l=0.45u m=1
XMMS1_1b m0_3 dh1 m1_1 vss sg13_hv_nmos w=2u l=0.45u m=1
XMMS1_2a m0_4 dhn1 m1_2 vss sg13_hv_nmos w=2u l=0.45u m=1
XMMS1_2b m0_5 dh1 m1_2 vss sg13_hv_nmos w=2u l=0.45u m=1
XMMS1_3a m0_6 dhn1 m1_3 vss sg13_hv_nmos w=2u l=0.45u m=1
XMMS1_3b m0_7 dh1 m1_3 vss sg13_hv_nmos w=2u l=0.45u m=1
XMMS1_4a m0_8 dhn1 m1_4 vss sg13_hv_nmos w=2u l=0.45u m=1
XMMS1_4b m0_9 dh1 m1_4 vss sg13_hv_nmos w=2u l=0.45u m=1
XMMS1_5a m0_10 dhn1 m1_5 vss sg13_hv_nmos w=2u l=0.45u m=1
XMMS1_5b m0_11 dh1 m1_5 vss sg13_hv_nmos w=2u l=0.45u m=1
XMMS1_6a m0_12 dhn1 m1_6 vss sg13_hv_nmos w=2u l=0.45u m=1
XMMS1_6b m0_13 dh1 m1_6 vss sg13_hv_nmos w=2u l=0.45u m=1
XMMS1_7a m0_14 dhn1 m1_7 vss sg13_hv_nmos w=2u l=0.45u m=1
XMMS1_7b m0_15 dh1 m1_7 vss sg13_hv_nmos w=2u l=0.45u m=1
XMMS1_8a m0_16 dhn1 m1_8 vss sg13_hv_nmos w=2u l=0.45u m=1
XMMS1_8b m0_17 dh1 m1_8 vss sg13_hv_nmos w=2u l=0.45u m=1
XMMS1_9a m0_18 dhn1 m1_9 vss sg13_hv_nmos w=2u l=0.45u m=1
XMMS1_9b m0_19 dh1 m1_9 vss sg13_hv_nmos w=2u l=0.45u m=1
XMMS1_10a m0_20 dhn1 m1_10 vss sg13_hv_nmos w=2u l=0.45u m=1
XMMS1_10b m0_21 dh1 m1_10 vss sg13_hv_nmos w=2u l=0.45u m=1
XMMS1_11a m0_22 dhn1 m1_11 vss sg13_hv_nmos w=2u l=0.45u m=1
XMMS1_11b m0_23 dh1 m1_11 vss sg13_hv_nmos w=2u l=0.45u m=1
XMMS1_12a m0_24 dhn1 m1_12 vss sg13_hv_nmos w=2u l=0.45u m=1
XMMS1_12b m0_25 dh1 m1_12 vss sg13_hv_nmos w=2u l=0.45u m=1
XMMS1_13a m0_26 dhn1 m1_13 vss sg13_hv_nmos w=2u l=0.45u m=1
XMMS1_13b m0_27 dh1 m1_13 vss sg13_hv_nmos w=2u l=0.45u m=1
XMMS1_14a m0_28 dhn1 m1_14 vss sg13_hv_nmos w=2u l=0.45u m=1
XMMS1_14b m0_29 dh1 m1_14 vss sg13_hv_nmos w=2u l=0.45u m=1
XMMS1_15a m0_30 dhn1 m1_15 vss sg13_hv_nmos w=2u l=0.45u m=1
XMMS1_15b m0_31 dh1 m1_15 vss sg13_hv_nmos w=2u l=0.45u m=1
XMMS1_16a m0_32 dhn1 m1_16 vss sg13_hv_nmos w=2u l=0.45u m=1
XMMS1_16b m0_33 dh1 m1_16 vss sg13_hv_nmos w=2u l=0.45u m=1
XMMS1_17a m0_34 dhn1 m1_17 vss sg13_hv_nmos w=2u l=0.45u m=1
XMMS1_17b m0_35 dh1 m1_17 vss sg13_hv_nmos w=2u l=0.45u m=1
XMMS1_18a m0_36 dhn1 m1_18 vss sg13_hv_nmos w=2u l=0.45u m=1
XMMS1_18b m0_37 dh1 m1_18 vss sg13_hv_nmos w=2u l=0.45u m=1
XMMS1_19a m0_38 dhn1 m1_19 vss sg13_hv_nmos w=2u l=0.45u m=1
XMMS1_19b m0_39 dh1 m1_19 vss sg13_hv_nmos w=2u l=0.45u m=1
XMMS1_20a m0_40 dhn1 m1_20 vss sg13_hv_nmos w=2u l=0.45u m=1
XMMS1_20b m0_41 dh1 m1_20 vss sg13_hv_nmos w=2u l=0.45u m=1
XMMS1_21a m0_42 dhn1 m1_21 vss sg13_hv_nmos w=2u l=0.45u m=1
XMMS1_21b m0_43 dh1 m1_21 vss sg13_hv_nmos w=2u l=0.45u m=1
XMMS1_22a m0_44 dhn1 m1_22 vss sg13_hv_nmos w=2u l=0.45u m=1
XMMS1_22b m0_45 dh1 m1_22 vss sg13_hv_nmos w=2u l=0.45u m=1
XMMS1_23a m0_46 dhn1 m1_23 vss sg13_hv_nmos w=2u l=0.45u m=1
XMMS1_23b m0_47 dh1 m1_23 vss sg13_hv_nmos w=2u l=0.45u m=1
XMMS1_24a m0_48 dhn1 m1_24 vss sg13_hv_nmos w=2u l=0.45u m=1
XMMS1_24b m0_49 dh1 m1_24 vss sg13_hv_nmos w=2u l=0.45u m=1
XMMS1_25a m0_50 dhn1 m1_25 vss sg13_hv_nmos w=2u l=0.45u m=1
XMMS1_25b m0_51 dh1 m1_25 vss sg13_hv_nmos w=2u l=0.45u m=1
XMMS1_26a m0_52 dhn1 m1_26 vss sg13_hv_nmos w=2u l=0.45u m=1
XMMS1_26b m0_53 dh1 m1_26 vss sg13_hv_nmos w=2u l=0.45u m=1
XMMS1_27a m0_54 dhn1 m1_27 vss sg13_hv_nmos w=2u l=0.45u m=1
XMMS1_27b m0_55 dh1 m1_27 vss sg13_hv_nmos w=2u l=0.45u m=1
XMMS1_28a m0_56 dhn1 m1_28 vss sg13_hv_nmos w=2u l=0.45u m=1
XMMS1_28b m0_57 dh1 m1_28 vss sg13_hv_nmos w=2u l=0.45u m=1
XMMS1_29a m0_58 dhn1 m1_29 vss sg13_hv_nmos w=2u l=0.45u m=1
XMMS1_29b m0_59 dh1 m1_29 vss sg13_hv_nmos w=2u l=0.45u m=1
XMMS1_30a m0_60 dhn1 m1_30 vss sg13_hv_nmos w=2u l=0.45u m=1
XMMS1_30b m0_61 dh1 m1_30 vss sg13_hv_nmos w=2u l=0.45u m=1
XMMS1_31a m0_62 dhn1 m1_31 vss sg13_hv_nmos w=2u l=0.45u m=1
XMMS1_31b m0_63 dh1 m1_31 vss sg13_hv_nmos w=2u l=0.45u m=1
XMMS1_32a m0_64 dhn1 m1_32 vss sg13_hv_nmos w=2u l=0.45u m=1
XMMS1_32b m0_65 dh1 m1_32 vss sg13_hv_nmos w=2u l=0.45u m=1
XMMS1_33a m0_66 dhn1 m1_33 vss sg13_hv_nmos w=2u l=0.45u m=1
XMMS1_33b m0_67 dh1 m1_33 vss sg13_hv_nmos w=2u l=0.45u m=1
XMMS1_34a m0_68 dhn1 m1_34 vss sg13_hv_nmos w=2u l=0.45u m=1
XMMS1_34b m0_69 dh1 m1_34 vss sg13_hv_nmos w=2u l=0.45u m=1
XMMS1_35a m0_70 dhn1 m1_35 vss sg13_hv_nmos w=2u l=0.45u m=1
XMMS1_35b m0_71 dh1 m1_35 vss sg13_hv_nmos w=2u l=0.45u m=1
XMMS1_36a m0_72 dhn1 m1_36 vss sg13_hv_nmos w=2u l=0.45u m=1
XMMS1_36b m0_73 dh1 m1_36 vss sg13_hv_nmos w=2u l=0.45u m=1
XMMS1_37a m0_74 dhn1 m1_37 vss sg13_hv_nmos w=2u l=0.45u m=1
XMMS1_37b m0_75 dh1 m1_37 vss sg13_hv_nmos w=2u l=0.45u m=1
XMMS1_38a m0_76 dhn1 m1_38 vss sg13_hv_nmos w=2u l=0.45u m=1
XMMS1_38b m0_77 dh1 m1_38 vss sg13_hv_nmos w=2u l=0.45u m=1
XMMS1_39a m0_78 dhn1 m1_39 vss sg13_hv_nmos w=2u l=0.45u m=1
XMMS1_39b m0_79 dh1 m1_39 vss sg13_hv_nmos w=2u l=0.45u m=1
XMMS1_40a m0_80 dhn1 m1_40 vss sg13_hv_nmos w=2u l=0.45u m=1
XMMS1_40b m0_81 dh1 m1_40 vss sg13_hv_nmos w=2u l=0.45u m=1
XMMS1_41a m0_82 dhn1 m1_41 vss sg13_hv_nmos w=2u l=0.45u m=1
XMMS1_41b m0_83 dh1 m1_41 vss sg13_hv_nmos w=2u l=0.45u m=1
XMMS1_42a m0_84 dhn1 m1_42 vss sg13_hv_nmos w=2u l=0.45u m=1
XMMS1_42b m0_85 dh1 m1_42 vss sg13_hv_nmos w=2u l=0.45u m=1
XMMS1_43a m0_86 dhn1 m1_43 vss sg13_hv_nmos w=2u l=0.45u m=1
XMMS1_43b m0_87 dh1 m1_43 vss sg13_hv_nmos w=2u l=0.45u m=1
XMMS1_44a m0_88 dhn1 m1_44 vss sg13_hv_nmos w=2u l=0.45u m=1
XMMS1_44b m0_89 dh1 m1_44 vss sg13_hv_nmos w=2u l=0.45u m=1
XMMS1_45a m0_90 dhn1 m1_45 vss sg13_hv_nmos w=2u l=0.45u m=1
XMMS1_45b m0_91 dh1 m1_45 vss sg13_hv_nmos w=2u l=0.45u m=1
XMMS1_46a m0_92 dhn1 m1_46 vss sg13_hv_nmos w=2u l=0.45u m=1
XMMS1_46b m0_93 dh1 m1_46 vss sg13_hv_nmos w=2u l=0.45u m=1
XMMS1_47a m0_94 dhn1 m1_47 vss sg13_hv_nmos w=2u l=0.45u m=1
XMMS1_47b m0_95 dh1 m1_47 vss sg13_hv_nmos w=2u l=0.45u m=1
XMMS1_48a m0_96 dhn1 m1_48 vss sg13_hv_nmos w=2u l=0.45u m=1
XMMS1_48b m0_97 dh1 m1_48 vss sg13_hv_nmos w=2u l=0.45u m=1
XMMS1_49a m0_98 dhn1 m1_49 vss sg13_hv_nmos w=2u l=0.45u m=1
XMMS1_49b m0_99 dh1 m1_49 vss sg13_hv_nmos w=2u l=0.45u m=1
XMMS1_50a m0_100 dhn1 m1_50 vss sg13_hv_nmos w=2u l=0.45u m=1
XMMS1_50b m0_101 dh1 m1_50 vss sg13_hv_nmos w=2u l=0.45u m=1
XMMS1_51a m0_102 dhn1 m1_51 vss sg13_hv_nmos w=2u l=0.45u m=1
XMMS1_51b m0_103 dh1 m1_51 vss sg13_hv_nmos w=2u l=0.45u m=1
XMMS1_52a m0_104 dhn1 m1_52 vss sg13_hv_nmos w=2u l=0.45u m=1
XMMS1_52b m0_105 dh1 m1_52 vss sg13_hv_nmos w=2u l=0.45u m=1
XMMS1_53a m0_106 dhn1 m1_53 vss sg13_hv_nmos w=2u l=0.45u m=1
XMMS1_53b m0_107 dh1 m1_53 vss sg13_hv_nmos w=2u l=0.45u m=1
XMMS1_54a m0_108 dhn1 m1_54 vss sg13_hv_nmos w=2u l=0.45u m=1
XMMS1_54b m0_109 dh1 m1_54 vss sg13_hv_nmos w=2u l=0.45u m=1
XMMS1_55a m0_110 dhn1 m1_55 vss sg13_hv_nmos w=2u l=0.45u m=1
XMMS1_55b m0_111 dh1 m1_55 vss sg13_hv_nmos w=2u l=0.45u m=1
XMMS1_56a m0_112 dhn1 m1_56 vss sg13_hv_nmos w=2u l=0.45u m=1
XMMS1_56b m0_113 dh1 m1_56 vss sg13_hv_nmos w=2u l=0.45u m=1
XMMS1_57a m0_114 dhn1 m1_57 vss sg13_hv_nmos w=2u l=0.45u m=1
XMMS1_57b m0_115 dh1 m1_57 vss sg13_hv_nmos w=2u l=0.45u m=1
XMMS1_58a m0_116 dhn1 m1_58 vss sg13_hv_nmos w=2u l=0.45u m=1
XMMS1_58b m0_117 dh1 m1_58 vss sg13_hv_nmos w=2u l=0.45u m=1
XMMS1_59a m0_118 dhn1 m1_59 vss sg13_hv_nmos w=2u l=0.45u m=1
XMMS1_59b m0_119 dh1 m1_59 vss sg13_hv_nmos w=2u l=0.45u m=1
XMMS1_60a m0_120 dhn1 m1_60 vss sg13_hv_nmos w=2u l=0.45u m=1
XMMS1_60b m0_121 dh1 m1_60 vss sg13_hv_nmos w=2u l=0.45u m=1
XMMS1_61a m0_122 dhn1 m1_61 vss sg13_hv_nmos w=2u l=0.45u m=1
XMMS1_61b m0_123 dh1 m1_61 vss sg13_hv_nmos w=2u l=0.45u m=1
XMMS1_62a m0_124 dhn1 m1_62 vss sg13_hv_nmos w=2u l=0.45u m=1
XMMS1_62b m0_125 dh1 m1_62 vss sg13_hv_nmos w=2u l=0.45u m=1
XMMS1_63a m0_126 dhn1 m1_63 vss sg13_hv_nmos w=2u l=0.45u m=1
XMMS1_63b m0_127 dh1 m1_63 vss sg13_hv_nmos w=2u l=0.45u m=1
XMMS2_0a m1_0 dhn2 m2_0 vss sg13_hv_nmos w=2u l=0.45u m=1
XMMS2_0b m1_1 dh2 m2_0 vss sg13_hv_nmos w=2u l=0.45u m=1
XMMS2_1a m1_2 dhn2 m2_1 vss sg13_hv_nmos w=2u l=0.45u m=1
XMMS2_1b m1_3 dh2 m2_1 vss sg13_hv_nmos w=2u l=0.45u m=1
XMMS2_2a m1_4 dhn2 m2_2 vss sg13_hv_nmos w=2u l=0.45u m=1
XMMS2_2b m1_5 dh2 m2_2 vss sg13_hv_nmos w=2u l=0.45u m=1
XMMS2_3a m1_6 dhn2 m2_3 vss sg13_hv_nmos w=2u l=0.45u m=1
XMMS2_3b m1_7 dh2 m2_3 vss sg13_hv_nmos w=2u l=0.45u m=1
XMMS2_4a m1_8 dhn2 m2_4 vss sg13_hv_nmos w=2u l=0.45u m=1
XMMS2_4b m1_9 dh2 m2_4 vss sg13_hv_nmos w=2u l=0.45u m=1
XMMS2_5a m1_10 dhn2 m2_5 vss sg13_hv_nmos w=2u l=0.45u m=1
XMMS2_5b m1_11 dh2 m2_5 vss sg13_hv_nmos w=2u l=0.45u m=1
XMMS2_6a m1_12 dhn2 m2_6 vss sg13_hv_nmos w=2u l=0.45u m=1
XMMS2_6b m1_13 dh2 m2_6 vss sg13_hv_nmos w=2u l=0.45u m=1
XMMS2_7a m1_14 dhn2 m2_7 vss sg13_hv_nmos w=2u l=0.45u m=1
XMMS2_7b m1_15 dh2 m2_7 vss sg13_hv_nmos w=2u l=0.45u m=1
XMMS2_8a m1_16 dhn2 m2_8 vss sg13_hv_nmos w=2u l=0.45u m=1
XMMS2_8b m1_17 dh2 m2_8 vss sg13_hv_nmos w=2u l=0.45u m=1
XMMS2_9a m1_18 dhn2 m2_9 vss sg13_hv_nmos w=2u l=0.45u m=1
XMMS2_9b m1_19 dh2 m2_9 vss sg13_hv_nmos w=2u l=0.45u m=1
XMMS2_10a m1_20 dhn2 m2_10 vss sg13_hv_nmos w=2u l=0.45u m=1
XMMS2_10b m1_21 dh2 m2_10 vss sg13_hv_nmos w=2u l=0.45u m=1
XMMS2_11a m1_22 dhn2 m2_11 vss sg13_hv_nmos w=2u l=0.45u m=1
XMMS2_11b m1_23 dh2 m2_11 vss sg13_hv_nmos w=2u l=0.45u m=1
XMMS2_12a m1_24 dhn2 m2_12 vss sg13_hv_nmos w=2u l=0.45u m=1
XMMS2_12b m1_25 dh2 m2_12 vss sg13_hv_nmos w=2u l=0.45u m=1
XMMS2_13a m1_26 dhn2 m2_13 vss sg13_hv_nmos w=2u l=0.45u m=1
XMMS2_13b m1_27 dh2 m2_13 vss sg13_hv_nmos w=2u l=0.45u m=1
XMMS2_14a m1_28 dhn2 m2_14 vss sg13_hv_nmos w=2u l=0.45u m=1
XMMS2_14b m1_29 dh2 m2_14 vss sg13_hv_nmos w=2u l=0.45u m=1
XMMS2_15a m1_30 dhn2 m2_15 vss sg13_hv_nmos w=2u l=0.45u m=1
XMMS2_15b m1_31 dh2 m2_15 vss sg13_hv_nmos w=2u l=0.45u m=1
XMMS2_16a m1_32 dhn2 m2_16 vss sg13_hv_nmos w=2u l=0.45u m=1
XMMS2_16b m1_33 dh2 m2_16 vss sg13_hv_nmos w=2u l=0.45u m=1
XMMS2_17a m1_34 dhn2 m2_17 vss sg13_hv_nmos w=2u l=0.45u m=1
XMMS2_17b m1_35 dh2 m2_17 vss sg13_hv_nmos w=2u l=0.45u m=1
XMMS2_18a m1_36 dhn2 m2_18 vss sg13_hv_nmos w=2u l=0.45u m=1
XMMS2_18b m1_37 dh2 m2_18 vss sg13_hv_nmos w=2u l=0.45u m=1
XMMS2_19a m1_38 dhn2 m2_19 vss sg13_hv_nmos w=2u l=0.45u m=1
XMMS2_19b m1_39 dh2 m2_19 vss sg13_hv_nmos w=2u l=0.45u m=1
XMMS2_20a m1_40 dhn2 m2_20 vss sg13_hv_nmos w=2u l=0.45u m=1
XMMS2_20b m1_41 dh2 m2_20 vss sg13_hv_nmos w=2u l=0.45u m=1
XMMS2_21a m1_42 dhn2 m2_21 vss sg13_hv_nmos w=2u l=0.45u m=1
XMMS2_21b m1_43 dh2 m2_21 vss sg13_hv_nmos w=2u l=0.45u m=1
XMMS2_22a m1_44 dhn2 m2_22 vss sg13_hv_nmos w=2u l=0.45u m=1
XMMS2_22b m1_45 dh2 m2_22 vss sg13_hv_nmos w=2u l=0.45u m=1
XMMS2_23a m1_46 dhn2 m2_23 vss sg13_hv_nmos w=2u l=0.45u m=1
XMMS2_23b m1_47 dh2 m2_23 vss sg13_hv_nmos w=2u l=0.45u m=1
XMMS2_24a m1_48 dhn2 m2_24 vss sg13_hv_nmos w=2u l=0.45u m=1
XMMS2_24b m1_49 dh2 m2_24 vss sg13_hv_nmos w=2u l=0.45u m=1
XMMS2_25a m1_50 dhn2 m2_25 vss sg13_hv_nmos w=2u l=0.45u m=1
XMMS2_25b m1_51 dh2 m2_25 vss sg13_hv_nmos w=2u l=0.45u m=1
XMMS2_26a m1_52 dhn2 m2_26 vss sg13_hv_nmos w=2u l=0.45u m=1
XMMS2_26b m1_53 dh2 m2_26 vss sg13_hv_nmos w=2u l=0.45u m=1
XMMS2_27a m1_54 dhn2 m2_27 vss sg13_hv_nmos w=2u l=0.45u m=1
XMMS2_27b m1_55 dh2 m2_27 vss sg13_hv_nmos w=2u l=0.45u m=1
XMMS2_28a m1_56 dhn2 m2_28 vss sg13_hv_nmos w=2u l=0.45u m=1
XMMS2_28b m1_57 dh2 m2_28 vss sg13_hv_nmos w=2u l=0.45u m=1
XMMS2_29a m1_58 dhn2 m2_29 vss sg13_hv_nmos w=2u l=0.45u m=1
XMMS2_29b m1_59 dh2 m2_29 vss sg13_hv_nmos w=2u l=0.45u m=1
XMMS2_30a m1_60 dhn2 m2_30 vss sg13_hv_nmos w=2u l=0.45u m=1
XMMS2_30b m1_61 dh2 m2_30 vss sg13_hv_nmos w=2u l=0.45u m=1
XMMS2_31a m1_62 dhn2 m2_31 vss sg13_hv_nmos w=2u l=0.45u m=1
XMMS2_31b m1_63 dh2 m2_31 vss sg13_hv_nmos w=2u l=0.45u m=1
XMMS3_0a m2_0 dhn3 m3_0 vss sg13_hv_nmos w=2u l=0.45u m=1
XMMS3_0b m2_1 dh3 m3_0 vss sg13_hv_nmos w=2u l=0.45u m=1
XMMS3_1a m2_2 dhn3 m3_1 vss sg13_hv_nmos w=2u l=0.45u m=1
XMMS3_1b m2_3 dh3 m3_1 vss sg13_hv_nmos w=2u l=0.45u m=1
XMMS3_2a m2_4 dhn3 m3_2 vss sg13_hv_nmos w=2u l=0.45u m=1
XMMS3_2b m2_5 dh3 m3_2 vss sg13_hv_nmos w=2u l=0.45u m=1
XMMS3_3a m2_6 dhn3 m3_3 vss sg13_hv_nmos w=2u l=0.45u m=1
XMMS3_3b m2_7 dh3 m3_3 vss sg13_hv_nmos w=2u l=0.45u m=1
XMMS3_4a m2_8 dhn3 m3_4 vss sg13_hv_nmos w=2u l=0.45u m=1
XMMS3_4b m2_9 dh3 m3_4 vss sg13_hv_nmos w=2u l=0.45u m=1
XMMS3_5a m2_10 dhn3 m3_5 vss sg13_hv_nmos w=2u l=0.45u m=1
XMMS3_5b m2_11 dh3 m3_5 vss sg13_hv_nmos w=2u l=0.45u m=1
XMMS3_6a m2_12 dhn3 m3_6 vss sg13_hv_nmos w=2u l=0.45u m=1
XMMS3_6b m2_13 dh3 m3_6 vss sg13_hv_nmos w=2u l=0.45u m=1
XMMS3_7a m2_14 dhn3 m3_7 vss sg13_hv_nmos w=2u l=0.45u m=1
XMMS3_7b m2_15 dh3 m3_7 vss sg13_hv_nmos w=2u l=0.45u m=1
XMMS3_8a m2_16 dhn3 m3_8 vss sg13_hv_nmos w=2u l=0.45u m=1
XMMS3_8b m2_17 dh3 m3_8 vss sg13_hv_nmos w=2u l=0.45u m=1
XMMS3_9a m2_18 dhn3 m3_9 vss sg13_hv_nmos w=2u l=0.45u m=1
XMMS3_9b m2_19 dh3 m3_9 vss sg13_hv_nmos w=2u l=0.45u m=1
XMMS3_10a m2_20 dhn3 m3_10 vss sg13_hv_nmos w=2u l=0.45u m=1
XMMS3_10b m2_21 dh3 m3_10 vss sg13_hv_nmos w=2u l=0.45u m=1
XMMS3_11a m2_22 dhn3 m3_11 vss sg13_hv_nmos w=2u l=0.45u m=1
XMMS3_11b m2_23 dh3 m3_11 vss sg13_hv_nmos w=2u l=0.45u m=1
XMMS3_12a m2_24 dhn3 m3_12 vss sg13_hv_nmos w=2u l=0.45u m=1
XMMS3_12b m2_25 dh3 m3_12 vss sg13_hv_nmos w=2u l=0.45u m=1
XMMS3_13a m2_26 dhn3 m3_13 vss sg13_hv_nmos w=2u l=0.45u m=1
XMMS3_13b m2_27 dh3 m3_13 vss sg13_hv_nmos w=2u l=0.45u m=1
XMMS3_14a m2_28 dhn3 m3_14 vss sg13_hv_nmos w=2u l=0.45u m=1
XMMS3_14b m2_29 dh3 m3_14 vss sg13_hv_nmos w=2u l=0.45u m=1
XMMS3_15a m2_30 dhn3 m3_15 vss sg13_hv_nmos w=2u l=0.45u m=1
XMMS3_15b m2_31 dh3 m3_15 vss sg13_hv_nmos w=2u l=0.45u m=1
XMMS4_0a m3_0 dhn4 m4_0 vss sg13_hv_nmos w=2u l=0.45u m=1
XMMS4_0b m3_1 dh4 m4_0 vss sg13_hv_nmos w=2u l=0.45u m=1
XMMS4_1a m3_2 dhn4 m4_1 vss sg13_hv_nmos w=2u l=0.45u m=1
XMMS4_1b m3_3 dh4 m4_1 vss sg13_hv_nmos w=2u l=0.45u m=1
XMMS4_2a m3_4 dhn4 m4_2 vss sg13_hv_nmos w=2u l=0.45u m=1
XMMS4_2b m3_5 dh4 m4_2 vss sg13_hv_nmos w=2u l=0.45u m=1
XMMS4_3a m3_6 dhn4 m4_3 vss sg13_hv_nmos w=2u l=0.45u m=1
XMMS4_3b m3_7 dh4 m4_3 vss sg13_hv_nmos w=2u l=0.45u m=1
XMMS4_4a m3_8 dhn4 m4_4 vss sg13_hv_nmos w=2u l=0.45u m=1
XMMS4_4b m3_9 dh4 m4_4 vss sg13_hv_nmos w=2u l=0.45u m=1
XMMS4_5a m3_10 dhn4 m4_5 vss sg13_hv_nmos w=2u l=0.45u m=1
XMMS4_5b m3_11 dh4 m4_5 vss sg13_hv_nmos w=2u l=0.45u m=1
XMMS4_6a m3_12 dhn4 m4_6 vss sg13_hv_nmos w=2u l=0.45u m=1
XMMS4_6b m3_13 dh4 m4_6 vss sg13_hv_nmos w=2u l=0.45u m=1
XMMS4_7a m3_14 dhn4 m4_7 vss sg13_hv_nmos w=2u l=0.45u m=1
XMMS4_7b m3_15 dh4 m4_7 vss sg13_hv_nmos w=2u l=0.45u m=1
XMMS5_0a m4_0 dhn5 m5_0 vss sg13_hv_nmos w=2u l=0.45u m=1
XMMS5_0b m4_1 dh5 m5_0 vss sg13_hv_nmos w=2u l=0.45u m=1
XMMS5_1a m4_2 dhn5 m5_1 vss sg13_hv_nmos w=2u l=0.45u m=1
XMMS5_1b m4_3 dh5 m5_1 vss sg13_hv_nmos w=2u l=0.45u m=1
XMMS5_2a m4_4 dhn5 m5_2 vss sg13_hv_nmos w=2u l=0.45u m=1
XMMS5_2b m4_5 dh5 m5_2 vss sg13_hv_nmos w=2u l=0.45u m=1
XMMS5_3a m4_6 dhn5 m5_3 vss sg13_hv_nmos w=2u l=0.45u m=1
XMMS5_3b m4_7 dh5 m5_3 vss sg13_hv_nmos w=2u l=0.45u m=1
XMMS6_0a m5_0 dhn6 m6_0 vss sg13_hv_nmos w=2u l=0.45u m=1
XMMS6_0b m5_1 dh6 m6_0 vss sg13_hv_nmos w=2u l=0.45u m=1
XMMS6_1a m5_2 dhn6 m6_1 vss sg13_hv_nmos w=2u l=0.45u m=1
XMMS6_1b m5_3 dh6 m6_1 vss sg13_hv_nmos w=2u l=0.45u m=1
XMMS7_0a m6_0 dhn7 out vss sg13_hv_nmos w=2u l=0.45u m=1
XMMS7_0b m6_1 dh7 out vss sg13_hv_nmos w=2u l=0.45u m=1
.ends g1_dac8
.subckt g1_cmp inp inn clk q qb vdd vss
XMMTAIL tail clk vss vss sg13_lv_nmos w=16u l=0.13u m=1
XMM1 xp inp tail vss sg13_lv_nmos w=24u l=0.68u m=1
XMM2 xq inn tail vss sg13_lv_nmos w=24u l=0.68u m=1
XMMD1 xq inp xq vss sg13_lv_nmos w=6u l=0.13u m=1
XMMD2 xp inn xp vss sg13_lv_nmos w=6u l=0.13u m=1
XMM3 xn yn xp vss sg13_lv_nmos w=3u l=0.13u m=1
XMM4 yn xn xq vss sg13_lv_nmos w=3u l=0.13u m=1
XMM5 xn yn vdd vdd sg13_lv_pmos w=3u l=0.13u m=1
XMM6 yn xn vdd vdd sg13_lv_pmos w=3u l=0.13u m=1
XMM7 xn clk vdd vdd sg13_lv_pmos w=6u l=0.13u m=1
XMM8 yn clk vdd vdd sg13_lv_pmos w=6u l=0.13u m=1
XMM9 xp clk vdd vdd sg13_lv_pmos w=3u l=0.13u m=1
XMM10 xq clk vdd vdd sg13_lv_pmos w=3u l=0.13u m=1
XMMIAP xnb xn vdd vdd sg13_lv_pmos w=1u l=0.13u m=1
XMMIAN xnb xn vss vss sg13_lv_nmos w=4u l=0.13u m=1
XMMIBP ynb yn vdd vdd sg13_lv_pmos w=1u l=0.13u m=1
XMMIBN ynb yn vss vss sg13_lv_nmos w=4u l=0.13u m=1
XMMNAP1 na xnb vdd vdd sg13_lv_pmos w=4u l=0.13u m=1
XMMNAP2 qb q na vdd sg13_lv_pmos w=4u l=0.13u m=1
XMMNAN1 qb xnb vss vss sg13_lv_nmos w=1.5u l=0.13u m=1
XMMNAN2 qb q vss vss sg13_lv_nmos w=1.5u l=0.13u m=1
XMMNBP1 nb ynb vdd vdd sg13_lv_pmos w=4u l=0.13u m=1
XMMNBP2 q qb nb vdd sg13_lv_pmos w=4u l=0.13u m=1
XMMNBN1 q ynb vss vss sg13_lv_nmos w=1.5u l=0.13u m=1
XMMNBN2 q qb vss vss sg13_lv_nmos w=1.5u l=0.13u m=1
.ends g1_cmp
.subckt g1_cmp_regenpair4 inp inn clk q qb vdd vss
XMMTAIL tail clk vss vss sg13_lv_nmos w=16u l=0.13u m=1
XMM1 xp inp tail vss sg13_lv_nmos w=12u l=0.34u m=1
XMM2 xq inn tail vss sg13_lv_nmos w=12u l=0.34u m=1
XMMD1 xq inp xq vss sg13_lv_nmos w=6u l=0.13u m=1
XMMD2 xp inn xp vss sg13_lv_nmos w=6u l=0.13u m=1
XMM3 xn yn xp vss sg13_lv_nmos w=6u l=0.26u m=1
XMM4 yn xn xq vss sg13_lv_nmos w=6u l=0.26u m=1
XMM5 xn yn vdd vdd sg13_lv_pmos w=3u l=0.13u m=1
XMM6 yn xn vdd vdd sg13_lv_pmos w=3u l=0.13u m=1
XMM7 xn clk vdd vdd sg13_lv_pmos w=6u l=0.13u m=1
XMM8 yn clk vdd vdd sg13_lv_pmos w=6u l=0.13u m=1
XMM9 xp clk vdd vdd sg13_lv_pmos w=3u l=0.13u m=1
XMM10 xq clk vdd vdd sg13_lv_pmos w=3u l=0.13u m=1
XMMIAP xnb xn vdd vdd sg13_lv_pmos w=1u l=0.13u m=1
XMMIAN xnb xn vss vss sg13_lv_nmos w=4u l=0.13u m=1
XMMIBP ynb yn vdd vdd sg13_lv_pmos w=1u l=0.13u m=1
XMMIBN ynb yn vss vss sg13_lv_nmos w=4u l=0.13u m=1
XMMNAP1 na xnb vdd vdd sg13_lv_pmos w=4u l=0.13u m=1
XMMNAP2 qb q na vdd sg13_lv_pmos w=4u l=0.13u m=1
XMMNAN1 qb xnb vss vss sg13_lv_nmos w=1.5u l=0.13u m=1
XMMNAN2 qb q vss vss sg13_lv_nmos w=1.5u l=0.13u m=1
XMMNBP1 nb ynb vdd vdd sg13_lv_pmos w=4u l=0.13u m=1
XMMNBP2 q qb nb vdd sg13_lv_pmos w=4u l=0.13u m=1
XMMNBN1 q ynb vss vss sg13_lv_nmos w=1.5u l=0.13u m=1
XMMNBN2 q qb vss vss sg13_lv_nmos w=1.5u l=0.13u m=1
.ends g1_cmp_regenpair4
.subckt g1_trip ISENSE VREF clk dac_soft_0_ dac_soft_1_ dac_soft_2_ dac_soft_3_ dac_soft_4_ dac_soft_5_ dac_soft_6_ dac_soft_7_ dac_hard_0_ dac_hard_1_ dac_hard_2_ dac_hard_3_ dac_hard_4_ dac_hard_5_ dac_hard_6_ dac_hard_7_ cmp_soft cmp_hard VDD IOVDD VSS
XCOND ISENSE icmp VSS g1_cond
XDACS VREF dac_soft_0_ dac_soft_1_ dac_soft_2_ dac_soft_3_ dac_soft_4_ dac_soft_5_ dac_soft_6_ dac_soft_7_ vth_soft VDD IOVDD VSS g1_dac8
XDACH VREF dac_hard_0_ dac_hard_1_ dac_hard_2_ dac_hard_3_ dac_hard_4_ dac_hard_5_ dac_hard_6_ dac_hard_7_ vth_hard VDD IOVDD VSS g1_dac8
XCCHS vth_soft VSS cap_cmim w=26u l=26u m=1
XCCHH vth_hard VSS cap_cmim w=26u l=26u m=1
XCLKI clk cmp_clk_n VDD VSS g1_inv
XCS icmp vth_soft clk cmp_soft cmp_soft_n VDD VSS g1_cmp
XCH icmp vth_hard cmp_clk_n cmp_hard cmp_hard_n VDD VSS g1_cmp_regenpair4
.ends g1_trip
.subckt G1_VSS_DERIVATIVE__sg13g2_Clamp_N43N43D4R gate iovss pad G1_EXPLICIT_SUBSTRATE_VSS
XMN0_1_ pad gate iovss G1_EXPLICIT_SUBSTRATE_VSS sg13_hv_nmos m=1 w=4.4u l=600.0n ng=1
XMN0_2_ pad gate iovss G1_EXPLICIT_SUBSTRATE_VSS sg13_hv_nmos m=1 w=4.4u l=600.0n ng=1
XMN0_3_ pad gate iovss G1_EXPLICIT_SUBSTRATE_VSS sg13_hv_nmos m=1 w=4.4u l=600.0n ng=1
XMN0_4_ pad gate iovss G1_EXPLICIT_SUBSTRATE_VSS sg13_hv_nmos m=1 w=4.4u l=600.0n ng=1
XMN0_5_ pad gate iovss G1_EXPLICIT_SUBSTRATE_VSS sg13_hv_nmos m=1 w=4.4u l=600.0n ng=1
XMN0_6_ pad gate iovss G1_EXPLICIT_SUBSTRATE_VSS sg13_hv_nmos m=1 w=4.4u l=600.0n ng=1
XMN0_7_ pad gate iovss G1_EXPLICIT_SUBSTRATE_VSS sg13_hv_nmos m=1 w=4.4u l=600.0n ng=1
XMN0_8_ pad gate iovss G1_EXPLICIT_SUBSTRATE_VSS sg13_hv_nmos m=1 w=4.4u l=600.0n ng=1
XMN0_9_ pad gate iovss G1_EXPLICIT_SUBSTRATE_VSS sg13_hv_nmos m=1 w=4.4u l=600.0n ng=1
XMN0_10_ pad gate iovss G1_EXPLICIT_SUBSTRATE_VSS sg13_hv_nmos m=1 w=4.4u l=600.0n ng=1
XMN0_11_ pad gate iovss G1_EXPLICIT_SUBSTRATE_VSS sg13_hv_nmos m=1 w=4.4u l=600.0n ng=1
XMN0_12_ pad gate iovss G1_EXPLICIT_SUBSTRATE_VSS sg13_hv_nmos m=1 w=4.4u l=600.0n ng=1
XMN0_13_ pad gate iovss G1_EXPLICIT_SUBSTRATE_VSS sg13_hv_nmos m=1 w=4.4u l=600.0n ng=1
XMN0_14_ pad gate iovss G1_EXPLICIT_SUBSTRATE_VSS sg13_hv_nmos m=1 w=4.4u l=600.0n ng=1
XMN0_15_ pad gate iovss G1_EXPLICIT_SUBSTRATE_VSS sg13_hv_nmos m=1 w=4.4u l=600.0n ng=1
XMN0_16_ pad gate iovss G1_EXPLICIT_SUBSTRATE_VSS sg13_hv_nmos m=1 w=4.4u l=600.0n ng=1
XMN0_17_ pad gate iovss G1_EXPLICIT_SUBSTRATE_VSS sg13_hv_nmos m=1 w=4.4u l=600.0n ng=1
XMN0_18_ pad gate iovss G1_EXPLICIT_SUBSTRATE_VSS sg13_hv_nmos m=1 w=4.4u l=600.0n ng=1
XMN0_19_ pad gate iovss G1_EXPLICIT_SUBSTRATE_VSS sg13_hv_nmos m=1 w=4.4u l=600.0n ng=1
XMN0_20_ pad gate iovss G1_EXPLICIT_SUBSTRATE_VSS sg13_hv_nmos m=1 w=4.4u l=600.0n ng=1
XMN0_21_ pad gate iovss G1_EXPLICIT_SUBSTRATE_VSS sg13_hv_nmos m=1 w=4.4u l=600.0n ng=1
XMN0_22_ pad gate iovss G1_EXPLICIT_SUBSTRATE_VSS sg13_hv_nmos m=1 w=4.4u l=600.0n ng=1
XMN0_23_ pad gate iovss G1_EXPLICIT_SUBSTRATE_VSS sg13_hv_nmos m=1 w=4.4u l=600.0n ng=1
XMN0_24_ pad gate iovss G1_EXPLICIT_SUBSTRATE_VSS sg13_hv_nmos m=1 w=4.4u l=600.0n ng=1
XMN0_25_ pad gate iovss G1_EXPLICIT_SUBSTRATE_VSS sg13_hv_nmos m=1 w=4.4u l=600.0n ng=1
XMN0_26_ pad gate iovss G1_EXPLICIT_SUBSTRATE_VSS sg13_hv_nmos m=1 w=4.4u l=600.0n ng=1
XMN0_27_ pad gate iovss G1_EXPLICIT_SUBSTRATE_VSS sg13_hv_nmos m=1 w=4.4u l=600.0n ng=1
XMN0_28_ pad gate iovss G1_EXPLICIT_SUBSTRATE_VSS sg13_hv_nmos m=1 w=4.4u l=600.0n ng=1
XMN0_29_ pad gate iovss G1_EXPLICIT_SUBSTRATE_VSS sg13_hv_nmos m=1 w=4.4u l=600.0n ng=1
XMN0_30_ pad gate iovss G1_EXPLICIT_SUBSTRATE_VSS sg13_hv_nmos m=1 w=4.4u l=600.0n ng=1
XMN0_31_ pad gate iovss G1_EXPLICIT_SUBSTRATE_VSS sg13_hv_nmos m=1 w=4.4u l=600.0n ng=1
XMN0_32_ pad gate iovss G1_EXPLICIT_SUBSTRATE_VSS sg13_hv_nmos m=1 w=4.4u l=600.0n ng=1
XMN0_33_ pad gate iovss G1_EXPLICIT_SUBSTRATE_VSS sg13_hv_nmos m=1 w=4.4u l=600.0n ng=1
XMN0_34_ pad gate iovss G1_EXPLICIT_SUBSTRATE_VSS sg13_hv_nmos m=1 w=4.4u l=600.0n ng=1
XMN0_35_ pad gate iovss G1_EXPLICIT_SUBSTRATE_VSS sg13_hv_nmos m=1 w=4.4u l=600.0n ng=1
XMN0_36_ pad gate iovss G1_EXPLICIT_SUBSTRATE_VSS sg13_hv_nmos m=1 w=4.4u l=600.0n ng=1
XMN0_37_ pad gate iovss G1_EXPLICIT_SUBSTRATE_VSS sg13_hv_nmos m=1 w=4.4u l=600.0n ng=1
XMN0_38_ pad gate iovss G1_EXPLICIT_SUBSTRATE_VSS sg13_hv_nmos m=1 w=4.4u l=600.0n ng=1
XMN0_39_ pad gate iovss G1_EXPLICIT_SUBSTRATE_VSS sg13_hv_nmos m=1 w=4.4u l=600.0n ng=1
XMN0_40_ pad gate iovss G1_EXPLICIT_SUBSTRATE_VSS sg13_hv_nmos m=1 w=4.4u l=600.0n ng=1
XMN0_41_ pad gate iovss G1_EXPLICIT_SUBSTRATE_VSS sg13_hv_nmos m=1 w=4.4u l=600.0n ng=1
XMN0_42_ pad gate iovss G1_EXPLICIT_SUBSTRATE_VSS sg13_hv_nmos m=1 w=4.4u l=600.0n ng=1
XMN0_43_ pad gate iovss G1_EXPLICIT_SUBSTRATE_VSS sg13_hv_nmos m=1 w=4.4u l=600.0n ng=1
XMN0_44_ pad gate iovss G1_EXPLICIT_SUBSTRATE_VSS sg13_hv_nmos m=1 w=4.4u l=600.0n ng=1
XMN0_45_ pad gate iovss G1_EXPLICIT_SUBSTRATE_VSS sg13_hv_nmos m=1 w=4.4u l=600.0n ng=1
XMN0_46_ pad gate iovss G1_EXPLICIT_SUBSTRATE_VSS sg13_hv_nmos m=1 w=4.4u l=600.0n ng=1
XMN0_47_ pad gate iovss G1_EXPLICIT_SUBSTRATE_VSS sg13_hv_nmos m=1 w=4.4u l=600.0n ng=1
XMN0_48_ pad gate iovss G1_EXPLICIT_SUBSTRATE_VSS sg13_hv_nmos m=1 w=4.4u l=600.0n ng=1
XMN0_49_ pad gate iovss G1_EXPLICIT_SUBSTRATE_VSS sg13_hv_nmos m=1 w=4.4u l=600.0n ng=1
XMN0_50_ pad gate iovss G1_EXPLICIT_SUBSTRATE_VSS sg13_hv_nmos m=1 w=4.4u l=600.0n ng=1
XMN0_51_ pad gate iovss G1_EXPLICIT_SUBSTRATE_VSS sg13_hv_nmos m=1 w=4.4u l=600.0n ng=1
XMN0_52_ pad gate iovss G1_EXPLICIT_SUBSTRATE_VSS sg13_hv_nmos m=1 w=4.4u l=600.0n ng=1
XMN0_53_ pad gate iovss G1_EXPLICIT_SUBSTRATE_VSS sg13_hv_nmos m=1 w=4.4u l=600.0n ng=1
XMN0_54_ pad gate iovss G1_EXPLICIT_SUBSTRATE_VSS sg13_hv_nmos m=1 w=4.4u l=600.0n ng=1
XMN0_55_ pad gate iovss G1_EXPLICIT_SUBSTRATE_VSS sg13_hv_nmos m=1 w=4.4u l=600.0n ng=1
XMN0_56_ pad gate iovss G1_EXPLICIT_SUBSTRATE_VSS sg13_hv_nmos m=1 w=4.4u l=600.0n ng=1
XMN0_57_ pad gate iovss G1_EXPLICIT_SUBSTRATE_VSS sg13_hv_nmos m=1 w=4.4u l=600.0n ng=1
XMN0_58_ pad gate iovss G1_EXPLICIT_SUBSTRATE_VSS sg13_hv_nmos m=1 w=4.4u l=600.0n ng=1
XMN0_59_ pad gate iovss G1_EXPLICIT_SUBSTRATE_VSS sg13_hv_nmos m=1 w=4.4u l=600.0n ng=1
XMN0_60_ pad gate iovss G1_EXPLICIT_SUBSTRATE_VSS sg13_hv_nmos m=1 w=4.4u l=600.0n ng=1
XMN0_61_ pad gate iovss G1_EXPLICIT_SUBSTRATE_VSS sg13_hv_nmos m=1 w=4.4u l=600.0n ng=1
XMN0_62_ pad gate iovss G1_EXPLICIT_SUBSTRATE_VSS sg13_hv_nmos m=1 w=4.4u l=600.0n ng=1
XMN0_63_ pad gate iovss G1_EXPLICIT_SUBSTRATE_VSS sg13_hv_nmos m=1 w=4.4u l=600.0n ng=1
XMN0_64_ pad gate iovss G1_EXPLICIT_SUBSTRATE_VSS sg13_hv_nmos m=1 w=4.4u l=600.0n ng=1
XMN0_65_ pad gate iovss G1_EXPLICIT_SUBSTRATE_VSS sg13_hv_nmos m=1 w=4.4u l=600.0n ng=1
XMN0_66_ pad gate iovss G1_EXPLICIT_SUBSTRATE_VSS sg13_hv_nmos m=1 w=4.4u l=600.0n ng=1
XMN0_67_ pad gate iovss G1_EXPLICIT_SUBSTRATE_VSS sg13_hv_nmos m=1 w=4.4u l=600.0n ng=1
XMN0_68_ pad gate iovss G1_EXPLICIT_SUBSTRATE_VSS sg13_hv_nmos m=1 w=4.4u l=600.0n ng=1
XMN0_69_ pad gate iovss G1_EXPLICIT_SUBSTRATE_VSS sg13_hv_nmos m=1 w=4.4u l=600.0n ng=1
XMN0_70_ pad gate iovss G1_EXPLICIT_SUBSTRATE_VSS sg13_hv_nmos m=1 w=4.4u l=600.0n ng=1
XMN0_71_ pad gate iovss G1_EXPLICIT_SUBSTRATE_VSS sg13_hv_nmos m=1 w=4.4u l=600.0n ng=1
XMN0_72_ pad gate iovss G1_EXPLICIT_SUBSTRATE_VSS sg13_hv_nmos m=1 w=4.4u l=600.0n ng=1
XMN0_73_ pad gate iovss G1_EXPLICIT_SUBSTRATE_VSS sg13_hv_nmos m=1 w=4.4u l=600.0n ng=1
XMN0_74_ pad gate iovss G1_EXPLICIT_SUBSTRATE_VSS sg13_hv_nmos m=1 w=4.4u l=600.0n ng=1
XMN0_75_ pad gate iovss G1_EXPLICIT_SUBSTRATE_VSS sg13_hv_nmos m=1 w=4.4u l=600.0n ng=1
XMN0_76_ pad gate iovss G1_EXPLICIT_SUBSTRATE_VSS sg13_hv_nmos m=1 w=4.4u l=600.0n ng=1
XMN0_77_ pad gate iovss G1_EXPLICIT_SUBSTRATE_VSS sg13_hv_nmos m=1 w=4.4u l=600.0n ng=1
XMN0_78_ pad gate iovss G1_EXPLICIT_SUBSTRATE_VSS sg13_hv_nmos m=1 w=4.4u l=600.0n ng=1
XMN0_79_ pad gate iovss G1_EXPLICIT_SUBSTRATE_VSS sg13_hv_nmos m=1 w=4.4u l=600.0n ng=1
XMN0_80_ pad gate iovss G1_EXPLICIT_SUBSTRATE_VSS sg13_hv_nmos m=1 w=4.4u l=600.0n ng=1
XMN0_81_ pad gate iovss G1_EXPLICIT_SUBSTRATE_VSS sg13_hv_nmos m=1 w=4.4u l=600.0n ng=1
XMN0_82_ pad gate iovss G1_EXPLICIT_SUBSTRATE_VSS sg13_hv_nmos m=1 w=4.4u l=600.0n ng=1
XMN0_83_ pad gate iovss G1_EXPLICIT_SUBSTRATE_VSS sg13_hv_nmos m=1 w=4.4u l=600.0n ng=1
XMN0_84_ pad gate iovss G1_EXPLICIT_SUBSTRATE_VSS sg13_hv_nmos m=1 w=4.4u l=600.0n ng=1
XMN0_85_ pad gate iovss G1_EXPLICIT_SUBSTRATE_VSS sg13_hv_nmos m=1 w=4.4u l=600.0n ng=1
XMN0_86_ pad gate iovss G1_EXPLICIT_SUBSTRATE_VSS sg13_hv_nmos m=1 w=4.4u l=600.0n ng=1
XMN0_87_ pad gate iovss G1_EXPLICIT_SUBSTRATE_VSS sg13_hv_nmos m=1 w=4.4u l=600.0n ng=1
XMN0_88_ pad gate iovss G1_EXPLICIT_SUBSTRATE_VSS sg13_hv_nmos m=1 w=4.4u l=600.0n ng=1
XMN0_89_ pad gate iovss G1_EXPLICIT_SUBSTRATE_VSS sg13_hv_nmos m=1 w=4.4u l=600.0n ng=1
XMN0_90_ pad gate iovss G1_EXPLICIT_SUBSTRATE_VSS sg13_hv_nmos m=1 w=4.4u l=600.0n ng=1
XMN0_91_ pad gate iovss G1_EXPLICIT_SUBSTRATE_VSS sg13_hv_nmos m=1 w=4.4u l=600.0n ng=1
XMN0_92_ pad gate iovss G1_EXPLICIT_SUBSTRATE_VSS sg13_hv_nmos m=1 w=4.4u l=600.0n ng=1
XMN0_93_ pad gate iovss G1_EXPLICIT_SUBSTRATE_VSS sg13_hv_nmos m=1 w=4.4u l=600.0n ng=1
XMN0_94_ pad gate iovss G1_EXPLICIT_SUBSTRATE_VSS sg13_hv_nmos m=1 w=4.4u l=600.0n ng=1
XMN0_95_ pad gate iovss G1_EXPLICIT_SUBSTRATE_VSS sg13_hv_nmos m=1 w=4.4u l=600.0n ng=1
XMN0_96_ pad gate iovss G1_EXPLICIT_SUBSTRATE_VSS sg13_hv_nmos m=1 w=4.4u l=600.0n ng=1
XMN0_97_ pad gate iovss G1_EXPLICIT_SUBSTRATE_VSS sg13_hv_nmos m=1 w=4.4u l=600.0n ng=1
XMN0_98_ pad gate iovss G1_EXPLICIT_SUBSTRATE_VSS sg13_hv_nmos m=1 w=4.4u l=600.0n ng=1
XMN0_99_ pad gate iovss G1_EXPLICIT_SUBSTRATE_VSS sg13_hv_nmos m=1 w=4.4u l=600.0n ng=1
XMN0_100_ pad gate iovss G1_EXPLICIT_SUBSTRATE_VSS sg13_hv_nmos m=1 w=4.4u l=600.0n ng=1
XMN0_101_ pad gate iovss G1_EXPLICIT_SUBSTRATE_VSS sg13_hv_nmos m=1 w=4.4u l=600.0n ng=1
XMN0_102_ pad gate iovss G1_EXPLICIT_SUBSTRATE_VSS sg13_hv_nmos m=1 w=4.4u l=600.0n ng=1
XMN0_103_ pad gate iovss G1_EXPLICIT_SUBSTRATE_VSS sg13_hv_nmos m=1 w=4.4u l=600.0n ng=1
XMN0_104_ pad gate iovss G1_EXPLICIT_SUBSTRATE_VSS sg13_hv_nmos m=1 w=4.4u l=600.0n ng=1
XMN0_105_ pad gate iovss G1_EXPLICIT_SUBSTRATE_VSS sg13_hv_nmos m=1 w=4.4u l=600.0n ng=1
XMN0_106_ pad gate iovss G1_EXPLICIT_SUBSTRATE_VSS sg13_hv_nmos m=1 w=4.4u l=600.0n ng=1
XMN0_107_ pad gate iovss G1_EXPLICIT_SUBSTRATE_VSS sg13_hv_nmos m=1 w=4.4u l=600.0n ng=1
XMN0_108_ pad gate iovss G1_EXPLICIT_SUBSTRATE_VSS sg13_hv_nmos m=1 w=4.4u l=600.0n ng=1
XMN0_109_ pad gate iovss G1_EXPLICIT_SUBSTRATE_VSS sg13_hv_nmos m=1 w=4.4u l=600.0n ng=1
XMN0_110_ pad gate iovss G1_EXPLICIT_SUBSTRATE_VSS sg13_hv_nmos m=1 w=4.4u l=600.0n ng=1
XMN0_111_ pad gate iovss G1_EXPLICIT_SUBSTRATE_VSS sg13_hv_nmos m=1 w=4.4u l=600.0n ng=1
XMN0_112_ pad gate iovss G1_EXPLICIT_SUBSTRATE_VSS sg13_hv_nmos m=1 w=4.4u l=600.0n ng=1
XMN0_113_ pad gate iovss G1_EXPLICIT_SUBSTRATE_VSS sg13_hv_nmos m=1 w=4.4u l=600.0n ng=1
XMN0_114_ pad gate iovss G1_EXPLICIT_SUBSTRATE_VSS sg13_hv_nmos m=1 w=4.4u l=600.0n ng=1
XMN0_115_ pad gate iovss G1_EXPLICIT_SUBSTRATE_VSS sg13_hv_nmos m=1 w=4.4u l=600.0n ng=1
XMN0_116_ pad gate iovss G1_EXPLICIT_SUBSTRATE_VSS sg13_hv_nmos m=1 w=4.4u l=600.0n ng=1
XMN0_117_ pad gate iovss G1_EXPLICIT_SUBSTRATE_VSS sg13_hv_nmos m=1 w=4.4u l=600.0n ng=1
XMN0_118_ pad gate iovss G1_EXPLICIT_SUBSTRATE_VSS sg13_hv_nmos m=1 w=4.4u l=600.0n ng=1
XMN0_119_ pad gate iovss G1_EXPLICIT_SUBSTRATE_VSS sg13_hv_nmos m=1 w=4.4u l=600.0n ng=1
XMN0_120_ pad gate iovss G1_EXPLICIT_SUBSTRATE_VSS sg13_hv_nmos m=1 w=4.4u l=600.0n ng=1
XMN0_121_ pad gate iovss G1_EXPLICIT_SUBSTRATE_VSS sg13_hv_nmos m=1 w=4.4u l=600.0n ng=1
XMN0_122_ pad gate iovss G1_EXPLICIT_SUBSTRATE_VSS sg13_hv_nmos m=1 w=4.4u l=600.0n ng=1
XMN0_123_ pad gate iovss G1_EXPLICIT_SUBSTRATE_VSS sg13_hv_nmos m=1 w=4.4u l=600.0n ng=1
XMN0_124_ pad gate iovss G1_EXPLICIT_SUBSTRATE_VSS sg13_hv_nmos m=1 w=4.4u l=600.0n ng=1
XMN0_125_ pad gate iovss G1_EXPLICIT_SUBSTRATE_VSS sg13_hv_nmos m=1 w=4.4u l=600.0n ng=1
XMN0_126_ pad gate iovss G1_EXPLICIT_SUBSTRATE_VSS sg13_hv_nmos m=1 w=4.4u l=600.0n ng=1
XMN0_127_ pad gate iovss G1_EXPLICIT_SUBSTRATE_VSS sg13_hv_nmos m=1 w=4.4u l=600.0n ng=1
XMN0_128_ pad gate iovss G1_EXPLICIT_SUBSTRATE_VSS sg13_hv_nmos m=1 w=4.4u l=600.0n ng=1
XMN0_129_ pad gate iovss G1_EXPLICIT_SUBSTRATE_VSS sg13_hv_nmos m=1 w=4.4u l=600.0n ng=1
XMN0_130_ pad gate iovss G1_EXPLICIT_SUBSTRATE_VSS sg13_hv_nmos m=1 w=4.4u l=600.0n ng=1
XMN0_131_ pad gate iovss G1_EXPLICIT_SUBSTRATE_VSS sg13_hv_nmos m=1 w=4.4u l=600.0n ng=1
XMN0_132_ pad gate iovss G1_EXPLICIT_SUBSTRATE_VSS sg13_hv_nmos m=1 w=4.4u l=600.0n ng=1
XMN0_133_ pad gate iovss G1_EXPLICIT_SUBSTRATE_VSS sg13_hv_nmos m=1 w=4.4u l=600.0n ng=1
XMN0_134_ pad gate iovss G1_EXPLICIT_SUBSTRATE_VSS sg13_hv_nmos m=1 w=4.4u l=600.0n ng=1
XMN0_135_ pad gate iovss G1_EXPLICIT_SUBSTRATE_VSS sg13_hv_nmos m=1 w=4.4u l=600.0n ng=1
XMN0_136_ pad gate iovss G1_EXPLICIT_SUBSTRATE_VSS sg13_hv_nmos m=1 w=4.4u l=600.0n ng=1
XMN0_137_ pad gate iovss G1_EXPLICIT_SUBSTRATE_VSS sg13_hv_nmos m=1 w=4.4u l=600.0n ng=1
XMN0_138_ pad gate iovss G1_EXPLICIT_SUBSTRATE_VSS sg13_hv_nmos m=1 w=4.4u l=600.0n ng=1
XMN0_139_ pad gate iovss G1_EXPLICIT_SUBSTRATE_VSS sg13_hv_nmos m=1 w=4.4u l=600.0n ng=1
XMN0_140_ pad gate iovss G1_EXPLICIT_SUBSTRATE_VSS sg13_hv_nmos m=1 w=4.4u l=600.0n ng=1
XMN0_141_ pad gate iovss G1_EXPLICIT_SUBSTRATE_VSS sg13_hv_nmos m=1 w=4.4u l=600.0n ng=1
XMN0_142_ pad gate iovss G1_EXPLICIT_SUBSTRATE_VSS sg13_hv_nmos m=1 w=4.4u l=600.0n ng=1
XMN0_143_ pad gate iovss G1_EXPLICIT_SUBSTRATE_VSS sg13_hv_nmos m=1 w=4.4u l=600.0n ng=1
XMN0_144_ pad gate iovss G1_EXPLICIT_SUBSTRATE_VSS sg13_hv_nmos m=1 w=4.4u l=600.0n ng=1
XMN0_145_ pad gate iovss G1_EXPLICIT_SUBSTRATE_VSS sg13_hv_nmos m=1 w=4.4u l=600.0n ng=1
XMN0_146_ pad gate iovss G1_EXPLICIT_SUBSTRATE_VSS sg13_hv_nmos m=1 w=4.4u l=600.0n ng=1
XMN0_147_ pad gate iovss G1_EXPLICIT_SUBSTRATE_VSS sg13_hv_nmos m=1 w=4.4u l=600.0n ng=1
XMN0_148_ pad gate iovss G1_EXPLICIT_SUBSTRATE_VSS sg13_hv_nmos m=1 w=4.4u l=600.0n ng=1
XMN0_149_ pad gate iovss G1_EXPLICIT_SUBSTRATE_VSS sg13_hv_nmos m=1 w=4.4u l=600.0n ng=1
XMN0_150_ pad gate iovss G1_EXPLICIT_SUBSTRATE_VSS sg13_hv_nmos m=1 w=4.4u l=600.0n ng=1
XMN0_151_ pad gate iovss G1_EXPLICIT_SUBSTRATE_VSS sg13_hv_nmos m=1 w=4.4u l=600.0n ng=1
XMN0_152_ pad gate iovss G1_EXPLICIT_SUBSTRATE_VSS sg13_hv_nmos m=1 w=4.4u l=600.0n ng=1
XMN0_153_ pad gate iovss G1_EXPLICIT_SUBSTRATE_VSS sg13_hv_nmos m=1 w=4.4u l=600.0n ng=1
XMN0_154_ pad gate iovss G1_EXPLICIT_SUBSTRATE_VSS sg13_hv_nmos m=1 w=4.4u l=600.0n ng=1
XMN0_155_ pad gate iovss G1_EXPLICIT_SUBSTRATE_VSS sg13_hv_nmos m=1 w=4.4u l=600.0n ng=1
XMN0_156_ pad gate iovss G1_EXPLICIT_SUBSTRATE_VSS sg13_hv_nmos m=1 w=4.4u l=600.0n ng=1
XMN0_157_ pad gate iovss G1_EXPLICIT_SUBSTRATE_VSS sg13_hv_nmos m=1 w=4.4u l=600.0n ng=1
XMN0_158_ pad gate iovss G1_EXPLICIT_SUBSTRATE_VSS sg13_hv_nmos m=1 w=4.4u l=600.0n ng=1
XMN0_159_ pad gate iovss G1_EXPLICIT_SUBSTRATE_VSS sg13_hv_nmos m=1 w=4.4u l=600.0n ng=1
XMN0_160_ pad gate iovss G1_EXPLICIT_SUBSTRATE_VSS sg13_hv_nmos m=1 w=4.4u l=600.0n ng=1
XMN0_161_ pad gate iovss G1_EXPLICIT_SUBSTRATE_VSS sg13_hv_nmos m=1 w=4.4u l=600.0n ng=1
XMN0_162_ pad gate iovss G1_EXPLICIT_SUBSTRATE_VSS sg13_hv_nmos m=1 w=4.4u l=600.0n ng=1
XMN0_163_ pad gate iovss G1_EXPLICIT_SUBSTRATE_VSS sg13_hv_nmos m=1 w=4.4u l=600.0n ng=1
XMN0_164_ pad gate iovss G1_EXPLICIT_SUBSTRATE_VSS sg13_hv_nmos m=1 w=4.4u l=600.0n ng=1
XMN0_165_ pad gate iovss G1_EXPLICIT_SUBSTRATE_VSS sg13_hv_nmos m=1 w=4.4u l=600.0n ng=1
XMN0_166_ pad gate iovss G1_EXPLICIT_SUBSTRATE_VSS sg13_hv_nmos m=1 w=4.4u l=600.0n ng=1
XMN0_167_ pad gate iovss G1_EXPLICIT_SUBSTRATE_VSS sg13_hv_nmos m=1 w=4.4u l=600.0n ng=1
XMN0_168_ pad gate iovss G1_EXPLICIT_SUBSTRATE_VSS sg13_hv_nmos m=1 w=4.4u l=600.0n ng=1
XMN0_169_ pad gate iovss G1_EXPLICIT_SUBSTRATE_VSS sg13_hv_nmos m=1 w=4.4u l=600.0n ng=1
XMN0_170_ pad gate iovss G1_EXPLICIT_SUBSTRATE_VSS sg13_hv_nmos m=1 w=4.4u l=600.0n ng=1
XMN0_171_ pad gate iovss G1_EXPLICIT_SUBSTRATE_VSS sg13_hv_nmos m=1 w=4.4u l=600.0n ng=1
XMN0_172_ pad gate iovss G1_EXPLICIT_SUBSTRATE_VSS sg13_hv_nmos m=1 w=4.4u l=600.0n ng=1
XR_G1_TAP_SYNTAX_XR0 iovss G1_EXPLICIT_SUBSTRATE_VSS ptap1 R=9.999
* removed (--pads nodcn): DD0 G1_EXPLICIT_SUBSTRATE_VSS gate dantenna m=1 w=480n l=480n a=230.4f p=1.92u
.ends G1_VSS_DERIVATIVE__sg13g2_Clamp_N43N43D4R
.subckt G1_VSS_DERIVATIVE__sg13g2_RCClampResistor pin1 pin2 G1_EXPLICIT_SUBSTRATE_VSS
XRR15 net15 net16 G1_EXPLICIT_SUBSTRATE_VSS rppd l=20u w=1u b=0 m=1
XRR20 net20 net21 G1_EXPLICIT_SUBSTRATE_VSS rppd l=20u w=1u b=0 m=1
XRR23 net23 net24 G1_EXPLICIT_SUBSTRATE_VSS rppd l=20u w=1u b=0 m=1
XRR17 net17 net18 G1_EXPLICIT_SUBSTRATE_VSS rppd l=20u w=1u b=0 m=1
XRR16 net16 net17 G1_EXPLICIT_SUBSTRATE_VSS rppd l=20u w=1u b=0 m=1
XRR25 net25 pin2 G1_EXPLICIT_SUBSTRATE_VSS rppd l=20u w=1u b=0 m=1
XRR22 net22 net23 G1_EXPLICIT_SUBSTRATE_VSS rppd l=20u w=1u b=0 m=1
XRR19 net19 net20 G1_EXPLICIT_SUBSTRATE_VSS rppd l=20u w=1u b=0 m=1
XRR24 net24 net25 G1_EXPLICIT_SUBSTRATE_VSS rppd l=20u w=1u b=0 m=1
XRR21 net21 net22 G1_EXPLICIT_SUBSTRATE_VSS rppd l=20u w=1u b=0 m=1
XRR18 net18 net19 G1_EXPLICIT_SUBSTRATE_VSS rppd l=20u w=1u b=0 m=1
XRR5 net5 net6 G1_EXPLICIT_SUBSTRATE_VSS rppd l=20u w=1u b=0 m=1
XRR8 net8 net9 G1_EXPLICIT_SUBSTRATE_VSS rppd l=20u w=1u b=0 m=1
XRR11 net11 net12 G1_EXPLICIT_SUBSTRATE_VSS rppd l=20u w=1u b=0 m=1
XRR14 net14 net15 G1_EXPLICIT_SUBSTRATE_VSS rppd l=20u w=1u b=0 m=1
XRR2 net2 net3 G1_EXPLICIT_SUBSTRATE_VSS rppd l=20u w=1u b=0 m=1
XRR1 net1 net2 G1_EXPLICIT_SUBSTRATE_VSS rppd l=20u w=1u b=0 m=1
XRR13 net13 net14 G1_EXPLICIT_SUBSTRATE_VSS rppd l=20u w=1u b=0 m=1
XRR10 net10 net11 G1_EXPLICIT_SUBSTRATE_VSS rppd l=20u w=1u b=0 m=1
XRR7 net7 net8 G1_EXPLICIT_SUBSTRATE_VSS rppd l=20u w=1u b=0 m=1
XRR4 net4 net5 G1_EXPLICIT_SUBSTRATE_VSS rppd l=20u w=1u b=0 m=1
XRR12 net12 net13 G1_EXPLICIT_SUBSTRATE_VSS rppd l=20u w=1u b=0 m=1
XRR9 net9 net10 G1_EXPLICIT_SUBSTRATE_VSS rppd l=20u w=1u b=0 m=1
XRR6 net6 net7 G1_EXPLICIT_SUBSTRATE_VSS rppd l=20u w=1u b=0 m=1
XRR3 net3 net4 G1_EXPLICIT_SUBSTRATE_VSS rppd l=20u w=1u b=0 m=1
XRR0 pin1 net1 G1_EXPLICIT_SUBSTRATE_VSS rppd l=20u w=1u b=0 m=1
.ends G1_VSS_DERIVATIVE__sg13g2_RCClampResistor
.subckt G1_VSS_DERIVATIVE__sg13g2_RCClampInverter out in iovss supply G1_EXPLICIT_SUBSTRATE_VSS
XMN1 iovss in iovss G1_EXPLICIT_SUBSTRATE_VSS sg13_hv_nmos m=1 w=63.000u l=9.5u ng=7
XMN3 out in iovss G1_EXPLICIT_SUBSTRATE_VSS sg13_hv_nmos m=1 w=54.000u l=500.0n ng=6
XMN0 iovss in iovss G1_EXPLICIT_SUBSTRATE_VSS sg13_hv_nmos m=1 w=63.000u l=9.5u ng=7
XMN2 out in iovss G1_EXPLICIT_SUBSTRATE_VSS sg13_hv_nmos m=1 w=54.000u l=500.0n ng=6
XR_G1_TAP_SYNTAX_XR0 iovss G1_EXPLICIT_SUBSTRATE_VSS ptap1 R=9.59
XMP0 out in supply supply sg13_hv_pmos m=1 w=350.000u l=500.0n ng=50
.ends G1_VSS_DERIVATIVE__sg13g2_RCClampInverter
.subckt G1_VSS_DERIVATIVE__sg13g2_IOPadVdd vdd vss iovdd iovss G1_EXPLICIT_SUBSTRATE_VSS
XI1 net3 iovss vdd G1_EXPLICIT_SUBSTRATE_VSS G1_VSS_DERIVATIVE__sg13g2_Clamp_N43N43D4R
XI4 vdd net1 G1_EXPLICIT_SUBSTRATE_VSS G1_VSS_DERIVATIVE__sg13g2_RCClampResistor
XR_G1_TAP_SYNTAX_XR1 iovss G1_EXPLICIT_SUBSTRATE_VSS ptap1 R=456.33m
XR_G1_TAP_SYNTAX_XR0 vss G1_EXPLICIT_SUBSTRATE_VSS ptap1 R=22.472
XI3 net3 net1 iovss vdd G1_EXPLICIT_SUBSTRATE_VSS G1_VSS_DERIVATIVE__sg13g2_RCClampInverter
.ends G1_VSS_DERIVATIVE__sg13g2_IOPadVdd
.subckt G1_VSS_DERIVATIVE__sg13g2_DCNDiode anode cathode guard G1_EXPLICIT_SUBSTRATE_VSS
* removed (--pads nodcn): DD1 G1_EXPLICIT_SUBSTRATE_VSS cathode dantenna m=1 w=1.26u l=27.78u a=35.003p p=58.08u
* removed (--pads nodcn): DD0 G1_EXPLICIT_SUBSTRATE_VSS cathode dantenna m=1 w=1.26u l=27.78u a=35.003p p=58.08u
XR_G1_TAP_SYNTAX_XR0 anode G1_EXPLICIT_SUBSTRATE_VSS ptap1 R=5.191
.ends G1_VSS_DERIVATIVE__sg13g2_DCNDiode
.subckt G1_VSS_DERIVATIVE__sg13g2_DCPDiode anode cathode guard G1_EXPLICIT_SUBSTRATE_VSS
XDD1 anode cathode dpantenna m=1 w=1.26u l=27.78u
XDD0 anode cathode dpantenna m=1 w=1.26u l=27.78u
XR_G1_TAP_SYNTAX_XR0 guard G1_EXPLICIT_SUBSTRATE_VSS ptap1 R=17.289
.ends G1_VSS_DERIVATIVE__sg13g2_DCPDiode
.subckt G1_VSS_DERIVATIVE__sg13g2_IOPadVss vdd vss iovdd iovss G1_EXPLICIT_SUBSTRATE_VSS
XI1 iovss vss iovdd G1_EXPLICIT_SUBSTRATE_VSS G1_VSS_DERIVATIVE__sg13g2_DCNDiode
XI2 vss iovdd iovss G1_EXPLICIT_SUBSTRATE_VSS G1_VSS_DERIVATIVE__sg13g2_DCPDiode
XR_G1_TAP_SYNTAX_XR1 iovss G1_EXPLICIT_SUBSTRATE_VSS ptap1 R=174.346m
XR_G1_TAP_SYNTAX_XR0 vss G1_EXPLICIT_SUBSTRATE_VSS ptap1 R=22.832
.ends G1_VSS_DERIVATIVE__sg13g2_IOPadVss
.subckt G1_VSS_DERIVATIVE__sg13g2_IOPadIOVdd vdd vss iovdd iovss G1_EXPLICIT_SUBSTRATE_VSS
XI1 net4 iovss iovdd G1_EXPLICIT_SUBSTRATE_VSS G1_VSS_DERIVATIVE__sg13g2_Clamp_N43N43D4R
XI3 iovdd net1 G1_EXPLICIT_SUBSTRATE_VSS G1_VSS_DERIVATIVE__sg13g2_RCClampResistor
XI2 net4 net1 iovss iovdd G1_EXPLICIT_SUBSTRATE_VSS G1_VSS_DERIVATIVE__sg13g2_RCClampInverter
XR_G1_TAP_SYNTAX_XR0 vss G1_EXPLICIT_SUBSTRATE_VSS ptap1 R=22.472
XR_G1_TAP_SYNTAX_XR1 iovss G1_EXPLICIT_SUBSTRATE_VSS ptap1 R=453.388m
.ends G1_VSS_DERIVATIVE__sg13g2_IOPadIOVdd
.subckt G1_VSS_DERIVATIVE__sg13g2_IOPadIOVss vdd vss iovdd iovss G1_EXPLICIT_SUBSTRATE_VSS
XI3 iovss iovss iovdd G1_EXPLICIT_SUBSTRATE_VSS G1_VSS_DERIVATIVE__sg13g2_DCNDiode
XI2 iovss iovdd iovss G1_EXPLICIT_SUBSTRATE_VSS G1_VSS_DERIVATIVE__sg13g2_DCPDiode
XR_G1_TAP_SYNTAX_XR1 vss G1_EXPLICIT_SUBSTRATE_VSS ptap1 R=22.472
XR_G1_TAP_SYNTAX_XR0 iovss G1_EXPLICIT_SUBSTRATE_VSS ptap1 R=169.45m
.ends G1_VSS_DERIVATIVE__sg13g2_IOPadIOVss
.subckt G1_VSS_DERIVATIVE__sg13g2_Clamp_P20N0D iovdd iovss pad G1_EXPLICIT_SUBSTRATE_VSS
XMP1 pad net2 iovdd iovdd sg13_hv_pmos m=1 w=133.2u l=600.0n ng=20
XMP0 pad net2 iovdd iovdd sg13_hv_pmos m=1 w=133.2u l=600.0n ng=20
XRR0 net2 iovdd iovdd rppd l=12.9u w=500n b=0 m=1
XR_G1_TAP_SYNTAX_XR1 iovss G1_EXPLICIT_SUBSTRATE_VSS ptap1 R=9.826
.ends G1_VSS_DERIVATIVE__sg13g2_Clamp_P20N0D
.subckt G1_VSS_DERIVATIVE__sg13g2_SecondaryProtection core minus pad plus G1_EXPLICIT_SUBSTRATE_VSS
XRR0 pad core G1_EXPLICIT_SUBSTRATE_VSS rppd m=1 l=2u w=1u b=0
* removed (--pads nodcn): DD1 G1_EXPLICIT_SUBSTRATE_VSS core dantenna m=1 w=640n l=3.1u a=1.984p p=7.48u
XR_G1_TAP_SYNTAX_XR1 minus G1_EXPLICIT_SUBSTRATE_VSS ptap1 R=46.556
XDD0 core plus dpantenna m=1 w=640n l=4.98u
.ends G1_VSS_DERIVATIVE__sg13g2_SecondaryProtection
.subckt G1_VSS_DERIVATIVE__sg13g2_Clamp_N20N0D iovss pad G1_EXPLICIT_SUBSTRATE_VSS
XMN0 pad net2 iovss G1_EXPLICIT_SUBSTRATE_VSS sg13_hv_nmos m=1 w=88.000u l=600.0n ng=20
XR_G1_TAP_SYNTAX_XR1 iovss G1_EXPLICIT_SUBSTRATE_VSS ptap1 R=11.438
XRR0 iovss net2 G1_EXPLICIT_SUBSTRATE_VSS rppd l=3.54u w=500n b=0 m=1
.ends G1_VSS_DERIVATIVE__sg13g2_Clamp_N20N0D
.subckt G1_VSS_DERIVATIVE__sg13g2_IOPadAnalog pad padres vdd vss iovdd iovss G1_EXPLICIT_SUBSTRATE_VSS
XI0 iovdd iovss pad G1_EXPLICIT_SUBSTRATE_VSS G1_VSS_DERIVATIVE__sg13g2_Clamp_P20N0D
XI5 iovss pad iovdd G1_EXPLICIT_SUBSTRATE_VSS G1_VSS_DERIVATIVE__sg13g2_DCNDiode
XI2 pad iovdd iovss G1_EXPLICIT_SUBSTRATE_VSS G1_VSS_DERIVATIVE__sg13g2_DCPDiode
XI3 padres iovss pad iovdd G1_EXPLICIT_SUBSTRATE_VSS G1_VSS_DERIVATIVE__sg13g2_SecondaryProtection
XI4 iovss pad G1_EXPLICIT_SUBSTRATE_VSS G1_VSS_DERIVATIVE__sg13g2_Clamp_N20N0D
XR_G1_TAP_SYNTAX_XR0 vss G1_EXPLICIT_SUBSTRATE_VSS ptap1 R=22.579
XR_G1_TAP_SYNTAX_XR1 iovss G1_EXPLICIT_SUBSTRATE_VSS ptap1 R=214.8m
.ends G1_VSS_DERIVATIVE__sg13g2_IOPadAnalog
.subckt G1_VSS_DERIVATIVE__sg13g2_LevelUpInv o i iovdd vdd vss G1_EXPLICIT_SUBSTRATE_VSS
XMN1 net2 i vss G1_EXPLICIT_SUBSTRATE_VSS sg13_lv_nmos m=1 w=2.75u l=130.00n ng=1
XMP3 net2 i vdd vdd sg13_lv_pmos m=1 w=4.75u l=130.00n ng=1
XMN0 o net4 vss G1_EXPLICIT_SUBSTRATE_VSS sg13_hv_nmos m=1 w=1.9u l=450.00n ng=1
XMN3 net4 net2 vss G1_EXPLICIT_SUBSTRATE_VSS sg13_hv_nmos m=1 w=1.9u l=450.00n ng=1
XMN2 net3 i vss G1_EXPLICIT_SUBSTRATE_VSS sg13_hv_nmos m=1 w=1.9u l=450.00n ng=1
XMP0 o net4 iovdd iovdd sg13_hv_pmos m=1 w=3.9u l=450.00n ng=1
XMP1 net3 net4 iovdd iovdd sg13_hv_pmos m=1 w=300.0n l=450.00n ng=1
XMP2 net4 net3 iovdd iovdd sg13_hv_pmos m=1 w=300.0n l=450.00n ng=1
XR_G1_TAP_SYNTAX_XR0 vss G1_EXPLICIT_SUBSTRATE_VSS ptap1 R=190.268
.ends G1_VSS_DERIVATIVE__sg13g2_LevelUpInv
.subckt G1_VSS_DERIVATIVE__sg13g2_GateLevelUpInv ngate pgate iovdd core vdd vss G1_EXPLICIT_SUBSTRATE_VSS
XI1 pgate core iovdd vdd vss G1_EXPLICIT_SUBSTRATE_VSS G1_VSS_DERIVATIVE__sg13g2_LevelUpInv
XI0 ngate core iovdd vdd vss G1_EXPLICIT_SUBSTRATE_VSS G1_VSS_DERIVATIVE__sg13g2_LevelUpInv
.ends G1_VSS_DERIVATIVE__sg13g2_GateLevelUpInv
.subckt G1_VSS_DERIVATIVE__sg13g2_Clamp_P15N15D gate iovdd iovss pad G1_EXPLICIT_SUBSTRATE_VSS
XDD0 gate iovdd dpantenna m=1 w=780.00n l=780.00n
XR_G1_TAP_SYNTAX_XR0 iovss G1_EXPLICIT_SUBSTRATE_VSS ptap1 R=9.826
XMP1 pad gate iovdd iovdd sg13_hv_pmos m=1 w=99.9u l=600.0n ng=15
XMP0 pad gate iovdd iovdd sg13_hv_pmos m=1 w=99.9u l=600.0n ng=15
.ends G1_VSS_DERIVATIVE__sg13g2_Clamp_P15N15D
.subckt G1_VSS_DERIVATIVE__sg13g2_Clamp_N15N15D gate iovss pad G1_EXPLICIT_SUBSTRATE_VSS
XR_G1_TAP_SYNTAX_XR0 iovss G1_EXPLICIT_SUBSTRATE_VSS ptap1 R=11.438
XMN0 pad gate iovss G1_EXPLICIT_SUBSTRATE_VSS sg13_hv_nmos m=1 w=66.000u l=600.0n ng=15
* removed (--pads nodcn): DD0 G1_EXPLICIT_SUBSTRATE_VSS gate dantenna m=1 w=780.00n l=780.00n a=608.400f p=3.12u
.ends G1_VSS_DERIVATIVE__sg13g2_Clamp_N15N15D
.subckt G1_VSS_DERIVATIVE__sg13g2_IOPadOut30mA pad c2p vdd vss iovdd iovss G1_EXPLICIT_SUBSTRATE_VSS
XI2 net2 net1 iovdd c2p vdd vss G1_EXPLICIT_SUBSTRATE_VSS G1_VSS_DERIVATIVE__sg13g2_GateLevelUpInv
XI1 net1 iovdd iovss pad G1_EXPLICIT_SUBSTRATE_VSS G1_VSS_DERIVATIVE__sg13g2_Clamp_P15N15D
XI3 net2 iovss pad G1_EXPLICIT_SUBSTRATE_VSS G1_VSS_DERIVATIVE__sg13g2_Clamp_N15N15D
XI4 iovss pad iovdd G1_EXPLICIT_SUBSTRATE_VSS G1_VSS_DERIVATIVE__sg13g2_DCNDiode
XI0 pad iovdd iovss G1_EXPLICIT_SUBSTRATE_VSS G1_VSS_DERIVATIVE__sg13g2_DCPDiode
XR_G1_TAP_SYNTAX_XR0 vss G1_EXPLICIT_SUBSTRATE_VSS ptap1 R=24.125
XR_G1_TAP_SYNTAX_XR1 iovss G1_EXPLICIT_SUBSTRATE_VSS ptap1 R=214.165m
.ends G1_VSS_DERIVATIVE__sg13g2_IOPadOut30mA
.subckt G1_VSS_DERIVATIVE__sg13g2_Clamp_P2N2D gate iovdd iovss pad G1_EXPLICIT_SUBSTRATE_VSS
XDD0 gate iovdd dpantenna m=1 w=480n l=480n
XMP1 pad gate iovdd iovdd sg13_hv_pmos m=1 w=13.32u l=600.0n ng=2
XMP0 pad gate iovdd iovdd sg13_hv_pmos m=1 w=13.32u l=600.0n ng=2
XR_G1_TAP_SYNTAX_XR0 iovss G1_EXPLICIT_SUBSTRATE_VSS ptap1 R=9.826
.ends G1_VSS_DERIVATIVE__sg13g2_Clamp_P2N2D
.subckt G1_VSS_DERIVATIVE__sg13g2_Clamp_N2N2D gate iovss pad G1_EXPLICIT_SUBSTRATE_VSS
XR_G1_TAP_SYNTAX_XR0 iovss G1_EXPLICIT_SUBSTRATE_VSS ptap1 R=11.438
XMN1 pad gate iovss G1_EXPLICIT_SUBSTRATE_VSS sg13_hv_nmos m=1 w=8.8u l=600.0n ng=2
* removed (--pads nodcn): DD0 G1_EXPLICIT_SUBSTRATE_VSS gate dantenna m=1 w=780.00n l=780.00n a=608.400f p=3.12u
.ends G1_VSS_DERIVATIVE__sg13g2_Clamp_N2N2D
.subckt G1_VSS_DERIVATIVE__sg13g2_IOPadOut4mA pad c2p vdd vss iovdd iovss G1_EXPLICIT_SUBSTRATE_VSS
XI2 net2 net1 iovdd c2p vdd vss G1_EXPLICIT_SUBSTRATE_VSS G1_VSS_DERIVATIVE__sg13g2_GateLevelUpInv
XI0 net1 iovdd iovss pad G1_EXPLICIT_SUBSTRATE_VSS G1_VSS_DERIVATIVE__sg13g2_Clamp_P2N2D
XI3 net2 iovss pad G1_EXPLICIT_SUBSTRATE_VSS G1_VSS_DERIVATIVE__sg13g2_Clamp_N2N2D
XI4 iovss pad iovdd G1_EXPLICIT_SUBSTRATE_VSS G1_VSS_DERIVATIVE__sg13g2_DCNDiode
XI1 pad iovdd iovss G1_EXPLICIT_SUBSTRATE_VSS G1_VSS_DERIVATIVE__sg13g2_DCPDiode
XR_G1_TAP_SYNTAX_XR1 iovss G1_EXPLICIT_SUBSTRATE_VSS ptap1 R=212.747m
XR_G1_TAP_SYNTAX_XR0 vss G1_EXPLICIT_SUBSTRATE_VSS ptap1 R=24.125
.ends G1_VSS_DERIVATIVE__sg13g2_IOPadOut4mA
.subckt G1_VSS_DERIVATIVE__sg13g2_LevelDown core pad iovdd iovss vdd vss G1_EXPLICIT_SUBSTRATE_VSS
XMP0 vdd vdd vdd vdd sg13_hv_pmos m=1 w=4.65u l=450.00n ng=1
XMP2 net4 net7 iovdd iovdd sg13_hv_pmos m=1 w=4.6u l=450.00n ng=2
XMP3 net7 net1 iovdd iovdd sg13_hv_pmos m=1 w=4.6u l=450.00n ng=2
XMN3 net4 net7 iovss G1_EXPLICIT_SUBSTRATE_VSS sg13_hv_nmos m=1 w=1.3u l=450.00n ng=1
XMN4 net7 net1 iovss G1_EXPLICIT_SUBSTRATE_VSS sg13_hv_nmos m=1 w=1.3u l=450.00n ng=1
XMN2 net2 net4 vss G1_EXPLICIT_SUBSTRATE_VSS sg13_hv_nmos m=1 w=2.65u l=450.00n ng=1
XMN0 vdd net7 net2 G1_EXPLICIT_SUBSTRATE_VSS sg13_hv_nmos m=1 w=2.65u l=450.00n ng=1
XMN1 core net2 vss G1_EXPLICIT_SUBSTRATE_VSS sg13_lv_nmos m=1 w=2.75u l=130.00n ng=1
XMP1 core net2 vdd vdd sg13_lv_pmos m=1 w=4.75u l=130.00n ng=1
XR_G1_TAP_SYNTAX_XR1 iovss G1_EXPLICIT_SUBSTRATE_VSS ptap1 R=199.584
XR_G1_TAP_SYNTAX_XR0 vss G1_EXPLICIT_SUBSTRATE_VSS ptap1 R=127.332
XI0 net1 iovss pad iovdd G1_EXPLICIT_SUBSTRATE_VSS G1_VSS_DERIVATIVE__sg13g2_SecondaryProtection
.ends G1_VSS_DERIVATIVE__sg13g2_LevelDown
.subckt G1_VSS_DERIVATIVE__sg13g2_IOPadIn pad p2c vdd vss iovdd iovss G1_EXPLICIT_SUBSTRATE_VSS
XI0 p2c pad iovdd iovss vdd vss G1_EXPLICIT_SUBSTRATE_VSS G1_VSS_DERIVATIVE__sg13g2_LevelDown
XI2 iovss pad iovdd G1_EXPLICIT_SUBSTRATE_VSS G1_VSS_DERIVATIVE__sg13g2_DCNDiode
XI1 pad iovdd iovss G1_EXPLICIT_SUBSTRATE_VSS G1_VSS_DERIVATIVE__sg13g2_DCPDiode
XR_G1_TAP_SYNTAX_XR0 vss G1_EXPLICIT_SUBSTRATE_VSS ptap1 R=24.69
XR_G1_TAP_SYNTAX_XR1 iovss G1_EXPLICIT_SUBSTRATE_VSS ptap1 R=173.674m
.ends G1_VSS_DERIVATIVE__sg13g2_IOPadIn
.subckt G1_VSS_DERIVATIVE__sg13g2_Clamp_P8N8D gate iovdd iovss pad G1_EXPLICIT_SUBSTRATE_VSS
XR_G1_TAP_SYNTAX_XR0 iovss G1_EXPLICIT_SUBSTRATE_VSS ptap1 R=9.826
XMP2 pad gate iovdd iovdd sg13_hv_pmos m=1 w=53.28u l=600.0n ng=8
XMP0 pad gate iovdd iovdd sg13_hv_pmos m=1 w=53.28u l=600.0n ng=8
XDD0 gate iovdd dpantenna m=1 w=480n l=480n
.ends G1_VSS_DERIVATIVE__sg13g2_Clamp_P8N8D
.subckt G1_VSS_DERIVATIVE__sg13g2_Clamp_N8N8D gate iovss pad G1_EXPLICIT_SUBSTRATE_VSS
XR_G1_TAP_SYNTAX_XR0 iovss G1_EXPLICIT_SUBSTRATE_VSS ptap1 R=11.438
XMN0 pad gate iovss G1_EXPLICIT_SUBSTRATE_VSS sg13_hv_nmos m=1 w=35.2u l=600.0n ng=8
* removed (--pads nodcn): DD0 G1_EXPLICIT_SUBSTRATE_VSS gate dantenna m=1 w=780.00n l=780.00n a=608.400f p=3.12u
.ends G1_VSS_DERIVATIVE__sg13g2_Clamp_N8N8D
.subckt G1_VSS_DERIVATIVE__sg13g2_IOPadOut16mA pad c2p vdd vss iovdd iovss G1_EXPLICIT_SUBSTRATE_VSS
XI2 net2 net1 iovdd c2p vdd vss G1_EXPLICIT_SUBSTRATE_VSS G1_VSS_DERIVATIVE__sg13g2_GateLevelUpInv
XI0 net1 iovdd iovss pad G1_EXPLICIT_SUBSTRATE_VSS G1_VSS_DERIVATIVE__sg13g2_Clamp_P8N8D
XI4 iovss pad iovdd G1_EXPLICIT_SUBSTRATE_VSS G1_VSS_DERIVATIVE__sg13g2_DCNDiode
XI3 net2 iovss pad G1_EXPLICIT_SUBSTRATE_VSS G1_VSS_DERIVATIVE__sg13g2_Clamp_N8N8D
XI1 pad iovdd iovss G1_EXPLICIT_SUBSTRATE_VSS G1_VSS_DERIVATIVE__sg13g2_DCPDiode
XR_G1_TAP_SYNTAX_XR0 vss G1_EXPLICIT_SUBSTRATE_VSS ptap1 R=23.888
XR_G1_TAP_SYNTAX_XR1 iovss G1_EXPLICIT_SUBSTRATE_VSS ptap1 R=208.667m
.ends G1_VSS_DERIVATIVE__sg13g2_IOPadOut16mA
* g1_digital replaced by the real RTL (XSPICE d_cosim, rtl/g1_dig_cosim_cdl.v); CDL port list kept; por_n: the wrapper ties
* por_n = 1 (the CDL drives it from sg13g2_tiehi); en/sclk/sdi/osc_clk through the single-threshold receiver
.subckt g1_digital bgr_r4 clk_div_out clr_d cmp_clk cmp_hard cmp_soft en fast_en fault_n gate_en osc_clk osc_en por_n sclk sdi sdo t2f_en t2f_mode trip trip_d trip_set_sel tripped VDD VSS dac_hard_7_ dac_hard_6_ dac_hard_5_ dac_hard_4_ dac_hard_3_ dac_hard_2_ dac_hard_1_ dac_hard_0_ dac_soft_7_ dac_soft_6_ dac_soft_5_ dac_soft_4_ dac_soft_3_ dac_soft_2_ dac_soft_1_ dac_soft_0_ osc_trim_3_ osc_trim_2_ osc_trim_1_ osc_trim_0_ trip_cause_1_ trip_cause_0_
aclock [osc_clk] [d_osc_clk] adc_clock
ain [en sclk sdi] [d_en d_sclk d_sdi] adc_clock
aadc [cmp_soft cmp_hard tripped] [d_cmp_soft d_cmp_hard d_tripped] adc
adig [d_osc_clk d_en d_sclk d_sdi d_cmp_soft d_cmp_hard d_tripped] [d_cmp_clk d_s7 d_s6 d_s5 d_s4 d_s3 d_s2 d_s1 d_s0 d_h7 d_h6 d_h5 d_h4 d_h3 d_h2 d_h1 d_h0 d_trip_d d_clr_d d_fast_en d_osc_en d_t3 d_t2 d_t1 d_t0 d_trip d_gate_en d_cause1 d_cause0 d_sdo d_sp15 d_sp14 d_sp13 d_sp12 d_sp11 d_sp10 d_sp9 d_sp8 d_sp7 d_sp6 d_sp5 d_sp4 d_sp3 d_sp2 d_sp1 d_sp0 d_inrush d_softarmed d_t2f_en d_t2f_mode d_bgr_r4 d_fault_n d_trip_set_sel d_clk_div_out] rtl
adac [d_cmp_clk d_s7 d_s6 d_s5 d_s4 d_s3 d_s2 d_s1 d_s0 d_h7 d_h6 d_h5 d_h4 d_h3 d_h2 d_h1 d_h0 d_trip_d d_clr_d d_fast_en d_osc_en d_t3 d_t2 d_t1 d_t0 d_trip d_gate_en d_cause1 d_cause0 d_sdo d_sp15 d_sp14 d_sp13 d_sp12 d_sp11 d_sp10 d_sp9 d_sp8 d_sp7 d_sp6 d_sp5 d_sp4 d_sp3 d_sp2 d_sp1 d_sp0 d_inrush d_softarmed d_t2f_en d_t2f_mode d_bgr_r4 d_fault_n d_trip_set_sel d_clk_div_out] [cmp_clk dac_soft_7_ dac_soft_6_ dac_soft_5_ dac_soft_4_ dac_soft_3_ dac_soft_2_ dac_soft_1_ dac_soft_0_ dac_hard_7_ dac_hard_6_ dac_hard_5_ dac_hard_4_ dac_hard_3_ dac_hard_2_ dac_hard_1_ dac_hard_0_ trip_d clr_d fast_en osc_en osc_trim_3_ osc_trim_2_ osc_trim_1_ osc_trim_0_ trip gate_en trip_cause_1_ trip_cause_0_ sdo sp15 sp14 sp13 sp12 sp11 sp10 sp9 sp8 sp7 sp6 sp5 sp4 sp3 sp2 sp1 sp0 inrush_active soft_armed t2f_en t2f_mode bgr_r4 fault_n trip_set_sel clk_div_out] dac
.ends
* g1_osc replaced (--osc ideal): ideal 9.436194721 MHz clock of run_top.py, gated by en; no supply current
.subckt g1_osc en trim_0_ trim_1_ trim_2_ trim_3_ osc_clk VDD VSS
Vosc_i osc_i VSS pulse(0 1.2 1e-07 1n 1n 5.19875e-08 1.05975e-07)
Ben_g en_g VSS V = v(en, VSS) * min(1, max(0, (time - 0.1u) / 50n))
Bosc_clk osc_clk VSS V = v(osc_i, VSS) * (0.5 + 0.5*tanh((v(en_g, VSS) - 0.6)/0.05))
Rosc_vdd VDD VSS 1e12
.ends
* g1_chip_top: deck-local copy of the CDL top; 4867 filler/decap/antenna instances merged into 34 (m=count);
* supply-pin ammeters vm_bgr on VDDA, vm_gatea on VDDA, vm_gated on VDD, vm_ls on VDDA, vm_lsd on VDD, vm_osc on VDD, vm_sense on VDDA, vm_t2f on VDDA, vm_t2fd on VDD, vm_tripa on VDDA, vm_tripd on VDD
.subckt g1_chip_top D_ELT D_STD EN FAULT_N GATE G_SHARED HBT_B HBT_C HBT_E SCLK SDI SDO SENSE_N SENSE_P TEMP_OUT TRIP_SET VDDA VREF VDD VSS IOVDD IOVSS
Xi_core_u_bgr VDDA__vm_bgr VSS i_core_bgr_r4_33 i_core_vref i_core_iptat i_core_pbias i_core_pcasc i_core_unused_vbe i_core_dvbe g1_bgr
Xi_core_u_digital i_core_bgr_r4_12 i_core_clk_div_out i_core_clr_d i_core_cmp_clk i_core_cmp_hard i_core_cmp_soft en_i i_core_fast_en i_core_fault_n_dig i_core_gate_en i_core_osc_clk i_core_osc_en net i_core_sclk_i i_core_sdi_i i_core_sdo_o i_core_t2f_en_12 i_core_t2f_mode_12 i_core_trip i_core_trip_d i_core_trip_set_sel i_core_tripped VDD VSS i_core_dac_hard_7_ i_core_dac_hard_6_ i_core_dac_hard_5_ i_core_dac_hard_4_ i_core_dac_hard_3_ i_core_dac_hard_2_ i_core_dac_hard_1_ i_core_dac_hard_0_ i_core_dac_soft_7_ i_core_dac_soft_6_ i_core_dac_soft_5_ i_core_dac_soft_4_ i_core_dac_soft_3_ i_core_dac_soft_2_ i_core_dac_soft_1_ i_core_dac_soft_0_ i_core_osc_trim_3_ i_core_osc_trim_2_ i_core_osc_trim_1_ i_core_osc_trim_0_ i_core_trip_cause_1_ i_core_trip_cause_0_ g1_digital
Xi_core_u_digital_1 net VDD VSS sg13g2_tiehi
Xi_core_u_dose D_ELT D_STD G_SHARED VSS g1_dose_macro
Xi_core_u_dut HBT_C HBT_B HBT_E VSS g1_dut_macro
Xi_core_u_gate i_core_trip_d i_core_clr_d i_core_fast_en i_core_cmp_hard en_i gate_o fault_n_o i_core_tripped VDD__vm_gated VDDA__vm_gatea VSS g1_gate
Xi_core_u_ls_en i_core_t2f_en_12 i_core_t2f_en_33 VDD__vm_lsd VDDA__vm_ls VSS g1_ls_up
Xi_core_u_ls_mode i_core_t2f_mode_12 i_core_t2f_mode_33 VDD__vm_lsd VDDA__vm_ls VSS g1_ls_up
Xi_core_u_ls_r4 i_core_bgr_r4_12 i_core_bgr_r4_33 VDD VDDA VSS g1_ls_up
Xi_core_u_osc i_core_osc_en i_core_osc_trim_0_ i_core_osc_trim_1_ i_core_osc_trim_2_ i_core_osc_trim_3_ i_core_osc_clk VDD__vm_osc VSS g1_osc
Xi_core_u_sense SENSE_P SENSE_N i_core_vref i_core_iptat i_core_isense i_core_unused_vped i_core_vref_buf VDDA__vm_sense VSS g1_sense
Xi_core_u_t2f VDDA__vm_t2f VDD__vm_t2fd VSS i_core_pbias i_core_pcasc i_core_vref i_core_t2f_en_33 i_core_t2f_mode_33 i_core_temp_out_o g1_t2f
Xi_core_u_trip i_core_isense i_core_vref_buf i_core_cmp_clk i_core_dac_soft_0_ i_core_dac_soft_1_ i_core_dac_soft_2_ i_core_dac_soft_3_ i_core_dac_soft_4_ i_core_dac_soft_5_ i_core_dac_soft_6_ i_core_dac_soft_7_ i_core_dac_hard_0_ i_core_dac_hard_1_ i_core_dac_hard_2_ i_core_dac_hard_3_ i_core_dac_hard_4_ i_core_dac_hard_5_ i_core_dac_hard_6_ i_core_dac_hard_7_ i_core_cmp_soft i_core_cmp_hard VDD__vm_tripd VDDA__vm_tripa VSS g1_trip
Xpad01_vdd VDD VSS IOVDD IOVSS VSS G1_VSS_DERIVATIVE__sg13g2_IOPadVdd
Xpad02_vss VDD VSS IOVDD IOVSS VSS G1_VSS_DERIVATIVE__sg13g2_IOPadVss
Xpad03_iovdd VDD VSS IOVDD IOVSS VSS G1_VSS_DERIVATIVE__sg13g2_IOPadIOVdd
Xpad04_iovss VDD VSS IOVDD IOVSS VSS G1_VSS_DERIVATIVE__sg13g2_IOPadIOVss
Xpad05_vss VDD VSS IOVDD IOVSS VSS G1_VSS_DERIVATIVE__sg13g2_IOPadVss
Xpad06_iovss VDD VSS IOVDD IOVSS VSS G1_VSS_DERIVATIVE__sg13g2_IOPadIOVss
Xpad07_vdda VDDA _nc1 VDD VSS IOVDD IOVSS VSS G1_VSS_DERIVATIVE__sg13g2_IOPadAnalog
Xpad08_sense_p SENSE_P _nc2 VDD VSS IOVDD IOVSS VSS G1_VSS_DERIVATIVE__sg13g2_IOPadAnalog
Xpad09_sense_n SENSE_N _nc3 VDD VSS IOVDD IOVSS VSS G1_VSS_DERIVATIVE__sg13g2_IOPadAnalog
Xpad10_gate GATE gate_o VDD VSS IOVDD IOVSS VSS G1_VSS_DERIVATIVE__sg13g2_IOPadOut30mA
Xpad11_fault_n FAULT_N fault_n_o VDD VSS IOVDD IOVSS VSS G1_VSS_DERIVATIVE__sg13g2_IOPadOut4mA
Xpad12_en EN en_i VDD VSS IOVDD IOVSS VSS G1_VSS_DERIVATIVE__sg13g2_IOPadIn
Xpad13_trip_set TRIP_SET i_core_trip_set VDD VSS IOVDD IOVSS VSS G1_VSS_DERIVATIVE__sg13g2_IOPadAnalog
Xpad14_sclk SCLK i_core_sclk_i VDD VSS IOVDD IOVSS VSS G1_VSS_DERIVATIVE__sg13g2_IOPadIn
Xpad15_sdi SDI i_core_sdi_i VDD VSS IOVDD IOVSS VSS G1_VSS_DERIVATIVE__sg13g2_IOPadIn
Xpad16_sdo SDO i_core_sdo_o VDD VSS IOVDD IOVSS VSS G1_VSS_DERIVATIVE__sg13g2_IOPadOut4mA
Xpad17_temp_out TEMP_OUT i_core_temp_out_o VDD VSS IOVDD IOVSS VSS G1_VSS_DERIVATIVE__sg13g2_IOPadOut16mA
Xpad18_vref VREF i_core_vref VDD VSS IOVDD IOVSS VSS G1_VSS_DERIVATIVE__sg13g2_IOPadAnalog
Xpad19_g_shared G_SHARED _nc4 VDD VSS IOVDD IOVSS VSS G1_VSS_DERIVATIVE__sg13g2_IOPadAnalog
Xpad20_d_std D_STD _nc5 VDD VSS IOVDD IOVSS VSS G1_VSS_DERIVATIVE__sg13g2_IOPadAnalog
Xpad21_d_elt D_ELT _nc6 VDD VSS IOVDD IOVSS VSS G1_VSS_DERIVATIVE__sg13g2_IOPadAnalog
Xpad22_hbt_e HBT_E _nc7 VDD VSS IOVDD IOVSS VSS G1_VSS_DERIVATIVE__sg13g2_IOPadAnalog
Xpad23_hbt_b HBT_B _nc8 VDD VSS IOVDD IOVSS VSS G1_VSS_DERIVATIVE__sg13g2_IOPadAnalog
Xpad24_hbt_c HBT_C _nc9 VDD VSS IOVDD IOVSS VSS G1_VSS_DERIVATIVE__sg13g2_IOPadAnalog
XANTENNA_1 en_i VDD VSS sg13g2_antennanp
XANTENNA_2 i_core_cmp_soft VDD VSS sg13g2_antennanp m=2
XANTENNA_4 i_core_sdi_i VDD VSS sg13g2_antennanp
XANTENNA_5 i_core_tripped VDD VSS sg13g2_antennanp m=2
XFILLER_0_1006 VDD VSS sg13g2_decap_8 m=4645
XFILLER_0_1293 VDD VSS sg13g2_fill_2 m=38
XFILLER_17_2 VDD VSS sg13g2_fill_1 m=21
XFILLER_17_740 VDD VSS sg13g2_decap_4 m=17
XIO_BOND_pad01_vdd VDD bondpad_70x70_tm1
XIO_BOND_pad02_vss VSS bondpad_70x70_tm1 m=2
XIO_BOND_pad03_iovdd IOVDD bondpad_70x70_tm1
XIO_BOND_pad04_iovss IOVSS bondpad_70x70_tm1 m=2
XIO_BOND_pad07_vdda VDDA bondpad_70x70_tm1
XIO_BOND_pad08_sense_p SENSE_P bondpad_70x70_tm1
XIO_BOND_pad09_sense_n SENSE_N bondpad_70x70_tm1
XIO_BOND_pad10_gate GATE bondpad_70x70_tm1
XIO_BOND_pad11_fault_n FAULT_N bondpad_70x70_tm1
XIO_BOND_pad12_en EN bondpad_70x70_tm1
XIO_BOND_pad13_trip_set TRIP_SET bondpad_70x70_tm1
XIO_BOND_pad14_sclk SCLK bondpad_70x70_tm1
XIO_BOND_pad15_sdi SDI bondpad_70x70_tm1
XIO_BOND_pad16_sdo SDO bondpad_70x70_tm1
XIO_BOND_pad17_temp_out TEMP_OUT bondpad_70x70_tm1
XIO_BOND_pad18_vref VREF bondpad_70x70_tm1
XIO_BOND_pad19_g_shared G_SHARED bondpad_70x70_tm1
XIO_BOND_pad20_d_std D_STD bondpad_70x70_tm1
XIO_BOND_pad21_d_elt D_ELT bondpad_70x70_tm1
XIO_BOND_pad22_hbt_e HBT_E bondpad_70x70_tm1
XIO_BOND_pad23_hbt_b HBT_B bondpad_70x70_tm1
XIO_BOND_pad24_hbt_c HBT_C bondpad_70x70_tm1
XIO_CORNER_NORTH_EAST_INST VDD VSS IOVDD IOVSS VSS G1_VSS_DERIVATIVE__sg13g2_Corner m=4
XIO_FILL_IO_EAST_0_0 VDD VSS IOVDD IOVSS VSS G1_VSS_DERIVATIVE__sg13g2_Filler4000 m=40
XIO_FILL_IO_EAST_0_20 VDD VSS IOVDD IOVSS VSS G1_VSS_DERIVATIVE__sg13g2_Filler2000 m=28
XIO_FILL_IO_EAST_0_30 VDD VSS IOVDD IOVSS VSS G1_VSS_DERIVATIVE__sg13g2_Filler400 m=44
Vm_bgr VDDA VDDA__vm_bgr dc 0
Vm_gatea VDDA VDDA__vm_gatea dc 0
Vm_gated VDD VDD__vm_gated dc 0
Vm_ls VDDA VDDA__vm_ls dc 0
Vm_lsd VDD VDD__vm_lsd dc 0
Vm_osc VDD VDD__vm_osc dc 0
Vm_sense VDDA VDDA__vm_sense dc 0
Vm_t2f VDDA VDDA__vm_t2f dc 0
Vm_t2fd VDD VDD__vm_t2fd dc 0
Vm_tripa VDDA VDDA__vm_tripa dc 0
Vm_tripd VDD VDD__vm_tripd dc 0
.ends g1_chip_top
Xchip d_elt d_std en_pad fault_n gate g_shared hbt_b hbt_c hbt_e sclk_pad sdi_pad sdo_pad sense_n sense_p temp_out_pad trip_set vdda vref_pad vdd 0 iovdd 0 g1_chip_top
Cvref_ext vref_pad 0 {CVREF}
Csdo sdo_pad 0 20p
Ctemp_out temp_out_pad 0 20p
Rpd_d_elt d_elt 0 1meg
Rpd_d_std d_std 0 1meg
Rpd_g_shared g_shared 0 1meg
Rpd_hbt_b hbt_b 0 1meg
Rpd_hbt_c hbt_c 0 1meg
Rpd_hbt_e hbt_e 0 1meg
Rpd_trip_set trip_set 0 1meg
.save v(gate) v(gfet) v(xchip.i_core_tripped) v(xchip.i_core_isense) v(xchip.i_core_cmp_soft) v(xchip.i_core_cmp_hard) v(xchip.i_core_trip_d) v(xchip.i_core_clr_d) v(xchip.i_core_fast_en) v(xchip.i_core_osc_clk) v(xchip.i_core_cmp_clk)
+ v(xchip.i_core_vref) v(xchip.i_core_iptat) v(xchip.en_i) v(shp) v(shn) v(fault_n) v(xchip.gate_o) v(vdda) v(vdd) v(iovdd) v(iprof) v(xchip.xi_core_u_osc.en_g)
+ v(xchip.xi_core_u_trip.icmp) v(xchip.xi_core_u_trip.vth_soft) v(xchip.xi_core_u_trip.vth_hard) v(xchip.i_core_trip) v(xchip.i_core_trip_cause_1_) v(xchip.i_core_trip_cause_0_) v(sclk_pad) v(sdi_pad) v(xchip.i_core_sdo_o)
+ v(xchip.i_core_dac_soft_0_) v(xchip.i_core_dac_soft_1_) v(xchip.i_core_dac_soft_2_) v(xchip.i_core_dac_soft_3_) v(xchip.i_core_dac_soft_4_) v(xchip.i_core_dac_soft_5_) v(xchip.i_core_dac_soft_6_) v(xchip.i_core_dac_soft_7_) v(xchip.i_core_dac_hard_0_) v(xchip.i_core_dac_hard_1_) v(xchip.i_core_dac_hard_2_) v(xchip.i_core_dac_hard_3_) v(xchip.i_core_dac_hard_4_) v(xchip.i_core_dac_hard_5_) v(xchip.i_core_dac_hard_6_) v(xchip.i_core_dac_hard_7_)
+ v(xchip.xi_core_u_digital.sp0) v(xchip.xi_core_u_digital.sp1) v(xchip.xi_core_u_digital.sp2) v(xchip.xi_core_u_digital.sp3) v(xchip.xi_core_u_digital.sp4) v(xchip.xi_core_u_digital.sp5) v(xchip.xi_core_u_digital.sp6) v(xchip.xi_core_u_digital.sp7) v(xchip.xi_core_u_digital.sp8) v(xchip.xi_core_u_digital.sp9) v(xchip.xi_core_u_digital.sp10) v(xchip.xi_core_u_digital.sp11) v(xchip.xi_core_u_digital.sp12) v(xchip.xi_core_u_digital.sp13) v(xchip.xi_core_u_digital.sp14) v(xchip.xi_core_u_digital.sp15) v(xchip.xi_core_u_digital.inrush_active) v(xchip.xi_core_u_digital.soft_armed)
+ i(vim) i(vma) i(vmi) i(v12) i(v.xchip.vm_bgr) i(v.xchip.vm_sense) i(v.xchip.vm_tripa) i(v.xchip.vm_tripd) i(v.xchip.vm_osc) i(v.xchip.vm_gatea) i(v.xchip.vm_gated)
+ v(xchip.i_core_temp_out_o) v(xchip.i_core_t2f_en_33) v(xchip.i_core_t2f_mode_33) v(xchip.i_core_pbias) v(xchip.i_core_pcasc) i(v.xchip.vm_t2f) i(v.xchip.vm_t2fd) i(v.xchip.vm_ls) i(v.xchip.vm_lsd)
+ v(xchip.i_core_vref_buf) v(xchip.i_core_unused_vped)
.control
set filetype=ascii
set wr_singlescale
set wr_vecnames
tran 2e-08 28u 0 5e-09
* quiet operating values after the register write(s): window averages over the last 2 us before the load
* event (comparator kickback averaged out); single-instant samples at t_cfg + 1 us kept as *_inst
meas tran vref_q avg v(xchip.i_core_vref) from=14u to=16u
meas tran isense_q avg v(xchip.i_core_isense) from=14u to=16u
meas tran icmp_q avg v(xchip.xi_core_u_trip.icmp) from=14u to=16u
meas tran vths_q avg v(xchip.xi_core_u_trip.vth_soft) from=14u to=16u
meas tran vthh_q avg v(xchip.xi_core_u_trip.vth_hard) from=14u to=16u
meas tran vref_i find v(xchip.i_core_vref) at=12.8565u
meas tran isense_i find v(xchip.i_core_isense) at=12.8565u
meas tran icmp_i find v(xchip.xi_core_u_trip.icmp) at=12.8565u
meas tran vths_i find v(xchip.xi_core_u_trip.vth_soft) at=12.8565u
meas tran vthh_i find v(xchip.xi_core_u_trip.vth_hard) at=12.8565u
meas tran iload_q find i(vim) at=12.8565u
meas tran gate_q find v(gate) at=12.8565u
meas tran fastq find v(xchip.i_core_fast_en) at=12.8565u
meas tran t_inrush_off when v(xchip.xi_core_u_digital.inrush_active)=0.6 fall=1 from=3u
meas tran inrush_q find v(xchip.xi_core_u_digital.inrush_active) at=12.8565u
meas tran softarmed_end find v(xchip.xi_core_u_digital.soft_armed) at=28u
let cs_v = 1*(v(xchip.i_core_dac_soft_0_) gt 0.6) + 2*(v(xchip.i_core_dac_soft_1_) gt 0.6) + 4*(v(xchip.i_core_dac_soft_2_) gt 0.6) + 8*(v(xchip.i_core_dac_soft_3_) gt 0.6) + 16*(v(xchip.i_core_dac_soft_4_) gt 0.6) + 32*(v(xchip.i_core_dac_soft_5_) gt 0.6) + 64*(v(xchip.i_core_dac_soft_6_) gt 0.6) + 128*(v(xchip.i_core_dac_soft_7_) gt 0.6)
let ch_v = 1*(v(xchip.i_core_dac_hard_0_) gt 0.6) + 2*(v(xchip.i_core_dac_hard_1_) gt 0.6) + 4*(v(xchip.i_core_dac_hard_2_) gt 0.6) + 8*(v(xchip.i_core_dac_hard_3_) gt 0.6) + 16*(v(xchip.i_core_dac_hard_4_) gt 0.6) + 32*(v(xchip.i_core_dac_hard_5_) gt 0.6) + 64*(v(xchip.i_core_dac_hard_6_) gt 0.6) + 128*(v(xchip.i_core_dac_hard_7_) gt 0.6)
meas tran code_soft find cs_v at=12.8565u
meas tran code_hard find ch_v at=12.8565u
let t_inrush_off_us = t_inrush_off*1e6
echo "QUIET window_us=14-16 vref=" $&vref_q " isense=" $&isense_q " icmp=" $&icmp_q " vth_soft=" $&vths_q " vth_hard=" $&vthh_q " vref_inst=" $&vref_i " isense_inst=" $&isense_i " icmp_inst=" $&icmp_i " vth_soft_inst=" $&vths_i " vth_hard_inst=" $&vthh_i " iload_A=" $&iload_q " gate=" $&gate_q " code_soft=" $&code_soft " code_hard=" $&code_hard " fast_en=" $&fastq " inrush_active=" $&inrush_q " t_inrush_off_us=" $&t_inrush_off_us " soft_armed_end=" $&softarmed_end
* clocks: 20 oscillator periods and 10 strobe periods after the configuration
meas tran tosc1 when v(xchip.i_core_osc_clk)=0.6 rise=1 from=11.8565u
meas tran tosc2 when v(xchip.i_core_osc_clk)=0.6 rise=21 from=11.8565u
let fosc_mhz = 20e-6/(tosc2 - tosc1)
meas tran tcc1 when v(xchip.i_core_cmp_clk)=0.6 rise=1 from=11.8565u
meas tran tcc2 when v(xchip.i_core_cmp_clk)=0.6 rise=11 from=11.8565u
let fcmp_mhz = 10e-6/(tcc2 - tcc1)
echo "CLOCK f_osc_MHz=" $&fosc_mhz " f_cmp_MHz=" $&fcmp_mhz " (RTL clock: ideal source at the block-simulated frequency)"
* supply currents averaged over the quiet armed window
let i_vdda = i(vma)
meas tran ia_vdda avg i_vdda from=13.8565u to=16u
let ua_vdda = ia_vdda*1e6
let i_iovdd = i(vmi)
meas tran ia_iovdd avg i_iovdd from=13.8565u to=16u
let ua_iovdd = ia_iovdd*1e6
let i_vdd = -i(v12)
meas tran ia_vdd avg i_vdd from=13.8565u to=16u
let ua_vdd = ia_vdd*1e6
let i_bgr = i(v.xchip.vm_bgr)
meas tran ia_bgr avg i_bgr from=13.8565u to=16u
let ua_bgr = ia_bgr*1e6
let i_sense = i(v.xchip.vm_sense)
meas tran ia_sense avg i_sense from=13.8565u to=16u
let ua_sense = ia_sense*1e6
let i_tripa = i(v.xchip.vm_tripa)
meas tran ia_tripa avg i_tripa from=13.8565u to=16u
let ua_tripa = ia_tripa*1e6
let i_tripd = i(v.xchip.vm_tripd)
meas tran ia_tripd avg i_tripd from=13.8565u to=16u
let ua_tripd = ia_tripd*1e6
let i_osc = i(v.xchip.vm_osc)
meas tran ia_osc avg i_osc from=13.8565u to=16u
let ua_osc = ia_osc*1e6
let i_gatea = i(v.xchip.vm_gatea)
meas tran ia_gatea avg i_gatea from=13.8565u to=16u
let ua_gatea = ia_gatea*1e6
let i_gated = i(v.xchip.vm_gated)
meas tran ia_gated avg i_gated from=13.8565u to=16u
let ua_gated = ia_gated*1e6
echo "SUPPLY_uA window=13.8565-16us VDDA=" $&ua_vdda " IOVDD=" $&ua_iovdd " VDD=" $&ua_vdd " | bgr=" $&ua_bgr " sense=" $&ua_sense " trip_3v3=" $&ua_tripa " trip_1v2=" $&ua_tripd " osc=" $&ua_osc " gate_3v3=" $&ua_gatea " gate_1v2=" $&ua_gated
* G1_T2F: output frequency (rising 0.6 V crossings) and supply currents over the quiet window
meas tran t2f_t1 when v(xchip.i_core_temp_out_o)=0.6 rise=1 from=13.8565u to=16u
meas tran t2f_t2 when v(xchip.i_core_temp_out_o)=0.6 rise=3 from=13.8565u to=16u
let t2f_mhz = 2e-6/(t2f_t2 - t2f_t1)
meas tran ia_t2f avg i(v.xchip.vm_t2f) from=13.8565u to=16u
let ua_t2f = ia_t2f*1e6
meas tran ia_t2fd avg i(v.xchip.vm_t2fd) from=13.8565u to=16u
let ua_t2fd = ia_t2fd*1e6
meas tran ia_ls avg i(v.xchip.vm_ls) from=13.8565u to=16u
let ua_ls = ia_ls*1e6
meas tran ia_lsd avg i(v.xchip.vm_lsd) from=13.8565u to=16u
let ua_lsd = ia_lsd*1e6
echo "T2F window=13.8565-16us f_MHz=" $&t2f_mhz " periods=2 vdda_t2f_uA=" $&ua_t2f " vdd12_t2f_uA=" $&ua_t2fd " vdda_ls_uA=" $&ua_ls " vdd_ls_uA=" $&ua_lsd
* trip evaluation after the load event at T_STEP
let tstep_s = 16u
meas tran tripped_max max v(xchip.i_core_tripped) from=11.8565u to=28u
meas tran tripped_pre max v(xchip.i_core_tripped) from=11.8565u to=16u
meas tran t_tripped when v(xchip.i_core_tripped)=0.6 rise=1 from=16u
meas tran t_trip_d when v(xchip.i_core_trip_d)=0.6 rise=1 from=16u
meas tran t_gate1v when v(gate)=1.0 fall=1 from=16u
meas tran t_gate03 when v(gate)=0.33 fall=1 from=16u
meas tran gate_min min v(gate) from=16u to=28u
meas tran gate_end find v(gate) at=28u
meas tran ipk max i(vim) from=16u to=28u
meas tran i_end find i(vim) at=28u
meas tran isense_pk max v(xchip.i_core_isense) from=16u to=28u
meas tran cause1e find v(xchip.i_core_trip_cause_1_) at=28u
meas tran cause0e find v(xchip.i_core_trip_cause_0_) at=28u
meas tran fault_end find v(fault_n) at=28u
let sp_v = 1*(v(xchip.xi_core_u_digital.sp0) gt 0.6) + 2*(v(xchip.xi_core_u_digital.sp1) gt 0.6) + 4*(v(xchip.xi_core_u_digital.sp2) gt 0.6) + 8*(v(xchip.xi_core_u_digital.sp3) gt 0.6) + 16*(v(xchip.xi_core_u_digital.sp4) gt 0.6) + 32*(v(xchip.xi_core_u_digital.sp5) gt 0.6) + 64*(v(xchip.xi_core_u_digital.sp6) gt 0.6) + 128*(v(xchip.xi_core_u_digital.sp7) gt 0.6) + 256*(v(xchip.xi_core_u_digital.sp8) gt 0.6) + 512*(v(xchip.xi_core_u_digital.sp9) gt 0.6) + 1024*(v(xchip.xi_core_u_digital.sp10) gt 0.6) + 2048*(v(xchip.xi_core_u_digital.sp11) gt 0.6) + 4096*(v(xchip.xi_core_u_digital.sp12) gt 0.6) + 8192*(v(xchip.xi_core_u_digital.sp13) gt 0.6) + 16384*(v(xchip.xi_core_u_digital.sp14) gt 0.6) + 32768*(v(xchip.xi_core_u_digital.sp15) gt 0.6)
meas tran soft_peak find sp_v at=28u
let cause = 2*(cause1e gt 0.6) + (cause0e gt 0.6)
let dt_gate1v_us = (t_gate1v - tstep_s)*1e6
let dt_gate03_us = (t_gate03 - tstep_s)*1e6
let dt_tripped_us = (t_tripped - tstep_s)*1e6
let dt_trip_d_us = (t_trip_d - tstep_s)*1e6
echo "TRIP tripped_max=" $&tripped_max " tripped_before_event=" $&tripped_pre " t_tripped_us=" $&dt_tripped_us " t_trip_d_us=" $&dt_trip_d_us " t_gate_1V_us=" $&dt_gate1v_us " t_gate_0.33V_us=" $&dt_gate03_us " gate_min=" $&gate_min " gate_end=" $&gate_end " ipk_A=" $&ipk " i_end_A=" $&i_end " isense_pk=" $&isense_pk " cause=" $&cause " fault_n_end=" $&fault_end " soft_peak=" $&soft_peak
let qi = integ(i(vim))
meas tran q_step find qi at=16u
meas tran q_end find qi at=28u
let q_passed = q_end - q_step
echo "CHARGE after_event_As=" $&q_passed
wrdata /work/build/g1_top/state_cdl_c_mid_sch_tt_27C_gear_compact_optitl4500_functional_cdlv5.txt v(xchip.en_i) v(xchip.xi_core_u_digital.inrush_active) v(xchip.i_core_trip) v(xchip.i_core_fast_en) v(xchip.i_core_trip_cause_1_) v(xchip.i_core_trip_cause_0_) v(xchip.i_core_dac_soft_0_) v(xchip.i_core_dac_soft_1_) v(xchip.i_core_dac_soft_2_) v(xchip.i_core_dac_soft_3_) v(xchip.i_core_dac_soft_4_) v(xchip.i_core_dac_soft_5_) v(xchip.i_core_dac_soft_6_) v(xchip.i_core_dac_soft_7_) v(xchip.i_core_dac_hard_0_) v(xchip.i_core_dac_hard_1_) v(xchip.i_core_dac_hard_2_) v(xchip.i_core_dac_hard_3_) v(xchip.i_core_dac_hard_4_) v(xchip.i_core_dac_hard_5_) v(xchip.i_core_dac_hard_6_) v(xchip.i_core_dac_hard_7_) v(xchip.xi_core_u_digital.soft_armed) v(xchip.xi_core_u_digital.sp0) v(xchip.xi_core_u_digital.sp1) v(xchip.xi_core_u_digital.sp2) v(xchip.xi_core_u_digital.sp3) v(xchip.xi_core_u_digital.sp4) v(xchip.xi_core_u_digital.sp5) v(xchip.xi_core_u_digital.sp6) v(xchip.xi_core_u_digital.sp7) v(xchip.xi_core_u_digital.sp8) v(xchip.xi_core_u_digital.sp9) v(xchip.xi_core_u_digital.sp10) v(xchip.xi_core_u_digital.sp11) v(xchip.xi_core_u_digital.sp12) v(xchip.xi_core_u_digital.sp13) v(xchip.xi_core_u_digital.sp14) v(xchip.xi_core_u_digital.sp15) v(sclk_pad) v(sdi_pad) v(xchip.i_core_sdo_o) v(xchip.i_core_clr_d)
linearize v(gate) v(gfet) v(xchip.i_core_tripped) v(xchip.i_core_isense) v(xchip.i_core_cmp_soft) v(xchip.i_core_cmp_hard) v(xchip.i_core_cmp_clk) v(xchip.i_core_trip_d) v(xchip.i_core_osc_clk) v(xchip.i_core_vref) v(xchip.en_i) v(shp) v(fault_n) v(vdda) v(vdd) v(iprof) v(xchip.xi_core_u_trip.icmp) v(xchip.xi_core_u_trip.vth_soft) v(xchip.xi_core_u_trip.vth_hard) v(xchip.i_core_trip) v(xchip.xi_core_u_digital.inrush_active) i(vim) i(vma) i(vmi) i(v12)
wrdata /work/build/g1_top/waves_cdl_c_mid_sch_tt_27C_gear_compact_optitl4500_functional_cdlv5.txt v(gate) v(gfet) v(xchip.i_core_tripped) v(xchip.i_core_isense) v(xchip.i_core_cmp_soft) v(xchip.i_core_cmp_hard) v(xchip.i_core_cmp_clk) v(xchip.i_core_trip_d) v(xchip.i_core_osc_clk) v(xchip.i_core_vref) v(xchip.en_i) v(shp) v(fault_n) v(vdda) v(vdd) v(iprof) v(xchip.xi_core_u_trip.icmp) v(xchip.xi_core_u_trip.vth_soft) v(xchip.xi_core_u_trip.vth_hard) v(xchip.i_core_trip) v(xchip.xi_core_u_digital.inrush_active) i(vim) i(vma) i(vmi) i(v12)
.endc
.end
