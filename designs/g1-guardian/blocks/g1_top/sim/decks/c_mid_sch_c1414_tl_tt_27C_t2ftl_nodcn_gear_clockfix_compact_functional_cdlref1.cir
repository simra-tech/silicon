* G1_TOP breaker path, chip level: in-range hard trip: code 200 (~39.25mV), 1.8A/45mV fault in 20ns; HARD_N=4
* case c_mid | block netlists sch | front end tl | clock to the RTL ideal | corner tt (mos_tt res_typ cap_typ hbt_typ) | 27 degC | run_top.py
* blockset c1414 (run_top.py BLOCKSETS); ideal-clock frequency 9.436194721 MHz
* netlist bgr: blocks/g1_bgr/layout/coordinated_full_closure/evidence/pex-preparation-20260922-r1/controls/r1/baseline_586.spice
* netlist sense: blocks/g1_trip/sim/qualification/joint586-softinputpair4-nf4-roomcal-s73133-20260924-r1/sense.spice
* netlist trip: blocks/g1_trip/sim/qualification/joint586-softinputpair4-nf4-roomcal-s73133-20260924-r1/trip.spice
* netlist osc: blocks/g1_osc/sim/qualification/fulltree_r095_load_20260924/common/osc.spice
* netlist gate: blocks/g1_gate/sim/netlist/g1_gate.spice
* WARNING osc: no sch netlist exists for blockset c1414; using the pex netlist
* NOTE bgr: BGR586 source carries 329 historical Sep-19 kpex capacitors, not an extraction of the BGR586 layout
* NOTE trip: NF4 schematic netlist (no parasitics)
* WARNING deviation --inpads nodcn: SENSE_P/SENSE_N use g1_IOPadAnalog_nodcn, a deck-local copy of the PDK sg13g2_IOPadAnalog without its dantenna-based parts (sg13g2_DCNDiode and the SecondaryProtection dantenna D1); clamps, DCPDiode, SecondaryProtection 587 Ohm + dpantenna, ptap resistors and padres kept; VREF pad and PDK file unchanged. Reason: the PDK darea diode model switches formula at -3nVt (measured current step 1e-16->4e-11 A at 78 mV/27 C, 2e-14->2e-10 A at 93 mV/85 C, 1e-12->4e-10 A at 104 mV/125 C), which stalls the transient; removed leakage < 1 nA per pad at 125 C behind the 1 Ohm Kelvin trace (README, Numerical notes).
.param VDDA=3.3 VDD=1.2 IOVDD=3.3 RSH=25m RGND=10m INOM=1 CVREF=1e-08
.lib /foss/pdks/ihp-sg13g2/libs.tech/ngspice/models/cornerMOSlv.lib mos_tt
.lib /foss/pdks/ihp-sg13g2/libs.tech/ngspice/models/cornerMOShv.lib mos_tt
.lib /foss/pdks/ihp-sg13g2/libs.tech/ngspice/models/cornerRES.lib res_typ
.lib /foss/pdks/ihp-sg13g2/libs.tech/ngspice/models/cornerCAP.lib cap_typ
.lib /foss/pdks/ihp-sg13g2/libs.tech/ngspice/models/cornerHBT.lib hbt_typ
.lib /foss/pdks/ihp-sg13g2/libs.tech/ngspice/models/cornerDIO.lib dio_tt
.include /foss/pdks/ihp-sg13g2/libs.ref/sg13g2_io/spice/sg13g2_io.spi
.include /work/designs/g1-guardian/blocks/g1_bgr/layout/coordinated_full_closure/evidence/pex-preparation-20260922-r1/controls/r1/baseline_586.spice
.include /work/designs/g1-guardian/blocks/g1_trip/sim/qualification/joint586-softinputpair4-nf4-roomcal-s73133-20260924-r1/sense.spice
.include /work/designs/g1-guardian/blocks/g1_trip/sim/qualification/joint586-softinputpair4-nf4-roomcal-s73133-20260924-r1/trip.spice
.include /work/designs/g1-guardian/blocks/g1_gate/sim/netlist/g1_gate.spice
.include /work/designs/g1-guardian/blocks/g1_t2f/sim/postlayout/g1_t2f_pex.spice
.include /work/designs/g1-guardian/blocks/g1_ctrl/ls/sim/netlist/g1_ls_up.spice
.temp 27
.global sub!
Vsub sub! 0 dc 0
* solver (README, "Numerical notes"): gear integration and loose absolute tolerances are what the PDK IO-pad
* models need when XSPICE events fall on their switching edges (with abstol 1e-9 / vntol 1e-5 the diode
* internal nodes stop converging: "timestep too small"); the DAC mux-tree nodes need rshunt; XSPICE forces
* trtol = 1, which the comparator decisions need at this reltol; default gmin (1e-13 stalls the pads)
.option method=gear itl4=100 reltol=0.001 abstol=1e-10 vntol=1e-6 chgtol=1e-14 rshunt=1e12
.nodeset v(vref_buf)=1.04 v(vped)=1.0008 v(isense)=1.5 v(xsense.vp)=0.047 v(xsense.vn)=0.047 v(iptat)=0.76 v(xsense.xota.out1)=2.51 v(xsense.xota.mir)=2.51 v(xsense.xota.tail)=1.6 v(xsense.xota.fn)=0.2 v(xsense.xota.fp)=0.2 v(xsense.xbuf.out1)=2.51 v(xsense.xbuf.mir)=2.51 v(xsense.xbuf.tail)=1.6 v(xsense.xbuf.fn)=0.2 v(xsense.xbuf.fp)=0.2 v(xsense.xref.out1)=2.51 v(xsense.xref.mir)=2.51 v(xsense.xref.tail)=1.6 v(xsense.xref.fn)=0.2 v(xsense.xref.fp)=0.2
* ---- supplies: one 3.3 V board rail feeds VDDA (pin 7) and IOVDD (pin 3), PLAN D14; 1.2 V VDD (pin 1)
V33 rail33 0 dc 3.3
Vma rail33 vdda_s dc 0
Vmi rail33 iovdd_s dc 0
Rsa vdda_s vdda 0.5
Cda vdda 0 1n
Rsi iovdd_s iovdd 0.5
Cdi iovdd 0 1n
V12 vdd_s 0 dc 1.2
Rsd vdd_s vdd 0.5
Cdd vdd 0 1n
* ---- board: load current profile (1 V = 1 A) x switch on the FET gate node, shunt, Kelvin traces, FET gate
Vprof iprof 0 pwl(0 1 1.6e-05 1 1.602e-05 1.8)
Bload 0 ldi I = v(iprof) * (0.5 + 0.5*tanh((v(gfet) - 1.5)/0.15))
Vim ldi shp dc 0
Rsh shp shn {RSH}
Rgnd shn 0 {RGND}
Rkp shp sense_p 1
Rkn shn sense_n 1
Rg gate gfet 10
Cgate gfet 0 5n
Cfault fault_n 0 20p
* ---- pads (PDK sg13g2_io SPICE models): SENSE_P/N on the bare pad terminal, VREF on the padres terminal
* (587 Ohm secondary protection, padframe/README.md); the VREF bond pad carries the board capacitor CVREF
* ---- deck-local pad copy for --inpads nodcn (PDK sg13g2_io.spi untouched)
.subckt g1_IOPadAnalog_nodcn pad padres vdd vss iovdd iovss
XI0 iovdd iovss pad sg13g2_Clamp_P20N0D
* XI5 iovss pad iovdd sg13g2_DCNDiode   (removed: dantenna x2)
XI2 pad iovdd iovss sg13g2_DCPDiode
* XI3 padres iovss pad iovdd sg13g2_SecondaryProtection   (replaced below without its dantenna D1)
XI3R pad padres sub! rppd R=586.899 l=2u w=1u
XI3P iovss sub! ptap1 R=46.556
XI3D padres iovdd dpantenna l=4.98u w=640n m=1
XI4 iovss pad sg13g2_Clamp_N20N0D
XR0 vss sub! ptap1 R=22.579
XR1 iovss sub! ptap1 R=214.8m
.ends
XPSP sense_p sense_p_res vdd 0 iovdd 0 g1_IOPadAnalog_nodcn
XPSN sense_n sense_n_res vdd 0 iovdd 0 g1_IOPadAnalog_nodcn
XPVREF vref_pad vref vdd 0 iovdd 0 sg13g2_IOPadAnalog
Cvref_ext vref_pad 0 {CVREF}
* digital input pads (EN, SCLK, SDI) as ideal 3.3 V -> 1.2 V level copies: the sg13g2_IOPadIn SPICE
* models abort the event-driven solver at their input edges with the charge tolerance the comparators
* need (README, "Numerical notes"); the pads are functionally verified in blocks/g1_gate (EN pad)
Ben_core en_core 0 V = v(en_pad)*1.2/3.3
Bsclk_core sclk_core 0 V = v(sclk_pad)*1.2/3.3
Bsdi_core sdi_core 0 V = v(sdi_pad)*1.2/3.3
* GATE / FAULT_N output pads as behavioural drivers fitted to the g1_gate block results with the PDK pad
* models (30 mA pad: 5 nF + 10 Ohm, fall 90-10 % 606 ns, arming 0-90 % 677 ns -> 47 Ohm driver; 4 mA pad:
* 20 pF, ~500 Ohm). Reason: README, "Numerical notes" (pad models and the StrongARM comparators need
* incompatible integration settings). The driver switches within 1 ns of gate_core / fault_core and
* draws its current from IOVDD.
Bgate_drv gate_drv 0 V = v(iovdd)*(0.5 + 0.5*tanh((v(gate_core) - 0.6)/0.05))
Rgate_drv gate_drv gate 47
Bgate_i iovdd 0 I = max(0, (v(gate_drv) - v(gate))/47)
Bfault_drv fault_drv 0 V = v(iovdd)*(0.5 + 0.5*tanh((v(fault_core) - 0.6)/0.05))
Rfault_drv fault_drv fault_n 500
Ven en_pad 0 pwl(0 0 3.01431035636e-06 0 3.01521035636e-06 1.485 3.01541035636e-06 1.815 3.01631035636e-06 3.3)
Vsclk sclk_pad 0 pwl(0 0 4.07405957685e-06 0 4.1800344989e-06 0 4.1809344989e-06 1.485 4.1811344989e-06 1.815 4.1820344989e-06 3.3 4.28600942095e-06 3.3 4.28690942095e-06 1.815 4.28710942095e-06 1.485 4.28800942095e-06 0 4.391984343e-06 0 4.392884343e-06 1.485 4.393084343e-06 1.815 4.393984343e-06 3.3 4.49795926505e-06 3.3 4.49885926505e-06 1.815 4.49905926505e-06 1.485 4.49995926505e-06 0 4.6039341871e-06 0 4.6048341871e-06 1.485 4.6050341871e-06 1.815 4.6059341871e-06 3.3 4.70990910914e-06 3.3 4.71080910914e-06 1.815 4.71100910914e-06 1.485 4.71190910914e-06 0 4.81588403119e-06 0 4.81678403119e-06 1.485 4.81698403119e-06 1.815 4.81788403119e-06 3.3 4.92185895324e-06 3.3 4.92275895324e-06 1.815 4.92295895324e-06 1.485 4.92385895324e-06 0 5.02783387529e-06 0 5.02873387529e-06 1.485 5.02893387529e-06 1.815 5.02983387529e-06 3.3 5.13380879734e-06 3.3 5.13470879734e-06 1.815 5.13490879734e-06 1.485 5.13580879734e-06 0 5.23978371939e-06 0 5.24068371939e-06 1.485 5.24088371939e-06 1.815 5.24178371939e-06 3.3 5.34575864144e-06 3.3 5.34665864144e-06 1.815 5.34685864144e-06 1.485 5.34775864144e-06 0 5.45173356349e-06 0 5.45263356349e-06 1.485 5.45283356349e-06 1.815 5.45373356349e-06 3.3 5.55770848554e-06 3.3 5.55860848554e-06 1.815 5.55880848554e-06 1.485 5.55970848554e-06 0 5.66368340759e-06 0 5.66458340759e-06 1.485 5.66478340759e-06 1.815 5.66568340759e-06 3.3 5.76965832964e-06 3.3 5.77055832964e-06 1.815 5.77075832964e-06 1.485 5.77165832964e-06 0 5.87563325169e-06 0 5.87653325169e-06 1.485 5.87673325169e-06 1.815 5.87763325169e-06 3.3 5.98160817374e-06 3.3 5.98250817374e-06 1.815 5.98270817374e-06 1.485 5.98360817374e-06 0 6.08758309579e-06 0 6.08848309579e-06 1.485 6.08868309579e-06 1.815 6.08958309579e-06 3.3 6.19355801783e-06 3.3 6.19445801783e-06 1.815 6.19465801783e-06 1.485 6.19555801783e-06 0 6.29953293988e-06 0 6.30043293988e-06 1.485 6.30063293988e-06 1.815 6.30153293988e-06 3.3 6.40550786193e-06 3.3 6.40640786193e-06 1.815 6.40660786193e-06 1.485 6.40750786193e-06 0 6.51148278398e-06 0 6.51238278398e-06 1.485 6.51258278398e-06 1.815 6.51348278398e-06 3.3 6.61745770603e-06 3.3 6.61835770603e-06 1.815 6.61855770603e-06 1.485 6.61945770603e-06 0 6.72343262808e-06 0 6.72433262808e-06 1.485 6.72453262808e-06 1.815 6.72543262808e-06 3.3 6.82940755013e-06 3.3 6.83030755013e-06 1.815 6.83050755013e-06 1.485 6.83140755013e-06 0 6.93538247218e-06 0 6.93628247218e-06 1.485 6.93648247218e-06 1.815 6.93738247218e-06 3.3 7.04135739423e-06 3.3 7.04225739423e-06 1.815 7.04245739423e-06 1.485 7.04335739423e-06 0 7.14733231628e-06 0 7.14823231628e-06 1.485 7.14843231628e-06 1.815 7.14933231628e-06 3.3 7.25330723833e-06 3.3 7.25420723833e-06 1.815 7.25440723833e-06 1.485 7.25530723833e-06 0 7.35928216038e-06 0 7.36018216038e-06 1.485 7.36038216038e-06 1.815 7.36128216038e-06 3.3 7.46525708243e-06 3.3 7.46615708243e-06 1.815 7.46635708243e-06 1.485 7.46725708243e-06 0 7.57123200448e-06 0 7.57213200448e-06 1.485 7.57233200448e-06 1.815 7.57323200448e-06 3.3 7.67720692653e-06 3.3 7.67810692653e-06 1.815 7.67830692653e-06 1.485 7.67920692653e-06 0 7.78318184857e-06 0 7.78408184857e-06 1.485 7.78428184857e-06 1.815 7.78518184857e-06 3.3 7.88915677062e-06 3.3 7.89005677062e-06 1.815 7.89025677062e-06 1.485 7.89115677062e-06 0 7.99513169267e-06 0 7.99603169267e-06 1.485 7.99623169267e-06 1.815 7.99713169267e-06 3.3 8.10110661472e-06 3.3 8.10200661472e-06 1.815 8.10220661472e-06 1.485 8.10310661472e-06 0 8.20708153677e-06 0 8.20798153677e-06 1.485 8.20818153677e-06 1.815 8.20908153677e-06 3.3 8.31305645882e-06 3.3 8.31395645882e-06 1.815 8.31415645882e-06 1.485 8.31505645882e-06 0 8.41903138087e-06 0 8.41993138087e-06 1.485 8.42013138087e-06 1.815 8.42103138087e-06 3.3 8.52500630292e-06 3.3 8.52590630292e-06 1.815 8.52610630292e-06 1.485 8.52700630292e-06 0 8.63098122497e-06 0 8.63188122497e-06 1.485 8.63208122497e-06 1.815 8.63298122497e-06 3.3 8.73695614702e-06 3.3 8.73785614702e-06 1.815 8.73805614702e-06 1.485 8.73895614702e-06 0 8.84293106907e-06 0 8.84383106907e-06 1.485 8.84403106907e-06 1.815 8.84493106907e-06 3.3 8.94890599112e-06 3.3 8.94980599112e-06 1.815 8.95000599112e-06 1.485 8.95090599112e-06 0 9.05488091317e-06 0 9.05578091317e-06 1.485 9.05598091317e-06 1.815 9.05688091317e-06 3.3 9.16085583522e-06 3.3 9.16175583522e-06 1.815 9.16195583522e-06 1.485 9.16285583522e-06 0 9.26683075726e-06 0 9.26773075726e-06 1.485 9.26793075726e-06 1.815 9.26883075726e-06 3.3 9.37280567931e-06 3.3 9.37370567931e-06 1.815 9.37390567931e-06 1.485 9.37480567931e-06 0 9.47878060136e-06 0 9.47968060136e-06 1.485 9.47988060136e-06 1.815 9.48078060136e-06 3.3 9.58475552341e-06 3.3 9.58565552341e-06 1.815 9.58585552341e-06 1.485 9.58675552341e-06 0 9.69073044546e-06 0 9.69163044546e-06 1.485 9.69183044546e-06 1.815 9.69273044546e-06 3.3 9.79670536751e-06 3.3 9.79760536751e-06 1.815 9.79780536751e-06 1.485 9.79870536751e-06 0 9.90268028956e-06 0 9.90358028956e-06 1.485 9.90378028956e-06 1.815 9.90468028956e-06 3.3 1.00086552116e-05 3.3 1.00095552116e-05 1.815 1.00097552116e-05 1.485 1.00106552116e-05 0 1.01146301337e-05 0 1.01155301337e-05 1.485 1.01157301337e-05 1.815 1.01166301337e-05 3.3 1.02206050557e-05 3.3 1.02215050557e-05 1.815 1.02217050557e-05 1.485 1.02226050557e-05 0 1.03265799778e-05 0 1.03274799778e-05 1.485 1.03276799778e-05 1.815 1.03285799778e-05 3.3 1.04325548998e-05 3.3 1.04334548998e-05 1.815 1.04336548998e-05 1.485 1.04345548998e-05 0 1.05385298219e-05 0 1.05394298219e-05 1.485 1.05396298219e-05 1.815 1.05405298219e-05 3.3 1.06445047439e-05 3.3 1.06454047439e-05 1.815 1.06456047439e-05 1.485 1.06465047439e-05 0 1.0750479666e-05 0 1.0751379666e-05 1.485 1.0751579666e-05 1.815 1.0752479666e-05 3.3 1.0856454588e-05 3.3 1.0857354588e-05 1.815 1.0857554588e-05 1.485 1.0858454588e-05 0)
Vsdi sdi_pad 0 pwl(0 0 4.07405957685e-06 0 4.92185895324e-06 0 4.92275895324e-06 1.485 4.92295895324e-06 1.815 4.92385895324e-06 3.3 5.13380879734e-06 3.3 5.13470879734e-06 1.815 5.13490879734e-06 1.485 5.13580879734e-06 0 8.73695614702e-06 0 8.73785614702e-06 1.485 8.73805614702e-06 1.815 8.73895614702e-06 3.3 9.58475552341e-06 3.3 9.58565552341e-06 1.815 9.58585552341e-06 1.485 9.58675552341e-06 0 1.00086552116e-05 0 1.00095552116e-05 1.485 1.00097552116e-05 1.815 1.00106552116e-05 3.3 1.02206050557e-05 3.3 1.02215050557e-05 1.815 1.02217050557e-05 1.485 1.02226050557e-05 0)
Cw_en en_core 0 20f
Cw_sclk sclk_core 0 20f
Cw_sdi sdi_core 0 20f
* the RTL reads EN / SCLK / SDI as a digital stimulus (XSPICE d_source) with the same edge times as the pad
* PWLs (event at the middle of each edge); the pad models still drive en_core for G1_GATE (README, "Numerical notes")
.model dsrc d_source(input_file="/work/build/g1_top/stim_c_mid_sch_c1414_tl_tt_27C_t2ftl_nodcn_gear_clockfix_compact_functional_cdlref1.txt")
adsrc [d_en d_sclk d_sdi] dsrc
* ---- oscillator enable gate (testbench): RTL osc_en, released at 0.1 us
Bosc osc_en_g 0 V = v(osc_en) * min(1, max(0, (time - 0.1u) / 50n))
* ---- analog chain at transistor level (per-block supply pins through 0 V sources for the current table)
Vr4 r4 0 dc 0
Vm_bgr vdda vdda_bgr dc 0
XBGR vdda_bgr 0 r4 vref iptat pbias pcasc vbe dvbe g1_bgr
Vm_sense vdda vdda_sense dc 0
XSENSE sense_p sense_n vref iptat isense vped vref_buf vdda_sense 0 g1_sense
Cw_isense isense 0 300f
Vm_tripa vdda vdda_trip dc 0
Vm_tripd vdd vdd_trip dc 0
XTRIP isense vref_buf cmp_clk soft0 soft1 soft2 soft3 soft4 soft5 soft6 soft7 hard0 hard1 hard2 hard3 hard4 hard5 hard6 hard7 cmp_soft cmp_hard vdd_trip vdda_trip 0 g1_trip
Cw_soft cmp_soft 0 20f
Cw_hard cmp_hard 0 20f
* the clock delivered to the digital macro is an ideal source at the block-simulated G1_OSC frequency;
* G1_OSC is not in this deck (README, "Numerical notes": with the transistor-level oscillator on the
* chip supply the event-driven solver aborts; case osc runs it in the chip context without G1_TRIP)
Vm_osc vdd vdd_osc dc 0
Rosc_dummy vdd_osc 0 1e12
Vosc_i osc_i 0 pulse(0 1.2 1e-07 1n 1n 5.19875e-08 1.05975e-07)
Bosc_clk osc_clk 0 V = v(osc_i) * (0.5 + 0.5*tanh((v(osc_en_g) - 0.6)/0.05))
Cw_clk osc_clk 0 100f
* ---- G1_T2F at transistor level (--t2f tl), wired as g1_chip_top_1414.cdl: pbias/pcasc/vref from G1_BGR,
* en/mode from the RTL t2f_en/t2f_mode (reset 1/0) through g1_ls_up, vdd12 = VDD; fout into 1 pF.
* The TEMP_OUT pad (sg13g2_IOPadOut16mA) is out of scope: fout sees a 1 pF lumped load only.
Vm_t2f vdda vdda_t2f dc 0
Vm_t2fd vdd vdd_t2f dc 0
Vm_ls vdda vdda_ls dc 0
Vm_lsd vdd vdd_ls dc 0
XLSEN t2f_en12 t2f_en33 vdd_ls vdda_ls 0 g1_ls_up
XLSMODE t2f_mode12 t2f_mode33 vdd_ls vdda_ls 0 g1_ls_up
XT2F vdda_t2f vdd_t2f 0 pbias pcasc vref t2f_en33 t2f_mode33 temp_out g1_t2f
Ctemp_out temp_out 0 1p
Vm_gatea vdda vdda_gate dc 0
Vm_gated vdd vdd_gate dc 0
XGATE trip_d clr_d fast_en cmp_hard en_core gate_core fault_core tripped vdd_gate vdda_gate 0 g1_gate
Cw_tripped tripped 0 20f
* ---- digital macro: the real RTL through XSPICE d_cosim (Icarus Verilog shim ivlng)
.model adc adc_bridge(in_low=0.55 in_high=0.65 rise_delay=1e-12 fall_delay=1e-12)
.model adc_clock adc_bridge(in_low=0.6 in_high=0.6 rise_delay=1e-12 fall_delay=1e-12)
.model dac dac_bridge(out_low=0 out_high=1.2 out_undef=0.6 t_rise=0.3n t_fall=0.3n)
.model rtl d_cosim simulation="ivlng" sim_args=["/work/build/g1_top/cosim_fe07aad945408618ef5188d9.vvp"]
aclock [osc_clk] [d_osc_clk] adc_clock
aadc [cmp_soft cmp_hard tripped] [d_cmp_soft d_cmp_hard d_tripped] adc
* d_cosim wrapper: rtl/g1_dig_cosim_t2f.v (g1_dig_cosim.v plus outputs t2f_en, t2f_mode)
adig [d_osc_clk d_en d_sclk d_sdi d_cmp_soft d_cmp_hard d_tripped] [d_cmp_clk d_s7 d_s6 d_s5 d_s4 d_s3 d_s2 d_s1 d_s0 d_h7 d_h6 d_h5 d_h4 d_h3 d_h2 d_h1 d_h0 d_trip_d d_clr_d d_fast_en d_osc_en d_t3 d_t2 d_t1 d_t0 d_trip d_gate_en d_cause1 d_cause0 d_sdo d_sp15 d_sp14 d_sp13 d_sp12 d_sp11 d_sp10 d_sp9 d_sp8 d_sp7 d_sp6 d_sp5 d_sp4 d_sp3 d_sp2 d_sp1 d_sp0 d_inrush d_softarmed d_t2f_en d_t2f_mode] rtl
adac [d_cmp_clk d_s7 d_s6 d_s5 d_s4 d_s3 d_s2 d_s1 d_s0 d_h7 d_h6 d_h5 d_h4 d_h3 d_h2 d_h1 d_h0 d_trip_d d_clr_d d_fast_en d_osc_en d_t3 d_t2 d_t1 d_t0 d_trip d_gate_en d_cause1 d_cause0 d_sdo d_sp15 d_sp14 d_sp13 d_sp12 d_sp11 d_sp10 d_sp9 d_sp8 d_sp7 d_sp6 d_sp5 d_sp4 d_sp3 d_sp2 d_sp1 d_sp0 d_inrush d_softarmed d_t2f_en d_t2f_mode] [cmp_clk soft7 soft6 soft5 soft4 soft3 soft2 soft1 soft0 hard7 hard6 hard5 hard4 hard3 hard2 hard1 hard0 trip_d clr_d fast_en osc_en trim3 trim2 trim1 trim0 dig_trip dig_gate_en cause1 cause0 sdo sp15 sp14 sp13 sp12 sp11 sp10 sp9 sp8 sp7 sp6 sp5 sp4 sp3 sp2 sp1 sp0 inrush_active soft_armed t2f_en12 t2f_mode12] dac
.save v(gate) v(gfet) v(tripped) v(isense) v(cmp_soft) v(cmp_hard) v(trip_d) v(clr_d) v(fast_en) v(osc_clk) v(cmp_clk)
+ v(vref) v(iptat) v(en_core) v(shp) v(shn) v(fault_n) v(gate_core) v(vdda) v(vdd) v(iovdd) v(iprof) v(osc_en_g)
+ v(xtrip.icmp) v(xtrip.vth_soft) v(xtrip.vth_hard) v(dig_trip) v(cause1) v(cause0) v(sclk_pad) v(sdi_pad) v(sdo)
+ v(soft0) v(soft1) v(soft2) v(soft3) v(soft4) v(soft5) v(soft6) v(soft7) v(hard0) v(hard1) v(hard2) v(hard3) v(hard4) v(hard5) v(hard6) v(hard7)
+ v(sp0) v(sp1) v(sp2) v(sp3) v(sp4) v(sp5) v(sp6) v(sp7) v(sp8) v(sp9) v(sp10) v(sp11) v(sp12) v(sp13) v(sp14) v(sp15) v(inrush_active) v(soft_armed)
+ i(vim) i(vma) i(vmi) i(v12) i(vm_bgr) i(vm_sense) i(vm_tripa) i(vm_tripd) i(vm_osc) i(vm_gatea) i(vm_gated)
+ v(temp_out) v(t2f_en33) v(t2f_mode33) v(pbias) v(pcasc) i(vm_t2f) i(vm_t2fd) i(vm_ls) i(vm_lsd)
+ v(vref_buf) v(vped)
.control
set filetype=ascii
set wr_singlescale
set wr_vecnames
tran 2e-08 28u 0 5e-09
* quiet operating values after the register write(s): window averages over the last 2 us before the load
* event (comparator kickback averaged out); single-instant samples at t_cfg + 1 us kept as *_inst
meas tran vref_q avg v(vref) from=14u to=16u
meas tran isense_q avg v(isense) from=14u to=16u
meas tran icmp_q avg v(xtrip.icmp) from=14u to=16u
meas tran vths_q avg v(xtrip.vth_soft) from=14u to=16u
meas tran vthh_q avg v(xtrip.vth_hard) from=14u to=16u
meas tran vref_i find v(vref) at=12.8565u
meas tran isense_i find v(isense) at=12.8565u
meas tran icmp_i find v(xtrip.icmp) at=12.8565u
meas tran vths_i find v(xtrip.vth_soft) at=12.8565u
meas tran vthh_i find v(xtrip.vth_hard) at=12.8565u
meas tran iload_q find i(vim) at=12.8565u
meas tran gate_q find v(gate) at=12.8565u
meas tran fastq find v(fast_en) at=12.8565u
meas tran t_inrush_off when v(inrush_active)=0.6 fall=1 from=3u
meas tran inrush_q find v(inrush_active) at=12.8565u
meas tran softarmed_end find v(soft_armed) at=28u
let cs_v = 1*(v(soft0) gt 0.6) + 2*(v(soft1) gt 0.6) + 4*(v(soft2) gt 0.6) + 8*(v(soft3) gt 0.6) + 16*(v(soft4) gt 0.6) + 32*(v(soft5) gt 0.6) + 64*(v(soft6) gt 0.6) + 128*(v(soft7) gt 0.6)
let ch_v = 1*(v(hard0) gt 0.6) + 2*(v(hard1) gt 0.6) + 4*(v(hard2) gt 0.6) + 8*(v(hard3) gt 0.6) + 16*(v(hard4) gt 0.6) + 32*(v(hard5) gt 0.6) + 64*(v(hard6) gt 0.6) + 128*(v(hard7) gt 0.6)
meas tran code_soft find cs_v at=12.8565u
meas tran code_hard find ch_v at=12.8565u
let t_inrush_off_us = t_inrush_off*1e6
echo "QUIET window_us=14-16 vref=" $&vref_q " isense=" $&isense_q " icmp=" $&icmp_q " vth_soft=" $&vths_q " vth_hard=" $&vthh_q " vref_inst=" $&vref_i " isense_inst=" $&isense_i " icmp_inst=" $&icmp_i " vth_soft_inst=" $&vths_i " vth_hard_inst=" $&vthh_i " iload_A=" $&iload_q " gate=" $&gate_q " code_soft=" $&code_soft " code_hard=" $&code_hard " fast_en=" $&fastq " inrush_active=" $&inrush_q " t_inrush_off_us=" $&t_inrush_off_us " soft_armed_end=" $&softarmed_end
* clocks: 20 oscillator periods and 10 strobe periods after the configuration
meas tran tosc1 when v(osc_clk)=0.6 rise=1 from=11.8565u
meas tran tosc2 when v(osc_clk)=0.6 rise=21 from=11.8565u
let fosc_mhz = 20e-6/(tosc2 - tosc1)
meas tran tcc1 when v(cmp_clk)=0.6 rise=1 from=11.8565u
meas tran tcc2 when v(cmp_clk)=0.6 rise=11 from=11.8565u
let fcmp_mhz = 10e-6/(tcc2 - tcc1)
echo "CLOCK f_osc_MHz=" $&fosc_mhz " f_cmp_MHz=" $&fcmp_mhz " (RTL clock: ideal source at the block-simulated frequency)"
* supply currents averaged over the quiet armed window
let i_vdda = i(vma)
meas tran ia_vdda avg i_vdda from=13.8565u to=16u
let ua_vdda = ia_vdda*1e6
let i_iovdd = i(vmi)
meas tran ia_iovdd avg i_iovdd from=13.8565u to=16u
let ua_iovdd = ia_iovdd*1e6
let i_vdd = -i(v12)
meas tran ia_vdd avg i_vdd from=13.8565u to=16u
let ua_vdd = ia_vdd*1e6
let i_bgr = i(vm_bgr)
meas tran ia_bgr avg i_bgr from=13.8565u to=16u
let ua_bgr = ia_bgr*1e6
let i_sense = i(vm_sense)
meas tran ia_sense avg i_sense from=13.8565u to=16u
let ua_sense = ia_sense*1e6
let i_tripa = i(vm_tripa)
meas tran ia_tripa avg i_tripa from=13.8565u to=16u
let ua_tripa = ia_tripa*1e6
let i_tripd = i(vm_tripd)
meas tran ia_tripd avg i_tripd from=13.8565u to=16u
let ua_tripd = ia_tripd*1e6
let i_osc = i(vm_osc)
meas tran ia_osc avg i_osc from=13.8565u to=16u
let ua_osc = ia_osc*1e6
let i_gatea = i(vm_gatea)
meas tran ia_gatea avg i_gatea from=13.8565u to=16u
let ua_gatea = ia_gatea*1e6
let i_gated = i(vm_gated)
meas tran ia_gated avg i_gated from=13.8565u to=16u
let ua_gated = ia_gated*1e6
echo "SUPPLY_uA window=13.8565-16us VDDA=" $&ua_vdda " IOVDD=" $&ua_iovdd " VDD=" $&ua_vdd " | bgr=" $&ua_bgr " sense=" $&ua_sense " trip_3v3=" $&ua_tripa " trip_1v2=" $&ua_tripd " osc=" $&ua_osc " gate_3v3=" $&ua_gatea " gate_1v2=" $&ua_gated
* G1_T2F: output frequency (rising 0.6 V crossings) and supply currents over the quiet window
meas tran t2f_t1 when v(temp_out)=0.6 rise=1 from=13.8565u to=16u
meas tran t2f_t2 when v(temp_out)=0.6 rise=3 from=13.8565u to=16u
let t2f_mhz = 2e-6/(t2f_t2 - t2f_t1)
meas tran ia_t2f avg i(vm_t2f) from=13.8565u to=16u
let ua_t2f = ia_t2f*1e6
meas tran ia_t2fd avg i(vm_t2fd) from=13.8565u to=16u
let ua_t2fd = ia_t2fd*1e6
meas tran ia_ls avg i(vm_ls) from=13.8565u to=16u
let ua_ls = ia_ls*1e6
meas tran ia_lsd avg i(vm_lsd) from=13.8565u to=16u
let ua_lsd = ia_lsd*1e6
echo "T2F window=13.8565-16us f_MHz=" $&t2f_mhz " periods=2 vdda_t2f_uA=" $&ua_t2f " vdd12_t2f_uA=" $&ua_t2fd " vdda_ls_uA=" $&ua_ls " vdd_ls_uA=" $&ua_lsd
* trip evaluation after the load event at T_STEP
let tstep_s = 16u
meas tran tripped_max max v(tripped) from=11.8565u to=28u
meas tran tripped_pre max v(tripped) from=11.8565u to=16u
meas tran t_tripped when v(tripped)=0.6 rise=1 from=16u
meas tran t_trip_d when v(trip_d)=0.6 rise=1 from=16u
meas tran t_gate1v when v(gate)=1.0 fall=1 from=16u
meas tran t_gate03 when v(gate)=0.33 fall=1 from=16u
meas tran gate_min min v(gate) from=16u to=28u
meas tran gate_end find v(gate) at=28u
meas tran ipk max i(vim) from=16u to=28u
meas tran i_end find i(vim) at=28u
meas tran isense_pk max v(isense) from=16u to=28u
meas tran cause1e find v(cause1) at=28u
meas tran cause0e find v(cause0) at=28u
meas tran fault_end find v(fault_n) at=28u
let sp_v = 1*(v(sp0) gt 0.6) + 2*(v(sp1) gt 0.6) + 4*(v(sp2) gt 0.6) + 8*(v(sp3) gt 0.6) + 16*(v(sp4) gt 0.6) + 32*(v(sp5) gt 0.6) + 64*(v(sp6) gt 0.6) + 128*(v(sp7) gt 0.6) + 256*(v(sp8) gt 0.6) + 512*(v(sp9) gt 0.6) + 1024*(v(sp10) gt 0.6) + 2048*(v(sp11) gt 0.6) + 4096*(v(sp12) gt 0.6) + 8192*(v(sp13) gt 0.6) + 16384*(v(sp14) gt 0.6) + 32768*(v(sp15) gt 0.6)
meas tran soft_peak find sp_v at=28u
let cause = 2*(cause1e gt 0.6) + (cause0e gt 0.6)
let dt_gate1v_us = (t_gate1v - tstep_s)*1e6
let dt_gate03_us = (t_gate03 - tstep_s)*1e6
let dt_tripped_us = (t_tripped - tstep_s)*1e6
let dt_trip_d_us = (t_trip_d - tstep_s)*1e6
echo "TRIP tripped_max=" $&tripped_max " tripped_before_event=" $&tripped_pre " t_tripped_us=" $&dt_tripped_us " t_trip_d_us=" $&dt_trip_d_us " t_gate_1V_us=" $&dt_gate1v_us " t_gate_0.33V_us=" $&dt_gate03_us " gate_min=" $&gate_min " gate_end=" $&gate_end " ipk_A=" $&ipk " i_end_A=" $&i_end " isense_pk=" $&isense_pk " cause=" $&cause " fault_n_end=" $&fault_end " soft_peak=" $&soft_peak
let qi = integ(i(vim))
meas tran q_step find qi at=16u
meas tran q_end find qi at=28u
let q_passed = q_end - q_step
echo "CHARGE after_event_As=" $&q_passed
wrdata /work/build/g1_top/state_c_mid_sch_c1414_tl_tt_27C_t2ftl_nodcn_gear_clockfix_compact_functional_cdlref1.txt v(en_core) v(inrush_active) v(dig_trip) v(fast_en) v(cause1) v(cause0) v(soft0) v(soft1) v(soft2) v(soft3) v(soft4) v(soft5) v(soft6) v(soft7) v(hard0) v(hard1) v(hard2) v(hard3) v(hard4) v(hard5) v(hard6) v(hard7) v(soft_armed) v(sp0) v(sp1) v(sp2) v(sp3) v(sp4) v(sp5) v(sp6) v(sp7) v(sp8) v(sp9) v(sp10) v(sp11) v(sp12) v(sp13) v(sp14) v(sp15) v(sclk_pad) v(sdi_pad) v(sdo) v(clr_d)
linearize v(gate) v(gfet) v(tripped) v(isense) v(cmp_soft) v(cmp_hard) v(cmp_clk) v(trip_d) v(osc_clk) v(vref) v(en_core) v(shp) v(fault_n) v(vdda) v(vdd) v(iprof) v(xtrip.icmp) v(xtrip.vth_soft) v(xtrip.vth_hard) v(dig_trip) v(inrush_active) i(vim) i(vma) i(vmi) i(v12)
wrdata /work/build/g1_top/waves_c_mid_sch_c1414_tl_tt_27C_t2ftl_nodcn_gear_clockfix_compact_functional_cdlref1.txt v(gate) v(gfet) v(tripped) v(isense) v(cmp_soft) v(cmp_hard) v(cmp_clk) v(trip_d) v(osc_clk) v(vref) v(en_core) v(shp) v(fault_n) v(vdda) v(vdd) v(iprof) v(xtrip.icmp) v(xtrip.vth_soft) v(xtrip.vth_hard) v(dig_trip) v(inrush_active) i(vim) i(vma) i(vmi) i(v12)
.endc
.end
