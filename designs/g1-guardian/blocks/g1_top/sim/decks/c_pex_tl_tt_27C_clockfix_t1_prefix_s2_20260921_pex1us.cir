* G1_TOP breaker path, chip level: (c) fast step to 3x nominal (20 ns rise): hard trip through the digital path, HARD_N = 4
* case c | block netlists pex | front end tl | clock to the RTL ideal | corner tt (mos_tt res_typ cap_typ hbt_typ) | 27 degC | run_top.py
.param VDDA=3.3 VDD=1.2 IOVDD=3.3 RSH=25m RGND=10m INOM=1 CVREF=1e-08
.lib /foss/pdks/ihp-sg13g2/libs.tech/ngspice/models/cornerMOSlv.lib mos_tt
.lib /foss/pdks/ihp-sg13g2/libs.tech/ngspice/models/cornerMOShv.lib mos_tt
.lib /foss/pdks/ihp-sg13g2/libs.tech/ngspice/models/cornerRES.lib res_typ
.lib /foss/pdks/ihp-sg13g2/libs.tech/ngspice/models/cornerCAP.lib cap_typ
.lib /foss/pdks/ihp-sg13g2/libs.tech/ngspice/models/cornerHBT.lib hbt_typ
.lib /foss/pdks/ihp-sg13g2/libs.tech/ngspice/models/cornerDIO.lib dio_tt
.include /foss/pdks/ihp-sg13g2/libs.ref/sg13g2_io/spice/sg13g2_io.spi
.include /work/designs/g1-guardian/blocks/g1_bgr/sim/postlayout/g1_bgr_pex.spice
.include /work/designs/g1-guardian/blocks/g1_sense/sim/postlayout/g1_sense_pex.spice
.include /work/designs/g1-guardian/blocks/g1_trip/sim/postlayout/g1_trip_pex.spice
.include /work/designs/g1-guardian/blocks/g1_gate/sim/postlayout/g1_gate_pex.spice
.temp 27
.global sub!
Vsub sub! 0 dc 0
* solver (README, "Numerical notes"): gear integration and loose absolute tolerances are what the PDK IO-pad
* models need when XSPICE events fall on their switching edges (with abstol 1e-9 / vntol 1e-5 the diode
* internal nodes stop converging: "timestep too small"); the DAC mux-tree nodes need rshunt; XSPICE forces
* trtol = 1, which the comparator decisions need at this reltol; default gmin (1e-13 stalls the pads)
.option method=trap itl4=100 reltol=0.001 abstol=1e-10 vntol=1e-6 chgtol=1e-14 rshunt=1e12
.nodeset v(vref_buf)=1.04 v(vped)=1.0008 v(isense)=1.5 v(xsense.vp)=0.047 v(xsense.vn)=0.047 v(iptat)=0.76 v(xsense.xota_out1)=2.51 v(xsense.xota_mir)=2.51 v(xsense.xota_tail)=1.6 v(xsense.xota_fn)=0.2 v(xsense.xota_fp)=0.2 v(xsense.xbuf_out1)=2.51 v(xsense.xbuf_mir)=2.51 v(xsense.xbuf_tail)=1.6 v(xsense.xbuf_fn)=0.2 v(xsense.xbuf_fp)=0.2 v(xsense.xref_out1)=2.51 v(xsense.xref_mir)=2.51 v(xsense.xref_tail)=1.6 v(xsense.xref_fn)=0.2 v(xsense.xref_fp)=0.2
* ---- supplies: one 3.3 V board rail feeds VDDA (pin 7) and IOVDD (pin 3), PLAN D14; 1.2 V VDD (pin 1)
V33 rail33 0 dc 3.3
Vma rail33 vdda_s dc 0
Vmi rail33 iovdd_s dc 0
Rsa vdda_s vdda 0.5
Cda vdda 0 1n
Rsi iovdd_s iovdd 0.5
Cdi iovdd 0 1n
V12 vdd_s 0 dc 1.2
Rsd vdd_s vdd 0.5
Cdd vdd 0 1n
* ---- board: load current profile (1 V = 1 A) x switch on the FET gate node, shunt, Kelvin traces, FET gate
Vprof iprof 0 pwl(0 1 3e-05 1 3.002e-05 3)
Bload 0 ldi I = v(iprof) * (0.5 + 0.5*tanh((v(gfet) - 1.5)/0.15))
Vim ldi shp dc 0
Rsh shp shn {RSH}
Rgnd shn 0 {RGND}
Rkp shp sense_p 1
Rkn shn sense_n 1
Rg gate gfet 10
Cgate gfet 0 5n
Cfault fault_n 0 20p
* ---- pads (PDK sg13g2_io SPICE models): SENSE_P/N on the bare pad terminal, VREF on the padres terminal
* (587 Ohm secondary protection, padframe/README.md); the VREF bond pad carries the board capacitor CVREF
XPSP sense_p sense_p_res vdd 0 iovdd 0 sg13g2_IOPadAnalog
XPSN sense_n sense_n_res vdd 0 iovdd 0 sg13g2_IOPadAnalog
XPVREF vref_pad vref vdd 0 iovdd 0 sg13g2_IOPadAnalog
Cvref_ext vref_pad 0 {CVREF}
* digital input pads (EN, SCLK, SDI) as ideal 3.3 V -> 1.2 V level copies: the sg13g2_IOPadIn SPICE
* models abort the event-driven solver at their input edges with the charge tolerance the comparators
* need (README, "Numerical notes"); the pads are functionally verified in blocks/g1_gate (EN pad)
Ben_core en_core 0 V = v(en_pad)*1.2/3.3
Bsclk_core sclk_core 0 V = v(sclk_pad)*1.2/3.3
Bsdi_core sdi_core 0 V = v(sdi_pad)*1.2/3.3
* GATE / FAULT_N output pads as behavioural drivers fitted to the g1_gate block results with the PDK pad
* models (30 mA pad: 5 nF + 10 Ohm, fall 90-10 % 606 ns, arming 0-90 % 677 ns -> 47 Ohm driver; 4 mA pad:
* 20 pF, ~500 Ohm). Reason: README, "Numerical notes" (pad models and the StrongARM comparators need
* incompatible integration settings). The driver switches within 1 ns of gate_core / fault_core and
* draws its current from IOVDD.
Bgate_drv gate_drv 0 V = v(iovdd)*(0.5 + 0.5*tanh((v(gate_core) - 0.6)/0.05))
Rgate_drv gate_drv gate 47
Bgate_i iovdd 0 I = max(0, (v(gate_drv) - v(gate))/47)
Bfault_drv fault_drv 0 V = v(iovdd)*(0.5 + 0.5*tanh((v(fault_core) - 0.6)/0.05))
Rfault_drv fault_drv fault_n 500
Ven en_pad 0 pwl(0 0 3.04640871692e-06 0 3.04730871692e-06 1.485 3.04750871692e-06 1.815 3.04840871692e-06 3.3)
Vsclk sclk_pad 0 pwl(0 0 1.8056415388e-05 0 1.81676006226e-05 0 1.81676006226e-05 0 1.81685006226e-05 1.485 1.81687006226e-05 1.815 1.81696006226e-05 3.3 1.82787858572e-05 3.3 1.82796858572e-05 1.815 1.82798858572e-05 1.485 1.82807858572e-05 0 1.83899710918e-05 0 1.83899710918e-05 0 1.83908710918e-05 1.485 1.83910710918e-05 1.815 1.83919710918e-05 3.3 1.85011563264e-05 3.3 1.85020563264e-05 1.815 1.85022563264e-05 1.485 1.85031563264e-05 0 1.8612341561e-05 0 1.8612341561e-05 0 1.8613241561e-05 1.485 1.8613441561e-05 1.815 1.8614341561e-05 3.3 1.87235267956e-05 3.3 1.87244267956e-05 1.815 1.87246267956e-05 1.485 1.87255267956e-05 0 1.88347120302e-05 0 1.88347120302e-05 0 1.88356120302e-05 1.485 1.88358120302e-05 1.815 1.88367120302e-05 3.3 1.89458972648e-05 3.3 1.89467972648e-05 1.815 1.89469972648e-05 1.485 1.89478972648e-05 0 1.90570824994e-05 0 1.90570824994e-05 0 1.90579824994e-05 1.485 1.90581824994e-05 1.815 1.90590824994e-05 3.3 1.9168267734e-05 3.3 1.9169167734e-05 1.815 1.9169367734e-05 1.485 1.9170267734e-05 0 1.92794529686e-05 0 1.92794529686e-05 0 1.92803529686e-05 1.485 1.92805529686e-05 1.815 1.92814529686e-05 3.3 1.93906382032e-05 3.3 1.93915382032e-05 1.815 1.93917382032e-05 1.485 1.93926382032e-05 0 1.95018234378e-05 0 1.95018234378e-05 0 1.95027234378e-05 1.485 1.95029234378e-05 1.815 1.95038234378e-05 3.3 1.96130086724e-05 3.3 1.96139086724e-05 1.815 1.96141086724e-05 1.485 1.96150086724e-05 0 1.9724193907e-05 0 1.9724193907e-05 0 1.9725093907e-05 1.485 1.9725293907e-05 1.815 1.9726193907e-05 3.3 1.98353791416e-05 3.3 1.98362791416e-05 1.815 1.98364791416e-05 1.485 1.98373791416e-05 0 1.99465643763e-05 0 1.99465643763e-05 0 1.99474643763e-05 1.485 1.99476643763e-05 1.815 1.99485643763e-05 3.3 2.00577496109e-05 3.3 2.00586496109e-05 1.815 2.00588496109e-05 1.485 2.00597496109e-05 0 2.01689348455e-05 0 2.01689348455e-05 0 2.01698348455e-05 1.485 2.01700348455e-05 1.815 2.01709348455e-05 3.3 2.02801200801e-05 3.3 2.02810200801e-05 1.815 2.02812200801e-05 1.485 2.02821200801e-05 0 2.03913053147e-05 0 2.03913053147e-05 0 2.03922053147e-05 1.485 2.03924053147e-05 1.815 2.03933053147e-05 3.3 2.05024905493e-05 3.3 2.05033905493e-05 1.815 2.05035905493e-05 1.485 2.05044905493e-05 0 2.06136757839e-05 0 2.06136757839e-05 0 2.06145757839e-05 1.485 2.06147757839e-05 1.815 2.06156757839e-05 3.3 2.07248610185e-05 3.3 2.07257610185e-05 1.815 2.07259610185e-05 1.485 2.07268610185e-05 0 2.08360462531e-05 0 2.08360462531e-05 0 2.08369462531e-05 1.485 2.08371462531e-05 1.815 2.08380462531e-05 3.3 2.09472314877e-05 3.3 2.09481314877e-05 1.815 2.09483314877e-05 1.485 2.09492314877e-05 0 2.10584167223e-05 0 2.10584167223e-05 0 2.10593167223e-05 1.485 2.10595167223e-05 1.815 2.10604167223e-05 3.3 2.11696019569e-05 3.3 2.11705019569e-05 1.815 2.11707019569e-05 1.485 2.11716019569e-05 0 2.12807871915e-05 0 2.12807871915e-05 0 2.12816871915e-05 1.485 2.12818871915e-05 1.815 2.12827871915e-05 3.3 2.13919724261e-05 3.3 2.13928724261e-05 1.815 2.13930724261e-05 1.485 2.13939724261e-05 0 2.15031576607e-05 0 2.15031576607e-05 0 2.15040576607e-05 1.485 2.15042576607e-05 1.815 2.15051576607e-05 3.3 2.16143428953e-05 3.3 2.16152428953e-05 1.815 2.16154428953e-05 1.485 2.16163428953e-05 0)
Vsdi sdi_pad 0 pwl(0 0 1.8056415388e-05 0 1.89458972648e-05 0 1.89467972648e-05 1.485 1.89469972648e-05 1.815 1.89478972648e-05 3.3 1.9168267734e-05 3.3 1.9169167734e-05 1.815 1.9169367734e-05 1.485 1.9170267734e-05 0)
Cw_en en_core 0 20f
Cw_sclk sclk_core 0 20f
Cw_sdi sdi_core 0 20f
* the RTL reads EN / SCLK / SDI as a digital stimulus (XSPICE d_source) with the same edge times as the pad
* PWLs (event at the middle of each edge); the pad models still drive en_core for G1_GATE (README, "Numerical notes")
.model dsrc d_source(input_file="/work/build/g1_top/stim_c_pex_tl_tt_27C_clockfix_t1_prefix_s2_20260921_pex1us.txt")
adsrc [d_en d_sclk d_sdi] dsrc
* ---- oscillator enable gate (testbench): RTL osc_en, released at 0.1 us
Bosc osc_en_g 0 V = v(osc_en) * min(1, max(0, (time - 0.1u) / 50n))
* ---- analog chain at transistor level (per-block supply pins through 0 V sources for the current table)
Vr4 r4 0 dc 0
Vm_bgr vdda vdda_bgr dc 0
XBGR vdda_bgr 0 r4 vref iptat pbias pcasc vbe dvbe g1_bgr
Vm_sense vdda vdda_sense dc 0
XSENSE sense_p sense_n vref iptat isense vped vref_buf vdda_sense 0 g1_sense
Cw_isense isense 0 300f
Vm_tripa vdda vdda_trip dc 0
Vm_tripd vdd vdd_trip dc 0
XTRIP isense vref_buf cmp_clk soft0 soft1 soft2 soft3 soft4 soft5 soft6 soft7 hard0 hard1 hard2 hard3 hard4 hard5 hard6 hard7 cmp_soft cmp_hard vdd_trip vdda_trip 0 g1_trip
Cw_soft cmp_soft 0 20f
Cw_hard cmp_hard 0 20f
Vm_osc vdd vdd_osc dc 0
* the clock delivered to the digital macro is an ideal source at the block-simulated G1_OSC frequency;
* G1_OSC is not in this deck (README, "Numerical notes": with the transistor-level oscillator on the
* chip supply the event-driven solver aborts; case osc runs it in the chip context without G1_TRIP)
Rosc_dummy vdd_osc 0 1e12
Vosc_i osc_i 0 pulse(0 1.2 1e-07 1n 1n 5.45926e-08 1.11185e-07)
Bosc_clk osc_clk 0 V = v(osc_i) * (0.5 + 0.5*tanh((v(osc_en_g) - 0.6)/0.05))
Cw_clk osc_clk 0 100f
Vm_gatea vdda vdda_gate dc 0
Vm_gated vdd vdd_gate dc 0
XGATE trip_d clr_d fast_en cmp_hard en_core gate_core fault_core tripped vdd_gate vdda_gate 0 g1_gate
Cw_tripped tripped 0 20f
* ---- digital macro: the real RTL through XSPICE d_cosim (Icarus Verilog shim ivlng)
.model adc adc_bridge(in_low=0.55 in_high=0.65 rise_delay=1e-12 fall_delay=1e-12)
.model adc_clock adc_bridge(in_low=0.6 in_high=0.6 rise_delay=1e-12 fall_delay=1e-12)
.model dac dac_bridge(out_low=0 out_high=1.2 out_undef=0.6 t_rise=0.3n t_fall=0.3n)
.model rtl d_cosim simulation="ivlng" sim_args=["/work/build/g1_top/g1_dig_cosim.vvp"]
aclock [osc_clk] [d_osc_clk] adc_clock
aadc [cmp_soft cmp_hard tripped] [d_cmp_soft d_cmp_hard d_tripped] adc
adig [d_osc_clk d_en d_sclk d_sdi d_cmp_soft d_cmp_hard d_tripped] [d_cmp_clk d_s7 d_s6 d_s5 d_s4 d_s3 d_s2 d_s1 d_s0 d_h7 d_h6 d_h5 d_h4 d_h3 d_h2 d_h1 d_h0 d_trip_d d_clr_d d_fast_en d_osc_en d_t3 d_t2 d_t1 d_t0 d_trip d_gate_en d_cause1 d_cause0 d_sdo d_sp15 d_sp14 d_sp13 d_sp12 d_sp11 d_sp10 d_sp9 d_sp8 d_sp7 d_sp6 d_sp5 d_sp4 d_sp3 d_sp2 d_sp1 d_sp0 d_inrush d_softarmed] rtl
adac [d_cmp_clk d_s7 d_s6 d_s5 d_s4 d_s3 d_s2 d_s1 d_s0 d_h7 d_h6 d_h5 d_h4 d_h3 d_h2 d_h1 d_h0 d_trip_d d_clr_d d_fast_en d_osc_en d_t3 d_t2 d_t1 d_t0 d_trip d_gate_en d_cause1 d_cause0 d_sdo d_sp15 d_sp14 d_sp13 d_sp12 d_sp11 d_sp10 d_sp9 d_sp8 d_sp7 d_sp6 d_sp5 d_sp4 d_sp3 d_sp2 d_sp1 d_sp0 d_inrush d_softarmed] [cmp_clk soft7 soft6 soft5 soft4 soft3 soft2 soft1 soft0 hard7 hard6 hard5 hard4 hard3 hard2 hard1 hard0 trip_d clr_d fast_en osc_en trim3 trim2 trim1 trim0 dig_trip dig_gate_en cause1 cause0 sdo sp15 sp14 sp13 sp12 sp11 sp10 sp9 sp8 sp7 sp6 sp5 sp4 sp3 sp2 sp1 sp0 inrush_active soft_armed] dac
.save v(gate) v(gfet) v(tripped) v(isense) v(cmp_soft) v(cmp_hard) v(trip_d) v(clr_d) v(fast_en) v(osc_clk) v(cmp_clk)
+ v(vref) v(iptat) v(en_core) v(shp) v(shn) v(fault_n) v(gate_core) v(vdda) v(vdd) v(iovdd) v(iprof) v(osc_en_g)
+ v(xtrip.icmp) v(xtrip.vth_soft) v(xtrip.vth_hard) v(dig_trip) v(cause1) v(cause0) v(sclk_pad) v(sdi_pad)
+ v(soft0) v(soft1) v(soft2) v(soft3) v(soft4) v(soft5) v(soft6) v(soft7) v(hard0) v(hard1) v(hard2) v(hard3) v(hard4) v(hard5) v(hard6) v(hard7)
+ v(sp0) v(sp1) v(sp2) v(sp3) v(sp4) v(sp5) v(sp6) v(sp7) v(sp8) v(sp9) v(sp10) v(sp11) v(sp12) v(sp13) v(sp14) v(sp15) v(inrush_active) v(soft_armed)
+ i(vim) i(vma) i(vmi) i(v12) i(vm_bgr) i(vm_sense) i(vm_tripa) i(vm_tripd) i(vm_osc) i(vm_gatea) i(vm_gated)
+ v(vref_buf) v(vped)
.control
set filetype=ascii
set wr_singlescale
set wr_vecnames
tran 2e-08 1u 0 5e-09
let observed_end = time[length(time)-1]
echo DIAGNOSTIC_PREFIX_END_S $&observed_end
wrdata /work/build/g1_top/waves_c_pex_tl_tt_27C_clockfix_t1_prefix_s2_20260921_pex1us.txt v(vref) v(isense) v(gate) v(vdd) v(vdda) v(osc_clk) v(cmp_clk)
rusage all
.endc
.end
