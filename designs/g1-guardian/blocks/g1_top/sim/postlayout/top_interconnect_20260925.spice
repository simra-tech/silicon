* g1_top_interconnect: lumped top-level routing parasitics of g1_chip_top_1414.gds (629d303a...)
* kpex 0.3.12 2.5D CC on the top-interconnect view (fill removed, block macros/IO/std cells = pin
+ shapes only)
* + route R (kpex ihp-sg13g2 sheet/via tables, series upper bound). Values are extracted/estimated,
+ not measured.
* Source CSV sha256 53a20e34a041c5bf06f4617dd8d0f492b1e4b99135a1aaee923551b2b671cfab, route table
+ sha256 5f9ff3098b1a669f57d7d76feb295b4623a0be8094388ef36046fe8c4979bdad
* Port names = canonical CDL net names without the i_core_ prefix, lower case; sub =
+ substrate/ground (connect to 0).
* Couplings between two routed signal nets are kept as net-to-net C; everything else a routed net
+ sees
* (substrate, supplies, unnamed rails, pin-only fragments, bondpads) is lumped to sub. Bondpad C is
+ NOT included
* (see README); add Cbp_* from the README table if the deck does not model pad metal.

* ---- C only (drop-in: connect ports to the deck nodes of the same net)
.subckt g1_top_interconnect d_elt d_std g_shared hbt_b hbt_c hbt_e sense_n sense_p en_i fault_n_o
+ gate_o bgr_r4_12 bgr_r4_33 clr_d cmp_clk cmp_hard cmp_soft dac_hard_0_ dac_hard_1_ dac_hard_2_
+ dac_hard_3_ dac_hard_4_ dac_hard_5_ dac_hard_6_ dac_hard_7_ dac_soft_0_ dac_soft_1_ dac_soft_2_
+ dac_soft_3_ dac_soft_4_ dac_soft_5_ dac_soft_6_ dac_soft_7_ fast_en iptat isense osc_clk osc_en
+ osc_trim_0_ osc_trim_1_ osc_trim_2_ osc_trim_3_ pbias pcasc sclk_i sdi_i sdo_o t2f_en_12 t2f_en_33
+ t2f_mode_12 t2f_mode_33 temp_out_o trip_d tripped vref vref_buf net sub
Cg_d_elt d_elt sub 54.75f
Cg_d_std d_std sub 24.55f
Cg_g_shared g_shared sub 34.16f
Cg_hbt_b hbt_b sub 68.4f
Cg_hbt_c hbt_c sub 49.92f
Cg_hbt_e hbt_e sub 42.47f
Cg_sense_n sense_n sub 19.96f
Cg_sense_p sense_p sub 30.87f
Cg_en_i en_i sub 43.09f
Cg_fault_n_o fault_n_o sub 36.47f
Cg_gate_o gate_o sub 20.82f
Cg_bgr_r4_12 bgr_r4_12 sub 5.369f
Cg_bgr_r4_33 bgr_r4_33 sub 29.06f
Cg_clr_d clr_d sub 1.646f
Cg_cmp_clk cmp_clk sub 34.31f
Cg_cmp_hard cmp_hard sub 24.29f
Cg_cmp_soft cmp_soft sub 38.97f
Cg_dac_hard_0_ dac_hard_0_ sub 9.151f
Cg_dac_hard_1_ dac_hard_1_ sub 4.175f
Cg_dac_hard_2_ dac_hard_2_ sub 5.247f
Cg_dac_hard_3_ dac_hard_3_ sub 16.54f
Cg_dac_hard_4_ dac_hard_4_ sub 4.685f
Cg_dac_hard_5_ dac_hard_5_ sub 7.372f
Cg_dac_hard_6_ dac_hard_6_ sub 13.26f
Cg_dac_hard_7_ dac_hard_7_ sub 18.3f
Cg_dac_soft_0_ dac_soft_0_ sub 3.03f
Cg_dac_soft_1_ dac_soft_1_ sub 2.881f
Cg_dac_soft_2_ dac_soft_2_ sub 4.716f
Cg_dac_soft_3_ dac_soft_3_ sub 1.432f
Cg_dac_soft_4_ dac_soft_4_ sub 4.642f
Cg_dac_soft_5_ dac_soft_5_ sub 4.978f
Cg_dac_soft_6_ dac_soft_6_ sub 10.09f
Cg_dac_soft_7_ dac_soft_7_ sub 2.246f
Cg_fast_en fast_en sub 2.523f
Cg_iptat iptat sub 13.43f
Cg_isense isense sub 6.426f
Cg_osc_clk osc_clk sub 21.92f
Cg_osc_en osc_en sub 19.3f
Cg_osc_trim_0_ osc_trim_0_ sub 13.17f
Cg_osc_trim_1_ osc_trim_1_ sub 4.923f
Cg_osc_trim_2_ osc_trim_2_ sub 20.92f
Cg_osc_trim_3_ osc_trim_3_ sub 5.621f
Cg_pbias pbias sub 9.946f
Cg_pcasc pcasc sub 20.63f
Cg_sclk_i sclk_i sub 54.31f
Cg_sdi_i sdi_i sub 105.1f
Cg_sdo_o sdo_o sub 54.78f
Cg_t2f_en_12 t2f_en_12 sub 4.664f
Cg_t2f_en_33 t2f_en_33 sub 35.45f
Cg_t2f_mode_12 t2f_mode_12 sub 6.233f
Cg_t2f_mode_33 t2f_mode_33 sub 29.69f
Cg_temp_out_o temp_out_o sub 20.38f
Cg_trip_d trip_d sub 1.988f
Cg_tripped tripped sub 27.98f
Cg_vref vref sub 35.58f
Cg_vref_buf vref_buf sub 10.31f
Cg_net net sub 41.52f
Cc_d_elt__d_std d_elt d_std 17.89f
Cc_d_elt__g_shared d_elt g_shared 0.94f
Cc_d_elt__hbt_b d_elt hbt_b 83.02f
Cc_d_elt__hbt_c d_elt hbt_c 10.15f
Cc_d_elt__hbt_e d_elt hbt_e 0.03f
Cc_d_elt__osc_clk d_elt osc_clk 1.792f
Cc_d_std__g_shared d_std g_shared 17.94f
Cc_d_std__hbt_b d_std hbt_b 0.358f
Cc_d_std__hbt_c d_std hbt_c 110.8f
Cc_d_std__hbt_e d_std hbt_e 0.027f
Cc_d_std__osc_clk d_std osc_clk 0.12f
Cc_g_shared__hbt_b g_shared hbt_b 11.11f
Cc_g_shared__hbt_c g_shared hbt_c 5.83f
Cc_g_shared__hbt_e g_shared hbt_e 0.052f
Cc_hbt_b__hbt_c hbt_b hbt_c 6.923f
Cc_hbt_b__hbt_e hbt_b hbt_e 0.041f
Cc_hbt_b__sclk_i hbt_b sclk_i 0.17f
Cc_hbt_b__sdi_i hbt_b sdi_i 0.505f
Cc_hbt_c__hbt_e hbt_c hbt_e 0.159f
Cc_hbt_c__osc_clk hbt_c osc_clk 2.417f
Cc_hbt_c__sclk_i hbt_c sclk_i 0.026f
Cc_hbt_c__sdi_i hbt_c sdi_i 0.276f
Cc_hbt_e__en_i hbt_e en_i 0.155f
Cc_hbt_e__bgr_r4_12 hbt_e bgr_r4_12 0.029f
Cc_hbt_e__bgr_r4_33 hbt_e bgr_r4_33 22.03f
Cc_hbt_e__clr_d hbt_e clr_d 0.026f
Cc_hbt_e__cmp_clk hbt_e cmp_clk 0.156f
Cc_hbt_e__cmp_hard hbt_e cmp_hard 0.03f
Cc_hbt_e__cmp_soft hbt_e cmp_soft 0.38f
Cc_hbt_e__dac_hard_0_ hbt_e dac_hard_0_ 0.401f
Cc_hbt_e__dac_hard_1_ hbt_e dac_hard_1_ 0.192f
Cc_hbt_e__dac_hard_2_ hbt_e dac_hard_2_ 0.195f
Cc_hbt_e__dac_hard_3_ hbt_e dac_hard_3_ 0.155f
Cc_hbt_e__dac_hard_4_ hbt_e dac_hard_4_ 0.03f
Cc_hbt_e__dac_hard_5_ hbt_e dac_hard_5_ 0.029f
Cc_hbt_e__dac_hard_6_ hbt_e dac_hard_6_ 0.312f
Cc_hbt_e__dac_hard_7_ hbt_e dac_hard_7_ 4.417f
Cc_hbt_e__dac_soft_0_ hbt_e dac_soft_0_ 0.205f
Cc_hbt_e__dac_soft_1_ hbt_e dac_soft_1_ 0.036f
Cc_hbt_e__dac_soft_2_ hbt_e dac_soft_2_ 0.287f
Cc_hbt_e__dac_soft_3_ hbt_e dac_soft_3_ 0.036f
Cc_hbt_e__dac_soft_4_ hbt_e dac_soft_4_ 0.168f
Cc_hbt_e__dac_soft_5_ hbt_e dac_soft_5_ 0.026f
Cc_hbt_e__dac_soft_6_ hbt_e dac_soft_6_ 0.197f
Cc_hbt_e__dac_soft_7_ hbt_e dac_soft_7_ 0.036f
Cc_hbt_e__fast_en hbt_e fast_en 0.026f
Cc_hbt_e__osc_clk hbt_e osc_clk 1.573f
Cc_hbt_e__osc_en hbt_e osc_en 0.029f
Cc_hbt_e__osc_trim_0_ hbt_e osc_trim_0_ 0.154f
Cc_hbt_e__osc_trim_1_ hbt_e osc_trim_1_ 4.009f
Cc_hbt_e__osc_trim_2_ hbt_e osc_trim_2_ 0.154f
Cc_hbt_e__osc_trim_3_ hbt_e osc_trim_3_ 0.115f
Cc_hbt_e__sclk_i hbt_e sclk_i 0.8f
Cc_hbt_e__sdi_i hbt_e sdi_i 0.064f
Cc_hbt_e__sdo_o hbt_e sdo_o 5.868f
Cc_hbt_e__t2f_en_12 hbt_e t2f_en_12 0.03f
Cc_hbt_e__t2f_mode_12 hbt_e t2f_mode_12 0.164f
Cc_hbt_e__trip_d hbt_e trip_d 0.027f
Cc_hbt_e__tripped hbt_e tripped 0.027f
Cc_hbt_e__net hbt_e net 0.482f
Cc_sense_n__sense_p sense_n sense_p 0.303f
Cc_sense_n__net sense_n net 0.019f
Cc_sense_p__net sense_p net 0.151f
Cc_en_i__fault_n_o en_i fault_n_o 6.415f
Cc_en_i__gate_o en_i gate_o 0.835f
Cc_en_i__bgr_r4_33 en_i bgr_r4_33 0.03f
Cc_en_i__clr_d en_i clr_d 0.408f
Cc_en_i__cmp_clk en_i cmp_clk 0.543f
Cc_en_i__cmp_hard en_i cmp_hard 5.459f
Cc_en_i__cmp_soft en_i cmp_soft 0.444f
Cc_en_i__dac_hard_0_ en_i dac_hard_0_ 45.79f
Cc_en_i__dac_hard_1_ en_i dac_hard_1_ 0.049f
Cc_en_i__dac_hard_2_ en_i dac_hard_2_ 0.052f
Cc_en_i__dac_hard_3_ en_i dac_hard_3_ 0.17f
Cc_en_i__dac_hard_4_ en_i dac_hard_4_ 0.049f
Cc_en_i__dac_hard_5_ en_i dac_hard_5_ 0.05f
Cc_en_i__dac_hard_6_ en_i dac_hard_6_ 0.113f
Cc_en_i__dac_hard_7_ en_i dac_hard_7_ 0.048f
Cc_en_i__iptat en_i iptat 0.031f
Cc_en_i__isense en_i isense 13.32f
Cc_en_i__osc_clk en_i osc_clk 0.029f
Cc_en_i__osc_en en_i osc_en 0.031f
Cc_en_i__osc_trim_1_ en_i osc_trim_1_ 0.032f
Cc_en_i__osc_trim_3_ en_i osc_trim_3_ 0.03f
Cc_en_i__pbias en_i pbias 0.194f
Cc_en_i__pcasc en_i pcasc 0.062f
Cc_en_i__sdi_i en_i sdi_i 1.747f
Cc_en_i__t2f_en_12 en_i t2f_en_12 0.085f
Cc_en_i__t2f_en_33 en_i t2f_en_33 0.642f
Cc_en_i__t2f_mode_33 en_i t2f_mode_33 0.306f
Cc_en_i__trip_d en_i trip_d 0.026f
Cc_en_i__tripped en_i tripped 1.185f
Cc_en_i__vref en_i vref 0.038f
Cc_en_i__vref_buf en_i vref_buf 0.157f
Cc_en_i__net en_i net 0.06f
Cc_fault_n_o__gate_o fault_n_o gate_o 2.308f
Cc_fault_n_o__bgr_r4_33 fault_n_o bgr_r4_33 0.026f
Cc_fault_n_o__cmp_clk fault_n_o cmp_clk 1.522f
Cc_fault_n_o__cmp_hard fault_n_o cmp_hard 8.848f
Cc_fault_n_o__cmp_soft fault_n_o cmp_soft 0.058f
Cc_fault_n_o__dac_hard_0_ fault_n_o dac_hard_0_ 0.057f
Cc_fault_n_o__dac_hard_1_ fault_n_o dac_hard_1_ 0.057f
Cc_fault_n_o__dac_hard_2_ fault_n_o dac_hard_2_ 0.107f
Cc_fault_n_o__dac_hard_3_ fault_n_o dac_hard_3_ 0.044f
Cc_fault_n_o__dac_hard_4_ fault_n_o dac_hard_4_ 0.042f
Cc_fault_n_o__dac_hard_5_ fault_n_o dac_hard_5_ 0.049f
Cc_fault_n_o__dac_hard_6_ fault_n_o dac_hard_6_ 0.095f
Cc_fault_n_o__dac_hard_7_ fault_n_o dac_hard_7_ 0.047f
Cc_fault_n_o__iptat fault_n_o iptat 0.075f
Cc_fault_n_o__isense fault_n_o isense 4.366f
Cc_fault_n_o__osc_trim_0_ fault_n_o osc_trim_0_ 0.045f
Cc_fault_n_o__osc_trim_2_ fault_n_o osc_trim_2_ 0.039f
Cc_fault_n_o__t2f_en_33 fault_n_o t2f_en_33 0.034f
Cc_fault_n_o__t2f_mode_33 fault_n_o t2f_mode_33 0.033f
Cc_fault_n_o__tripped fault_n_o tripped 0.386f
Cc_fault_n_o__vref fault_n_o vref 0.026f
Cc_fault_n_o__vref_buf fault_n_o vref_buf 0.114f
Cc_fault_n_o__net fault_n_o net 0.127f
Cc_gate_o__cmp_clk gate_o cmp_clk 3.354f
Cc_gate_o__cmp_hard gate_o cmp_hard 0.096f
Cc_gate_o__cmp_soft gate_o cmp_soft 0.051f
Cc_gate_o__dac_hard_1_ gate_o dac_hard_1_ 0.072f
Cc_gate_o__dac_hard_2_ gate_o dac_hard_2_ 46.57f
Cc_gate_o__dac_hard_3_ gate_o dac_hard_3_ 1.636f
Cc_gate_o__dac_hard_4_ gate_o dac_hard_4_ 0.048f
Cc_gate_o__dac_hard_5_ gate_o dac_hard_5_ 0.05f
Cc_gate_o__dac_hard_6_ gate_o dac_hard_6_ 0.47f
Cc_gate_o__dac_hard_7_ gate_o dac_hard_7_ 0.048f
Cc_gate_o__iptat gate_o iptat 0.844f
Cc_gate_o__isense gate_o isense 0.029f
Cc_gate_o__osc_trim_0_ gate_o osc_trim_0_ 0.059f
Cc_gate_o__osc_trim_2_ gate_o osc_trim_2_ 0.061f
Cc_gate_o__t2f_en_33 gate_o t2f_en_33 0.049f
Cc_gate_o__t2f_mode_33 gate_o t2f_mode_33 0.157f
Cc_gate_o__tripped gate_o tripped 1.861f
Cc_gate_o__vref gate_o vref 0.03f
Cc_gate_o__vref_buf gate_o vref_buf 0.163f
Cc_gate_o__net gate_o net 0.371f
Cc_bgr_r4_12__bgr_r4_33 bgr_r4_12 bgr_r4_33 0.035f
Cc_bgr_r4_12__clr_d bgr_r4_12 clr_d 0.057f
Cc_bgr_r4_12__cmp_clk bgr_r4_12 cmp_clk 0.029f
Cc_bgr_r4_12__cmp_hard bgr_r4_12 cmp_hard 1.615f
Cc_bgr_r4_12__fast_en bgr_r4_12 fast_en 2.64f
Cc_bgr_r4_12__osc_clk bgr_r4_12 osc_clk 3.112f
Cc_bgr_r4_12__osc_en bgr_r4_12 osc_en 1.718f
Cc_bgr_r4_12__osc_trim_1_ bgr_r4_12 osc_trim_1_ 0.029f
Cc_bgr_r4_12__osc_trim_3_ bgr_r4_12 osc_trim_3_ 5.496f
Cc_bgr_r4_12__t2f_en_12 bgr_r4_12 t2f_en_12 0.084f
Cc_bgr_r4_12__t2f_en_33 bgr_r4_12 t2f_en_33 0.05f
Cc_bgr_r4_12__t2f_mode_12 bgr_r4_12 t2f_mode_12 1.343f
Cc_bgr_r4_12__trip_d bgr_r4_12 trip_d 0.027f
Cc_bgr_r4_12__tripped bgr_r4_12 tripped 0.064f
Cc_bgr_r4_33__clr_d bgr_r4_33 clr_d 7.543f
Cc_bgr_r4_33__cmp_clk bgr_r4_33 cmp_clk 0.027f
Cc_bgr_r4_33__cmp_hard bgr_r4_33 cmp_hard 0.024f
Cc_bgr_r4_33__cmp_soft bgr_r4_33 cmp_soft 0.021f
Cc_bgr_r4_33__dac_hard_0_ bgr_r4_33 dac_hard_0_ 0.027f
Cc_bgr_r4_33__dac_hard_1_ bgr_r4_33 dac_hard_1_ 0.021f
Cc_bgr_r4_33__dac_hard_2_ bgr_r4_33 dac_hard_2_ 0.021f
Cc_bgr_r4_33__dac_hard_3_ bgr_r4_33 dac_hard_3_ 0.87f
Cc_bgr_r4_33__dac_hard_4_ bgr_r4_33 dac_hard_4_ 0.019f
Cc_bgr_r4_33__dac_hard_5_ bgr_r4_33 dac_hard_5_ 0.029f
Cc_bgr_r4_33__dac_hard_6_ bgr_r4_33 dac_hard_6_ 0.032f
Cc_bgr_r4_33__dac_hard_7_ bgr_r4_33 dac_hard_7_ 0.037f
Cc_bgr_r4_33__dac_soft_0_ bgr_r4_33 dac_soft_0_ 0.023f
Cc_bgr_r4_33__dac_soft_1_ bgr_r4_33 dac_soft_1_ 0.994f
Cc_bgr_r4_33__dac_soft_2_ bgr_r4_33 dac_soft_2_ 0.024f
Cc_bgr_r4_33__dac_soft_3_ bgr_r4_33 dac_soft_3_ 0.019f
Cc_bgr_r4_33__dac_soft_4_ bgr_r4_33 dac_soft_4_ 0.027f
Cc_bgr_r4_33__dac_soft_5_ bgr_r4_33 dac_soft_5_ 0.025f
Cc_bgr_r4_33__dac_soft_6_ bgr_r4_33 dac_soft_6_ 0.021f
Cc_bgr_r4_33__dac_soft_7_ bgr_r4_33 dac_soft_7_ 0.021f
Cc_bgr_r4_33__fast_en bgr_r4_33 fast_en 0.02f
Cc_bgr_r4_33__iptat bgr_r4_33 iptat 0.038f
Cc_bgr_r4_33__osc_clk bgr_r4_33 osc_clk 1.555f
Cc_bgr_r4_33__osc_en bgr_r4_33 osc_en 0.09f
Cc_bgr_r4_33__osc_trim_0_ bgr_r4_33 osc_trim_0_ 1.208f
Cc_bgr_r4_33__osc_trim_1_ bgr_r4_33 osc_trim_1_ 2.147f
Cc_bgr_r4_33__osc_trim_2_ bgr_r4_33 osc_trim_2_ 0.028f
Cc_bgr_r4_33__osc_trim_3_ bgr_r4_33 osc_trim_3_ 0.071f
Cc_bgr_r4_33__pbias bgr_r4_33 pbias 0.031f
Cc_bgr_r4_33__pcasc bgr_r4_33 pcasc 0.466f
Cc_bgr_r4_33__sdo_o bgr_r4_33 sdo_o 0.454f
Cc_bgr_r4_33__t2f_en_12 bgr_r4_33 t2f_en_12 0.151f
Cc_bgr_r4_33__t2f_en_33 bgr_r4_33 t2f_en_33 0.382f
Cc_bgr_r4_33__t2f_mode_12 bgr_r4_33 t2f_mode_12 0.51f
Cc_bgr_r4_33__trip_d bgr_r4_33 trip_d 0.039f
Cc_bgr_r4_33__tripped bgr_r4_33 tripped 0.073f
Cc_bgr_r4_33__vref bgr_r4_33 vref 1f
Cc_bgr_r4_33__net bgr_r4_33 net 0.154f
Cc_clr_d__cmp_clk clr_d cmp_clk 0.029f
Cc_clr_d__cmp_hard clr_d cmp_hard 0.068f
Cc_clr_d__fast_en clr_d fast_en 0.981f
Cc_clr_d__osc_clk clr_d osc_clk 0.017f
Cc_clr_d__osc_en clr_d osc_en 0.025f
Cc_clr_d__osc_trim_1_ clr_d osc_trim_1_ 4.176f
Cc_clr_d__osc_trim_3_ clr_d osc_trim_3_ 0.019f
Cc_clr_d__t2f_en_12 clr_d t2f_en_12 0.079f
Cc_clr_d__t2f_mode_12 clr_d t2f_mode_12 0.252f
Cc_clr_d__trip_d clr_d trip_d 9.308f
Cc_clr_d__tripped clr_d tripped 0.023f
Cc_cmp_clk__cmp_hard cmp_clk cmp_hard 40.98f
Cc_cmp_clk__cmp_soft cmp_clk cmp_soft 0.229f
Cc_cmp_clk__dac_hard_1_ cmp_clk dac_hard_1_ 0.08f
Cc_cmp_clk__dac_hard_4_ cmp_clk dac_hard_4_ 0.019f
Cc_cmp_clk__dac_hard_5_ cmp_clk dac_hard_5_ 17.35f
Cc_cmp_clk__dac_hard_6_ cmp_clk dac_hard_6_ 0.026f
Cc_cmp_clk__dac_hard_7_ cmp_clk dac_hard_7_ 21.01f
Cc_cmp_clk__fast_en cmp_clk fast_en 0.069f
Cc_cmp_clk__iptat cmp_clk iptat 0.023f
Cc_cmp_clk__isense cmp_clk isense 0.021f
Cc_cmp_clk__osc_clk cmp_clk osc_clk 0.027f
Cc_cmp_clk__osc_en cmp_clk osc_en 0.133f
Cc_cmp_clk__t2f_en_12 cmp_clk t2f_en_12 0.014f
Cc_cmp_clk__t2f_en_33 cmp_clk t2f_en_33 0.884f
Cc_cmp_clk__t2f_mode_33 cmp_clk t2f_mode_33 0.206f
Cc_cmp_clk__trip_d cmp_clk trip_d 0.029f
Cc_cmp_clk__tripped cmp_clk tripped 0.293f
Cc_cmp_clk__vref cmp_clk vref 0.026f
Cc_cmp_clk__vref_buf cmp_clk vref_buf 0.027f
Cc_cmp_clk__net cmp_clk net 1.053f
Cc_cmp_hard__cmp_soft cmp_hard cmp_soft 0.735f
Cc_cmp_hard__dac_hard_1_ cmp_hard dac_hard_1_ 0.015f
Cc_cmp_hard__dac_hard_3_ cmp_hard dac_hard_3_ 47.09f
Cc_cmp_hard__dac_hard_4_ cmp_hard dac_hard_4_ 1.043f
Cc_cmp_hard__dac_hard_5_ cmp_hard dac_hard_5_ 0.045f
Cc_cmp_hard__dac_hard_7_ cmp_hard dac_hard_7_ 0.053f
Cc_cmp_hard__fast_en cmp_hard fast_en 0.297f
Cc_cmp_hard__iptat cmp_hard iptat 0.019f
Cc_cmp_hard__isense cmp_hard isense 0.016f
Cc_cmp_hard__osc_clk cmp_hard osc_clk 0.024f
Cc_cmp_hard__osc_en cmp_hard osc_en 1.628f
Cc_cmp_hard__osc_trim_1_ cmp_hard osc_trim_1_ 0.065f
Cc_cmp_hard__osc_trim_3_ cmp_hard osc_trim_3_ 0.03f
Cc_cmp_hard__t2f_en_12 cmp_hard t2f_en_12 0.029f
Cc_cmp_hard__t2f_en_33 cmp_hard t2f_en_33 0.025f
Cc_cmp_hard__t2f_mode_12 cmp_hard t2f_mode_12 0.033f
Cc_cmp_hard__trip_d cmp_hard trip_d 0.639f
Cc_cmp_hard__tripped cmp_hard tripped 47.32f
Cc_cmp_hard__vref cmp_hard vref 0.031f
Cc_cmp_hard__vref_buf cmp_hard vref_buf 0.024f
Cc_cmp_hard__net cmp_hard net 0.067f
Cc_cmp_soft__dac_hard_0_ cmp_soft dac_hard_0_ 83.69f
Cc_cmp_soft__dac_hard_1_ cmp_soft dac_hard_1_ 84.04f
Cc_cmp_soft__dac_hard_2_ cmp_soft dac_hard_2_ 0.095f
Cc_cmp_soft__dac_hard_3_ cmp_soft dac_hard_3_ 0.015f
Cc_cmp_soft__dac_hard_4_ cmp_soft dac_hard_4_ 0.016f
Cc_cmp_soft__dac_hard_5_ cmp_soft dac_hard_5_ 0.019f
Cc_cmp_soft__dac_hard_6_ cmp_soft dac_hard_6_ 0.125f
Cc_cmp_soft__dac_hard_7_ cmp_soft dac_hard_7_ 0.304f
Cc_cmp_soft__dac_soft_0_ cmp_soft dac_soft_0_ 0.071f
Cc_cmp_soft__dac_soft_1_ cmp_soft dac_soft_1_ 0.557f
Cc_cmp_soft__dac_soft_2_ cmp_soft dac_soft_2_ 0.814f
Cc_cmp_soft__dac_soft_3_ cmp_soft dac_soft_3_ 0.776f
Cc_cmp_soft__dac_soft_4_ cmp_soft dac_soft_4_ 0.037f
Cc_cmp_soft__dac_soft_5_ cmp_soft dac_soft_5_ 0.014f
Cc_cmp_soft__dac_soft_6_ cmp_soft dac_soft_6_ 0.063f
Cc_cmp_soft__dac_soft_7_ cmp_soft dac_soft_7_ 0.011f
Cc_cmp_soft__iptat cmp_soft iptat 0.023f
Cc_cmp_soft__isense cmp_soft isense 0.026f
Cc_cmp_soft__osc_clk cmp_soft osc_clk 0.02f
Cc_cmp_soft__osc_en cmp_soft osc_en 0.014f
Cc_cmp_soft__osc_trim_0_ cmp_soft osc_trim_0_ 0.011f
Cc_cmp_soft__osc_trim_1_ cmp_soft osc_trim_1_ 0.011f
Cc_cmp_soft__osc_trim_2_ cmp_soft osc_trim_2_ 0.024f
Cc_cmp_soft__osc_trim_3_ cmp_soft osc_trim_3_ 0.011f
Cc_cmp_soft__sclk_i cmp_soft sclk_i 52.71f
Cc_cmp_soft__sdi_i cmp_soft sdi_i 5.058f
Cc_cmp_soft__sdo_o cmp_soft sdo_o 0.05f
Cc_cmp_soft__tripped cmp_soft tripped 0.01f
Cc_cmp_soft__vref cmp_soft vref 0.018f
Cc_cmp_soft__vref_buf cmp_soft vref_buf 0.21f
Cc_dac_hard_0___dac_hard_1_ dac_hard_0_ dac_hard_1_ 2.662f
Cc_dac_hard_0___dac_hard_2_ dac_hard_0_ dac_hard_2_ 0.163f
Cc_dac_hard_0___dac_hard_3_ dac_hard_0_ dac_hard_3_ 0.036f
Cc_dac_hard_0___dac_hard_4_ dac_hard_0_ dac_hard_4_ 0.021f
Cc_dac_hard_0___dac_hard_5_ dac_hard_0_ dac_hard_5_ 0.02f
Cc_dac_hard_0___dac_hard_6_ dac_hard_0_ dac_hard_6_ 0.13f
Cc_dac_hard_0___dac_hard_7_ dac_hard_0_ dac_hard_7_ 0.131f
Cc_dac_hard_0___dac_soft_0_ dac_hard_0_ dac_soft_0_ 0.195f
Cc_dac_hard_0___dac_soft_1_ dac_hard_0_ dac_soft_1_ 0.115f
Cc_dac_hard_0___dac_soft_2_ dac_hard_0_ dac_soft_2_ 0.09f
Cc_dac_hard_0___dac_soft_3_ dac_hard_0_ dac_soft_3_ 0.027f
Cc_dac_hard_0___dac_soft_4_ dac_hard_0_ dac_soft_4_ 0.019f
Cc_dac_hard_0___dac_soft_5_ dac_hard_0_ dac_soft_5_ 0.02f
Cc_dac_hard_0___dac_soft_6_ dac_hard_0_ dac_soft_6_ 0.055f
Cc_dac_hard_0___dac_soft_7_ dac_hard_0_ dac_soft_7_ 0.017f
Cc_dac_hard_0___iptat dac_hard_0_ iptat 0.025f
Cc_dac_hard_0___isense dac_hard_0_ isense 1.03f
Cc_dac_hard_0___osc_clk dac_hard_0_ osc_clk 0.027f
Cc_dac_hard_0___osc_en dac_hard_0_ osc_en 0.02f
Cc_dac_hard_0___osc_trim_0_ dac_hard_0_ osc_trim_0_ 0.017f
Cc_dac_hard_0___osc_trim_1_ dac_hard_0_ osc_trim_1_ 0.017f
Cc_dac_hard_0___osc_trim_2_ dac_hard_0_ osc_trim_2_ 0.03f
Cc_dac_hard_0___osc_trim_3_ dac_hard_0_ osc_trim_3_ 0.017f
Cc_dac_hard_0___sclk_i dac_hard_0_ sclk_i 0.023f
Cc_dac_hard_0___sdo_o dac_hard_0_ sdo_o 0.309f
Cc_dac_hard_0___vref dac_hard_0_ vref 0.024f
Cc_dac_hard_0___vref_buf dac_hard_0_ vref_buf 0.198f
Cc_dac_hard_1___dac_hard_2_ dac_hard_1_ dac_hard_2_ 15.75f
Cc_dac_hard_1___dac_hard_3_ dac_hard_1_ dac_hard_3_ 0.033f
Cc_dac_hard_1___dac_hard_4_ dac_hard_1_ dac_hard_4_ 0.023f
Cc_dac_hard_1___dac_hard_5_ dac_hard_1_ dac_hard_5_ 0.022f
Cc_dac_hard_1___dac_hard_6_ dac_hard_1_ dac_hard_6_ 0.163f
Cc_dac_hard_1___dac_hard_7_ dac_hard_1_ dac_hard_7_ 0.1f
Cc_dac_hard_1___dac_soft_0_ dac_hard_1_ dac_soft_0_ 33.16f
Cc_dac_hard_1___dac_soft_1_ dac_hard_1_ dac_soft_1_ 0.021f
Cc_dac_hard_1___dac_soft_2_ dac_hard_1_ dac_soft_2_ 0.187f
Cc_dac_hard_1___dac_soft_3_ dac_hard_1_ dac_soft_3_ 0.013f
Cc_dac_hard_1___dac_soft_4_ dac_hard_1_ dac_soft_4_ 0.016f
Cc_dac_hard_1___dac_soft_5_ dac_hard_1_ dac_soft_5_ 0.016f
Cc_dac_hard_1___dac_soft_6_ dac_hard_1_ dac_soft_6_ 0.05f
Cc_dac_hard_1___dac_soft_7_ dac_hard_1_ dac_soft_7_ 0.013f
Cc_dac_hard_1___iptat dac_hard_1_ iptat 0.025f
Cc_dac_hard_1___isense dac_hard_1_ isense 0.026f
Cc_dac_hard_1___osc_clk dac_hard_1_ osc_clk 0.023f
Cc_dac_hard_1___osc_en dac_hard_1_ osc_en 0.016f
Cc_dac_hard_1___osc_trim_0_ dac_hard_1_ osc_trim_0_ 0.013f
Cc_dac_hard_1___osc_trim_1_ dac_hard_1_ osc_trim_1_ 0.013f
Cc_dac_hard_1___osc_trim_2_ dac_hard_1_ osc_trim_2_ 0.026f
Cc_dac_hard_1___osc_trim_3_ dac_hard_1_ osc_trim_3_ 0.013f
Cc_dac_hard_1___sclk_i dac_hard_1_ sclk_i 0.022f
Cc_dac_hard_1___sdo_o dac_hard_1_ sdo_o 0.038f
Cc_dac_hard_1___vref dac_hard_1_ vref 0.02f
Cc_dac_hard_1___vref_buf dac_hard_1_ vref_buf 0.399f
Cc_dac_hard_2___dac_hard_3_ dac_hard_2_ dac_hard_3_ 1.34f
Cc_dac_hard_2___dac_hard_4_ dac_hard_2_ dac_hard_4_ 1.164f
Cc_dac_hard_2___dac_hard_5_ dac_hard_2_ dac_hard_5_ 0.028f
Cc_dac_hard_2___dac_hard_6_ dac_hard_2_ dac_hard_6_ 0.288f
Cc_dac_hard_2___dac_hard_7_ dac_hard_2_ dac_hard_7_ 0.143f
Cc_dac_hard_2___dac_soft_0_ dac_hard_2_ dac_soft_0_ 29.94f
Cc_dac_hard_2___dac_soft_1_ dac_hard_2_ dac_soft_1_ 0.253f
Cc_dac_hard_2___dac_soft_2_ dac_hard_2_ dac_soft_2_ 0.293f
Cc_dac_hard_2___dac_soft_3_ dac_hard_2_ dac_soft_3_ 0.013f
Cc_dac_hard_2___dac_soft_4_ dac_hard_2_ dac_soft_4_ 33.48f
Cc_dac_hard_2___dac_soft_5_ dac_hard_2_ dac_soft_5_ 0.016f
Cc_dac_hard_2___dac_soft_6_ dac_hard_2_ dac_soft_6_ 0.052f
Cc_dac_hard_2___dac_soft_7_ dac_hard_2_ dac_soft_7_ 0.013f
Cc_dac_hard_2___iptat dac_hard_2_ iptat 0.134f
Cc_dac_hard_2___isense dac_hard_2_ isense 0.026f
Cc_dac_hard_2___osc_clk dac_hard_2_ osc_clk 0.023f
Cc_dac_hard_2___osc_en dac_hard_2_ osc_en 0.016f
Cc_dac_hard_2___osc_trim_0_ dac_hard_2_ osc_trim_0_ 0.013f
Cc_dac_hard_2___osc_trim_1_ dac_hard_2_ osc_trim_1_ 0.013f
Cc_dac_hard_2___osc_trim_2_ dac_hard_2_ osc_trim_2_ 0.026f
Cc_dac_hard_2___osc_trim_3_ dac_hard_2_ osc_trim_3_ 0.013f
Cc_dac_hard_2___sclk_i dac_hard_2_ sclk_i 0.563f
Cc_dac_hard_2___sdo_o dac_hard_2_ sdo_o 0.044f
Cc_dac_hard_2___vref dac_hard_2_ vref 0.02f
Cc_dac_hard_2___vref_buf dac_hard_2_ vref_buf 0.203f
Cc_dac_hard_3___dac_hard_4_ dac_hard_3_ dac_hard_4_ 1.523f
Cc_dac_hard_3___dac_hard_5_ dac_hard_3_ dac_hard_5_ 0.071f
Cc_dac_hard_3___dac_hard_6_ dac_hard_3_ dac_hard_6_ 3.158f
Cc_dac_hard_3___dac_hard_7_ dac_hard_3_ dac_hard_7_ 0.122f
Cc_dac_hard_3___dac_soft_1_ dac_hard_3_ dac_soft_1_ 0.052f
Cc_dac_hard_3___dac_soft_2_ dac_hard_3_ dac_soft_2_ 0.159f
Cc_dac_hard_3___dac_soft_3_ dac_hard_3_ dac_soft_3_ 0.056f
Cc_dac_hard_3___dac_soft_4_ dac_hard_3_ dac_soft_4_ 0.284f
Cc_dac_hard_3___dac_soft_5_ dac_hard_3_ dac_soft_5_ 0.427f
Cc_dac_hard_3___dac_soft_7_ dac_hard_3_ dac_soft_7_ 3.415f
Cc_dac_hard_3___iptat dac_hard_3_ iptat 16.62f
Cc_dac_hard_3___isense dac_hard_3_ isense 0.016f
Cc_dac_hard_3___osc_clk dac_hard_3_ osc_clk 0.091f
Cc_dac_hard_3___osc_en dac_hard_3_ osc_en 0.091f
Cc_dac_hard_3___osc_trim_0_ dac_hard_3_ osc_trim_0_ 0.053f
Cc_dac_hard_3___osc_trim_1_ dac_hard_3_ osc_trim_1_ 0.073f
Cc_dac_hard_3___osc_trim_2_ dac_hard_3_ osc_trim_2_ 0.223f
Cc_dac_hard_3___osc_trim_3_ dac_hard_3_ osc_trim_3_ 0.076f
Cc_dac_hard_3___tripped dac_hard_3_ tripped 0.056f
Cc_dac_hard_3___vref dac_hard_3_ vref 0.024f
Cc_dac_hard_3___vref_buf dac_hard_3_ vref_buf 0.024f
Cc_dac_hard_3___net dac_hard_3_ net 0.254f
Cc_dac_hard_4___dac_hard_5_ dac_hard_4_ dac_hard_5_ 21.38f
Cc_dac_hard_4___dac_hard_6_ dac_hard_4_ dac_hard_6_ 8.198f
Cc_dac_hard_4___dac_hard_7_ dac_hard_4_ dac_hard_7_ 0.616f
Cc_dac_hard_4___dac_soft_1_ dac_hard_4_ dac_soft_1_ 0.258f
Cc_dac_hard_4___dac_soft_2_ dac_hard_4_ dac_soft_2_ 32.76f
Cc_dac_hard_4___dac_soft_3_ dac_hard_4_ dac_soft_3_ 33.97f
Cc_dac_hard_4___dac_soft_5_ dac_hard_4_ dac_soft_5_ 0.129f
Cc_dac_hard_4___dac_soft_6_ dac_hard_4_ dac_soft_6_ 0.203f
Cc_dac_hard_4___dac_soft_7_ dac_hard_4_ dac_soft_7_ 0.808f
Cc_dac_hard_4___iptat dac_hard_4_ iptat 0.205f
Cc_dac_hard_4___isense dac_hard_4_ isense 0.023f
Cc_dac_hard_4___osc_clk dac_hard_4_ osc_clk 0.019f
Cc_dac_hard_4___osc_en dac_hard_4_ osc_en 0.013f
Cc_dac_hard_4___osc_trim_0_ dac_hard_4_ osc_trim_0_ 0.011f
Cc_dac_hard_4___osc_trim_1_ dac_hard_4_ osc_trim_1_ 0.011f
Cc_dac_hard_4___osc_trim_2_ dac_hard_4_ osc_trim_2_ 0.022f
Cc_dac_hard_4___osc_trim_3_ dac_hard_4_ osc_trim_3_ 0.011f
Cc_dac_hard_4___sdo_o dac_hard_4_ sdo_o 0.05f
Cc_dac_hard_4___tripped dac_hard_4_ tripped 0.553f
Cc_dac_hard_4___vref dac_hard_4_ vref 0.017f
Cc_dac_hard_4___vref_buf dac_hard_4_ vref_buf 0.03f
Cc_dac_hard_4___net dac_hard_4_ net 0.012f
Cc_dac_hard_5___dac_hard_6_ dac_hard_5_ dac_hard_6_ 0.305f
Cc_dac_hard_5___dac_hard_7_ dac_hard_5_ dac_hard_7_ 2.189f
Cc_dac_hard_5___dac_soft_1_ dac_hard_5_ dac_soft_1_ 0.066f
Cc_dac_hard_5___dac_soft_3_ dac_hard_5_ dac_soft_3_ 34.38f
Cc_dac_hard_5___dac_soft_5_ dac_hard_5_ dac_soft_5_ 0.762f
Cc_dac_hard_5___dac_soft_7_ dac_hard_5_ dac_soft_7_ 0.192f
Cc_dac_hard_5___iptat dac_hard_5_ iptat 0.023f
Cc_dac_hard_5___isense dac_hard_5_ isense 0.021f
Cc_dac_hard_5___osc_clk dac_hard_5_ osc_clk 0.024f
Cc_dac_hard_5___osc_en dac_hard_5_ osc_en 0.019f
Cc_dac_hard_5___osc_trim_0_ dac_hard_5_ osc_trim_0_ 0.016f
Cc_dac_hard_5___osc_trim_1_ dac_hard_5_ osc_trim_1_ 0.019f
Cc_dac_hard_5___osc_trim_2_ dac_hard_5_ osc_trim_2_ 0.028f
Cc_dac_hard_5___osc_trim_3_ dac_hard_5_ osc_trim_3_ 0.095f
Cc_dac_hard_5___t2f_en_33 dac_hard_5_ t2f_en_33 0.539f
Cc_dac_hard_5___t2f_mode_33 dac_hard_5_ t2f_mode_33 1.002f
Cc_dac_hard_5___tripped dac_hard_5_ tripped 0.592f
Cc_dac_hard_5___vref dac_hard_5_ vref 0.022f
Cc_dac_hard_5___vref_buf dac_hard_5_ vref_buf 0.027f
Cc_dac_hard_5___net dac_hard_5_ net 0.148f
Cc_dac_hard_6___dac_hard_7_ dac_hard_6_ dac_hard_7_ 5.032f
Cc_dac_hard_6___dac_soft_0_ dac_hard_6_ dac_soft_0_ 0.029f
Cc_dac_hard_6___dac_soft_1_ dac_hard_6_ dac_soft_1_ 1.467f
Cc_dac_hard_6___dac_soft_2_ dac_hard_6_ dac_soft_2_ 2.551f
Cc_dac_hard_6___dac_soft_3_ dac_hard_6_ dac_soft_3_ 0.026f
Cc_dac_hard_6___dac_soft_4_ dac_hard_6_ dac_soft_4_ 1.433f
Cc_dac_hard_6___dac_soft_5_ dac_hard_6_ dac_soft_5_ 0.054f
Cc_dac_hard_6___dac_soft_7_ dac_hard_6_ dac_soft_7_ 17.19f
Cc_dac_hard_6___iptat dac_hard_6_ iptat 0.332f
Cc_dac_hard_6___isense dac_hard_6_ isense 0.035f
Cc_dac_hard_6___osc_clk dac_hard_6_ osc_clk 0.031f
Cc_dac_hard_6___osc_en dac_hard_6_ osc_en 0.026f
Cc_dac_hard_6___osc_trim_0_ dac_hard_6_ osc_trim_0_ 0.023f
Cc_dac_hard_6___osc_trim_1_ dac_hard_6_ osc_trim_1_ 0.023f
Cc_dac_hard_6___osc_trim_2_ dac_hard_6_ osc_trim_2_ 0.034f
Cc_dac_hard_6___osc_trim_3_ dac_hard_6_ osc_trim_3_ 0.023f
Cc_dac_hard_6___sdo_o dac_hard_6_ sdo_o 0.087f
Cc_dac_hard_6___vref dac_hard_6_ vref 0.029f
Cc_dac_hard_6___vref_buf dac_hard_6_ vref_buf 1.157f
Cc_dac_hard_7___dac_soft_0_ dac_hard_7_ dac_soft_0_ 0.07f
Cc_dac_hard_7___dac_soft_1_ dac_hard_7_ dac_soft_1_ 0.27f
Cc_dac_hard_7___dac_soft_2_ dac_hard_7_ dac_soft_2_ 2.073f
Cc_dac_hard_7___dac_soft_3_ dac_hard_7_ dac_soft_3_ 0.419f
Cc_dac_hard_7___dac_soft_4_ dac_hard_7_ dac_soft_4_ 0.214f
Cc_dac_hard_7___dac_soft_5_ dac_hard_7_ dac_soft_5_ 0.024f
Cc_dac_hard_7___dac_soft_6_ dac_hard_7_ dac_soft_6_ 0.15f
Cc_dac_hard_7___dac_soft_7_ dac_hard_7_ dac_soft_7_ 0.105f
Cc_dac_hard_7___iptat dac_hard_7_ iptat 0.028f
Cc_dac_hard_7___isense dac_hard_7_ isense 0.026f
Cc_dac_hard_7___osc_clk dac_hard_7_ osc_clk 0.049f
Cc_dac_hard_7___osc_en dac_hard_7_ osc_en 0.066f
Cc_dac_hard_7___osc_trim_0_ dac_hard_7_ osc_trim_0_ 0.024f
Cc_dac_hard_7___osc_trim_1_ dac_hard_7_ osc_trim_1_ 0.047f
Cc_dac_hard_7___osc_trim_2_ dac_hard_7_ osc_trim_2_ 0.036f
Cc_dac_hard_7___osc_trim_3_ dac_hard_7_ osc_trim_3_ 0.094f
Cc_dac_hard_7___sclk_i dac_hard_7_ sclk_i 0.093f
Cc_dac_hard_7___sdo_o dac_hard_7_ sdo_o 0.177f
Cc_dac_hard_7___t2f_en_33 dac_hard_7_ t2f_en_33 0.021f
Cc_dac_hard_7___t2f_mode_33 dac_hard_7_ t2f_mode_33 0.028f
Cc_dac_hard_7___tripped dac_hard_7_ tripped 0.022f
Cc_dac_hard_7___vref dac_hard_7_ vref 0.101f
Cc_dac_hard_7___vref_buf dac_hard_7_ vref_buf 0.032f
Cc_dac_hard_7___net dac_hard_7_ net 0.575f
Cc_dac_soft_0___dac_soft_1_ dac_soft_0_ dac_soft_1_ 1.296f
Cc_dac_soft_0___dac_soft_2_ dac_soft_0_ dac_soft_2_ 0.096f
Cc_dac_soft_0___dac_soft_3_ dac_soft_0_ dac_soft_3_ 0.129f
Cc_dac_soft_0___dac_soft_4_ dac_soft_0_ dac_soft_4_ 0.052f
Cc_dac_soft_0___dac_soft_5_ dac_soft_0_ dac_soft_5_ 0.022f
Cc_dac_soft_0___dac_soft_6_ dac_soft_0_ dac_soft_6_ 0.047f
Cc_dac_soft_0___dac_soft_7_ dac_soft_0_ dac_soft_7_ 0.022f
Cc_dac_soft_0___isense dac_soft_0_ isense 0.015f
Cc_dac_soft_0___osc_clk dac_soft_0_ osc_clk 0.031f
Cc_dac_soft_0___osc_en dac_soft_0_ osc_en 0.024f
Cc_dac_soft_0___osc_trim_0_ dac_soft_0_ osc_trim_0_ 0.024f
Cc_dac_soft_0___osc_trim_1_ dac_soft_0_ osc_trim_1_ 0.023f
Cc_dac_soft_0___osc_trim_2_ dac_soft_0_ osc_trim_2_ 0.032f
Cc_dac_soft_0___osc_trim_3_ dac_soft_0_ osc_trim_3_ 0.022f
Cc_dac_soft_0___sclk_i dac_soft_0_ sclk_i 0.026f
Cc_dac_soft_0___sdo_o dac_soft_0_ sdo_o 0.09f
Cc_dac_soft_0___vref dac_soft_0_ vref 0.042f
Cc_dac_soft_0___vref_buf dac_soft_0_ vref_buf 0.017f
Cc_dac_soft_1___dac_soft_2_ dac_soft_1_ dac_soft_2_ 0.672f
Cc_dac_soft_1___dac_soft_3_ dac_soft_1_ dac_soft_3_ 1.433f
Cc_dac_soft_1___dac_soft_4_ dac_soft_1_ dac_soft_4_ 0.07f
Cc_dac_soft_1___dac_soft_5_ dac_soft_1_ dac_soft_5_ 24.17f
Cc_dac_soft_1___dac_soft_6_ dac_soft_1_ dac_soft_6_ 0.469f
Cc_dac_soft_1___dac_soft_7_ dac_soft_1_ dac_soft_7_ 25.82f
Cc_dac_soft_1___isense dac_soft_1_ isense 0.013f
Cc_dac_soft_1___osc_clk dac_soft_1_ osc_clk 0.028f
Cc_dac_soft_1___osc_en dac_soft_1_ osc_en 0.022f
Cc_dac_soft_1___osc_trim_0_ dac_soft_1_ osc_trim_0_ 0.019f
Cc_dac_soft_1___osc_trim_1_ dac_soft_1_ osc_trim_1_ 0.019f
Cc_dac_soft_1___osc_trim_2_ dac_soft_1_ osc_trim_2_ 0.032f
Cc_dac_soft_1___osc_trim_3_ dac_soft_1_ osc_trim_3_ 0.021f
Cc_dac_soft_1___sclk_i dac_soft_1_ sclk_i 0.039f
Cc_dac_soft_1___sdo_o dac_soft_1_ sdo_o 0.309f
Cc_dac_soft_1___vref dac_soft_1_ vref 0.149f
Cc_dac_soft_1___vref_buf dac_soft_1_ vref_buf 0.015f
Cc_dac_soft_2___dac_soft_3_ dac_soft_2_ dac_soft_3_ 3.154f
Cc_dac_soft_2___dac_soft_4_ dac_soft_2_ dac_soft_4_ 0.12f
Cc_dac_soft_2___dac_soft_5_ dac_soft_2_ dac_soft_5_ 0.018f
Cc_dac_soft_2___dac_soft_6_ dac_soft_2_ dac_soft_6_ 0.055f
Cc_dac_soft_2___dac_soft_7_ dac_soft_2_ dac_soft_7_ 0.057f
Cc_dac_soft_2___isense dac_soft_2_ isense 0.013f
Cc_dac_soft_2___osc_clk dac_soft_2_ osc_clk 0.023f
Cc_dac_soft_2___osc_en dac_soft_2_ osc_en 0.018f
Cc_dac_soft_2___osc_trim_0_ dac_soft_2_ osc_trim_0_ 0.015f
Cc_dac_soft_2___osc_trim_1_ dac_soft_2_ osc_trim_1_ 0.015f
Cc_dac_soft_2___osc_trim_2_ dac_soft_2_ osc_trim_2_ 0.295f
Cc_dac_soft_2___osc_trim_3_ dac_soft_2_ osc_trim_3_ 0.015f
Cc_dac_soft_2___sclk_i dac_soft_2_ sclk_i 0.051f
Cc_dac_soft_2___sdo_o dac_soft_2_ sdo_o 0.133f
Cc_dac_soft_2___vref dac_soft_2_ vref 0.021f
Cc_dac_soft_2___vref_buf dac_soft_2_ vref_buf 0.015f
Cc_dac_soft_3___dac_soft_4_ dac_soft_3_ dac_soft_4_ 0.257f
Cc_dac_soft_3___dac_soft_5_ dac_soft_3_ dac_soft_5_ 2.868f
Cc_dac_soft_3___dac_soft_6_ dac_soft_3_ dac_soft_6_ 0.014f
Cc_dac_soft_3___dac_soft_7_ dac_soft_3_ dac_soft_7_ 0.137f
Cc_dac_soft_3___isense dac_soft_3_ isense 0.013f
Cc_dac_soft_3___osc_clk dac_soft_3_ osc_clk 0.019f
Cc_dac_soft_3___osc_en dac_soft_3_ osc_en 0.013f
Cc_dac_soft_3___osc_trim_0_ dac_soft_3_ osc_trim_0_ 0.011f
Cc_dac_soft_3___osc_trim_1_ dac_soft_3_ osc_trim_1_ 0.013f
Cc_dac_soft_3___osc_trim_2_ dac_soft_3_ osc_trim_2_ 0.045f
Cc_dac_soft_3___osc_trim_3_ dac_soft_3_ osc_trim_3_ 0.014f
Cc_dac_soft_3___sclk_i dac_soft_3_ sclk_i 0.025f
Cc_dac_soft_3___vref dac_soft_3_ vref 0.017f
Cc_dac_soft_3___vref_buf dac_soft_3_ vref_buf 0.016f
Cc_dac_soft_4___dac_soft_5_ dac_soft_4_ dac_soft_5_ 1.042f
Cc_dac_soft_4___dac_soft_6_ dac_soft_4_ dac_soft_6_ 0.176f
Cc_dac_soft_4___dac_soft_7_ dac_soft_4_ dac_soft_7_ 0.267f
Cc_dac_soft_4___iptat dac_soft_4_ iptat 0.038f
Cc_dac_soft_4___isense dac_soft_4_ isense 0.014f
Cc_dac_soft_4___osc_clk dac_soft_4_ osc_clk 0.026f
Cc_dac_soft_4___osc_en dac_soft_4_ osc_en 0.019f
Cc_dac_soft_4___osc_trim_0_ dac_soft_4_ osc_trim_0_ 0.016f
Cc_dac_soft_4___osc_trim_1_ dac_soft_4_ osc_trim_1_ 0.016f
Cc_dac_soft_4___osc_trim_2_ dac_soft_4_ osc_trim_2_ 0.03f
Cc_dac_soft_4___osc_trim_3_ dac_soft_4_ osc_trim_3_ 0.016f
Cc_dac_soft_4___sdo_o dac_soft_4_ sdo_o 0.052f
Cc_dac_soft_4___vref dac_soft_4_ vref 0.024f
Cc_dac_soft_4___vref_buf dac_soft_4_ vref_buf 1.882f
Cc_dac_soft_5___dac_soft_6_ dac_soft_5_ dac_soft_6_ 0.326f
Cc_dac_soft_5___dac_soft_7_ dac_soft_5_ dac_soft_7_ 6.023f
Cc_dac_soft_5___iptat dac_soft_5_ iptat 0.064f
Cc_dac_soft_5___isense dac_soft_5_ isense 0.013f
Cc_dac_soft_5___osc_clk dac_soft_5_ osc_clk 0.026f
Cc_dac_soft_5___osc_en dac_soft_5_ osc_en 0.019f
Cc_dac_soft_5___osc_trim_0_ dac_soft_5_ osc_trim_0_ 0.013f
Cc_dac_soft_5___osc_trim_1_ dac_soft_5_ osc_trim_1_ 0.016f
Cc_dac_soft_5___osc_trim_2_ dac_soft_5_ osc_trim_2_ 0.052f
Cc_dac_soft_5___osc_trim_3_ dac_soft_5_ osc_trim_3_ 6.493f
Cc_dac_soft_5___sdo_o dac_soft_5_ sdo_o 0.029f
Cc_dac_soft_5___vref dac_soft_5_ vref 0.02f
Cc_dac_soft_5___vref_buf dac_soft_5_ vref_buf 0.046f
Cc_dac_soft_5___net dac_soft_5_ net 0.762f
Cc_dac_soft_6___dac_soft_7_ dac_soft_6_ dac_soft_7_ 1.204f
Cc_dac_soft_6___isense dac_soft_6_ isense 0.013f
Cc_dac_soft_6___osc_clk dac_soft_6_ osc_clk 0.206f
Cc_dac_soft_6___osc_en dac_soft_6_ osc_en 0.033f
Cc_dac_soft_6___osc_trim_0_ dac_soft_6_ osc_trim_0_ 0.022f
Cc_dac_soft_6___osc_trim_1_ dac_soft_6_ osc_trim_1_ 0.023f
Cc_dac_soft_6___osc_trim_2_ dac_soft_6_ osc_trim_2_ 0.051f
Cc_dac_soft_6___osc_trim_3_ dac_soft_6_ osc_trim_3_ 0.025f
Cc_dac_soft_6___sdo_o dac_soft_6_ sdo_o 8.394f
Cc_dac_soft_6___vref dac_soft_6_ vref 0.033f
Cc_dac_soft_6___vref_buf dac_soft_6_ vref_buf 0.024f
Cc_dac_soft_7___isense dac_soft_7_ isense 0.019f
Cc_dac_soft_7___osc_clk dac_soft_7_ osc_clk 0.033f
Cc_dac_soft_7___osc_en dac_soft_7_ osc_en 0.026f
Cc_dac_soft_7___osc_trim_0_ dac_soft_7_ osc_trim_0_ 0.014f
Cc_dac_soft_7___osc_trim_1_ dac_soft_7_ osc_trim_1_ 3.141f
Cc_dac_soft_7___osc_trim_2_ dac_soft_7_ osc_trim_2_ 0.033f
Cc_dac_soft_7___osc_trim_3_ dac_soft_7_ osc_trim_3_ 3.152f
Cc_dac_soft_7___sdo_o dac_soft_7_ sdo_o 0.224f
Cc_dac_soft_7___vref dac_soft_7_ vref 0.021f
Cc_dac_soft_7___vref_buf dac_soft_7_ vref_buf 0.03f
Cc_fast_en__osc_clk fast_en osc_clk 2.635f
Cc_fast_en__osc_en fast_en osc_en 0.088f
Cc_fast_en__osc_trim_3_ fast_en osc_trim_3_ 0.23f
Cc_fast_en__t2f_en_12 fast_en t2f_en_12 0.044f
Cc_fast_en__t2f_mode_12 fast_en t2f_mode_12 0.028f
Cc_fast_en__trip_d fast_en trip_d 2.405f
Cc_iptat__isense iptat isense 10.98f
Cc_iptat__osc_clk iptat osc_clk 0.032f
Cc_iptat__osc_en iptat osc_en 0.025f
Cc_iptat__osc_trim_0_ iptat osc_trim_0_ 0.022f
Cc_iptat__osc_trim_1_ iptat osc_trim_1_ 0.025f
Cc_iptat__osc_trim_2_ iptat osc_trim_2_ 0.044f
Cc_iptat__osc_trim_3_ iptat osc_trim_3_ 0.025f
Cc_iptat__pbias iptat pbias 0.371f
Cc_iptat__sdo_o iptat sdo_o 0.058f
Cc_iptat__t2f_en_33 iptat t2f_en_33 0.018f
Cc_iptat__t2f_mode_33 iptat t2f_mode_33 0.018f
Cc_iptat__tripped iptat tripped 0.019f
Cc_iptat__vref iptat vref 0.453f
Cc_iptat__vref_buf iptat vref_buf 0.286f
Cc_iptat__net iptat net 0.024f
Cc_isense__pbias isense pbias 0.051f
Cc_isense__t2f_en_33 isense t2f_en_33 0.016f
Cc_isense__t2f_mode_33 isense t2f_mode_33 0.016f
Cc_isense__tripped isense tripped 0.016f
Cc_isense__vref isense vref 0.029f
Cc_isense__vref_buf isense vref_buf 27.86f
Cc_isense__net isense net 0.022f
Cc_osc_clk__osc_en osc_clk osc_en 14.97f
Cc_osc_clk__osc_trim_0_ osc_clk osc_trim_0_ 0.051f
Cc_osc_clk__osc_trim_1_ osc_clk osc_trim_1_ 14.99f
Cc_osc_clk__osc_trim_2_ osc_clk osc_trim_2_ 2.807f
Cc_osc_clk__osc_trim_3_ osc_clk osc_trim_3_ 27.85f
Cc_osc_clk__pbias osc_clk pbias 0.034f
Cc_osc_clk__pcasc osc_clk pcasc 0.03f
Cc_osc_clk__sdi_i osc_clk sdi_i 1.692f
Cc_osc_clk__sdo_o osc_clk sdo_o 0.13f
Cc_osc_clk__t2f_en_12 osc_clk t2f_en_12 0.201f
Cc_osc_clk__t2f_mode_12 osc_clk t2f_mode_12 0.124f
Cc_osc_clk__trip_d osc_clk trip_d 7.394f
Cc_osc_clk__tripped osc_clk tripped 0.426f
Cc_osc_clk__vref osc_clk vref 38.31f
Cc_osc_clk__net osc_clk net 0.069f
Cc_osc_en__osc_trim_0_ osc_en osc_trim_0_ 0.243f
Cc_osc_en__osc_trim_1_ osc_en osc_trim_1_ 6.287f
Cc_osc_en__osc_trim_2_ osc_en osc_trim_2_ 0.392f
Cc_osc_en__osc_trim_3_ osc_en osc_trim_3_ 50.65f
Cc_osc_en__pbias osc_en pbias 0.025f
Cc_osc_en__pcasc osc_en pcasc 0.022f
Cc_osc_en__sdi_i osc_en sdi_i 0.03f
Cc_osc_en__sdo_o osc_en sdo_o 0.205f
Cc_osc_en__t2f_en_12 osc_en t2f_en_12 0.03f
Cc_osc_en__t2f_mode_12 osc_en t2f_mode_12 0.03f
Cc_osc_en__trip_d osc_en trip_d 0.025f
Cc_osc_en__tripped osc_en tripped 0.085f
Cc_osc_en__vref osc_en vref 0.047f
Cc_osc_en__net osc_en net 0.316f
Cc_osc_trim_0___osc_trim_1_ osc_trim_0_ osc_trim_1_ 46.47f
Cc_osc_trim_0___osc_trim_2_ osc_trim_0_ osc_trim_2_ 1.495f
Cc_osc_trim_0___osc_trim_3_ osc_trim_0_ osc_trim_3_ 0.071f
Cc_osc_trim_0___pbias osc_trim_0_ pbias 0.022f
Cc_osc_trim_0___pcasc osc_trim_0_ pcasc 0.539f
Cc_osc_trim_0___sdi_i osc_trim_0_ sdi_i 0.042f
Cc_osc_trim_0___sdo_o osc_trim_0_ sdo_o 0.956f
Cc_osc_trim_0___tripped osc_trim_0_ tripped 0.053f
Cc_osc_trim_0___vref osc_trim_0_ vref 27.42f
Cc_osc_trim_0___net osc_trim_0_ net 0.022f
Cc_osc_trim_1___osc_trim_2_ osc_trim_1_ osc_trim_2_ 0.208f
Cc_osc_trim_1___osc_trim_3_ osc_trim_1_ osc_trim_3_ 11.28f
Cc_osc_trim_1___pbias osc_trim_1_ pbias 0.024f
Cc_osc_trim_1___pcasc osc_trim_1_ pcasc 0.023f
Cc_osc_trim_1___sdi_i osc_trim_1_ sdi_i 0.031f
Cc_osc_trim_1___sdo_o osc_trim_1_ sdo_o 0.365f
Cc_osc_trim_1___t2f_en_12 osc_trim_1_ t2f_en_12 0.22f
Cc_osc_trim_1___t2f_mode_12 osc_trim_1_ t2f_mode_12 0.057f
Cc_osc_trim_1___trip_d osc_trim_1_ trip_d 3.958f
Cc_osc_trim_1___tripped osc_trim_1_ tripped 0.386f
Cc_osc_trim_1___vref osc_trim_1_ vref 12.77f
Cc_osc_trim_1___net osc_trim_1_ net 0.429f
Cc_osc_trim_2___osc_trim_3_ osc_trim_2_ osc_trim_3_ 0.344f
Cc_osc_trim_2___pbias osc_trim_2_ pbias 13.41f
Cc_osc_trim_2___pcasc osc_trim_2_ pcasc 0.026f
Cc_osc_trim_2___sdi_i osc_trim_2_ sdi_i 0.038f
Cc_osc_trim_2___tripped osc_trim_2_ tripped 0.046f
Cc_osc_trim_2___vref osc_trim_2_ vref 0.065f
Cc_osc_trim_2___vref_buf osc_trim_2_ vref_buf 1.246f
Cc_osc_trim_2___net osc_trim_2_ net 0.039f
Cc_osc_trim_3___pbias osc_trim_3_ pbias 0.025f
Cc_osc_trim_3___pcasc osc_trim_3_ pcasc 0.019f
Cc_osc_trim_3___sdi_i osc_trim_3_ sdi_i 0.026f
Cc_osc_trim_3___sdo_o osc_trim_3_ sdo_o 0.266f
Cc_osc_trim_3___t2f_en_12 osc_trim_3_ t2f_en_12 0.023f
Cc_osc_trim_3___t2f_mode_12 osc_trim_3_ t2f_mode_12 0.023f
Cc_osc_trim_3___trip_d osc_trim_3_ trip_d 0.02f
Cc_osc_trim_3___tripped osc_trim_3_ tripped 0.43f
Cc_osc_trim_3___vref osc_trim_3_ vref 12.76f
Cc_osc_trim_3___net osc_trim_3_ net 6.539f
Cc_pbias__pcasc pbias pcasc 72.46f
Cc_pbias__sdi_i pbias sdi_i 0.646f
Cc_pbias__sdo_o pbias sdo_o 0.049f
Cc_pbias__t2f_en_33 pbias t2f_en_33 0.126f
Cc_pbias__t2f_mode_33 pbias t2f_mode_33 3.002f
Cc_pbias__vref pbias vref 38.83f
Cc_pbias__vref_buf pbias vref_buf 0.195f
Cc_pcasc__sdi_i pcasc sdi_i 0.091f
Cc_pcasc__sdo_o pcasc sdo_o 0.376f
Cc_pcasc__t2f_en_33 pcasc t2f_en_33 0.321f
Cc_pcasc__t2f_mode_33 pcasc t2f_mode_33 0.076f
Cc_pcasc__vref pcasc vref 0.52f
Cc_sclk_i__sdi_i sclk_i sdi_i 49.07f
Cc_sdi_i__sdo_o sdi_i sdo_o 0.859f
Cc_sdi_i__tripped sdi_i tripped 0.013f
Cc_sdi_i__vref sdi_i vref 0.146f
Cc_sdo_o__vref sdo_o vref 1.256f
Cc_t2f_en_12__t2f_mode_12 t2f_en_12 t2f_mode_12 16.9f
Cc_t2f_en_12__trip_d t2f_en_12 trip_d 0.104f
Cc_t2f_en_12__tripped t2f_en_12 tripped 6.417f
Cc_t2f_en_12__net t2f_en_12 net 0.016f
Cc_t2f_en_33__t2f_mode_12 t2f_en_33 t2f_mode_12 6.328f
Cc_t2f_en_33__t2f_mode_33 t2f_en_33 t2f_mode_33 81.21f
Cc_t2f_en_33__temp_out_o t2f_en_33 temp_out_o 0.502f
Cc_t2f_en_33__tripped t2f_en_33 tripped 0.417f
Cc_t2f_en_33__vref t2f_en_33 vref 0.033f
Cc_t2f_en_33__vref_buf t2f_en_33 vref_buf 0.024f
Cc_t2f_en_33__net t2f_en_33 net 55.28f
Cc_t2f_mode_12__trip_d t2f_mode_12 trip_d 0.031f
Cc_t2f_mode_12__tripped t2f_mode_12 tripped 0.027f
Cc_t2f_mode_33__tripped t2f_mode_33 tripped 51.43f
Cc_t2f_mode_33__vref t2f_mode_33 vref 0.034f
Cc_t2f_mode_33__vref_buf t2f_mode_33 vref_buf 0.024f
Cc_t2f_mode_33__net t2f_mode_33 net 0.027f
Cc_temp_out_o__vref temp_out_o vref 0.032f
Cc_trip_d__tripped trip_d tripped 0.174f
Cc_tripped__vref tripped vref 0.037f
Cc_tripped__vref_buf tripped vref_buf 0.024f
Cc_tripped__net tripped net 2.804f
Cc_vref__vref_buf vref vref_buf 0.037f
Cc_vref__net vref net 0.666f
Cc_vref_buf__net vref_buf net 0.03f
.ends g1_top_interconnect

* ---- pi RC variant: <net> = driver side, <net>_far = receiver side; R = series upper bound;
* ground C split half/half, couplings placed at the driver-side nodes
.subckt g1_top_interconnect_pi d_elt d_elt_far d_std d_std_far g_shared g_shared_far hbt_b hbt_b_far
+ hbt_c hbt_c_far hbt_e hbt_e_far sense_n sense_n_far sense_p sense_p_far en_i en_i_far fault_n_o
+ fault_n_o_far gate_o gate_o_far bgr_r4_12 bgr_r4_12_far bgr_r4_33 bgr_r4_33_far clr_d clr_d_far
+ cmp_clk cmp_clk_far cmp_hard cmp_hard_far cmp_soft cmp_soft_far dac_hard_0_ dac_hard_0__far
+ dac_hard_1_ dac_hard_1__far dac_hard_2_ dac_hard_2__far dac_hard_3_ dac_hard_3__far dac_hard_4_
+ dac_hard_4__far dac_hard_5_ dac_hard_5__far dac_hard_6_ dac_hard_6__far dac_hard_7_
+ dac_hard_7__far dac_soft_0_ dac_soft_0__far dac_soft_1_ dac_soft_1__far dac_soft_2_
+ dac_soft_2__far dac_soft_3_ dac_soft_3__far dac_soft_4_ dac_soft_4__far dac_soft_5_
+ dac_soft_5__far dac_soft_6_ dac_soft_6__far dac_soft_7_ dac_soft_7__far fast_en fast_en_far iptat
+ iptat_far isense isense_far osc_clk osc_clk_far osc_en osc_en_far osc_trim_0_ osc_trim_0__far
+ osc_trim_1_ osc_trim_1__far osc_trim_2_ osc_trim_2__far osc_trim_3_ osc_trim_3__far pbias
+ pbias_far pcasc pcasc_far sclk_i sclk_i_far sdi_i sdi_i_far sdo_o sdo_o_far t2f_en_12
+ t2f_en_12_far t2f_en_33 t2f_en_33_far t2f_mode_12 t2f_mode_12_far t2f_mode_33 t2f_mode_33_far
+ temp_out_o temp_out_o_far trip_d trip_d_far tripped tripped_far vref vref_far vref_buf
+ vref_buf_far net net_far sub
R_d_elt d_elt d_elt_far 376.5
Cga_d_elt d_elt sub 27.37f
Cgb_d_elt d_elt_far sub 27.37f
R_d_std d_std d_std_far 322.7
Cga_d_std d_std sub 12.27f
Cgb_d_std d_std_far sub 12.27f
R_g_shared g_shared g_shared_far 274.4
Cga_g_shared g_shared sub 17.08f
Cgb_g_shared g_shared_far sub 17.08f
R_hbt_b hbt_b hbt_b_far 450.9
Cga_hbt_b hbt_b sub 34.2f
Cgb_hbt_b hbt_b_far sub 34.2f
R_hbt_c hbt_c hbt_c_far 499.4
Cga_hbt_c hbt_c sub 24.96f
Cgb_hbt_c hbt_c_far sub 24.96f
R_hbt_e hbt_e hbt_e_far 203.3
Cga_hbt_e hbt_e sub 21.23f
Cgb_hbt_e hbt_e_far sub 21.23f
R_sense_n sense_n sense_n_far 106.1
Cga_sense_n sense_n sub 9.978f
Cgb_sense_n sense_n_far sub 9.978f
R_sense_p sense_p sense_p_far 171.5
Cga_sense_p sense_p sub 15.43f
Cgb_sense_p sense_p_far sub 15.43f
R_en_i en_i en_i_far 478.3
Cga_en_i en_i sub 21.54f
Cgb_en_i en_i_far sub 21.54f
R_fault_n_o fault_n_o fault_n_o_far 289.7
Cga_fault_n_o fault_n_o sub 18.24f
Cgb_fault_n_o fault_n_o_far sub 18.24f
R_gate_o gate_o gate_o_far 216.4
Cga_gate_o gate_o sub 10.41f
Cgb_gate_o gate_o_far sub 10.41f
R_bgr_r4_12 bgr_r4_12 bgr_r4_12_far 81.9
Cga_bgr_r4_12 bgr_r4_12 sub 2.684f
Cgb_bgr_r4_12 bgr_r4_12_far sub 2.684f
R_bgr_r4_33 bgr_r4_33 bgr_r4_33_far 249.1
Cga_bgr_r4_33 bgr_r4_33 sub 14.53f
Cgb_bgr_r4_33 bgr_r4_33_far sub 14.53f
R_clr_d clr_d clr_d_far 56.2
Cga_clr_d clr_d sub 0.823f
Cgb_clr_d clr_d_far sub 0.823f
R_cmp_clk cmp_clk cmp_clk_far 282.9
Cga_cmp_clk cmp_clk sub 17.16f
Cgb_cmp_clk cmp_clk_far sub 17.16f
R_cmp_hard cmp_hard cmp_hard_far 422.5
Cga_cmp_hard cmp_hard sub 12.15f
Cgb_cmp_hard cmp_hard_far sub 12.15f
R_cmp_soft cmp_soft cmp_soft_far 541.2
Cga_cmp_soft cmp_soft sub 19.48f
Cgb_cmp_soft cmp_soft_far sub 19.48f
R_dac_hard_0_ dac_hard_0_ dac_hard_0__far 211.2
Cga_dac_hard_0_ dac_hard_0_ sub 4.575f
Cgb_dac_hard_0_ dac_hard_0__far sub 4.575f
R_dac_hard_1_ dac_hard_1_ dac_hard_1__far 212.3
Cga_dac_hard_1_ dac_hard_1_ sub 2.087f
Cgb_dac_hard_1_ dac_hard_1__far sub 2.087f
R_dac_hard_2_ dac_hard_2_ dac_hard_2__far 249.6
Cga_dac_hard_2_ dac_hard_2_ sub 2.623f
Cgb_dac_hard_2_ dac_hard_2__far sub 2.623f
R_dac_hard_3_ dac_hard_3_ dac_hard_3__far 234.8
Cga_dac_hard_3_ dac_hard_3_ sub 8.268f
Cgb_dac_hard_3_ dac_hard_3__far sub 8.268f
R_dac_hard_4_ dac_hard_4_ dac_hard_4__far 223.2
Cga_dac_hard_4_ dac_hard_4_ sub 2.342f
Cgb_dac_hard_4_ dac_hard_4__far sub 2.342f
R_dac_hard_5_ dac_hard_5_ dac_hard_5__far 224.5
Cga_dac_hard_5_ dac_hard_5_ sub 3.686f
Cgb_dac_hard_5_ dac_hard_5__far sub 3.686f
R_dac_hard_6_ dac_hard_6_ dac_hard_6__far 223.4
Cga_dac_hard_6_ dac_hard_6_ sub 6.631f
Cgb_dac_hard_6_ dac_hard_6__far sub 6.631f
R_dac_hard_7_ dac_hard_7_ dac_hard_7__far 212.7
Cga_dac_hard_7_ dac_hard_7_ sub 9.152f
Cgb_dac_hard_7_ dac_hard_7__far sub 9.152f
R_dac_soft_0_ dac_soft_0_ dac_soft_0__far 109.1
Cga_dac_soft_0_ dac_soft_0_ sub 1.515f
Cgb_dac_soft_0_ dac_soft_0__far sub 1.515f
R_dac_soft_1_ dac_soft_1_ dac_soft_1__far 130
Cga_dac_soft_1_ dac_soft_1_ sub 1.44f
Cgb_dac_soft_1_ dac_soft_1__far sub 1.44f
R_dac_soft_2_ dac_soft_2_ dac_soft_2__far 131.4
Cga_dac_soft_2_ dac_soft_2_ sub 2.358f
Cgb_dac_soft_2_ dac_soft_2__far sub 2.358f
R_dac_soft_3_ dac_soft_3_ dac_soft_3__far 128.8
Cga_dac_soft_3_ dac_soft_3_ sub 0.716f
Cgb_dac_soft_3_ dac_soft_3__far sub 0.716f
R_dac_soft_4_ dac_soft_4_ dac_soft_4__far 103.2
Cga_dac_soft_4_ dac_soft_4_ sub 2.321f
Cgb_dac_soft_4_ dac_soft_4__far sub 2.321f
R_dac_soft_5_ dac_soft_5_ dac_soft_5__far 104.6
Cga_dac_soft_5_ dac_soft_5_ sub 2.489f
Cgb_dac_soft_5_ dac_soft_5__far sub 2.489f
R_dac_soft_6_ dac_soft_6_ dac_soft_6__far 62.6
Cga_dac_soft_6_ dac_soft_6_ sub 5.043f
Cgb_dac_soft_6_ dac_soft_6__far sub 5.043f
R_dac_soft_7_ dac_soft_7_ dac_soft_7__far 105.9
Cga_dac_soft_7_ dac_soft_7_ sub 1.123f
Cgb_dac_soft_7_ dac_soft_7__far sub 1.123f
R_fast_en fast_en fast_en_far 60.6
Cga_fast_en fast_en sub 1.262f
Cgb_fast_en fast_en_far sub 1.262f
R_iptat iptat iptat_far 158.4
Cga_iptat iptat sub 6.713f
Cgb_iptat iptat_far sub 6.713f
R_isense isense isense_far 140.3
Cga_isense isense sub 3.213f
Cgb_isense isense_far sub 3.213f
R_osc_clk osc_clk osc_clk_far 416.9
Cga_osc_clk osc_clk sub 10.96f
Cgb_osc_clk osc_clk_far sub 10.96f
R_osc_en osc_en osc_en_far 245.6
Cga_osc_en osc_en sub 9.651f
Cgb_osc_en osc_en_far sub 9.651f
R_osc_trim_0_ osc_trim_0_ osc_trim_0__far 219.7
Cga_osc_trim_0_ osc_trim_0_ sub 6.583f
Cgb_osc_trim_0_ osc_trim_0__far sub 6.583f
R_osc_trim_1_ osc_trim_1_ osc_trim_1__far 244.2
Cga_osc_trim_1_ osc_trim_1_ sub 2.462f
Cgb_osc_trim_1_ osc_trim_1__far sub 2.462f
R_osc_trim_2_ osc_trim_2_ osc_trim_2__far 223
Cga_osc_trim_2_ osc_trim_2_ sub 10.46f
Cgb_osc_trim_2_ osc_trim_2__far sub 10.46f
R_osc_trim_3_ osc_trim_3_ osc_trim_3__far 247.9
Cga_osc_trim_3_ osc_trim_3_ sub 2.811f
Cgb_osc_trim_3_ osc_trim_3__far sub 2.811f
R_pbias pbias pbias_far 233.2
Cga_pbias pbias sub 4.973f
Cgb_pbias pbias_far sub 4.973f
R_pcasc pcasc pcasc_far 232.4
Cga_pcasc pcasc sub 10.32f
Cgb_pcasc pcasc_far sub 10.32f
R_sclk_i sclk_i sclk_i_far 411.8
Cga_sclk_i sclk_i sub 27.16f
Cgb_sclk_i sclk_i_far sub 27.16f
R_sdi_i sdi_i sdi_i_far 708.6
Cga_sdi_i sdi_i sub 52.55f
Cgb_sdi_i sdi_i_far sub 52.55f
R_sdo_o sdo_o sdo_o_far 72.1
Cga_sdo_o sdo_o sub 27.39f
Cgb_sdo_o sdo_o_far sub 27.39f
R_t2f_en_12 t2f_en_12 t2f_en_12_far 58.1
Cga_t2f_en_12 t2f_en_12 sub 2.332f
Cgb_t2f_en_12 t2f_en_12_far sub 2.332f
R_t2f_en_33 t2f_en_33 t2f_en_33_far 454.5
Cga_t2f_en_33 t2f_en_33 sub 17.73f
Cgb_t2f_en_33 t2f_en_33_far sub 17.73f
R_t2f_mode_12 t2f_mode_12 t2f_mode_12_far 93.5
Cga_t2f_mode_12 t2f_mode_12 sub 3.116f
Cgb_t2f_mode_12 t2f_mode_12_far sub 3.116f
R_t2f_mode_33 t2f_mode_33 t2f_mode_33_far 388.4
Cga_t2f_mode_33 t2f_mode_33 sub 14.84f
Cgb_t2f_mode_33 t2f_mode_33_far sub 14.84f
R_temp_out_o temp_out_o temp_out_o_far 126.5
Cga_temp_out_o temp_out_o sub 10.19f
Cgb_temp_out_o temp_out_o_far sub 10.19f
R_trip_d trip_d trip_d_far 57.1
Cga_trip_d trip_d sub 0.994f
Cgb_trip_d trip_d_far sub 0.994f
R_tripped tripped tripped_far 364.5
Cga_tripped tripped sub 13.99f
Cgb_tripped tripped_far sub 13.99f
R_vref vref vref_far 447.1
Cga_vref vref sub 17.79f
Cgb_vref vref_far sub 17.79f
R_vref_buf vref_buf vref_buf_far 137.4
Cga_vref_buf vref_buf sub 5.155f
Cgb_vref_buf vref_buf_far sub 5.155f
R_net net net_far 324.8
Cga_net net sub 20.76f
Cgb_net net_far sub 20.76f
Cc_d_elt__d_std d_elt d_std 17.89f
Cc_d_elt__g_shared d_elt g_shared 0.94f
Cc_d_elt__hbt_b d_elt hbt_b 83.02f
Cc_d_elt__hbt_c d_elt hbt_c 10.15f
Cc_d_elt__hbt_e d_elt hbt_e 0.03f
Cc_d_elt__osc_clk d_elt osc_clk 1.792f
Cc_d_std__g_shared d_std g_shared 17.94f
Cc_d_std__hbt_b d_std hbt_b 0.358f
Cc_d_std__hbt_c d_std hbt_c 110.8f
Cc_d_std__hbt_e d_std hbt_e 0.027f
Cc_d_std__osc_clk d_std osc_clk 0.12f
Cc_g_shared__hbt_b g_shared hbt_b 11.11f
Cc_g_shared__hbt_c g_shared hbt_c 5.83f
Cc_g_shared__hbt_e g_shared hbt_e 0.052f
Cc_hbt_b__hbt_c hbt_b hbt_c 6.923f
Cc_hbt_b__hbt_e hbt_b hbt_e 0.041f
Cc_hbt_b__sclk_i hbt_b sclk_i 0.17f
Cc_hbt_b__sdi_i hbt_b sdi_i 0.505f
Cc_hbt_c__hbt_e hbt_c hbt_e 0.159f
Cc_hbt_c__osc_clk hbt_c osc_clk 2.417f
Cc_hbt_c__sclk_i hbt_c sclk_i 0.026f
Cc_hbt_c__sdi_i hbt_c sdi_i 0.276f
Cc_hbt_e__en_i hbt_e en_i 0.155f
Cc_hbt_e__bgr_r4_12 hbt_e bgr_r4_12 0.029f
Cc_hbt_e__bgr_r4_33 hbt_e bgr_r4_33 22.03f
Cc_hbt_e__clr_d hbt_e clr_d 0.026f
Cc_hbt_e__cmp_clk hbt_e cmp_clk 0.156f
Cc_hbt_e__cmp_hard hbt_e cmp_hard 0.03f
Cc_hbt_e__cmp_soft hbt_e cmp_soft 0.38f
Cc_hbt_e__dac_hard_0_ hbt_e dac_hard_0_ 0.401f
Cc_hbt_e__dac_hard_1_ hbt_e dac_hard_1_ 0.192f
Cc_hbt_e__dac_hard_2_ hbt_e dac_hard_2_ 0.195f
Cc_hbt_e__dac_hard_3_ hbt_e dac_hard_3_ 0.155f
Cc_hbt_e__dac_hard_4_ hbt_e dac_hard_4_ 0.03f
Cc_hbt_e__dac_hard_5_ hbt_e dac_hard_5_ 0.029f
Cc_hbt_e__dac_hard_6_ hbt_e dac_hard_6_ 0.312f
Cc_hbt_e__dac_hard_7_ hbt_e dac_hard_7_ 4.417f
Cc_hbt_e__dac_soft_0_ hbt_e dac_soft_0_ 0.205f
Cc_hbt_e__dac_soft_1_ hbt_e dac_soft_1_ 0.036f
Cc_hbt_e__dac_soft_2_ hbt_e dac_soft_2_ 0.287f
Cc_hbt_e__dac_soft_3_ hbt_e dac_soft_3_ 0.036f
Cc_hbt_e__dac_soft_4_ hbt_e dac_soft_4_ 0.168f
Cc_hbt_e__dac_soft_5_ hbt_e dac_soft_5_ 0.026f
Cc_hbt_e__dac_soft_6_ hbt_e dac_soft_6_ 0.197f
Cc_hbt_e__dac_soft_7_ hbt_e dac_soft_7_ 0.036f
Cc_hbt_e__fast_en hbt_e fast_en 0.026f
Cc_hbt_e__osc_clk hbt_e osc_clk 1.573f
Cc_hbt_e__osc_en hbt_e osc_en 0.029f
Cc_hbt_e__osc_trim_0_ hbt_e osc_trim_0_ 0.154f
Cc_hbt_e__osc_trim_1_ hbt_e osc_trim_1_ 4.009f
Cc_hbt_e__osc_trim_2_ hbt_e osc_trim_2_ 0.154f
Cc_hbt_e__osc_trim_3_ hbt_e osc_trim_3_ 0.115f
Cc_hbt_e__sclk_i hbt_e sclk_i 0.8f
Cc_hbt_e__sdi_i hbt_e sdi_i 0.064f
Cc_hbt_e__sdo_o hbt_e sdo_o 5.868f
Cc_hbt_e__t2f_en_12 hbt_e t2f_en_12 0.03f
Cc_hbt_e__t2f_mode_12 hbt_e t2f_mode_12 0.164f
Cc_hbt_e__trip_d hbt_e trip_d 0.027f
Cc_hbt_e__tripped hbt_e tripped 0.027f
Cc_hbt_e__net hbt_e net 0.482f
Cc_sense_n__sense_p sense_n sense_p 0.303f
Cc_sense_n__net sense_n net 0.019f
Cc_sense_p__net sense_p net 0.151f
Cc_en_i__fault_n_o en_i fault_n_o 6.415f
Cc_en_i__gate_o en_i gate_o 0.835f
Cc_en_i__bgr_r4_33 en_i bgr_r4_33 0.03f
Cc_en_i__clr_d en_i clr_d 0.408f
Cc_en_i__cmp_clk en_i cmp_clk 0.543f
Cc_en_i__cmp_hard en_i cmp_hard 5.459f
Cc_en_i__cmp_soft en_i cmp_soft 0.444f
Cc_en_i__dac_hard_0_ en_i dac_hard_0_ 45.79f
Cc_en_i__dac_hard_1_ en_i dac_hard_1_ 0.049f
Cc_en_i__dac_hard_2_ en_i dac_hard_2_ 0.052f
Cc_en_i__dac_hard_3_ en_i dac_hard_3_ 0.17f
Cc_en_i__dac_hard_4_ en_i dac_hard_4_ 0.049f
Cc_en_i__dac_hard_5_ en_i dac_hard_5_ 0.05f
Cc_en_i__dac_hard_6_ en_i dac_hard_6_ 0.113f
Cc_en_i__dac_hard_7_ en_i dac_hard_7_ 0.048f
Cc_en_i__iptat en_i iptat 0.031f
Cc_en_i__isense en_i isense 13.32f
Cc_en_i__osc_clk en_i osc_clk 0.029f
Cc_en_i__osc_en en_i osc_en 0.031f
Cc_en_i__osc_trim_1_ en_i osc_trim_1_ 0.032f
Cc_en_i__osc_trim_3_ en_i osc_trim_3_ 0.03f
Cc_en_i__pbias en_i pbias 0.194f
Cc_en_i__pcasc en_i pcasc 0.062f
Cc_en_i__sdi_i en_i sdi_i 1.747f
Cc_en_i__t2f_en_12 en_i t2f_en_12 0.085f
Cc_en_i__t2f_en_33 en_i t2f_en_33 0.642f
Cc_en_i__t2f_mode_33 en_i t2f_mode_33 0.306f
Cc_en_i__trip_d en_i trip_d 0.026f
Cc_en_i__tripped en_i tripped 1.185f
Cc_en_i__vref en_i vref 0.038f
Cc_en_i__vref_buf en_i vref_buf 0.157f
Cc_en_i__net en_i net 0.06f
Cc_fault_n_o__gate_o fault_n_o gate_o 2.308f
Cc_fault_n_o__bgr_r4_33 fault_n_o bgr_r4_33 0.026f
Cc_fault_n_o__cmp_clk fault_n_o cmp_clk 1.522f
Cc_fault_n_o__cmp_hard fault_n_o cmp_hard 8.848f
Cc_fault_n_o__cmp_soft fault_n_o cmp_soft 0.058f
Cc_fault_n_o__dac_hard_0_ fault_n_o dac_hard_0_ 0.057f
Cc_fault_n_o__dac_hard_1_ fault_n_o dac_hard_1_ 0.057f
Cc_fault_n_o__dac_hard_2_ fault_n_o dac_hard_2_ 0.107f
Cc_fault_n_o__dac_hard_3_ fault_n_o dac_hard_3_ 0.044f
Cc_fault_n_o__dac_hard_4_ fault_n_o dac_hard_4_ 0.042f
Cc_fault_n_o__dac_hard_5_ fault_n_o dac_hard_5_ 0.049f
Cc_fault_n_o__dac_hard_6_ fault_n_o dac_hard_6_ 0.095f
Cc_fault_n_o__dac_hard_7_ fault_n_o dac_hard_7_ 0.047f
Cc_fault_n_o__iptat fault_n_o iptat 0.075f
Cc_fault_n_o__isense fault_n_o isense 4.366f
Cc_fault_n_o__osc_trim_0_ fault_n_o osc_trim_0_ 0.045f
Cc_fault_n_o__osc_trim_2_ fault_n_o osc_trim_2_ 0.039f
Cc_fault_n_o__t2f_en_33 fault_n_o t2f_en_33 0.034f
Cc_fault_n_o__t2f_mode_33 fault_n_o t2f_mode_33 0.033f
Cc_fault_n_o__tripped fault_n_o tripped 0.386f
Cc_fault_n_o__vref fault_n_o vref 0.026f
Cc_fault_n_o__vref_buf fault_n_o vref_buf 0.114f
Cc_fault_n_o__net fault_n_o net 0.127f
Cc_gate_o__cmp_clk gate_o cmp_clk 3.354f
Cc_gate_o__cmp_hard gate_o cmp_hard 0.096f
Cc_gate_o__cmp_soft gate_o cmp_soft 0.051f
Cc_gate_o__dac_hard_1_ gate_o dac_hard_1_ 0.072f
Cc_gate_o__dac_hard_2_ gate_o dac_hard_2_ 46.57f
Cc_gate_o__dac_hard_3_ gate_o dac_hard_3_ 1.636f
Cc_gate_o__dac_hard_4_ gate_o dac_hard_4_ 0.048f
Cc_gate_o__dac_hard_5_ gate_o dac_hard_5_ 0.05f
Cc_gate_o__dac_hard_6_ gate_o dac_hard_6_ 0.47f
Cc_gate_o__dac_hard_7_ gate_o dac_hard_7_ 0.048f
Cc_gate_o__iptat gate_o iptat 0.844f
Cc_gate_o__isense gate_o isense 0.029f
Cc_gate_o__osc_trim_0_ gate_o osc_trim_0_ 0.059f
Cc_gate_o__osc_trim_2_ gate_o osc_trim_2_ 0.061f
Cc_gate_o__t2f_en_33 gate_o t2f_en_33 0.049f
Cc_gate_o__t2f_mode_33 gate_o t2f_mode_33 0.157f
Cc_gate_o__tripped gate_o tripped 1.861f
Cc_gate_o__vref gate_o vref 0.03f
Cc_gate_o__vref_buf gate_o vref_buf 0.163f
Cc_gate_o__net gate_o net 0.371f
Cc_bgr_r4_12__bgr_r4_33 bgr_r4_12 bgr_r4_33 0.035f
Cc_bgr_r4_12__clr_d bgr_r4_12 clr_d 0.057f
Cc_bgr_r4_12__cmp_clk bgr_r4_12 cmp_clk 0.029f
Cc_bgr_r4_12__cmp_hard bgr_r4_12 cmp_hard 1.615f
Cc_bgr_r4_12__fast_en bgr_r4_12 fast_en 2.64f
Cc_bgr_r4_12__osc_clk bgr_r4_12 osc_clk 3.112f
Cc_bgr_r4_12__osc_en bgr_r4_12 osc_en 1.718f
Cc_bgr_r4_12__osc_trim_1_ bgr_r4_12 osc_trim_1_ 0.029f
Cc_bgr_r4_12__osc_trim_3_ bgr_r4_12 osc_trim_3_ 5.496f
Cc_bgr_r4_12__t2f_en_12 bgr_r4_12 t2f_en_12 0.084f
Cc_bgr_r4_12__t2f_en_33 bgr_r4_12 t2f_en_33 0.05f
Cc_bgr_r4_12__t2f_mode_12 bgr_r4_12 t2f_mode_12 1.343f
Cc_bgr_r4_12__trip_d bgr_r4_12 trip_d 0.027f
Cc_bgr_r4_12__tripped bgr_r4_12 tripped 0.064f
Cc_bgr_r4_33__clr_d bgr_r4_33 clr_d 7.543f
Cc_bgr_r4_33__cmp_clk bgr_r4_33 cmp_clk 0.027f
Cc_bgr_r4_33__cmp_hard bgr_r4_33 cmp_hard 0.024f
Cc_bgr_r4_33__cmp_soft bgr_r4_33 cmp_soft 0.021f
Cc_bgr_r4_33__dac_hard_0_ bgr_r4_33 dac_hard_0_ 0.027f
Cc_bgr_r4_33__dac_hard_1_ bgr_r4_33 dac_hard_1_ 0.021f
Cc_bgr_r4_33__dac_hard_2_ bgr_r4_33 dac_hard_2_ 0.021f
Cc_bgr_r4_33__dac_hard_3_ bgr_r4_33 dac_hard_3_ 0.87f
Cc_bgr_r4_33__dac_hard_4_ bgr_r4_33 dac_hard_4_ 0.019f
Cc_bgr_r4_33__dac_hard_5_ bgr_r4_33 dac_hard_5_ 0.029f
Cc_bgr_r4_33__dac_hard_6_ bgr_r4_33 dac_hard_6_ 0.032f
Cc_bgr_r4_33__dac_hard_7_ bgr_r4_33 dac_hard_7_ 0.037f
Cc_bgr_r4_33__dac_soft_0_ bgr_r4_33 dac_soft_0_ 0.023f
Cc_bgr_r4_33__dac_soft_1_ bgr_r4_33 dac_soft_1_ 0.994f
Cc_bgr_r4_33__dac_soft_2_ bgr_r4_33 dac_soft_2_ 0.024f
Cc_bgr_r4_33__dac_soft_3_ bgr_r4_33 dac_soft_3_ 0.019f
Cc_bgr_r4_33__dac_soft_4_ bgr_r4_33 dac_soft_4_ 0.027f
Cc_bgr_r4_33__dac_soft_5_ bgr_r4_33 dac_soft_5_ 0.025f
Cc_bgr_r4_33__dac_soft_6_ bgr_r4_33 dac_soft_6_ 0.021f
Cc_bgr_r4_33__dac_soft_7_ bgr_r4_33 dac_soft_7_ 0.021f
Cc_bgr_r4_33__fast_en bgr_r4_33 fast_en 0.02f
Cc_bgr_r4_33__iptat bgr_r4_33 iptat 0.038f
Cc_bgr_r4_33__osc_clk bgr_r4_33 osc_clk 1.555f
Cc_bgr_r4_33__osc_en bgr_r4_33 osc_en 0.09f
Cc_bgr_r4_33__osc_trim_0_ bgr_r4_33 osc_trim_0_ 1.208f
Cc_bgr_r4_33__osc_trim_1_ bgr_r4_33 osc_trim_1_ 2.147f
Cc_bgr_r4_33__osc_trim_2_ bgr_r4_33 osc_trim_2_ 0.028f
Cc_bgr_r4_33__osc_trim_3_ bgr_r4_33 osc_trim_3_ 0.071f
Cc_bgr_r4_33__pbias bgr_r4_33 pbias 0.031f
Cc_bgr_r4_33__pcasc bgr_r4_33 pcasc 0.466f
Cc_bgr_r4_33__sdo_o bgr_r4_33 sdo_o 0.454f
Cc_bgr_r4_33__t2f_en_12 bgr_r4_33 t2f_en_12 0.151f
Cc_bgr_r4_33__t2f_en_33 bgr_r4_33 t2f_en_33 0.382f
Cc_bgr_r4_33__t2f_mode_12 bgr_r4_33 t2f_mode_12 0.51f
Cc_bgr_r4_33__trip_d bgr_r4_33 trip_d 0.039f
Cc_bgr_r4_33__tripped bgr_r4_33 tripped 0.073f
Cc_bgr_r4_33__vref bgr_r4_33 vref 1f
Cc_bgr_r4_33__net bgr_r4_33 net 0.154f
Cc_clr_d__cmp_clk clr_d cmp_clk 0.029f
Cc_clr_d__cmp_hard clr_d cmp_hard 0.068f
Cc_clr_d__fast_en clr_d fast_en 0.981f
Cc_clr_d__osc_clk clr_d osc_clk 0.017f
Cc_clr_d__osc_en clr_d osc_en 0.025f
Cc_clr_d__osc_trim_1_ clr_d osc_trim_1_ 4.176f
Cc_clr_d__osc_trim_3_ clr_d osc_trim_3_ 0.019f
Cc_clr_d__t2f_en_12 clr_d t2f_en_12 0.079f
Cc_clr_d__t2f_mode_12 clr_d t2f_mode_12 0.252f
Cc_clr_d__trip_d clr_d trip_d 9.308f
Cc_clr_d__tripped clr_d tripped 0.023f
Cc_cmp_clk__cmp_hard cmp_clk cmp_hard 40.98f
Cc_cmp_clk__cmp_soft cmp_clk cmp_soft 0.229f
Cc_cmp_clk__dac_hard_1_ cmp_clk dac_hard_1_ 0.08f
Cc_cmp_clk__dac_hard_4_ cmp_clk dac_hard_4_ 0.019f
Cc_cmp_clk__dac_hard_5_ cmp_clk dac_hard_5_ 17.35f
Cc_cmp_clk__dac_hard_6_ cmp_clk dac_hard_6_ 0.026f
Cc_cmp_clk__dac_hard_7_ cmp_clk dac_hard_7_ 21.01f
Cc_cmp_clk__fast_en cmp_clk fast_en 0.069f
Cc_cmp_clk__iptat cmp_clk iptat 0.023f
Cc_cmp_clk__isense cmp_clk isense 0.021f
Cc_cmp_clk__osc_clk cmp_clk osc_clk 0.027f
Cc_cmp_clk__osc_en cmp_clk osc_en 0.133f
Cc_cmp_clk__t2f_en_12 cmp_clk t2f_en_12 0.014f
Cc_cmp_clk__t2f_en_33 cmp_clk t2f_en_33 0.884f
Cc_cmp_clk__t2f_mode_33 cmp_clk t2f_mode_33 0.206f
Cc_cmp_clk__trip_d cmp_clk trip_d 0.029f
Cc_cmp_clk__tripped cmp_clk tripped 0.293f
Cc_cmp_clk__vref cmp_clk vref 0.026f
Cc_cmp_clk__vref_buf cmp_clk vref_buf 0.027f
Cc_cmp_clk__net cmp_clk net 1.053f
Cc_cmp_hard__cmp_soft cmp_hard cmp_soft 0.735f
Cc_cmp_hard__dac_hard_1_ cmp_hard dac_hard_1_ 0.015f
Cc_cmp_hard__dac_hard_3_ cmp_hard dac_hard_3_ 47.09f
Cc_cmp_hard__dac_hard_4_ cmp_hard dac_hard_4_ 1.043f
Cc_cmp_hard__dac_hard_5_ cmp_hard dac_hard_5_ 0.045f
Cc_cmp_hard__dac_hard_7_ cmp_hard dac_hard_7_ 0.053f
Cc_cmp_hard__fast_en cmp_hard fast_en 0.297f
Cc_cmp_hard__iptat cmp_hard iptat 0.019f
Cc_cmp_hard__isense cmp_hard isense 0.016f
Cc_cmp_hard__osc_clk cmp_hard osc_clk 0.024f
Cc_cmp_hard__osc_en cmp_hard osc_en 1.628f
Cc_cmp_hard__osc_trim_1_ cmp_hard osc_trim_1_ 0.065f
Cc_cmp_hard__osc_trim_3_ cmp_hard osc_trim_3_ 0.03f
Cc_cmp_hard__t2f_en_12 cmp_hard t2f_en_12 0.029f
Cc_cmp_hard__t2f_en_33 cmp_hard t2f_en_33 0.025f
Cc_cmp_hard__t2f_mode_12 cmp_hard t2f_mode_12 0.033f
Cc_cmp_hard__trip_d cmp_hard trip_d 0.639f
Cc_cmp_hard__tripped cmp_hard tripped 47.32f
Cc_cmp_hard__vref cmp_hard vref 0.031f
Cc_cmp_hard__vref_buf cmp_hard vref_buf 0.024f
Cc_cmp_hard__net cmp_hard net 0.067f
Cc_cmp_soft__dac_hard_0_ cmp_soft dac_hard_0_ 83.69f
Cc_cmp_soft__dac_hard_1_ cmp_soft dac_hard_1_ 84.04f
Cc_cmp_soft__dac_hard_2_ cmp_soft dac_hard_2_ 0.095f
Cc_cmp_soft__dac_hard_3_ cmp_soft dac_hard_3_ 0.015f
Cc_cmp_soft__dac_hard_4_ cmp_soft dac_hard_4_ 0.016f
Cc_cmp_soft__dac_hard_5_ cmp_soft dac_hard_5_ 0.019f
Cc_cmp_soft__dac_hard_6_ cmp_soft dac_hard_6_ 0.125f
Cc_cmp_soft__dac_hard_7_ cmp_soft dac_hard_7_ 0.304f
Cc_cmp_soft__dac_soft_0_ cmp_soft dac_soft_0_ 0.071f
Cc_cmp_soft__dac_soft_1_ cmp_soft dac_soft_1_ 0.557f
Cc_cmp_soft__dac_soft_2_ cmp_soft dac_soft_2_ 0.814f
Cc_cmp_soft__dac_soft_3_ cmp_soft dac_soft_3_ 0.776f
Cc_cmp_soft__dac_soft_4_ cmp_soft dac_soft_4_ 0.037f
Cc_cmp_soft__dac_soft_5_ cmp_soft dac_soft_5_ 0.014f
Cc_cmp_soft__dac_soft_6_ cmp_soft dac_soft_6_ 0.063f
Cc_cmp_soft__dac_soft_7_ cmp_soft dac_soft_7_ 0.011f
Cc_cmp_soft__iptat cmp_soft iptat 0.023f
Cc_cmp_soft__isense cmp_soft isense 0.026f
Cc_cmp_soft__osc_clk cmp_soft osc_clk 0.02f
Cc_cmp_soft__osc_en cmp_soft osc_en 0.014f
Cc_cmp_soft__osc_trim_0_ cmp_soft osc_trim_0_ 0.011f
Cc_cmp_soft__osc_trim_1_ cmp_soft osc_trim_1_ 0.011f
Cc_cmp_soft__osc_trim_2_ cmp_soft osc_trim_2_ 0.024f
Cc_cmp_soft__osc_trim_3_ cmp_soft osc_trim_3_ 0.011f
Cc_cmp_soft__sclk_i cmp_soft sclk_i 52.71f
Cc_cmp_soft__sdi_i cmp_soft sdi_i 5.058f
Cc_cmp_soft__sdo_o cmp_soft sdo_o 0.05f
Cc_cmp_soft__tripped cmp_soft tripped 0.01f
Cc_cmp_soft__vref cmp_soft vref 0.018f
Cc_cmp_soft__vref_buf cmp_soft vref_buf 0.21f
Cc_dac_hard_0___dac_hard_1_ dac_hard_0_ dac_hard_1_ 2.662f
Cc_dac_hard_0___dac_hard_2_ dac_hard_0_ dac_hard_2_ 0.163f
Cc_dac_hard_0___dac_hard_3_ dac_hard_0_ dac_hard_3_ 0.036f
Cc_dac_hard_0___dac_hard_4_ dac_hard_0_ dac_hard_4_ 0.021f
Cc_dac_hard_0___dac_hard_5_ dac_hard_0_ dac_hard_5_ 0.02f
Cc_dac_hard_0___dac_hard_6_ dac_hard_0_ dac_hard_6_ 0.13f
Cc_dac_hard_0___dac_hard_7_ dac_hard_0_ dac_hard_7_ 0.131f
Cc_dac_hard_0___dac_soft_0_ dac_hard_0_ dac_soft_0_ 0.195f
Cc_dac_hard_0___dac_soft_1_ dac_hard_0_ dac_soft_1_ 0.115f
Cc_dac_hard_0___dac_soft_2_ dac_hard_0_ dac_soft_2_ 0.09f
Cc_dac_hard_0___dac_soft_3_ dac_hard_0_ dac_soft_3_ 0.027f
Cc_dac_hard_0___dac_soft_4_ dac_hard_0_ dac_soft_4_ 0.019f
Cc_dac_hard_0___dac_soft_5_ dac_hard_0_ dac_soft_5_ 0.02f
Cc_dac_hard_0___dac_soft_6_ dac_hard_0_ dac_soft_6_ 0.055f
Cc_dac_hard_0___dac_soft_7_ dac_hard_0_ dac_soft_7_ 0.017f
Cc_dac_hard_0___iptat dac_hard_0_ iptat 0.025f
Cc_dac_hard_0___isense dac_hard_0_ isense 1.03f
Cc_dac_hard_0___osc_clk dac_hard_0_ osc_clk 0.027f
Cc_dac_hard_0___osc_en dac_hard_0_ osc_en 0.02f
Cc_dac_hard_0___osc_trim_0_ dac_hard_0_ osc_trim_0_ 0.017f
Cc_dac_hard_0___osc_trim_1_ dac_hard_0_ osc_trim_1_ 0.017f
Cc_dac_hard_0___osc_trim_2_ dac_hard_0_ osc_trim_2_ 0.03f
Cc_dac_hard_0___osc_trim_3_ dac_hard_0_ osc_trim_3_ 0.017f
Cc_dac_hard_0___sclk_i dac_hard_0_ sclk_i 0.023f
Cc_dac_hard_0___sdo_o dac_hard_0_ sdo_o 0.309f
Cc_dac_hard_0___vref dac_hard_0_ vref 0.024f
Cc_dac_hard_0___vref_buf dac_hard_0_ vref_buf 0.198f
Cc_dac_hard_1___dac_hard_2_ dac_hard_1_ dac_hard_2_ 15.75f
Cc_dac_hard_1___dac_hard_3_ dac_hard_1_ dac_hard_3_ 0.033f
Cc_dac_hard_1___dac_hard_4_ dac_hard_1_ dac_hard_4_ 0.023f
Cc_dac_hard_1___dac_hard_5_ dac_hard_1_ dac_hard_5_ 0.022f
Cc_dac_hard_1___dac_hard_6_ dac_hard_1_ dac_hard_6_ 0.163f
Cc_dac_hard_1___dac_hard_7_ dac_hard_1_ dac_hard_7_ 0.1f
Cc_dac_hard_1___dac_soft_0_ dac_hard_1_ dac_soft_0_ 33.16f
Cc_dac_hard_1___dac_soft_1_ dac_hard_1_ dac_soft_1_ 0.021f
Cc_dac_hard_1___dac_soft_2_ dac_hard_1_ dac_soft_2_ 0.187f
Cc_dac_hard_1___dac_soft_3_ dac_hard_1_ dac_soft_3_ 0.013f
Cc_dac_hard_1___dac_soft_4_ dac_hard_1_ dac_soft_4_ 0.016f
Cc_dac_hard_1___dac_soft_5_ dac_hard_1_ dac_soft_5_ 0.016f
Cc_dac_hard_1___dac_soft_6_ dac_hard_1_ dac_soft_6_ 0.05f
Cc_dac_hard_1___dac_soft_7_ dac_hard_1_ dac_soft_7_ 0.013f
Cc_dac_hard_1___iptat dac_hard_1_ iptat 0.025f
Cc_dac_hard_1___isense dac_hard_1_ isense 0.026f
Cc_dac_hard_1___osc_clk dac_hard_1_ osc_clk 0.023f
Cc_dac_hard_1___osc_en dac_hard_1_ osc_en 0.016f
Cc_dac_hard_1___osc_trim_0_ dac_hard_1_ osc_trim_0_ 0.013f
Cc_dac_hard_1___osc_trim_1_ dac_hard_1_ osc_trim_1_ 0.013f
Cc_dac_hard_1___osc_trim_2_ dac_hard_1_ osc_trim_2_ 0.026f
Cc_dac_hard_1___osc_trim_3_ dac_hard_1_ osc_trim_3_ 0.013f
Cc_dac_hard_1___sclk_i dac_hard_1_ sclk_i 0.022f
Cc_dac_hard_1___sdo_o dac_hard_1_ sdo_o 0.038f
Cc_dac_hard_1___vref dac_hard_1_ vref 0.02f
Cc_dac_hard_1___vref_buf dac_hard_1_ vref_buf 0.399f
Cc_dac_hard_2___dac_hard_3_ dac_hard_2_ dac_hard_3_ 1.34f
Cc_dac_hard_2___dac_hard_4_ dac_hard_2_ dac_hard_4_ 1.164f
Cc_dac_hard_2___dac_hard_5_ dac_hard_2_ dac_hard_5_ 0.028f
Cc_dac_hard_2___dac_hard_6_ dac_hard_2_ dac_hard_6_ 0.288f
Cc_dac_hard_2___dac_hard_7_ dac_hard_2_ dac_hard_7_ 0.143f
Cc_dac_hard_2___dac_soft_0_ dac_hard_2_ dac_soft_0_ 29.94f
Cc_dac_hard_2___dac_soft_1_ dac_hard_2_ dac_soft_1_ 0.253f
Cc_dac_hard_2___dac_soft_2_ dac_hard_2_ dac_soft_2_ 0.293f
Cc_dac_hard_2___dac_soft_3_ dac_hard_2_ dac_soft_3_ 0.013f
Cc_dac_hard_2___dac_soft_4_ dac_hard_2_ dac_soft_4_ 33.48f
Cc_dac_hard_2___dac_soft_5_ dac_hard_2_ dac_soft_5_ 0.016f
Cc_dac_hard_2___dac_soft_6_ dac_hard_2_ dac_soft_6_ 0.052f
Cc_dac_hard_2___dac_soft_7_ dac_hard_2_ dac_soft_7_ 0.013f
Cc_dac_hard_2___iptat dac_hard_2_ iptat 0.134f
Cc_dac_hard_2___isense dac_hard_2_ isense 0.026f
Cc_dac_hard_2___osc_clk dac_hard_2_ osc_clk 0.023f
Cc_dac_hard_2___osc_en dac_hard_2_ osc_en 0.016f
Cc_dac_hard_2___osc_trim_0_ dac_hard_2_ osc_trim_0_ 0.013f
Cc_dac_hard_2___osc_trim_1_ dac_hard_2_ osc_trim_1_ 0.013f
Cc_dac_hard_2___osc_trim_2_ dac_hard_2_ osc_trim_2_ 0.026f
Cc_dac_hard_2___osc_trim_3_ dac_hard_2_ osc_trim_3_ 0.013f
Cc_dac_hard_2___sclk_i dac_hard_2_ sclk_i 0.563f
Cc_dac_hard_2___sdo_o dac_hard_2_ sdo_o 0.044f
Cc_dac_hard_2___vref dac_hard_2_ vref 0.02f
Cc_dac_hard_2___vref_buf dac_hard_2_ vref_buf 0.203f
Cc_dac_hard_3___dac_hard_4_ dac_hard_3_ dac_hard_4_ 1.523f
Cc_dac_hard_3___dac_hard_5_ dac_hard_3_ dac_hard_5_ 0.071f
Cc_dac_hard_3___dac_hard_6_ dac_hard_3_ dac_hard_6_ 3.158f
Cc_dac_hard_3___dac_hard_7_ dac_hard_3_ dac_hard_7_ 0.122f
Cc_dac_hard_3___dac_soft_1_ dac_hard_3_ dac_soft_1_ 0.052f
Cc_dac_hard_3___dac_soft_2_ dac_hard_3_ dac_soft_2_ 0.159f
Cc_dac_hard_3___dac_soft_3_ dac_hard_3_ dac_soft_3_ 0.056f
Cc_dac_hard_3___dac_soft_4_ dac_hard_3_ dac_soft_4_ 0.284f
Cc_dac_hard_3___dac_soft_5_ dac_hard_3_ dac_soft_5_ 0.427f
Cc_dac_hard_3___dac_soft_7_ dac_hard_3_ dac_soft_7_ 3.415f
Cc_dac_hard_3___iptat dac_hard_3_ iptat 16.62f
Cc_dac_hard_3___isense dac_hard_3_ isense 0.016f
Cc_dac_hard_3___osc_clk dac_hard_3_ osc_clk 0.091f
Cc_dac_hard_3___osc_en dac_hard_3_ osc_en 0.091f
Cc_dac_hard_3___osc_trim_0_ dac_hard_3_ osc_trim_0_ 0.053f
Cc_dac_hard_3___osc_trim_1_ dac_hard_3_ osc_trim_1_ 0.073f
Cc_dac_hard_3___osc_trim_2_ dac_hard_3_ osc_trim_2_ 0.223f
Cc_dac_hard_3___osc_trim_3_ dac_hard_3_ osc_trim_3_ 0.076f
Cc_dac_hard_3___tripped dac_hard_3_ tripped 0.056f
Cc_dac_hard_3___vref dac_hard_3_ vref 0.024f
Cc_dac_hard_3___vref_buf dac_hard_3_ vref_buf 0.024f
Cc_dac_hard_3___net dac_hard_3_ net 0.254f
Cc_dac_hard_4___dac_hard_5_ dac_hard_4_ dac_hard_5_ 21.38f
Cc_dac_hard_4___dac_hard_6_ dac_hard_4_ dac_hard_6_ 8.198f
Cc_dac_hard_4___dac_hard_7_ dac_hard_4_ dac_hard_7_ 0.616f
Cc_dac_hard_4___dac_soft_1_ dac_hard_4_ dac_soft_1_ 0.258f
Cc_dac_hard_4___dac_soft_2_ dac_hard_4_ dac_soft_2_ 32.76f
Cc_dac_hard_4___dac_soft_3_ dac_hard_4_ dac_soft_3_ 33.97f
Cc_dac_hard_4___dac_soft_5_ dac_hard_4_ dac_soft_5_ 0.129f
Cc_dac_hard_4___dac_soft_6_ dac_hard_4_ dac_soft_6_ 0.203f
Cc_dac_hard_4___dac_soft_7_ dac_hard_4_ dac_soft_7_ 0.808f
Cc_dac_hard_4___iptat dac_hard_4_ iptat 0.205f
Cc_dac_hard_4___isense dac_hard_4_ isense 0.023f
Cc_dac_hard_4___osc_clk dac_hard_4_ osc_clk 0.019f
Cc_dac_hard_4___osc_en dac_hard_4_ osc_en 0.013f
Cc_dac_hard_4___osc_trim_0_ dac_hard_4_ osc_trim_0_ 0.011f
Cc_dac_hard_4___osc_trim_1_ dac_hard_4_ osc_trim_1_ 0.011f
Cc_dac_hard_4___osc_trim_2_ dac_hard_4_ osc_trim_2_ 0.022f
Cc_dac_hard_4___osc_trim_3_ dac_hard_4_ osc_trim_3_ 0.011f
Cc_dac_hard_4___sdo_o dac_hard_4_ sdo_o 0.05f
Cc_dac_hard_4___tripped dac_hard_4_ tripped 0.553f
Cc_dac_hard_4___vref dac_hard_4_ vref 0.017f
Cc_dac_hard_4___vref_buf dac_hard_4_ vref_buf 0.03f
Cc_dac_hard_4___net dac_hard_4_ net 0.012f
Cc_dac_hard_5___dac_hard_6_ dac_hard_5_ dac_hard_6_ 0.305f
Cc_dac_hard_5___dac_hard_7_ dac_hard_5_ dac_hard_7_ 2.189f
Cc_dac_hard_5___dac_soft_1_ dac_hard_5_ dac_soft_1_ 0.066f
Cc_dac_hard_5___dac_soft_3_ dac_hard_5_ dac_soft_3_ 34.38f
Cc_dac_hard_5___dac_soft_5_ dac_hard_5_ dac_soft_5_ 0.762f
Cc_dac_hard_5___dac_soft_7_ dac_hard_5_ dac_soft_7_ 0.192f
Cc_dac_hard_5___iptat dac_hard_5_ iptat 0.023f
Cc_dac_hard_5___isense dac_hard_5_ isense 0.021f
Cc_dac_hard_5___osc_clk dac_hard_5_ osc_clk 0.024f
Cc_dac_hard_5___osc_en dac_hard_5_ osc_en 0.019f
Cc_dac_hard_5___osc_trim_0_ dac_hard_5_ osc_trim_0_ 0.016f
Cc_dac_hard_5___osc_trim_1_ dac_hard_5_ osc_trim_1_ 0.019f
Cc_dac_hard_5___osc_trim_2_ dac_hard_5_ osc_trim_2_ 0.028f
Cc_dac_hard_5___osc_trim_3_ dac_hard_5_ osc_trim_3_ 0.095f
Cc_dac_hard_5___t2f_en_33 dac_hard_5_ t2f_en_33 0.539f
Cc_dac_hard_5___t2f_mode_33 dac_hard_5_ t2f_mode_33 1.002f
Cc_dac_hard_5___tripped dac_hard_5_ tripped 0.592f
Cc_dac_hard_5___vref dac_hard_5_ vref 0.022f
Cc_dac_hard_5___vref_buf dac_hard_5_ vref_buf 0.027f
Cc_dac_hard_5___net dac_hard_5_ net 0.148f
Cc_dac_hard_6___dac_hard_7_ dac_hard_6_ dac_hard_7_ 5.032f
Cc_dac_hard_6___dac_soft_0_ dac_hard_6_ dac_soft_0_ 0.029f
Cc_dac_hard_6___dac_soft_1_ dac_hard_6_ dac_soft_1_ 1.467f
Cc_dac_hard_6___dac_soft_2_ dac_hard_6_ dac_soft_2_ 2.551f
Cc_dac_hard_6___dac_soft_3_ dac_hard_6_ dac_soft_3_ 0.026f
Cc_dac_hard_6___dac_soft_4_ dac_hard_6_ dac_soft_4_ 1.433f
Cc_dac_hard_6___dac_soft_5_ dac_hard_6_ dac_soft_5_ 0.054f
Cc_dac_hard_6___dac_soft_7_ dac_hard_6_ dac_soft_7_ 17.19f
Cc_dac_hard_6___iptat dac_hard_6_ iptat 0.332f
Cc_dac_hard_6___isense dac_hard_6_ isense 0.035f
Cc_dac_hard_6___osc_clk dac_hard_6_ osc_clk 0.031f
Cc_dac_hard_6___osc_en dac_hard_6_ osc_en 0.026f
Cc_dac_hard_6___osc_trim_0_ dac_hard_6_ osc_trim_0_ 0.023f
Cc_dac_hard_6___osc_trim_1_ dac_hard_6_ osc_trim_1_ 0.023f
Cc_dac_hard_6___osc_trim_2_ dac_hard_6_ osc_trim_2_ 0.034f
Cc_dac_hard_6___osc_trim_3_ dac_hard_6_ osc_trim_3_ 0.023f
Cc_dac_hard_6___sdo_o dac_hard_6_ sdo_o 0.087f
Cc_dac_hard_6___vref dac_hard_6_ vref 0.029f
Cc_dac_hard_6___vref_buf dac_hard_6_ vref_buf 1.157f
Cc_dac_hard_7___dac_soft_0_ dac_hard_7_ dac_soft_0_ 0.07f
Cc_dac_hard_7___dac_soft_1_ dac_hard_7_ dac_soft_1_ 0.27f
Cc_dac_hard_7___dac_soft_2_ dac_hard_7_ dac_soft_2_ 2.073f
Cc_dac_hard_7___dac_soft_3_ dac_hard_7_ dac_soft_3_ 0.419f
Cc_dac_hard_7___dac_soft_4_ dac_hard_7_ dac_soft_4_ 0.214f
Cc_dac_hard_7___dac_soft_5_ dac_hard_7_ dac_soft_5_ 0.024f
Cc_dac_hard_7___dac_soft_6_ dac_hard_7_ dac_soft_6_ 0.15f
Cc_dac_hard_7___dac_soft_7_ dac_hard_7_ dac_soft_7_ 0.105f
Cc_dac_hard_7___iptat dac_hard_7_ iptat 0.028f
Cc_dac_hard_7___isense dac_hard_7_ isense 0.026f
Cc_dac_hard_7___osc_clk dac_hard_7_ osc_clk 0.049f
Cc_dac_hard_7___osc_en dac_hard_7_ osc_en 0.066f
Cc_dac_hard_7___osc_trim_0_ dac_hard_7_ osc_trim_0_ 0.024f
Cc_dac_hard_7___osc_trim_1_ dac_hard_7_ osc_trim_1_ 0.047f
Cc_dac_hard_7___osc_trim_2_ dac_hard_7_ osc_trim_2_ 0.036f
Cc_dac_hard_7___osc_trim_3_ dac_hard_7_ osc_trim_3_ 0.094f
Cc_dac_hard_7___sclk_i dac_hard_7_ sclk_i 0.093f
Cc_dac_hard_7___sdo_o dac_hard_7_ sdo_o 0.177f
Cc_dac_hard_7___t2f_en_33 dac_hard_7_ t2f_en_33 0.021f
Cc_dac_hard_7___t2f_mode_33 dac_hard_7_ t2f_mode_33 0.028f
Cc_dac_hard_7___tripped dac_hard_7_ tripped 0.022f
Cc_dac_hard_7___vref dac_hard_7_ vref 0.101f
Cc_dac_hard_7___vref_buf dac_hard_7_ vref_buf 0.032f
Cc_dac_hard_7___net dac_hard_7_ net 0.575f
Cc_dac_soft_0___dac_soft_1_ dac_soft_0_ dac_soft_1_ 1.296f
Cc_dac_soft_0___dac_soft_2_ dac_soft_0_ dac_soft_2_ 0.096f
Cc_dac_soft_0___dac_soft_3_ dac_soft_0_ dac_soft_3_ 0.129f
Cc_dac_soft_0___dac_soft_4_ dac_soft_0_ dac_soft_4_ 0.052f
Cc_dac_soft_0___dac_soft_5_ dac_soft_0_ dac_soft_5_ 0.022f
Cc_dac_soft_0___dac_soft_6_ dac_soft_0_ dac_soft_6_ 0.047f
Cc_dac_soft_0___dac_soft_7_ dac_soft_0_ dac_soft_7_ 0.022f
Cc_dac_soft_0___isense dac_soft_0_ isense 0.015f
Cc_dac_soft_0___osc_clk dac_soft_0_ osc_clk 0.031f
Cc_dac_soft_0___osc_en dac_soft_0_ osc_en 0.024f
Cc_dac_soft_0___osc_trim_0_ dac_soft_0_ osc_trim_0_ 0.024f
Cc_dac_soft_0___osc_trim_1_ dac_soft_0_ osc_trim_1_ 0.023f
Cc_dac_soft_0___osc_trim_2_ dac_soft_0_ osc_trim_2_ 0.032f
Cc_dac_soft_0___osc_trim_3_ dac_soft_0_ osc_trim_3_ 0.022f
Cc_dac_soft_0___sclk_i dac_soft_0_ sclk_i 0.026f
Cc_dac_soft_0___sdo_o dac_soft_0_ sdo_o 0.09f
Cc_dac_soft_0___vref dac_soft_0_ vref 0.042f
Cc_dac_soft_0___vref_buf dac_soft_0_ vref_buf 0.017f
Cc_dac_soft_1___dac_soft_2_ dac_soft_1_ dac_soft_2_ 0.672f
Cc_dac_soft_1___dac_soft_3_ dac_soft_1_ dac_soft_3_ 1.433f
Cc_dac_soft_1___dac_soft_4_ dac_soft_1_ dac_soft_4_ 0.07f
Cc_dac_soft_1___dac_soft_5_ dac_soft_1_ dac_soft_5_ 24.17f
Cc_dac_soft_1___dac_soft_6_ dac_soft_1_ dac_soft_6_ 0.469f
Cc_dac_soft_1___dac_soft_7_ dac_soft_1_ dac_soft_7_ 25.82f
Cc_dac_soft_1___isense dac_soft_1_ isense 0.013f
Cc_dac_soft_1___osc_clk dac_soft_1_ osc_clk 0.028f
Cc_dac_soft_1___osc_en dac_soft_1_ osc_en 0.022f
Cc_dac_soft_1___osc_trim_0_ dac_soft_1_ osc_trim_0_ 0.019f
Cc_dac_soft_1___osc_trim_1_ dac_soft_1_ osc_trim_1_ 0.019f
Cc_dac_soft_1___osc_trim_2_ dac_soft_1_ osc_trim_2_ 0.032f
Cc_dac_soft_1___osc_trim_3_ dac_soft_1_ osc_trim_3_ 0.021f
Cc_dac_soft_1___sclk_i dac_soft_1_ sclk_i 0.039f
Cc_dac_soft_1___sdo_o dac_soft_1_ sdo_o 0.309f
Cc_dac_soft_1___vref dac_soft_1_ vref 0.149f
Cc_dac_soft_1___vref_buf dac_soft_1_ vref_buf 0.015f
Cc_dac_soft_2___dac_soft_3_ dac_soft_2_ dac_soft_3_ 3.154f
Cc_dac_soft_2___dac_soft_4_ dac_soft_2_ dac_soft_4_ 0.12f
Cc_dac_soft_2___dac_soft_5_ dac_soft_2_ dac_soft_5_ 0.018f
Cc_dac_soft_2___dac_soft_6_ dac_soft_2_ dac_soft_6_ 0.055f
Cc_dac_soft_2___dac_soft_7_ dac_soft_2_ dac_soft_7_ 0.057f
Cc_dac_soft_2___isense dac_soft_2_ isense 0.013f
Cc_dac_soft_2___osc_clk dac_soft_2_ osc_clk 0.023f
Cc_dac_soft_2___osc_en dac_soft_2_ osc_en 0.018f
Cc_dac_soft_2___osc_trim_0_ dac_soft_2_ osc_trim_0_ 0.015f
Cc_dac_soft_2___osc_trim_1_ dac_soft_2_ osc_trim_1_ 0.015f
Cc_dac_soft_2___osc_trim_2_ dac_soft_2_ osc_trim_2_ 0.295f
Cc_dac_soft_2___osc_trim_3_ dac_soft_2_ osc_trim_3_ 0.015f
Cc_dac_soft_2___sclk_i dac_soft_2_ sclk_i 0.051f
Cc_dac_soft_2___sdo_o dac_soft_2_ sdo_o 0.133f
Cc_dac_soft_2___vref dac_soft_2_ vref 0.021f
Cc_dac_soft_2___vref_buf dac_soft_2_ vref_buf 0.015f
Cc_dac_soft_3___dac_soft_4_ dac_soft_3_ dac_soft_4_ 0.257f
Cc_dac_soft_3___dac_soft_5_ dac_soft_3_ dac_soft_5_ 2.868f
Cc_dac_soft_3___dac_soft_6_ dac_soft_3_ dac_soft_6_ 0.014f
Cc_dac_soft_3___dac_soft_7_ dac_soft_3_ dac_soft_7_ 0.137f
Cc_dac_soft_3___isense dac_soft_3_ isense 0.013f
Cc_dac_soft_3___osc_clk dac_soft_3_ osc_clk 0.019f
Cc_dac_soft_3___osc_en dac_soft_3_ osc_en 0.013f
Cc_dac_soft_3___osc_trim_0_ dac_soft_3_ osc_trim_0_ 0.011f
Cc_dac_soft_3___osc_trim_1_ dac_soft_3_ osc_trim_1_ 0.013f
Cc_dac_soft_3___osc_trim_2_ dac_soft_3_ osc_trim_2_ 0.045f
Cc_dac_soft_3___osc_trim_3_ dac_soft_3_ osc_trim_3_ 0.014f
Cc_dac_soft_3___sclk_i dac_soft_3_ sclk_i 0.025f
Cc_dac_soft_3___vref dac_soft_3_ vref 0.017f
Cc_dac_soft_3___vref_buf dac_soft_3_ vref_buf 0.016f
Cc_dac_soft_4___dac_soft_5_ dac_soft_4_ dac_soft_5_ 1.042f
Cc_dac_soft_4___dac_soft_6_ dac_soft_4_ dac_soft_6_ 0.176f
Cc_dac_soft_4___dac_soft_7_ dac_soft_4_ dac_soft_7_ 0.267f
Cc_dac_soft_4___iptat dac_soft_4_ iptat 0.038f
Cc_dac_soft_4___isense dac_soft_4_ isense 0.014f
Cc_dac_soft_4___osc_clk dac_soft_4_ osc_clk 0.026f
Cc_dac_soft_4___osc_en dac_soft_4_ osc_en 0.019f
Cc_dac_soft_4___osc_trim_0_ dac_soft_4_ osc_trim_0_ 0.016f
Cc_dac_soft_4___osc_trim_1_ dac_soft_4_ osc_trim_1_ 0.016f
Cc_dac_soft_4___osc_trim_2_ dac_soft_4_ osc_trim_2_ 0.03f
Cc_dac_soft_4___osc_trim_3_ dac_soft_4_ osc_trim_3_ 0.016f
Cc_dac_soft_4___sdo_o dac_soft_4_ sdo_o 0.052f
Cc_dac_soft_4___vref dac_soft_4_ vref 0.024f
Cc_dac_soft_4___vref_buf dac_soft_4_ vref_buf 1.882f
Cc_dac_soft_5___dac_soft_6_ dac_soft_5_ dac_soft_6_ 0.326f
Cc_dac_soft_5___dac_soft_7_ dac_soft_5_ dac_soft_7_ 6.023f
Cc_dac_soft_5___iptat dac_soft_5_ iptat 0.064f
Cc_dac_soft_5___isense dac_soft_5_ isense 0.013f
Cc_dac_soft_5___osc_clk dac_soft_5_ osc_clk 0.026f
Cc_dac_soft_5___osc_en dac_soft_5_ osc_en 0.019f
Cc_dac_soft_5___osc_trim_0_ dac_soft_5_ osc_trim_0_ 0.013f
Cc_dac_soft_5___osc_trim_1_ dac_soft_5_ osc_trim_1_ 0.016f
Cc_dac_soft_5___osc_trim_2_ dac_soft_5_ osc_trim_2_ 0.052f
Cc_dac_soft_5___osc_trim_3_ dac_soft_5_ osc_trim_3_ 6.493f
Cc_dac_soft_5___sdo_o dac_soft_5_ sdo_o 0.029f
Cc_dac_soft_5___vref dac_soft_5_ vref 0.02f
Cc_dac_soft_5___vref_buf dac_soft_5_ vref_buf 0.046f
Cc_dac_soft_5___net dac_soft_5_ net 0.762f
Cc_dac_soft_6___dac_soft_7_ dac_soft_6_ dac_soft_7_ 1.204f
Cc_dac_soft_6___isense dac_soft_6_ isense 0.013f
Cc_dac_soft_6___osc_clk dac_soft_6_ osc_clk 0.206f
Cc_dac_soft_6___osc_en dac_soft_6_ osc_en 0.033f
Cc_dac_soft_6___osc_trim_0_ dac_soft_6_ osc_trim_0_ 0.022f
Cc_dac_soft_6___osc_trim_1_ dac_soft_6_ osc_trim_1_ 0.023f
Cc_dac_soft_6___osc_trim_2_ dac_soft_6_ osc_trim_2_ 0.051f
Cc_dac_soft_6___osc_trim_3_ dac_soft_6_ osc_trim_3_ 0.025f
Cc_dac_soft_6___sdo_o dac_soft_6_ sdo_o 8.394f
Cc_dac_soft_6___vref dac_soft_6_ vref 0.033f
Cc_dac_soft_6___vref_buf dac_soft_6_ vref_buf 0.024f
Cc_dac_soft_7___isense dac_soft_7_ isense 0.019f
Cc_dac_soft_7___osc_clk dac_soft_7_ osc_clk 0.033f
Cc_dac_soft_7___osc_en dac_soft_7_ osc_en 0.026f
Cc_dac_soft_7___osc_trim_0_ dac_soft_7_ osc_trim_0_ 0.014f
Cc_dac_soft_7___osc_trim_1_ dac_soft_7_ osc_trim_1_ 3.141f
Cc_dac_soft_7___osc_trim_2_ dac_soft_7_ osc_trim_2_ 0.033f
Cc_dac_soft_7___osc_trim_3_ dac_soft_7_ osc_trim_3_ 3.152f
Cc_dac_soft_7___sdo_o dac_soft_7_ sdo_o 0.224f
Cc_dac_soft_7___vref dac_soft_7_ vref 0.021f
Cc_dac_soft_7___vref_buf dac_soft_7_ vref_buf 0.03f
Cc_fast_en__osc_clk fast_en osc_clk 2.635f
Cc_fast_en__osc_en fast_en osc_en 0.088f
Cc_fast_en__osc_trim_3_ fast_en osc_trim_3_ 0.23f
Cc_fast_en__t2f_en_12 fast_en t2f_en_12 0.044f
Cc_fast_en__t2f_mode_12 fast_en t2f_mode_12 0.028f
Cc_fast_en__trip_d fast_en trip_d 2.405f
Cc_iptat__isense iptat isense 10.98f
Cc_iptat__osc_clk iptat osc_clk 0.032f
Cc_iptat__osc_en iptat osc_en 0.025f
Cc_iptat__osc_trim_0_ iptat osc_trim_0_ 0.022f
Cc_iptat__osc_trim_1_ iptat osc_trim_1_ 0.025f
Cc_iptat__osc_trim_2_ iptat osc_trim_2_ 0.044f
Cc_iptat__osc_trim_3_ iptat osc_trim_3_ 0.025f
Cc_iptat__pbias iptat pbias 0.371f
Cc_iptat__sdo_o iptat sdo_o 0.058f
Cc_iptat__t2f_en_33 iptat t2f_en_33 0.018f
Cc_iptat__t2f_mode_33 iptat t2f_mode_33 0.018f
Cc_iptat__tripped iptat tripped 0.019f
Cc_iptat__vref iptat vref 0.453f
Cc_iptat__vref_buf iptat vref_buf 0.286f
Cc_iptat__net iptat net 0.024f
Cc_isense__pbias isense pbias 0.051f
Cc_isense__t2f_en_33 isense t2f_en_33 0.016f
Cc_isense__t2f_mode_33 isense t2f_mode_33 0.016f
Cc_isense__tripped isense tripped 0.016f
Cc_isense__vref isense vref 0.029f
Cc_isense__vref_buf isense vref_buf 27.86f
Cc_isense__net isense net 0.022f
Cc_osc_clk__osc_en osc_clk osc_en 14.97f
Cc_osc_clk__osc_trim_0_ osc_clk osc_trim_0_ 0.051f
Cc_osc_clk__osc_trim_1_ osc_clk osc_trim_1_ 14.99f
Cc_osc_clk__osc_trim_2_ osc_clk osc_trim_2_ 2.807f
Cc_osc_clk__osc_trim_3_ osc_clk osc_trim_3_ 27.85f
Cc_osc_clk__pbias osc_clk pbias 0.034f
Cc_osc_clk__pcasc osc_clk pcasc 0.03f
Cc_osc_clk__sdi_i osc_clk sdi_i 1.692f
Cc_osc_clk__sdo_o osc_clk sdo_o 0.13f
Cc_osc_clk__t2f_en_12 osc_clk t2f_en_12 0.201f
Cc_osc_clk__t2f_mode_12 osc_clk t2f_mode_12 0.124f
Cc_osc_clk__trip_d osc_clk trip_d 7.394f
Cc_osc_clk__tripped osc_clk tripped 0.426f
Cc_osc_clk__vref osc_clk vref 38.31f
Cc_osc_clk__net osc_clk net 0.069f
Cc_osc_en__osc_trim_0_ osc_en osc_trim_0_ 0.243f
Cc_osc_en__osc_trim_1_ osc_en osc_trim_1_ 6.287f
Cc_osc_en__osc_trim_2_ osc_en osc_trim_2_ 0.392f
Cc_osc_en__osc_trim_3_ osc_en osc_trim_3_ 50.65f
Cc_osc_en__pbias osc_en pbias 0.025f
Cc_osc_en__pcasc osc_en pcasc 0.022f
Cc_osc_en__sdi_i osc_en sdi_i 0.03f
Cc_osc_en__sdo_o osc_en sdo_o 0.205f
Cc_osc_en__t2f_en_12 osc_en t2f_en_12 0.03f
Cc_osc_en__t2f_mode_12 osc_en t2f_mode_12 0.03f
Cc_osc_en__trip_d osc_en trip_d 0.025f
Cc_osc_en__tripped osc_en tripped 0.085f
Cc_osc_en__vref osc_en vref 0.047f
Cc_osc_en__net osc_en net 0.316f
Cc_osc_trim_0___osc_trim_1_ osc_trim_0_ osc_trim_1_ 46.47f
Cc_osc_trim_0___osc_trim_2_ osc_trim_0_ osc_trim_2_ 1.495f
Cc_osc_trim_0___osc_trim_3_ osc_trim_0_ osc_trim_3_ 0.071f
Cc_osc_trim_0___pbias osc_trim_0_ pbias 0.022f
Cc_osc_trim_0___pcasc osc_trim_0_ pcasc 0.539f
Cc_osc_trim_0___sdi_i osc_trim_0_ sdi_i 0.042f
Cc_osc_trim_0___sdo_o osc_trim_0_ sdo_o 0.956f
Cc_osc_trim_0___tripped osc_trim_0_ tripped 0.053f
Cc_osc_trim_0___vref osc_trim_0_ vref 27.42f
Cc_osc_trim_0___net osc_trim_0_ net 0.022f
Cc_osc_trim_1___osc_trim_2_ osc_trim_1_ osc_trim_2_ 0.208f
Cc_osc_trim_1___osc_trim_3_ osc_trim_1_ osc_trim_3_ 11.28f
Cc_osc_trim_1___pbias osc_trim_1_ pbias 0.024f
Cc_osc_trim_1___pcasc osc_trim_1_ pcasc 0.023f
Cc_osc_trim_1___sdi_i osc_trim_1_ sdi_i 0.031f
Cc_osc_trim_1___sdo_o osc_trim_1_ sdo_o 0.365f
Cc_osc_trim_1___t2f_en_12 osc_trim_1_ t2f_en_12 0.22f
Cc_osc_trim_1___t2f_mode_12 osc_trim_1_ t2f_mode_12 0.057f
Cc_osc_trim_1___trip_d osc_trim_1_ trip_d 3.958f
Cc_osc_trim_1___tripped osc_trim_1_ tripped 0.386f
Cc_osc_trim_1___vref osc_trim_1_ vref 12.77f
Cc_osc_trim_1___net osc_trim_1_ net 0.429f
Cc_osc_trim_2___osc_trim_3_ osc_trim_2_ osc_trim_3_ 0.344f
Cc_osc_trim_2___pbias osc_trim_2_ pbias 13.41f
Cc_osc_trim_2___pcasc osc_trim_2_ pcasc 0.026f
Cc_osc_trim_2___sdi_i osc_trim_2_ sdi_i 0.038f
Cc_osc_trim_2___tripped osc_trim_2_ tripped 0.046f
Cc_osc_trim_2___vref osc_trim_2_ vref 0.065f
Cc_osc_trim_2___vref_buf osc_trim_2_ vref_buf 1.246f
Cc_osc_trim_2___net osc_trim_2_ net 0.039f
Cc_osc_trim_3___pbias osc_trim_3_ pbias 0.025f
Cc_osc_trim_3___pcasc osc_trim_3_ pcasc 0.019f
Cc_osc_trim_3___sdi_i osc_trim_3_ sdi_i 0.026f
Cc_osc_trim_3___sdo_o osc_trim_3_ sdo_o 0.266f
Cc_osc_trim_3___t2f_en_12 osc_trim_3_ t2f_en_12 0.023f
Cc_osc_trim_3___t2f_mode_12 osc_trim_3_ t2f_mode_12 0.023f
Cc_osc_trim_3___trip_d osc_trim_3_ trip_d 0.02f
Cc_osc_trim_3___tripped osc_trim_3_ tripped 0.43f
Cc_osc_trim_3___vref osc_trim_3_ vref 12.76f
Cc_osc_trim_3___net osc_trim_3_ net 6.539f
Cc_pbias__pcasc pbias pcasc 72.46f
Cc_pbias__sdi_i pbias sdi_i 0.646f
Cc_pbias__sdo_o pbias sdo_o 0.049f
Cc_pbias__t2f_en_33 pbias t2f_en_33 0.126f
Cc_pbias__t2f_mode_33 pbias t2f_mode_33 3.002f
Cc_pbias__vref pbias vref 38.83f
Cc_pbias__vref_buf pbias vref_buf 0.195f
Cc_pcasc__sdi_i pcasc sdi_i 0.091f
Cc_pcasc__sdo_o pcasc sdo_o 0.376f
Cc_pcasc__t2f_en_33 pcasc t2f_en_33 0.321f
Cc_pcasc__t2f_mode_33 pcasc t2f_mode_33 0.076f
Cc_pcasc__vref pcasc vref 0.52f
Cc_sclk_i__sdi_i sclk_i sdi_i 49.07f
Cc_sdi_i__sdo_o sdi_i sdo_o 0.859f
Cc_sdi_i__tripped sdi_i tripped 0.013f
Cc_sdi_i__vref sdi_i vref 0.146f
Cc_sdo_o__vref sdo_o vref 1.256f
Cc_t2f_en_12__t2f_mode_12 t2f_en_12 t2f_mode_12 16.9f
Cc_t2f_en_12__trip_d t2f_en_12 trip_d 0.104f
Cc_t2f_en_12__tripped t2f_en_12 tripped 6.417f
Cc_t2f_en_12__net t2f_en_12 net 0.016f
Cc_t2f_en_33__t2f_mode_12 t2f_en_33 t2f_mode_12 6.328f
Cc_t2f_en_33__t2f_mode_33 t2f_en_33 t2f_mode_33 81.21f
Cc_t2f_en_33__temp_out_o t2f_en_33 temp_out_o 0.502f
Cc_t2f_en_33__tripped t2f_en_33 tripped 0.417f
Cc_t2f_en_33__vref t2f_en_33 vref 0.033f
Cc_t2f_en_33__vref_buf t2f_en_33 vref_buf 0.024f
Cc_t2f_en_33__net t2f_en_33 net 55.28f
Cc_t2f_mode_12__trip_d t2f_mode_12 trip_d 0.031f
Cc_t2f_mode_12__tripped t2f_mode_12 tripped 0.027f
Cc_t2f_mode_33__tripped t2f_mode_33 tripped 51.43f
Cc_t2f_mode_33__vref t2f_mode_33 vref 0.034f
Cc_t2f_mode_33__vref_buf t2f_mode_33 vref_buf 0.024f
Cc_t2f_mode_33__net t2f_mode_33 net 0.027f
Cc_temp_out_o__vref temp_out_o vref 0.032f
Cc_trip_d__tripped trip_d tripped 0.174f
Cc_tripped__vref tripped vref 0.037f
Cc_tripped__vref_buf tripped vref_buf 0.024f
Cc_tripped__net tripped net 2.804f
Cc_vref__vref_buf vref vref_buf 0.037f
Cc_vref__net vref net 0.666f
Cc_vref_buf__net vref_buf net 0.03f
.ends g1_top_interconnect_pi
