* g1_top_interconnect_rc: distributed RC of the top-level routing of g1_chip_top (r4), element lines for the
* body of the deck-local g1_chip_top (run_top_cdl.py --interconnect extracted-rc; pin renames in the map JSON).
* R: KLayout RNetExtractor (square counting, kpex ihp-sg13g2 sheet/via tables) on the fill-free top-interconnect view,
* Kron-reduced onto the pin nodes of each network fragment (exact at DC).
* C: kpex 0.3.12 2.5D CC on the same view. Extracted, not measured. Inputs (sha256): rnet 301534952b2a0685, csv d8cc7ac616bcf039.
* 348 resistors, 4825 capacitors; 14 network components tied to their net node (see map JSON).
Rtic0 D_ELT D_ELT__Xi_core_u_dose 374.929
Rtic1 D_STD D_STD__Xi_core_u_dose 321.139
Rtic2 G_SHARED G_SHARED__Xi_core_u_dose 272.64
Rtic3 HBT_B HBT_B__Xi_core_u_dut 449.655
Rtic4 HBT_C HBT_C__Xi_core_u_dut 497.912
Rtic5 HBT_E HBT_E__Xi_core_u_dut 201.284
Rtic6 SENSE_N SENSE_N__Xi_core_u_sense 104.88
Rtic7 SENSE_P SENSE_P__Xi_core_u_sense 169.719
Rtic8 VDDA VDDA__Xi_core_u_gate 564.792
Rtic9 VDDA VDDA__Xi_core_u_ls_en 5787.28
Rtic10 VDDA VDDA__Xi_core_u_ls_mode 2668.74
Rtic11 VDDA VDDA__Xi_core_u_ls_r4 4272.59
Rtic12 VDDA VDDA__Xi_core_u_sense 3.93395
Rtic13 VDDA VDDA__Xi_core_u_t2f 26.2252
Rtic14 VDDA VDDA__Xi_core_u_trip 9.23888
Rtic15 VDDA__Xi_core_u_gate VDDA__Xi_core_u_ls_en 199.932
Rtic16 VDDA__Xi_core_u_gate VDDA__Xi_core_u_ls_mode 92.1966
Rtic17 VDDA__Xi_core_u_gate VDDA__Xi_core_u_ls_r4 147.605
Rtic18 VDDA__Xi_core_u_gate VDDA__Xi_core_u_sense 8.11048
Rtic19 VDDA__Xi_core_u_gate VDDA__Xi_core_u_t2f 2822.78
Rtic20 VDDA__Xi_core_u_gate VDDA__Xi_core_u_trip 994.439
Rtic21 VDDA__Xi_core_u_ls_en VDDA__Xi_core_u_ls_mode 37.8239
Rtic22 VDDA__Xi_core_u_ls_en VDDA__Xi_core_u_ls_r4 24.0535
Rtic23 VDDA__Xi_core_u_ls_en VDDA__Xi_core_u_sense 83.106
Rtic24 VDDA__Xi_core_u_ls_en VDDA__Xi_core_u_t2f 28924.3
Rtic25 VDDA__Xi_core_u_ls_en VDDA__Xi_core_u_trip 10189.7
Rtic26 VDDA__Xi_core_u_ls_mode VDDA__Xi_core_u_ls_r4 27.9243
Rtic27 VDDA__Xi_core_u_ls_mode VDDA__Xi_core_u_sense 38.3234
Rtic28 VDDA__Xi_core_u_ls_mode VDDA__Xi_core_u_t2f 13338.1
Rtic29 VDDA__Xi_core_u_ls_mode VDDA__Xi_core_u_trip 4698.88
Rtic30 VDDA__Xi_core_u_ls_r4 VDDA__Xi_core_u_sense 61.3549
Rtic31 VDDA__Xi_core_u_ls_r4 VDDA__Xi_core_u_t2f 21354
Rtic32 VDDA__Xi_core_u_ls_r4 VDDA__Xi_core_u_trip 7522.81
Rtic33 VDDA__Xi_core_u_sense VDDA__Xi_core_u_t2f 19.6615
Rtic34 VDDA__Xi_core_u_sense VDDA__Xi_core_u_trip 6.92657
Rtic35 VDDA__Xi_core_u_t2f VDDA__Xi_core_u_trip 9.49374
Rtic36 VDD VDD__Xi_core_u_digital 4.03031
Rtic37 VDD VDD__Xi_core_u_digital_1 83.9647
Rtic38 VDD VDD__Xi_core_u_gate 11.5666
Rtic39 VDD VDD__Xi_core_u_ls_en 88.861
Rtic40 VDD VDD__Xi_core_u_ls_mode 105.803
Rtic41 VDD VDD__Xi_core_u_ls_r4 77.441
Rtic42 VDD VDD__Xi_core_u_osc 13.1358
Rtic43 VDD VDD__Xi_core_u_t2f 10.6124
Rtic44 VDD VDD__Xi_core_u_trip 8.9579
Rtic45 VDD VDD__retained_fullchip_sg13g2_antennanp_1020_000_891_000 58.665
Rtic46 VDD__Xi_core_u_digital VDD__Xi_core_u_digital_1 211.54
Rtic47 VDD__Xi_core_u_digital VDD__Xi_core_u_gate 29.219
Rtic48 VDD__Xi_core_u_digital VDD__Xi_core_u_ls_en 224.557
Rtic49 VDD__Xi_core_u_digital VDD__Xi_core_u_ls_mode 267.37
Rtic50 VDD__Xi_core_u_digital VDD__Xi_core_u_ls_r4 195.698
Rtic51 VDD__Xi_core_u_digital VDD__Xi_core_u_osc 33.0252
Rtic52 VDD__Xi_core_u_digital VDD__Xi_core_u_t2f 26.7066
Rtic53 VDD__Xi_core_u_digital VDD__Xi_core_u_trip 22.5461
Rtic54 VDD__Xi_core_u_digital VDD__retained_fullchip_sg13g2_antennanp_1020_000_891_000 147.8
Rtic55 VDD__Xi_core_u_digital_1 VDD__Xi_core_u_gate 360.873
Rtic56 VDD__Xi_core_u_digital_1 VDD__Xi_core_u_ls_en 2843.49
Rtic57 VDD__Xi_core_u_digital_1 VDD__Xi_core_u_ls_mode 3385.61
Rtic58 VDD__Xi_core_u_digital_1 VDD__Xi_core_u_ls_r4 2478.06
Rtic59 VDD__Xi_core_u_digital_1 VDD__Xi_core_u_osc 308.363
Rtic60 VDD__Xi_core_u_digital_1 VDD__Xi_core_u_t2f 182.662
Rtic61 VDD__Xi_core_u_digital_1 VDD__Xi_core_u_trip 222.996
Rtic62 VDD__Xi_core_u_digital_1 VDD__retained_fullchip_sg13g2_antennanp_1020_000_891_000 26.8162
Rtic63 VDD__Xi_core_u_gate VDD__Xi_core_u_ls_en 149.428
Rtic64 VDD__Xi_core_u_gate VDD__Xi_core_u_ls_mode 177.917
Rtic65 VDD__Xi_core_u_gate VDD__Xi_core_u_ls_r4 130.224
Rtic66 VDD__Xi_core_u_gate VDD__Xi_core_u_osc 44.7155
Rtic67 VDD__Xi_core_u_gate VDD__Xi_core_u_t2f 45.2477
Rtic68 VDD__Xi_core_u_gate VDD__Xi_core_u_trip 23.1656
Rtic69 VDD__Xi_core_u_gate VDD__retained_fullchip_sg13g2_antennanp_1020_000_891_000 252.137
Rtic70 VDD__Xi_core_u_ls_en VDD__Xi_core_u_ls_mode 37.4236
Rtic71 VDD__Xi_core_u_ls_en VDD__Xi_core_u_ls_r4 27.3918
Rtic72 VDD__Xi_core_u_ls_en VDD__Xi_core_u_osc 371.955
Rtic73 VDD__Xi_core_u_ls_en VDD__Xi_core_u_t2f 359.946
Rtic74 VDD__Xi_core_u_ls_en VDD__Xi_core_u_trip 199.045
Rtic75 VDD__Xi_core_u_ls_en VDD__retained_fullchip_sg13g2_antennanp_1020_000_891_000 1986.71
Rtic76 VDD__Xi_core_u_ls_mode VDD__Xi_core_u_ls_r4 25.9183
Rtic77 VDD__Xi_core_u_ls_mode VDD__Xi_core_u_osc 442.869
Rtic78 VDD__Xi_core_u_ls_mode VDD__Xi_core_u_t2f 428.572
Rtic79 VDD__Xi_core_u_ls_mode VDD__Xi_core_u_trip 236.993
Rtic80 VDD__Xi_core_u_ls_mode VDD__retained_fullchip_sg13g2_antennanp_1020_000_891_000 2365.48
Rtic81 VDD__Xi_core_u_ls_r4 VDD__Xi_core_u_osc 324.153
Rtic82 VDD__Xi_core_u_ls_r4 VDD__Xi_core_u_t2f 313.688
Rtic83 VDD__Xi_core_u_ls_r4 VDD__Xi_core_u_trip 173.464
Rtic84 VDD__Xi_core_u_ls_r4 VDD__retained_fullchip_sg13g2_antennanp_1020_000_891_000 1731.39
Rtic85 VDD__Xi_core_u_osc VDD__Xi_core_u_t2f 35.4156
Rtic86 VDD__Xi_core_u_osc VDD__Xi_core_u_trip 19.5153
Rtic87 VDD__Xi_core_u_osc VDD__retained_fullchip_sg13g2_antennanp_1020_000_891_000 215.449
Rtic88 VDD__Xi_core_u_t2f VDD__Xi_core_u_trip 26.0125
Rtic89 VDD__Xi_core_u_t2f VDD__retained_fullchip_sg13g2_antennanp_1020_000_891_000 127.623
Rtic90 VDD__Xi_core_u_trip VDD__retained_fullchip_sg13g2_antennanp_1020_000_891_000 155.804
Rtic91 VDD__retained_fullchip_sg13g2_antennanp_1020_000_891_000 VDD__retained_fullchip_sg13g2_antennanp_1021_440_891_000 0.36
Rtic92 VDD__retained_fullchip_sg13g2_antennanp_1021_440_891_000 VDD__retained_fullchip_sg13g2_antennanp_1022_880_891_000 0.36
Rtic93 VDD__retained_fullchip_sg13g2_antennanp_1022_880_891_000 VDD__retained_fullchip_sg13g2_antennanp_1024_320_891_000 0.36
Rtic94 VDD__retained_fullchip_sg13g2_antennanp_1024_320_891_000 VDD__retained_fullchip_sg13g2_antennanp_1025_760_891_000 0.36
Rtic95 VDD__retained_fullchip_sg13g2_antennanp_1025_760_891_000 VDD__retained_fullchip_sg13g2_antennanp_1027_200_891_000 0.36
Rtic96 VSS VSS__Xi_core_u_digital 3.30881
Rtic97 VSS VSS__Xi_core_u_digital_1 22.6018
Rtic98 VSS VSS__Xi_core_u_dose 8.00983
Rtic99 VSS VSS__Xi_core_u_dut 7.38286
Rtic100 VSS VSS__Xi_core_u_gate 6.43022
Rtic101 VSS VSS__Xi_core_u_ls_en 41.0219
Rtic102 VSS VSS__Xi_core_u_ls_mode 29.6155
Rtic103 VSS VSS__Xi_core_u_ls_r4 39.9078
Rtic104 VSS VSS__Xi_core_u_osc 15.74
Rtic105 VSS VSS__Xi_core_u_sense 4.10223
Rtic106 VSS VSS__Xi_core_u_t2f 11.2526
Rtic107 VSS VSS__Xi_core_u_trip 6.78396
Rtic108 VSS VSS__retained_fullchip_sg13g2_antennanp_1020_000_891_000 113.252
Rtic109 VSS VSS__retained_fullchip_sg13g2_antennanp_1021_440_891_000 331.013
Rtic110 VSS VSS__retained_fullchip_sg13g2_antennanp_1022_880_891_000 2126.14
Rtic111 VSS VSS__retained_fullchip_sg13g2_antennanp_1024_320_891_000 219.746
Rtic112 VSS VSS__retained_fullchip_sg13g2_antennanp_1025_760_891_000 2058.9
Rtic113 VSS VSS__retained_fullchip_sg13g2_antennanp_1027_200_891_000 71.9113
Rtic114 VSS__Xi_core_u_digital VSS__Xi_core_u_digital_1 190.248
Rtic115 VSS__Xi_core_u_digital VSS__Xi_core_u_dose 74.2161
Rtic116 VSS__Xi_core_u_digital VSS__Xi_core_u_dut 69.1085
Rtic117 VSS__Xi_core_u_digital VSS__Xi_core_u_gate 57.1172
Rtic118 VSS__Xi_core_u_digital VSS__Xi_core_u_ls_en 375.752
Rtic119 VSS__Xi_core_u_digital VSS__Xi_core_u_ls_mode 270.54
Rtic120 VSS__Xi_core_u_digital VSS__Xi_core_u_ls_r4 365.028
Rtic121 VSS__Xi_core_u_digital VSS__Xi_core_u_osc 127.856
Rtic122 VSS__Xi_core_u_digital VSS__Xi_core_u_sense 34.9637
Rtic123 VSS__Xi_core_u_digital VSS__Xi_core_u_t2f 93.5163
Rtic124 VSS__Xi_core_u_digital VSS__Xi_core_u_trip 58.8889
Rtic125 VSS__Xi_core_u_digital VSS__retained_fullchip_sg13g2_antennanp_1020_000_891_000 952.586
Rtic126 VSS__Xi_core_u_digital VSS__retained_fullchip_sg13g2_antennanp_1021_440_891_000 2784.21
Rtic127 VSS__Xi_core_u_digital VSS__retained_fullchip_sg13g2_antennanp_1022_880_891_000 17883.4
Rtic128 VSS__Xi_core_u_digital VSS__retained_fullchip_sg13g2_antennanp_1024_320_891_000 1848.33
Rtic129 VSS__Xi_core_u_digital VSS__retained_fullchip_sg13g2_antennanp_1025_760_891_000 17317.8
Rtic130 VSS__Xi_core_u_digital VSS__retained_fullchip_sg13g2_antennanp_1027_200_891_000 604.86
Rtic131 VSS__Xi_core_u_digital_1 VSS__Xi_core_u_dose 246.107
Rtic132 VSS__Xi_core_u_digital_1 VSS__Xi_core_u_dut 239.847
Rtic133 VSS__Xi_core_u_digital_1 VSS__Xi_core_u_gate 151.273
Rtic134 VSS__Xi_core_u_digital_1 VSS__Xi_core_u_ls_en 1159.43
Rtic135 VSS__Xi_core_u_digital_1 VSS__Xi_core_u_ls_mode 802.153
Rtic136 VSS__Xi_core_u_digital_1 VSS__Xi_core_u_ls_r4 1102.74
Rtic137 VSS__Xi_core_u_digital_1 VSS__Xi_core_u_osc 260.309
Rtic138 VSS__Xi_core_u_digital_1 VSS__Xi_core_u_sense 86.1787
Rtic139 VSS__Xi_core_u_digital_1 VSS__Xi_core_u_t2f 134.773
Rtic140 VSS__Xi_core_u_digital_1 VSS__Xi_core_u_trip 98.2672
Rtic141 VSS__Xi_core_u_digital_1 VSS__retained_fullchip_sg13g2_antennanp_1020_000_891_000 1425.67
Rtic142 VSS__Xi_core_u_digital_1 VSS__retained_fullchip_sg13g2_antennanp_1021_440_891_000 4166.93
Rtic143 VSS__Xi_core_u_digital_1 VSS__retained_fullchip_sg13g2_antennanp_1022_880_891_000 26764.7
Rtic144 VSS__Xi_core_u_digital_1 VSS__retained_fullchip_sg13g2_antennanp_1024_320_891_000 2766.25
Rtic145 VSS__Xi_core_u_digital_1 VSS__retained_fullchip_sg13g2_antennanp_1025_760_891_000 25918.3
Rtic146 VSS__Xi_core_u_digital_1 VSS__retained_fullchip_sg13g2_antennanp_1027_200_891_000 905.25
Rtic147 VSS__Xi_core_u_dose VSS__Xi_core_u_dut 20.7602
Rtic148 VSS__Xi_core_u_dose VSS__Xi_core_u_gate 67.8024
Rtic149 VSS__Xi_core_u_dose VSS__Xi_core_u_ls_en 123.117
Rtic150 VSS__Xi_core_u_dose VSS__Xi_core_u_ls_mode 203.01
Rtic151 VSS__Xi_core_u_dose VSS__Xi_core_u_ls_r4 169.991
Rtic152 VSS__Xi_core_u_dose VSS__Xi_core_u_osc 168.333
Rtic153 VSS__Xi_core_u_dose VSS__Xi_core_u_sense 12.8441
Rtic154 VSS__Xi_core_u_dose VSS__Xi_core_u_t2f 122.319
Rtic155 VSS__Xi_core_u_dose VSS__Xi_core_u_trip 74.1681
Rtic156 VSS__Xi_core_u_dose VSS__retained_fullchip_sg13g2_antennanp_1020_000_891_000 1233.06
Rtic157 VSS__Xi_core_u_dose VSS__retained_fullchip_sg13g2_antennanp_1021_440_891_000 3603.99
Rtic158 VSS__Xi_core_u_dose VSS__retained_fullchip_sg13g2_antennanp_1022_880_891_000 23148.9
Rtic159 VSS__Xi_core_u_dose VSS__retained_fullchip_sg13g2_antennanp_1024_320_891_000 2392.54
Rtic160 VSS__Xi_core_u_dose VSS__retained_fullchip_sg13g2_antennanp_1025_760_891_000 22416.9
Rtic161 VSS__Xi_core_u_dose VSS__retained_fullchip_sg13g2_antennanp_1027_200_891_000 782.954
Rtic162 VSS__Xi_core_u_dut VSS__Xi_core_u_gate 64.8893
Rtic163 VSS__Xi_core_u_dut VSS__Xi_core_u_ls_en 152.987
Rtic164 VSS__Xi_core_u_dut VSS__Xi_core_u_ls_mode 217.203
Rtic165 VSS__Xi_core_u_dut VSS__Xi_core_u_ls_r4 200.657
Rtic166 VSS__Xi_core_u_dut VSS__Xi_core_u_osc 168.337
Rtic167 VSS__Xi_core_u_dut VSS__Xi_core_u_sense 16.0982
Rtic168 VSS__Xi_core_u_dut VSS__Xi_core_u_t2f 120.13
Rtic169 VSS__Xi_core_u_dut VSS__Xi_core_u_trip 70.9859
Rtic170 VSS__Xi_core_u_dut VSS__retained_fullchip_sg13g2_antennanp_1020_000_891_000 1202.23
Rtic171 VSS__Xi_core_u_dut VSS__retained_fullchip_sg13g2_antennanp_1021_440_891_000 3513.85
Rtic172 VSS__Xi_core_u_dut VSS__retained_fullchip_sg13g2_antennanp_1022_880_891_000 22570
Rtic173 VSS__Xi_core_u_dut VSS__retained_fullchip_sg13g2_antennanp_1024_320_891_000 2332.71
Rtic174 VSS__Xi_core_u_dut VSS__retained_fullchip_sg13g2_antennanp_1025_760_891_000 21856.2
Rtic175 VSS__Xi_core_u_dut VSS__retained_fullchip_sg13g2_antennanp_1027_200_891_000 763.372
Rtic176 VSS__Xi_core_u_gate VSS__Xi_core_u_ls_en 152.37
Rtic177 VSS__Xi_core_u_gate VSS__Xi_core_u_ls_mode 64.5951
Rtic178 VSS__Xi_core_u_gate VSS__Xi_core_u_ls_r4 108.246
Rtic179 VSS__Xi_core_u_gate VSS__Xi_core_u_osc 41.3063
Rtic180 VSS__Xi_core_u_gate VSS__Xi_core_u_sense 29.2045
Rtic181 VSS__Xi_core_u_gate VSS__Xi_core_u_t2f 73.5093
Rtic182 VSS__Xi_core_u_gate VSS__Xi_core_u_trip 48.198
Rtic183 VSS__Xi_core_u_gate VSS__retained_fullchip_sg13g2_antennanp_1020_000_891_000 756.931
Rtic184 VSS__Xi_core_u_gate VSS__retained_fullchip_sg13g2_antennanp_1021_440_891_000 2212.35
Rtic185 VSS__Xi_core_u_gate VSS__retained_fullchip_sg13g2_antennanp_1022_880_891_000 14210.2
Rtic186 VSS__Xi_core_u_gate VSS__retained_fullchip_sg13g2_antennanp_1024_320_891_000 1468.69
Rtic187 VSS__Xi_core_u_gate VSS__retained_fullchip_sg13g2_antennanp_1025_760_891_000 13760.9
Rtic188 VSS__Xi_core_u_gate VSS__retained_fullchip_sg13g2_antennanp_1027_200_891_000 480.626
Rtic189 VSS__Xi_core_u_ls_en VSS__Xi_core_u_ls_mode 79.7683
Rtic190 VSS__Xi_core_u_ls_en VSS__Xi_core_u_ls_r4 42.3952
Rtic191 VSS__Xi_core_u_ls_en VSS__Xi_core_u_osc 566.31
Rtic192 VSS__Xi_core_u_ls_en VSS__Xi_core_u_sense 73.6145
Rtic193 VSS__Xi_core_u_ls_en VSS__Xi_core_u_t2f 572.694
Rtic194 VSS__Xi_core_u_ls_en VSS__Xi_core_u_trip 354.645
Rtic195 VSS__Xi_core_u_ls_en VSS__retained_fullchip_sg13g2_antennanp_1020_000_891_000 5806.98
Rtic196 VSS__Xi_core_u_ls_en VSS__retained_fullchip_sg13g2_antennanp_1021_440_891_000 16972.6
Rtic197 VSS__Xi_core_u_ls_en VSS__retained_fullchip_sg13g2_antennanp_1022_880_891_000 109017
Rtic198 VSS__Xi_core_u_ls_en VSS__retained_fullchip_sg13g2_antennanp_1024_320_891_000 11267.4
Rtic199 VSS__Xi_core_u_ls_en VSS__retained_fullchip_sg13g2_antennanp_1025_760_891_000 105570
Rtic200 VSS__Xi_core_u_ls_en VSS__retained_fullchip_sg13g2_antennanp_1027_200_891_000 3687.23
Rtic201 VSS__Xi_core_u_ls_mode VSS__Xi_core_u_ls_r4 47.9682
Rtic202 VSS__Xi_core_u_ls_mode VSS__Xi_core_u_osc 296.243
Rtic203 VSS__Xi_core_u_ls_mode VSS__Xi_core_u_sense 107.886
Rtic204 VSS__Xi_core_u_ls_mode VSS__Xi_core_u_t2f 396.321
Rtic205 VSS__Xi_core_u_ls_mode VSS__Xi_core_u_trip 245.211
Rtic206 VSS__Xi_core_u_ls_mode VSS__retained_fullchip_sg13g2_antennanp_1020_000_891_000 4017.63
Rtic207 VSS__Xi_core_u_ls_mode VSS__retained_fullchip_sg13g2_antennanp_1021_440_891_000 11742.7
Rtic208 VSS__Xi_core_u_ls_mode VSS__retained_fullchip_sg13g2_antennanp_1022_880_891_000 75425
Rtic209 VSS__Xi_core_u_ls_mode VSS__retained_fullchip_sg13g2_antennanp_1024_320_891_000 7795.51
Rtic210 VSS__Xi_core_u_ls_mode VSS__retained_fullchip_sg13g2_antennanp_1025_760_891_000 73039.8
Rtic211 VSS__Xi_core_u_ls_mode VSS__retained_fullchip_sg13g2_antennanp_1027_200_891_000 2551.06
Rtic212 VSS__Xi_core_u_ls_r4 VSS__Xi_core_u_osc 459.209
Rtic213 VSS__Xi_core_u_ls_r4 VSS__Xi_core_u_sense 97.6521
Rtic214 VSS__Xi_core_u_ls_r4 VSS__Xi_core_u_t2f 544.765
Rtic215 VSS__Xi_core_u_ls_r4 VSS__Xi_core_u_trip 337.192
Rtic216 VSS__Xi_core_u_ls_r4 VSS__retained_fullchip_sg13g2_antennanp_1020_000_891_000 5523.08
Rtic217 VSS__Xi_core_u_ls_r4 VSS__retained_fullchip_sg13g2_antennanp_1021_440_891_000 16142.8
Rtic218 VSS__Xi_core_u_ls_r4 VSS__retained_fullchip_sg13g2_antennanp_1022_880_891_000 103687
Rtic219 VSS__Xi_core_u_ls_r4 VSS__retained_fullchip_sg13g2_antennanp_1024_320_891_000 10716.6
Rtic220 VSS__Xi_core_u_ls_r4 VSS__retained_fullchip_sg13g2_antennanp_1025_760_891_000 100408
Rtic221 VSS__Xi_core_u_ls_r4 VSS__retained_fullchip_sg13g2_antennanp_1027_200_891_000 3506.97
Rtic222 VSS__Xi_core_u_osc VSS__Xi_core_u_sense 52.9815
Rtic223 VSS__Xi_core_u_osc VSS__Xi_core_u_t2f 122.165
Rtic224 VSS__Xi_core_u_osc VSS__Xi_core_u_trip 91.2439
Rtic225 VSS__Xi_core_u_osc VSS__retained_fullchip_sg13g2_antennanp_1020_000_891_000 1299.83
Rtic226 VSS__Xi_core_u_osc VSS__retained_fullchip_sg13g2_antennanp_1021_440_891_000 3799.12
Rtic227 VSS__Xi_core_u_osc VSS__retained_fullchip_sg13g2_antennanp_1022_880_891_000 24402.3
Rtic228 VSS__Xi_core_u_osc VSS__retained_fullchip_sg13g2_antennanp_1024_320_891_000 2522.08
Rtic229 VSS__Xi_core_u_osc VSS__retained_fullchip_sg13g2_antennanp_1025_760_891_000 23630.6
Rtic230 VSS__Xi_core_u_osc VSS__retained_fullchip_sg13g2_antennanp_1027_200_891_000 825.345
Rtic231 VSS__Xi_core_u_sense VSS__Xi_core_u_t2f 41.0765
Rtic232 VSS__Xi_core_u_sense VSS__Xi_core_u_trip 28.9056
Rtic233 VSS__Xi_core_u_sense VSS__retained_fullchip_sg13g2_antennanp_1020_000_891_000 430.724
Rtic234 VSS__Xi_core_u_sense VSS__retained_fullchip_sg13g2_antennanp_1021_440_891_000 1258.92
Rtic235 VSS__Xi_core_u_sense VSS__retained_fullchip_sg13g2_antennanp_1022_880_891_000 8086.2
Rtic236 VSS__Xi_core_u_sense VSS__retained_fullchip_sg13g2_antennanp_1024_320_891_000 835.745
Rtic237 VSS__Xi_core_u_sense VSS__retained_fullchip_sg13g2_antennanp_1025_760_891_000 7830.49
Rtic238 VSS__Xi_core_u_sense VSS__retained_fullchip_sg13g2_antennanp_1027_200_891_000 273.495
Rtic239 VSS__Xi_core_u_t2f VSS__Xi_core_u_trip 18.7475
Rtic240 VSS__Xi_core_u_t2f VSS__retained_fullchip_sg13g2_antennanp_1020_000_891_000 226.651
Rtic241 VSS__Xi_core_u_t2f VSS__retained_fullchip_sg13g2_antennanp_1021_440_891_000 662.453
Rtic242 VSS__Xi_core_u_t2f VSS__retained_fullchip_sg13g2_antennanp_1022_880_891_000 4255.03
Rtic243 VSS__Xi_core_u_t2f VSS__retained_fullchip_sg13g2_antennanp_1024_320_891_000 439.776
Rtic244 VSS__Xi_core_u_t2f VSS__retained_fullchip_sg13g2_antennanp_1025_760_891_000 4120.47
Rtic245 VSS__Xi_core_u_t2f VSS__retained_fullchip_sg13g2_antennanp_1027_200_891_000 143.915
Rtic246 VSS__Xi_core_u_trip VSS__retained_fullchip_sg13g2_antennanp_1020_000_891_000 154.035
Rtic247 VSS__Xi_core_u_trip VSS__retained_fullchip_sg13g2_antennanp_1021_440_891_000 450.213
Rtic248 VSS__Xi_core_u_trip VSS__retained_fullchip_sg13g2_antennanp_1022_880_891_000 2891.78
Rtic249 VSS__Xi_core_u_trip VSS__retained_fullchip_sg13g2_antennanp_1024_320_891_000 298.878
Rtic250 VSS__Xi_core_u_trip VSS__retained_fullchip_sg13g2_antennanp_1025_760_891_000 2800.33
Rtic251 VSS__Xi_core_u_trip VSS__retained_fullchip_sg13g2_antennanp_1027_200_891_000 97.8071
Rtic252 VSS__retained_fullchip_sg13g2_antennanp_1020_000_891_000 VSS__retained_fullchip_sg13g2_antennanp_1021_440_891_000 0.357966
Rtic253 VSS__retained_fullchip_sg13g2_antennanp_1020_000_891_000 VSS__retained_fullchip_sg13g2_antennanp_1022_880_891_000 159.494
Rtic254 VSS__retained_fullchip_sg13g2_antennanp_1020_000_891_000 VSS__retained_fullchip_sg13g2_antennanp_1024_320_891_000 16.9909
Rtic255 VSS__retained_fullchip_sg13g2_antennanp_1020_000_891_000 VSS__retained_fullchip_sg13g2_antennanp_1025_760_891_000 164.077
Rtic256 VSS__retained_fullchip_sg13g2_antennanp_1020_000_891_000 VSS__retained_fullchip_sg13g2_antennanp_1027_200_891_000 9.73364
Rtic257 VSS__retained_fullchip_sg13g2_antennanp_1021_440_891_000 VSS__retained_fullchip_sg13g2_antennanp_1022_880_891_000 0.359722
Rtic258 VSS__retained_fullchip_sg13g2_antennanp_1021_440_891_000 VSS__retained_fullchip_sg13g2_antennanp_1024_320_891_000 49.6607
Rtic259 VSS__retained_fullchip_sg13g2_antennanp_1021_440_891_000 VSS__retained_fullchip_sg13g2_antennanp_1025_760_891_000 479.562
Rtic260 VSS__retained_fullchip_sg13g2_antennanp_1021_440_891_000 VSS__retained_fullchip_sg13g2_antennanp_1027_200_891_000 28.4494
Rtic261 VSS__retained_fullchip_sg13g2_antennanp_1022_880_891_000 VSS__retained_fullchip_sg13g2_antennanp_1024_320_891_000 0.361655
Rtic262 VSS__retained_fullchip_sg13g2_antennanp_1022_880_891_000 VSS__retained_fullchip_sg13g2_antennanp_1025_760_891_000 3080.29
Rtic263 VSS__retained_fullchip_sg13g2_antennanp_1022_880_891_000 VSS__retained_fullchip_sg13g2_antennanp_1027_200_891_000 182.734
Rtic264 VSS__retained_fullchip_sg13g2_antennanp_1024_320_891_000 VSS__retained_fullchip_sg13g2_antennanp_1025_760_891_000 0.361655
Rtic265 VSS__retained_fullchip_sg13g2_antennanp_1024_320_891_000 VSS__retained_fullchip_sg13g2_antennanp_1027_200_891_000 18.8864
Rtic266 VSS__retained_fullchip_sg13g2_antennanp_1025_760_891_000 VSS__retained_fullchip_sg13g2_antennanp_1027_200_891_000 0.359269
Rtic267 en_i en_i__Xi_core_u_gate 110.066
Rtic268 en_i en_i__Xpad12_en 2033.66
Rtic269 en_i en_i__retained_fullchip_sg13g2_antennanp_1020_000_891_000 812.67
Rtic270 en_i__Xi_core_u_gate en_i__Xpad12_en 2502.69
Rtic271 en_i__Xi_core_u_gate en_i__retained_fullchip_sg13g2_antennanp_1020_000_891_000 1000.1
Rtic272 en_i__Xpad12_en en_i__retained_fullchip_sg13g2_antennanp_1020_000_891_000 101.334
Rtic273 fault_n_o fault_n_o__Xpad11_fault_n 286.858
Rtic274 gate_o gate_o__Xpad10_gate 214.649
Rtic275 i_core_bgr_r4_12 i_core_bgr_r4_12__Xi_core_u_ls_r4 80.748
Rtic276 i_core_bgr_r4_33 i_core_bgr_r4_33__Xi_core_u_ls_r4 246.816
Rtic277 i_core_clr_d i_core_clr_d__Xi_core_u_gate 55.044
Rtic278 i_core_cmp_clk i_core_cmp_clk__Xi_core_u_trip 280.014
Rtic279 i_core_cmp_hard i_core_cmp_hard__Xi_core_u_gate 93.8483
Rtic280 i_core_cmp_hard i_core_cmp_hard__Xi_core_u_trip 807.317
Rtic281 i_core_cmp_hard__Xi_core_u_gate i_core_cmp_hard__Xi_core_u_trip 623.02
Rtic282 i_core_cmp_soft i_core_cmp_soft__Xi_core_u_trip 940.672
Rtic283 i_core_cmp_soft i_core_cmp_soft__retained_fullchip_sg13g2_antennanp_1021_440_891_000 1840.6
Rtic284 i_core_cmp_soft i_core_cmp_soft__retained_fullchip_sg13g2_antennanp_1022_880_891_000 1905.16
Rtic285 i_core_cmp_soft__Xi_core_u_trip i_core_cmp_soft__retained_fullchip_sg13g2_antennanp_1021_440_891_000 108.066
Rtic286 i_core_cmp_soft__Xi_core_u_trip i_core_cmp_soft__retained_fullchip_sg13g2_antennanp_1022_880_891_000 111.856
Rtic287 i_core_cmp_soft__retained_fullchip_sg13g2_antennanp_1021_440_891_000 i_core_cmp_soft__retained_fullchip_sg13g2_antennanp_1022_880_891_000 44.6682
Rtic288 i_core_dac_hard_0_ i_core_dac_hard_0___Xi_core_u_trip 209.787
Rtic289 i_core_dac_hard_1_ i_core_dac_hard_1___Xi_core_u_trip 210.906
Rtic290 i_core_dac_hard_2_ i_core_dac_hard_2___Xi_core_u_trip 246.92
Rtic291 i_core_dac_hard_3_ i_core_dac_hard_3___Xi_core_u_trip 232.521
Rtic292 i_core_dac_hard_4_ i_core_dac_hard_4___Xi_core_u_trip 221.109
Rtic293 i_core_dac_hard_5_ i_core_dac_hard_5___Xi_core_u_trip 222.639
Rtic294 i_core_dac_hard_6_ i_core_dac_hard_6___Xi_core_u_trip 221.558
Rtic295 i_core_dac_hard_7_ i_core_dac_hard_7___Xi_core_u_trip 209.186
Rtic296 i_core_dac_soft_0_ i_core_dac_soft_0___Xi_core_u_trip 107.508
Rtic297 i_core_dac_soft_1_ i_core_dac_soft_1___Xi_core_u_trip 127.683
Rtic298 i_core_dac_soft_2_ i_core_dac_soft_2___Xi_core_u_trip 129.333
Rtic299 i_core_dac_soft_3_ i_core_dac_soft_3___Xi_core_u_trip 126.733
Rtic300 i_core_dac_soft_4_ i_core_dac_soft_4___Xi_core_u_trip 102.062
Rtic301 i_core_dac_soft_5_ i_core_dac_soft_5___Xi_core_u_trip 103.351
Rtic302 i_core_dac_soft_6_ i_core_dac_soft_6___Xi_core_u_trip 59.9832
Rtic303 i_core_dac_soft_7_ i_core_dac_soft_7___Xi_core_u_trip 104.389
Rtic304 i_core_fast_en i_core_fast_en__Xi_core_u_gate 58.8774
Rtic305 i_core_iptat i_core_iptat__Xi_core_u_sense 156.527
Rtic306 i_core_isense i_core_isense__Xi_core_u_trip 139.513
Rtic307 i_core_osc_clk i_core_osc_clk__Xi_core_u_osc 414.681
Rtic308 i_core_osc_en i_core_osc_en__Xi_core_u_osc 243.669
Rtic309 i_core_osc_trim_0_ i_core_osc_trim_0___Xi_core_u_osc 217.896
Rtic310 i_core_osc_trim_1_ i_core_osc_trim_1___Xi_core_u_osc 242.502
Rtic311 i_core_osc_trim_2_ i_core_osc_trim_2___Xi_core_u_osc 221.205
Rtic312 i_core_osc_trim_3_ i_core_osc_trim_3___Xi_core_u_osc 246.11
Rtic313 i_core_pbias i_core_pbias__Xi_core_u_t2f 231.772
Rtic314 i_core_pcasc i_core_pcasc__Xi_core_u_t2f 230.892
Rtic315 i_core_sclk_i i_core_sclk_i__Xpad14_sclk 409.655
Rtic316 i_core_sdi_i i_core_sdi_i__Xpad15_sdi 383.341
Rtic317 i_core_sdi_i i_core_sdi_i__retained_fullchip_sg13g2_antennanp_1024_320_891_000 717894
Rtic318 i_core_sdi_i__Xpad15_sdi i_core_sdi_i__retained_fullchip_sg13g2_antennanp_1024_320_891_000 321.676
Rtic319 i_core_sdo_o i_core_sdo_o__Xpad16_sdo 69.3237
Rtic320 i_core_t2f_en_12 i_core_t2f_en_12__Xi_core_u_ls_en 57.6023
Rtic321 i_core_t2f_en_33 i_core_t2f_en_33__Xi_core_u_t2f 451.205
Rtic322 i_core_t2f_mode_12 i_core_t2f_mode_12__Xi_core_u_ls_mode 92.4571
Rtic323 i_core_t2f_mode_33 i_core_t2f_mode_33__Xi_core_u_t2f 386.19
Rtic324 i_core_temp_out_o i_core_temp_out_o__Xpad17_temp_out 126.023
Rtic325 i_core_trip_d i_core_trip_d__Xi_core_u_gate 55.695
Rtic326 i_core_tripped i_core_tripped__Xi_core_u_gate 82.4592
Rtic327 i_core_tripped i_core_tripped__retained_fullchip_sg13g2_antennanp_1027_200_891_000 96789.8
Rtic328 i_core_tripped__Xi_core_u_gate i_core_tripped__retained_fullchip_sg13g2_antennanp_1027_200_891_000 269.54
Rtic329 i_core_vref i_core_vref__Xi_core_u_sense 143.478
Rtic330 i_core_vref i_core_vref__Xpad18_vref 266.705
Rtic331 i_core_vref__Xi_core_u_sense i_core_vref__Xpad18_vref 9340.52
Rtic332 i_core_vref_buf i_core_vref_buf__Xi_core_u_trip 136.494
Rtic333 net net__Xi_core_u_digital_1 323.363
Rtic334 VDDA VDDA__Xi_core_u_bgr 0.001
Rtic335 VSS VSS__Xi_core_u_bgr 0.001
Rtic336 _nc1 _nc1__Xpad07_vdda 0.001
Rtic337 _nc2 _nc2__Xpad08_sense_p 0.001
Rtic338 _nc3 _nc3__Xpad09_sense_n 0.001
Rtic339 _nc4 _nc4__Xpad19_g_shared 0.001
Rtic340 _nc5 _nc5__Xpad20_d_std 0.001
Rtic341 _nc6 _nc6__Xpad21_d_elt 0.001
Rtic342 _nc7 _nc7__Xpad22_hbt_e 0.001
Rtic343 _nc8 _nc8__Xpad23_hbt_b 0.001
Rtic344 _nc9 _nc9__Xpad24_hbt_c 0.001
Rtic345 i_core_dvbe i_core_dvbe__Xi_core_u_bgr 0.001
Rtic346 i_core_trip_set i_core_trip_set__Xpad13_trip_set 0.001
Rtic347 i_core_vref i_core_vref__Xi_core_u_t2f 0.001
Ctic0 D_ELT D_STD 8.9465f
Ctic1 D_ELT G_SHARED 0.47f
Ctic2 D_ELT HBT_B 41.5105f
Ctic3 D_ELT HBT_B__Xi_core_u_dut 0.0015f
Ctic4 D_ELT HBT_C 5.1195f
Ctic5 D_ELT HBT_C__Xi_core_u_dut 0.046f
Ctic6 D_ELT HBT_E 0.015f
Ctic7 D_ELT VDD 0.281563f
Ctic8 D_ELT VDD__Xi_core_u_digital 11.7826f
Ctic9 D_ELT VDD__Xi_core_u_digital_1 0.0010625f
Ctic10 D_ELT VDD__Xi_core_u_gate 0.0010625f
Ctic11 D_ELT VDD__Xi_core_u_ls_en 0.0010625f
Ctic12 D_ELT VDD__Xi_core_u_ls_mode 0.0010625f
Ctic13 D_ELT VDD__Xi_core_u_ls_r4 0.0010625f
Ctic14 D_ELT VDD__Xi_core_u_osc 0.0010625f
Ctic15 D_ELT VDD__Xi_core_u_t2f 0.0010625f
Ctic16 D_ELT VDD__Xi_core_u_trip 0.0010625f
Ctic17 D_ELT VDD__retained_fullchip_sg13g2_antennanp_1020_000_891_000 0.0010625f
Ctic18 D_ELT VDD__retained_fullchip_sg13g2_antennanp_1021_440_891_000 0.0010625f
Ctic19 D_ELT VDD__retained_fullchip_sg13g2_antennanp_1022_880_891_000 0.0010625f
Ctic20 D_ELT VDD__retained_fullchip_sg13g2_antennanp_1024_320_891_000 0.0010625f
Ctic21 D_ELT VDD__retained_fullchip_sg13g2_antennanp_1025_760_891_000 0.0010625f
Ctic22 D_ELT VDD__retained_fullchip_sg13g2_antennanp_1027_200_891_000 0.0010625f
Ctic23 D_ELT VSS 13.4392f
Ctic24 D_ELT VSS__Xi_core_u_digital 1.89324f
Ctic25 D_ELT VSS__Xi_core_u_digital_1 0.0107368f
Ctic26 D_ELT VSS__Xi_core_u_dose 0.0107368f
Ctic27 D_ELT VSS__Xi_core_u_dut 0.0107368f
Ctic28 D_ELT VSS__Xi_core_u_gate 0.0107368f
Ctic29 D_ELT VSS__Xi_core_u_ls_en 0.0107368f
Ctic30 D_ELT VSS__Xi_core_u_ls_mode 0.0107368f
Ctic31 D_ELT VSS__Xi_core_u_ls_r4 0.0107368f
Ctic32 D_ELT VSS__Xi_core_u_osc 0.0107368f
Ctic33 D_ELT VSS__Xi_core_u_sense 0.0107368f
Ctic34 D_ELT VSS__Xi_core_u_t2f 0.0107368f
Ctic35 D_ELT VSS__Xi_core_u_trip 0.0107368f
Ctic36 D_ELT VSS__retained_fullchip_sg13g2_antennanp_1020_000_891_000 0.0107368f
Ctic37 D_ELT VSS__retained_fullchip_sg13g2_antennanp_1021_440_891_000 0.0107368f
Ctic38 D_ELT VSS__retained_fullchip_sg13g2_antennanp_1022_880_891_000 0.0107368f
Ctic39 D_ELT VSS__retained_fullchip_sg13g2_antennanp_1024_320_891_000 0.0107368f
Ctic40 D_ELT VSS__retained_fullchip_sg13g2_antennanp_1025_760_891_000 0.0107368f
Ctic41 D_ELT VSS__retained_fullchip_sg13g2_antennanp_1027_200_891_000 0.0107368f
Ctic42 D_ELT _nc6__Xpad21_d_elt 0.001f
Ctic43 D_ELT i_core_osc_clk 0.896f
Ctic44 D_ELT__Xi_core_u_dose D_STD__Xi_core_u_dose 8.9465f
Ctic45 D_ELT__Xi_core_u_dose G_SHARED__Xi_core_u_dose 0.47f
Ctic46 D_ELT__Xi_core_u_dose HBT_B__Xi_core_u_dut 41.509f
Ctic47 D_ELT__Xi_core_u_dose HBT_C__Xi_core_u_dut 5.0735f
Ctic48 D_ELT__Xi_core_u_dose HBT_E__Xi_core_u_dut 0.015f
Ctic49 D_ELT__Xi_core_u_dose VDD 0.2805f
Ctic50 D_ELT__Xi_core_u_dose VDD__Xi_core_u_ls_en 11.7815f
Ctic51 D_ELT__Xi_core_u_dose VSS 13.4285f
Ctic52 D_ELT__Xi_core_u_dose VSS__Xi_core_u_dose 1.8825f
Ctic53 D_ELT__Xi_core_u_dose _nc6__Xpad21_d_elt 0.001f
Ctic54 D_ELT__Xi_core_u_dose i_core_osc_clk 0.896f
Ctic55 D_STD G_SHARED 9.0275f
Ctic56 D_STD HBT_B 0.1805f
Ctic57 D_STD HBT_B__Xi_core_u_dut 0.0015f
Ctic58 D_STD HBT_C 0.045f
Ctic59 D_STD HBT_C__Xi_core_u_dut 55.4385f
Ctic60 D_STD HBT_E 0.0135f
Ctic61 D_STD VDD 0.295312f
Ctic62 D_STD VDD__Xi_core_u_digital 0.749813f
Ctic63 D_STD VDD__Xi_core_u_digital_1 0.0013125f
Ctic64 D_STD VDD__Xi_core_u_gate 0.0013125f
Ctic65 D_STD VDD__Xi_core_u_ls_en 0.0013125f
Ctic66 D_STD VDD__Xi_core_u_ls_mode 0.0013125f
Ctic67 D_STD VDD__Xi_core_u_ls_r4 0.0013125f
Ctic68 D_STD VDD__Xi_core_u_osc 0.0013125f
Ctic69 D_STD VDD__Xi_core_u_t2f 0.0013125f
Ctic70 D_STD VDD__Xi_core_u_trip 0.0013125f
Ctic71 D_STD VDD__retained_fullchip_sg13g2_antennanp_1020_000_891_000 0.0013125f
Ctic72 D_STD VDD__retained_fullchip_sg13g2_antennanp_1021_440_891_000 0.0013125f
Ctic73 D_STD VDD__retained_fullchip_sg13g2_antennanp_1022_880_891_000 0.0013125f
Ctic74 D_STD VDD__retained_fullchip_sg13g2_antennanp_1024_320_891_000 0.0013125f
Ctic75 D_STD VDD__retained_fullchip_sg13g2_antennanp_1025_760_891_000 0.0013125f
Ctic76 D_STD VDD__retained_fullchip_sg13g2_antennanp_1027_200_891_000 0.0013125f
Ctic77 D_STD VSS 10.2542f
Ctic78 D_STD VSS__Xi_core_u_digital 0.938684f
Ctic79 D_STD VSS__Xi_core_u_digital_1 0.0106842f
Ctic80 D_STD VSS__Xi_core_u_dose 0.0106842f
Ctic81 D_STD VSS__Xi_core_u_dut 0.0106842f
Ctic82 D_STD VSS__Xi_core_u_gate 0.0106842f
Ctic83 D_STD VSS__Xi_core_u_ls_en 0.0106842f
Ctic84 D_STD VSS__Xi_core_u_ls_mode 0.0106842f
Ctic85 D_STD VSS__Xi_core_u_ls_r4 0.0106842f
Ctic86 D_STD VSS__Xi_core_u_osc 0.0106842f
Ctic87 D_STD VSS__Xi_core_u_sense 0.0106842f
Ctic88 D_STD VSS__Xi_core_u_t2f 0.0106842f
Ctic89 D_STD VSS__Xi_core_u_trip 0.0106842f
Ctic90 D_STD VSS__retained_fullchip_sg13g2_antennanp_1020_000_891_000 0.0106842f
Ctic91 D_STD VSS__retained_fullchip_sg13g2_antennanp_1021_440_891_000 0.0106842f
Ctic92 D_STD VSS__retained_fullchip_sg13g2_antennanp_1022_880_891_000 0.0106842f
Ctic93 D_STD VSS__retained_fullchip_sg13g2_antennanp_1024_320_891_000 0.0106842f
Ctic94 D_STD VSS__retained_fullchip_sg13g2_antennanp_1025_760_891_000 0.0106842f
Ctic95 D_STD VSS__retained_fullchip_sg13g2_antennanp_1027_200_891_000 0.0106842f
Ctic96 D_STD _nc4__Xpad19_g_shared 0.0015f
Ctic97 D_STD _nc5__Xpad20_d_std 0.001f
Ctic98 D_STD i_core_osc_clk 0.06f
Ctic99 D_STD__Xi_core_u_dose G_SHARED 0.0565f
Ctic100 D_STD__Xi_core_u_dose G_SHARED__Xi_core_u_dose 8.971f
Ctic101 D_STD__Xi_core_u_dose HBT_B__Xi_core_u_dut 0.179f
Ctic102 D_STD__Xi_core_u_dose HBT_C__Xi_core_u_dut 55.3935f
Ctic103 D_STD__Xi_core_u_dose HBT_E__Xi_core_u_dut 0.0135f
Ctic104 D_STD__Xi_core_u_dose VDD 0.294f
Ctic105 D_STD__Xi_core_u_dose VDD__Xi_core_u_ls_en 0.7485f
Ctic106 D_STD__Xi_core_u_dose VSS 10.2435f
Ctic107 D_STD__Xi_core_u_dose VSS__Xi_core_u_ls_en 0.928f
Ctic108 D_STD__Xi_core_u_dose _nc4__Xpad19_g_shared 0.0015f
Ctic109 D_STD__Xi_core_u_dose _nc5__Xpad20_d_std 0.001f
Ctic110 D_STD__Xi_core_u_dose i_core_osc_clk 0.06f
Ctic111 G_SHARED HBT_B 0.0015f
Ctic112 G_SHARED HBT_B__Xi_core_u_dut 5.5565f
Ctic113 G_SHARED HBT_C 0.0085f
Ctic114 G_SHARED HBT_C__Xi_core_u_dut 2.9235f
Ctic115 G_SHARED HBT_E 0.026f
Ctic116 G_SHARED VDD 0.2885f
Ctic117 G_SHARED VDD__Xi_core_u_digital 4.2625f
Ctic118 G_SHARED VDD__Xi_core_u_digital_1 0.001f
Ctic119 G_SHARED VDD__Xi_core_u_gate 0.001f
Ctic120 G_SHARED VDD__Xi_core_u_ls_en 0.001f
Ctic121 G_SHARED VDD__Xi_core_u_ls_mode 0.001f
Ctic122 G_SHARED VDD__Xi_core_u_ls_r4 0.001f
Ctic123 G_SHARED VDD__Xi_core_u_osc 0.001f
Ctic124 G_SHARED VDD__Xi_core_u_t2f 0.001f
Ctic125 G_SHARED VDD__Xi_core_u_trip 0.001f
Ctic126 G_SHARED VDD__retained_fullchip_sg13g2_antennanp_1020_000_891_000 0.001f
Ctic127 G_SHARED VDD__retained_fullchip_sg13g2_antennanp_1021_440_891_000 0.001f
Ctic128 G_SHARED VDD__retained_fullchip_sg13g2_antennanp_1022_880_891_000 0.001f
Ctic129 G_SHARED VDD__retained_fullchip_sg13g2_antennanp_1024_320_891_000 0.001f
Ctic130 G_SHARED VDD__retained_fullchip_sg13g2_antennanp_1025_760_891_000 0.001f
Ctic131 G_SHARED VDD__retained_fullchip_sg13g2_antennanp_1027_200_891_000 0.001f
Ctic132 G_SHARED VSS 10.9757f
Ctic133 G_SHARED VSS__Xi_core_u_digital 1.57574f
Ctic134 G_SHARED VSS__Xi_core_u_digital_1 0.0107368f
Ctic135 G_SHARED VSS__Xi_core_u_dose 0.0107368f
Ctic136 G_SHARED VSS__Xi_core_u_dut 0.0107368f
Ctic137 G_SHARED VSS__Xi_core_u_gate 0.0107368f
Ctic138 G_SHARED VSS__Xi_core_u_ls_en 0.0107368f
Ctic139 G_SHARED VSS__Xi_core_u_ls_mode 0.0107368f
Ctic140 G_SHARED VSS__Xi_core_u_ls_r4 0.0107368f
Ctic141 G_SHARED VSS__Xi_core_u_osc 0.0107368f
Ctic142 G_SHARED VSS__Xi_core_u_sense 0.0107368f
Ctic143 G_SHARED VSS__Xi_core_u_t2f 0.0107368f
Ctic144 G_SHARED VSS__Xi_core_u_trip 0.0107368f
Ctic145 G_SHARED VSS__retained_fullchip_sg13g2_antennanp_1020_000_891_000 0.0107368f
Ctic146 G_SHARED VSS__retained_fullchip_sg13g2_antennanp_1021_440_891_000 0.0107368f
Ctic147 G_SHARED VSS__retained_fullchip_sg13g2_antennanp_1022_880_891_000 0.0107368f
Ctic148 G_SHARED VSS__retained_fullchip_sg13g2_antennanp_1024_320_891_000 0.0107368f
Ctic149 G_SHARED VSS__retained_fullchip_sg13g2_antennanp_1025_760_891_000 0.0107368f
Ctic150 G_SHARED VSS__retained_fullchip_sg13g2_antennanp_1027_200_891_000 0.0107368f
Ctic151 G_SHARED _nc4__Xpad19_g_shared 0.001f
Ctic152 G_SHARED i_core_osc_clk 0.0005f
Ctic153 G_SHARED__Xi_core_u_dose HBT_B__Xi_core_u_dut 5.555f
Ctic154 G_SHARED__Xi_core_u_dose HBT_C__Xi_core_u_dut 2.915f
Ctic155 G_SHARED__Xi_core_u_dose HBT_E__Xi_core_u_dut 0.026f
Ctic156 G_SHARED__Xi_core_u_dose VDD 0.2875f
Ctic157 G_SHARED__Xi_core_u_dose VDD__Xi_core_u_ls_en 4.2615f
Ctic158 G_SHARED__Xi_core_u_dose VSS 10.965f
Ctic159 G_SHARED__Xi_core_u_dose VSS__Xi_core_u_dose 1.565f
Ctic160 G_SHARED__Xi_core_u_dose _nc4__Xpad19_g_shared 0.001f
Ctic161 G_SHARED__Xi_core_u_dose i_core_osc_clk 0.0005f
Ctic162 HBT_B HBT_C 3.5075f
Ctic163 HBT_B HBT_C__Xi_core_u_dut 0.046f
Ctic164 HBT_B HBT_E 0.021f
Ctic165 HBT_B VDD 0.2805f
Ctic166 HBT_B VDD__Xi_core_u_digital 3.3195f
Ctic167 HBT_B VSS 17.4003f
Ctic168 HBT_B VSS__Xi_core_u_digital 13.2103f
Ctic169 HBT_B VSS__Xi_core_u_digital_1 0.00784211f
Ctic170 HBT_B VSS__Xi_core_u_dose 0.00784211f
Ctic171 HBT_B VSS__Xi_core_u_dut 0.00784211f
Ctic172 HBT_B VSS__Xi_core_u_gate 0.00784211f
Ctic173 HBT_B VSS__Xi_core_u_ls_en 0.00784211f
Ctic174 HBT_B VSS__Xi_core_u_ls_mode 0.00784211f
Ctic175 HBT_B VSS__Xi_core_u_ls_r4 0.00784211f
Ctic176 HBT_B VSS__Xi_core_u_osc 0.00784211f
Ctic177 HBT_B VSS__Xi_core_u_sense 0.00784211f
Ctic178 HBT_B VSS__Xi_core_u_t2f 0.00784211f
Ctic179 HBT_B VSS__Xi_core_u_trip 0.00784211f
Ctic180 HBT_B VSS__retained_fullchip_sg13g2_antennanp_1020_000_891_000 0.00784211f
Ctic181 HBT_B VSS__retained_fullchip_sg13g2_antennanp_1021_440_891_000 0.00784211f
Ctic182 HBT_B VSS__retained_fullchip_sg13g2_antennanp_1022_880_891_000 0.00784211f
Ctic183 HBT_B VSS__retained_fullchip_sg13g2_antennanp_1024_320_891_000 0.00784211f
Ctic184 HBT_B VSS__retained_fullchip_sg13g2_antennanp_1025_760_891_000 0.00784211f
Ctic185 HBT_B VSS__retained_fullchip_sg13g2_antennanp_1027_200_891_000 0.00784211f
Ctic186 HBT_B _nc8__Xpad23_hbt_b 0.001f
Ctic188 HBT_B i_core_sclk_i__Xpad14_sclk 0.085f
Ctic189 HBT_B i_core_sdi_i 0.3115f
Ctic190 HBT_B i_core_sdi_i__Xpad15_sdi 0.059f
Ctic191 HBT_B i_core_sdi_i__retained_fullchip_sg13g2_antennanp_1024_320_891_000 0.059f
Ctic192 HBT_B__Xi_core_u_dut HBT_C__Xi_core_u_dut 3.4615f
Ctic193 HBT_B__Xi_core_u_dut HBT_E 0.0005f
Ctic194 HBT_B__Xi_core_u_dut HBT_E__Xi_core_u_dut 0.0205f
Ctic195 HBT_B__Xi_core_u_dut VDD 0.2805f
Ctic196 HBT_B__Xi_core_u_dut VDD__Xi_core_u_ls_en 3.3195f
Ctic197 HBT_B__Xi_core_u_dut VSS 17.3925f
Ctic198 HBT_B__Xi_core_u_dut VSS__Xi_core_u_dut 13.2025f
Ctic199 HBT_B__Xi_core_u_dut _nc8__Xpad23_hbt_b 0.001f
Ctic201 HBT_B__Xi_core_u_dut i_core_sclk_i 0.085f
Ctic202 HBT_B__Xi_core_u_dut i_core_sdi_i 0.2525f
Ctic203 HBT_C HBT_E 0.1245f
Ctic204 HBT_C VDD 0.3245f
Ctic205 HBT_C VDD__Xi_core_u_digital 1.058f
Ctic206 HBT_C VSS 18.6468f
Ctic207 HBT_C VSS__Xi_core_u_digital 4.75034f
Ctic208 HBT_C VSS__Xi_core_u_digital_1 0.00784211f
Ctic209 HBT_C VSS__Xi_core_u_dose 0.00784211f
Ctic210 HBT_C VSS__Xi_core_u_dut 0.00784211f
Ctic211 HBT_C VSS__Xi_core_u_gate 0.00784211f
Ctic212 HBT_C VSS__Xi_core_u_ls_en 0.00784211f
Ctic213 HBT_C VSS__Xi_core_u_ls_mode 0.00784211f
Ctic214 HBT_C VSS__Xi_core_u_ls_r4 0.00784211f
Ctic215 HBT_C VSS__Xi_core_u_osc 0.00784211f
Ctic216 HBT_C VSS__Xi_core_u_sense 0.00784211f
Ctic217 HBT_C VSS__Xi_core_u_t2f 0.00784211f
Ctic218 HBT_C VSS__Xi_core_u_trip 0.00784211f
Ctic219 HBT_C VSS__retained_fullchip_sg13g2_antennanp_1020_000_891_000 0.00784211f
Ctic220 HBT_C VSS__retained_fullchip_sg13g2_antennanp_1021_440_891_000 0.00784211f
Ctic221 HBT_C VSS__retained_fullchip_sg13g2_antennanp_1022_880_891_000 0.00784211f
Ctic222 HBT_C VSS__retained_fullchip_sg13g2_antennanp_1024_320_891_000 0.00784211f
Ctic223 HBT_C VSS__retained_fullchip_sg13g2_antennanp_1025_760_891_000 0.00784211f
Ctic224 HBT_C VSS__retained_fullchip_sg13g2_antennanp_1027_200_891_000 0.00784211f
Ctic226 HBT_C _nc5__Xpad20_d_std 0.0015f
Ctic227 HBT_C _nc6__Xpad21_d_elt 0.0015f
Ctic228 HBT_C _nc7__Xpad22_hbt_e 0.0015f
Ctic229 HBT_C _nc8__Xpad23_hbt_b 0.0015f
Ctic230 HBT_C _nc9__Xpad24_hbt_c 0.001f
Ctic231 HBT_C i_core_osc_clk__Xi_core_u_osc 1.2085f
Ctic232 HBT_C i_core_sclk_i__Xpad14_sclk 0.013f
Ctic233 HBT_C i_core_sdi_i 0.197f
Ctic234 HBT_C i_core_sdi_i__Xpad15_sdi 0.059f
Ctic235 HBT_C i_core_sdi_i__retained_fullchip_sg13g2_antennanp_1024_320_891_000 0.059f
Ctic236 HBT_C__Xi_core_u_dut HBT_E 0.045f
Ctic237 HBT_C__Xi_core_u_dut HBT_E__Xi_core_u_dut 0.0795f
Ctic238 HBT_C__Xi_core_u_dut VDD 0.3245f
Ctic239 HBT_C__Xi_core_u_dut VDD__Xi_core_u_ls_en 1.058f
Ctic240 HBT_C__Xi_core_u_dut VSS 18.639f
Ctic241 HBT_C__Xi_core_u_dut VSS__Xi_core_u_dut 4.7425f
Ctic243 HBT_C__Xi_core_u_dut _nc5__Xpad20_d_std 0.0015f
Ctic244 HBT_C__Xi_core_u_dut _nc6__Xpad21_d_elt 0.0015f
Ctic245 HBT_C__Xi_core_u_dut _nc7__Xpad22_hbt_e 0.0015f
Ctic246 HBT_C__Xi_core_u_dut _nc8__Xpad23_hbt_b 0.0015f
Ctic247 HBT_C__Xi_core_u_dut _nc9__Xpad24_hbt_c 0.001f
Ctic248 HBT_C__Xi_core_u_dut i_core_osc_clk 1.2085f
Ctic249 HBT_C__Xi_core_u_dut i_core_sclk_i 0.013f
Ctic250 HBT_C__Xi_core_u_dut i_core_sdi_i 0.138f
Ctic251 HBT_E VDD 0.280813f
Ctic252 HBT_E VDDA__Xi_core_u_gate 0.012f
Ctic253 HBT_E VDD__Xi_core_u_digital 1.62531f
Ctic254 HBT_E VDD__Xi_core_u_digital_1 0.0003125f
Ctic255 HBT_E VDD__Xi_core_u_gate 0.0003125f
Ctic256 HBT_E VDD__Xi_core_u_ls_en 0.0003125f
Ctic257 HBT_E VDD__Xi_core_u_ls_mode 0.0003125f
Ctic258 HBT_E VDD__Xi_core_u_ls_r4 0.0003125f
Ctic259 HBT_E VDD__Xi_core_u_osc 0.0003125f
Ctic260 HBT_E VDD__Xi_core_u_t2f 0.0003125f
Ctic261 HBT_E VDD__Xi_core_u_trip 0.0003125f
Ctic262 HBT_E VDD__retained_fullchip_sg13g2_antennanp_1020_000_891_000 0.0003125f
Ctic263 HBT_E VDD__retained_fullchip_sg13g2_antennanp_1021_440_891_000 0.0003125f
Ctic264 HBT_E VDD__retained_fullchip_sg13g2_antennanp_1022_880_891_000 0.0003125f
Ctic265 HBT_E VDD__retained_fullchip_sg13g2_antennanp_1024_320_891_000 0.0003125f
Ctic266 HBT_E VDD__retained_fullchip_sg13g2_antennanp_1025_760_891_000 0.0003125f
Ctic267 HBT_E VDD__retained_fullchip_sg13g2_antennanp_1027_200_891_000 0.0003125f
Ctic268 HBT_E VSS 17.5655f
Ctic269 HBT_E VSS__Xi_core_u_digital 1.7665f
Ctic270 HBT_E VSS__Xi_core_u_digital_1 0.009f
Ctic271 HBT_E VSS__Xi_core_u_dose 0.009f
Ctic272 HBT_E VSS__Xi_core_u_dut 0.009f
Ctic273 HBT_E VSS__Xi_core_u_gate 0.009f
Ctic274 HBT_E VSS__Xi_core_u_ls_en 0.009f
Ctic275 HBT_E VSS__Xi_core_u_ls_mode 0.009f
Ctic276 HBT_E VSS__Xi_core_u_ls_r4 0.009f
Ctic277 HBT_E VSS__Xi_core_u_osc 0.009f
Ctic278 HBT_E VSS__Xi_core_u_sense 0.009f
Ctic279 HBT_E VSS__Xi_core_u_t2f 0.009f
Ctic280 HBT_E VSS__Xi_core_u_trip 0.009f
Ctic281 HBT_E VSS__retained_fullchip_sg13g2_antennanp_1020_000_891_000 0.009f
Ctic282 HBT_E VSS__retained_fullchip_sg13g2_antennanp_1021_440_891_000 0.009f
Ctic283 HBT_E VSS__retained_fullchip_sg13g2_antennanp_1022_880_891_000 0.009f
Ctic284 HBT_E VSS__retained_fullchip_sg13g2_antennanp_1024_320_891_000 0.009f
Ctic285 HBT_E VSS__retained_fullchip_sg13g2_antennanp_1025_760_891_000 0.009f
Ctic286 HBT_E VSS__retained_fullchip_sg13g2_antennanp_1027_200_891_000 0.009f
Ctic287 HBT_E _nc7__Xpad22_hbt_e 0.001f
Ctic288 HBT_E en_i 0.0775f
Ctic289 HBT_E i_core_bgr_r4_12 0.0145f
Ctic290 HBT_E i_core_bgr_r4_33 11.014f
Ctic291 HBT_E i_core_clr_d 0.013f
Ctic292 HBT_E i_core_cmp_clk 0.078f
Ctic293 HBT_E i_core_cmp_hard 0.015f
Ctic294 HBT_E i_core_cmp_soft 0.19f
Ctic295 HBT_E i_core_dac_hard_0_ 0.2005f
Ctic296 HBT_E i_core_dac_hard_1_ 0.096f
Ctic297 HBT_E i_core_dac_hard_2_ 0.0975f
Ctic298 HBT_E i_core_dac_hard_3_ 0.0775f
Ctic299 HBT_E i_core_dac_hard_4_ 0.015f
Ctic300 HBT_E i_core_dac_hard_5_ 0.0145f
Ctic301 HBT_E i_core_dac_hard_6_ 0.156f
Ctic302 HBT_E i_core_dac_hard_7_ 2.2085f
Ctic303 HBT_E i_core_dac_soft_0_ 0.1025f
Ctic304 HBT_E i_core_dac_soft_1_ 0.018f
Ctic305 HBT_E i_core_dac_soft_2_ 0.1435f
Ctic306 HBT_E i_core_dac_soft_3_ 0.018f
Ctic307 HBT_E i_core_dac_soft_4_ 0.084f
Ctic308 HBT_E i_core_dac_soft_5_ 0.013f
Ctic309 HBT_E i_core_dac_soft_6_ 0.0985f
Ctic310 HBT_E i_core_dac_soft_7_ 0.018f
Ctic311 HBT_E i_core_fast_en 0.013f
Ctic312 HBT_E i_core_osc_clk 0.7865f
Ctic313 HBT_E i_core_osc_en 0.0145f
Ctic314 HBT_E i_core_osc_trim_0_ 0.077f
Ctic315 HBT_E i_core_osc_trim_1_ 2.0045f
Ctic316 HBT_E i_core_osc_trim_2_ 0.077f
Ctic317 HBT_E i_core_osc_trim_3_ 0.0575f
Ctic318 HBT_E i_core_sclk_i 0.4f
Ctic319 HBT_E i_core_sdi_i 0.0686667f
Ctic320 HBT_E i_core_sdi_i__Xpad15_sdi 0.0366667f
Ctic321 HBT_E i_core_sdi_i__retained_fullchip_sg13g2_antennanp_1024_320_891_000 0.0366667f
Ctic322 HBT_E i_core_sdo_o 2.934f
Ctic323 HBT_E i_core_t2f_en_12 0.015f
Ctic324 HBT_E i_core_t2f_mode_12 0.082f
Ctic325 HBT_E i_core_trip_d 0.0135f
Ctic326 HBT_E i_core_tripped__Xi_core_u_gate 0.0135f
Ctic327 HBT_E net 0.241f
Ctic328 HBT_E__Xi_core_u_dut VDD 0.2805f
Ctic329 HBT_E__Xi_core_u_dut VDDA__Xi_core_u_ls_en 0.012f
Ctic330 HBT_E__Xi_core_u_dut VDD__Xi_core_u_ls_en 1.625f
Ctic331 HBT_E__Xi_core_u_dut VSS 17.5565f
Ctic332 HBT_E__Xi_core_u_dut VSS__Xi_core_u_dut 1.7575f
Ctic333 HBT_E__Xi_core_u_dut _nc7__Xpad22_hbt_e 0.001f
Ctic334 HBT_E__Xi_core_u_dut en_i__Xi_core_u_gate 0.0775f
Ctic335 HBT_E__Xi_core_u_dut i_core_bgr_r4_12__Xi_core_u_ls_r4 0.0145f
Ctic336 HBT_E__Xi_core_u_dut i_core_bgr_r4_33__Xi_core_u_ls_r4 11.014f
Ctic337 HBT_E__Xi_core_u_dut i_core_clr_d__Xi_core_u_gate 0.013f
Ctic338 HBT_E__Xi_core_u_dut i_core_cmp_clk 0.078f
Ctic339 HBT_E__Xi_core_u_dut i_core_cmp_hard__Xi_core_u_gate 0.015f
Ctic340 HBT_E__Xi_core_u_dut i_core_cmp_soft 0.19f
Ctic341 HBT_E__Xi_core_u_dut i_core_dac_hard_0_ 0.2005f
Ctic342 HBT_E__Xi_core_u_dut i_core_dac_hard_1_ 0.096f
Ctic343 HBT_E__Xi_core_u_dut i_core_dac_hard_2_ 0.0975f
Ctic344 HBT_E__Xi_core_u_dut i_core_dac_hard_3_ 0.0775f
Ctic345 HBT_E__Xi_core_u_dut i_core_dac_hard_4_ 0.015f
Ctic346 HBT_E__Xi_core_u_dut i_core_dac_hard_5_ 0.0145f
Ctic347 HBT_E__Xi_core_u_dut i_core_dac_hard_6_ 0.156f
Ctic348 HBT_E__Xi_core_u_dut i_core_dac_hard_7_ 2.2085f
Ctic349 HBT_E__Xi_core_u_dut i_core_dac_soft_0___Xi_core_u_trip 0.1025f
Ctic350 HBT_E__Xi_core_u_dut i_core_dac_soft_1___Xi_core_u_trip 0.018f
Ctic351 HBT_E__Xi_core_u_dut i_core_dac_soft_2___Xi_core_u_trip 0.1435f
Ctic352 HBT_E__Xi_core_u_dut i_core_dac_soft_3___Xi_core_u_trip 0.018f
Ctic353 HBT_E__Xi_core_u_dut i_core_dac_soft_4___Xi_core_u_trip 0.084f
Ctic354 HBT_E__Xi_core_u_dut i_core_dac_soft_5___Xi_core_u_trip 0.013f
Ctic355 HBT_E__Xi_core_u_dut i_core_dac_soft_6___Xi_core_u_trip 0.0985f
Ctic356 HBT_E__Xi_core_u_dut i_core_dac_soft_7___Xi_core_u_trip 0.018f
Ctic357 HBT_E__Xi_core_u_dut i_core_fast_en__Xi_core_u_gate 0.013f
Ctic358 HBT_E__Xi_core_u_dut i_core_osc_clk 0.7865f
Ctic359 HBT_E__Xi_core_u_dut i_core_osc_en 0.0145f
Ctic360 HBT_E__Xi_core_u_dut i_core_osc_trim_0_ 0.077f
Ctic361 HBT_E__Xi_core_u_dut i_core_osc_trim_1_ 2.0045f
Ctic362 HBT_E__Xi_core_u_dut i_core_osc_trim_2_ 0.077f
Ctic363 HBT_E__Xi_core_u_dut i_core_osc_trim_3_ 0.0575f
Ctic364 HBT_E__Xi_core_u_dut i_core_sclk_i 0.4f
Ctic365 HBT_E__Xi_core_u_dut i_core_sdi_i 0.032f
Ctic366 HBT_E__Xi_core_u_dut i_core_sdo_o 2.934f
Ctic367 HBT_E__Xi_core_u_dut i_core_t2f_en_12__Xi_core_u_ls_en 0.015f
Ctic368 HBT_E__Xi_core_u_dut i_core_t2f_mode_12__Xi_core_u_ls_mode 0.082f
Ctic369 HBT_E__Xi_core_u_dut i_core_trip_d__Xi_core_u_gate 0.0135f
Ctic370 HBT_E__Xi_core_u_dut i_core_tripped 0.0135f
Ctic371 HBT_E__Xi_core_u_dut net 0.241f
Ctic372 IOVDD IOVSS 3.502f
Ctic373 IOVDD VSS 48.202f
Ctic374 IOVSS VDD 3.502f
Ctic375 SENSE_N SENSE_P 0.165f
Ctic376 SENSE_N SENSE_P__Xi_core_u_sense 0.0135f
Ctic377 SENSE_N VDD 0.2815f
Ctic378 SENSE_N VDDA 0.0395f
Ctic379 SENSE_N VDD__Xi_core_u_digital 0.001f
Ctic380 SENSE_N VDD__Xi_core_u_digital_1 1.3075f
Ctic381 SENSE_N VDD__Xi_core_u_gate 0.001f
Ctic382 SENSE_N VDD__Xi_core_u_ls_en 0.001f
Ctic383 SENSE_N VDD__Xi_core_u_ls_mode 0.001f
Ctic384 SENSE_N VDD__Xi_core_u_ls_r4 0.001f
Ctic385 SENSE_N VDD__Xi_core_u_osc 0.001f
Ctic386 SENSE_N VDD__Xi_core_u_t2f 0.001f
Ctic387 SENSE_N VDD__Xi_core_u_trip 0.001f
Ctic388 SENSE_N VDD__retained_fullchip_sg13g2_antennanp_1020_000_891_000 0.001f
Ctic389 SENSE_N VDD__retained_fullchip_sg13g2_antennanp_1021_440_891_000 0.001f
Ctic390 SENSE_N VDD__retained_fullchip_sg13g2_antennanp_1022_880_891_000 0.001f
Ctic391 SENSE_N VDD__retained_fullchip_sg13g2_antennanp_1024_320_891_000 0.001f
Ctic392 SENSE_N VDD__retained_fullchip_sg13g2_antennanp_1025_760_891_000 0.001f
Ctic393 SENSE_N VDD__retained_fullchip_sg13g2_antennanp_1027_200_891_000 0.001f
Ctic394 SENSE_N VSS 4.95892f
Ctic395 SENSE_N VSS__Xi_core_u_digital 0.0114211f
Ctic396 SENSE_N VSS__Xi_core_u_digital_1 0.0114211f
Ctic397 SENSE_N VSS__Xi_core_u_dose 0.0114211f
Ctic398 SENSE_N VSS__Xi_core_u_dut 0.0114211f
Ctic399 SENSE_N VSS__Xi_core_u_gate 0.0114211f
Ctic400 SENSE_N VSS__Xi_core_u_ls_en 0.0114211f
Ctic401 SENSE_N VSS__Xi_core_u_ls_mode 0.0114211f
Ctic402 SENSE_N VSS__Xi_core_u_ls_r4 0.0114211f
Ctic403 SENSE_N VSS__Xi_core_u_osc 0.0114211f
Ctic404 SENSE_N VSS__Xi_core_u_sense 0.0114211f
Ctic405 SENSE_N VSS__Xi_core_u_t2f 0.0114211f
Ctic406 SENSE_N VSS__Xi_core_u_trip 3.41442f
Ctic407 SENSE_N VSS__retained_fullchip_sg13g2_antennanp_1020_000_891_000 0.0114211f
Ctic408 SENSE_N VSS__retained_fullchip_sg13g2_antennanp_1021_440_891_000 0.0114211f
Ctic409 SENSE_N VSS__retained_fullchip_sg13g2_antennanp_1022_880_891_000 0.0114211f
Ctic410 SENSE_N VSS__retained_fullchip_sg13g2_antennanp_1024_320_891_000 0.0114211f
Ctic411 SENSE_N VSS__retained_fullchip_sg13g2_antennanp_1025_760_891_000 0.0114211f
Ctic412 SENSE_N VSS__retained_fullchip_sg13g2_antennanp_1027_200_891_000 0.0114211f
Ctic413 SENSE_N _nc3__Xpad09_sense_n 0.001f
Ctic414 SENSE_N i_core_t2f_en_33 0.003f
Ctic415 SENSE_N i_core_t2f_mode_33 0.0025f
Ctic416 SENSE_N net__Xi_core_u_digital_1 0.0095f
Ctic417 SENSE_N__Xi_core_u_sense SENSE_P__Xi_core_u_sense 0.1515f
Ctic418 SENSE_N__Xi_core_u_sense VDD 0.2805f
Ctic419 SENSE_N__Xi_core_u_sense VDDA__Xi_core_u_sense 0.0395f
Ctic420 SENSE_N__Xi_core_u_sense VDD__retained_fullchip_sg13g2_antennanp_1020_000_891_000 1.3065f
Ctic421 SENSE_N__Xi_core_u_sense VSS 4.9475f
Ctic422 SENSE_N__Xi_core_u_sense VSS__Xi_core_u_trip 3.403f
Ctic423 SENSE_N__Xi_core_u_sense _nc3__Xpad09_sense_n 0.001f
Ctic424 SENSE_N__Xi_core_u_sense i_core_t2f_en_33__Xi_core_u_t2f 0.003f
Ctic425 SENSE_N__Xi_core_u_sense i_core_t2f_mode_33__Xi_core_u_t2f 0.0025f
Ctic426 SENSE_N__Xi_core_u_sense net__Xi_core_u_digital_1 0.0095f
Ctic427 SENSE_P VDD 0.28725f
Ctic428 SENSE_P VDDA 0.0275f
Ctic429 SENSE_P VDD__Xi_core_u_digital 0.00125f
Ctic430 SENSE_P VDD__Xi_core_u_digital_1 0.00125f
Ctic431 SENSE_P VDD__Xi_core_u_gate 0.00125f
Ctic432 SENSE_P VDD__Xi_core_u_ls_en 0.00125f
Ctic433 SENSE_P VDD__Xi_core_u_ls_mode 0.67325f
Ctic434 SENSE_P VDD__Xi_core_u_ls_r4 0.00125f
Ctic435 SENSE_P VDD__Xi_core_u_osc 0.00125f
Ctic436 SENSE_P VDD__Xi_core_u_t2f 0.00125f
Ctic437 SENSE_P VDD__Xi_core_u_trip 0.00125f
Ctic438 SENSE_P VDD__retained_fullchip_sg13g2_antennanp_1020_000_891_000 0.00125f
Ctic439 SENSE_P VDD__retained_fullchip_sg13g2_antennanp_1021_440_891_000 0.00125f
Ctic440 SENSE_P VDD__retained_fullchip_sg13g2_antennanp_1022_880_891_000 0.00125f
Ctic441 SENSE_P VDD__retained_fullchip_sg13g2_antennanp_1024_320_891_000 0.00125f
Ctic442 SENSE_P VDD__retained_fullchip_sg13g2_antennanp_1025_760_891_000 0.00125f
Ctic443 SENSE_P VDD__retained_fullchip_sg13g2_antennanp_1027_200_891_000 0.00125f
Ctic444 SENSE_P VSS 9.11668f
Ctic445 SENSE_P VSS__Xi_core_u_digital 0.0116842f
Ctic446 SENSE_P VSS__Xi_core_u_digital_1 0.0116842f
Ctic447 SENSE_P VSS__Xi_core_u_dose 0.0116842f
Ctic448 SENSE_P VSS__Xi_core_u_dut 0.0116842f
Ctic449 SENSE_P VSS__Xi_core_u_gate 0.0116842f
Ctic450 SENSE_P VSS__Xi_core_u_ls_en 0.0116842f
Ctic451 SENSE_P VSS__Xi_core_u_ls_mode 0.0116842f
Ctic452 SENSE_P VSS__Xi_core_u_ls_r4 0.0116842f
Ctic453 SENSE_P VSS__Xi_core_u_osc 0.0116842f
Ctic454 SENSE_P VSS__Xi_core_u_sense 0.0116842f
Ctic455 SENSE_P VSS__Xi_core_u_t2f 0.0116842f
Ctic456 SENSE_P VSS__Xi_core_u_trip 5.33968f
Ctic457 SENSE_P VSS__retained_fullchip_sg13g2_antennanp_1020_000_891_000 0.0116842f
Ctic458 SENSE_P VSS__retained_fullchip_sg13g2_antennanp_1021_440_891_000 0.0116842f
Ctic459 SENSE_P VSS__retained_fullchip_sg13g2_antennanp_1022_880_891_000 0.0116842f
Ctic460 SENSE_P VSS__retained_fullchip_sg13g2_antennanp_1024_320_891_000 0.0116842f
Ctic461 SENSE_P VSS__retained_fullchip_sg13g2_antennanp_1025_760_891_000 0.0116842f
Ctic462 SENSE_P VSS__retained_fullchip_sg13g2_antennanp_1027_200_891_000 0.0116842f
Ctic463 SENSE_P _nc2__Xpad08_sense_p 0.0015f
Ctic464 SENSE_P _nc3__Xpad09_sense_n 0.0005f
Ctic465 SENSE_P net 0.0755f
Ctic466 SENSE_P__Xi_core_u_sense VDD 0.286f
Ctic467 SENSE_P__Xi_core_u_sense VDDA__Xi_core_u_sense 0.0275f
Ctic468 SENSE_P__Xi_core_u_sense VDD__retained_fullchip_sg13g2_antennanp_1020_000_891_000 0.672f
Ctic469 SENSE_P__Xi_core_u_sense VSS 9.105f
Ctic470 SENSE_P__Xi_core_u_sense VSS__Xi_core_u_trip 5.328f
Ctic471 SENSE_P__Xi_core_u_sense _nc2__Xpad08_sense_p 0.0015f
Ctic472 SENSE_P__Xi_core_u_sense _nc3__Xpad09_sense_n 0.0005f
Ctic473 SENSE_P__Xi_core_u_sense net__Xi_core_u_digital_1 0.0755f
Ctic474 TRIP_SET VSS 0.00642105f
Ctic475 TRIP_SET VSS__Xi_core_u_digital 0.00642105f
Ctic476 TRIP_SET VSS__Xi_core_u_digital_1 0.00642105f
Ctic477 TRIP_SET VSS__Xi_core_u_dose 0.00642105f
Ctic478 TRIP_SET VSS__Xi_core_u_dut 0.00642105f
Ctic479 TRIP_SET VSS__Xi_core_u_gate 0.00642105f
Ctic480 TRIP_SET VSS__Xi_core_u_ls_en 0.00642105f
Ctic481 TRIP_SET VSS__Xi_core_u_ls_mode 0.00642105f
Ctic482 TRIP_SET VSS__Xi_core_u_ls_r4 0.00642105f
Ctic483 TRIP_SET VSS__Xi_core_u_osc 0.00642105f
Ctic484 TRIP_SET VSS__Xi_core_u_sense 0.00642105f
Ctic485 TRIP_SET VSS__Xi_core_u_t2f 0.00642105f
Ctic486 TRIP_SET VSS__Xi_core_u_trip 0.00642105f
Ctic487 TRIP_SET VSS__retained_fullchip_sg13g2_antennanp_1020_000_891_000 0.00642105f
Ctic488 TRIP_SET VSS__retained_fullchip_sg13g2_antennanp_1021_440_891_000 0.00642105f
Ctic489 TRIP_SET VSS__retained_fullchip_sg13g2_antennanp_1022_880_891_000 0.00642105f
Ctic490 TRIP_SET VSS__retained_fullchip_sg13g2_antennanp_1024_320_891_000 0.00642105f
Ctic491 TRIP_SET VSS__retained_fullchip_sg13g2_antennanp_1025_760_891_000 0.00642105f
Ctic492 TRIP_SET VSS__retained_fullchip_sg13g2_antennanp_1027_200_891_000 0.00642105f
Ctic493 TRIP_SET i_core_sclk_i 0.2005f
Ctic494 TRIP_SET i_core_sclk_i__Xpad14_sclk 0.2005f
Ctic495 TRIP_SET i_core_sdi_i 1.568f
Ctic496 TRIP_SET i_core_sdi_i__Xpad15_sdi 1.568f
Ctic497 TRIP_SET i_core_sdi_i__retained_fullchip_sg13g2_antennanp_1024_320_891_000 1.568f
Ctic498 VDD VDDA 0.0794375f
Ctic499 VDD VDDA__Xi_core_u_bgr 0.0003125f
Ctic500 VDD VDDA__Xi_core_u_gate 0.0785f
Ctic501 VDD VDDA__Xi_core_u_ls_en 0.0785f
Ctic502 VDD VDDA__Xi_core_u_ls_mode 0.0785f
Ctic503 VDD VDDA__Xi_core_u_ls_r4 0.0785f
Ctic504 VDD VDDA__Xi_core_u_sense 0.0785f
Ctic505 VDD VDDA__Xi_core_u_t2f 0.0785f
Ctic506 VDD VDDA__Xi_core_u_trip 0.0785f
Ctic507 VDD VREF 0.0075f
Ctic508 VDD VSS 293.26f
Ctic509 VDD VSS__Xi_core_u_bgr 0.000625f
Ctic510 VDD VSS__Xi_core_u_digital 3.17096f
Ctic511 VDD VSS__Xi_core_u_digital_1 3.05153f
Ctic512 VDD VSS__Xi_core_u_dose 3.05153f
Ctic513 VDD VSS__Xi_core_u_dut 3.05153f
Ctic514 VDD VSS__Xi_core_u_gate 3.05153f
Ctic515 VDD VSS__Xi_core_u_ls_en 3.05153f
Ctic516 VDD VSS__Xi_core_u_ls_mode 3.05153f
Ctic517 VDD VSS__Xi_core_u_ls_r4 3.05153f
Ctic518 VDD VSS__Xi_core_u_osc 3.05153f
Ctic519 VDD VSS__Xi_core_u_sense 3.05153f
Ctic520 VDD VSS__Xi_core_u_t2f 3.05153f
Ctic521 VDD VSS__Xi_core_u_trip 3.05153f
Ctic522 VDD VSS__retained_fullchip_sg13g2_antennanp_1020_000_891_000 3.05153f
Ctic523 VDD VSS__retained_fullchip_sg13g2_antennanp_1021_440_891_000 3.05153f
Ctic524 VDD VSS__retained_fullchip_sg13g2_antennanp_1022_880_891_000 3.05153f
Ctic525 VDD VSS__retained_fullchip_sg13g2_antennanp_1024_320_891_000 3.05153f
Ctic526 VDD VSS__retained_fullchip_sg13g2_antennanp_1025_760_891_000 3.05153f
Ctic527 VDD VSS__retained_fullchip_sg13g2_antennanp_1027_200_891_000 3.05153f
Ctic528 VDD _nc2__Xpad08_sense_p 0.000125f
Ctic529 VDD _nc5__Xpad20_d_std 0.000125f
Ctic530 VDD en_i 0.01525f
Ctic531 VDD en_i__Xi_core_u_gate 0.01525f
Ctic532 VDD en_i__Xpad12_en 0.01525f
Ctic533 VDD en_i__retained_fullchip_sg13g2_antennanp_1020_000_891_000 0.203188f
Ctic534 VDD fault_n_o 2.05844f
Ctic535 VDD fault_n_o__Xpad11_fault_n 1.9945f
Ctic536 VDD gate_o 1.95388f
Ctic537 VDD gate_o__Xpad10_gate 1.9175f
Ctic538 VDD i_core_bgr_r4_12 0.044375f
Ctic539 VDD i_core_bgr_r4_33 0.597562f
Ctic540 VDD i_core_clr_d 0.01225f
Ctic541 VDD i_core_cmp_clk__Xi_core_u_trip 0.0428125f
Ctic542 VDD i_core_cmp_hard__Xi_core_u_trip 0.061375f
Ctic543 VDD i_core_cmp_soft__Xi_core_u_trip 0.180188f
Ctic544 VDD i_core_dac_hard_0_ 0.0204375f
Ctic545 VDD i_core_dac_hard_1_ 0.00875f
Ctic546 VDD i_core_dac_hard_2_ 0.00875f
Ctic547 VDD i_core_dac_hard_3___Xi_core_u_trip 0.133313f
Ctic548 VDD i_core_dac_hard_4_ 0.0356875f
Ctic549 VDD i_core_dac_hard_5_ 0.050375f
Ctic550 VDD i_core_dac_hard_6_ 0.058375f
Ctic551 VDD i_core_dac_hard_7_ 0.120625f
Ctic552 VDD i_core_dac_soft_0___Xi_core_u_trip 0.008f
Ctic553 VDD i_core_dac_soft_1___Xi_core_u_trip 0.0140625f
Ctic554 VDD i_core_dac_soft_2___Xi_core_u_trip 0.0344375f
Ctic555 VDD i_core_dac_soft_3___Xi_core_u_trip 0.0175f
Ctic556 VDD i_core_dac_soft_4___Xi_core_u_trip 0.0130625f
Ctic557 VDD i_core_dac_soft_5___Xi_core_u_trip 0.00925f
Ctic558 VDD i_core_dac_soft_6___Xi_core_u_trip 0.0815f
Ctic559 VDD i_core_dac_soft_7___Xi_core_u_trip 0.0023125f
Ctic560 VDD i_core_dvbe__Xi_core_u_bgr 0.0015625f
Ctic561 VDD i_core_fast_en 0.043f
Ctic562 VDD i_core_iptat 0.0885625f
Ctic563 VDD i_core_isense__Xi_core_u_trip 0.01425f
Ctic564 VDD i_core_osc_clk__Xi_core_u_osc 0.048375f
Ctic565 VDD i_core_osc_en__Xi_core_u_osc 0.0509375f
Ctic566 VDD i_core_osc_trim_0___Xi_core_u_osc 0.0695625f
Ctic567 VDD i_core_osc_trim_1___Xi_core_u_osc 0.012375f
Ctic568 VDD i_core_osc_trim_2___Xi_core_u_osc 0.0578125f
Ctic569 VDD i_core_osc_trim_3___Xi_core_u_osc 0.0169375f
Ctic570 VDD i_core_pbias 0.017125f
Ctic571 VDD i_core_pcasc 0.316812f
Ctic572 VDD i_core_sclk_i 4.1995f
Ctic573 VDD i_core_sclk_i__Xpad14_sclk 4.2595f
Ctic574 VDD i_core_sdi_i 2.241f
Ctic575 VDD i_core_sdi_i__Xpad15_sdi 2.4945f
Ctic576 VDD i_core_sdi_i__retained_fullchip_sg13g2_antennanp_1024_320_891_000 2.241f
Ctic577 VDD i_core_sdo_o 0.0615f
Ctic578 VDD i_core_sdo_o__Xpad16_sdo 1.6705f
Ctic579 VDD i_core_t2f_en_12 0.030625f
Ctic580 VDD i_core_t2f_en_33__Xi_core_u_t2f 0.109937f
Ctic581 VDD i_core_t2f_mode_12 0.0219375f
Ctic582 VDD i_core_t2f_mode_33__Xi_core_u_t2f 0.071125f
Ctic583 VDD i_core_temp_out_o 1.4f
Ctic584 VDD i_core_temp_out_o__Xpad17_temp_out 1.55587f
Ctic585 VDD i_core_trip_d 0.031625f
Ctic586 VDD i_core_tripped__retained_fullchip_sg13g2_antennanp_1027_200_891_000 0.124313f
Ctic587 VDD i_core_vref 0.668562f
Ctic588 VDD i_core_vref__Xi_core_u_sense 0.571f
Ctic589 VDD i_core_vref__Xpad18_vref 0.571f
Ctic591 VDD net__Xi_core_u_digital_1 0.20775f
Ctic592 VDDA VDD__Xi_core_u_digital 0.0009375f
Ctic593 VDDA VDD__Xi_core_u_digital_1 0.0009375f
Ctic594 VDDA VDD__Xi_core_u_gate 0.0009375f
Ctic595 VDDA VDD__Xi_core_u_ls_en 0.0009375f
Ctic596 VDDA VDD__Xi_core_u_ls_mode 17.2702f
Ctic597 VDDA VDD__Xi_core_u_ls_r4 0.0009375f
Ctic598 VDDA VDD__Xi_core_u_osc 0.0009375f
Ctic599 VDDA VDD__Xi_core_u_t2f 0.0009375f
Ctic600 VDDA VDD__Xi_core_u_trip 0.0009375f
Ctic601 VDDA VDD__retained_fullchip_sg13g2_antennanp_1020_000_891_000 0.0009375f
Ctic602 VDDA VDD__retained_fullchip_sg13g2_antennanp_1021_440_891_000 0.0009375f
Ctic603 VDDA VDD__retained_fullchip_sg13g2_antennanp_1022_880_891_000 0.0009375f
Ctic604 VDDA VDD__retained_fullchip_sg13g2_antennanp_1024_320_891_000 0.0009375f
Ctic605 VDDA VDD__retained_fullchip_sg13g2_antennanp_1025_760_891_000 0.0009375f
Ctic606 VDDA VDD__retained_fullchip_sg13g2_antennanp_1027_200_891_000 0.0009375f
Ctic607 VDDA VSS 26.769f
Ctic608 VDDA VSS__Xi_core_u_digital 0.005f
Ctic609 VDDA VSS__Xi_core_u_digital_1 0.005f
Ctic610 VDDA VSS__Xi_core_u_dose 0.005f
Ctic611 VDDA VSS__Xi_core_u_dut 0.005f
Ctic612 VDDA VSS__Xi_core_u_gate 0.005f
Ctic613 VDDA VSS__Xi_core_u_ls_en 0.005f
Ctic614 VDDA VSS__Xi_core_u_ls_mode 6.49775f
Ctic615 VDDA VSS__Xi_core_u_ls_r4 0.005f
Ctic616 VDDA VSS__Xi_core_u_osc 0.005f
Ctic617 VDDA VSS__Xi_core_u_sense 0.005f
Ctic618 VDDA VSS__Xi_core_u_t2f 0.005f
Ctic619 VDDA VSS__Xi_core_u_trip 0.005f
Ctic620 VDDA VSS__retained_fullchip_sg13g2_antennanp_1020_000_891_000 0.005f
Ctic621 VDDA VSS__retained_fullchip_sg13g2_antennanp_1021_440_891_000 0.005f
Ctic622 VDDA VSS__retained_fullchip_sg13g2_antennanp_1022_880_891_000 0.005f
Ctic623 VDDA VSS__retained_fullchip_sg13g2_antennanp_1024_320_891_000 0.005f
Ctic624 VDDA VSS__retained_fullchip_sg13g2_antennanp_1025_760_891_000 0.005f
Ctic625 VDDA VSS__retained_fullchip_sg13g2_antennanp_1027_200_891_000 0.005f
Ctic626 VDDA _nc1__Xpad07_vdda 0.00025f
Ctic627 VDDA en_i__Xi_core_u_gate 0.25825f
Ctic628 VDDA fault_n_o 0.0585f
Ctic629 VDDA gate_o__Xpad10_gate 0.12525f
Ctic630 VDDA i_core_bgr_r4_12__Xi_core_u_ls_r4 0.040375f
Ctic631 VDDA i_core_bgr_r4_33__Xi_core_u_ls_r4 0.027125f
Ctic632 VDDA i_core_clr_d__Xi_core_u_gate 0.0285f
Ctic633 VDDA i_core_cmp_clk 0.704375f
Ctic634 VDDA i_core_cmp_hard__Xi_core_u_gate 0.1335f
Ctic635 VDDA i_core_cmp_soft__retained_fullchip_sg13g2_antennanp_1022_880_891_000 0.038625f
Ctic636 VDDA i_core_dac_hard_0___Xi_core_u_trip 0.03f
Ctic637 VDDA i_core_dac_hard_1___Xi_core_u_trip 0.02f
Ctic638 VDDA i_core_dac_hard_2___Xi_core_u_trip 0.034625f
Ctic639 VDDA i_core_dac_hard_3___Xi_core_u_trip 0.096375f
Ctic640 VDDA i_core_dac_hard_4___Xi_core_u_trip 0.144625f
Ctic641 VDDA i_core_dac_hard_5___Xi_core_u_trip 0.066625f
Ctic642 VDDA i_core_dac_hard_6___Xi_core_u_trip 0.137125f
Ctic643 VDDA i_core_dac_hard_7___Xi_core_u_trip 0.054125f
Ctic644 VDDA i_core_fast_en__Xi_core_u_gate 0.00375f
Ctic645 VDDA i_core_iptat__Xi_core_u_sense 0.02325f
Ctic646 VDDA i_core_isense 0.0175f
Ctic647 VDDA i_core_osc_clk 0.0195f
Ctic648 VDDA i_core_osc_en 0.894125f
Ctic649 VDDA i_core_osc_trim_0_ 0.02425f
Ctic650 VDDA i_core_osc_trim_1_ 0.008875f
Ctic651 VDDA i_core_osc_trim_2_ 0.028625f
Ctic652 VDDA i_core_osc_trim_3_ 0.02475f
Ctic653 VDDA i_core_pbias 0.006f
Ctic654 VDDA i_core_pcasc 0.005875f
Ctic655 VDDA i_core_sdi_i__retained_fullchip_sg13g2_antennanp_1024_320_891_000 0.0145f
Ctic656 VDDA i_core_sdo_o 0.0375f
Ctic657 VDDA i_core_t2f_en_12__Xi_core_u_ls_en 0.010375f
Ctic658 VDDA i_core_t2f_en_33 0.136375f
Ctic659 VDDA i_core_t2f_mode_12__Xi_core_u_ls_mode 0.003375f
Ctic660 VDDA i_core_t2f_mode_33 0.0475f
Ctic661 VDDA i_core_temp_out_o 0.022625f
Ctic662 VDDA i_core_trip_d__Xi_core_u_gate 0.004f
Ctic663 VDDA i_core_tripped 0.1795f
Ctic664 VDDA i_core_vref__Xi_core_u_sense 0.067f
Ctic665 VDDA i_core_vref_buf 0.057625f
Ctic666 VDDA net 0.024f
Ctic667 VDDA__Xi_core_u_bgr VDD__Xi_core_u_digital 0.0003125f
Ctic668 VDDA__Xi_core_u_bgr VDD__Xi_core_u_digital_1 0.0003125f
Ctic669 VDDA__Xi_core_u_bgr VDD__Xi_core_u_gate 0.0003125f
Ctic670 VDDA__Xi_core_u_bgr VDD__Xi_core_u_ls_en 0.0003125f
Ctic671 VDDA__Xi_core_u_bgr VDD__Xi_core_u_ls_mode 0.0003125f
Ctic672 VDDA__Xi_core_u_bgr VDD__Xi_core_u_ls_r4 0.0003125f
Ctic673 VDDA__Xi_core_u_bgr VDD__Xi_core_u_osc 0.0003125f
Ctic674 VDDA__Xi_core_u_bgr VDD__Xi_core_u_t2f 0.0003125f
Ctic675 VDDA__Xi_core_u_bgr VDD__Xi_core_u_trip 0.0003125f
Ctic676 VDDA__Xi_core_u_bgr VDD__retained_fullchip_sg13g2_antennanp_1020_000_891_000 0.0003125f
Ctic677 VDDA__Xi_core_u_bgr VDD__retained_fullchip_sg13g2_antennanp_1021_440_891_000 0.0003125f
Ctic678 VDDA__Xi_core_u_bgr VDD__retained_fullchip_sg13g2_antennanp_1022_880_891_000 0.0003125f
Ctic679 VDDA__Xi_core_u_bgr VDD__retained_fullchip_sg13g2_antennanp_1024_320_891_000 0.0003125f
Ctic680 VDDA__Xi_core_u_bgr VDD__retained_fullchip_sg13g2_antennanp_1025_760_891_000 0.0003125f
Ctic681 VDDA__Xi_core_u_bgr VDD__retained_fullchip_sg13g2_antennanp_1027_200_891_000 0.0003125f
Ctic682 VDDA__Xi_core_u_bgr VSS 0.000421053f
Ctic683 VDDA__Xi_core_u_bgr VSS__Xi_core_u_digital 0.000421053f
Ctic684 VDDA__Xi_core_u_bgr VSS__Xi_core_u_digital_1 0.000421053f
Ctic685 VDDA__Xi_core_u_bgr VSS__Xi_core_u_dose 0.000421053f
Ctic686 VDDA__Xi_core_u_bgr VSS__Xi_core_u_dut 0.000421053f
Ctic687 VDDA__Xi_core_u_bgr VSS__Xi_core_u_gate 0.000421053f
Ctic688 VDDA__Xi_core_u_bgr VSS__Xi_core_u_ls_en 0.000421053f
Ctic689 VDDA__Xi_core_u_bgr VSS__Xi_core_u_ls_mode 0.000421053f
Ctic690 VDDA__Xi_core_u_bgr VSS__Xi_core_u_ls_r4 0.000421053f
Ctic691 VDDA__Xi_core_u_bgr VSS__Xi_core_u_osc 0.000421053f
Ctic692 VDDA__Xi_core_u_bgr VSS__Xi_core_u_sense 0.000421053f
Ctic693 VDDA__Xi_core_u_bgr VSS__Xi_core_u_t2f 0.000421053f
Ctic694 VDDA__Xi_core_u_bgr VSS__Xi_core_u_trip 0.000421053f
Ctic695 VDDA__Xi_core_u_bgr VSS__retained_fullchip_sg13g2_antennanp_1020_000_891_000 0.000421053f
Ctic696 VDDA__Xi_core_u_bgr VSS__retained_fullchip_sg13g2_antennanp_1021_440_891_000 0.000421053f
Ctic697 VDDA__Xi_core_u_bgr VSS__retained_fullchip_sg13g2_antennanp_1022_880_891_000 0.000421053f
Ctic698 VDDA__Xi_core_u_bgr VSS__retained_fullchip_sg13g2_antennanp_1024_320_891_000 0.000421053f
Ctic699 VDDA__Xi_core_u_bgr VSS__retained_fullchip_sg13g2_antennanp_1025_760_891_000 0.000421053f
Ctic700 VDDA__Xi_core_u_bgr VSS__retained_fullchip_sg13g2_antennanp_1027_200_891_000 0.000421053f
Ctic701 VDDA__Xi_core_u_bgr i_core_pcasc 0.0005f
Ctic702 VDDA__Xi_core_u_bgr i_core_pcasc__Xi_core_u_t2f 0.0005f
Ctic703 VDDA__Xi_core_u_bgr i_core_sdo_o 0.0005f
Ctic704 VDDA__Xi_core_u_bgr i_core_sdo_o__Xpad16_sdo 0.0005f
Ctic705 VDDA__Xi_core_u_bgr i_core_vref 0.0246667f
Ctic706 VDDA__Xi_core_u_bgr i_core_vref__Xi_core_u_sense 0.0246667f
Ctic707 VDDA__Xi_core_u_bgr i_core_vref__Xpad18_vref 0.0246667f
Ctic708 VDDA__Xi_core_u_gate VDD__Xi_core_u_gate 17.2692f
Ctic709 VDDA__Xi_core_u_gate VSS 26.764f
Ctic710 VDDA__Xi_core_u_gate VSS__Xi_core_u_gate 6.49275f
Ctic711 VDDA__Xi_core_u_gate _nc1__Xpad07_vdda 0.00025f
Ctic712 VDDA__Xi_core_u_gate en_i 0.25825f
Ctic713 VDDA__Xi_core_u_gate fault_n_o 0.0585f
Ctic714 VDDA__Xi_core_u_gate gate_o 0.12525f
Ctic715 VDDA__Xi_core_u_gate i_core_bgr_r4_12 0.040375f
Ctic716 VDDA__Xi_core_u_gate i_core_bgr_r4_33__Xi_core_u_ls_r4 0.027125f
Ctic717 VDDA__Xi_core_u_gate i_core_clr_d 0.0285f
Ctic718 VDDA__Xi_core_u_gate i_core_cmp_clk 0.704375f
Ctic719 VDDA__Xi_core_u_gate i_core_cmp_hard 0.1335f
Ctic720 VDDA__Xi_core_u_gate i_core_cmp_soft 0.038625f
Ctic721 VDDA__Xi_core_u_gate i_core_dac_hard_0_ 0.03f
Ctic722 VDDA__Xi_core_u_gate i_core_dac_hard_1_ 0.02f
Ctic723 VDDA__Xi_core_u_gate i_core_dac_hard_2_ 0.034625f
Ctic724 VDDA__Xi_core_u_gate i_core_dac_hard_3_ 0.096375f
Ctic725 VDDA__Xi_core_u_gate i_core_dac_hard_4_ 0.144625f
Ctic726 VDDA__Xi_core_u_gate i_core_dac_hard_5_ 0.066625f
Ctic727 VDDA__Xi_core_u_gate i_core_dac_hard_6_ 0.137125f
Ctic728 VDDA__Xi_core_u_gate i_core_dac_hard_7_ 0.054125f
Ctic729 VDDA__Xi_core_u_gate i_core_fast_en 0.00375f
Ctic730 VDDA__Xi_core_u_gate i_core_iptat__Xi_core_u_sense 0.02325f
Ctic731 VDDA__Xi_core_u_gate i_core_isense 0.0175f
Ctic732 VDDA__Xi_core_u_gate i_core_osc_clk 0.0195f
Ctic733 VDDA__Xi_core_u_gate i_core_osc_en 0.894125f
Ctic734 VDDA__Xi_core_u_gate i_core_osc_trim_0_ 0.02425f
Ctic735 VDDA__Xi_core_u_gate i_core_osc_trim_1_ 0.008875f
Ctic736 VDDA__Xi_core_u_gate i_core_osc_trim_2_ 0.028625f
Ctic737 VDDA__Xi_core_u_gate i_core_osc_trim_3_ 0.02475f
Ctic738 VDDA__Xi_core_u_gate i_core_pbias 0.006f
Ctic739 VDDA__Xi_core_u_gate i_core_pcasc 0.005875f
Ctic740 VDDA__Xi_core_u_gate i_core_sdi_i 0.0145f
Ctic741 VDDA__Xi_core_u_gate i_core_sdo_o 0.0375f
Ctic742 VDDA__Xi_core_u_gate i_core_t2f_en_12 0.010375f
Ctic743 VDDA__Xi_core_u_gate i_core_t2f_en_33 0.136375f
Ctic744 VDDA__Xi_core_u_gate i_core_t2f_mode_12 0.003375f
Ctic745 VDDA__Xi_core_u_gate i_core_t2f_mode_33 0.0475f
Ctic746 VDDA__Xi_core_u_gate i_core_temp_out_o__Xpad17_temp_out 0.022625f
Ctic747 VDDA__Xi_core_u_gate i_core_trip_d 0.004f
Ctic748 VDDA__Xi_core_u_gate i_core_tripped 0.1795f
Ctic749 VDDA__Xi_core_u_gate i_core_vref__Xi_core_u_sense 0.067f
Ctic750 VDDA__Xi_core_u_gate i_core_vref_buf 0.057625f
Ctic751 VDDA__Xi_core_u_gate net 0.024f
Ctic752 VDDA__Xi_core_u_ls_en VDD__Xi_core_u_ls_en 17.2692f
Ctic753 VDDA__Xi_core_u_ls_en VSS 26.764f
Ctic754 VDDA__Xi_core_u_ls_en VSS__Xi_core_u_ls_en 6.49275f
Ctic755 VDDA__Xi_core_u_ls_en _nc1__Xpad07_vdda 0.00025f
Ctic756 VDDA__Xi_core_u_ls_en en_i__Xi_core_u_gate 0.25825f
Ctic757 VDDA__Xi_core_u_ls_en fault_n_o 0.0585f
Ctic758 VDDA__Xi_core_u_ls_en gate_o 0.12525f
Ctic759 VDDA__Xi_core_u_ls_en i_core_bgr_r4_12__Xi_core_u_ls_r4 0.040375f
Ctic760 VDDA__Xi_core_u_ls_en i_core_bgr_r4_33__Xi_core_u_ls_r4 0.027125f
Ctic761 VDDA__Xi_core_u_ls_en i_core_clr_d__Xi_core_u_gate 0.0285f
Ctic762 VDDA__Xi_core_u_ls_en i_core_cmp_clk 0.704375f
Ctic763 VDDA__Xi_core_u_ls_en i_core_cmp_hard__Xi_core_u_gate 0.1335f
Ctic764 VDDA__Xi_core_u_ls_en i_core_cmp_soft 0.038625f
Ctic765 VDDA__Xi_core_u_ls_en i_core_dac_hard_0_ 0.03f
Ctic766 VDDA__Xi_core_u_ls_en i_core_dac_hard_1_ 0.02f
Ctic767 VDDA__Xi_core_u_ls_en i_core_dac_hard_2_ 0.034625f
Ctic768 VDDA__Xi_core_u_ls_en i_core_dac_hard_3_ 0.096375f
Ctic769 VDDA__Xi_core_u_ls_en i_core_dac_hard_4_ 0.144625f
Ctic770 VDDA__Xi_core_u_ls_en i_core_dac_hard_5_ 0.066625f
Ctic771 VDDA__Xi_core_u_ls_en i_core_dac_hard_6_ 0.137125f
Ctic772 VDDA__Xi_core_u_ls_en i_core_dac_hard_7_ 0.054125f
Ctic773 VDDA__Xi_core_u_ls_en i_core_fast_en__Xi_core_u_gate 0.00375f
Ctic774 VDDA__Xi_core_u_ls_en i_core_iptat__Xi_core_u_sense 0.02325f
Ctic775 VDDA__Xi_core_u_ls_en i_core_isense 0.0175f
Ctic776 VDDA__Xi_core_u_ls_en i_core_osc_clk 0.0195f
Ctic777 VDDA__Xi_core_u_ls_en i_core_osc_en 0.894125f
Ctic778 VDDA__Xi_core_u_ls_en i_core_osc_trim_0_ 0.02425f
Ctic779 VDDA__Xi_core_u_ls_en i_core_osc_trim_1_ 0.008875f
Ctic780 VDDA__Xi_core_u_ls_en i_core_osc_trim_2_ 0.028625f
Ctic781 VDDA__Xi_core_u_ls_en i_core_osc_trim_3_ 0.02475f
Ctic782 VDDA__Xi_core_u_ls_en i_core_pbias 0.006f
Ctic783 VDDA__Xi_core_u_ls_en i_core_pcasc 0.005875f
Ctic784 VDDA__Xi_core_u_ls_en i_core_sdi_i 0.0145f
Ctic785 VDDA__Xi_core_u_ls_en i_core_sdo_o 0.0375f
Ctic786 VDDA__Xi_core_u_ls_en i_core_t2f_en_12__Xi_core_u_ls_en 0.010375f
Ctic787 VDDA__Xi_core_u_ls_en i_core_t2f_en_33 0.136375f
Ctic788 VDDA__Xi_core_u_ls_en i_core_t2f_mode_12__Xi_core_u_ls_mode 0.003375f
Ctic789 VDDA__Xi_core_u_ls_en i_core_t2f_mode_33 0.0475f
Ctic790 VDDA__Xi_core_u_ls_en i_core_temp_out_o__Xpad17_temp_out 0.022625f
Ctic791 VDDA__Xi_core_u_ls_en i_core_trip_d__Xi_core_u_gate 0.004f
Ctic792 VDDA__Xi_core_u_ls_en i_core_tripped 0.1795f
Ctic793 VDDA__Xi_core_u_ls_en i_core_vref__Xi_core_u_sense 0.067f
Ctic794 VDDA__Xi_core_u_ls_en i_core_vref_buf 0.057625f
Ctic795 VDDA__Xi_core_u_ls_en net 0.024f
Ctic796 VDDA__Xi_core_u_ls_mode VDD__Xi_core_u_ls_mode 17.2692f
Ctic797 VDDA__Xi_core_u_ls_mode VSS 26.764f
Ctic798 VDDA__Xi_core_u_ls_mode VSS__Xi_core_u_ls_mode 6.49275f
Ctic799 VDDA__Xi_core_u_ls_mode _nc1__Xpad07_vdda 0.00025f
Ctic800 VDDA__Xi_core_u_ls_mode en_i__Xi_core_u_gate 0.25825f
Ctic801 VDDA__Xi_core_u_ls_mode fault_n_o 0.0585f
Ctic802 VDDA__Xi_core_u_ls_mode gate_o 0.12525f
Ctic803 VDDA__Xi_core_u_ls_mode i_core_bgr_r4_12__Xi_core_u_ls_r4 0.040375f
Ctic804 VDDA__Xi_core_u_ls_mode i_core_bgr_r4_33__Xi_core_u_ls_r4 0.027125f
Ctic805 VDDA__Xi_core_u_ls_mode i_core_clr_d__Xi_core_u_gate 0.0285f
Ctic806 VDDA__Xi_core_u_ls_mode i_core_cmp_clk 0.704375f
Ctic807 VDDA__Xi_core_u_ls_mode i_core_cmp_hard__Xi_core_u_gate 0.1335f
Ctic808 VDDA__Xi_core_u_ls_mode i_core_cmp_soft 0.038625f
Ctic809 VDDA__Xi_core_u_ls_mode i_core_dac_hard_0_ 0.03f
Ctic810 VDDA__Xi_core_u_ls_mode i_core_dac_hard_1_ 0.02f
Ctic811 VDDA__Xi_core_u_ls_mode i_core_dac_hard_2_ 0.034625f
Ctic812 VDDA__Xi_core_u_ls_mode i_core_dac_hard_3_ 0.096375f
Ctic813 VDDA__Xi_core_u_ls_mode i_core_dac_hard_4_ 0.144625f
Ctic814 VDDA__Xi_core_u_ls_mode i_core_dac_hard_5_ 0.066625f
Ctic815 VDDA__Xi_core_u_ls_mode i_core_dac_hard_6_ 0.137125f
Ctic816 VDDA__Xi_core_u_ls_mode i_core_dac_hard_7_ 0.054125f
Ctic817 VDDA__Xi_core_u_ls_mode i_core_fast_en__Xi_core_u_gate 0.00375f
Ctic818 VDDA__Xi_core_u_ls_mode i_core_iptat__Xi_core_u_sense 0.02325f
Ctic819 VDDA__Xi_core_u_ls_mode i_core_isense 0.0175f
Ctic820 VDDA__Xi_core_u_ls_mode i_core_osc_clk 0.0195f
Ctic821 VDDA__Xi_core_u_ls_mode i_core_osc_en 0.894125f
Ctic822 VDDA__Xi_core_u_ls_mode i_core_osc_trim_0_ 0.02425f
Ctic823 VDDA__Xi_core_u_ls_mode i_core_osc_trim_1_ 0.008875f
Ctic824 VDDA__Xi_core_u_ls_mode i_core_osc_trim_2_ 0.028625f
Ctic825 VDDA__Xi_core_u_ls_mode i_core_osc_trim_3_ 0.02475f
Ctic826 VDDA__Xi_core_u_ls_mode i_core_pbias 0.006f
Ctic827 VDDA__Xi_core_u_ls_mode i_core_pcasc 0.005875f
Ctic828 VDDA__Xi_core_u_ls_mode i_core_sdi_i 0.0145f
Ctic829 VDDA__Xi_core_u_ls_mode i_core_sdo_o 0.0375f
Ctic830 VDDA__Xi_core_u_ls_mode i_core_t2f_en_12__Xi_core_u_ls_en 0.010375f
Ctic831 VDDA__Xi_core_u_ls_mode i_core_t2f_en_33 0.136375f
Ctic832 VDDA__Xi_core_u_ls_mode i_core_t2f_mode_12__Xi_core_u_ls_mode 0.003375f
Ctic833 VDDA__Xi_core_u_ls_mode i_core_t2f_mode_33 0.0475f
Ctic834 VDDA__Xi_core_u_ls_mode i_core_temp_out_o__Xpad17_temp_out 0.022625f
Ctic835 VDDA__Xi_core_u_ls_mode i_core_trip_d__Xi_core_u_gate 0.004f
Ctic836 VDDA__Xi_core_u_ls_mode i_core_tripped 0.1795f
Ctic837 VDDA__Xi_core_u_ls_mode i_core_vref__Xi_core_u_sense 0.067f
Ctic838 VDDA__Xi_core_u_ls_mode i_core_vref_buf 0.057625f
Ctic839 VDDA__Xi_core_u_ls_mode net 0.024f
Ctic840 VDDA__Xi_core_u_ls_r4 VDD__Xi_core_u_ls_r4 17.2692f
Ctic841 VDDA__Xi_core_u_ls_r4 VSS 26.764f
Ctic842 VDDA__Xi_core_u_ls_r4 VSS__Xi_core_u_ls_r4 6.49275f
Ctic843 VDDA__Xi_core_u_ls_r4 _nc1__Xpad07_vdda 0.00025f
Ctic844 VDDA__Xi_core_u_ls_r4 en_i__Xi_core_u_gate 0.25825f
Ctic845 VDDA__Xi_core_u_ls_r4 fault_n_o 0.0585f
Ctic846 VDDA__Xi_core_u_ls_r4 gate_o 0.12525f
Ctic847 VDDA__Xi_core_u_ls_r4 i_core_bgr_r4_12__Xi_core_u_ls_r4 0.040375f
Ctic848 VDDA__Xi_core_u_ls_r4 i_core_bgr_r4_33__Xi_core_u_ls_r4 0.027125f
Ctic849 VDDA__Xi_core_u_ls_r4 i_core_clr_d__Xi_core_u_gate 0.0285f
Ctic850 VDDA__Xi_core_u_ls_r4 i_core_cmp_clk 0.704375f
Ctic851 VDDA__Xi_core_u_ls_r4 i_core_cmp_hard__Xi_core_u_gate 0.1335f
Ctic852 VDDA__Xi_core_u_ls_r4 i_core_cmp_soft 0.038625f
Ctic853 VDDA__Xi_core_u_ls_r4 i_core_dac_hard_0_ 0.03f
Ctic854 VDDA__Xi_core_u_ls_r4 i_core_dac_hard_1_ 0.02f
Ctic855 VDDA__Xi_core_u_ls_r4 i_core_dac_hard_2_ 0.034625f
Ctic856 VDDA__Xi_core_u_ls_r4 i_core_dac_hard_3_ 0.096375f
Ctic857 VDDA__Xi_core_u_ls_r4 i_core_dac_hard_4_ 0.144625f
Ctic858 VDDA__Xi_core_u_ls_r4 i_core_dac_hard_5_ 0.066625f
Ctic859 VDDA__Xi_core_u_ls_r4 i_core_dac_hard_6_ 0.137125f
Ctic860 VDDA__Xi_core_u_ls_r4 i_core_dac_hard_7_ 0.054125f
Ctic861 VDDA__Xi_core_u_ls_r4 i_core_fast_en__Xi_core_u_gate 0.00375f
Ctic862 VDDA__Xi_core_u_ls_r4 i_core_iptat__Xi_core_u_sense 0.02325f
Ctic863 VDDA__Xi_core_u_ls_r4 i_core_isense 0.0175f
Ctic864 VDDA__Xi_core_u_ls_r4 i_core_osc_clk 0.0195f
Ctic865 VDDA__Xi_core_u_ls_r4 i_core_osc_en 0.894125f
Ctic866 VDDA__Xi_core_u_ls_r4 i_core_osc_trim_0_ 0.02425f
Ctic867 VDDA__Xi_core_u_ls_r4 i_core_osc_trim_1_ 0.008875f
Ctic868 VDDA__Xi_core_u_ls_r4 i_core_osc_trim_2_ 0.028625f
Ctic869 VDDA__Xi_core_u_ls_r4 i_core_osc_trim_3_ 0.02475f
Ctic870 VDDA__Xi_core_u_ls_r4 i_core_pbias 0.006f
Ctic871 VDDA__Xi_core_u_ls_r4 i_core_pcasc 0.005875f
Ctic872 VDDA__Xi_core_u_ls_r4 i_core_sdi_i 0.0145f
Ctic873 VDDA__Xi_core_u_ls_r4 i_core_sdo_o 0.0375f
Ctic874 VDDA__Xi_core_u_ls_r4 i_core_t2f_en_12__Xi_core_u_ls_en 0.010375f
Ctic875 VDDA__Xi_core_u_ls_r4 i_core_t2f_en_33 0.136375f
Ctic876 VDDA__Xi_core_u_ls_r4 i_core_t2f_mode_12__Xi_core_u_ls_mode 0.003375f
Ctic877 VDDA__Xi_core_u_ls_r4 i_core_t2f_mode_33 0.0475f
Ctic878 VDDA__Xi_core_u_ls_r4 i_core_temp_out_o__Xpad17_temp_out 0.022625f
Ctic879 VDDA__Xi_core_u_ls_r4 i_core_trip_d__Xi_core_u_gate 0.004f
Ctic880 VDDA__Xi_core_u_ls_r4 i_core_tripped 0.1795f
Ctic881 VDDA__Xi_core_u_ls_r4 i_core_vref__Xi_core_u_sense 0.067f
Ctic882 VDDA__Xi_core_u_ls_r4 i_core_vref_buf 0.057625f
Ctic883 VDDA__Xi_core_u_ls_r4 net 0.024f
Ctic884 VDDA__Xi_core_u_sense VDD__Xi_core_u_gate 17.2692f
Ctic885 VDDA__Xi_core_u_sense VSS 26.764f
Ctic886 VDDA__Xi_core_u_sense VSS__Xi_core_u_sense 6.49275f
Ctic887 VDDA__Xi_core_u_sense _nc1__Xpad07_vdda 0.00025f
Ctic888 VDDA__Xi_core_u_sense en_i 0.25825f
Ctic889 VDDA__Xi_core_u_sense fault_n_o 0.0585f
Ctic890 VDDA__Xi_core_u_sense gate_o 0.12525f
Ctic891 VDDA__Xi_core_u_sense i_core_bgr_r4_12 0.040375f
Ctic892 VDDA__Xi_core_u_sense i_core_bgr_r4_33 0.027125f
Ctic893 VDDA__Xi_core_u_sense i_core_clr_d 0.0285f
Ctic894 VDDA__Xi_core_u_sense i_core_cmp_clk 0.704375f
Ctic895 VDDA__Xi_core_u_sense i_core_cmp_hard 0.1335f
Ctic896 VDDA__Xi_core_u_sense i_core_cmp_soft__retained_fullchip_sg13g2_antennanp_1021_440_891_000 0.038625f
Ctic897 VDDA__Xi_core_u_sense i_core_dac_hard_0___Xi_core_u_trip 0.03f
Ctic898 VDDA__Xi_core_u_sense i_core_dac_hard_1___Xi_core_u_trip 0.02f
Ctic899 VDDA__Xi_core_u_sense i_core_dac_hard_2___Xi_core_u_trip 0.034625f
Ctic900 VDDA__Xi_core_u_sense i_core_dac_hard_3_ 0.096375f
Ctic901 VDDA__Xi_core_u_sense i_core_dac_hard_4___Xi_core_u_trip 0.144625f
Ctic902 VDDA__Xi_core_u_sense i_core_dac_hard_5___Xi_core_u_trip 0.066625f
Ctic903 VDDA__Xi_core_u_sense i_core_dac_hard_6___Xi_core_u_trip 0.137125f
Ctic904 VDDA__Xi_core_u_sense i_core_dac_hard_7___Xi_core_u_trip 0.054125f
Ctic905 VDDA__Xi_core_u_sense i_core_fast_en__Xi_core_u_gate 0.00375f
Ctic906 VDDA__Xi_core_u_sense i_core_iptat__Xi_core_u_sense 0.02325f
Ctic907 VDDA__Xi_core_u_sense i_core_isense 0.0175f
Ctic908 VDDA__Xi_core_u_sense i_core_osc_clk__Xi_core_u_osc 0.0195f
Ctic909 VDDA__Xi_core_u_sense i_core_osc_en 0.894125f
Ctic910 VDDA__Xi_core_u_sense i_core_osc_trim_0_ 0.02425f
Ctic911 VDDA__Xi_core_u_sense i_core_osc_trim_1_ 0.008875f
Ctic912 VDDA__Xi_core_u_sense i_core_osc_trim_2_ 0.028625f
Ctic913 VDDA__Xi_core_u_sense i_core_osc_trim_3_ 0.02475f
Ctic914 VDDA__Xi_core_u_sense i_core_pbias 0.006f
Ctic915 VDDA__Xi_core_u_sense i_core_pcasc 0.005875f
Ctic916 VDDA__Xi_core_u_sense i_core_sdi_i__retained_fullchip_sg13g2_antennanp_1024_320_891_000 0.0145f
Ctic917 VDDA__Xi_core_u_sense i_core_sdo_o 0.0375f
Ctic918 VDDA__Xi_core_u_sense i_core_t2f_en_12 0.010375f
Ctic919 VDDA__Xi_core_u_sense i_core_t2f_en_33 0.136375f
Ctic920 VDDA__Xi_core_u_sense i_core_t2f_mode_12 0.003375f
Ctic921 VDDA__Xi_core_u_sense i_core_t2f_mode_33 0.0475f
Ctic922 VDDA__Xi_core_u_sense i_core_temp_out_o__Xpad17_temp_out 0.022625f
Ctic923 VDDA__Xi_core_u_sense i_core_trip_d 0.004f
Ctic924 VDDA__Xi_core_u_sense i_core_tripped__Xi_core_u_gate 0.1795f
Ctic925 VDDA__Xi_core_u_sense i_core_vref__Xi_core_u_sense 0.067f
Ctic926 VDDA__Xi_core_u_sense i_core_vref_buf 0.057625f
Ctic927 VDDA__Xi_core_u_sense net 0.024f
Ctic928 VDDA__Xi_core_u_t2f VDD__Xi_core_u_t2f 17.2692f
Ctic929 VDDA__Xi_core_u_t2f VSS 26.764f
Ctic930 VDDA__Xi_core_u_t2f VSS__Xi_core_u_t2f 6.49275f
Ctic931 VDDA__Xi_core_u_t2f _nc1__Xpad07_vdda 0.00025f
Ctic932 VDDA__Xi_core_u_t2f en_i__Xpad12_en 0.25825f
Ctic933 VDDA__Xi_core_u_t2f fault_n_o__Xpad11_fault_n 0.0585f
Ctic934 VDDA__Xi_core_u_t2f gate_o__Xpad10_gate 0.12525f
Ctic935 VDDA__Xi_core_u_t2f i_core_bgr_r4_12 0.040375f
Ctic936 VDDA__Xi_core_u_t2f i_core_bgr_r4_33 0.027125f
Ctic937 VDDA__Xi_core_u_t2f i_core_clr_d 0.0285f
Ctic938 VDDA__Xi_core_u_t2f i_core_cmp_clk__Xi_core_u_trip 0.704375f
Ctic939 VDDA__Xi_core_u_t2f i_core_cmp_hard__Xi_core_u_trip 0.1335f
Ctic940 VDDA__Xi_core_u_t2f i_core_cmp_soft__Xi_core_u_trip 0.038625f
Ctic941 VDDA__Xi_core_u_t2f i_core_dac_hard_0___Xi_core_u_trip 0.03f
Ctic942 VDDA__Xi_core_u_t2f i_core_dac_hard_1___Xi_core_u_trip 0.02f
Ctic943 VDDA__Xi_core_u_t2f i_core_dac_hard_2___Xi_core_u_trip 0.034625f
Ctic944 VDDA__Xi_core_u_t2f i_core_dac_hard_3___Xi_core_u_trip 0.096375f
Ctic945 VDDA__Xi_core_u_t2f i_core_dac_hard_4___Xi_core_u_trip 0.144625f
Ctic946 VDDA__Xi_core_u_t2f i_core_dac_hard_5___Xi_core_u_trip 0.066625f
Ctic947 VDDA__Xi_core_u_t2f i_core_dac_hard_6___Xi_core_u_trip 0.137125f
Ctic948 VDDA__Xi_core_u_t2f i_core_dac_hard_7___Xi_core_u_trip 0.054125f
Ctic949 VDDA__Xi_core_u_t2f i_core_fast_en__Xi_core_u_gate 0.00375f
Ctic950 VDDA__Xi_core_u_t2f i_core_iptat 0.02325f
Ctic951 VDDA__Xi_core_u_t2f i_core_isense__Xi_core_u_trip 0.0175f
Ctic952 VDDA__Xi_core_u_t2f i_core_osc_clk__Xi_core_u_osc 0.0195f
Ctic953 VDDA__Xi_core_u_t2f i_core_osc_en__Xi_core_u_osc 0.894125f
Ctic954 VDDA__Xi_core_u_t2f i_core_osc_trim_0___Xi_core_u_osc 0.02425f
Ctic955 VDDA__Xi_core_u_t2f i_core_osc_trim_1___Xi_core_u_osc 0.008875f
Ctic956 VDDA__Xi_core_u_t2f i_core_osc_trim_2___Xi_core_u_osc 0.028625f
Ctic957 VDDA__Xi_core_u_t2f i_core_osc_trim_3___Xi_core_u_osc 0.02475f
Ctic958 VDDA__Xi_core_u_t2f i_core_pbias__Xi_core_u_t2f 0.006f
Ctic959 VDDA__Xi_core_u_t2f i_core_pcasc__Xi_core_u_t2f 0.005875f
Ctic960 VDDA__Xi_core_u_t2f i_core_sdi_i__retained_fullchip_sg13g2_antennanp_1024_320_891_000 0.0145f
Ctic961 VDDA__Xi_core_u_t2f i_core_sdo_o__Xpad16_sdo 0.0375f
Ctic962 VDDA__Xi_core_u_t2f i_core_t2f_en_12 0.010375f
Ctic963 VDDA__Xi_core_u_t2f i_core_t2f_en_33__Xi_core_u_t2f 0.136375f
Ctic964 VDDA__Xi_core_u_t2f i_core_t2f_mode_12 0.003375f
Ctic965 VDDA__Xi_core_u_t2f i_core_t2f_mode_33__Xi_core_u_t2f 0.0475f
Ctic966 VDDA__Xi_core_u_t2f i_core_temp_out_o 0.022625f
Ctic967 VDDA__Xi_core_u_t2f i_core_trip_d 0.004f
Ctic968 VDDA__Xi_core_u_t2f i_core_tripped__retained_fullchip_sg13g2_antennanp_1027_200_891_000 0.1795f
Ctic969 VDDA__Xi_core_u_t2f i_core_vref__Xpad18_vref 0.067f
Ctic970 VDDA__Xi_core_u_t2f i_core_vref_buf__Xi_core_u_trip 0.057625f
Ctic971 VDDA__Xi_core_u_t2f net__Xi_core_u_digital_1 0.024f
Ctic972 VDDA__Xi_core_u_trip VDD__Xi_core_u_trip 17.2692f
Ctic973 VDDA__Xi_core_u_trip VSS 26.764f
Ctic974 VDDA__Xi_core_u_trip VSS__Xi_core_u_osc 6.49275f
Ctic975 VDDA__Xi_core_u_trip _nc1__Xpad07_vdda 0.00025f
Ctic976 VDDA__Xi_core_u_trip en_i__retained_fullchip_sg13g2_antennanp_1020_000_891_000 0.25825f
Ctic977 VDDA__Xi_core_u_trip fault_n_o__Xpad11_fault_n 0.0585f
Ctic978 VDDA__Xi_core_u_trip gate_o 0.12525f
Ctic979 VDDA__Xi_core_u_trip i_core_bgr_r4_12 0.040375f
Ctic980 VDDA__Xi_core_u_trip i_core_bgr_r4_33 0.027125f
Ctic981 VDDA__Xi_core_u_trip i_core_clr_d 0.0285f
Ctic982 VDDA__Xi_core_u_trip i_core_cmp_clk__Xi_core_u_trip 0.704375f
Ctic983 VDDA__Xi_core_u_trip i_core_cmp_hard__Xi_core_u_trip 0.1335f
Ctic984 VDDA__Xi_core_u_trip i_core_cmp_soft__Xi_core_u_trip 0.038625f
Ctic985 VDDA__Xi_core_u_trip i_core_dac_hard_0___Xi_core_u_trip 0.03f
Ctic986 VDDA__Xi_core_u_trip i_core_dac_hard_1___Xi_core_u_trip 0.02f
Ctic987 VDDA__Xi_core_u_trip i_core_dac_hard_2___Xi_core_u_trip 0.034625f
Ctic988 VDDA__Xi_core_u_trip i_core_dac_hard_3___Xi_core_u_trip 0.096375f
Ctic989 VDDA__Xi_core_u_trip i_core_dac_hard_4___Xi_core_u_trip 0.144625f
Ctic990 VDDA__Xi_core_u_trip i_core_dac_hard_5___Xi_core_u_trip 0.066625f
Ctic991 VDDA__Xi_core_u_trip i_core_dac_hard_6___Xi_core_u_trip 0.137125f
Ctic992 VDDA__Xi_core_u_trip i_core_dac_hard_7___Xi_core_u_trip 0.054125f
Ctic993 VDDA__Xi_core_u_trip i_core_fast_en__Xi_core_u_gate 0.00375f
Ctic994 VDDA__Xi_core_u_trip i_core_iptat 0.02325f
Ctic995 VDDA__Xi_core_u_trip i_core_isense__Xi_core_u_trip 0.0175f
Ctic996 VDDA__Xi_core_u_trip i_core_osc_clk__Xi_core_u_osc 0.0195f
Ctic997 VDDA__Xi_core_u_trip i_core_osc_en__Xi_core_u_osc 0.894125f
Ctic998 VDDA__Xi_core_u_trip i_core_osc_trim_0___Xi_core_u_osc 0.02425f
Ctic999 VDDA__Xi_core_u_trip i_core_osc_trim_1___Xi_core_u_osc 0.008875f
Ctic1000 VDDA__Xi_core_u_trip i_core_osc_trim_2___Xi_core_u_osc 0.028625f
Ctic1001 VDDA__Xi_core_u_trip i_core_osc_trim_3___Xi_core_u_osc 0.02475f
Ctic1002 VDDA__Xi_core_u_trip i_core_pbias 0.006f
Ctic1003 VDDA__Xi_core_u_trip i_core_pcasc 0.005875f
Ctic1004 VDDA__Xi_core_u_trip i_core_sdi_i__retained_fullchip_sg13g2_antennanp_1024_320_891_000 0.0145f
Ctic1005 VDDA__Xi_core_u_trip i_core_sdo_o__Xpad16_sdo 0.0375f
Ctic1006 VDDA__Xi_core_u_trip i_core_t2f_en_12 0.010375f
Ctic1007 VDDA__Xi_core_u_trip i_core_t2f_en_33__Xi_core_u_t2f 0.136375f
Ctic1008 VDDA__Xi_core_u_trip i_core_t2f_mode_12 0.003375f
Ctic1009 VDDA__Xi_core_u_trip i_core_t2f_mode_33__Xi_core_u_t2f 0.0475f
Ctic1010 VDDA__Xi_core_u_trip i_core_temp_out_o__Xpad17_temp_out 0.022625f
Ctic1011 VDDA__Xi_core_u_trip i_core_trip_d 0.004f
Ctic1012 VDDA__Xi_core_u_trip i_core_tripped__retained_fullchip_sg13g2_antennanp_1027_200_891_000 0.1795f
Ctic1013 VDDA__Xi_core_u_trip i_core_vref 0.067f
Ctic1014 VDDA__Xi_core_u_trip i_core_vref_buf__Xi_core_u_trip 0.057625f
Ctic1015 VDDA__Xi_core_u_trip net__Xi_core_u_digital_1 0.024f
Ctic1016 VDD__Xi_core_u_digital VREF 0.0075f
Ctic1017 VDD__Xi_core_u_digital VSS 193.95f
Ctic1018 VDD__Xi_core_u_digital VSS__Xi_core_u_bgr 0.000625f
Ctic1019 VDD__Xi_core_u_digital VSS__Xi_core_u_digital 48.3766f
Ctic1020 VDD__Xi_core_u_digital VSS__Xi_core_u_digital_1 0.100579f
Ctic1021 VDD__Xi_core_u_digital VSS__Xi_core_u_dose 0.100579f
Ctic1022 VDD__Xi_core_u_digital VSS__Xi_core_u_dut 0.100579f
Ctic1023 VDD__Xi_core_u_digital VSS__Xi_core_u_gate 0.100579f
Ctic1024 VDD__Xi_core_u_digital VSS__Xi_core_u_ls_en 0.100579f
Ctic1025 VDD__Xi_core_u_digital VSS__Xi_core_u_ls_mode 0.100579f
Ctic1026 VDD__Xi_core_u_digital VSS__Xi_core_u_ls_r4 0.100579f
Ctic1027 VDD__Xi_core_u_digital VSS__Xi_core_u_osc 0.100579f
Ctic1028 VDD__Xi_core_u_digital VSS__Xi_core_u_sense 0.100579f
Ctic1029 VDD__Xi_core_u_digital VSS__Xi_core_u_t2f 0.100579f
Ctic1030 VDD__Xi_core_u_digital VSS__Xi_core_u_trip 0.100579f
Ctic1031 VDD__Xi_core_u_digital VSS__retained_fullchip_sg13g2_antennanp_1020_000_891_000 0.100579f
Ctic1032 VDD__Xi_core_u_digital VSS__retained_fullchip_sg13g2_antennanp_1021_440_891_000 0.100579f
Ctic1033 VDD__Xi_core_u_digital VSS__retained_fullchip_sg13g2_antennanp_1022_880_891_000 0.100579f
Ctic1034 VDD__Xi_core_u_digital VSS__retained_fullchip_sg13g2_antennanp_1024_320_891_000 0.100579f
Ctic1035 VDD__Xi_core_u_digital VSS__retained_fullchip_sg13g2_antennanp_1025_760_891_000 0.100579f
Ctic1036 VDD__Xi_core_u_digital VSS__retained_fullchip_sg13g2_antennanp_1027_200_891_000 0.100579f
Ctic1037 VDD__Xi_core_u_digital _nc2__Xpad08_sense_p 0.000125f
Ctic1038 VDD__Xi_core_u_digital _nc5__Xpad20_d_std 0.000125f
Ctic1039 VDD__Xi_core_u_digital en_i 0.187938f
Ctic1040 VDD__Xi_core_u_digital fault_n_o 0.0639375f
Ctic1042 VDD__Xi_core_u_digital gate_o 0.036375f
Ctic1043 VDD__Xi_core_u_digital i_core_bgr_r4_12 0.044375f
Ctic1044 VDD__Xi_core_u_digital i_core_bgr_r4_33__Xi_core_u_ls_r4 0.597562f
Ctic1045 VDD__Xi_core_u_digital i_core_clr_d 0.01225f
Ctic1046 VDD__Xi_core_u_digital i_core_cmp_clk 0.0428125f
Ctic1047 VDD__Xi_core_u_digital i_core_cmp_hard 0.061375f
Ctic1048 VDD__Xi_core_u_digital i_core_cmp_soft 0.180188f
Ctic1049 VDD__Xi_core_u_digital i_core_dac_hard_0_ 0.0204375f
Ctic1050 VDD__Xi_core_u_digital i_core_dac_hard_1_ 0.00875f
Ctic1051 VDD__Xi_core_u_digital i_core_dac_hard_2_ 0.00875f
Ctic1052 VDD__Xi_core_u_digital i_core_dac_hard_3_ 0.133313f
Ctic1053 VDD__Xi_core_u_digital i_core_dac_hard_4_ 0.0356875f
Ctic1054 VDD__Xi_core_u_digital i_core_dac_hard_5_ 0.050375f
Ctic1055 VDD__Xi_core_u_digital i_core_dac_hard_6_ 0.058375f
Ctic1056 VDD__Xi_core_u_digital i_core_dac_hard_7_ 0.120625f
Ctic1057 VDD__Xi_core_u_digital i_core_dac_soft_0_ 0.008f
Ctic1058 VDD__Xi_core_u_digital i_core_dac_soft_1_ 0.0140625f
Ctic1059 VDD__Xi_core_u_digital i_core_dac_soft_2_ 0.0344375f
Ctic1060 VDD__Xi_core_u_digital i_core_dac_soft_3_ 0.0175f
Ctic1061 VDD__Xi_core_u_digital i_core_dac_soft_4_ 0.0130625f
Ctic1062 VDD__Xi_core_u_digital i_core_dac_soft_5_ 0.00925f
Ctic1063 VDD__Xi_core_u_digital i_core_dac_soft_6_ 0.0815f
Ctic1064 VDD__Xi_core_u_digital i_core_dac_soft_7_ 0.0023125f
Ctic1065 VDD__Xi_core_u_digital i_core_dvbe__Xi_core_u_bgr 0.0015625f
Ctic1066 VDD__Xi_core_u_digital i_core_fast_en 0.043f
Ctic1067 VDD__Xi_core_u_digital i_core_iptat 0.0885625f
Ctic1068 VDD__Xi_core_u_digital i_core_isense 0.01425f
Ctic1069 VDD__Xi_core_u_digital i_core_osc_clk 0.048375f
Ctic1070 VDD__Xi_core_u_digital i_core_osc_en 0.0509375f
Ctic1071 VDD__Xi_core_u_digital i_core_osc_trim_0_ 0.0695625f
Ctic1072 VDD__Xi_core_u_digital i_core_osc_trim_1_ 0.012375f
Ctic1073 VDD__Xi_core_u_digital i_core_osc_trim_2_ 0.0578125f
Ctic1074 VDD__Xi_core_u_digital i_core_osc_trim_3_ 0.0169375f
Ctic1075 VDD__Xi_core_u_digital i_core_pbias 0.017125f
Ctic1076 VDD__Xi_core_u_digital i_core_pcasc 0.316812f
Ctic1077 VDD__Xi_core_u_digital i_core_sclk_i 0.0598125f
Ctic1078 VDD__Xi_core_u_digital i_core_sclk_i__Xpad14_sclk 0.0001875f
Ctic1079 VDD__Xi_core_u_digital i_core_sdi_i 0.2535f
Ctic1080 VDD__Xi_core_u_digital i_core_sdo_o 1.609f
Ctic1081 VDD__Xi_core_u_digital i_core_t2f_en_12 0.030625f
Ctic1082 VDD__Xi_core_u_digital i_core_t2f_en_33 0.109937f
Ctic1083 VDD__Xi_core_u_digital i_core_t2f_mode_12 0.0219375f
Ctic1084 VDD__Xi_core_u_digital i_core_t2f_mode_33 0.071125f
Ctic1085 VDD__Xi_core_u_digital i_core_temp_out_o__Xpad17_temp_out 0.155875f
Ctic1086 VDD__Xi_core_u_digital i_core_trip_d 0.031625f
Ctic1087 VDD__Xi_core_u_digital i_core_tripped 0.124313f
Ctic1088 VDD__Xi_core_u_digital i_core_vref 0.0975625f
Ctic1090 VDD__Xi_core_u_digital net 0.20775f
Ctic1091 VDD__Xi_core_u_digital_1 VREF 0.0075f
Ctic1092 VDD__Xi_core_u_digital_1 VSS 193.85f
Ctic1093 VDD__Xi_core_u_digital_1 VSS__Xi_core_u_bgr 0.000625f
Ctic1094 VDD__Xi_core_u_digital_1 VSS__Xi_core_u_digital 0.119438f
Ctic1095 VDD__Xi_core_u_digital_1 VSS__Xi_core_u_digital_1 48.1566f
Ctic1096 VDD__Xi_core_u_digital_1 _nc2__Xpad08_sense_p 0.000125f
Ctic1097 VDD__Xi_core_u_digital_1 _nc5__Xpad20_d_std 0.000125f
Ctic1098 VDD__Xi_core_u_digital_1 en_i__Xpad12_en 0.187938f
Ctic1099 VDD__Xi_core_u_digital_1 fault_n_o__Xpad11_fault_n 0.0639375f
Ctic1100 VDD__Xi_core_u_digital_1 gate_o__Xpad10_gate 0.036375f
Ctic1101 VDD__Xi_core_u_digital_1 i_core_bgr_r4_12 0.044375f
Ctic1102 VDD__Xi_core_u_digital_1 i_core_bgr_r4_33 0.597562f
Ctic1103 VDD__Xi_core_u_digital_1 i_core_clr_d 0.01225f
Ctic1104 VDD__Xi_core_u_digital_1 i_core_cmp_clk__Xi_core_u_trip 0.0428125f
Ctic1105 VDD__Xi_core_u_digital_1 i_core_cmp_hard__Xi_core_u_trip 0.061375f
Ctic1106 VDD__Xi_core_u_digital_1 i_core_cmp_soft__retained_fullchip_sg13g2_antennanp_1022_880_891_000 0.180188f
Ctic1107 VDD__Xi_core_u_digital_1 i_core_dac_hard_0___Xi_core_u_trip 0.0204375f
Ctic1108 VDD__Xi_core_u_digital_1 i_core_dac_hard_1___Xi_core_u_trip 0.00875f
Ctic1109 VDD__Xi_core_u_digital_1 i_core_dac_hard_2___Xi_core_u_trip 0.00875f
Ctic1110 VDD__Xi_core_u_digital_1 i_core_dac_hard_3___Xi_core_u_trip 0.133313f
Ctic1111 VDD__Xi_core_u_digital_1 i_core_dac_hard_4___Xi_core_u_trip 0.0356875f
Ctic1112 VDD__Xi_core_u_digital_1 i_core_dac_hard_5___Xi_core_u_trip 0.050375f
Ctic1113 VDD__Xi_core_u_digital_1 i_core_dac_hard_6___Xi_core_u_trip 0.058375f
Ctic1114 VDD__Xi_core_u_digital_1 i_core_dac_hard_7___Xi_core_u_trip 0.120625f
Ctic1115 VDD__Xi_core_u_digital_1 i_core_dac_soft_0___Xi_core_u_trip 0.008f
Ctic1116 VDD__Xi_core_u_digital_1 i_core_dac_soft_1___Xi_core_u_trip 0.0140625f
Ctic1117 VDD__Xi_core_u_digital_1 i_core_dac_soft_2___Xi_core_u_trip 0.0344375f
Ctic1118 VDD__Xi_core_u_digital_1 i_core_dac_soft_3___Xi_core_u_trip 0.0175f
Ctic1119 VDD__Xi_core_u_digital_1 i_core_dac_soft_4___Xi_core_u_trip 0.0130625f
Ctic1120 VDD__Xi_core_u_digital_1 i_core_dac_soft_5___Xi_core_u_trip 0.00925f
Ctic1121 VDD__Xi_core_u_digital_1 i_core_dac_soft_6___Xi_core_u_trip 0.0815f
Ctic1122 VDD__Xi_core_u_digital_1 i_core_dac_soft_7___Xi_core_u_trip 0.0023125f
Ctic1123 VDD__Xi_core_u_digital_1 i_core_dvbe__Xi_core_u_bgr 0.0015625f
Ctic1124 VDD__Xi_core_u_digital_1 i_core_fast_en__Xi_core_u_gate 0.043f
Ctic1125 VDD__Xi_core_u_digital_1 i_core_iptat__Xi_core_u_sense 0.0885625f
Ctic1126 VDD__Xi_core_u_digital_1 i_core_isense 0.01425f
Ctic1127 VDD__Xi_core_u_digital_1 i_core_osc_clk__Xi_core_u_osc 0.048375f
Ctic1128 VDD__Xi_core_u_digital_1 i_core_osc_en__Xi_core_u_osc 0.0509375f
Ctic1129 VDD__Xi_core_u_digital_1 i_core_osc_trim_0___Xi_core_u_osc 0.0695625f
Ctic1130 VDD__Xi_core_u_digital_1 i_core_osc_trim_1___Xi_core_u_osc 0.012375f
Ctic1131 VDD__Xi_core_u_digital_1 i_core_osc_trim_2___Xi_core_u_osc 0.0578125f
Ctic1132 VDD__Xi_core_u_digital_1 i_core_osc_trim_3___Xi_core_u_osc 0.0169375f
Ctic1133 VDD__Xi_core_u_digital_1 i_core_pbias__Xi_core_u_t2f 0.017125f
Ctic1134 VDD__Xi_core_u_digital_1 i_core_pcasc__Xi_core_u_t2f 0.316812f
Ctic1135 VDD__Xi_core_u_digital_1 i_core_sclk_i 0.0598125f
Ctic1136 VDD__Xi_core_u_digital_1 i_core_sclk_i__Xpad14_sclk 0.0001875f
Ctic1137 VDD__Xi_core_u_digital_1 i_core_sdi_i__retained_fullchip_sg13g2_antennanp_1024_320_891_000 0.2535f
Ctic1138 VDD__Xi_core_u_digital_1 i_core_sdo_o__Xpad16_sdo 1.609f
Ctic1139 VDD__Xi_core_u_digital_1 i_core_t2f_en_12 0.030625f
Ctic1140 VDD__Xi_core_u_digital_1 i_core_t2f_en_33__Xi_core_u_t2f 0.109937f
Ctic1141 VDD__Xi_core_u_digital_1 i_core_t2f_mode_12 0.0219375f
Ctic1142 VDD__Xi_core_u_digital_1 i_core_t2f_mode_33__Xi_core_u_t2f 0.071125f
Ctic1143 VDD__Xi_core_u_digital_1 i_core_temp_out_o 0.155125f
Ctic1144 VDD__Xi_core_u_digital_1 i_core_temp_out_o__Xpad17_temp_out 0.00075f
Ctic1145 VDD__Xi_core_u_digital_1 i_core_trip_d 0.031625f
Ctic1146 VDD__Xi_core_u_digital_1 i_core_tripped__retained_fullchip_sg13g2_antennanp_1027_200_891_000 0.124313f
Ctic1147 VDD__Xi_core_u_digital_1 i_core_vref__Xpad18_vref 0.0975625f
Ctic1149 VDD__Xi_core_u_digital_1 net__Xi_core_u_digital_1 0.20775f
Ctic1150 VDD__Xi_core_u_gate VREF 0.0075f
Ctic1151 VDD__Xi_core_u_gate VSS 193.85f
Ctic1152 VDD__Xi_core_u_gate VSS__Xi_core_u_bgr 0.000625f
Ctic1153 VDD__Xi_core_u_gate VSS__Xi_core_u_digital 0.119438f
Ctic1154 VDD__Xi_core_u_gate VSS__Xi_core_u_ls_r4 48.1566f
Ctic1155 VDD__Xi_core_u_gate _nc2__Xpad08_sense_p 0.000125f
Ctic1156 VDD__Xi_core_u_gate _nc5__Xpad20_d_std 0.000125f
Ctic1157 VDD__Xi_core_u_gate en_i__Xi_core_u_gate 0.187938f
Ctic1158 VDD__Xi_core_u_gate fault_n_o 0.0639375f
Ctic1160 VDD__Xi_core_u_gate gate_o 0.036375f
Ctic1161 VDD__Xi_core_u_gate i_core_bgr_r4_12__Xi_core_u_ls_r4 0.044375f
Ctic1162 VDD__Xi_core_u_gate i_core_bgr_r4_33__Xi_core_u_ls_r4 0.597562f
Ctic1163 VDD__Xi_core_u_gate i_core_clr_d__Xi_core_u_gate 0.01225f
Ctic1164 VDD__Xi_core_u_gate i_core_cmp_clk 0.0428125f
Ctic1165 VDD__Xi_core_u_gate i_core_cmp_hard__Xi_core_u_gate 0.061375f
Ctic1166 VDD__Xi_core_u_gate i_core_cmp_soft 0.180188f
Ctic1167 VDD__Xi_core_u_gate i_core_dac_hard_0_ 0.0204375f
Ctic1168 VDD__Xi_core_u_gate i_core_dac_hard_1_ 0.00875f
Ctic1169 VDD__Xi_core_u_gate i_core_dac_hard_2_ 0.00875f
Ctic1170 VDD__Xi_core_u_gate i_core_dac_hard_3_ 0.133313f
Ctic1171 VDD__Xi_core_u_gate i_core_dac_hard_4_ 0.0356875f
Ctic1172 VDD__Xi_core_u_gate i_core_dac_hard_5_ 0.050375f
Ctic1173 VDD__Xi_core_u_gate i_core_dac_hard_6_ 0.058375f
Ctic1174 VDD__Xi_core_u_gate i_core_dac_hard_7_ 0.120625f
Ctic1175 VDD__Xi_core_u_gate i_core_dac_soft_0___Xi_core_u_trip 0.008f
Ctic1176 VDD__Xi_core_u_gate i_core_dac_soft_1___Xi_core_u_trip 0.0140625f
Ctic1177 VDD__Xi_core_u_gate i_core_dac_soft_2___Xi_core_u_trip 0.0344375f
Ctic1178 VDD__Xi_core_u_gate i_core_dac_soft_3___Xi_core_u_trip 0.0175f
Ctic1179 VDD__Xi_core_u_gate i_core_dac_soft_4___Xi_core_u_trip 0.0130625f
Ctic1180 VDD__Xi_core_u_gate i_core_dac_soft_5___Xi_core_u_trip 0.00925f
Ctic1181 VDD__Xi_core_u_gate i_core_dac_soft_6___Xi_core_u_trip 0.0815f
Ctic1182 VDD__Xi_core_u_gate i_core_dac_soft_7___Xi_core_u_trip 0.0023125f
Ctic1183 VDD__Xi_core_u_gate i_core_dvbe__Xi_core_u_bgr 0.0015625f
Ctic1184 VDD__Xi_core_u_gate i_core_fast_en__Xi_core_u_gate 0.043f
Ctic1185 VDD__Xi_core_u_gate i_core_iptat__Xi_core_u_sense 0.0885625f
Ctic1186 VDD__Xi_core_u_gate i_core_isense 0.01425f
Ctic1187 VDD__Xi_core_u_gate i_core_osc_clk 0.048375f
Ctic1188 VDD__Xi_core_u_gate i_core_osc_en 0.0509375f
Ctic1189 VDD__Xi_core_u_gate i_core_osc_trim_0_ 0.0695625f
Ctic1190 VDD__Xi_core_u_gate i_core_osc_trim_1_ 0.012375f
Ctic1191 VDD__Xi_core_u_gate i_core_osc_trim_2_ 0.0578125f
Ctic1192 VDD__Xi_core_u_gate i_core_osc_trim_3_ 0.0169375f
Ctic1193 VDD__Xi_core_u_gate i_core_pbias 0.017125f
Ctic1194 VDD__Xi_core_u_gate i_core_pcasc 0.316812f
Ctic1195 VDD__Xi_core_u_gate i_core_sclk_i 0.0598125f
Ctic1196 VDD__Xi_core_u_gate i_core_sclk_i__Xpad14_sclk 0.0001875f
Ctic1197 VDD__Xi_core_u_gate i_core_sdi_i 0.2535f
Ctic1198 VDD__Xi_core_u_gate i_core_sdo_o 1.609f
Ctic1199 VDD__Xi_core_u_gate i_core_t2f_en_12__Xi_core_u_ls_en 0.030625f
Ctic1200 VDD__Xi_core_u_gate i_core_t2f_en_33 0.109937f
Ctic1201 VDD__Xi_core_u_gate i_core_t2f_mode_12__Xi_core_u_ls_mode 0.0219375f
Ctic1202 VDD__Xi_core_u_gate i_core_t2f_mode_33 0.071125f
Ctic1203 VDD__Xi_core_u_gate i_core_temp_out_o__Xpad17_temp_out 0.155875f
Ctic1204 VDD__Xi_core_u_gate i_core_trip_d__Xi_core_u_gate 0.031625f
Ctic1205 VDD__Xi_core_u_gate i_core_tripped 0.124313f
Ctic1206 VDD__Xi_core_u_gate i_core_vref__Xi_core_u_sense 0.0975625f
Ctic1208 VDD__Xi_core_u_gate net 0.20775f
Ctic1209 VDD__Xi_core_u_ls_en VREF 0.0075f
Ctic1210 VDD__Xi_core_u_ls_en VSS 193.85f
Ctic1211 VDD__Xi_core_u_ls_en VSS__Xi_core_u_bgr 0.000625f
Ctic1212 VDD__Xi_core_u_ls_en VSS__Xi_core_u_digital 0.119438f
Ctic1213 VDD__Xi_core_u_ls_en VSS__Xi_core_u_ls_en 48.1566f
Ctic1214 VDD__Xi_core_u_ls_en _nc2__Xpad08_sense_p 0.000125f
Ctic1215 VDD__Xi_core_u_ls_en _nc5__Xpad20_d_std 0.000125f
Ctic1216 VDD__Xi_core_u_ls_en en_i__Xi_core_u_gate 0.187938f
Ctic1217 VDD__Xi_core_u_ls_en fault_n_o 0.0639375f
Ctic1219 VDD__Xi_core_u_ls_en gate_o 0.036375f
Ctic1220 VDD__Xi_core_u_ls_en i_core_bgr_r4_12__Xi_core_u_ls_r4 0.044375f
Ctic1221 VDD__Xi_core_u_ls_en i_core_bgr_r4_33__Xi_core_u_ls_r4 0.597562f
Ctic1222 VDD__Xi_core_u_ls_en i_core_clr_d__Xi_core_u_gate 0.01225f
Ctic1223 VDD__Xi_core_u_ls_en i_core_cmp_clk 0.0428125f
Ctic1224 VDD__Xi_core_u_ls_en i_core_cmp_hard__Xi_core_u_gate 0.061375f
Ctic1225 VDD__Xi_core_u_ls_en i_core_cmp_soft 0.180188f
Ctic1226 VDD__Xi_core_u_ls_en i_core_dac_hard_0_ 0.0204375f
Ctic1227 VDD__Xi_core_u_ls_en i_core_dac_hard_1_ 0.00875f
Ctic1228 VDD__Xi_core_u_ls_en i_core_dac_hard_2_ 0.00875f
Ctic1229 VDD__Xi_core_u_ls_en i_core_dac_hard_3_ 0.133313f
Ctic1230 VDD__Xi_core_u_ls_en i_core_dac_hard_4_ 0.0356875f
Ctic1231 VDD__Xi_core_u_ls_en i_core_dac_hard_5_ 0.050375f
Ctic1232 VDD__Xi_core_u_ls_en i_core_dac_hard_6_ 0.058375f
Ctic1233 VDD__Xi_core_u_ls_en i_core_dac_hard_7_ 0.120625f
Ctic1234 VDD__Xi_core_u_ls_en i_core_dac_soft_0___Xi_core_u_trip 0.008f
Ctic1235 VDD__Xi_core_u_ls_en i_core_dac_soft_1___Xi_core_u_trip 0.0140625f
Ctic1236 VDD__Xi_core_u_ls_en i_core_dac_soft_2___Xi_core_u_trip 0.0344375f
Ctic1237 VDD__Xi_core_u_ls_en i_core_dac_soft_3___Xi_core_u_trip 0.0175f
Ctic1238 VDD__Xi_core_u_ls_en i_core_dac_soft_4___Xi_core_u_trip 0.0130625f
Ctic1239 VDD__Xi_core_u_ls_en i_core_dac_soft_5___Xi_core_u_trip 0.00925f
Ctic1240 VDD__Xi_core_u_ls_en i_core_dac_soft_6___Xi_core_u_trip 0.0815f
Ctic1241 VDD__Xi_core_u_ls_en i_core_dac_soft_7___Xi_core_u_trip 0.0023125f
Ctic1242 VDD__Xi_core_u_ls_en i_core_dvbe__Xi_core_u_bgr 0.0015625f
Ctic1243 VDD__Xi_core_u_ls_en i_core_fast_en__Xi_core_u_gate 0.043f
Ctic1244 VDD__Xi_core_u_ls_en i_core_iptat__Xi_core_u_sense 0.0885625f
Ctic1245 VDD__Xi_core_u_ls_en i_core_isense 0.01425f
Ctic1246 VDD__Xi_core_u_ls_en i_core_osc_clk 0.048375f
Ctic1247 VDD__Xi_core_u_ls_en i_core_osc_en 0.0509375f
Ctic1248 VDD__Xi_core_u_ls_en i_core_osc_trim_0_ 0.0695625f
Ctic1249 VDD__Xi_core_u_ls_en i_core_osc_trim_1_ 0.012375f
Ctic1250 VDD__Xi_core_u_ls_en i_core_osc_trim_2_ 0.0578125f
Ctic1251 VDD__Xi_core_u_ls_en i_core_osc_trim_3_ 0.0169375f
Ctic1252 VDD__Xi_core_u_ls_en i_core_pbias 0.017125f
Ctic1253 VDD__Xi_core_u_ls_en i_core_pcasc 0.316812f
Ctic1254 VDD__Xi_core_u_ls_en i_core_sclk_i 0.0598125f
Ctic1255 VDD__Xi_core_u_ls_en i_core_sclk_i__Xpad14_sclk 0.0001875f
Ctic1256 VDD__Xi_core_u_ls_en i_core_sdi_i 0.2535f
Ctic1257 VDD__Xi_core_u_ls_en i_core_sdo_o 1.609f
Ctic1258 VDD__Xi_core_u_ls_en i_core_t2f_en_12__Xi_core_u_ls_en 0.030625f
Ctic1259 VDD__Xi_core_u_ls_en i_core_t2f_en_33 0.109937f
Ctic1260 VDD__Xi_core_u_ls_en i_core_t2f_mode_12__Xi_core_u_ls_mode 0.0219375f
Ctic1261 VDD__Xi_core_u_ls_en i_core_t2f_mode_33 0.071125f
Ctic1262 VDD__Xi_core_u_ls_en i_core_temp_out_o__Xpad17_temp_out 0.155875f
Ctic1263 VDD__Xi_core_u_ls_en i_core_trip_d__Xi_core_u_gate 0.031625f
Ctic1264 VDD__Xi_core_u_ls_en i_core_tripped 0.124313f
Ctic1265 VDD__Xi_core_u_ls_en i_core_vref__Xi_core_u_sense 0.0975625f
Ctic1267 VDD__Xi_core_u_ls_en net 0.20775f
Ctic1268 VDD__Xi_core_u_ls_mode VREF 0.0075f
Ctic1269 VDD__Xi_core_u_ls_mode VSS 193.85f
Ctic1270 VDD__Xi_core_u_ls_mode VSS__Xi_core_u_bgr 0.000625f
Ctic1271 VDD__Xi_core_u_ls_mode VSS__Xi_core_u_digital 0.119438f
Ctic1272 VDD__Xi_core_u_ls_mode VSS__Xi_core_u_ls_mode 48.1566f
Ctic1273 VDD__Xi_core_u_ls_mode _nc2__Xpad08_sense_p 0.000125f
Ctic1274 VDD__Xi_core_u_ls_mode _nc5__Xpad20_d_std 0.000125f
Ctic1275 VDD__Xi_core_u_ls_mode en_i__Xi_core_u_gate 0.187938f
Ctic1276 VDD__Xi_core_u_ls_mode fault_n_o 0.0639375f
Ctic1278 VDD__Xi_core_u_ls_mode gate_o 0.036375f
Ctic1279 VDD__Xi_core_u_ls_mode i_core_bgr_r4_12__Xi_core_u_ls_r4 0.044375f
Ctic1280 VDD__Xi_core_u_ls_mode i_core_bgr_r4_33__Xi_core_u_ls_r4 0.597562f
Ctic1281 VDD__Xi_core_u_ls_mode i_core_clr_d__Xi_core_u_gate 0.01225f
Ctic1282 VDD__Xi_core_u_ls_mode i_core_cmp_clk 0.0428125f
Ctic1283 VDD__Xi_core_u_ls_mode i_core_cmp_hard__Xi_core_u_gate 0.061375f
Ctic1284 VDD__Xi_core_u_ls_mode i_core_cmp_soft 0.180188f
Ctic1285 VDD__Xi_core_u_ls_mode i_core_dac_hard_0_ 0.0204375f
Ctic1286 VDD__Xi_core_u_ls_mode i_core_dac_hard_1_ 0.00875f
Ctic1287 VDD__Xi_core_u_ls_mode i_core_dac_hard_2_ 0.00875f
Ctic1288 VDD__Xi_core_u_ls_mode i_core_dac_hard_3_ 0.133313f
Ctic1289 VDD__Xi_core_u_ls_mode i_core_dac_hard_4_ 0.0356875f
Ctic1290 VDD__Xi_core_u_ls_mode i_core_dac_hard_5_ 0.050375f
Ctic1291 VDD__Xi_core_u_ls_mode i_core_dac_hard_6_ 0.058375f
Ctic1292 VDD__Xi_core_u_ls_mode i_core_dac_hard_7_ 0.120625f
Ctic1293 VDD__Xi_core_u_ls_mode i_core_dac_soft_0___Xi_core_u_trip 0.008f
Ctic1294 VDD__Xi_core_u_ls_mode i_core_dac_soft_1___Xi_core_u_trip 0.0140625f
Ctic1295 VDD__Xi_core_u_ls_mode i_core_dac_soft_2___Xi_core_u_trip 0.0344375f
Ctic1296 VDD__Xi_core_u_ls_mode i_core_dac_soft_3___Xi_core_u_trip 0.0175f
Ctic1297 VDD__Xi_core_u_ls_mode i_core_dac_soft_4___Xi_core_u_trip 0.0130625f
Ctic1298 VDD__Xi_core_u_ls_mode i_core_dac_soft_5___Xi_core_u_trip 0.00925f
Ctic1299 VDD__Xi_core_u_ls_mode i_core_dac_soft_6___Xi_core_u_trip 0.0815f
Ctic1300 VDD__Xi_core_u_ls_mode i_core_dac_soft_7___Xi_core_u_trip 0.0023125f
Ctic1301 VDD__Xi_core_u_ls_mode i_core_dvbe__Xi_core_u_bgr 0.0015625f
Ctic1302 VDD__Xi_core_u_ls_mode i_core_fast_en__Xi_core_u_gate 0.043f
Ctic1303 VDD__Xi_core_u_ls_mode i_core_iptat__Xi_core_u_sense 0.0885625f
Ctic1304 VDD__Xi_core_u_ls_mode i_core_isense 0.01425f
Ctic1305 VDD__Xi_core_u_ls_mode i_core_osc_clk 0.048375f
Ctic1306 VDD__Xi_core_u_ls_mode i_core_osc_en 0.0509375f
Ctic1307 VDD__Xi_core_u_ls_mode i_core_osc_trim_0_ 0.0695625f
Ctic1308 VDD__Xi_core_u_ls_mode i_core_osc_trim_1_ 0.012375f
Ctic1309 VDD__Xi_core_u_ls_mode i_core_osc_trim_2_ 0.0578125f
Ctic1310 VDD__Xi_core_u_ls_mode i_core_osc_trim_3_ 0.0169375f
Ctic1311 VDD__Xi_core_u_ls_mode i_core_pbias 0.017125f
Ctic1312 VDD__Xi_core_u_ls_mode i_core_pcasc 0.316812f
Ctic1313 VDD__Xi_core_u_ls_mode i_core_sclk_i 0.0598125f
Ctic1314 VDD__Xi_core_u_ls_mode i_core_sclk_i__Xpad14_sclk 0.0001875f
Ctic1315 VDD__Xi_core_u_ls_mode i_core_sdi_i 0.2535f
Ctic1316 VDD__Xi_core_u_ls_mode i_core_sdo_o 1.609f
Ctic1317 VDD__Xi_core_u_ls_mode i_core_t2f_en_12__Xi_core_u_ls_en 0.030625f
Ctic1318 VDD__Xi_core_u_ls_mode i_core_t2f_en_33 0.109937f
Ctic1319 VDD__Xi_core_u_ls_mode i_core_t2f_mode_12__Xi_core_u_ls_mode 0.0219375f
Ctic1320 VDD__Xi_core_u_ls_mode i_core_t2f_mode_33 0.071125f
Ctic1321 VDD__Xi_core_u_ls_mode i_core_temp_out_o__Xpad17_temp_out 0.155875f
Ctic1322 VDD__Xi_core_u_ls_mode i_core_trip_d__Xi_core_u_gate 0.031625f
Ctic1323 VDD__Xi_core_u_ls_mode i_core_tripped 0.124313f
Ctic1324 VDD__Xi_core_u_ls_mode i_core_vref__Xi_core_u_sense 0.0975625f
Ctic1326 VDD__Xi_core_u_ls_mode net 0.20775f
Ctic1327 VDD__Xi_core_u_ls_r4 VREF 0.0075f
Ctic1328 VDD__Xi_core_u_ls_r4 VSS 193.85f
Ctic1329 VDD__Xi_core_u_ls_r4 VSS__Xi_core_u_bgr 0.000625f
Ctic1330 VDD__Xi_core_u_ls_r4 VSS__Xi_core_u_digital 0.119438f
Ctic1331 VDD__Xi_core_u_ls_r4 VSS__Xi_core_u_ls_r4 48.1566f
Ctic1332 VDD__Xi_core_u_ls_r4 _nc2__Xpad08_sense_p 0.000125f
Ctic1333 VDD__Xi_core_u_ls_r4 _nc5__Xpad20_d_std 0.000125f
Ctic1334 VDD__Xi_core_u_ls_r4 en_i__Xi_core_u_gate 0.187938f
Ctic1335 VDD__Xi_core_u_ls_r4 fault_n_o 0.0639375f
Ctic1337 VDD__Xi_core_u_ls_r4 gate_o 0.036375f
Ctic1338 VDD__Xi_core_u_ls_r4 i_core_bgr_r4_12__Xi_core_u_ls_r4 0.044375f
Ctic1339 VDD__Xi_core_u_ls_r4 i_core_bgr_r4_33__Xi_core_u_ls_r4 0.597562f
Ctic1340 VDD__Xi_core_u_ls_r4 i_core_clr_d__Xi_core_u_gate 0.01225f
Ctic1341 VDD__Xi_core_u_ls_r4 i_core_cmp_clk 0.0428125f
Ctic1342 VDD__Xi_core_u_ls_r4 i_core_cmp_hard__Xi_core_u_gate 0.061375f
Ctic1343 VDD__Xi_core_u_ls_r4 i_core_cmp_soft 0.180188f
Ctic1344 VDD__Xi_core_u_ls_r4 i_core_dac_hard_0_ 0.0204375f
Ctic1345 VDD__Xi_core_u_ls_r4 i_core_dac_hard_1_ 0.00875f
Ctic1346 VDD__Xi_core_u_ls_r4 i_core_dac_hard_2_ 0.00875f
Ctic1347 VDD__Xi_core_u_ls_r4 i_core_dac_hard_3_ 0.133313f
Ctic1348 VDD__Xi_core_u_ls_r4 i_core_dac_hard_4_ 0.0356875f
Ctic1349 VDD__Xi_core_u_ls_r4 i_core_dac_hard_5_ 0.050375f
Ctic1350 VDD__Xi_core_u_ls_r4 i_core_dac_hard_6_ 0.058375f
Ctic1351 VDD__Xi_core_u_ls_r4 i_core_dac_hard_7_ 0.120625f
Ctic1352 VDD__Xi_core_u_ls_r4 i_core_dac_soft_0___Xi_core_u_trip 0.008f
Ctic1353 VDD__Xi_core_u_ls_r4 i_core_dac_soft_1___Xi_core_u_trip 0.0140625f
Ctic1354 VDD__Xi_core_u_ls_r4 i_core_dac_soft_2___Xi_core_u_trip 0.0344375f
Ctic1355 VDD__Xi_core_u_ls_r4 i_core_dac_soft_3___Xi_core_u_trip 0.0175f
Ctic1356 VDD__Xi_core_u_ls_r4 i_core_dac_soft_4___Xi_core_u_trip 0.0130625f
Ctic1357 VDD__Xi_core_u_ls_r4 i_core_dac_soft_5___Xi_core_u_trip 0.00925f
Ctic1358 VDD__Xi_core_u_ls_r4 i_core_dac_soft_6___Xi_core_u_trip 0.0815f
Ctic1359 VDD__Xi_core_u_ls_r4 i_core_dac_soft_7___Xi_core_u_trip 0.0023125f
Ctic1360 VDD__Xi_core_u_ls_r4 i_core_dvbe__Xi_core_u_bgr 0.0015625f
Ctic1361 VDD__Xi_core_u_ls_r4 i_core_fast_en__Xi_core_u_gate 0.043f
Ctic1362 VDD__Xi_core_u_ls_r4 i_core_iptat__Xi_core_u_sense 0.0885625f
Ctic1363 VDD__Xi_core_u_ls_r4 i_core_isense 0.01425f
Ctic1364 VDD__Xi_core_u_ls_r4 i_core_osc_clk 0.048375f
Ctic1365 VDD__Xi_core_u_ls_r4 i_core_osc_en 0.0509375f
Ctic1366 VDD__Xi_core_u_ls_r4 i_core_osc_trim_0_ 0.0695625f
Ctic1367 VDD__Xi_core_u_ls_r4 i_core_osc_trim_1_ 0.012375f
Ctic1368 VDD__Xi_core_u_ls_r4 i_core_osc_trim_2_ 0.0578125f
Ctic1369 VDD__Xi_core_u_ls_r4 i_core_osc_trim_3_ 0.0169375f
Ctic1370 VDD__Xi_core_u_ls_r4 i_core_pbias 0.017125f
Ctic1371 VDD__Xi_core_u_ls_r4 i_core_pcasc 0.316812f
Ctic1372 VDD__Xi_core_u_ls_r4 i_core_sclk_i 0.0598125f
Ctic1373 VDD__Xi_core_u_ls_r4 i_core_sclk_i__Xpad14_sclk 0.0001875f
Ctic1374 VDD__Xi_core_u_ls_r4 i_core_sdi_i 0.2535f
Ctic1375 VDD__Xi_core_u_ls_r4 i_core_sdo_o 1.609f
Ctic1376 VDD__Xi_core_u_ls_r4 i_core_t2f_en_12__Xi_core_u_ls_en 0.030625f
Ctic1377 VDD__Xi_core_u_ls_r4 i_core_t2f_en_33 0.109937f
Ctic1378 VDD__Xi_core_u_ls_r4 i_core_t2f_mode_12__Xi_core_u_ls_mode 0.0219375f
Ctic1379 VDD__Xi_core_u_ls_r4 i_core_t2f_mode_33 0.071125f
Ctic1380 VDD__Xi_core_u_ls_r4 i_core_temp_out_o__Xpad17_temp_out 0.155875f
Ctic1381 VDD__Xi_core_u_ls_r4 i_core_trip_d__Xi_core_u_gate 0.031625f
Ctic1382 VDD__Xi_core_u_ls_r4 i_core_tripped 0.124313f
Ctic1383 VDD__Xi_core_u_ls_r4 i_core_vref__Xi_core_u_sense 0.0975625f
Ctic1385 VDD__Xi_core_u_ls_r4 net 0.20775f
Ctic1386 VDD__Xi_core_u_osc VREF 0.0075f
Ctic1387 VDD__Xi_core_u_osc VSS 242.006f
Ctic1388 VDD__Xi_core_u_osc VSS__Xi_core_u_bgr 0.000625f
Ctic1389 VDD__Xi_core_u_osc VSS__Xi_core_u_digital 0.119438f
Ctic1390 VDD__Xi_core_u_osc _nc2__Xpad08_sense_p 0.000125f
Ctic1391 VDD__Xi_core_u_osc _nc5__Xpad20_d_std 0.000125f
Ctic1392 VDD__Xi_core_u_osc en_i__retained_fullchip_sg13g2_antennanp_1020_000_891_000 0.187938f
Ctic1393 VDD__Xi_core_u_osc fault_n_o__Xpad11_fault_n 0.0639375f
Ctic1394 VDD__Xi_core_u_osc gate_o 0.036375f
Ctic1395 VDD__Xi_core_u_osc i_core_bgr_r4_12 0.044375f
Ctic1396 VDD__Xi_core_u_osc i_core_bgr_r4_33 0.597562f
Ctic1397 VDD__Xi_core_u_osc i_core_clr_d 0.01225f
Ctic1398 VDD__Xi_core_u_osc i_core_cmp_clk__Xi_core_u_trip 0.0428125f
Ctic1399 VDD__Xi_core_u_osc i_core_cmp_hard__Xi_core_u_trip 0.061375f
Ctic1400 VDD__Xi_core_u_osc i_core_cmp_soft__Xi_core_u_trip 0.180188f
Ctic1401 VDD__Xi_core_u_osc i_core_dac_hard_0___Xi_core_u_trip 0.0204375f
Ctic1402 VDD__Xi_core_u_osc i_core_dac_hard_1___Xi_core_u_trip 0.00875f
Ctic1403 VDD__Xi_core_u_osc i_core_dac_hard_2___Xi_core_u_trip 0.00875f
Ctic1404 VDD__Xi_core_u_osc i_core_dac_hard_3___Xi_core_u_trip 0.133313f
Ctic1405 VDD__Xi_core_u_osc i_core_dac_hard_4___Xi_core_u_trip 0.0356875f
Ctic1406 VDD__Xi_core_u_osc i_core_dac_hard_5___Xi_core_u_trip 0.050375f
Ctic1407 VDD__Xi_core_u_osc i_core_dac_hard_6___Xi_core_u_trip 0.058375f
Ctic1408 VDD__Xi_core_u_osc i_core_dac_hard_7___Xi_core_u_trip 0.120625f
Ctic1409 VDD__Xi_core_u_osc i_core_dac_soft_0___Xi_core_u_trip 0.008f
Ctic1410 VDD__Xi_core_u_osc i_core_dac_soft_1___Xi_core_u_trip 0.0140625f
Ctic1411 VDD__Xi_core_u_osc i_core_dac_soft_2___Xi_core_u_trip 0.0344375f
Ctic1412 VDD__Xi_core_u_osc i_core_dac_soft_3___Xi_core_u_trip 0.0175f
Ctic1413 VDD__Xi_core_u_osc i_core_dac_soft_4___Xi_core_u_trip 0.0130625f
Ctic1414 VDD__Xi_core_u_osc i_core_dac_soft_5___Xi_core_u_trip 0.00925f
Ctic1415 VDD__Xi_core_u_osc i_core_dac_soft_6___Xi_core_u_trip 0.0815f
Ctic1416 VDD__Xi_core_u_osc i_core_dac_soft_7___Xi_core_u_trip 0.0023125f
Ctic1417 VDD__Xi_core_u_osc i_core_dvbe__Xi_core_u_bgr 0.0015625f
Ctic1418 VDD__Xi_core_u_osc i_core_fast_en 0.043f
Ctic1419 VDD__Xi_core_u_osc i_core_iptat 0.0885625f
Ctic1420 VDD__Xi_core_u_osc i_core_isense__Xi_core_u_trip 0.01425f
Ctic1421 VDD__Xi_core_u_osc i_core_osc_clk__Xi_core_u_osc 0.048375f
Ctic1422 VDD__Xi_core_u_osc i_core_osc_en__Xi_core_u_osc 0.0509375f
Ctic1423 VDD__Xi_core_u_osc i_core_osc_trim_0___Xi_core_u_osc 0.0695625f
Ctic1424 VDD__Xi_core_u_osc i_core_osc_trim_1___Xi_core_u_osc 0.012375f
Ctic1425 VDD__Xi_core_u_osc i_core_osc_trim_2___Xi_core_u_osc 0.0578125f
Ctic1426 VDD__Xi_core_u_osc i_core_osc_trim_3___Xi_core_u_osc 0.0169375f
Ctic1427 VDD__Xi_core_u_osc i_core_pbias__Xi_core_u_t2f 0.017125f
Ctic1428 VDD__Xi_core_u_osc i_core_pcasc__Xi_core_u_t2f 0.316812f
Ctic1429 VDD__Xi_core_u_osc i_core_sclk_i__Xpad14_sclk 0.06f
Ctic1430 VDD__Xi_core_u_osc i_core_sdi_i__Xpad15_sdi 0.2535f
Ctic1431 VDD__Xi_core_u_osc i_core_sdo_o__Xpad16_sdo 1.609f
Ctic1432 VDD__Xi_core_u_osc i_core_t2f_en_12 0.030625f
Ctic1433 VDD__Xi_core_u_osc i_core_t2f_en_33__Xi_core_u_t2f 0.109937f
Ctic1434 VDD__Xi_core_u_osc i_core_t2f_mode_12 0.0219375f
Ctic1435 VDD__Xi_core_u_osc i_core_t2f_mode_33__Xi_core_u_t2f 0.071125f
Ctic1436 VDD__Xi_core_u_osc i_core_temp_out_o__Xpad17_temp_out 0.155875f
Ctic1437 VDD__Xi_core_u_osc i_core_trip_d 0.031625f
Ctic1438 VDD__Xi_core_u_osc i_core_tripped__retained_fullchip_sg13g2_antennanp_1027_200_891_000 0.124313f
Ctic1439 VDD__Xi_core_u_osc i_core_vref__Xpad18_vref 0.0975625f
Ctic1441 VDD__Xi_core_u_osc net__Xi_core_u_digital_1 0.20775f
Ctic1442 VDD__Xi_core_u_t2f VREF 0.0075f
Ctic1443 VDD__Xi_core_u_t2f VSS 193.85f
Ctic1444 VDD__Xi_core_u_t2f VSS__Xi_core_u_bgr 0.000625f
Ctic1445 VDD__Xi_core_u_t2f VSS__Xi_core_u_digital 0.119438f
Ctic1446 VDD__Xi_core_u_t2f VSS__Xi_core_u_t2f 48.1566f
Ctic1447 VDD__Xi_core_u_t2f _nc2__Xpad08_sense_p 0.000125f
Ctic1448 VDD__Xi_core_u_t2f _nc5__Xpad20_d_std 0.000125f
Ctic1449 VDD__Xi_core_u_t2f en_i__Xpad12_en 0.187938f
Ctic1450 VDD__Xi_core_u_t2f fault_n_o__Xpad11_fault_n 0.0639375f
Ctic1451 VDD__Xi_core_u_t2f gate_o__Xpad10_gate 0.036375f
Ctic1452 VDD__Xi_core_u_t2f i_core_bgr_r4_12 0.044375f
Ctic1453 VDD__Xi_core_u_t2f i_core_bgr_r4_33 0.597562f
Ctic1454 VDD__Xi_core_u_t2f i_core_clr_d 0.01225f
Ctic1455 VDD__Xi_core_u_t2f i_core_cmp_clk__Xi_core_u_trip 0.0428125f
Ctic1456 VDD__Xi_core_u_t2f i_core_cmp_hard__Xi_core_u_trip 0.061375f
Ctic1457 VDD__Xi_core_u_t2f i_core_cmp_soft__Xi_core_u_trip 0.180188f
Ctic1458 VDD__Xi_core_u_t2f i_core_dac_hard_0___Xi_core_u_trip 0.0204375f
Ctic1459 VDD__Xi_core_u_t2f i_core_dac_hard_1___Xi_core_u_trip 0.00875f
Ctic1460 VDD__Xi_core_u_t2f i_core_dac_hard_2___Xi_core_u_trip 0.00875f
Ctic1461 VDD__Xi_core_u_t2f i_core_dac_hard_3___Xi_core_u_trip 0.133313f
Ctic1462 VDD__Xi_core_u_t2f i_core_dac_hard_4___Xi_core_u_trip 0.0356875f
Ctic1463 VDD__Xi_core_u_t2f i_core_dac_hard_5___Xi_core_u_trip 0.050375f
Ctic1464 VDD__Xi_core_u_t2f i_core_dac_hard_6___Xi_core_u_trip 0.058375f
Ctic1465 VDD__Xi_core_u_t2f i_core_dac_hard_7___Xi_core_u_trip 0.120625f
Ctic1466 VDD__Xi_core_u_t2f i_core_dac_soft_0___Xi_core_u_trip 0.008f
Ctic1467 VDD__Xi_core_u_t2f i_core_dac_soft_1___Xi_core_u_trip 0.0140625f
Ctic1468 VDD__Xi_core_u_t2f i_core_dac_soft_2___Xi_core_u_trip 0.0344375f
Ctic1469 VDD__Xi_core_u_t2f i_core_dac_soft_3___Xi_core_u_trip 0.0175f
Ctic1470 VDD__Xi_core_u_t2f i_core_dac_soft_4___Xi_core_u_trip 0.0130625f
Ctic1471 VDD__Xi_core_u_t2f i_core_dac_soft_5___Xi_core_u_trip 0.00925f
Ctic1472 VDD__Xi_core_u_t2f i_core_dac_soft_6___Xi_core_u_trip 0.0815f
Ctic1473 VDD__Xi_core_u_t2f i_core_dac_soft_7___Xi_core_u_trip 0.0023125f
Ctic1474 VDD__Xi_core_u_t2f i_core_dvbe__Xi_core_u_bgr 0.0015625f
Ctic1475 VDD__Xi_core_u_t2f i_core_fast_en__Xi_core_u_gate 0.043f
Ctic1476 VDD__Xi_core_u_t2f i_core_iptat 0.0885625f
Ctic1477 VDD__Xi_core_u_t2f i_core_isense__Xi_core_u_trip 0.01425f
Ctic1478 VDD__Xi_core_u_t2f i_core_osc_clk__Xi_core_u_osc 0.048375f
Ctic1479 VDD__Xi_core_u_t2f i_core_osc_en__Xi_core_u_osc 0.0509375f
Ctic1480 VDD__Xi_core_u_t2f i_core_osc_trim_0___Xi_core_u_osc 0.0695625f
Ctic1481 VDD__Xi_core_u_t2f i_core_osc_trim_1___Xi_core_u_osc 0.012375f
Ctic1482 VDD__Xi_core_u_t2f i_core_osc_trim_2___Xi_core_u_osc 0.0578125f
Ctic1483 VDD__Xi_core_u_t2f i_core_osc_trim_3___Xi_core_u_osc 0.0169375f
Ctic1484 VDD__Xi_core_u_t2f i_core_pbias__Xi_core_u_t2f 0.017125f
Ctic1485 VDD__Xi_core_u_t2f i_core_pcasc__Xi_core_u_t2f 0.316812f
Ctic1486 VDD__Xi_core_u_t2f i_core_sclk_i__Xpad14_sclk 0.06f
Ctic1487 VDD__Xi_core_u_t2f i_core_sdi_i__retained_fullchip_sg13g2_antennanp_1024_320_891_000 0.2535f
Ctic1488 VDD__Xi_core_u_t2f i_core_sdo_o__Xpad16_sdo 1.609f
Ctic1489 VDD__Xi_core_u_t2f i_core_t2f_en_12 0.030625f
Ctic1490 VDD__Xi_core_u_t2f i_core_t2f_en_33__Xi_core_u_t2f 0.109937f
Ctic1491 VDD__Xi_core_u_t2f i_core_t2f_mode_12 0.0219375f
Ctic1492 VDD__Xi_core_u_t2f i_core_t2f_mode_33__Xi_core_u_t2f 0.071125f
Ctic1493 VDD__Xi_core_u_t2f i_core_temp_out_o 0.155125f
Ctic1494 VDD__Xi_core_u_t2f i_core_temp_out_o__Xpad17_temp_out 0.00075f
Ctic1495 VDD__Xi_core_u_t2f i_core_trip_d 0.031625f
Ctic1496 VDD__Xi_core_u_t2f i_core_tripped__retained_fullchip_sg13g2_antennanp_1027_200_891_000 0.124313f
Ctic1497 VDD__Xi_core_u_t2f i_core_vref__Xpad18_vref 0.0975625f
Ctic1499 VDD__Xi_core_u_t2f net__Xi_core_u_digital_1 0.20775f
Ctic1500 VDD__Xi_core_u_trip VREF 0.0075f
Ctic1501 VDD__Xi_core_u_trip VSS 193.85f
Ctic1502 VDD__Xi_core_u_trip VSS__Xi_core_u_bgr 0.000625f
Ctic1503 VDD__Xi_core_u_trip VSS__Xi_core_u_digital 0.119438f
Ctic1504 VDD__Xi_core_u_trip VSS__Xi_core_u_osc 48.1566f
Ctic1505 VDD__Xi_core_u_trip _nc2__Xpad08_sense_p 0.000125f
Ctic1506 VDD__Xi_core_u_trip _nc5__Xpad20_d_std 0.000125f
Ctic1507 VDD__Xi_core_u_trip en_i__retained_fullchip_sg13g2_antennanp_1020_000_891_000 0.187938f
Ctic1508 VDD__Xi_core_u_trip fault_n_o__Xpad11_fault_n 0.0639375f
Ctic1509 VDD__Xi_core_u_trip gate_o 0.036375f
Ctic1510 VDD__Xi_core_u_trip i_core_bgr_r4_12 0.044375f
Ctic1511 VDD__Xi_core_u_trip i_core_bgr_r4_33 0.597562f
Ctic1512 VDD__Xi_core_u_trip i_core_clr_d 0.01225f
Ctic1513 VDD__Xi_core_u_trip i_core_cmp_clk__Xi_core_u_trip 0.0428125f
Ctic1514 VDD__Xi_core_u_trip i_core_cmp_hard__Xi_core_u_trip 0.061375f
Ctic1515 VDD__Xi_core_u_trip i_core_cmp_soft__Xi_core_u_trip 0.180188f
Ctic1516 VDD__Xi_core_u_trip i_core_dac_hard_0___Xi_core_u_trip 0.0204375f
Ctic1517 VDD__Xi_core_u_trip i_core_dac_hard_1___Xi_core_u_trip 0.00875f
Ctic1518 VDD__Xi_core_u_trip i_core_dac_hard_2___Xi_core_u_trip 0.00875f
Ctic1519 VDD__Xi_core_u_trip i_core_dac_hard_3___Xi_core_u_trip 0.133313f
Ctic1520 VDD__Xi_core_u_trip i_core_dac_hard_4___Xi_core_u_trip 0.0356875f
Ctic1521 VDD__Xi_core_u_trip i_core_dac_hard_5___Xi_core_u_trip 0.050375f
Ctic1522 VDD__Xi_core_u_trip i_core_dac_hard_6___Xi_core_u_trip 0.058375f
Ctic1523 VDD__Xi_core_u_trip i_core_dac_hard_7___Xi_core_u_trip 0.120625f
Ctic1524 VDD__Xi_core_u_trip i_core_dac_soft_0___Xi_core_u_trip 0.008f
Ctic1525 VDD__Xi_core_u_trip i_core_dac_soft_1___Xi_core_u_trip 0.0140625f
Ctic1526 VDD__Xi_core_u_trip i_core_dac_soft_2___Xi_core_u_trip 0.0344375f
Ctic1527 VDD__Xi_core_u_trip i_core_dac_soft_3___Xi_core_u_trip 0.0175f
Ctic1528 VDD__Xi_core_u_trip i_core_dac_soft_4___Xi_core_u_trip 0.0130625f
Ctic1529 VDD__Xi_core_u_trip i_core_dac_soft_5___Xi_core_u_trip 0.00925f
Ctic1530 VDD__Xi_core_u_trip i_core_dac_soft_6___Xi_core_u_trip 0.0815f
Ctic1531 VDD__Xi_core_u_trip i_core_dac_soft_7___Xi_core_u_trip 0.0023125f
Ctic1532 VDD__Xi_core_u_trip i_core_dvbe__Xi_core_u_bgr 0.0015625f
Ctic1533 VDD__Xi_core_u_trip i_core_fast_en__Xi_core_u_gate 0.043f
Ctic1534 VDD__Xi_core_u_trip i_core_iptat 0.0885625f
Ctic1535 VDD__Xi_core_u_trip i_core_isense__Xi_core_u_trip 0.01425f
Ctic1536 VDD__Xi_core_u_trip i_core_osc_clk__Xi_core_u_osc 0.048375f
Ctic1537 VDD__Xi_core_u_trip i_core_osc_en__Xi_core_u_osc 0.0509375f
Ctic1538 VDD__Xi_core_u_trip i_core_osc_trim_0___Xi_core_u_osc 0.0695625f
Ctic1539 VDD__Xi_core_u_trip i_core_osc_trim_1___Xi_core_u_osc 0.012375f
Ctic1540 VDD__Xi_core_u_trip i_core_osc_trim_2___Xi_core_u_osc 0.0578125f
Ctic1541 VDD__Xi_core_u_trip i_core_osc_trim_3___Xi_core_u_osc 0.0169375f
Ctic1542 VDD__Xi_core_u_trip i_core_pbias 0.017125f
Ctic1543 VDD__Xi_core_u_trip i_core_pcasc 0.316812f
Ctic1544 VDD__Xi_core_u_trip i_core_sclk_i 0.0598125f
Ctic1545 VDD__Xi_core_u_trip i_core_sclk_i__Xpad14_sclk 0.0001875f
Ctic1546 VDD__Xi_core_u_trip i_core_sdi_i__retained_fullchip_sg13g2_antennanp_1024_320_891_000 0.2535f
Ctic1547 VDD__Xi_core_u_trip i_core_sdo_o__Xpad16_sdo 1.609f
Ctic1548 VDD__Xi_core_u_trip i_core_t2f_en_12 0.030625f
Ctic1549 VDD__Xi_core_u_trip i_core_t2f_en_33__Xi_core_u_t2f 0.109937f
Ctic1550 VDD__Xi_core_u_trip i_core_t2f_mode_12 0.0219375f
Ctic1551 VDD__Xi_core_u_trip i_core_t2f_mode_33__Xi_core_u_t2f 0.071125f
Ctic1552 VDD__Xi_core_u_trip i_core_temp_out_o__Xpad17_temp_out 0.155875f
Ctic1553 VDD__Xi_core_u_trip i_core_trip_d 0.031625f
Ctic1554 VDD__Xi_core_u_trip i_core_tripped__retained_fullchip_sg13g2_antennanp_1027_200_891_000 0.124313f
Ctic1555 VDD__Xi_core_u_trip i_core_vref 0.0975625f
Ctic1557 VDD__Xi_core_u_trip net__Xi_core_u_digital_1 0.20775f
Ctic1558 VDD__retained_fullchip_sg13g2_antennanp_1020_000_891_000 VREF 0.0075f
Ctic1559 VDD__retained_fullchip_sg13g2_antennanp_1020_000_891_000 VSS 193.85f
Ctic1560 VDD__retained_fullchip_sg13g2_antennanp_1020_000_891_000 VSS__Xi_core_u_bgr 0.000625f
Ctic1561 VDD__retained_fullchip_sg13g2_antennanp_1020_000_891_000 VSS__Xi_core_u_digital 0.119438f
Ctic1562 VDD__retained_fullchip_sg13g2_antennanp_1020_000_891_000 VSS__retained_fullchip_sg13g2_antennanp_1020_000_891_000 48.1566f
Ctic1563 VDD__retained_fullchip_sg13g2_antennanp_1020_000_891_000 _nc2__Xpad08_sense_p 0.000125f
Ctic1564 VDD__retained_fullchip_sg13g2_antennanp_1020_000_891_000 _nc5__Xpad20_d_std 0.000125f
Ctic1565 VDD__retained_fullchip_sg13g2_antennanp_1020_000_891_000 en_i__retained_fullchip_sg13g2_antennanp_1020_000_891_000 0.187938f
Ctic1566 VDD__retained_fullchip_sg13g2_antennanp_1020_000_891_000 fault_n_o__Xpad11_fault_n 0.0639375f
Ctic1567 VDD__retained_fullchip_sg13g2_antennanp_1020_000_891_000 gate_o__Xpad10_gate 0.036375f
Ctic1568 VDD__retained_fullchip_sg13g2_antennanp_1020_000_891_000 i_core_bgr_r4_12 0.044375f
Ctic1569 VDD__retained_fullchip_sg13g2_antennanp_1020_000_891_000 i_core_bgr_r4_33 0.597562f
Ctic1570 VDD__retained_fullchip_sg13g2_antennanp_1020_000_891_000 i_core_clr_d 0.01225f
Ctic1571 VDD__retained_fullchip_sg13g2_antennanp_1020_000_891_000 i_core_cmp_clk__Xi_core_u_trip 0.0428125f
Ctic1572 VDD__retained_fullchip_sg13g2_antennanp_1020_000_891_000 i_core_cmp_hard__Xi_core_u_trip 0.061375f
Ctic1573 VDD__retained_fullchip_sg13g2_antennanp_1020_000_891_000 i_core_cmp_soft__retained_fullchip_sg13g2_antennanp_1021_440_891_000 0.180188f
Ctic1574 VDD__retained_fullchip_sg13g2_antennanp_1020_000_891_000 i_core_dac_hard_0___Xi_core_u_trip 0.0204375f
Ctic1575 VDD__retained_fullchip_sg13g2_antennanp_1020_000_891_000 i_core_dac_hard_1___Xi_core_u_trip 0.00875f
Ctic1576 VDD__retained_fullchip_sg13g2_antennanp_1020_000_891_000 i_core_dac_hard_2___Xi_core_u_trip 0.00875f
Ctic1577 VDD__retained_fullchip_sg13g2_antennanp_1020_000_891_000 i_core_dac_hard_3___Xi_core_u_trip 0.133313f
Ctic1578 VDD__retained_fullchip_sg13g2_antennanp_1020_000_891_000 i_core_dac_hard_4___Xi_core_u_trip 0.0356875f
Ctic1579 VDD__retained_fullchip_sg13g2_antennanp_1020_000_891_000 i_core_dac_hard_5___Xi_core_u_trip 0.050375f
Ctic1580 VDD__retained_fullchip_sg13g2_antennanp_1020_000_891_000 i_core_dac_hard_6___Xi_core_u_trip 0.058375f
Ctic1581 VDD__retained_fullchip_sg13g2_antennanp_1020_000_891_000 i_core_dac_hard_7___Xi_core_u_trip 0.120625f
Ctic1582 VDD__retained_fullchip_sg13g2_antennanp_1020_000_891_000 i_core_dac_soft_0___Xi_core_u_trip 0.008f
Ctic1583 VDD__retained_fullchip_sg13g2_antennanp_1020_000_891_000 i_core_dac_soft_1___Xi_core_u_trip 0.0140625f
Ctic1584 VDD__retained_fullchip_sg13g2_antennanp_1020_000_891_000 i_core_dac_soft_2___Xi_core_u_trip 0.0344375f
Ctic1585 VDD__retained_fullchip_sg13g2_antennanp_1020_000_891_000 i_core_dac_soft_3___Xi_core_u_trip 0.0175f
Ctic1586 VDD__retained_fullchip_sg13g2_antennanp_1020_000_891_000 i_core_dac_soft_4___Xi_core_u_trip 0.0130625f
Ctic1587 VDD__retained_fullchip_sg13g2_antennanp_1020_000_891_000 i_core_dac_soft_5___Xi_core_u_trip 0.00925f
Ctic1588 VDD__retained_fullchip_sg13g2_antennanp_1020_000_891_000 i_core_dac_soft_6___Xi_core_u_trip 0.0815f
Ctic1589 VDD__retained_fullchip_sg13g2_antennanp_1020_000_891_000 i_core_dac_soft_7___Xi_core_u_trip 0.0023125f
Ctic1590 VDD__retained_fullchip_sg13g2_antennanp_1020_000_891_000 i_core_dvbe__Xi_core_u_bgr 0.0015625f
Ctic1591 VDD__retained_fullchip_sg13g2_antennanp_1020_000_891_000 i_core_fast_en__Xi_core_u_gate 0.043f
Ctic1592 VDD__retained_fullchip_sg13g2_antennanp_1020_000_891_000 i_core_iptat__Xi_core_u_sense 0.0885625f
Ctic1593 VDD__retained_fullchip_sg13g2_antennanp_1020_000_891_000 i_core_isense 0.01425f
Ctic1594 VDD__retained_fullchip_sg13g2_antennanp_1020_000_891_000 i_core_osc_clk__Xi_core_u_osc 0.048375f
Ctic1595 VDD__retained_fullchip_sg13g2_antennanp_1020_000_891_000 i_core_osc_en__Xi_core_u_osc 0.0509375f
Ctic1596 VDD__retained_fullchip_sg13g2_antennanp_1020_000_891_000 i_core_osc_trim_0___Xi_core_u_osc 0.0695625f
Ctic1597 VDD__retained_fullchip_sg13g2_antennanp_1020_000_891_000 i_core_osc_trim_1___Xi_core_u_osc 0.012375f
Ctic1598 VDD__retained_fullchip_sg13g2_antennanp_1020_000_891_000 i_core_osc_trim_2___Xi_core_u_osc 0.0578125f
Ctic1599 VDD__retained_fullchip_sg13g2_antennanp_1020_000_891_000 i_core_osc_trim_3___Xi_core_u_osc 0.0169375f
Ctic1600 VDD__retained_fullchip_sg13g2_antennanp_1020_000_891_000 i_core_pbias__Xi_core_u_t2f 0.017125f
Ctic1601 VDD__retained_fullchip_sg13g2_antennanp_1020_000_891_000 i_core_pcasc__Xi_core_u_t2f 0.316812f
Ctic1602 VDD__retained_fullchip_sg13g2_antennanp_1020_000_891_000 i_core_sclk_i 0.0598125f
Ctic1603 VDD__retained_fullchip_sg13g2_antennanp_1020_000_891_000 i_core_sclk_i__Xpad14_sclk 0.0001875f
Ctic1604 VDD__retained_fullchip_sg13g2_antennanp_1020_000_891_000 i_core_sdi_i__retained_fullchip_sg13g2_antennanp_1024_320_891_000 0.2535f
Ctic1605 VDD__retained_fullchip_sg13g2_antennanp_1020_000_891_000 i_core_sdo_o__Xpad16_sdo 1.609f
Ctic1606 VDD__retained_fullchip_sg13g2_antennanp_1020_000_891_000 i_core_t2f_en_12 0.030625f
Ctic1607 VDD__retained_fullchip_sg13g2_antennanp_1020_000_891_000 i_core_t2f_en_33__Xi_core_u_t2f 0.109937f
Ctic1608 VDD__retained_fullchip_sg13g2_antennanp_1020_000_891_000 i_core_t2f_mode_12 0.0219375f
Ctic1609 VDD__retained_fullchip_sg13g2_antennanp_1020_000_891_000 i_core_t2f_mode_33__Xi_core_u_t2f 0.071125f
Ctic1610 VDD__retained_fullchip_sg13g2_antennanp_1020_000_891_000 i_core_temp_out_o 0.155125f
Ctic1611 VDD__retained_fullchip_sg13g2_antennanp_1020_000_891_000 i_core_temp_out_o__Xpad17_temp_out 0.00075f
Ctic1612 VDD__retained_fullchip_sg13g2_antennanp_1020_000_891_000 i_core_trip_d 0.031625f
Ctic1613 VDD__retained_fullchip_sg13g2_antennanp_1020_000_891_000 i_core_tripped__retained_fullchip_sg13g2_antennanp_1027_200_891_000 0.124313f
Ctic1614 VDD__retained_fullchip_sg13g2_antennanp_1020_000_891_000 i_core_vref__Xpad18_vref 0.0975625f
Ctic1616 VDD__retained_fullchip_sg13g2_antennanp_1020_000_891_000 net__Xi_core_u_digital_1 0.20775f
Ctic1617 VDD__retained_fullchip_sg13g2_antennanp_1021_440_891_000 VREF 0.0075f
Ctic1618 VDD__retained_fullchip_sg13g2_antennanp_1021_440_891_000 VSS 193.85f
Ctic1619 VDD__retained_fullchip_sg13g2_antennanp_1021_440_891_000 VSS__Xi_core_u_bgr 0.000625f
Ctic1620 VDD__retained_fullchip_sg13g2_antennanp_1021_440_891_000 VSS__Xi_core_u_digital 0.119438f
Ctic1621 VDD__retained_fullchip_sg13g2_antennanp_1021_440_891_000 VSS__retained_fullchip_sg13g2_antennanp_1021_440_891_000 48.1566f
Ctic1622 VDD__retained_fullchip_sg13g2_antennanp_1021_440_891_000 _nc2__Xpad08_sense_p 0.000125f
Ctic1623 VDD__retained_fullchip_sg13g2_antennanp_1021_440_891_000 _nc5__Xpad20_d_std 0.000125f
Ctic1624 VDD__retained_fullchip_sg13g2_antennanp_1021_440_891_000 en_i__retained_fullchip_sg13g2_antennanp_1020_000_891_000 0.187938f
Ctic1625 VDD__retained_fullchip_sg13g2_antennanp_1021_440_891_000 fault_n_o__Xpad11_fault_n 0.0639375f
Ctic1626 VDD__retained_fullchip_sg13g2_antennanp_1021_440_891_000 gate_o__Xpad10_gate 0.036375f
Ctic1627 VDD__retained_fullchip_sg13g2_antennanp_1021_440_891_000 i_core_bgr_r4_12 0.044375f
Ctic1628 VDD__retained_fullchip_sg13g2_antennanp_1021_440_891_000 i_core_bgr_r4_33 0.597562f
Ctic1629 VDD__retained_fullchip_sg13g2_antennanp_1021_440_891_000 i_core_clr_d 0.01225f
Ctic1630 VDD__retained_fullchip_sg13g2_antennanp_1021_440_891_000 i_core_cmp_clk__Xi_core_u_trip 0.0428125f
Ctic1631 VDD__retained_fullchip_sg13g2_antennanp_1021_440_891_000 i_core_cmp_hard__Xi_core_u_trip 0.061375f
Ctic1632 VDD__retained_fullchip_sg13g2_antennanp_1021_440_891_000 i_core_cmp_soft__retained_fullchip_sg13g2_antennanp_1021_440_891_000 0.180188f
Ctic1633 VDD__retained_fullchip_sg13g2_antennanp_1021_440_891_000 i_core_dac_hard_0___Xi_core_u_trip 0.0204375f
Ctic1634 VDD__retained_fullchip_sg13g2_antennanp_1021_440_891_000 i_core_dac_hard_1___Xi_core_u_trip 0.00875f
Ctic1635 VDD__retained_fullchip_sg13g2_antennanp_1021_440_891_000 i_core_dac_hard_2___Xi_core_u_trip 0.00875f
Ctic1636 VDD__retained_fullchip_sg13g2_antennanp_1021_440_891_000 i_core_dac_hard_3___Xi_core_u_trip 0.133313f
Ctic1637 VDD__retained_fullchip_sg13g2_antennanp_1021_440_891_000 i_core_dac_hard_4___Xi_core_u_trip 0.0356875f
Ctic1638 VDD__retained_fullchip_sg13g2_antennanp_1021_440_891_000 i_core_dac_hard_5___Xi_core_u_trip 0.050375f
Ctic1639 VDD__retained_fullchip_sg13g2_antennanp_1021_440_891_000 i_core_dac_hard_6___Xi_core_u_trip 0.058375f
Ctic1640 VDD__retained_fullchip_sg13g2_antennanp_1021_440_891_000 i_core_dac_hard_7___Xi_core_u_trip 0.120625f
Ctic1641 VDD__retained_fullchip_sg13g2_antennanp_1021_440_891_000 i_core_dac_soft_0___Xi_core_u_trip 0.008f
Ctic1642 VDD__retained_fullchip_sg13g2_antennanp_1021_440_891_000 i_core_dac_soft_1___Xi_core_u_trip 0.0140625f
Ctic1643 VDD__retained_fullchip_sg13g2_antennanp_1021_440_891_000 i_core_dac_soft_2___Xi_core_u_trip 0.0344375f
Ctic1644 VDD__retained_fullchip_sg13g2_antennanp_1021_440_891_000 i_core_dac_soft_3___Xi_core_u_trip 0.0175f
Ctic1645 VDD__retained_fullchip_sg13g2_antennanp_1021_440_891_000 i_core_dac_soft_4___Xi_core_u_trip 0.0130625f
Ctic1646 VDD__retained_fullchip_sg13g2_antennanp_1021_440_891_000 i_core_dac_soft_5___Xi_core_u_trip 0.00925f
Ctic1647 VDD__retained_fullchip_sg13g2_antennanp_1021_440_891_000 i_core_dac_soft_6___Xi_core_u_trip 0.0815f
Ctic1648 VDD__retained_fullchip_sg13g2_antennanp_1021_440_891_000 i_core_dac_soft_7___Xi_core_u_trip 0.0023125f
Ctic1649 VDD__retained_fullchip_sg13g2_antennanp_1021_440_891_000 i_core_dvbe__Xi_core_u_bgr 0.0015625f
Ctic1650 VDD__retained_fullchip_sg13g2_antennanp_1021_440_891_000 i_core_fast_en__Xi_core_u_gate 0.043f
Ctic1651 VDD__retained_fullchip_sg13g2_antennanp_1021_440_891_000 i_core_iptat__Xi_core_u_sense 0.0885625f
Ctic1652 VDD__retained_fullchip_sg13g2_antennanp_1021_440_891_000 i_core_isense 0.01425f
Ctic1653 VDD__retained_fullchip_sg13g2_antennanp_1021_440_891_000 i_core_osc_clk__Xi_core_u_osc 0.048375f
Ctic1654 VDD__retained_fullchip_sg13g2_antennanp_1021_440_891_000 i_core_osc_en__Xi_core_u_osc 0.0509375f
Ctic1655 VDD__retained_fullchip_sg13g2_antennanp_1021_440_891_000 i_core_osc_trim_0___Xi_core_u_osc 0.0695625f
Ctic1656 VDD__retained_fullchip_sg13g2_antennanp_1021_440_891_000 i_core_osc_trim_1___Xi_core_u_osc 0.012375f
Ctic1657 VDD__retained_fullchip_sg13g2_antennanp_1021_440_891_000 i_core_osc_trim_2___Xi_core_u_osc 0.0578125f
Ctic1658 VDD__retained_fullchip_sg13g2_antennanp_1021_440_891_000 i_core_osc_trim_3___Xi_core_u_osc 0.0169375f
Ctic1659 VDD__retained_fullchip_sg13g2_antennanp_1021_440_891_000 i_core_pbias__Xi_core_u_t2f 0.017125f
Ctic1660 VDD__retained_fullchip_sg13g2_antennanp_1021_440_891_000 i_core_pcasc__Xi_core_u_t2f 0.316812f
Ctic1661 VDD__retained_fullchip_sg13g2_antennanp_1021_440_891_000 i_core_sclk_i 0.0598125f
Ctic1662 VDD__retained_fullchip_sg13g2_antennanp_1021_440_891_000 i_core_sclk_i__Xpad14_sclk 0.0001875f
Ctic1663 VDD__retained_fullchip_sg13g2_antennanp_1021_440_891_000 i_core_sdi_i__retained_fullchip_sg13g2_antennanp_1024_320_891_000 0.2535f
Ctic1664 VDD__retained_fullchip_sg13g2_antennanp_1021_440_891_000 i_core_sdo_o__Xpad16_sdo 1.609f
Ctic1665 VDD__retained_fullchip_sg13g2_antennanp_1021_440_891_000 i_core_t2f_en_12 0.030625f
Ctic1666 VDD__retained_fullchip_sg13g2_antennanp_1021_440_891_000 i_core_t2f_en_33__Xi_core_u_t2f 0.109937f
Ctic1667 VDD__retained_fullchip_sg13g2_antennanp_1021_440_891_000 i_core_t2f_mode_12 0.0219375f
Ctic1668 VDD__retained_fullchip_sg13g2_antennanp_1021_440_891_000 i_core_t2f_mode_33__Xi_core_u_t2f 0.071125f
Ctic1669 VDD__retained_fullchip_sg13g2_antennanp_1021_440_891_000 i_core_temp_out_o 0.155125f
Ctic1670 VDD__retained_fullchip_sg13g2_antennanp_1021_440_891_000 i_core_temp_out_o__Xpad17_temp_out 0.00075f
Ctic1671 VDD__retained_fullchip_sg13g2_antennanp_1021_440_891_000 i_core_trip_d 0.031625f
Ctic1672 VDD__retained_fullchip_sg13g2_antennanp_1021_440_891_000 i_core_tripped__retained_fullchip_sg13g2_antennanp_1027_200_891_000 0.124313f
Ctic1673 VDD__retained_fullchip_sg13g2_antennanp_1021_440_891_000 i_core_vref__Xpad18_vref 0.0975625f
Ctic1675 VDD__retained_fullchip_sg13g2_antennanp_1021_440_891_000 net__Xi_core_u_digital_1 0.20775f
Ctic1676 VDD__retained_fullchip_sg13g2_antennanp_1022_880_891_000 VREF 0.0075f
Ctic1677 VDD__retained_fullchip_sg13g2_antennanp_1022_880_891_000 VSS 193.85f
Ctic1678 VDD__retained_fullchip_sg13g2_antennanp_1022_880_891_000 VSS__Xi_core_u_bgr 0.000625f
Ctic1679 VDD__retained_fullchip_sg13g2_antennanp_1022_880_891_000 VSS__Xi_core_u_digital 0.119438f
Ctic1680 VDD__retained_fullchip_sg13g2_antennanp_1022_880_891_000 VSS__retained_fullchip_sg13g2_antennanp_1022_880_891_000 48.1566f
Ctic1681 VDD__retained_fullchip_sg13g2_antennanp_1022_880_891_000 _nc2__Xpad08_sense_p 0.000125f
Ctic1682 VDD__retained_fullchip_sg13g2_antennanp_1022_880_891_000 _nc5__Xpad20_d_std 0.000125f
Ctic1683 VDD__retained_fullchip_sg13g2_antennanp_1022_880_891_000 en_i__retained_fullchip_sg13g2_antennanp_1020_000_891_000 0.187938f
Ctic1684 VDD__retained_fullchip_sg13g2_antennanp_1022_880_891_000 fault_n_o__Xpad11_fault_n 0.0639375f
Ctic1685 VDD__retained_fullchip_sg13g2_antennanp_1022_880_891_000 gate_o__Xpad10_gate 0.036375f
Ctic1686 VDD__retained_fullchip_sg13g2_antennanp_1022_880_891_000 i_core_bgr_r4_12 0.044375f
Ctic1687 VDD__retained_fullchip_sg13g2_antennanp_1022_880_891_000 i_core_bgr_r4_33 0.597562f
Ctic1688 VDD__retained_fullchip_sg13g2_antennanp_1022_880_891_000 i_core_clr_d 0.01225f
Ctic1689 VDD__retained_fullchip_sg13g2_antennanp_1022_880_891_000 i_core_cmp_clk__Xi_core_u_trip 0.0428125f
Ctic1690 VDD__retained_fullchip_sg13g2_antennanp_1022_880_891_000 i_core_cmp_hard__Xi_core_u_trip 0.061375f
Ctic1691 VDD__retained_fullchip_sg13g2_antennanp_1022_880_891_000 i_core_cmp_soft__retained_fullchip_sg13g2_antennanp_1022_880_891_000 0.180188f
Ctic1692 VDD__retained_fullchip_sg13g2_antennanp_1022_880_891_000 i_core_dac_hard_0___Xi_core_u_trip 0.0204375f
Ctic1693 VDD__retained_fullchip_sg13g2_antennanp_1022_880_891_000 i_core_dac_hard_1___Xi_core_u_trip 0.00875f
Ctic1694 VDD__retained_fullchip_sg13g2_antennanp_1022_880_891_000 i_core_dac_hard_2___Xi_core_u_trip 0.00875f
Ctic1695 VDD__retained_fullchip_sg13g2_antennanp_1022_880_891_000 i_core_dac_hard_3___Xi_core_u_trip 0.133313f
Ctic1696 VDD__retained_fullchip_sg13g2_antennanp_1022_880_891_000 i_core_dac_hard_4___Xi_core_u_trip 0.0356875f
Ctic1697 VDD__retained_fullchip_sg13g2_antennanp_1022_880_891_000 i_core_dac_hard_5___Xi_core_u_trip 0.050375f
Ctic1698 VDD__retained_fullchip_sg13g2_antennanp_1022_880_891_000 i_core_dac_hard_6___Xi_core_u_trip 0.058375f
Ctic1699 VDD__retained_fullchip_sg13g2_antennanp_1022_880_891_000 i_core_dac_hard_7___Xi_core_u_trip 0.120625f
Ctic1700 VDD__retained_fullchip_sg13g2_antennanp_1022_880_891_000 i_core_dac_soft_0___Xi_core_u_trip 0.008f
Ctic1701 VDD__retained_fullchip_sg13g2_antennanp_1022_880_891_000 i_core_dac_soft_1___Xi_core_u_trip 0.0140625f
Ctic1702 VDD__retained_fullchip_sg13g2_antennanp_1022_880_891_000 i_core_dac_soft_2___Xi_core_u_trip 0.0344375f
Ctic1703 VDD__retained_fullchip_sg13g2_antennanp_1022_880_891_000 i_core_dac_soft_3___Xi_core_u_trip 0.0175f
Ctic1704 VDD__retained_fullchip_sg13g2_antennanp_1022_880_891_000 i_core_dac_soft_4___Xi_core_u_trip 0.0130625f
Ctic1705 VDD__retained_fullchip_sg13g2_antennanp_1022_880_891_000 i_core_dac_soft_5___Xi_core_u_trip 0.00925f
Ctic1706 VDD__retained_fullchip_sg13g2_antennanp_1022_880_891_000 i_core_dac_soft_6___Xi_core_u_trip 0.0815f
Ctic1707 VDD__retained_fullchip_sg13g2_antennanp_1022_880_891_000 i_core_dac_soft_7___Xi_core_u_trip 0.0023125f
Ctic1708 VDD__retained_fullchip_sg13g2_antennanp_1022_880_891_000 i_core_dvbe__Xi_core_u_bgr 0.0015625f
Ctic1709 VDD__retained_fullchip_sg13g2_antennanp_1022_880_891_000 i_core_fast_en__Xi_core_u_gate 0.043f
Ctic1710 VDD__retained_fullchip_sg13g2_antennanp_1022_880_891_000 i_core_iptat__Xi_core_u_sense 0.0885625f
Ctic1711 VDD__retained_fullchip_sg13g2_antennanp_1022_880_891_000 i_core_isense 0.01425f
Ctic1712 VDD__retained_fullchip_sg13g2_antennanp_1022_880_891_000 i_core_osc_clk__Xi_core_u_osc 0.048375f
Ctic1713 VDD__retained_fullchip_sg13g2_antennanp_1022_880_891_000 i_core_osc_en__Xi_core_u_osc 0.0509375f
Ctic1714 VDD__retained_fullchip_sg13g2_antennanp_1022_880_891_000 i_core_osc_trim_0___Xi_core_u_osc 0.0695625f
Ctic1715 VDD__retained_fullchip_sg13g2_antennanp_1022_880_891_000 i_core_osc_trim_1___Xi_core_u_osc 0.012375f
Ctic1716 VDD__retained_fullchip_sg13g2_antennanp_1022_880_891_000 i_core_osc_trim_2___Xi_core_u_osc 0.0578125f
Ctic1717 VDD__retained_fullchip_sg13g2_antennanp_1022_880_891_000 i_core_osc_trim_3___Xi_core_u_osc 0.0169375f
Ctic1718 VDD__retained_fullchip_sg13g2_antennanp_1022_880_891_000 i_core_pbias__Xi_core_u_t2f 0.017125f
Ctic1719 VDD__retained_fullchip_sg13g2_antennanp_1022_880_891_000 i_core_pcasc__Xi_core_u_t2f 0.316812f
Ctic1720 VDD__retained_fullchip_sg13g2_antennanp_1022_880_891_000 i_core_sclk_i 0.0598125f
Ctic1721 VDD__retained_fullchip_sg13g2_antennanp_1022_880_891_000 i_core_sclk_i__Xpad14_sclk 0.0001875f
Ctic1722 VDD__retained_fullchip_sg13g2_antennanp_1022_880_891_000 i_core_sdi_i__retained_fullchip_sg13g2_antennanp_1024_320_891_000 0.2535f
Ctic1723 VDD__retained_fullchip_sg13g2_antennanp_1022_880_891_000 i_core_sdo_o__Xpad16_sdo 1.609f
Ctic1724 VDD__retained_fullchip_sg13g2_antennanp_1022_880_891_000 i_core_t2f_en_12 0.030625f
Ctic1725 VDD__retained_fullchip_sg13g2_antennanp_1022_880_891_000 i_core_t2f_en_33__Xi_core_u_t2f 0.109937f
Ctic1726 VDD__retained_fullchip_sg13g2_antennanp_1022_880_891_000 i_core_t2f_mode_12 0.0219375f
Ctic1727 VDD__retained_fullchip_sg13g2_antennanp_1022_880_891_000 i_core_t2f_mode_33__Xi_core_u_t2f 0.071125f
Ctic1728 VDD__retained_fullchip_sg13g2_antennanp_1022_880_891_000 i_core_temp_out_o 0.155125f
Ctic1729 VDD__retained_fullchip_sg13g2_antennanp_1022_880_891_000 i_core_temp_out_o__Xpad17_temp_out 0.00075f
Ctic1730 VDD__retained_fullchip_sg13g2_antennanp_1022_880_891_000 i_core_trip_d 0.031625f
Ctic1731 VDD__retained_fullchip_sg13g2_antennanp_1022_880_891_000 i_core_tripped__retained_fullchip_sg13g2_antennanp_1027_200_891_000 0.124313f
Ctic1732 VDD__retained_fullchip_sg13g2_antennanp_1022_880_891_000 i_core_vref__Xpad18_vref 0.0975625f
Ctic1734 VDD__retained_fullchip_sg13g2_antennanp_1022_880_891_000 net__Xi_core_u_digital_1 0.20775f
Ctic1735 VDD__retained_fullchip_sg13g2_antennanp_1024_320_891_000 VREF 0.0075f
Ctic1736 VDD__retained_fullchip_sg13g2_antennanp_1024_320_891_000 VSS 193.85f
Ctic1737 VDD__retained_fullchip_sg13g2_antennanp_1024_320_891_000 VSS__Xi_core_u_bgr 0.000625f
Ctic1738 VDD__retained_fullchip_sg13g2_antennanp_1024_320_891_000 VSS__Xi_core_u_digital 0.119438f
Ctic1739 VDD__retained_fullchip_sg13g2_antennanp_1024_320_891_000 VSS__retained_fullchip_sg13g2_antennanp_1024_320_891_000 48.1566f
Ctic1740 VDD__retained_fullchip_sg13g2_antennanp_1024_320_891_000 _nc2__Xpad08_sense_p 0.000125f
Ctic1741 VDD__retained_fullchip_sg13g2_antennanp_1024_320_891_000 _nc5__Xpad20_d_std 0.000125f
Ctic1742 VDD__retained_fullchip_sg13g2_antennanp_1024_320_891_000 en_i__retained_fullchip_sg13g2_antennanp_1020_000_891_000 0.187938f
Ctic1743 VDD__retained_fullchip_sg13g2_antennanp_1024_320_891_000 fault_n_o__Xpad11_fault_n 0.0639375f
Ctic1744 VDD__retained_fullchip_sg13g2_antennanp_1024_320_891_000 gate_o__Xpad10_gate 0.036375f
Ctic1745 VDD__retained_fullchip_sg13g2_antennanp_1024_320_891_000 i_core_bgr_r4_12 0.044375f
Ctic1746 VDD__retained_fullchip_sg13g2_antennanp_1024_320_891_000 i_core_bgr_r4_33 0.597562f
Ctic1747 VDD__retained_fullchip_sg13g2_antennanp_1024_320_891_000 i_core_clr_d 0.01225f
Ctic1748 VDD__retained_fullchip_sg13g2_antennanp_1024_320_891_000 i_core_cmp_clk__Xi_core_u_trip 0.0428125f
Ctic1749 VDD__retained_fullchip_sg13g2_antennanp_1024_320_891_000 i_core_cmp_hard__Xi_core_u_trip 0.061375f
Ctic1750 VDD__retained_fullchip_sg13g2_antennanp_1024_320_891_000 i_core_cmp_soft__retained_fullchip_sg13g2_antennanp_1022_880_891_000 0.180188f
Ctic1751 VDD__retained_fullchip_sg13g2_antennanp_1024_320_891_000 i_core_dac_hard_0___Xi_core_u_trip 0.0204375f
Ctic1752 VDD__retained_fullchip_sg13g2_antennanp_1024_320_891_000 i_core_dac_hard_1___Xi_core_u_trip 0.00875f
Ctic1753 VDD__retained_fullchip_sg13g2_antennanp_1024_320_891_000 i_core_dac_hard_2___Xi_core_u_trip 0.00875f
Ctic1754 VDD__retained_fullchip_sg13g2_antennanp_1024_320_891_000 i_core_dac_hard_3___Xi_core_u_trip 0.133313f
Ctic1755 VDD__retained_fullchip_sg13g2_antennanp_1024_320_891_000 i_core_dac_hard_4___Xi_core_u_trip 0.0356875f
Ctic1756 VDD__retained_fullchip_sg13g2_antennanp_1024_320_891_000 i_core_dac_hard_5___Xi_core_u_trip 0.050375f
Ctic1757 VDD__retained_fullchip_sg13g2_antennanp_1024_320_891_000 i_core_dac_hard_6___Xi_core_u_trip 0.058375f
Ctic1758 VDD__retained_fullchip_sg13g2_antennanp_1024_320_891_000 i_core_dac_hard_7___Xi_core_u_trip 0.120625f
Ctic1759 VDD__retained_fullchip_sg13g2_antennanp_1024_320_891_000 i_core_dac_soft_0___Xi_core_u_trip 0.008f
Ctic1760 VDD__retained_fullchip_sg13g2_antennanp_1024_320_891_000 i_core_dac_soft_1___Xi_core_u_trip 0.0140625f
Ctic1761 VDD__retained_fullchip_sg13g2_antennanp_1024_320_891_000 i_core_dac_soft_2___Xi_core_u_trip 0.0344375f
Ctic1762 VDD__retained_fullchip_sg13g2_antennanp_1024_320_891_000 i_core_dac_soft_3___Xi_core_u_trip 0.0175f
Ctic1763 VDD__retained_fullchip_sg13g2_antennanp_1024_320_891_000 i_core_dac_soft_4___Xi_core_u_trip 0.0130625f
Ctic1764 VDD__retained_fullchip_sg13g2_antennanp_1024_320_891_000 i_core_dac_soft_5___Xi_core_u_trip 0.00925f
Ctic1765 VDD__retained_fullchip_sg13g2_antennanp_1024_320_891_000 i_core_dac_soft_6___Xi_core_u_trip 0.0815f
Ctic1766 VDD__retained_fullchip_sg13g2_antennanp_1024_320_891_000 i_core_dac_soft_7___Xi_core_u_trip 0.0023125f
Ctic1767 VDD__retained_fullchip_sg13g2_antennanp_1024_320_891_000 i_core_dvbe__Xi_core_u_bgr 0.0015625f
Ctic1768 VDD__retained_fullchip_sg13g2_antennanp_1024_320_891_000 i_core_fast_en__Xi_core_u_gate 0.043f
Ctic1769 VDD__retained_fullchip_sg13g2_antennanp_1024_320_891_000 i_core_iptat__Xi_core_u_sense 0.0885625f
Ctic1770 VDD__retained_fullchip_sg13g2_antennanp_1024_320_891_000 i_core_isense 0.01425f
Ctic1771 VDD__retained_fullchip_sg13g2_antennanp_1024_320_891_000 i_core_osc_clk__Xi_core_u_osc 0.048375f
Ctic1772 VDD__retained_fullchip_sg13g2_antennanp_1024_320_891_000 i_core_osc_en__Xi_core_u_osc 0.0509375f
Ctic1773 VDD__retained_fullchip_sg13g2_antennanp_1024_320_891_000 i_core_osc_trim_0___Xi_core_u_osc 0.0695625f
Ctic1774 VDD__retained_fullchip_sg13g2_antennanp_1024_320_891_000 i_core_osc_trim_1___Xi_core_u_osc 0.012375f
Ctic1775 VDD__retained_fullchip_sg13g2_antennanp_1024_320_891_000 i_core_osc_trim_2___Xi_core_u_osc 0.0578125f
Ctic1776 VDD__retained_fullchip_sg13g2_antennanp_1024_320_891_000 i_core_osc_trim_3___Xi_core_u_osc 0.0169375f
Ctic1777 VDD__retained_fullchip_sg13g2_antennanp_1024_320_891_000 i_core_pbias__Xi_core_u_t2f 0.017125f
Ctic1778 VDD__retained_fullchip_sg13g2_antennanp_1024_320_891_000 i_core_pcasc__Xi_core_u_t2f 0.316812f
Ctic1779 VDD__retained_fullchip_sg13g2_antennanp_1024_320_891_000 i_core_sclk_i 0.0598125f
Ctic1780 VDD__retained_fullchip_sg13g2_antennanp_1024_320_891_000 i_core_sclk_i__Xpad14_sclk 0.0001875f
Ctic1781 VDD__retained_fullchip_sg13g2_antennanp_1024_320_891_000 i_core_sdi_i__retained_fullchip_sg13g2_antennanp_1024_320_891_000 0.2535f
Ctic1782 VDD__retained_fullchip_sg13g2_antennanp_1024_320_891_000 i_core_sdo_o__Xpad16_sdo 1.609f
Ctic1783 VDD__retained_fullchip_sg13g2_antennanp_1024_320_891_000 i_core_t2f_en_12 0.030625f
Ctic1784 VDD__retained_fullchip_sg13g2_antennanp_1024_320_891_000 i_core_t2f_en_33__Xi_core_u_t2f 0.109937f
Ctic1785 VDD__retained_fullchip_sg13g2_antennanp_1024_320_891_000 i_core_t2f_mode_12 0.0219375f
Ctic1786 VDD__retained_fullchip_sg13g2_antennanp_1024_320_891_000 i_core_t2f_mode_33__Xi_core_u_t2f 0.071125f
Ctic1787 VDD__retained_fullchip_sg13g2_antennanp_1024_320_891_000 i_core_temp_out_o 0.155125f
Ctic1788 VDD__retained_fullchip_sg13g2_antennanp_1024_320_891_000 i_core_temp_out_o__Xpad17_temp_out 0.00075f
Ctic1789 VDD__retained_fullchip_sg13g2_antennanp_1024_320_891_000 i_core_trip_d 0.031625f
Ctic1790 VDD__retained_fullchip_sg13g2_antennanp_1024_320_891_000 i_core_tripped__retained_fullchip_sg13g2_antennanp_1027_200_891_000 0.124313f
Ctic1791 VDD__retained_fullchip_sg13g2_antennanp_1024_320_891_000 i_core_vref__Xpad18_vref 0.0975625f
Ctic1793 VDD__retained_fullchip_sg13g2_antennanp_1024_320_891_000 net__Xi_core_u_digital_1 0.20775f
Ctic1794 VDD__retained_fullchip_sg13g2_antennanp_1025_760_891_000 VREF 0.0075f
Ctic1795 VDD__retained_fullchip_sg13g2_antennanp_1025_760_891_000 VSS 193.85f
Ctic1796 VDD__retained_fullchip_sg13g2_antennanp_1025_760_891_000 VSS__Xi_core_u_bgr 0.000625f
Ctic1797 VDD__retained_fullchip_sg13g2_antennanp_1025_760_891_000 VSS__Xi_core_u_digital 0.119438f
Ctic1798 VDD__retained_fullchip_sg13g2_antennanp_1025_760_891_000 VSS__retained_fullchip_sg13g2_antennanp_1025_760_891_000 48.1566f
Ctic1799 VDD__retained_fullchip_sg13g2_antennanp_1025_760_891_000 _nc2__Xpad08_sense_p 0.000125f
Ctic1800 VDD__retained_fullchip_sg13g2_antennanp_1025_760_891_000 _nc5__Xpad20_d_std 0.000125f
Ctic1801 VDD__retained_fullchip_sg13g2_antennanp_1025_760_891_000 en_i__retained_fullchip_sg13g2_antennanp_1020_000_891_000 0.187938f
Ctic1802 VDD__retained_fullchip_sg13g2_antennanp_1025_760_891_000 fault_n_o__Xpad11_fault_n 0.0639375f
Ctic1803 VDD__retained_fullchip_sg13g2_antennanp_1025_760_891_000 gate_o__Xpad10_gate 0.036375f
Ctic1804 VDD__retained_fullchip_sg13g2_antennanp_1025_760_891_000 i_core_bgr_r4_12 0.044375f
Ctic1805 VDD__retained_fullchip_sg13g2_antennanp_1025_760_891_000 i_core_bgr_r4_33 0.597562f
Ctic1806 VDD__retained_fullchip_sg13g2_antennanp_1025_760_891_000 i_core_clr_d 0.01225f
Ctic1807 VDD__retained_fullchip_sg13g2_antennanp_1025_760_891_000 i_core_cmp_clk__Xi_core_u_trip 0.0428125f
Ctic1808 VDD__retained_fullchip_sg13g2_antennanp_1025_760_891_000 i_core_cmp_hard__Xi_core_u_trip 0.061375f
Ctic1809 VDD__retained_fullchip_sg13g2_antennanp_1025_760_891_000 i_core_cmp_soft__retained_fullchip_sg13g2_antennanp_1022_880_891_000 0.180188f
Ctic1810 VDD__retained_fullchip_sg13g2_antennanp_1025_760_891_000 i_core_dac_hard_0___Xi_core_u_trip 0.0204375f
Ctic1811 VDD__retained_fullchip_sg13g2_antennanp_1025_760_891_000 i_core_dac_hard_1___Xi_core_u_trip 0.00875f
Ctic1812 VDD__retained_fullchip_sg13g2_antennanp_1025_760_891_000 i_core_dac_hard_2___Xi_core_u_trip 0.00875f
Ctic1813 VDD__retained_fullchip_sg13g2_antennanp_1025_760_891_000 i_core_dac_hard_3___Xi_core_u_trip 0.133313f
Ctic1814 VDD__retained_fullchip_sg13g2_antennanp_1025_760_891_000 i_core_dac_hard_4___Xi_core_u_trip 0.0356875f
Ctic1815 VDD__retained_fullchip_sg13g2_antennanp_1025_760_891_000 i_core_dac_hard_5___Xi_core_u_trip 0.050375f
Ctic1816 VDD__retained_fullchip_sg13g2_antennanp_1025_760_891_000 i_core_dac_hard_6___Xi_core_u_trip 0.058375f
Ctic1817 VDD__retained_fullchip_sg13g2_antennanp_1025_760_891_000 i_core_dac_hard_7___Xi_core_u_trip 0.120625f
Ctic1818 VDD__retained_fullchip_sg13g2_antennanp_1025_760_891_000 i_core_dac_soft_0___Xi_core_u_trip 0.008f
Ctic1819 VDD__retained_fullchip_sg13g2_antennanp_1025_760_891_000 i_core_dac_soft_1___Xi_core_u_trip 0.0140625f
Ctic1820 VDD__retained_fullchip_sg13g2_antennanp_1025_760_891_000 i_core_dac_soft_2___Xi_core_u_trip 0.0344375f
Ctic1821 VDD__retained_fullchip_sg13g2_antennanp_1025_760_891_000 i_core_dac_soft_3___Xi_core_u_trip 0.0175f
Ctic1822 VDD__retained_fullchip_sg13g2_antennanp_1025_760_891_000 i_core_dac_soft_4___Xi_core_u_trip 0.0130625f
Ctic1823 VDD__retained_fullchip_sg13g2_antennanp_1025_760_891_000 i_core_dac_soft_5___Xi_core_u_trip 0.00925f
Ctic1824 VDD__retained_fullchip_sg13g2_antennanp_1025_760_891_000 i_core_dac_soft_6___Xi_core_u_trip 0.0815f
Ctic1825 VDD__retained_fullchip_sg13g2_antennanp_1025_760_891_000 i_core_dac_soft_7___Xi_core_u_trip 0.0023125f
Ctic1826 VDD__retained_fullchip_sg13g2_antennanp_1025_760_891_000 i_core_dvbe__Xi_core_u_bgr 0.0015625f
Ctic1827 VDD__retained_fullchip_sg13g2_antennanp_1025_760_891_000 i_core_fast_en__Xi_core_u_gate 0.043f
Ctic1828 VDD__retained_fullchip_sg13g2_antennanp_1025_760_891_000 i_core_iptat__Xi_core_u_sense 0.0885625f
Ctic1829 VDD__retained_fullchip_sg13g2_antennanp_1025_760_891_000 i_core_isense 0.01425f
Ctic1830 VDD__retained_fullchip_sg13g2_antennanp_1025_760_891_000 i_core_osc_clk__Xi_core_u_osc 0.048375f
Ctic1831 VDD__retained_fullchip_sg13g2_antennanp_1025_760_891_000 i_core_osc_en__Xi_core_u_osc 0.0509375f
Ctic1832 VDD__retained_fullchip_sg13g2_antennanp_1025_760_891_000 i_core_osc_trim_0___Xi_core_u_osc 0.0695625f
Ctic1833 VDD__retained_fullchip_sg13g2_antennanp_1025_760_891_000 i_core_osc_trim_1___Xi_core_u_osc 0.012375f
Ctic1834 VDD__retained_fullchip_sg13g2_antennanp_1025_760_891_000 i_core_osc_trim_2___Xi_core_u_osc 0.0578125f
Ctic1835 VDD__retained_fullchip_sg13g2_antennanp_1025_760_891_000 i_core_osc_trim_3___Xi_core_u_osc 0.0169375f
Ctic1836 VDD__retained_fullchip_sg13g2_antennanp_1025_760_891_000 i_core_pbias__Xi_core_u_t2f 0.017125f
Ctic1837 VDD__retained_fullchip_sg13g2_antennanp_1025_760_891_000 i_core_pcasc__Xi_core_u_t2f 0.316812f
Ctic1838 VDD__retained_fullchip_sg13g2_antennanp_1025_760_891_000 i_core_sclk_i 0.0598125f
Ctic1839 VDD__retained_fullchip_sg13g2_antennanp_1025_760_891_000 i_core_sclk_i__Xpad14_sclk 0.0001875f
Ctic1840 VDD__retained_fullchip_sg13g2_antennanp_1025_760_891_000 i_core_sdi_i__retained_fullchip_sg13g2_antennanp_1024_320_891_000 0.2535f
Ctic1841 VDD__retained_fullchip_sg13g2_antennanp_1025_760_891_000 i_core_sdo_o__Xpad16_sdo 1.609f
Ctic1842 VDD__retained_fullchip_sg13g2_antennanp_1025_760_891_000 i_core_t2f_en_12 0.030625f
Ctic1843 VDD__retained_fullchip_sg13g2_antennanp_1025_760_891_000 i_core_t2f_en_33__Xi_core_u_t2f 0.109937f
Ctic1844 VDD__retained_fullchip_sg13g2_antennanp_1025_760_891_000 i_core_t2f_mode_12 0.0219375f
Ctic1845 VDD__retained_fullchip_sg13g2_antennanp_1025_760_891_000 i_core_t2f_mode_33__Xi_core_u_t2f 0.071125f
Ctic1846 VDD__retained_fullchip_sg13g2_antennanp_1025_760_891_000 i_core_temp_out_o 0.155125f
Ctic1847 VDD__retained_fullchip_sg13g2_antennanp_1025_760_891_000 i_core_temp_out_o__Xpad17_temp_out 0.00075f
Ctic1848 VDD__retained_fullchip_sg13g2_antennanp_1025_760_891_000 i_core_trip_d 0.031625f
Ctic1849 VDD__retained_fullchip_sg13g2_antennanp_1025_760_891_000 i_core_tripped__retained_fullchip_sg13g2_antennanp_1027_200_891_000 0.124313f
Ctic1850 VDD__retained_fullchip_sg13g2_antennanp_1025_760_891_000 i_core_vref__Xpad18_vref 0.0975625f
Ctic1852 VDD__retained_fullchip_sg13g2_antennanp_1025_760_891_000 net__Xi_core_u_digital_1 0.20775f
Ctic1853 VDD__retained_fullchip_sg13g2_antennanp_1027_200_891_000 VREF 0.0075f
Ctic1854 VDD__retained_fullchip_sg13g2_antennanp_1027_200_891_000 VSS 193.85f
Ctic1855 VDD__retained_fullchip_sg13g2_antennanp_1027_200_891_000 VSS__Xi_core_u_bgr 0.000625f
Ctic1856 VDD__retained_fullchip_sg13g2_antennanp_1027_200_891_000 VSS__Xi_core_u_digital 0.119438f
Ctic1857 VDD__retained_fullchip_sg13g2_antennanp_1027_200_891_000 VSS__retained_fullchip_sg13g2_antennanp_1027_200_891_000 48.1566f
Ctic1858 VDD__retained_fullchip_sg13g2_antennanp_1027_200_891_000 _nc2__Xpad08_sense_p 0.000125f
Ctic1859 VDD__retained_fullchip_sg13g2_antennanp_1027_200_891_000 _nc5__Xpad20_d_std 0.000125f
Ctic1860 VDD__retained_fullchip_sg13g2_antennanp_1027_200_891_000 en_i__retained_fullchip_sg13g2_antennanp_1020_000_891_000 0.187938f
Ctic1861 VDD__retained_fullchip_sg13g2_antennanp_1027_200_891_000 fault_n_o__Xpad11_fault_n 0.0639375f
Ctic1862 VDD__retained_fullchip_sg13g2_antennanp_1027_200_891_000 gate_o__Xpad10_gate 0.036375f
Ctic1863 VDD__retained_fullchip_sg13g2_antennanp_1027_200_891_000 i_core_bgr_r4_12 0.044375f
Ctic1864 VDD__retained_fullchip_sg13g2_antennanp_1027_200_891_000 i_core_bgr_r4_33 0.597562f
Ctic1865 VDD__retained_fullchip_sg13g2_antennanp_1027_200_891_000 i_core_clr_d 0.01225f
Ctic1866 VDD__retained_fullchip_sg13g2_antennanp_1027_200_891_000 i_core_cmp_clk__Xi_core_u_trip 0.0428125f
Ctic1867 VDD__retained_fullchip_sg13g2_antennanp_1027_200_891_000 i_core_cmp_hard__Xi_core_u_trip 0.061375f
Ctic1868 VDD__retained_fullchip_sg13g2_antennanp_1027_200_891_000 i_core_cmp_soft__retained_fullchip_sg13g2_antennanp_1022_880_891_000 0.180188f
Ctic1869 VDD__retained_fullchip_sg13g2_antennanp_1027_200_891_000 i_core_dac_hard_0___Xi_core_u_trip 0.0204375f
Ctic1870 VDD__retained_fullchip_sg13g2_antennanp_1027_200_891_000 i_core_dac_hard_1___Xi_core_u_trip 0.00875f
Ctic1871 VDD__retained_fullchip_sg13g2_antennanp_1027_200_891_000 i_core_dac_hard_2___Xi_core_u_trip 0.00875f
Ctic1872 VDD__retained_fullchip_sg13g2_antennanp_1027_200_891_000 i_core_dac_hard_3___Xi_core_u_trip 0.133313f
Ctic1873 VDD__retained_fullchip_sg13g2_antennanp_1027_200_891_000 i_core_dac_hard_4___Xi_core_u_trip 0.0356875f
Ctic1874 VDD__retained_fullchip_sg13g2_antennanp_1027_200_891_000 i_core_dac_hard_5___Xi_core_u_trip 0.050375f
Ctic1875 VDD__retained_fullchip_sg13g2_antennanp_1027_200_891_000 i_core_dac_hard_6___Xi_core_u_trip 0.058375f
Ctic1876 VDD__retained_fullchip_sg13g2_antennanp_1027_200_891_000 i_core_dac_hard_7___Xi_core_u_trip 0.120625f
Ctic1877 VDD__retained_fullchip_sg13g2_antennanp_1027_200_891_000 i_core_dac_soft_0___Xi_core_u_trip 0.008f
Ctic1878 VDD__retained_fullchip_sg13g2_antennanp_1027_200_891_000 i_core_dac_soft_1___Xi_core_u_trip 0.0140625f
Ctic1879 VDD__retained_fullchip_sg13g2_antennanp_1027_200_891_000 i_core_dac_soft_2___Xi_core_u_trip 0.0344375f
Ctic1880 VDD__retained_fullchip_sg13g2_antennanp_1027_200_891_000 i_core_dac_soft_3___Xi_core_u_trip 0.0175f
Ctic1881 VDD__retained_fullchip_sg13g2_antennanp_1027_200_891_000 i_core_dac_soft_4___Xi_core_u_trip 0.0130625f
Ctic1882 VDD__retained_fullchip_sg13g2_antennanp_1027_200_891_000 i_core_dac_soft_5___Xi_core_u_trip 0.00925f
Ctic1883 VDD__retained_fullchip_sg13g2_antennanp_1027_200_891_000 i_core_dac_soft_6___Xi_core_u_trip 0.0815f
Ctic1884 VDD__retained_fullchip_sg13g2_antennanp_1027_200_891_000 i_core_dac_soft_7___Xi_core_u_trip 0.0023125f
Ctic1885 VDD__retained_fullchip_sg13g2_antennanp_1027_200_891_000 i_core_dvbe__Xi_core_u_bgr 0.0015625f
Ctic1886 VDD__retained_fullchip_sg13g2_antennanp_1027_200_891_000 i_core_fast_en__Xi_core_u_gate 0.043f
Ctic1887 VDD__retained_fullchip_sg13g2_antennanp_1027_200_891_000 i_core_iptat__Xi_core_u_sense 0.0885625f
Ctic1888 VDD__retained_fullchip_sg13g2_antennanp_1027_200_891_000 i_core_isense 0.01425f
Ctic1889 VDD__retained_fullchip_sg13g2_antennanp_1027_200_891_000 i_core_osc_clk__Xi_core_u_osc 0.048375f
Ctic1890 VDD__retained_fullchip_sg13g2_antennanp_1027_200_891_000 i_core_osc_en__Xi_core_u_osc 0.0509375f
Ctic1891 VDD__retained_fullchip_sg13g2_antennanp_1027_200_891_000 i_core_osc_trim_0___Xi_core_u_osc 0.0695625f
Ctic1892 VDD__retained_fullchip_sg13g2_antennanp_1027_200_891_000 i_core_osc_trim_1___Xi_core_u_osc 0.012375f
Ctic1893 VDD__retained_fullchip_sg13g2_antennanp_1027_200_891_000 i_core_osc_trim_2___Xi_core_u_osc 0.0578125f
Ctic1894 VDD__retained_fullchip_sg13g2_antennanp_1027_200_891_000 i_core_osc_trim_3___Xi_core_u_osc 0.0169375f
Ctic1895 VDD__retained_fullchip_sg13g2_antennanp_1027_200_891_000 i_core_pbias__Xi_core_u_t2f 0.017125f
Ctic1896 VDD__retained_fullchip_sg13g2_antennanp_1027_200_891_000 i_core_pcasc__Xi_core_u_t2f 0.316812f
Ctic1897 VDD__retained_fullchip_sg13g2_antennanp_1027_200_891_000 i_core_sclk_i 0.0598125f
Ctic1898 VDD__retained_fullchip_sg13g2_antennanp_1027_200_891_000 i_core_sclk_i__Xpad14_sclk 0.0001875f
Ctic1899 VDD__retained_fullchip_sg13g2_antennanp_1027_200_891_000 i_core_sdi_i__retained_fullchip_sg13g2_antennanp_1024_320_891_000 0.2535f
Ctic1900 VDD__retained_fullchip_sg13g2_antennanp_1027_200_891_000 i_core_sdo_o__Xpad16_sdo 1.609f
Ctic1901 VDD__retained_fullchip_sg13g2_antennanp_1027_200_891_000 i_core_t2f_en_12 0.030625f
Ctic1902 VDD__retained_fullchip_sg13g2_antennanp_1027_200_891_000 i_core_t2f_en_33__Xi_core_u_t2f 0.109937f
Ctic1903 VDD__retained_fullchip_sg13g2_antennanp_1027_200_891_000 i_core_t2f_mode_12 0.0219375f
Ctic1904 VDD__retained_fullchip_sg13g2_antennanp_1027_200_891_000 i_core_t2f_mode_33__Xi_core_u_t2f 0.071125f
Ctic1905 VDD__retained_fullchip_sg13g2_antennanp_1027_200_891_000 i_core_temp_out_o 0.155125f
Ctic1906 VDD__retained_fullchip_sg13g2_antennanp_1027_200_891_000 i_core_temp_out_o__Xpad17_temp_out 0.00075f
Ctic1907 VDD__retained_fullchip_sg13g2_antennanp_1027_200_891_000 i_core_trip_d 0.031625f
Ctic1908 VDD__retained_fullchip_sg13g2_antennanp_1027_200_891_000 i_core_tripped__retained_fullchip_sg13g2_antennanp_1027_200_891_000 0.124313f
Ctic1909 VDD__retained_fullchip_sg13g2_antennanp_1027_200_891_000 i_core_vref__Xpad18_vref 0.0975625f
Ctic1911 VDD__retained_fullchip_sg13g2_antennanp_1027_200_891_000 net__Xi_core_u_digital_1 0.20775f
Ctic1912 VREF VSS 0.00547368f
Ctic1913 VREF VSS__Xi_core_u_digital 0.00547368f
Ctic1914 VREF VSS__Xi_core_u_digital_1 0.00547368f
Ctic1915 VREF VSS__Xi_core_u_dose 0.00547368f
Ctic1916 VREF VSS__Xi_core_u_dut 0.00547368f
Ctic1917 VREF VSS__Xi_core_u_gate 0.00547368f
Ctic1918 VREF VSS__Xi_core_u_ls_en 0.00547368f
Ctic1919 VREF VSS__Xi_core_u_ls_mode 0.00547368f
Ctic1920 VREF VSS__Xi_core_u_ls_r4 0.00547368f
Ctic1921 VREF VSS__Xi_core_u_osc 0.00547368f
Ctic1922 VREF VSS__Xi_core_u_sense 0.00547368f
Ctic1923 VREF VSS__Xi_core_u_t2f 0.00547368f
Ctic1924 VREF VSS__Xi_core_u_trip 0.00547368f
Ctic1925 VREF VSS__retained_fullchip_sg13g2_antennanp_1020_000_891_000 0.00547368f
Ctic1926 VREF VSS__retained_fullchip_sg13g2_antennanp_1021_440_891_000 0.00547368f
Ctic1927 VREF VSS__retained_fullchip_sg13g2_antennanp_1022_880_891_000 0.00547368f
Ctic1928 VREF VSS__retained_fullchip_sg13g2_antennanp_1024_320_891_000 0.00547368f
Ctic1929 VREF VSS__retained_fullchip_sg13g2_antennanp_1025_760_891_000 0.00547368f
Ctic1930 VREF VSS__retained_fullchip_sg13g2_antennanp_1027_200_891_000 0.00547368f
Ctic1931 VREF i_core_temp_out_o 1.125f
Ctic1932 VREF i_core_temp_out_o__Xpad17_temp_out 1.125f
Ctic1933 VREF i_core_vref 0.002f
Ctic1934 VREF i_core_vref__Xi_core_u_sense 0.002f
Ctic1935 VREF i_core_vref__Xpad18_vref 0.002f
Ctic1936 VSS VSS__Xi_core_u_digital 108.583f
Ctic1937 VSS VSS__Xi_core_u_digital_1 108.583f
Ctic1938 VSS VSS__Xi_core_u_dose 108.583f
Ctic1939 VSS VSS__Xi_core_u_dut 108.583f
Ctic1940 VSS VSS__Xi_core_u_gate 108.583f
Ctic1941 VSS VSS__Xi_core_u_ls_en 108.583f
Ctic1942 VSS VSS__Xi_core_u_ls_mode 108.583f
Ctic1943 VSS VSS__Xi_core_u_ls_r4 108.583f
Ctic1944 VSS VSS__Xi_core_u_osc 108.583f
Ctic1945 VSS VSS__Xi_core_u_sense 108.583f
Ctic1946 VSS VSS__Xi_core_u_t2f 108.583f
Ctic1947 VSS VSS__Xi_core_u_trip 108.583f
Ctic1948 VSS VSS__retained_fullchip_sg13g2_antennanp_1020_000_891_000 108.583f
Ctic1949 VSS VSS__retained_fullchip_sg13g2_antennanp_1021_440_891_000 108.583f
Ctic1950 VSS VSS__retained_fullchip_sg13g2_antennanp_1022_880_891_000 108.583f
Ctic1951 VSS VSS__retained_fullchip_sg13g2_antennanp_1024_320_891_000 108.583f
Ctic1952 VSS VSS__retained_fullchip_sg13g2_antennanp_1025_760_891_000 108.583f
Ctic1953 VSS VSS__retained_fullchip_sg13g2_antennanp_1027_200_891_000 108.583f
Ctic1954 VSS _nc1__Xpad07_vdda 0.000421053f
Ctic1955 VSS _nc2__Xpad08_sense_p 0.000368421f
Ctic1956 VSS _nc3__Xpad09_sense_n 0.000421053f
Ctic1957 VSS _nc4__Xpad19_g_shared 0.000315789f
Ctic1958 VSS _nc5__Xpad20_d_std 0.000315789f
Ctic1959 VSS _nc6__Xpad21_d_elt 0.000315789f
Ctic1960 VSS _nc7__Xpad22_hbt_e 0.000315789f
Ctic1961 VSS _nc8__Xpad23_hbt_b 0.000368421f
Ctic1962 VSS _nc9__Xpad24_hbt_c 0.000368421f
Ctic1963 VSS en_i 7.35075f
Ctic1964 VSS en_i__Xi_core_u_gate 7.35075f
Ctic1965 VSS en_i__Xpad12_en 7.35096f
Ctic1966 VSS en_i__retained_fullchip_sg13g2_antennanp_1020_000_891_000 7.80086f
Ctic1967 VSS fault_n_o 10.8452f
Ctic1968 VSS fault_n_o__Xpad11_fault_n 10.3014f
Ctic1969 VSS gate_o 7.02324f
Ctic1970 VSS gate_o__Xpad10_gate 6.94497f
Ctic1971 VSS i_core_bgr_r4_12 1.52468f
Ctic1972 VSS i_core_bgr_r4_12__Xi_core_u_ls_r4 1.449f
Ctic1973 VSS i_core_bgr_r4_33 8.86426f
Ctic1974 VSS i_core_bgr_r4_33__Xi_core_u_ls_r4 8.773f
Ctic1975 VSS i_core_clr_d 0.543f
Ctic1976 VSS i_core_clr_d__Xi_core_u_gate 0.535f
Ctic1977 VSS i_core_cmp_clk 9.456f
Ctic1978 VSS i_core_cmp_clk__Xi_core_u_trip 9.934f
Ctic1979 VSS i_core_cmp_hard 5.45767f
Ctic1980 VSS i_core_cmp_hard__Xi_core_u_gate 5.45767f
Ctic1981 VSS i_core_cmp_hard__Xi_core_u_trip 5.76667f
Ctic1982 VSS i_core_cmp_soft 8.2265f
Ctic1983 VSS i_core_cmp_soft__Xi_core_u_trip 8.37761f
Ctic1984 VSS i_core_cmp_soft__retained_fullchip_sg13g2_antennanp_1021_440_891_000 8.2265f
Ctic1985 VSS i_core_cmp_soft__retained_fullchip_sg13g2_antennanp_1022_880_891_000 8.2265f
Ctic1986 VSS i_core_dac_hard_0_ 4.02313f
Ctic1987 VSS i_core_dac_hard_0___Xi_core_u_trip 3.9915f
Ctic1988 VSS i_core_dac_hard_1_ 1.83282f
Ctic1989 VSS i_core_dac_hard_1___Xi_core_u_trip 1.8205f
Ctic1990 VSS i_core_dac_hard_2_ 2.17789f
Ctic1991 VSS i_core_dac_hard_2___Xi_core_u_trip 2.15f
Ctic1992 VSS i_core_dac_hard_3_ 5.976f
Ctic1993 VSS i_core_dac_hard_3___Xi_core_u_trip 6.06442f
Ctic1994 VSS i_core_dac_hard_4_ 1.18861f
Ctic1995 VSS i_core_dac_hard_4___Xi_core_u_trip 1.1545f
Ctic1996 VSS i_core_dac_hard_5_ 2.58837f
Ctic1997 VSS i_core_dac_hard_5___Xi_core_u_trip 2.538f
Ctic1998 VSS i_core_dac_hard_6_ 5.15203f
Ctic1999 VSS i_core_dac_hard_6___Xi_core_u_trip 5.0975f
Ctic2000 VSS i_core_dac_hard_7_ 7.27166f
Ctic2001 VSS i_core_dac_hard_7___Xi_core_u_trip 7.1895f
Ctic2002 VSS i_core_dac_soft_0_ 1.37f
Ctic2003 VSS i_core_dac_soft_0___Xi_core_u_trip 1.37853f
Ctic2004 VSS i_core_dac_soft_1_ 1.313f
Ctic2005 VSS i_core_dac_soft_1___Xi_core_u_trip 1.31458f
Ctic2006 VSS i_core_dac_soft_2_ 1.93f
Ctic2007 VSS i_core_dac_soft_2___Xi_core_u_trip 1.94605f
Ctic2008 VSS i_core_dac_soft_3_ 0.457f
Ctic2009 VSS i_core_dac_soft_3___Xi_core_u_trip 0.469526f
Ctic2010 VSS i_core_dac_soft_4_ 2.0185f
Ctic2011 VSS i_core_dac_soft_4___Xi_core_u_trip 2.03934f
Ctic2012 VSS i_core_dac_soft_5_ 2.314f
Ctic2013 VSS i_core_dac_soft_5___Xi_core_u_trip 2.32463f
Ctic2014 VSS i_core_dac_soft_6_ 4.025f
Ctic2015 VSS i_core_dac_soft_6___Xi_core_u_trip 4.06353f
Ctic2016 VSS i_core_dac_soft_7_ 1.047f
Ctic2017 VSS i_core_dac_soft_7___Xi_core_u_trip 1.05305f
Ctic2018 VSS i_core_fast_en 0.813921f
Ctic2019 VSS i_core_fast_en__Xi_core_u_gate 0.8035f
Ctic2020 VSS i_core_iptat 3.83118f
Ctic2021 VSS i_core_iptat__Xi_core_u_sense 3.5865f
Ctic2022 VSS i_core_isense 1.638f
Ctic2023 VSS i_core_isense__Xi_core_u_trip 1.78442f
Ctic2024 VSS i_core_osc_clk 9.5785f
Ctic2025 VSS i_core_osc_clk__Xi_core_u_osc 9.67482f
Ctic2026 VSS i_core_osc_en 3.9635f
Ctic2027 VSS i_core_osc_en__Xi_core_u_osc 4.14282f
Ctic2028 VSS i_core_osc_trim_0_ 5.4495f
Ctic2029 VSS i_core_osc_trim_0___Xi_core_u_osc 5.50008f
Ctic2030 VSS i_core_osc_trim_1_ 2.1305f
Ctic2031 VSS i_core_osc_trim_1___Xi_core_u_osc 2.15118f
Ctic2032 VSS i_core_osc_trim_2_ 8.794f
Ctic2033 VSS i_core_osc_trim_2___Xi_core_u_osc 8.90868f
Ctic2034 VSS i_core_osc_trim_3_ 2.2685f
Ctic2035 VSS i_core_osc_trim_3___Xi_core_u_osc 2.30087f
Ctic2036 VSS i_core_pbias 4.229f
Ctic2037 VSS i_core_pbias__Xi_core_u_t2f 4.164f
Ctic2038 VSS i_core_pcasc 7.52284f
Ctic2039 VSS i_core_pcasc__Xi_core_u_t2f 7.497f
Ctic2040 VSS i_core_sclk_i 18.0095f
Ctic2041 VSS i_core_sclk_i__Xpad14_sclk 18.4574f
Ctic2042 VSS i_core_sdi_i 23.2923f
Ctic2043 VSS i_core_sdi_i__Xpad15_sdi 24.2924f
Ctic2044 VSS i_core_sdi_i__retained_fullchip_sg13g2_antennanp_1024_320_891_000 23.2923f
Ctic2045 VSS i_core_sdo_o 13.288f
Ctic2046 VSS i_core_sdo_o__Xpad16_sdo 13.3957f
Ctic2047 VSS i_core_t2f_en_12 1.70371f
Ctic2048 VSS i_core_t2f_en_12__Xi_core_u_ls_en 1.6635f
Ctic2049 VSS i_core_t2f_en_33 14.727f
Ctic2050 VSS i_core_t2f_en_33__Xi_core_u_t2f 14.8916f
Ctic2051 VSS i_core_t2f_mode_12 2.74811f
Ctic2052 VSS i_core_t2f_mode_12__Xi_core_u_ls_mode 2.727f
Ctic2053 VSS i_core_t2f_mode_33 11.112f
Ctic2054 VSS i_core_t2f_mode_33__Xi_core_u_t2f 11.4249f
Ctic2055 VSS i_core_temp_out_o 5.8365f
Ctic2056 VSS i_core_temp_out_o__Xpad17_temp_out 5.88745f
Ctic2057 VSS i_core_trip_d 0.678026f
Ctic2058 VSS i_core_trip_d__Xi_core_u_gate 0.6725f
Ctic2059 VSS i_core_trip_set__Xpad13_trip_set 0.000105263f
Ctic2060 VSS i_core_tripped 7.192f
Ctic2061 VSS i_core_tripped__Xi_core_u_gate 7.192f
Ctic2062 VSS i_core_tripped__retained_fullchip_sg13g2_antennanp_1027_200_891_000 7.34853f
Ctic2063 VSS i_core_vref 10.0777f
Ctic2064 VSS i_core_vref__Xi_core_u_sense 10.0777f
Ctic2065 VSS i_core_vref__Xi_core_u_t2f 0.000947368f
Ctic2066 VSS i_core_vref__Xpad18_vref 10.1504f
Ctic2067 VSS i_core_vref_buf 3.393f
Ctic2068 VSS i_core_vref_buf__Xi_core_u_trip 3.55421f
Ctic2069 VSS net 15.656f
Ctic2070 VSS net__Xi_core_u_digital_1 16.0083f
Ctic2071 VSS__Xi_core_u_bgr i_core_pcasc 0.0005f
Ctic2072 VSS__Xi_core_u_bgr i_core_pcasc__Xi_core_u_t2f 0.0005f
Ctic2073 VSS__Xi_core_u_bgr i_core_sdo_o 0.0005f
Ctic2074 VSS__Xi_core_u_bgr i_core_sdo_o__Xpad16_sdo 0.0005f
Ctic2075 VSS__Xi_core_u_bgr i_core_vref 0.0246667f
Ctic2076 VSS__Xi_core_u_bgr i_core_vref__Xi_core_u_sense 0.0246667f
Ctic2077 VSS__Xi_core_u_bgr i_core_vref__Xpad18_vref 0.0246667f
Ctic2078 VSS__Xi_core_u_digital _nc1__Xpad07_vdda 0.000421053f
Ctic2079 VSS__Xi_core_u_digital _nc2__Xpad08_sense_p 0.000368421f
Ctic2080 VSS__Xi_core_u_digital _nc3__Xpad09_sense_n 0.000421053f
Ctic2081 VSS__Xi_core_u_digital _nc4__Xpad19_g_shared 0.000315789f
Ctic2082 VSS__Xi_core_u_digital _nc5__Xpad20_d_std 0.000315789f
Ctic2083 VSS__Xi_core_u_digital _nc6__Xpad21_d_elt 0.000315789f
Ctic2084 VSS__Xi_core_u_digital _nc7__Xpad22_hbt_e 0.000315789f
Ctic2085 VSS__Xi_core_u_digital _nc8__Xpad23_hbt_b 0.000368421f
Ctic2086 VSS__Xi_core_u_digital _nc9__Xpad24_hbt_c 0.000368421f
Ctic2087 VSS__Xi_core_u_digital en_i 0.450105f
Ctic2088 VSS__Xi_core_u_digital en_i__Xpad12_en 0.000210526f
Ctic2089 VSS__Xi_core_u_digital fault_n_o 0.545211f
Ctic2090 VSS__Xi_core_u_digital fault_n_o__Xpad11_fault_n 0.00142105f
Ctic2091 VSS__Xi_core_u_digital gate_o 0.0797368f
Ctic2092 VSS__Xi_core_u_digital gate_o__Xpad10_gate 0.00147368f
Ctic2093 VSS__Xi_core_u_digital i_core_bgr_r4_12 0.0756842f
Ctic2094 VSS__Xi_core_u_digital i_core_bgr_r4_33__Xi_core_u_ls_r4 0.0912632f
Ctic2095 VSS__Xi_core_u_digital i_core_clr_d 0.008f
Ctic2096 VSS__Xi_core_u_digital i_core_cmp_clk 0.478f
Ctic2097 VSS__Xi_core_u_digital i_core_cmp_hard 0.309f
Ctic2098 VSS__Xi_core_u_digital i_core_cmp_soft 0.151105f
Ctic2099 VSS__Xi_core_u_digital i_core_dac_hard_0_ 0.0316316f
Ctic2100 VSS__Xi_core_u_digital i_core_dac_hard_1_ 0.0123158f
Ctic2101 VSS__Xi_core_u_digital i_core_dac_hard_2_ 0.0278947f
Ctic2102 VSS__Xi_core_u_digital i_core_dac_hard_3_ 0.0884211f
Ctic2103 VSS__Xi_core_u_digital i_core_dac_hard_4_ 0.0341053f
Ctic2104 VSS__Xi_core_u_digital i_core_dac_hard_5_ 0.0503684f
Ctic2105 VSS__Xi_core_u_digital i_core_dac_hard_6_ 0.0545263f
Ctic2106 VSS__Xi_core_u_digital i_core_dac_hard_7_ 0.0821579f
Ctic2107 VSS__Xi_core_u_digital i_core_dac_soft_0_ 0.00852632f
Ctic2108 VSS__Xi_core_u_digital i_core_dac_soft_1_ 0.00157895f
Ctic2109 VSS__Xi_core_u_digital i_core_dac_soft_2_ 0.0160526f
Ctic2110 VSS__Xi_core_u_digital i_core_dac_soft_3_ 0.0125263f
Ctic2111 VSS__Xi_core_u_digital i_core_dac_soft_4_ 0.0208421f
Ctic2112 VSS__Xi_core_u_digital i_core_dac_soft_5_ 0.0106316f
Ctic2113 VSS__Xi_core_u_digital i_core_dac_soft_6_ 0.0385263f
Ctic2114 VSS__Xi_core_u_digital i_core_dac_soft_7_ 0.00605263f
Ctic2115 VSS__Xi_core_u_digital i_core_fast_en 0.0104211f
Ctic2116 VSS__Xi_core_u_digital i_core_iptat 0.244684f
Ctic2117 VSS__Xi_core_u_digital i_core_isense 0.146421f
Ctic2118 VSS__Xi_core_u_digital i_core_osc_clk 0.0963158f
Ctic2119 VSS__Xi_core_u_digital i_core_osc_en 0.179316f
Ctic2120 VSS__Xi_core_u_digital i_core_osc_trim_0_ 0.0505789f
Ctic2121 VSS__Xi_core_u_digital i_core_osc_trim_1_ 0.0206842f
Ctic2122 VSS__Xi_core_u_digital i_core_osc_trim_2_ 0.114684f
Ctic2123 VSS__Xi_core_u_digital i_core_osc_trim_3_ 0.0323684f
Ctic2124 VSS__Xi_core_u_digital i_core_pbias 0.065f
Ctic2125 VSS__Xi_core_u_digital i_core_pcasc 0.0258421f
Ctic2126 VSS__Xi_core_u_digital i_core_sclk_i 0.447842f
Ctic2128 VSS__Xi_core_u_digital i_core_sdi_i 1.00005f
Ctic2130 VSS__Xi_core_u_digital i_core_sdo_o 0.106895f
Ctic2131 VSS__Xi_core_u_digital i_core_sdo_o__Xpad16_sdo 0.000789474f
Ctic2132 VSS__Xi_core_u_digital i_core_t2f_en_12 0.0402105f
Ctic2133 VSS__Xi_core_u_digital i_core_t2f_en_33 0.164632f
Ctic2134 VSS__Xi_core_u_digital i_core_t2f_mode_12 0.0211053f
Ctic2135 VSS__Xi_core_u_digital i_core_t2f_mode_33 0.312895f
Ctic2136 VSS__Xi_core_u_digital i_core_temp_out_o__Xpad17_temp_out 0.0509474f
Ctic2137 VSS__Xi_core_u_digital i_core_trip_d 0.00552632f
Ctic2138 VSS__Xi_core_u_digital i_core_trip_set__Xpad13_trip_set 0.000105263f
Ctic2139 VSS__Xi_core_u_digital i_core_tripped 0.156526f
Ctic2140 VSS__Xi_core_u_digital i_core_vref 0.0726842f
Ctic2141 VSS__Xi_core_u_digital i_core_vref__Xi_core_u_t2f 0.000947368f
Ctic2143 VSS__Xi_core_u_digital i_core_vref_buf 0.161211f
Ctic2144 VSS__Xi_core_u_digital net 0.352316f
Ctic2145 VSS__Xi_core_u_digital_1 _nc1__Xpad07_vdda 0.000421053f
Ctic2146 VSS__Xi_core_u_digital_1 _nc2__Xpad08_sense_p 0.000368421f
Ctic2147 VSS__Xi_core_u_digital_1 _nc3__Xpad09_sense_n 0.000421053f
Ctic2148 VSS__Xi_core_u_digital_1 _nc4__Xpad19_g_shared 0.000315789f
Ctic2149 VSS__Xi_core_u_digital_1 _nc5__Xpad20_d_std 0.000315789f
Ctic2150 VSS__Xi_core_u_digital_1 _nc6__Xpad21_d_elt 0.000315789f
Ctic2151 VSS__Xi_core_u_digital_1 _nc7__Xpad22_hbt_e 0.000315789f
Ctic2152 VSS__Xi_core_u_digital_1 _nc8__Xpad23_hbt_b 0.000368421f
Ctic2153 VSS__Xi_core_u_digital_1 _nc9__Xpad24_hbt_c 0.000368421f
Ctic2154 VSS__Xi_core_u_digital_1 en_i__Xpad12_en 0.450316f
Ctic2155 VSS__Xi_core_u_digital_1 fault_n_o__Xpad11_fault_n 0.546632f
Ctic2156 VSS__Xi_core_u_digital_1 gate_o__Xpad10_gate 0.0812105f
Ctic2157 VSS__Xi_core_u_digital_1 i_core_bgr_r4_12 0.0756842f
Ctic2158 VSS__Xi_core_u_digital_1 i_core_bgr_r4_33 0.0912632f
Ctic2159 VSS__Xi_core_u_digital_1 i_core_clr_d 0.008f
Ctic2160 VSS__Xi_core_u_digital_1 i_core_cmp_clk__Xi_core_u_trip 0.478f
Ctic2161 VSS__Xi_core_u_digital_1 i_core_cmp_hard__Xi_core_u_trip 0.309f
Ctic2162 VSS__Xi_core_u_digital_1 i_core_cmp_soft__retained_fullchip_sg13g2_antennanp_1022_880_891_000 0.151105f
Ctic2163 VSS__Xi_core_u_digital_1 i_core_dac_hard_0___Xi_core_u_trip 0.0316316f
Ctic2164 VSS__Xi_core_u_digital_1 i_core_dac_hard_1___Xi_core_u_trip 0.0123158f
Ctic2165 VSS__Xi_core_u_digital_1 i_core_dac_hard_2___Xi_core_u_trip 0.0278947f
Ctic2166 VSS__Xi_core_u_digital_1 i_core_dac_hard_3___Xi_core_u_trip 0.0884211f
Ctic2167 VSS__Xi_core_u_digital_1 i_core_dac_hard_4___Xi_core_u_trip 0.0341053f
Ctic2168 VSS__Xi_core_u_digital_1 i_core_dac_hard_5___Xi_core_u_trip 0.0503684f
Ctic2169 VSS__Xi_core_u_digital_1 i_core_dac_hard_6___Xi_core_u_trip 0.0545263f
Ctic2170 VSS__Xi_core_u_digital_1 i_core_dac_hard_7___Xi_core_u_trip 0.0821579f
Ctic2171 VSS__Xi_core_u_digital_1 i_core_dac_soft_0___Xi_core_u_trip 0.00852632f
Ctic2172 VSS__Xi_core_u_digital_1 i_core_dac_soft_1___Xi_core_u_trip 0.00157895f
Ctic2173 VSS__Xi_core_u_digital_1 i_core_dac_soft_2___Xi_core_u_trip 0.0160526f
Ctic2174 VSS__Xi_core_u_digital_1 i_core_dac_soft_3___Xi_core_u_trip 0.0125263f
Ctic2175 VSS__Xi_core_u_digital_1 i_core_dac_soft_4___Xi_core_u_trip 0.0208421f
Ctic2176 VSS__Xi_core_u_digital_1 i_core_dac_soft_5___Xi_core_u_trip 0.0106316f
Ctic2177 VSS__Xi_core_u_digital_1 i_core_dac_soft_6___Xi_core_u_trip 0.0385263f
Ctic2178 VSS__Xi_core_u_digital_1 i_core_dac_soft_7___Xi_core_u_trip 0.00605263f
Ctic2179 VSS__Xi_core_u_digital_1 i_core_fast_en__Xi_core_u_gate 0.0104211f
Ctic2180 VSS__Xi_core_u_digital_1 i_core_iptat__Xi_core_u_sense 0.244684f
Ctic2181 VSS__Xi_core_u_digital_1 i_core_isense 0.146421f
Ctic2182 VSS__Xi_core_u_digital_1 i_core_osc_clk__Xi_core_u_osc 0.0963158f
Ctic2183 VSS__Xi_core_u_digital_1 i_core_osc_en__Xi_core_u_osc 0.179316f
Ctic2184 VSS__Xi_core_u_digital_1 i_core_osc_trim_0___Xi_core_u_osc 0.0505789f
Ctic2185 VSS__Xi_core_u_digital_1 i_core_osc_trim_1___Xi_core_u_osc 0.0206842f
Ctic2186 VSS__Xi_core_u_digital_1 i_core_osc_trim_2___Xi_core_u_osc 0.114684f
Ctic2187 VSS__Xi_core_u_digital_1 i_core_osc_trim_3___Xi_core_u_osc 0.0323684f
Ctic2188 VSS__Xi_core_u_digital_1 i_core_pbias__Xi_core_u_t2f 0.065f
Ctic2189 VSS__Xi_core_u_digital_1 i_core_pcasc__Xi_core_u_t2f 0.0258421f
Ctic2190 VSS__Xi_core_u_digital_1 i_core_sclk_i 0.447842f
Ctic2193 VSS__Xi_core_u_digital_1 i_core_sdi_i__retained_fullchip_sg13g2_antennanp_1024_320_891_000 1.00005f
Ctic2194 VSS__Xi_core_u_digital_1 i_core_sdo_o__Xpad16_sdo 0.107684f
Ctic2195 VSS__Xi_core_u_digital_1 i_core_t2f_en_12 0.0402105f
Ctic2196 VSS__Xi_core_u_digital_1 i_core_t2f_en_33__Xi_core_u_t2f 0.164632f
Ctic2197 VSS__Xi_core_u_digital_1 i_core_t2f_mode_12 0.0211053f
Ctic2198 VSS__Xi_core_u_digital_1 i_core_t2f_mode_33__Xi_core_u_t2f 0.312895f
Ctic2199 VSS__Xi_core_u_digital_1 i_core_temp_out_o 0.0501053f
Ctic2200 VSS__Xi_core_u_digital_1 i_core_temp_out_o__Xpad17_temp_out 0.000842105f
Ctic2201 VSS__Xi_core_u_digital_1 i_core_trip_d__Xi_core_u_gate 0.00552632f
Ctic2202 VSS__Xi_core_u_digital_1 i_core_trip_set__Xpad13_trip_set 0.000105263f
Ctic2203 VSS__Xi_core_u_digital_1 i_core_tripped__retained_fullchip_sg13g2_antennanp_1027_200_891_000 0.156526f
Ctic2204 VSS__Xi_core_u_digital_1 i_core_vref__Xi_core_u_t2f 0.000947368f
Ctic2205 VSS__Xi_core_u_digital_1 i_core_vref__Xpad18_vref 0.0726842f
Ctic2206 VSS__Xi_core_u_digital_1 i_core_vref_buf 0.161211f
Ctic2207 VSS__Xi_core_u_digital_1 net__Xi_core_u_digital_1 0.352316f
Ctic2208 VSS__Xi_core_u_dose _nc1__Xpad07_vdda 0.000421053f
Ctic2209 VSS__Xi_core_u_dose _nc2__Xpad08_sense_p 0.000368421f
Ctic2210 VSS__Xi_core_u_dose _nc3__Xpad09_sense_n 0.000421053f
Ctic2211 VSS__Xi_core_u_dose _nc4__Xpad19_g_shared 0.000315789f
Ctic2212 VSS__Xi_core_u_dose _nc5__Xpad20_d_std 0.000315789f
Ctic2213 VSS__Xi_core_u_dose _nc6__Xpad21_d_elt 0.000315789f
Ctic2214 VSS__Xi_core_u_dose _nc7__Xpad22_hbt_e 0.000315789f
Ctic2215 VSS__Xi_core_u_dose _nc8__Xpad23_hbt_b 0.000368421f
Ctic2216 VSS__Xi_core_u_dose _nc9__Xpad24_hbt_c 0.000368421f
Ctic2217 VSS__Xi_core_u_dose en_i__Xi_core_u_gate 0.450105f
Ctic2218 VSS__Xi_core_u_dose en_i__Xpad12_en 0.000210526f
Ctic2219 VSS__Xi_core_u_dose fault_n_o 0.545211f
Ctic2220 VSS__Xi_core_u_dose fault_n_o__Xpad11_fault_n 0.00142105f
Ctic2221 VSS__Xi_core_u_dose gate_o 0.0797368f
Ctic2222 VSS__Xi_core_u_dose gate_o__Xpad10_gate 0.00147368f
Ctic2223 VSS__Xi_core_u_dose i_core_bgr_r4_12__Xi_core_u_ls_r4 0.0756842f
Ctic2224 VSS__Xi_core_u_dose i_core_bgr_r4_33__Xi_core_u_ls_r4 0.0912632f
Ctic2225 VSS__Xi_core_u_dose i_core_clr_d__Xi_core_u_gate 0.008f
Ctic2226 VSS__Xi_core_u_dose i_core_cmp_clk 0.478f
Ctic2227 VSS__Xi_core_u_dose i_core_cmp_hard__Xi_core_u_gate 0.309f
Ctic2228 VSS__Xi_core_u_dose i_core_cmp_soft 0.151105f
Ctic2229 VSS__Xi_core_u_dose i_core_dac_hard_0_ 0.0316316f
Ctic2230 VSS__Xi_core_u_dose i_core_dac_hard_1_ 0.0123158f
Ctic2231 VSS__Xi_core_u_dose i_core_dac_hard_2_ 0.0278947f
Ctic2232 VSS__Xi_core_u_dose i_core_dac_hard_3_ 0.0884211f
Ctic2233 VSS__Xi_core_u_dose i_core_dac_hard_4_ 0.0341053f
Ctic2234 VSS__Xi_core_u_dose i_core_dac_hard_5_ 0.0503684f
Ctic2235 VSS__Xi_core_u_dose i_core_dac_hard_6_ 0.0545263f
Ctic2236 VSS__Xi_core_u_dose i_core_dac_hard_7_ 0.0821579f
Ctic2237 VSS__Xi_core_u_dose i_core_dac_soft_0___Xi_core_u_trip 0.00852632f
Ctic2238 VSS__Xi_core_u_dose i_core_dac_soft_1___Xi_core_u_trip 0.00157895f
Ctic2239 VSS__Xi_core_u_dose i_core_dac_soft_2___Xi_core_u_trip 0.0160526f
Ctic2240 VSS__Xi_core_u_dose i_core_dac_soft_3___Xi_core_u_trip 0.0125263f
Ctic2241 VSS__Xi_core_u_dose i_core_dac_soft_4___Xi_core_u_trip 0.0208421f
Ctic2242 VSS__Xi_core_u_dose i_core_dac_soft_5___Xi_core_u_trip 0.0106316f
Ctic2243 VSS__Xi_core_u_dose i_core_dac_soft_6___Xi_core_u_trip 0.0385263f
Ctic2244 VSS__Xi_core_u_dose i_core_dac_soft_7___Xi_core_u_trip 0.00605263f
Ctic2245 VSS__Xi_core_u_dose i_core_fast_en__Xi_core_u_gate 0.0104211f
Ctic2246 VSS__Xi_core_u_dose i_core_iptat__Xi_core_u_sense 0.244684f
Ctic2247 VSS__Xi_core_u_dose i_core_isense 0.146421f
Ctic2248 VSS__Xi_core_u_dose i_core_osc_clk 0.0963158f
Ctic2249 VSS__Xi_core_u_dose i_core_osc_en 0.179316f
Ctic2250 VSS__Xi_core_u_dose i_core_osc_trim_0_ 0.0505789f
Ctic2251 VSS__Xi_core_u_dose i_core_osc_trim_1_ 0.0206842f
Ctic2252 VSS__Xi_core_u_dose i_core_osc_trim_2_ 0.114684f
Ctic2253 VSS__Xi_core_u_dose i_core_osc_trim_3_ 0.0323684f
Ctic2254 VSS__Xi_core_u_dose i_core_pbias 0.065f
Ctic2255 VSS__Xi_core_u_dose i_core_pcasc 0.0258421f
Ctic2256 VSS__Xi_core_u_dose i_core_sclk_i 0.447842f
Ctic2258 VSS__Xi_core_u_dose i_core_sdi_i 1.00005f
Ctic2260 VSS__Xi_core_u_dose i_core_sdo_o 0.106895f
Ctic2261 VSS__Xi_core_u_dose i_core_sdo_o__Xpad16_sdo 0.000789474f
Ctic2262 VSS__Xi_core_u_dose i_core_t2f_en_12__Xi_core_u_ls_en 0.0402105f
Ctic2263 VSS__Xi_core_u_dose i_core_t2f_en_33 0.164632f
Ctic2264 VSS__Xi_core_u_dose i_core_t2f_mode_12__Xi_core_u_ls_mode 0.0211053f
Ctic2265 VSS__Xi_core_u_dose i_core_t2f_mode_33 0.312895f
Ctic2266 VSS__Xi_core_u_dose i_core_temp_out_o__Xpad17_temp_out 0.0509474f
Ctic2267 VSS__Xi_core_u_dose i_core_trip_d__Xi_core_u_gate 0.00552632f
Ctic2268 VSS__Xi_core_u_dose i_core_trip_set__Xpad13_trip_set 0.000105263f
Ctic2269 VSS__Xi_core_u_dose i_core_tripped 0.156526f
Ctic2270 VSS__Xi_core_u_dose i_core_vref__Xi_core_u_sense 0.0726842f
Ctic2271 VSS__Xi_core_u_dose i_core_vref__Xi_core_u_t2f 0.000947368f
Ctic2273 VSS__Xi_core_u_dose i_core_vref_buf 0.161211f
Ctic2274 VSS__Xi_core_u_dose net 0.352316f
Ctic2275 VSS__Xi_core_u_dut _nc1__Xpad07_vdda 0.000421053f
Ctic2276 VSS__Xi_core_u_dut _nc2__Xpad08_sense_p 0.000368421f
Ctic2277 VSS__Xi_core_u_dut _nc3__Xpad09_sense_n 0.000421053f
Ctic2278 VSS__Xi_core_u_dut _nc4__Xpad19_g_shared 0.000315789f
Ctic2279 VSS__Xi_core_u_dut _nc5__Xpad20_d_std 0.000315789f
Ctic2280 VSS__Xi_core_u_dut _nc6__Xpad21_d_elt 0.000315789f
Ctic2281 VSS__Xi_core_u_dut _nc7__Xpad22_hbt_e 0.000315789f
Ctic2282 VSS__Xi_core_u_dut _nc8__Xpad23_hbt_b 0.000368421f
Ctic2283 VSS__Xi_core_u_dut _nc9__Xpad24_hbt_c 0.000368421f
Ctic2284 VSS__Xi_core_u_dut en_i__Xi_core_u_gate 0.450105f
Ctic2285 VSS__Xi_core_u_dut en_i__Xpad12_en 0.000210526f
Ctic2286 VSS__Xi_core_u_dut fault_n_o 0.545211f
Ctic2287 VSS__Xi_core_u_dut fault_n_o__Xpad11_fault_n 0.00142105f
Ctic2288 VSS__Xi_core_u_dut gate_o 0.0797368f
Ctic2289 VSS__Xi_core_u_dut gate_o__Xpad10_gate 0.00147368f
Ctic2290 VSS__Xi_core_u_dut i_core_bgr_r4_12__Xi_core_u_ls_r4 0.0756842f
Ctic2291 VSS__Xi_core_u_dut i_core_bgr_r4_33__Xi_core_u_ls_r4 0.0912632f
Ctic2292 VSS__Xi_core_u_dut i_core_clr_d__Xi_core_u_gate 0.008f
Ctic2293 VSS__Xi_core_u_dut i_core_cmp_clk 0.478f
Ctic2294 VSS__Xi_core_u_dut i_core_cmp_hard__Xi_core_u_gate 0.309f
Ctic2295 VSS__Xi_core_u_dut i_core_cmp_soft 0.151105f
Ctic2296 VSS__Xi_core_u_dut i_core_dac_hard_0_ 0.0316316f
Ctic2297 VSS__Xi_core_u_dut i_core_dac_hard_1_ 0.0123158f
Ctic2298 VSS__Xi_core_u_dut i_core_dac_hard_2_ 0.0278947f
Ctic2299 VSS__Xi_core_u_dut i_core_dac_hard_3_ 0.0884211f
Ctic2300 VSS__Xi_core_u_dut i_core_dac_hard_4_ 0.0341053f
Ctic2301 VSS__Xi_core_u_dut i_core_dac_hard_5_ 0.0503684f
Ctic2302 VSS__Xi_core_u_dut i_core_dac_hard_6_ 0.0545263f
Ctic2303 VSS__Xi_core_u_dut i_core_dac_hard_7_ 0.0821579f
Ctic2304 VSS__Xi_core_u_dut i_core_dac_soft_0___Xi_core_u_trip 0.00852632f
Ctic2305 VSS__Xi_core_u_dut i_core_dac_soft_1___Xi_core_u_trip 0.00157895f
Ctic2306 VSS__Xi_core_u_dut i_core_dac_soft_2___Xi_core_u_trip 0.0160526f
Ctic2307 VSS__Xi_core_u_dut i_core_dac_soft_3___Xi_core_u_trip 0.0125263f
Ctic2308 VSS__Xi_core_u_dut i_core_dac_soft_4___Xi_core_u_trip 0.0208421f
Ctic2309 VSS__Xi_core_u_dut i_core_dac_soft_5___Xi_core_u_trip 0.0106316f
Ctic2310 VSS__Xi_core_u_dut i_core_dac_soft_6___Xi_core_u_trip 0.0385263f
Ctic2311 VSS__Xi_core_u_dut i_core_dac_soft_7___Xi_core_u_trip 0.00605263f
Ctic2312 VSS__Xi_core_u_dut i_core_fast_en__Xi_core_u_gate 0.0104211f
Ctic2313 VSS__Xi_core_u_dut i_core_iptat__Xi_core_u_sense 0.244684f
Ctic2314 VSS__Xi_core_u_dut i_core_isense 0.146421f
Ctic2315 VSS__Xi_core_u_dut i_core_osc_clk 0.0963158f
Ctic2316 VSS__Xi_core_u_dut i_core_osc_en 0.179316f
Ctic2317 VSS__Xi_core_u_dut i_core_osc_trim_0_ 0.0505789f
Ctic2318 VSS__Xi_core_u_dut i_core_osc_trim_1_ 0.0206842f
Ctic2319 VSS__Xi_core_u_dut i_core_osc_trim_2_ 0.114684f
Ctic2320 VSS__Xi_core_u_dut i_core_osc_trim_3_ 0.0323684f
Ctic2321 VSS__Xi_core_u_dut i_core_pbias 0.065f
Ctic2322 VSS__Xi_core_u_dut i_core_pcasc 0.0258421f
Ctic2323 VSS__Xi_core_u_dut i_core_sclk_i 0.447842f
Ctic2325 VSS__Xi_core_u_dut i_core_sdi_i 1.00005f
Ctic2327 VSS__Xi_core_u_dut i_core_sdo_o 0.106895f
Ctic2328 VSS__Xi_core_u_dut i_core_sdo_o__Xpad16_sdo 0.000789474f
Ctic2329 VSS__Xi_core_u_dut i_core_t2f_en_12__Xi_core_u_ls_en 0.0402105f
Ctic2330 VSS__Xi_core_u_dut i_core_t2f_en_33 0.164632f
Ctic2331 VSS__Xi_core_u_dut i_core_t2f_mode_12__Xi_core_u_ls_mode 0.0211053f
Ctic2332 VSS__Xi_core_u_dut i_core_t2f_mode_33 0.312895f
Ctic2333 VSS__Xi_core_u_dut i_core_temp_out_o__Xpad17_temp_out 0.0509474f
Ctic2334 VSS__Xi_core_u_dut i_core_trip_d__Xi_core_u_gate 0.00552632f
Ctic2335 VSS__Xi_core_u_dut i_core_trip_set__Xpad13_trip_set 0.000105263f
Ctic2336 VSS__Xi_core_u_dut i_core_tripped 0.156526f
Ctic2337 VSS__Xi_core_u_dut i_core_vref__Xi_core_u_sense 0.0726842f
Ctic2338 VSS__Xi_core_u_dut i_core_vref__Xi_core_u_t2f 0.000947368f
Ctic2340 VSS__Xi_core_u_dut i_core_vref_buf 0.161211f
Ctic2341 VSS__Xi_core_u_dut net 0.352316f
Ctic2342 VSS__Xi_core_u_gate _nc1__Xpad07_vdda 0.000421053f
Ctic2343 VSS__Xi_core_u_gate _nc2__Xpad08_sense_p 0.000368421f
Ctic2344 VSS__Xi_core_u_gate _nc3__Xpad09_sense_n 0.000421053f
Ctic2345 VSS__Xi_core_u_gate _nc4__Xpad19_g_shared 0.000315789f
Ctic2346 VSS__Xi_core_u_gate _nc5__Xpad20_d_std 0.000315789f
Ctic2347 VSS__Xi_core_u_gate _nc6__Xpad21_d_elt 0.000315789f
Ctic2348 VSS__Xi_core_u_gate _nc7__Xpad22_hbt_e 0.000315789f
Ctic2349 VSS__Xi_core_u_gate _nc8__Xpad23_hbt_b 0.000368421f
Ctic2350 VSS__Xi_core_u_gate _nc9__Xpad24_hbt_c 0.000368421f
Ctic2351 VSS__Xi_core_u_gate en_i 0.450105f
Ctic2352 VSS__Xi_core_u_gate en_i__Xpad12_en 0.000210526f
Ctic2353 VSS__Xi_core_u_gate fault_n_o 0.545211f
Ctic2354 VSS__Xi_core_u_gate fault_n_o__Xpad11_fault_n 0.00142105f
Ctic2355 VSS__Xi_core_u_gate gate_o 0.0797368f
Ctic2356 VSS__Xi_core_u_gate gate_o__Xpad10_gate 0.00147368f
Ctic2357 VSS__Xi_core_u_gate i_core_bgr_r4_12 0.0756842f
Ctic2358 VSS__Xi_core_u_gate i_core_bgr_r4_33__Xi_core_u_ls_r4 0.0912632f
Ctic2359 VSS__Xi_core_u_gate i_core_clr_d 0.008f
Ctic2360 VSS__Xi_core_u_gate i_core_cmp_clk 0.478f
Ctic2361 VSS__Xi_core_u_gate i_core_cmp_hard__Xi_core_u_gate 0.309f
Ctic2362 VSS__Xi_core_u_gate i_core_cmp_soft__retained_fullchip_sg13g2_antennanp_1021_440_891_000 0.151105f
Ctic2363 VSS__Xi_core_u_gate i_core_dac_hard_0_ 0.0316316f
Ctic2364 VSS__Xi_core_u_gate i_core_dac_hard_1_ 0.0123158f
Ctic2365 VSS__Xi_core_u_gate i_core_dac_hard_2_ 0.0278947f
Ctic2366 VSS__Xi_core_u_gate i_core_dac_hard_3_ 0.0884211f
Ctic2367 VSS__Xi_core_u_gate i_core_dac_hard_4_ 0.0341053f
Ctic2368 VSS__Xi_core_u_gate i_core_dac_hard_5_ 0.0503684f
Ctic2369 VSS__Xi_core_u_gate i_core_dac_hard_6_ 0.0545263f
Ctic2370 VSS__Xi_core_u_gate i_core_dac_hard_7_ 0.0821579f
Ctic2371 VSS__Xi_core_u_gate i_core_dac_soft_0___Xi_core_u_trip 0.00852632f
Ctic2372 VSS__Xi_core_u_gate i_core_dac_soft_1___Xi_core_u_trip 0.00157895f
Ctic2373 VSS__Xi_core_u_gate i_core_dac_soft_2___Xi_core_u_trip 0.0160526f
Ctic2374 VSS__Xi_core_u_gate i_core_dac_soft_3___Xi_core_u_trip 0.0125263f
Ctic2375 VSS__Xi_core_u_gate i_core_dac_soft_4___Xi_core_u_trip 0.0208421f
Ctic2376 VSS__Xi_core_u_gate i_core_dac_soft_5___Xi_core_u_trip 0.0106316f
Ctic2377 VSS__Xi_core_u_gate i_core_dac_soft_6___Xi_core_u_trip 0.0385263f
Ctic2378 VSS__Xi_core_u_gate i_core_dac_soft_7___Xi_core_u_trip 0.00605263f
Ctic2379 VSS__Xi_core_u_gate i_core_fast_en__Xi_core_u_gate 0.0104211f
Ctic2380 VSS__Xi_core_u_gate i_core_iptat__Xi_core_u_sense 0.244684f
Ctic2381 VSS__Xi_core_u_gate i_core_isense 0.146421f
Ctic2382 VSS__Xi_core_u_gate i_core_osc_clk 0.0963158f
Ctic2383 VSS__Xi_core_u_gate i_core_osc_en 0.179316f
Ctic2384 VSS__Xi_core_u_gate i_core_osc_trim_0_ 0.0505789f
Ctic2385 VSS__Xi_core_u_gate i_core_osc_trim_1_ 0.0206842f
Ctic2386 VSS__Xi_core_u_gate i_core_osc_trim_2_ 0.114684f
Ctic2387 VSS__Xi_core_u_gate i_core_osc_trim_3_ 0.0323684f
Ctic2388 VSS__Xi_core_u_gate i_core_pbias 0.065f
Ctic2389 VSS__Xi_core_u_gate i_core_pcasc 0.0258421f
Ctic2390 VSS__Xi_core_u_gate i_core_sclk_i 0.447842f
Ctic2393 VSS__Xi_core_u_gate i_core_sdi_i__retained_fullchip_sg13g2_antennanp_1024_320_891_000 1.00005f
Ctic2394 VSS__Xi_core_u_gate i_core_sdo_o 0.106895f
Ctic2395 VSS__Xi_core_u_gate i_core_sdo_o__Xpad16_sdo 0.000789474f
Ctic2396 VSS__Xi_core_u_gate i_core_t2f_en_12 0.0402105f
Ctic2397 VSS__Xi_core_u_gate i_core_t2f_en_33 0.164632f
Ctic2398 VSS__Xi_core_u_gate i_core_t2f_mode_12 0.0211053f
Ctic2399 VSS__Xi_core_u_gate i_core_t2f_mode_33 0.312895f
Ctic2400 VSS__Xi_core_u_gate i_core_temp_out_o__Xpad17_temp_out 0.0509474f
Ctic2401 VSS__Xi_core_u_gate i_core_trip_d 0.00552632f
Ctic2402 VSS__Xi_core_u_gate i_core_trip_set__Xpad13_trip_set 0.000105263f
Ctic2403 VSS__Xi_core_u_gate i_core_tripped__Xi_core_u_gate 0.156526f
Ctic2404 VSS__Xi_core_u_gate i_core_vref__Xi_core_u_sense 0.0726842f
Ctic2405 VSS__Xi_core_u_gate i_core_vref__Xi_core_u_t2f 0.000947368f
Ctic2407 VSS__Xi_core_u_gate i_core_vref_buf 0.161211f
Ctic2408 VSS__Xi_core_u_gate net 0.352316f
Ctic2409 VSS__Xi_core_u_ls_en _nc1__Xpad07_vdda 0.000421053f
Ctic2410 VSS__Xi_core_u_ls_en _nc2__Xpad08_sense_p 0.000368421f
Ctic2411 VSS__Xi_core_u_ls_en _nc3__Xpad09_sense_n 0.000421053f
Ctic2412 VSS__Xi_core_u_ls_en _nc4__Xpad19_g_shared 0.000315789f
Ctic2413 VSS__Xi_core_u_ls_en _nc5__Xpad20_d_std 0.000315789f
Ctic2414 VSS__Xi_core_u_ls_en _nc6__Xpad21_d_elt 0.000315789f
Ctic2415 VSS__Xi_core_u_ls_en _nc7__Xpad22_hbt_e 0.000315789f
Ctic2416 VSS__Xi_core_u_ls_en _nc8__Xpad23_hbt_b 0.000368421f
Ctic2417 VSS__Xi_core_u_ls_en _nc9__Xpad24_hbt_c 0.000368421f
Ctic2418 VSS__Xi_core_u_ls_en en_i__Xi_core_u_gate 0.450105f
Ctic2419 VSS__Xi_core_u_ls_en en_i__Xpad12_en 0.000210526f
Ctic2420 VSS__Xi_core_u_ls_en fault_n_o 0.545211f
Ctic2421 VSS__Xi_core_u_ls_en fault_n_o__Xpad11_fault_n 0.00142105f
Ctic2422 VSS__Xi_core_u_ls_en gate_o 0.0797368f
Ctic2423 VSS__Xi_core_u_ls_en gate_o__Xpad10_gate 0.00147368f
Ctic2424 VSS__Xi_core_u_ls_en i_core_bgr_r4_12__Xi_core_u_ls_r4 0.0756842f
Ctic2425 VSS__Xi_core_u_ls_en i_core_bgr_r4_33__Xi_core_u_ls_r4 0.0912632f
Ctic2426 VSS__Xi_core_u_ls_en i_core_clr_d__Xi_core_u_gate 0.008f
Ctic2427 VSS__Xi_core_u_ls_en i_core_cmp_clk 0.478f
Ctic2428 VSS__Xi_core_u_ls_en i_core_cmp_hard__Xi_core_u_gate 0.309f
Ctic2429 VSS__Xi_core_u_ls_en i_core_cmp_soft 0.151105f
Ctic2430 VSS__Xi_core_u_ls_en i_core_dac_hard_0_ 0.0316316f
Ctic2431 VSS__Xi_core_u_ls_en i_core_dac_hard_1_ 0.0123158f
Ctic2432 VSS__Xi_core_u_ls_en i_core_dac_hard_2_ 0.0278947f
Ctic2433 VSS__Xi_core_u_ls_en i_core_dac_hard_3_ 0.0884211f
Ctic2434 VSS__Xi_core_u_ls_en i_core_dac_hard_4_ 0.0341053f
Ctic2435 VSS__Xi_core_u_ls_en i_core_dac_hard_5_ 0.0503684f
Ctic2436 VSS__Xi_core_u_ls_en i_core_dac_hard_6_ 0.0545263f
Ctic2437 VSS__Xi_core_u_ls_en i_core_dac_hard_7_ 0.0821579f
Ctic2438 VSS__Xi_core_u_ls_en i_core_dac_soft_0___Xi_core_u_trip 0.00852632f
Ctic2439 VSS__Xi_core_u_ls_en i_core_dac_soft_1___Xi_core_u_trip 0.00157895f
Ctic2440 VSS__Xi_core_u_ls_en i_core_dac_soft_2___Xi_core_u_trip 0.0160526f
Ctic2441 VSS__Xi_core_u_ls_en i_core_dac_soft_3___Xi_core_u_trip 0.0125263f
Ctic2442 VSS__Xi_core_u_ls_en i_core_dac_soft_4___Xi_core_u_trip 0.0208421f
Ctic2443 VSS__Xi_core_u_ls_en i_core_dac_soft_5___Xi_core_u_trip 0.0106316f
Ctic2444 VSS__Xi_core_u_ls_en i_core_dac_soft_6___Xi_core_u_trip 0.0385263f
Ctic2445 VSS__Xi_core_u_ls_en i_core_dac_soft_7___Xi_core_u_trip 0.00605263f
Ctic2446 VSS__Xi_core_u_ls_en i_core_fast_en__Xi_core_u_gate 0.0104211f
Ctic2447 VSS__Xi_core_u_ls_en i_core_iptat__Xi_core_u_sense 0.244684f
Ctic2448 VSS__Xi_core_u_ls_en i_core_isense 0.146421f
Ctic2449 VSS__Xi_core_u_ls_en i_core_osc_clk 0.0963158f
Ctic2450 VSS__Xi_core_u_ls_en i_core_osc_en 0.179316f
Ctic2451 VSS__Xi_core_u_ls_en i_core_osc_trim_0_ 0.0505789f
Ctic2452 VSS__Xi_core_u_ls_en i_core_osc_trim_1_ 0.0206842f
Ctic2453 VSS__Xi_core_u_ls_en i_core_osc_trim_2_ 0.114684f
Ctic2454 VSS__Xi_core_u_ls_en i_core_osc_trim_3_ 0.0323684f
Ctic2455 VSS__Xi_core_u_ls_en i_core_pbias 0.065f
Ctic2456 VSS__Xi_core_u_ls_en i_core_pcasc 0.0258421f
Ctic2457 VSS__Xi_core_u_ls_en i_core_sclk_i 0.447842f
Ctic2459 VSS__Xi_core_u_ls_en i_core_sdi_i 1.00005f
Ctic2461 VSS__Xi_core_u_ls_en i_core_sdo_o 0.106895f
Ctic2462 VSS__Xi_core_u_ls_en i_core_sdo_o__Xpad16_sdo 0.000789474f
Ctic2463 VSS__Xi_core_u_ls_en i_core_t2f_en_12__Xi_core_u_ls_en 0.0402105f
Ctic2464 VSS__Xi_core_u_ls_en i_core_t2f_en_33 0.164632f
Ctic2465 VSS__Xi_core_u_ls_en i_core_t2f_mode_12__Xi_core_u_ls_mode 0.0211053f
Ctic2466 VSS__Xi_core_u_ls_en i_core_t2f_mode_33 0.312895f
Ctic2467 VSS__Xi_core_u_ls_en i_core_temp_out_o__Xpad17_temp_out 0.0509474f
Ctic2468 VSS__Xi_core_u_ls_en i_core_trip_d__Xi_core_u_gate 0.00552632f
Ctic2469 VSS__Xi_core_u_ls_en i_core_trip_set__Xpad13_trip_set 0.000105263f
Ctic2470 VSS__Xi_core_u_ls_en i_core_tripped 0.156526f
Ctic2471 VSS__Xi_core_u_ls_en i_core_vref__Xi_core_u_sense 0.0726842f
Ctic2472 VSS__Xi_core_u_ls_en i_core_vref__Xi_core_u_t2f 0.000947368f
Ctic2474 VSS__Xi_core_u_ls_en i_core_vref_buf 0.161211f
Ctic2475 VSS__Xi_core_u_ls_en net 0.352316f
Ctic2476 VSS__Xi_core_u_ls_mode _nc1__Xpad07_vdda 0.000421053f
Ctic2477 VSS__Xi_core_u_ls_mode _nc2__Xpad08_sense_p 0.000368421f
Ctic2478 VSS__Xi_core_u_ls_mode _nc3__Xpad09_sense_n 0.000421053f
Ctic2479 VSS__Xi_core_u_ls_mode _nc4__Xpad19_g_shared 0.000315789f
Ctic2480 VSS__Xi_core_u_ls_mode _nc5__Xpad20_d_std 0.000315789f
Ctic2481 VSS__Xi_core_u_ls_mode _nc6__Xpad21_d_elt 0.000315789f
Ctic2482 VSS__Xi_core_u_ls_mode _nc7__Xpad22_hbt_e 0.000315789f
Ctic2483 VSS__Xi_core_u_ls_mode _nc8__Xpad23_hbt_b 0.000368421f
Ctic2484 VSS__Xi_core_u_ls_mode _nc9__Xpad24_hbt_c 0.000368421f
Ctic2485 VSS__Xi_core_u_ls_mode en_i__Xi_core_u_gate 0.450105f
Ctic2486 VSS__Xi_core_u_ls_mode en_i__Xpad12_en 0.000210526f
Ctic2487 VSS__Xi_core_u_ls_mode fault_n_o 0.545211f
Ctic2488 VSS__Xi_core_u_ls_mode fault_n_o__Xpad11_fault_n 0.00142105f
Ctic2489 VSS__Xi_core_u_ls_mode gate_o 0.0797368f
Ctic2490 VSS__Xi_core_u_ls_mode gate_o__Xpad10_gate 0.00147368f
Ctic2491 VSS__Xi_core_u_ls_mode i_core_bgr_r4_12__Xi_core_u_ls_r4 0.0756842f
Ctic2492 VSS__Xi_core_u_ls_mode i_core_bgr_r4_33__Xi_core_u_ls_r4 0.0912632f
Ctic2493 VSS__Xi_core_u_ls_mode i_core_clr_d__Xi_core_u_gate 0.008f
Ctic2494 VSS__Xi_core_u_ls_mode i_core_cmp_clk 0.478f
Ctic2495 VSS__Xi_core_u_ls_mode i_core_cmp_hard__Xi_core_u_gate 0.309f
Ctic2496 VSS__Xi_core_u_ls_mode i_core_cmp_soft 0.151105f
Ctic2497 VSS__Xi_core_u_ls_mode i_core_dac_hard_0_ 0.0316316f
Ctic2498 VSS__Xi_core_u_ls_mode i_core_dac_hard_1_ 0.0123158f
Ctic2499 VSS__Xi_core_u_ls_mode i_core_dac_hard_2_ 0.0278947f
Ctic2500 VSS__Xi_core_u_ls_mode i_core_dac_hard_3_ 0.0884211f
Ctic2501 VSS__Xi_core_u_ls_mode i_core_dac_hard_4_ 0.0341053f
Ctic2502 VSS__Xi_core_u_ls_mode i_core_dac_hard_5_ 0.0503684f
Ctic2503 VSS__Xi_core_u_ls_mode i_core_dac_hard_6_ 0.0545263f
Ctic2504 VSS__Xi_core_u_ls_mode i_core_dac_hard_7_ 0.0821579f
Ctic2505 VSS__Xi_core_u_ls_mode i_core_dac_soft_0___Xi_core_u_trip 0.00852632f
Ctic2506 VSS__Xi_core_u_ls_mode i_core_dac_soft_1___Xi_core_u_trip 0.00157895f
Ctic2507 VSS__Xi_core_u_ls_mode i_core_dac_soft_2___Xi_core_u_trip 0.0160526f
Ctic2508 VSS__Xi_core_u_ls_mode i_core_dac_soft_3___Xi_core_u_trip 0.0125263f
Ctic2509 VSS__Xi_core_u_ls_mode i_core_dac_soft_4___Xi_core_u_trip 0.0208421f
Ctic2510 VSS__Xi_core_u_ls_mode i_core_dac_soft_5___Xi_core_u_trip 0.0106316f
Ctic2511 VSS__Xi_core_u_ls_mode i_core_dac_soft_6___Xi_core_u_trip 0.0385263f
Ctic2512 VSS__Xi_core_u_ls_mode i_core_dac_soft_7___Xi_core_u_trip 0.00605263f
Ctic2513 VSS__Xi_core_u_ls_mode i_core_fast_en__Xi_core_u_gate 0.0104211f
Ctic2514 VSS__Xi_core_u_ls_mode i_core_iptat__Xi_core_u_sense 0.244684f
Ctic2515 VSS__Xi_core_u_ls_mode i_core_isense 0.146421f
Ctic2516 VSS__Xi_core_u_ls_mode i_core_osc_clk 0.0963158f
Ctic2517 VSS__Xi_core_u_ls_mode i_core_osc_en 0.179316f
Ctic2518 VSS__Xi_core_u_ls_mode i_core_osc_trim_0_ 0.0505789f
Ctic2519 VSS__Xi_core_u_ls_mode i_core_osc_trim_1_ 0.0206842f
Ctic2520 VSS__Xi_core_u_ls_mode i_core_osc_trim_2_ 0.114684f
Ctic2521 VSS__Xi_core_u_ls_mode i_core_osc_trim_3_ 0.0323684f
Ctic2522 VSS__Xi_core_u_ls_mode i_core_pbias 0.065f
Ctic2523 VSS__Xi_core_u_ls_mode i_core_pcasc 0.0258421f
Ctic2524 VSS__Xi_core_u_ls_mode i_core_sclk_i 0.447842f
Ctic2526 VSS__Xi_core_u_ls_mode i_core_sdi_i 1.00005f
Ctic2528 VSS__Xi_core_u_ls_mode i_core_sdo_o 0.106895f
Ctic2529 VSS__Xi_core_u_ls_mode i_core_sdo_o__Xpad16_sdo 0.000789474f
Ctic2530 VSS__Xi_core_u_ls_mode i_core_t2f_en_12__Xi_core_u_ls_en 0.0402105f
Ctic2531 VSS__Xi_core_u_ls_mode i_core_t2f_en_33 0.164632f
Ctic2532 VSS__Xi_core_u_ls_mode i_core_t2f_mode_12__Xi_core_u_ls_mode 0.0211053f
Ctic2533 VSS__Xi_core_u_ls_mode i_core_t2f_mode_33 0.312895f
Ctic2534 VSS__Xi_core_u_ls_mode i_core_temp_out_o__Xpad17_temp_out 0.0509474f
Ctic2535 VSS__Xi_core_u_ls_mode i_core_trip_d__Xi_core_u_gate 0.00552632f
Ctic2536 VSS__Xi_core_u_ls_mode i_core_trip_set__Xpad13_trip_set 0.000105263f
Ctic2537 VSS__Xi_core_u_ls_mode i_core_tripped 0.156526f
Ctic2538 VSS__Xi_core_u_ls_mode i_core_vref__Xi_core_u_sense 0.0726842f
Ctic2539 VSS__Xi_core_u_ls_mode i_core_vref__Xi_core_u_t2f 0.000947368f
Ctic2541 VSS__Xi_core_u_ls_mode i_core_vref_buf 0.161211f
Ctic2542 VSS__Xi_core_u_ls_mode net 0.352316f
Ctic2543 VSS__Xi_core_u_ls_r4 _nc1__Xpad07_vdda 0.000421053f
Ctic2544 VSS__Xi_core_u_ls_r4 _nc2__Xpad08_sense_p 0.000368421f
Ctic2545 VSS__Xi_core_u_ls_r4 _nc3__Xpad09_sense_n 0.000421053f
Ctic2546 VSS__Xi_core_u_ls_r4 _nc4__Xpad19_g_shared 0.000315789f
Ctic2547 VSS__Xi_core_u_ls_r4 _nc5__Xpad20_d_std 0.000315789f
Ctic2548 VSS__Xi_core_u_ls_r4 _nc6__Xpad21_d_elt 0.000315789f
Ctic2549 VSS__Xi_core_u_ls_r4 _nc7__Xpad22_hbt_e 0.000315789f
Ctic2550 VSS__Xi_core_u_ls_r4 _nc8__Xpad23_hbt_b 0.000368421f
Ctic2551 VSS__Xi_core_u_ls_r4 _nc9__Xpad24_hbt_c 0.000368421f
Ctic2552 VSS__Xi_core_u_ls_r4 en_i__Xi_core_u_gate 0.450105f
Ctic2553 VSS__Xi_core_u_ls_r4 en_i__Xpad12_en 0.000210526f
Ctic2554 VSS__Xi_core_u_ls_r4 fault_n_o 0.545211f
Ctic2555 VSS__Xi_core_u_ls_r4 fault_n_o__Xpad11_fault_n 0.00142105f
Ctic2556 VSS__Xi_core_u_ls_r4 gate_o 0.0797368f
Ctic2557 VSS__Xi_core_u_ls_r4 gate_o__Xpad10_gate 0.00147368f
Ctic2558 VSS__Xi_core_u_ls_r4 i_core_bgr_r4_12__Xi_core_u_ls_r4 0.0756842f
Ctic2559 VSS__Xi_core_u_ls_r4 i_core_bgr_r4_33__Xi_core_u_ls_r4 0.0912632f
Ctic2560 VSS__Xi_core_u_ls_r4 i_core_clr_d__Xi_core_u_gate 0.008f
Ctic2561 VSS__Xi_core_u_ls_r4 i_core_cmp_clk 0.478f
Ctic2562 VSS__Xi_core_u_ls_r4 i_core_cmp_hard__Xi_core_u_gate 0.309f
Ctic2563 VSS__Xi_core_u_ls_r4 i_core_cmp_soft 0.151105f
Ctic2564 VSS__Xi_core_u_ls_r4 i_core_dac_hard_0_ 0.0316316f
Ctic2565 VSS__Xi_core_u_ls_r4 i_core_dac_hard_1_ 0.0123158f
Ctic2566 VSS__Xi_core_u_ls_r4 i_core_dac_hard_2_ 0.0278947f
Ctic2567 VSS__Xi_core_u_ls_r4 i_core_dac_hard_3_ 0.0884211f
Ctic2568 VSS__Xi_core_u_ls_r4 i_core_dac_hard_4_ 0.0341053f
Ctic2569 VSS__Xi_core_u_ls_r4 i_core_dac_hard_5_ 0.0503684f
Ctic2570 VSS__Xi_core_u_ls_r4 i_core_dac_hard_6_ 0.0545263f
Ctic2571 VSS__Xi_core_u_ls_r4 i_core_dac_hard_7_ 0.0821579f
Ctic2572 VSS__Xi_core_u_ls_r4 i_core_dac_soft_0___Xi_core_u_trip 0.00852632f
Ctic2573 VSS__Xi_core_u_ls_r4 i_core_dac_soft_1___Xi_core_u_trip 0.00157895f
Ctic2574 VSS__Xi_core_u_ls_r4 i_core_dac_soft_2___Xi_core_u_trip 0.0160526f
Ctic2575 VSS__Xi_core_u_ls_r4 i_core_dac_soft_3___Xi_core_u_trip 0.0125263f
Ctic2576 VSS__Xi_core_u_ls_r4 i_core_dac_soft_4___Xi_core_u_trip 0.0208421f
Ctic2577 VSS__Xi_core_u_ls_r4 i_core_dac_soft_5___Xi_core_u_trip 0.0106316f
Ctic2578 VSS__Xi_core_u_ls_r4 i_core_dac_soft_6___Xi_core_u_trip 0.0385263f
Ctic2579 VSS__Xi_core_u_ls_r4 i_core_dac_soft_7___Xi_core_u_trip 0.00605263f
Ctic2580 VSS__Xi_core_u_ls_r4 i_core_fast_en__Xi_core_u_gate 0.0104211f
Ctic2581 VSS__Xi_core_u_ls_r4 i_core_iptat__Xi_core_u_sense 0.244684f
Ctic2582 VSS__Xi_core_u_ls_r4 i_core_isense 0.146421f
Ctic2583 VSS__Xi_core_u_ls_r4 i_core_osc_clk 0.0963158f
Ctic2584 VSS__Xi_core_u_ls_r4 i_core_osc_en 0.179316f
Ctic2585 VSS__Xi_core_u_ls_r4 i_core_osc_trim_0_ 0.0505789f
Ctic2586 VSS__Xi_core_u_ls_r4 i_core_osc_trim_1_ 0.0206842f
Ctic2587 VSS__Xi_core_u_ls_r4 i_core_osc_trim_2_ 0.114684f
Ctic2588 VSS__Xi_core_u_ls_r4 i_core_osc_trim_3_ 0.0323684f
Ctic2589 VSS__Xi_core_u_ls_r4 i_core_pbias 0.065f
Ctic2590 VSS__Xi_core_u_ls_r4 i_core_pcasc 0.0258421f
Ctic2591 VSS__Xi_core_u_ls_r4 i_core_sclk_i 0.447842f
Ctic2593 VSS__Xi_core_u_ls_r4 i_core_sdi_i 1.00005f
Ctic2595 VSS__Xi_core_u_ls_r4 i_core_sdo_o 0.106895f
Ctic2596 VSS__Xi_core_u_ls_r4 i_core_sdo_o__Xpad16_sdo 0.000789474f
Ctic2597 VSS__Xi_core_u_ls_r4 i_core_t2f_en_12__Xi_core_u_ls_en 0.0402105f
Ctic2598 VSS__Xi_core_u_ls_r4 i_core_t2f_en_33 0.164632f
Ctic2599 VSS__Xi_core_u_ls_r4 i_core_t2f_mode_12__Xi_core_u_ls_mode 0.0211053f
Ctic2600 VSS__Xi_core_u_ls_r4 i_core_t2f_mode_33 0.312895f
Ctic2601 VSS__Xi_core_u_ls_r4 i_core_temp_out_o__Xpad17_temp_out 0.0509474f
Ctic2602 VSS__Xi_core_u_ls_r4 i_core_trip_d__Xi_core_u_gate 0.00552632f
Ctic2603 VSS__Xi_core_u_ls_r4 i_core_trip_set__Xpad13_trip_set 0.000105263f
Ctic2604 VSS__Xi_core_u_ls_r4 i_core_tripped 0.156526f
Ctic2605 VSS__Xi_core_u_ls_r4 i_core_vref__Xi_core_u_sense 0.0726842f
Ctic2606 VSS__Xi_core_u_ls_r4 i_core_vref__Xi_core_u_t2f 0.000947368f
Ctic2608 VSS__Xi_core_u_ls_r4 i_core_vref_buf 0.161211f
Ctic2609 VSS__Xi_core_u_ls_r4 net 0.352316f
Ctic2610 VSS__Xi_core_u_osc _nc1__Xpad07_vdda 0.000421053f
Ctic2611 VSS__Xi_core_u_osc _nc2__Xpad08_sense_p 0.000368421f
Ctic2612 VSS__Xi_core_u_osc _nc3__Xpad09_sense_n 0.000421053f
Ctic2613 VSS__Xi_core_u_osc _nc4__Xpad19_g_shared 0.000315789f
Ctic2614 VSS__Xi_core_u_osc _nc5__Xpad20_d_std 0.000315789f
Ctic2615 VSS__Xi_core_u_osc _nc6__Xpad21_d_elt 0.000315789f
Ctic2616 VSS__Xi_core_u_osc _nc7__Xpad22_hbt_e 0.000315789f
Ctic2617 VSS__Xi_core_u_osc _nc8__Xpad23_hbt_b 0.000368421f
Ctic2618 VSS__Xi_core_u_osc _nc9__Xpad24_hbt_c 0.000368421f
Ctic2619 VSS__Xi_core_u_osc en_i__Xpad12_en 0.000210526f
Ctic2620 VSS__Xi_core_u_osc en_i__retained_fullchip_sg13g2_antennanp_1020_000_891_000 0.450105f
Ctic2621 VSS__Xi_core_u_osc fault_n_o__Xpad11_fault_n 0.546632f
Ctic2622 VSS__Xi_core_u_osc gate_o 0.0797368f
Ctic2623 VSS__Xi_core_u_osc gate_o__Xpad10_gate 0.00147368f
Ctic2624 VSS__Xi_core_u_osc i_core_bgr_r4_12 0.0756842f
Ctic2625 VSS__Xi_core_u_osc i_core_bgr_r4_33 0.0912632f
Ctic2626 VSS__Xi_core_u_osc i_core_clr_d 0.008f
Ctic2627 VSS__Xi_core_u_osc i_core_cmp_clk__Xi_core_u_trip 0.478f
Ctic2628 VSS__Xi_core_u_osc i_core_cmp_hard__Xi_core_u_trip 0.309f
Ctic2629 VSS__Xi_core_u_osc i_core_cmp_soft__Xi_core_u_trip 0.151105f
Ctic2630 VSS__Xi_core_u_osc i_core_dac_hard_0___Xi_core_u_trip 0.0316316f
Ctic2631 VSS__Xi_core_u_osc i_core_dac_hard_1___Xi_core_u_trip 0.0123158f
Ctic2632 VSS__Xi_core_u_osc i_core_dac_hard_2___Xi_core_u_trip 0.0278947f
Ctic2633 VSS__Xi_core_u_osc i_core_dac_hard_3___Xi_core_u_trip 0.0884211f
Ctic2634 VSS__Xi_core_u_osc i_core_dac_hard_4___Xi_core_u_trip 0.0341053f
Ctic2635 VSS__Xi_core_u_osc i_core_dac_hard_5___Xi_core_u_trip 0.0503684f
Ctic2636 VSS__Xi_core_u_osc i_core_dac_hard_6___Xi_core_u_trip 0.0545263f
Ctic2637 VSS__Xi_core_u_osc i_core_dac_hard_7___Xi_core_u_trip 0.0821579f
Ctic2638 VSS__Xi_core_u_osc i_core_dac_soft_0___Xi_core_u_trip 0.00852632f
Ctic2639 VSS__Xi_core_u_osc i_core_dac_soft_1___Xi_core_u_trip 0.00157895f
Ctic2640 VSS__Xi_core_u_osc i_core_dac_soft_2___Xi_core_u_trip 0.0160526f
Ctic2641 VSS__Xi_core_u_osc i_core_dac_soft_3___Xi_core_u_trip 0.0125263f
Ctic2642 VSS__Xi_core_u_osc i_core_dac_soft_4___Xi_core_u_trip 0.0208421f
Ctic2643 VSS__Xi_core_u_osc i_core_dac_soft_5___Xi_core_u_trip 0.0106316f
Ctic2644 VSS__Xi_core_u_osc i_core_dac_soft_6___Xi_core_u_trip 0.0385263f
Ctic2645 VSS__Xi_core_u_osc i_core_dac_soft_7___Xi_core_u_trip 0.00605263f
Ctic2646 VSS__Xi_core_u_osc i_core_fast_en 0.0104211f
Ctic2647 VSS__Xi_core_u_osc i_core_iptat 0.244684f
Ctic2648 VSS__Xi_core_u_osc i_core_isense__Xi_core_u_trip 0.146421f
Ctic2649 VSS__Xi_core_u_osc i_core_osc_clk__Xi_core_u_osc 0.0963158f
Ctic2650 VSS__Xi_core_u_osc i_core_osc_en__Xi_core_u_osc 0.179316f
Ctic2651 VSS__Xi_core_u_osc i_core_osc_trim_0___Xi_core_u_osc 0.0505789f
Ctic2652 VSS__Xi_core_u_osc i_core_osc_trim_1___Xi_core_u_osc 0.0206842f
Ctic2653 VSS__Xi_core_u_osc i_core_osc_trim_2___Xi_core_u_osc 0.114684f
Ctic2654 VSS__Xi_core_u_osc i_core_osc_trim_3___Xi_core_u_osc 0.0323684f
Ctic2655 VSS__Xi_core_u_osc i_core_pbias 0.065f
Ctic2656 VSS__Xi_core_u_osc i_core_pcasc 0.0258421f
Ctic2657 VSS__Xi_core_u_osc i_core_sclk_i 0.447842f
Ctic2660 VSS__Xi_core_u_osc i_core_sdi_i__retained_fullchip_sg13g2_antennanp_1024_320_891_000 1.00005f
Ctic2661 VSS__Xi_core_u_osc i_core_sdo_o__Xpad16_sdo 0.107684f
Ctic2662 VSS__Xi_core_u_osc i_core_t2f_en_12 0.0402105f
Ctic2663 VSS__Xi_core_u_osc i_core_t2f_en_33__Xi_core_u_t2f 0.164632f
Ctic2664 VSS__Xi_core_u_osc i_core_t2f_mode_12 0.0211053f
Ctic2665 VSS__Xi_core_u_osc i_core_t2f_mode_33__Xi_core_u_t2f 0.312895f
Ctic2666 VSS__Xi_core_u_osc i_core_temp_out_o__Xpad17_temp_out 0.0509474f
Ctic2667 VSS__Xi_core_u_osc i_core_trip_d 0.00552632f
Ctic2668 VSS__Xi_core_u_osc i_core_trip_set__Xpad13_trip_set 0.000105263f
Ctic2669 VSS__Xi_core_u_osc i_core_tripped__retained_fullchip_sg13g2_antennanp_1027_200_891_000 0.156526f
Ctic2670 VSS__Xi_core_u_osc i_core_vref 0.0726842f
Ctic2671 VSS__Xi_core_u_osc i_core_vref__Xi_core_u_t2f 0.000947368f
Ctic2673 VSS__Xi_core_u_osc i_core_vref_buf__Xi_core_u_trip 0.161211f
Ctic2674 VSS__Xi_core_u_osc net__Xi_core_u_digital_1 0.352316f
Ctic2675 VSS__Xi_core_u_sense _nc1__Xpad07_vdda 0.000421053f
Ctic2676 VSS__Xi_core_u_sense _nc2__Xpad08_sense_p 0.000368421f
Ctic2677 VSS__Xi_core_u_sense _nc3__Xpad09_sense_n 0.000421053f
Ctic2678 VSS__Xi_core_u_sense _nc4__Xpad19_g_shared 0.000315789f
Ctic2679 VSS__Xi_core_u_sense _nc5__Xpad20_d_std 0.000315789f
Ctic2680 VSS__Xi_core_u_sense _nc6__Xpad21_d_elt 0.000315789f
Ctic2681 VSS__Xi_core_u_sense _nc7__Xpad22_hbt_e 0.000315789f
Ctic2682 VSS__Xi_core_u_sense _nc8__Xpad23_hbt_b 0.000368421f
Ctic2683 VSS__Xi_core_u_sense _nc9__Xpad24_hbt_c 0.000368421f
Ctic2684 VSS__Xi_core_u_sense en_i 0.450105f
Ctic2685 VSS__Xi_core_u_sense en_i__Xpad12_en 0.000210526f
Ctic2686 VSS__Xi_core_u_sense fault_n_o 0.545211f
Ctic2687 VSS__Xi_core_u_sense fault_n_o__Xpad11_fault_n 0.00142105f
Ctic2688 VSS__Xi_core_u_sense gate_o 0.0797368f
Ctic2689 VSS__Xi_core_u_sense gate_o__Xpad10_gate 0.00147368f
Ctic2690 VSS__Xi_core_u_sense i_core_bgr_r4_12 0.0756842f
Ctic2691 VSS__Xi_core_u_sense i_core_bgr_r4_33 0.0912632f
Ctic2692 VSS__Xi_core_u_sense i_core_clr_d 0.008f
Ctic2693 VSS__Xi_core_u_sense i_core_cmp_clk 0.478f
Ctic2694 VSS__Xi_core_u_sense i_core_cmp_hard 0.309f
Ctic2695 VSS__Xi_core_u_sense i_core_cmp_soft__retained_fullchip_sg13g2_antennanp_1021_440_891_000 0.151105f
Ctic2696 VSS__Xi_core_u_sense i_core_dac_hard_0___Xi_core_u_trip 0.0316316f
Ctic2697 VSS__Xi_core_u_sense i_core_dac_hard_1___Xi_core_u_trip 0.0123158f
Ctic2698 VSS__Xi_core_u_sense i_core_dac_hard_2___Xi_core_u_trip 0.0278947f
Ctic2699 VSS__Xi_core_u_sense i_core_dac_hard_3_ 0.0884211f
Ctic2700 VSS__Xi_core_u_sense i_core_dac_hard_4_ 0.0341053f
Ctic2701 VSS__Xi_core_u_sense i_core_dac_hard_5_ 0.0503684f
Ctic2702 VSS__Xi_core_u_sense i_core_dac_hard_6_ 0.0545263f
Ctic2703 VSS__Xi_core_u_sense i_core_dac_hard_7_ 0.0821579f
Ctic2704 VSS__Xi_core_u_sense i_core_dac_soft_0___Xi_core_u_trip 0.00852632f
Ctic2705 VSS__Xi_core_u_sense i_core_dac_soft_1___Xi_core_u_trip 0.00157895f
Ctic2706 VSS__Xi_core_u_sense i_core_dac_soft_2___Xi_core_u_trip 0.0160526f
Ctic2707 VSS__Xi_core_u_sense i_core_dac_soft_3___Xi_core_u_trip 0.0125263f
Ctic2708 VSS__Xi_core_u_sense i_core_dac_soft_4___Xi_core_u_trip 0.0208421f
Ctic2709 VSS__Xi_core_u_sense i_core_dac_soft_5___Xi_core_u_trip 0.0106316f
Ctic2710 VSS__Xi_core_u_sense i_core_dac_soft_6___Xi_core_u_trip 0.0385263f
Ctic2711 VSS__Xi_core_u_sense i_core_dac_soft_7___Xi_core_u_trip 0.00605263f
Ctic2712 VSS__Xi_core_u_sense i_core_fast_en__Xi_core_u_gate 0.0104211f
Ctic2713 VSS__Xi_core_u_sense i_core_iptat__Xi_core_u_sense 0.244684f
Ctic2714 VSS__Xi_core_u_sense i_core_isense 0.146421f
Ctic2715 VSS__Xi_core_u_sense i_core_osc_clk__Xi_core_u_osc 0.0963158f
Ctic2716 VSS__Xi_core_u_sense i_core_osc_en 0.179316f
Ctic2717 VSS__Xi_core_u_sense i_core_osc_trim_0_ 0.0505789f
Ctic2718 VSS__Xi_core_u_sense i_core_osc_trim_1_ 0.0206842f
Ctic2719 VSS__Xi_core_u_sense i_core_osc_trim_2_ 0.114684f
Ctic2720 VSS__Xi_core_u_sense i_core_osc_trim_3_ 0.0323684f
Ctic2721 VSS__Xi_core_u_sense i_core_pbias 0.065f
Ctic2722 VSS__Xi_core_u_sense i_core_pcasc 0.0258421f
Ctic2723 VSS__Xi_core_u_sense i_core_sclk_i 0.447842f
Ctic2726 VSS__Xi_core_u_sense i_core_sdi_i__retained_fullchip_sg13g2_antennanp_1024_320_891_000 1.00005f
Ctic2727 VSS__Xi_core_u_sense i_core_sdo_o 0.106895f
Ctic2728 VSS__Xi_core_u_sense i_core_sdo_o__Xpad16_sdo 0.000789474f
Ctic2729 VSS__Xi_core_u_sense i_core_t2f_en_12 0.0402105f
Ctic2730 VSS__Xi_core_u_sense i_core_t2f_en_33 0.164632f
Ctic2731 VSS__Xi_core_u_sense i_core_t2f_mode_12 0.0211053f
Ctic2732 VSS__Xi_core_u_sense i_core_t2f_mode_33 0.312895f
Ctic2733 VSS__Xi_core_u_sense i_core_temp_out_o__Xpad17_temp_out 0.0509474f
Ctic2734 VSS__Xi_core_u_sense i_core_trip_d 0.00552632f
Ctic2735 VSS__Xi_core_u_sense i_core_trip_set__Xpad13_trip_set 0.000105263f
Ctic2736 VSS__Xi_core_u_sense i_core_tripped__Xi_core_u_gate 0.156526f
Ctic2737 VSS__Xi_core_u_sense i_core_vref__Xi_core_u_sense 0.0726842f
Ctic2738 VSS__Xi_core_u_sense i_core_vref__Xi_core_u_t2f 0.000947368f
Ctic2740 VSS__Xi_core_u_sense i_core_vref_buf 0.161211f
Ctic2741 VSS__Xi_core_u_sense net 0.352316f
Ctic2742 VSS__Xi_core_u_t2f _nc1__Xpad07_vdda 0.000421053f
Ctic2743 VSS__Xi_core_u_t2f _nc2__Xpad08_sense_p 0.000368421f
Ctic2744 VSS__Xi_core_u_t2f _nc3__Xpad09_sense_n 0.000421053f
Ctic2745 VSS__Xi_core_u_t2f _nc4__Xpad19_g_shared 0.000315789f
Ctic2746 VSS__Xi_core_u_t2f _nc5__Xpad20_d_std 0.000315789f
Ctic2747 VSS__Xi_core_u_t2f _nc6__Xpad21_d_elt 0.000315789f
Ctic2748 VSS__Xi_core_u_t2f _nc7__Xpad22_hbt_e 0.000315789f
Ctic2749 VSS__Xi_core_u_t2f _nc8__Xpad23_hbt_b 0.000368421f
Ctic2750 VSS__Xi_core_u_t2f _nc9__Xpad24_hbt_c 0.000368421f
Ctic2751 VSS__Xi_core_u_t2f en_i__Xpad12_en 0.000210526f
Ctic2752 VSS__Xi_core_u_t2f en_i__retained_fullchip_sg13g2_antennanp_1020_000_891_000 0.450105f
Ctic2753 VSS__Xi_core_u_t2f fault_n_o__Xpad11_fault_n 0.546632f
Ctic2754 VSS__Xi_core_u_t2f gate_o__Xpad10_gate 0.0812105f
Ctic2755 VSS__Xi_core_u_t2f i_core_bgr_r4_12 0.0756842f
Ctic2756 VSS__Xi_core_u_t2f i_core_bgr_r4_33 0.0912632f
Ctic2757 VSS__Xi_core_u_t2f i_core_clr_d 0.008f
Ctic2758 VSS__Xi_core_u_t2f i_core_cmp_clk__Xi_core_u_trip 0.478f
Ctic2759 VSS__Xi_core_u_t2f i_core_cmp_hard__Xi_core_u_trip 0.309f
Ctic2760 VSS__Xi_core_u_t2f i_core_cmp_soft__Xi_core_u_trip 0.151105f
Ctic2761 VSS__Xi_core_u_t2f i_core_dac_hard_0___Xi_core_u_trip 0.0316316f
Ctic2762 VSS__Xi_core_u_t2f i_core_dac_hard_1___Xi_core_u_trip 0.0123158f
Ctic2763 VSS__Xi_core_u_t2f i_core_dac_hard_2___Xi_core_u_trip 0.0278947f
Ctic2764 VSS__Xi_core_u_t2f i_core_dac_hard_3___Xi_core_u_trip 0.0884211f
Ctic2765 VSS__Xi_core_u_t2f i_core_dac_hard_4___Xi_core_u_trip 0.0341053f
Ctic2766 VSS__Xi_core_u_t2f i_core_dac_hard_5___Xi_core_u_trip 0.0503684f
Ctic2767 VSS__Xi_core_u_t2f i_core_dac_hard_6___Xi_core_u_trip 0.0545263f
Ctic2768 VSS__Xi_core_u_t2f i_core_dac_hard_7___Xi_core_u_trip 0.0821579f
Ctic2769 VSS__Xi_core_u_t2f i_core_dac_soft_0___Xi_core_u_trip 0.00852632f
Ctic2770 VSS__Xi_core_u_t2f i_core_dac_soft_1___Xi_core_u_trip 0.00157895f
Ctic2771 VSS__Xi_core_u_t2f i_core_dac_soft_2___Xi_core_u_trip 0.0160526f
Ctic2772 VSS__Xi_core_u_t2f i_core_dac_soft_3___Xi_core_u_trip 0.0125263f
Ctic2773 VSS__Xi_core_u_t2f i_core_dac_soft_4___Xi_core_u_trip 0.0208421f
Ctic2774 VSS__Xi_core_u_t2f i_core_dac_soft_5___Xi_core_u_trip 0.0106316f
Ctic2775 VSS__Xi_core_u_t2f i_core_dac_soft_6___Xi_core_u_trip 0.0385263f
Ctic2776 VSS__Xi_core_u_t2f i_core_dac_soft_7___Xi_core_u_trip 0.00605263f
Ctic2777 VSS__Xi_core_u_t2f i_core_fast_en__Xi_core_u_gate 0.0104211f
Ctic2778 VSS__Xi_core_u_t2f i_core_iptat 0.244684f
Ctic2779 VSS__Xi_core_u_t2f i_core_isense__Xi_core_u_trip 0.146421f
Ctic2780 VSS__Xi_core_u_t2f i_core_osc_clk__Xi_core_u_osc 0.0963158f
Ctic2781 VSS__Xi_core_u_t2f i_core_osc_en__Xi_core_u_osc 0.179316f
Ctic2782 VSS__Xi_core_u_t2f i_core_osc_trim_0___Xi_core_u_osc 0.0505789f
Ctic2783 VSS__Xi_core_u_t2f i_core_osc_trim_1___Xi_core_u_osc 0.0206842f
Ctic2784 VSS__Xi_core_u_t2f i_core_osc_trim_2___Xi_core_u_osc 0.114684f
Ctic2785 VSS__Xi_core_u_t2f i_core_osc_trim_3___Xi_core_u_osc 0.0323684f
Ctic2786 VSS__Xi_core_u_t2f i_core_pbias__Xi_core_u_t2f 0.065f
Ctic2787 VSS__Xi_core_u_t2f i_core_pcasc__Xi_core_u_t2f 0.0258421f
Ctic2788 VSS__Xi_core_u_t2f i_core_sclk_i 0.447842f
Ctic2791 VSS__Xi_core_u_t2f i_core_sdi_i__retained_fullchip_sg13g2_antennanp_1024_320_891_000 1.00005f
Ctic2792 VSS__Xi_core_u_t2f i_core_sdo_o__Xpad16_sdo 0.107684f
Ctic2793 VSS__Xi_core_u_t2f i_core_t2f_en_12 0.0402105f
Ctic2794 VSS__Xi_core_u_t2f i_core_t2f_en_33__Xi_core_u_t2f 0.164632f
Ctic2795 VSS__Xi_core_u_t2f i_core_t2f_mode_12 0.0211053f
Ctic2796 VSS__Xi_core_u_t2f i_core_t2f_mode_33__Xi_core_u_t2f 0.312895f
Ctic2797 VSS__Xi_core_u_t2f i_core_temp_out_o 0.0501053f
Ctic2798 VSS__Xi_core_u_t2f i_core_temp_out_o__Xpad17_temp_out 0.000842105f
Ctic2799 VSS__Xi_core_u_t2f i_core_trip_d 0.00552632f
Ctic2800 VSS__Xi_core_u_t2f i_core_trip_set__Xpad13_trip_set 0.000105263f
Ctic2801 VSS__Xi_core_u_t2f i_core_tripped__retained_fullchip_sg13g2_antennanp_1027_200_891_000 0.156526f
Ctic2802 VSS__Xi_core_u_t2f i_core_vref__Xi_core_u_t2f 0.000947368f
Ctic2803 VSS__Xi_core_u_t2f i_core_vref__Xpad18_vref 0.0726842f
Ctic2804 VSS__Xi_core_u_t2f i_core_vref_buf__Xi_core_u_trip 0.161211f
Ctic2805 VSS__Xi_core_u_t2f net__Xi_core_u_digital_1 0.352316f
Ctic2806 VSS__Xi_core_u_trip _nc1__Xpad07_vdda 0.000421053f
Ctic2807 VSS__Xi_core_u_trip _nc2__Xpad08_sense_p 0.000368421f
Ctic2808 VSS__Xi_core_u_trip _nc3__Xpad09_sense_n 0.000421053f
Ctic2809 VSS__Xi_core_u_trip _nc4__Xpad19_g_shared 0.000315789f
Ctic2810 VSS__Xi_core_u_trip _nc5__Xpad20_d_std 0.000315789f
Ctic2811 VSS__Xi_core_u_trip _nc6__Xpad21_d_elt 0.000315789f
Ctic2812 VSS__Xi_core_u_trip _nc7__Xpad22_hbt_e 0.000315789f
Ctic2813 VSS__Xi_core_u_trip _nc8__Xpad23_hbt_b 0.000368421f
Ctic2814 VSS__Xi_core_u_trip _nc9__Xpad24_hbt_c 0.000368421f
Ctic2815 VSS__Xi_core_u_trip en_i__Xpad12_en 0.000210526f
Ctic2816 VSS__Xi_core_u_trip en_i__retained_fullchip_sg13g2_antennanp_1020_000_891_000 0.450105f
Ctic2817 VSS__Xi_core_u_trip fault_n_o 0.545211f
Ctic2818 VSS__Xi_core_u_trip fault_n_o__Xpad11_fault_n 0.00142105f
Ctic2819 VSS__Xi_core_u_trip gate_o 0.0797368f
Ctic2820 VSS__Xi_core_u_trip gate_o__Xpad10_gate 0.00147368f
Ctic2821 VSS__Xi_core_u_trip i_core_bgr_r4_12 0.0756842f
Ctic2822 VSS__Xi_core_u_trip i_core_bgr_r4_33 0.0912632f
Ctic2823 VSS__Xi_core_u_trip i_core_clr_d 0.008f
Ctic2824 VSS__Xi_core_u_trip i_core_cmp_clk__Xi_core_u_trip 0.478f
Ctic2825 VSS__Xi_core_u_trip i_core_cmp_hard__Xi_core_u_trip 0.309f
Ctic2826 VSS__Xi_core_u_trip i_core_cmp_soft__retained_fullchip_sg13g2_antennanp_1021_440_891_000 0.151105f
Ctic2827 VSS__Xi_core_u_trip i_core_dac_hard_0___Xi_core_u_trip 0.0316316f
Ctic2828 VSS__Xi_core_u_trip i_core_dac_hard_1___Xi_core_u_trip 0.0123158f
Ctic2829 VSS__Xi_core_u_trip i_core_dac_hard_2___Xi_core_u_trip 0.0278947f
Ctic2830 VSS__Xi_core_u_trip i_core_dac_hard_3___Xi_core_u_trip 0.0884211f
Ctic2831 VSS__Xi_core_u_trip i_core_dac_hard_4___Xi_core_u_trip 0.0341053f
Ctic2832 VSS__Xi_core_u_trip i_core_dac_hard_5___Xi_core_u_trip 0.0503684f
Ctic2833 VSS__Xi_core_u_trip i_core_dac_hard_6___Xi_core_u_trip 0.0545263f
Ctic2834 VSS__Xi_core_u_trip i_core_dac_hard_7___Xi_core_u_trip 0.0821579f
Ctic2835 VSS__Xi_core_u_trip i_core_dac_soft_0___Xi_core_u_trip 0.00852632f
Ctic2836 VSS__Xi_core_u_trip i_core_dac_soft_1___Xi_core_u_trip 0.00157895f
Ctic2837 VSS__Xi_core_u_trip i_core_dac_soft_2___Xi_core_u_trip 0.0160526f
Ctic2838 VSS__Xi_core_u_trip i_core_dac_soft_3___Xi_core_u_trip 0.0125263f
Ctic2839 VSS__Xi_core_u_trip i_core_dac_soft_4___Xi_core_u_trip 0.0208421f
Ctic2840 VSS__Xi_core_u_trip i_core_dac_soft_5___Xi_core_u_trip 0.0106316f
Ctic2841 VSS__Xi_core_u_trip i_core_dac_soft_6___Xi_core_u_trip 0.0385263f
Ctic2842 VSS__Xi_core_u_trip i_core_dac_soft_7___Xi_core_u_trip 0.00605263f
Ctic2843 VSS__Xi_core_u_trip i_core_fast_en__Xi_core_u_gate 0.0104211f
Ctic2844 VSS__Xi_core_u_trip i_core_iptat__Xi_core_u_sense 0.244684f
Ctic2845 VSS__Xi_core_u_trip i_core_isense 0.146421f
Ctic2846 VSS__Xi_core_u_trip i_core_osc_clk__Xi_core_u_osc 0.0963158f
Ctic2847 VSS__Xi_core_u_trip i_core_osc_en 0.179316f
Ctic2848 VSS__Xi_core_u_trip i_core_osc_trim_0_ 0.0505789f
Ctic2849 VSS__Xi_core_u_trip i_core_osc_trim_1_ 0.0206842f
Ctic2850 VSS__Xi_core_u_trip i_core_osc_trim_2_ 0.114684f
Ctic2851 VSS__Xi_core_u_trip i_core_osc_trim_3_ 0.0323684f
Ctic2852 VSS__Xi_core_u_trip i_core_pbias 0.065f
Ctic2853 VSS__Xi_core_u_trip i_core_pcasc 0.0258421f
Ctic2854 VSS__Xi_core_u_trip i_core_sclk_i 0.447842f
Ctic2857 VSS__Xi_core_u_trip i_core_sdi_i__retained_fullchip_sg13g2_antennanp_1024_320_891_000 1.00005f
Ctic2858 VSS__Xi_core_u_trip i_core_sdo_o 0.106895f
Ctic2859 VSS__Xi_core_u_trip i_core_sdo_o__Xpad16_sdo 0.000789474f
Ctic2860 VSS__Xi_core_u_trip i_core_t2f_en_12 0.0402105f
Ctic2861 VSS__Xi_core_u_trip i_core_t2f_en_33 0.164632f
Ctic2862 VSS__Xi_core_u_trip i_core_t2f_mode_12 0.0211053f
Ctic2863 VSS__Xi_core_u_trip i_core_t2f_mode_33 0.312895f
Ctic2864 VSS__Xi_core_u_trip i_core_temp_out_o 0.0501053f
Ctic2865 VSS__Xi_core_u_trip i_core_temp_out_o__Xpad17_temp_out 0.000842105f
Ctic2866 VSS__Xi_core_u_trip i_core_trip_d 0.00552632f
Ctic2867 VSS__Xi_core_u_trip i_core_trip_set__Xpad13_trip_set 0.000105263f
Ctic2868 VSS__Xi_core_u_trip i_core_tripped__Xi_core_u_gate 0.156526f
Ctic2869 VSS__Xi_core_u_trip i_core_vref__Xi_core_u_sense 0.0726842f
Ctic2870 VSS__Xi_core_u_trip i_core_vref__Xi_core_u_t2f 0.000947368f
Ctic2872 VSS__Xi_core_u_trip i_core_vref_buf 0.161211f
Ctic2873 VSS__Xi_core_u_trip net 0.352316f
Ctic2874 VSS__retained_fullchip_sg13g2_antennanp_1020_000_891_000 _nc1__Xpad07_vdda 0.000421053f
Ctic2875 VSS__retained_fullchip_sg13g2_antennanp_1020_000_891_000 _nc2__Xpad08_sense_p 0.000368421f
Ctic2876 VSS__retained_fullchip_sg13g2_antennanp_1020_000_891_000 _nc3__Xpad09_sense_n 0.000421053f
Ctic2877 VSS__retained_fullchip_sg13g2_antennanp_1020_000_891_000 _nc4__Xpad19_g_shared 0.000315789f
Ctic2878 VSS__retained_fullchip_sg13g2_antennanp_1020_000_891_000 _nc5__Xpad20_d_std 0.000315789f
Ctic2879 VSS__retained_fullchip_sg13g2_antennanp_1020_000_891_000 _nc6__Xpad21_d_elt 0.000315789f
Ctic2880 VSS__retained_fullchip_sg13g2_antennanp_1020_000_891_000 _nc7__Xpad22_hbt_e 0.000315789f
Ctic2881 VSS__retained_fullchip_sg13g2_antennanp_1020_000_891_000 _nc8__Xpad23_hbt_b 0.000368421f
Ctic2882 VSS__retained_fullchip_sg13g2_antennanp_1020_000_891_000 _nc9__Xpad24_hbt_c 0.000368421f
Ctic2883 VSS__retained_fullchip_sg13g2_antennanp_1020_000_891_000 en_i__Xpad12_en 0.000210526f
Ctic2884 VSS__retained_fullchip_sg13g2_antennanp_1020_000_891_000 en_i__retained_fullchip_sg13g2_antennanp_1020_000_891_000 0.450105f
Ctic2885 VSS__retained_fullchip_sg13g2_antennanp_1020_000_891_000 fault_n_o__Xpad11_fault_n 0.546632f
Ctic2886 VSS__retained_fullchip_sg13g2_antennanp_1020_000_891_000 gate_o__Xpad10_gate 0.0812105f
Ctic2887 VSS__retained_fullchip_sg13g2_antennanp_1020_000_891_000 i_core_bgr_r4_12 0.0756842f
Ctic2888 VSS__retained_fullchip_sg13g2_antennanp_1020_000_891_000 i_core_bgr_r4_33 0.0912632f
Ctic2889 VSS__retained_fullchip_sg13g2_antennanp_1020_000_891_000 i_core_clr_d 0.008f
Ctic2890 VSS__retained_fullchip_sg13g2_antennanp_1020_000_891_000 i_core_cmp_clk__Xi_core_u_trip 0.478f
Ctic2891 VSS__retained_fullchip_sg13g2_antennanp_1020_000_891_000 i_core_cmp_hard__Xi_core_u_trip 0.309f
Ctic2892 VSS__retained_fullchip_sg13g2_antennanp_1020_000_891_000 i_core_cmp_soft__retained_fullchip_sg13g2_antennanp_1021_440_891_000 0.151105f
Ctic2893 VSS__retained_fullchip_sg13g2_antennanp_1020_000_891_000 i_core_dac_hard_0___Xi_core_u_trip 0.0316316f
Ctic2894 VSS__retained_fullchip_sg13g2_antennanp_1020_000_891_000 i_core_dac_hard_1___Xi_core_u_trip 0.0123158f
Ctic2895 VSS__retained_fullchip_sg13g2_antennanp_1020_000_891_000 i_core_dac_hard_2___Xi_core_u_trip 0.0278947f
Ctic2896 VSS__retained_fullchip_sg13g2_antennanp_1020_000_891_000 i_core_dac_hard_3___Xi_core_u_trip 0.0884211f
Ctic2897 VSS__retained_fullchip_sg13g2_antennanp_1020_000_891_000 i_core_dac_hard_4___Xi_core_u_trip 0.0341053f
Ctic2898 VSS__retained_fullchip_sg13g2_antennanp_1020_000_891_000 i_core_dac_hard_5___Xi_core_u_trip 0.0503684f
Ctic2899 VSS__retained_fullchip_sg13g2_antennanp_1020_000_891_000 i_core_dac_hard_6___Xi_core_u_trip 0.0545263f
Ctic2900 VSS__retained_fullchip_sg13g2_antennanp_1020_000_891_000 i_core_dac_hard_7___Xi_core_u_trip 0.0821579f
Ctic2901 VSS__retained_fullchip_sg13g2_antennanp_1020_000_891_000 i_core_dac_soft_0___Xi_core_u_trip 0.00852632f
Ctic2902 VSS__retained_fullchip_sg13g2_antennanp_1020_000_891_000 i_core_dac_soft_1___Xi_core_u_trip 0.00157895f
Ctic2903 VSS__retained_fullchip_sg13g2_antennanp_1020_000_891_000 i_core_dac_soft_2___Xi_core_u_trip 0.0160526f
Ctic2904 VSS__retained_fullchip_sg13g2_antennanp_1020_000_891_000 i_core_dac_soft_3___Xi_core_u_trip 0.0125263f
Ctic2905 VSS__retained_fullchip_sg13g2_antennanp_1020_000_891_000 i_core_dac_soft_4___Xi_core_u_trip 0.0208421f
Ctic2906 VSS__retained_fullchip_sg13g2_antennanp_1020_000_891_000 i_core_dac_soft_5___Xi_core_u_trip 0.0106316f
Ctic2907 VSS__retained_fullchip_sg13g2_antennanp_1020_000_891_000 i_core_dac_soft_6___Xi_core_u_trip 0.0385263f
Ctic2908 VSS__retained_fullchip_sg13g2_antennanp_1020_000_891_000 i_core_dac_soft_7___Xi_core_u_trip 0.00605263f
Ctic2909 VSS__retained_fullchip_sg13g2_antennanp_1020_000_891_000 i_core_fast_en__Xi_core_u_gate 0.0104211f
Ctic2910 VSS__retained_fullchip_sg13g2_antennanp_1020_000_891_000 i_core_iptat__Xi_core_u_sense 0.244684f
Ctic2911 VSS__retained_fullchip_sg13g2_antennanp_1020_000_891_000 i_core_isense 0.146421f
Ctic2912 VSS__retained_fullchip_sg13g2_antennanp_1020_000_891_000 i_core_osc_clk__Xi_core_u_osc 0.0963158f
Ctic2913 VSS__retained_fullchip_sg13g2_antennanp_1020_000_891_000 i_core_osc_en__Xi_core_u_osc 0.179316f
Ctic2914 VSS__retained_fullchip_sg13g2_antennanp_1020_000_891_000 i_core_osc_trim_0___Xi_core_u_osc 0.0505789f
Ctic2915 VSS__retained_fullchip_sg13g2_antennanp_1020_000_891_000 i_core_osc_trim_1___Xi_core_u_osc 0.0206842f
Ctic2916 VSS__retained_fullchip_sg13g2_antennanp_1020_000_891_000 i_core_osc_trim_2___Xi_core_u_osc 0.114684f
Ctic2917 VSS__retained_fullchip_sg13g2_antennanp_1020_000_891_000 i_core_osc_trim_3___Xi_core_u_osc 0.0323684f
Ctic2918 VSS__retained_fullchip_sg13g2_antennanp_1020_000_891_000 i_core_pbias__Xi_core_u_t2f 0.065f
Ctic2919 VSS__retained_fullchip_sg13g2_antennanp_1020_000_891_000 i_core_pcasc__Xi_core_u_t2f 0.0258421f
Ctic2920 VSS__retained_fullchip_sg13g2_antennanp_1020_000_891_000 i_core_sclk_i 0.447842f
Ctic2923 VSS__retained_fullchip_sg13g2_antennanp_1020_000_891_000 i_core_sdi_i__retained_fullchip_sg13g2_antennanp_1024_320_891_000 1.00005f
Ctic2924 VSS__retained_fullchip_sg13g2_antennanp_1020_000_891_000 i_core_sdo_o__Xpad16_sdo 0.107684f
Ctic2925 VSS__retained_fullchip_sg13g2_antennanp_1020_000_891_000 i_core_t2f_en_12 0.0402105f
Ctic2926 VSS__retained_fullchip_sg13g2_antennanp_1020_000_891_000 i_core_t2f_en_33__Xi_core_u_t2f 0.164632f
Ctic2927 VSS__retained_fullchip_sg13g2_antennanp_1020_000_891_000 i_core_t2f_mode_12 0.0211053f
Ctic2928 VSS__retained_fullchip_sg13g2_antennanp_1020_000_891_000 i_core_t2f_mode_33__Xi_core_u_t2f 0.312895f
Ctic2929 VSS__retained_fullchip_sg13g2_antennanp_1020_000_891_000 i_core_temp_out_o 0.0501053f
Ctic2930 VSS__retained_fullchip_sg13g2_antennanp_1020_000_891_000 i_core_temp_out_o__Xpad17_temp_out 0.000842105f
Ctic2931 VSS__retained_fullchip_sg13g2_antennanp_1020_000_891_000 i_core_trip_d 0.00552632f
Ctic2932 VSS__retained_fullchip_sg13g2_antennanp_1020_000_891_000 i_core_trip_set__Xpad13_trip_set 0.000105263f
Ctic2933 VSS__retained_fullchip_sg13g2_antennanp_1020_000_891_000 i_core_tripped__retained_fullchip_sg13g2_antennanp_1027_200_891_000 0.156526f
Ctic2934 VSS__retained_fullchip_sg13g2_antennanp_1020_000_891_000 i_core_vref__Xi_core_u_t2f 0.000947368f
Ctic2935 VSS__retained_fullchip_sg13g2_antennanp_1020_000_891_000 i_core_vref__Xpad18_vref 0.0726842f
Ctic2936 VSS__retained_fullchip_sg13g2_antennanp_1020_000_891_000 i_core_vref_buf 0.161211f
Ctic2937 VSS__retained_fullchip_sg13g2_antennanp_1020_000_891_000 net__Xi_core_u_digital_1 0.352316f
Ctic2938 VSS__retained_fullchip_sg13g2_antennanp_1021_440_891_000 _nc1__Xpad07_vdda 0.000421053f
Ctic2939 VSS__retained_fullchip_sg13g2_antennanp_1021_440_891_000 _nc2__Xpad08_sense_p 0.000368421f
Ctic2940 VSS__retained_fullchip_sg13g2_antennanp_1021_440_891_000 _nc3__Xpad09_sense_n 0.000421053f
Ctic2941 VSS__retained_fullchip_sg13g2_antennanp_1021_440_891_000 _nc4__Xpad19_g_shared 0.000315789f
Ctic2942 VSS__retained_fullchip_sg13g2_antennanp_1021_440_891_000 _nc5__Xpad20_d_std 0.000315789f
Ctic2943 VSS__retained_fullchip_sg13g2_antennanp_1021_440_891_000 _nc6__Xpad21_d_elt 0.000315789f
Ctic2944 VSS__retained_fullchip_sg13g2_antennanp_1021_440_891_000 _nc7__Xpad22_hbt_e 0.000315789f
Ctic2945 VSS__retained_fullchip_sg13g2_antennanp_1021_440_891_000 _nc8__Xpad23_hbt_b 0.000368421f
Ctic2946 VSS__retained_fullchip_sg13g2_antennanp_1021_440_891_000 _nc9__Xpad24_hbt_c 0.000368421f
Ctic2947 VSS__retained_fullchip_sg13g2_antennanp_1021_440_891_000 en_i__Xpad12_en 0.000210526f
Ctic2948 VSS__retained_fullchip_sg13g2_antennanp_1021_440_891_000 en_i__retained_fullchip_sg13g2_antennanp_1020_000_891_000 0.450105f
Ctic2949 VSS__retained_fullchip_sg13g2_antennanp_1021_440_891_000 fault_n_o__Xpad11_fault_n 0.546632f
Ctic2950 VSS__retained_fullchip_sg13g2_antennanp_1021_440_891_000 gate_o__Xpad10_gate 0.0812105f
Ctic2951 VSS__retained_fullchip_sg13g2_antennanp_1021_440_891_000 i_core_bgr_r4_12 0.0756842f
Ctic2952 VSS__retained_fullchip_sg13g2_antennanp_1021_440_891_000 i_core_bgr_r4_33 0.0912632f
Ctic2953 VSS__retained_fullchip_sg13g2_antennanp_1021_440_891_000 i_core_clr_d 0.008f
Ctic2954 VSS__retained_fullchip_sg13g2_antennanp_1021_440_891_000 i_core_cmp_clk__Xi_core_u_trip 0.478f
Ctic2955 VSS__retained_fullchip_sg13g2_antennanp_1021_440_891_000 i_core_cmp_hard__Xi_core_u_trip 0.309f
Ctic2956 VSS__retained_fullchip_sg13g2_antennanp_1021_440_891_000 i_core_cmp_soft__retained_fullchip_sg13g2_antennanp_1021_440_891_000 0.151105f
Ctic2957 VSS__retained_fullchip_sg13g2_antennanp_1021_440_891_000 i_core_dac_hard_0___Xi_core_u_trip 0.0316316f
Ctic2958 VSS__retained_fullchip_sg13g2_antennanp_1021_440_891_000 i_core_dac_hard_1___Xi_core_u_trip 0.0123158f
Ctic2959 VSS__retained_fullchip_sg13g2_antennanp_1021_440_891_000 i_core_dac_hard_2___Xi_core_u_trip 0.0278947f
Ctic2960 VSS__retained_fullchip_sg13g2_antennanp_1021_440_891_000 i_core_dac_hard_3___Xi_core_u_trip 0.0884211f
Ctic2961 VSS__retained_fullchip_sg13g2_antennanp_1021_440_891_000 i_core_dac_hard_4___Xi_core_u_trip 0.0341053f
Ctic2962 VSS__retained_fullchip_sg13g2_antennanp_1021_440_891_000 i_core_dac_hard_5___Xi_core_u_trip 0.0503684f
Ctic2963 VSS__retained_fullchip_sg13g2_antennanp_1021_440_891_000 i_core_dac_hard_6___Xi_core_u_trip 0.0545263f
Ctic2964 VSS__retained_fullchip_sg13g2_antennanp_1021_440_891_000 i_core_dac_hard_7___Xi_core_u_trip 0.0821579f
Ctic2965 VSS__retained_fullchip_sg13g2_antennanp_1021_440_891_000 i_core_dac_soft_0___Xi_core_u_trip 0.00852632f
Ctic2966 VSS__retained_fullchip_sg13g2_antennanp_1021_440_891_000 i_core_dac_soft_1___Xi_core_u_trip 0.00157895f
Ctic2967 VSS__retained_fullchip_sg13g2_antennanp_1021_440_891_000 i_core_dac_soft_2___Xi_core_u_trip 0.0160526f
Ctic2968 VSS__retained_fullchip_sg13g2_antennanp_1021_440_891_000 i_core_dac_soft_3___Xi_core_u_trip 0.0125263f
Ctic2969 VSS__retained_fullchip_sg13g2_antennanp_1021_440_891_000 i_core_dac_soft_4___Xi_core_u_trip 0.0208421f
Ctic2970 VSS__retained_fullchip_sg13g2_antennanp_1021_440_891_000 i_core_dac_soft_5___Xi_core_u_trip 0.0106316f
Ctic2971 VSS__retained_fullchip_sg13g2_antennanp_1021_440_891_000 i_core_dac_soft_6___Xi_core_u_trip 0.0385263f
Ctic2972 VSS__retained_fullchip_sg13g2_antennanp_1021_440_891_000 i_core_dac_soft_7___Xi_core_u_trip 0.00605263f
Ctic2973 VSS__retained_fullchip_sg13g2_antennanp_1021_440_891_000 i_core_fast_en__Xi_core_u_gate 0.0104211f
Ctic2974 VSS__retained_fullchip_sg13g2_antennanp_1021_440_891_000 i_core_iptat__Xi_core_u_sense 0.244684f
Ctic2975 VSS__retained_fullchip_sg13g2_antennanp_1021_440_891_000 i_core_isense 0.146421f
Ctic2976 VSS__retained_fullchip_sg13g2_antennanp_1021_440_891_000 i_core_osc_clk__Xi_core_u_osc 0.0963158f
Ctic2977 VSS__retained_fullchip_sg13g2_antennanp_1021_440_891_000 i_core_osc_en__Xi_core_u_osc 0.179316f
Ctic2978 VSS__retained_fullchip_sg13g2_antennanp_1021_440_891_000 i_core_osc_trim_0___Xi_core_u_osc 0.0505789f
Ctic2979 VSS__retained_fullchip_sg13g2_antennanp_1021_440_891_000 i_core_osc_trim_1___Xi_core_u_osc 0.0206842f
Ctic2980 VSS__retained_fullchip_sg13g2_antennanp_1021_440_891_000 i_core_osc_trim_2___Xi_core_u_osc 0.114684f
Ctic2981 VSS__retained_fullchip_sg13g2_antennanp_1021_440_891_000 i_core_osc_trim_3___Xi_core_u_osc 0.0323684f
Ctic2982 VSS__retained_fullchip_sg13g2_antennanp_1021_440_891_000 i_core_pbias__Xi_core_u_t2f 0.065f
Ctic2983 VSS__retained_fullchip_sg13g2_antennanp_1021_440_891_000 i_core_pcasc__Xi_core_u_t2f 0.0258421f
Ctic2984 VSS__retained_fullchip_sg13g2_antennanp_1021_440_891_000 i_core_sclk_i 0.447842f
Ctic2987 VSS__retained_fullchip_sg13g2_antennanp_1021_440_891_000 i_core_sdi_i__retained_fullchip_sg13g2_antennanp_1024_320_891_000 1.00005f
Ctic2988 VSS__retained_fullchip_sg13g2_antennanp_1021_440_891_000 i_core_sdo_o__Xpad16_sdo 0.107684f
Ctic2989 VSS__retained_fullchip_sg13g2_antennanp_1021_440_891_000 i_core_t2f_en_12 0.0402105f
Ctic2990 VSS__retained_fullchip_sg13g2_antennanp_1021_440_891_000 i_core_t2f_en_33__Xi_core_u_t2f 0.164632f
Ctic2991 VSS__retained_fullchip_sg13g2_antennanp_1021_440_891_000 i_core_t2f_mode_12 0.0211053f
Ctic2992 VSS__retained_fullchip_sg13g2_antennanp_1021_440_891_000 i_core_t2f_mode_33__Xi_core_u_t2f 0.312895f
Ctic2993 VSS__retained_fullchip_sg13g2_antennanp_1021_440_891_000 i_core_temp_out_o 0.0501053f
Ctic2994 VSS__retained_fullchip_sg13g2_antennanp_1021_440_891_000 i_core_temp_out_o__Xpad17_temp_out 0.000842105f
Ctic2995 VSS__retained_fullchip_sg13g2_antennanp_1021_440_891_000 i_core_trip_d 0.00552632f
Ctic2996 VSS__retained_fullchip_sg13g2_antennanp_1021_440_891_000 i_core_trip_set__Xpad13_trip_set 0.000105263f
Ctic2997 VSS__retained_fullchip_sg13g2_antennanp_1021_440_891_000 i_core_tripped__retained_fullchip_sg13g2_antennanp_1027_200_891_000 0.156526f
Ctic2998 VSS__retained_fullchip_sg13g2_antennanp_1021_440_891_000 i_core_vref__Xi_core_u_t2f 0.000947368f
Ctic2999 VSS__retained_fullchip_sg13g2_antennanp_1021_440_891_000 i_core_vref__Xpad18_vref 0.0726842f
Ctic3000 VSS__retained_fullchip_sg13g2_antennanp_1021_440_891_000 i_core_vref_buf 0.161211f
Ctic3001 VSS__retained_fullchip_sg13g2_antennanp_1021_440_891_000 net__Xi_core_u_digital_1 0.352316f
Ctic3002 VSS__retained_fullchip_sg13g2_antennanp_1022_880_891_000 _nc1__Xpad07_vdda 0.000421053f
Ctic3003 VSS__retained_fullchip_sg13g2_antennanp_1022_880_891_000 _nc2__Xpad08_sense_p 0.000368421f
Ctic3004 VSS__retained_fullchip_sg13g2_antennanp_1022_880_891_000 _nc3__Xpad09_sense_n 0.000421053f
Ctic3005 VSS__retained_fullchip_sg13g2_antennanp_1022_880_891_000 _nc4__Xpad19_g_shared 0.000315789f
Ctic3006 VSS__retained_fullchip_sg13g2_antennanp_1022_880_891_000 _nc5__Xpad20_d_std 0.000315789f
Ctic3007 VSS__retained_fullchip_sg13g2_antennanp_1022_880_891_000 _nc6__Xpad21_d_elt 0.000315789f
Ctic3008 VSS__retained_fullchip_sg13g2_antennanp_1022_880_891_000 _nc7__Xpad22_hbt_e 0.000315789f
Ctic3009 VSS__retained_fullchip_sg13g2_antennanp_1022_880_891_000 _nc8__Xpad23_hbt_b 0.000368421f
Ctic3010 VSS__retained_fullchip_sg13g2_antennanp_1022_880_891_000 _nc9__Xpad24_hbt_c 0.000368421f
Ctic3011 VSS__retained_fullchip_sg13g2_antennanp_1022_880_891_000 en_i__Xpad12_en 0.000210526f
Ctic3012 VSS__retained_fullchip_sg13g2_antennanp_1022_880_891_000 en_i__retained_fullchip_sg13g2_antennanp_1020_000_891_000 0.450105f
Ctic3013 VSS__retained_fullchip_sg13g2_antennanp_1022_880_891_000 fault_n_o__Xpad11_fault_n 0.546632f
Ctic3014 VSS__retained_fullchip_sg13g2_antennanp_1022_880_891_000 gate_o__Xpad10_gate 0.0812105f
Ctic3015 VSS__retained_fullchip_sg13g2_antennanp_1022_880_891_000 i_core_bgr_r4_12 0.0756842f
Ctic3016 VSS__retained_fullchip_sg13g2_antennanp_1022_880_891_000 i_core_bgr_r4_33 0.0912632f
Ctic3017 VSS__retained_fullchip_sg13g2_antennanp_1022_880_891_000 i_core_clr_d 0.008f
Ctic3018 VSS__retained_fullchip_sg13g2_antennanp_1022_880_891_000 i_core_cmp_clk__Xi_core_u_trip 0.478f
Ctic3019 VSS__retained_fullchip_sg13g2_antennanp_1022_880_891_000 i_core_cmp_hard__Xi_core_u_trip 0.309f
Ctic3020 VSS__retained_fullchip_sg13g2_antennanp_1022_880_891_000 i_core_cmp_soft__retained_fullchip_sg13g2_antennanp_1022_880_891_000 0.151105f
Ctic3021 VSS__retained_fullchip_sg13g2_antennanp_1022_880_891_000 i_core_dac_hard_0___Xi_core_u_trip 0.0316316f
Ctic3022 VSS__retained_fullchip_sg13g2_antennanp_1022_880_891_000 i_core_dac_hard_1___Xi_core_u_trip 0.0123158f
Ctic3023 VSS__retained_fullchip_sg13g2_antennanp_1022_880_891_000 i_core_dac_hard_2___Xi_core_u_trip 0.0278947f
Ctic3024 VSS__retained_fullchip_sg13g2_antennanp_1022_880_891_000 i_core_dac_hard_3___Xi_core_u_trip 0.0884211f
Ctic3025 VSS__retained_fullchip_sg13g2_antennanp_1022_880_891_000 i_core_dac_hard_4___Xi_core_u_trip 0.0341053f
Ctic3026 VSS__retained_fullchip_sg13g2_antennanp_1022_880_891_000 i_core_dac_hard_5___Xi_core_u_trip 0.0503684f
Ctic3027 VSS__retained_fullchip_sg13g2_antennanp_1022_880_891_000 i_core_dac_hard_6___Xi_core_u_trip 0.0545263f
Ctic3028 VSS__retained_fullchip_sg13g2_antennanp_1022_880_891_000 i_core_dac_hard_7___Xi_core_u_trip 0.0821579f
Ctic3029 VSS__retained_fullchip_sg13g2_antennanp_1022_880_891_000 i_core_dac_soft_0___Xi_core_u_trip 0.00852632f
Ctic3030 VSS__retained_fullchip_sg13g2_antennanp_1022_880_891_000 i_core_dac_soft_1___Xi_core_u_trip 0.00157895f
Ctic3031 VSS__retained_fullchip_sg13g2_antennanp_1022_880_891_000 i_core_dac_soft_2___Xi_core_u_trip 0.0160526f
Ctic3032 VSS__retained_fullchip_sg13g2_antennanp_1022_880_891_000 i_core_dac_soft_3___Xi_core_u_trip 0.0125263f
Ctic3033 VSS__retained_fullchip_sg13g2_antennanp_1022_880_891_000 i_core_dac_soft_4___Xi_core_u_trip 0.0208421f
Ctic3034 VSS__retained_fullchip_sg13g2_antennanp_1022_880_891_000 i_core_dac_soft_5___Xi_core_u_trip 0.0106316f
Ctic3035 VSS__retained_fullchip_sg13g2_antennanp_1022_880_891_000 i_core_dac_soft_6___Xi_core_u_trip 0.0385263f
Ctic3036 VSS__retained_fullchip_sg13g2_antennanp_1022_880_891_000 i_core_dac_soft_7___Xi_core_u_trip 0.00605263f
Ctic3037 VSS__retained_fullchip_sg13g2_antennanp_1022_880_891_000 i_core_fast_en__Xi_core_u_gate 0.0104211f
Ctic3038 VSS__retained_fullchip_sg13g2_antennanp_1022_880_891_000 i_core_iptat__Xi_core_u_sense 0.244684f
Ctic3039 VSS__retained_fullchip_sg13g2_antennanp_1022_880_891_000 i_core_isense 0.146421f
Ctic3040 VSS__retained_fullchip_sg13g2_antennanp_1022_880_891_000 i_core_osc_clk__Xi_core_u_osc 0.0963158f
Ctic3041 VSS__retained_fullchip_sg13g2_antennanp_1022_880_891_000 i_core_osc_en__Xi_core_u_osc 0.179316f
Ctic3042 VSS__retained_fullchip_sg13g2_antennanp_1022_880_891_000 i_core_osc_trim_0___Xi_core_u_osc 0.0505789f
Ctic3043 VSS__retained_fullchip_sg13g2_antennanp_1022_880_891_000 i_core_osc_trim_1___Xi_core_u_osc 0.0206842f
Ctic3044 VSS__retained_fullchip_sg13g2_antennanp_1022_880_891_000 i_core_osc_trim_2___Xi_core_u_osc 0.114684f
Ctic3045 VSS__retained_fullchip_sg13g2_antennanp_1022_880_891_000 i_core_osc_trim_3___Xi_core_u_osc 0.0323684f
Ctic3046 VSS__retained_fullchip_sg13g2_antennanp_1022_880_891_000 i_core_pbias__Xi_core_u_t2f 0.065f
Ctic3047 VSS__retained_fullchip_sg13g2_antennanp_1022_880_891_000 i_core_pcasc__Xi_core_u_t2f 0.0258421f
Ctic3048 VSS__retained_fullchip_sg13g2_antennanp_1022_880_891_000 i_core_sclk_i 0.447842f
Ctic3051 VSS__retained_fullchip_sg13g2_antennanp_1022_880_891_000 i_core_sdi_i__retained_fullchip_sg13g2_antennanp_1024_320_891_000 1.00005f
Ctic3052 VSS__retained_fullchip_sg13g2_antennanp_1022_880_891_000 i_core_sdo_o__Xpad16_sdo 0.107684f
Ctic3053 VSS__retained_fullchip_sg13g2_antennanp_1022_880_891_000 i_core_t2f_en_12 0.0402105f
Ctic3054 VSS__retained_fullchip_sg13g2_antennanp_1022_880_891_000 i_core_t2f_en_33__Xi_core_u_t2f 0.164632f
Ctic3055 VSS__retained_fullchip_sg13g2_antennanp_1022_880_891_000 i_core_t2f_mode_12 0.0211053f
Ctic3056 VSS__retained_fullchip_sg13g2_antennanp_1022_880_891_000 i_core_t2f_mode_33__Xi_core_u_t2f 0.312895f
Ctic3057 VSS__retained_fullchip_sg13g2_antennanp_1022_880_891_000 i_core_temp_out_o 0.0501053f
Ctic3058 VSS__retained_fullchip_sg13g2_antennanp_1022_880_891_000 i_core_temp_out_o__Xpad17_temp_out 0.000842105f
Ctic3059 VSS__retained_fullchip_sg13g2_antennanp_1022_880_891_000 i_core_trip_d 0.00552632f
Ctic3060 VSS__retained_fullchip_sg13g2_antennanp_1022_880_891_000 i_core_trip_set__Xpad13_trip_set 0.000105263f
Ctic3061 VSS__retained_fullchip_sg13g2_antennanp_1022_880_891_000 i_core_tripped__retained_fullchip_sg13g2_antennanp_1027_200_891_000 0.156526f
Ctic3062 VSS__retained_fullchip_sg13g2_antennanp_1022_880_891_000 i_core_vref__Xi_core_u_t2f 0.000947368f
Ctic3063 VSS__retained_fullchip_sg13g2_antennanp_1022_880_891_000 i_core_vref__Xpad18_vref 0.0726842f
Ctic3064 VSS__retained_fullchip_sg13g2_antennanp_1022_880_891_000 i_core_vref_buf 0.161211f
Ctic3065 VSS__retained_fullchip_sg13g2_antennanp_1022_880_891_000 net__Xi_core_u_digital_1 0.352316f
Ctic3066 VSS__retained_fullchip_sg13g2_antennanp_1024_320_891_000 _nc1__Xpad07_vdda 0.000421053f
Ctic3067 VSS__retained_fullchip_sg13g2_antennanp_1024_320_891_000 _nc2__Xpad08_sense_p 0.000368421f
Ctic3068 VSS__retained_fullchip_sg13g2_antennanp_1024_320_891_000 _nc3__Xpad09_sense_n 0.000421053f
Ctic3069 VSS__retained_fullchip_sg13g2_antennanp_1024_320_891_000 _nc4__Xpad19_g_shared 0.000315789f
Ctic3070 VSS__retained_fullchip_sg13g2_antennanp_1024_320_891_000 _nc5__Xpad20_d_std 0.000315789f
Ctic3071 VSS__retained_fullchip_sg13g2_antennanp_1024_320_891_000 _nc6__Xpad21_d_elt 0.000315789f
Ctic3072 VSS__retained_fullchip_sg13g2_antennanp_1024_320_891_000 _nc7__Xpad22_hbt_e 0.000315789f
Ctic3073 VSS__retained_fullchip_sg13g2_antennanp_1024_320_891_000 _nc8__Xpad23_hbt_b 0.000368421f
Ctic3074 VSS__retained_fullchip_sg13g2_antennanp_1024_320_891_000 _nc9__Xpad24_hbt_c 0.000368421f
Ctic3075 VSS__retained_fullchip_sg13g2_antennanp_1024_320_891_000 en_i__Xpad12_en 0.000210526f
Ctic3076 VSS__retained_fullchip_sg13g2_antennanp_1024_320_891_000 en_i__retained_fullchip_sg13g2_antennanp_1020_000_891_000 0.450105f
Ctic3077 VSS__retained_fullchip_sg13g2_antennanp_1024_320_891_000 fault_n_o__Xpad11_fault_n 0.546632f
Ctic3078 VSS__retained_fullchip_sg13g2_antennanp_1024_320_891_000 gate_o__Xpad10_gate 0.0812105f
Ctic3079 VSS__retained_fullchip_sg13g2_antennanp_1024_320_891_000 i_core_bgr_r4_12 0.0756842f
Ctic3080 VSS__retained_fullchip_sg13g2_antennanp_1024_320_891_000 i_core_bgr_r4_33 0.0912632f
Ctic3081 VSS__retained_fullchip_sg13g2_antennanp_1024_320_891_000 i_core_clr_d 0.008f
Ctic3082 VSS__retained_fullchip_sg13g2_antennanp_1024_320_891_000 i_core_cmp_clk__Xi_core_u_trip 0.478f
Ctic3083 VSS__retained_fullchip_sg13g2_antennanp_1024_320_891_000 i_core_cmp_hard__Xi_core_u_trip 0.309f
Ctic3084 VSS__retained_fullchip_sg13g2_antennanp_1024_320_891_000 i_core_cmp_soft__retained_fullchip_sg13g2_antennanp_1022_880_891_000 0.151105f
Ctic3085 VSS__retained_fullchip_sg13g2_antennanp_1024_320_891_000 i_core_dac_hard_0___Xi_core_u_trip 0.0316316f
Ctic3086 VSS__retained_fullchip_sg13g2_antennanp_1024_320_891_000 i_core_dac_hard_1___Xi_core_u_trip 0.0123158f
Ctic3087 VSS__retained_fullchip_sg13g2_antennanp_1024_320_891_000 i_core_dac_hard_2___Xi_core_u_trip 0.0278947f
Ctic3088 VSS__retained_fullchip_sg13g2_antennanp_1024_320_891_000 i_core_dac_hard_3___Xi_core_u_trip 0.0884211f
Ctic3089 VSS__retained_fullchip_sg13g2_antennanp_1024_320_891_000 i_core_dac_hard_4___Xi_core_u_trip 0.0341053f
Ctic3090 VSS__retained_fullchip_sg13g2_antennanp_1024_320_891_000 i_core_dac_hard_5___Xi_core_u_trip 0.0503684f
Ctic3091 VSS__retained_fullchip_sg13g2_antennanp_1024_320_891_000 i_core_dac_hard_6___Xi_core_u_trip 0.0545263f
Ctic3092 VSS__retained_fullchip_sg13g2_antennanp_1024_320_891_000 i_core_dac_hard_7___Xi_core_u_trip 0.0821579f
Ctic3093 VSS__retained_fullchip_sg13g2_antennanp_1024_320_891_000 i_core_dac_soft_0___Xi_core_u_trip 0.00852632f
Ctic3094 VSS__retained_fullchip_sg13g2_antennanp_1024_320_891_000 i_core_dac_soft_1___Xi_core_u_trip 0.00157895f
Ctic3095 VSS__retained_fullchip_sg13g2_antennanp_1024_320_891_000 i_core_dac_soft_2___Xi_core_u_trip 0.0160526f
Ctic3096 VSS__retained_fullchip_sg13g2_antennanp_1024_320_891_000 i_core_dac_soft_3___Xi_core_u_trip 0.0125263f
Ctic3097 VSS__retained_fullchip_sg13g2_antennanp_1024_320_891_000 i_core_dac_soft_4___Xi_core_u_trip 0.0208421f
Ctic3098 VSS__retained_fullchip_sg13g2_antennanp_1024_320_891_000 i_core_dac_soft_5___Xi_core_u_trip 0.0106316f
Ctic3099 VSS__retained_fullchip_sg13g2_antennanp_1024_320_891_000 i_core_dac_soft_6___Xi_core_u_trip 0.0385263f
Ctic3100 VSS__retained_fullchip_sg13g2_antennanp_1024_320_891_000 i_core_dac_soft_7___Xi_core_u_trip 0.00605263f
Ctic3101 VSS__retained_fullchip_sg13g2_antennanp_1024_320_891_000 i_core_fast_en__Xi_core_u_gate 0.0104211f
Ctic3102 VSS__retained_fullchip_sg13g2_antennanp_1024_320_891_000 i_core_iptat__Xi_core_u_sense 0.244684f
Ctic3103 VSS__retained_fullchip_sg13g2_antennanp_1024_320_891_000 i_core_isense 0.146421f
Ctic3104 VSS__retained_fullchip_sg13g2_antennanp_1024_320_891_000 i_core_osc_clk__Xi_core_u_osc 0.0963158f
Ctic3105 VSS__retained_fullchip_sg13g2_antennanp_1024_320_891_000 i_core_osc_en__Xi_core_u_osc 0.179316f
Ctic3106 VSS__retained_fullchip_sg13g2_antennanp_1024_320_891_000 i_core_osc_trim_0___Xi_core_u_osc 0.0505789f
Ctic3107 VSS__retained_fullchip_sg13g2_antennanp_1024_320_891_000 i_core_osc_trim_1___Xi_core_u_osc 0.0206842f
Ctic3108 VSS__retained_fullchip_sg13g2_antennanp_1024_320_891_000 i_core_osc_trim_2___Xi_core_u_osc 0.114684f
Ctic3109 VSS__retained_fullchip_sg13g2_antennanp_1024_320_891_000 i_core_osc_trim_3___Xi_core_u_osc 0.0323684f
Ctic3110 VSS__retained_fullchip_sg13g2_antennanp_1024_320_891_000 i_core_pbias__Xi_core_u_t2f 0.065f
Ctic3111 VSS__retained_fullchip_sg13g2_antennanp_1024_320_891_000 i_core_pcasc__Xi_core_u_t2f 0.0258421f
Ctic3112 VSS__retained_fullchip_sg13g2_antennanp_1024_320_891_000 i_core_sclk_i 0.447842f
Ctic3115 VSS__retained_fullchip_sg13g2_antennanp_1024_320_891_000 i_core_sdi_i__retained_fullchip_sg13g2_antennanp_1024_320_891_000 1.00005f
Ctic3116 VSS__retained_fullchip_sg13g2_antennanp_1024_320_891_000 i_core_sdo_o__Xpad16_sdo 0.107684f
Ctic3117 VSS__retained_fullchip_sg13g2_antennanp_1024_320_891_000 i_core_t2f_en_12 0.0402105f
Ctic3118 VSS__retained_fullchip_sg13g2_antennanp_1024_320_891_000 i_core_t2f_en_33__Xi_core_u_t2f 0.164632f
Ctic3119 VSS__retained_fullchip_sg13g2_antennanp_1024_320_891_000 i_core_t2f_mode_12 0.0211053f
Ctic3120 VSS__retained_fullchip_sg13g2_antennanp_1024_320_891_000 i_core_t2f_mode_33__Xi_core_u_t2f 0.312895f
Ctic3121 VSS__retained_fullchip_sg13g2_antennanp_1024_320_891_000 i_core_temp_out_o 0.0501053f
Ctic3122 VSS__retained_fullchip_sg13g2_antennanp_1024_320_891_000 i_core_temp_out_o__Xpad17_temp_out 0.000842105f
Ctic3123 VSS__retained_fullchip_sg13g2_antennanp_1024_320_891_000 i_core_trip_d 0.00552632f
Ctic3124 VSS__retained_fullchip_sg13g2_antennanp_1024_320_891_000 i_core_trip_set__Xpad13_trip_set 0.000105263f
Ctic3125 VSS__retained_fullchip_sg13g2_antennanp_1024_320_891_000 i_core_tripped__retained_fullchip_sg13g2_antennanp_1027_200_891_000 0.156526f
Ctic3126 VSS__retained_fullchip_sg13g2_antennanp_1024_320_891_000 i_core_vref__Xi_core_u_t2f 0.000947368f
Ctic3127 VSS__retained_fullchip_sg13g2_antennanp_1024_320_891_000 i_core_vref__Xpad18_vref 0.0726842f
Ctic3128 VSS__retained_fullchip_sg13g2_antennanp_1024_320_891_000 i_core_vref_buf 0.161211f
Ctic3129 VSS__retained_fullchip_sg13g2_antennanp_1024_320_891_000 net__Xi_core_u_digital_1 0.352316f
Ctic3130 VSS__retained_fullchip_sg13g2_antennanp_1025_760_891_000 _nc1__Xpad07_vdda 0.000421053f
Ctic3131 VSS__retained_fullchip_sg13g2_antennanp_1025_760_891_000 _nc2__Xpad08_sense_p 0.000368421f
Ctic3132 VSS__retained_fullchip_sg13g2_antennanp_1025_760_891_000 _nc3__Xpad09_sense_n 0.000421053f
Ctic3133 VSS__retained_fullchip_sg13g2_antennanp_1025_760_891_000 _nc4__Xpad19_g_shared 0.000315789f
Ctic3134 VSS__retained_fullchip_sg13g2_antennanp_1025_760_891_000 _nc5__Xpad20_d_std 0.000315789f
Ctic3135 VSS__retained_fullchip_sg13g2_antennanp_1025_760_891_000 _nc6__Xpad21_d_elt 0.000315789f
Ctic3136 VSS__retained_fullchip_sg13g2_antennanp_1025_760_891_000 _nc7__Xpad22_hbt_e 0.000315789f
Ctic3137 VSS__retained_fullchip_sg13g2_antennanp_1025_760_891_000 _nc8__Xpad23_hbt_b 0.000368421f
Ctic3138 VSS__retained_fullchip_sg13g2_antennanp_1025_760_891_000 _nc9__Xpad24_hbt_c 0.000368421f
Ctic3139 VSS__retained_fullchip_sg13g2_antennanp_1025_760_891_000 en_i__Xpad12_en 0.000210526f
Ctic3140 VSS__retained_fullchip_sg13g2_antennanp_1025_760_891_000 en_i__retained_fullchip_sg13g2_antennanp_1020_000_891_000 0.450105f
Ctic3141 VSS__retained_fullchip_sg13g2_antennanp_1025_760_891_000 fault_n_o__Xpad11_fault_n 0.546632f
Ctic3142 VSS__retained_fullchip_sg13g2_antennanp_1025_760_891_000 gate_o__Xpad10_gate 0.0812105f
Ctic3143 VSS__retained_fullchip_sg13g2_antennanp_1025_760_891_000 i_core_bgr_r4_12 0.0756842f
Ctic3144 VSS__retained_fullchip_sg13g2_antennanp_1025_760_891_000 i_core_bgr_r4_33 0.0912632f
Ctic3145 VSS__retained_fullchip_sg13g2_antennanp_1025_760_891_000 i_core_clr_d 0.008f
Ctic3146 VSS__retained_fullchip_sg13g2_antennanp_1025_760_891_000 i_core_cmp_clk__Xi_core_u_trip 0.478f
Ctic3147 VSS__retained_fullchip_sg13g2_antennanp_1025_760_891_000 i_core_cmp_hard__Xi_core_u_trip 0.309f
Ctic3148 VSS__retained_fullchip_sg13g2_antennanp_1025_760_891_000 i_core_cmp_soft__retained_fullchip_sg13g2_antennanp_1022_880_891_000 0.151105f
Ctic3149 VSS__retained_fullchip_sg13g2_antennanp_1025_760_891_000 i_core_dac_hard_0___Xi_core_u_trip 0.0316316f
Ctic3150 VSS__retained_fullchip_sg13g2_antennanp_1025_760_891_000 i_core_dac_hard_1___Xi_core_u_trip 0.0123158f
Ctic3151 VSS__retained_fullchip_sg13g2_antennanp_1025_760_891_000 i_core_dac_hard_2___Xi_core_u_trip 0.0278947f
Ctic3152 VSS__retained_fullchip_sg13g2_antennanp_1025_760_891_000 i_core_dac_hard_3___Xi_core_u_trip 0.0884211f
Ctic3153 VSS__retained_fullchip_sg13g2_antennanp_1025_760_891_000 i_core_dac_hard_4___Xi_core_u_trip 0.0341053f
Ctic3154 VSS__retained_fullchip_sg13g2_antennanp_1025_760_891_000 i_core_dac_hard_5___Xi_core_u_trip 0.0503684f
Ctic3155 VSS__retained_fullchip_sg13g2_antennanp_1025_760_891_000 i_core_dac_hard_6___Xi_core_u_trip 0.0545263f
Ctic3156 VSS__retained_fullchip_sg13g2_antennanp_1025_760_891_000 i_core_dac_hard_7___Xi_core_u_trip 0.0821579f
Ctic3157 VSS__retained_fullchip_sg13g2_antennanp_1025_760_891_000 i_core_dac_soft_0___Xi_core_u_trip 0.00852632f
Ctic3158 VSS__retained_fullchip_sg13g2_antennanp_1025_760_891_000 i_core_dac_soft_1___Xi_core_u_trip 0.00157895f
Ctic3159 VSS__retained_fullchip_sg13g2_antennanp_1025_760_891_000 i_core_dac_soft_2___Xi_core_u_trip 0.0160526f
Ctic3160 VSS__retained_fullchip_sg13g2_antennanp_1025_760_891_000 i_core_dac_soft_3___Xi_core_u_trip 0.0125263f
Ctic3161 VSS__retained_fullchip_sg13g2_antennanp_1025_760_891_000 i_core_dac_soft_4___Xi_core_u_trip 0.0208421f
Ctic3162 VSS__retained_fullchip_sg13g2_antennanp_1025_760_891_000 i_core_dac_soft_5___Xi_core_u_trip 0.0106316f
Ctic3163 VSS__retained_fullchip_sg13g2_antennanp_1025_760_891_000 i_core_dac_soft_6___Xi_core_u_trip 0.0385263f
Ctic3164 VSS__retained_fullchip_sg13g2_antennanp_1025_760_891_000 i_core_dac_soft_7___Xi_core_u_trip 0.00605263f
Ctic3165 VSS__retained_fullchip_sg13g2_antennanp_1025_760_891_000 i_core_fast_en__Xi_core_u_gate 0.0104211f
Ctic3166 VSS__retained_fullchip_sg13g2_antennanp_1025_760_891_000 i_core_iptat__Xi_core_u_sense 0.244684f
Ctic3167 VSS__retained_fullchip_sg13g2_antennanp_1025_760_891_000 i_core_isense 0.146421f
Ctic3168 VSS__retained_fullchip_sg13g2_antennanp_1025_760_891_000 i_core_osc_clk__Xi_core_u_osc 0.0963158f
Ctic3169 VSS__retained_fullchip_sg13g2_antennanp_1025_760_891_000 i_core_osc_en__Xi_core_u_osc 0.179316f
Ctic3170 VSS__retained_fullchip_sg13g2_antennanp_1025_760_891_000 i_core_osc_trim_0___Xi_core_u_osc 0.0505789f
Ctic3171 VSS__retained_fullchip_sg13g2_antennanp_1025_760_891_000 i_core_osc_trim_1___Xi_core_u_osc 0.0206842f
Ctic3172 VSS__retained_fullchip_sg13g2_antennanp_1025_760_891_000 i_core_osc_trim_2___Xi_core_u_osc 0.114684f
Ctic3173 VSS__retained_fullchip_sg13g2_antennanp_1025_760_891_000 i_core_osc_trim_3___Xi_core_u_osc 0.0323684f
Ctic3174 VSS__retained_fullchip_sg13g2_antennanp_1025_760_891_000 i_core_pbias__Xi_core_u_t2f 0.065f
Ctic3175 VSS__retained_fullchip_sg13g2_antennanp_1025_760_891_000 i_core_pcasc__Xi_core_u_t2f 0.0258421f
Ctic3176 VSS__retained_fullchip_sg13g2_antennanp_1025_760_891_000 i_core_sclk_i 0.447842f
Ctic3179 VSS__retained_fullchip_sg13g2_antennanp_1025_760_891_000 i_core_sdi_i__retained_fullchip_sg13g2_antennanp_1024_320_891_000 1.00005f
Ctic3180 VSS__retained_fullchip_sg13g2_antennanp_1025_760_891_000 i_core_sdo_o__Xpad16_sdo 0.107684f
Ctic3181 VSS__retained_fullchip_sg13g2_antennanp_1025_760_891_000 i_core_t2f_en_12 0.0402105f
Ctic3182 VSS__retained_fullchip_sg13g2_antennanp_1025_760_891_000 i_core_t2f_en_33__Xi_core_u_t2f 0.164632f
Ctic3183 VSS__retained_fullchip_sg13g2_antennanp_1025_760_891_000 i_core_t2f_mode_12 0.0211053f
Ctic3184 VSS__retained_fullchip_sg13g2_antennanp_1025_760_891_000 i_core_t2f_mode_33__Xi_core_u_t2f 0.312895f
Ctic3185 VSS__retained_fullchip_sg13g2_antennanp_1025_760_891_000 i_core_temp_out_o 0.0501053f
Ctic3186 VSS__retained_fullchip_sg13g2_antennanp_1025_760_891_000 i_core_temp_out_o__Xpad17_temp_out 0.000842105f
Ctic3187 VSS__retained_fullchip_sg13g2_antennanp_1025_760_891_000 i_core_trip_d 0.00552632f
Ctic3188 VSS__retained_fullchip_sg13g2_antennanp_1025_760_891_000 i_core_trip_set__Xpad13_trip_set 0.000105263f
Ctic3189 VSS__retained_fullchip_sg13g2_antennanp_1025_760_891_000 i_core_tripped__retained_fullchip_sg13g2_antennanp_1027_200_891_000 0.156526f
Ctic3190 VSS__retained_fullchip_sg13g2_antennanp_1025_760_891_000 i_core_vref__Xi_core_u_t2f 0.000947368f
Ctic3191 VSS__retained_fullchip_sg13g2_antennanp_1025_760_891_000 i_core_vref__Xpad18_vref 0.0726842f
Ctic3192 VSS__retained_fullchip_sg13g2_antennanp_1025_760_891_000 i_core_vref_buf 0.161211f
Ctic3193 VSS__retained_fullchip_sg13g2_antennanp_1025_760_891_000 net__Xi_core_u_digital_1 0.352316f
Ctic3194 VSS__retained_fullchip_sg13g2_antennanp_1027_200_891_000 _nc1__Xpad07_vdda 0.000421053f
Ctic3195 VSS__retained_fullchip_sg13g2_antennanp_1027_200_891_000 _nc2__Xpad08_sense_p 0.000368421f
Ctic3196 VSS__retained_fullchip_sg13g2_antennanp_1027_200_891_000 _nc3__Xpad09_sense_n 0.000421053f
Ctic3197 VSS__retained_fullchip_sg13g2_antennanp_1027_200_891_000 _nc4__Xpad19_g_shared 0.000315789f
Ctic3198 VSS__retained_fullchip_sg13g2_antennanp_1027_200_891_000 _nc5__Xpad20_d_std 0.000315789f
Ctic3199 VSS__retained_fullchip_sg13g2_antennanp_1027_200_891_000 _nc6__Xpad21_d_elt 0.000315789f
Ctic3200 VSS__retained_fullchip_sg13g2_antennanp_1027_200_891_000 _nc7__Xpad22_hbt_e 0.000315789f
Ctic3201 VSS__retained_fullchip_sg13g2_antennanp_1027_200_891_000 _nc8__Xpad23_hbt_b 0.000368421f
Ctic3202 VSS__retained_fullchip_sg13g2_antennanp_1027_200_891_000 _nc9__Xpad24_hbt_c 0.000368421f
Ctic3203 VSS__retained_fullchip_sg13g2_antennanp_1027_200_891_000 en_i__Xpad12_en 0.000210526f
Ctic3204 VSS__retained_fullchip_sg13g2_antennanp_1027_200_891_000 en_i__retained_fullchip_sg13g2_antennanp_1020_000_891_000 0.450105f
Ctic3205 VSS__retained_fullchip_sg13g2_antennanp_1027_200_891_000 fault_n_o__Xpad11_fault_n 0.546632f
Ctic3206 VSS__retained_fullchip_sg13g2_antennanp_1027_200_891_000 gate_o__Xpad10_gate 0.0812105f
Ctic3207 VSS__retained_fullchip_sg13g2_antennanp_1027_200_891_000 i_core_bgr_r4_12 0.0756842f
Ctic3208 VSS__retained_fullchip_sg13g2_antennanp_1027_200_891_000 i_core_bgr_r4_33 0.0912632f
Ctic3209 VSS__retained_fullchip_sg13g2_antennanp_1027_200_891_000 i_core_clr_d 0.008f
Ctic3210 VSS__retained_fullchip_sg13g2_antennanp_1027_200_891_000 i_core_cmp_clk__Xi_core_u_trip 0.478f
Ctic3211 VSS__retained_fullchip_sg13g2_antennanp_1027_200_891_000 i_core_cmp_hard__Xi_core_u_trip 0.309f
Ctic3212 VSS__retained_fullchip_sg13g2_antennanp_1027_200_891_000 i_core_cmp_soft__retained_fullchip_sg13g2_antennanp_1022_880_891_000 0.151105f
Ctic3213 VSS__retained_fullchip_sg13g2_antennanp_1027_200_891_000 i_core_dac_hard_0___Xi_core_u_trip 0.0316316f
Ctic3214 VSS__retained_fullchip_sg13g2_antennanp_1027_200_891_000 i_core_dac_hard_1___Xi_core_u_trip 0.0123158f
Ctic3215 VSS__retained_fullchip_sg13g2_antennanp_1027_200_891_000 i_core_dac_hard_2___Xi_core_u_trip 0.0278947f
Ctic3216 VSS__retained_fullchip_sg13g2_antennanp_1027_200_891_000 i_core_dac_hard_3___Xi_core_u_trip 0.0884211f
Ctic3217 VSS__retained_fullchip_sg13g2_antennanp_1027_200_891_000 i_core_dac_hard_4___Xi_core_u_trip 0.0341053f
Ctic3218 VSS__retained_fullchip_sg13g2_antennanp_1027_200_891_000 i_core_dac_hard_5___Xi_core_u_trip 0.0503684f
Ctic3219 VSS__retained_fullchip_sg13g2_antennanp_1027_200_891_000 i_core_dac_hard_6___Xi_core_u_trip 0.0545263f
Ctic3220 VSS__retained_fullchip_sg13g2_antennanp_1027_200_891_000 i_core_dac_hard_7___Xi_core_u_trip 0.0821579f
Ctic3221 VSS__retained_fullchip_sg13g2_antennanp_1027_200_891_000 i_core_dac_soft_0___Xi_core_u_trip 0.00852632f
Ctic3222 VSS__retained_fullchip_sg13g2_antennanp_1027_200_891_000 i_core_dac_soft_1___Xi_core_u_trip 0.00157895f
Ctic3223 VSS__retained_fullchip_sg13g2_antennanp_1027_200_891_000 i_core_dac_soft_2___Xi_core_u_trip 0.0160526f
Ctic3224 VSS__retained_fullchip_sg13g2_antennanp_1027_200_891_000 i_core_dac_soft_3___Xi_core_u_trip 0.0125263f
Ctic3225 VSS__retained_fullchip_sg13g2_antennanp_1027_200_891_000 i_core_dac_soft_4___Xi_core_u_trip 0.0208421f
Ctic3226 VSS__retained_fullchip_sg13g2_antennanp_1027_200_891_000 i_core_dac_soft_5___Xi_core_u_trip 0.0106316f
Ctic3227 VSS__retained_fullchip_sg13g2_antennanp_1027_200_891_000 i_core_dac_soft_6___Xi_core_u_trip 0.0385263f
Ctic3228 VSS__retained_fullchip_sg13g2_antennanp_1027_200_891_000 i_core_dac_soft_7___Xi_core_u_trip 0.00605263f
Ctic3229 VSS__retained_fullchip_sg13g2_antennanp_1027_200_891_000 i_core_fast_en__Xi_core_u_gate 0.0104211f
Ctic3230 VSS__retained_fullchip_sg13g2_antennanp_1027_200_891_000 i_core_iptat__Xi_core_u_sense 0.244684f
Ctic3231 VSS__retained_fullchip_sg13g2_antennanp_1027_200_891_000 i_core_isense 0.146421f
Ctic3232 VSS__retained_fullchip_sg13g2_antennanp_1027_200_891_000 i_core_osc_clk__Xi_core_u_osc 0.0963158f
Ctic3233 VSS__retained_fullchip_sg13g2_antennanp_1027_200_891_000 i_core_osc_en__Xi_core_u_osc 0.179316f
Ctic3234 VSS__retained_fullchip_sg13g2_antennanp_1027_200_891_000 i_core_osc_trim_0___Xi_core_u_osc 0.0505789f
Ctic3235 VSS__retained_fullchip_sg13g2_antennanp_1027_200_891_000 i_core_osc_trim_1___Xi_core_u_osc 0.0206842f
Ctic3236 VSS__retained_fullchip_sg13g2_antennanp_1027_200_891_000 i_core_osc_trim_2___Xi_core_u_osc 0.114684f
Ctic3237 VSS__retained_fullchip_sg13g2_antennanp_1027_200_891_000 i_core_osc_trim_3___Xi_core_u_osc 0.0323684f
Ctic3238 VSS__retained_fullchip_sg13g2_antennanp_1027_200_891_000 i_core_pbias__Xi_core_u_t2f 0.065f
Ctic3239 VSS__retained_fullchip_sg13g2_antennanp_1027_200_891_000 i_core_pcasc__Xi_core_u_t2f 0.0258421f
Ctic3240 VSS__retained_fullchip_sg13g2_antennanp_1027_200_891_000 i_core_sclk_i 0.447842f
Ctic3243 VSS__retained_fullchip_sg13g2_antennanp_1027_200_891_000 i_core_sdi_i__retained_fullchip_sg13g2_antennanp_1024_320_891_000 1.00005f
Ctic3244 VSS__retained_fullchip_sg13g2_antennanp_1027_200_891_000 i_core_sdo_o__Xpad16_sdo 0.107684f
Ctic3245 VSS__retained_fullchip_sg13g2_antennanp_1027_200_891_000 i_core_t2f_en_12 0.0402105f
Ctic3246 VSS__retained_fullchip_sg13g2_antennanp_1027_200_891_000 i_core_t2f_en_33__Xi_core_u_t2f 0.164632f
Ctic3247 VSS__retained_fullchip_sg13g2_antennanp_1027_200_891_000 i_core_t2f_mode_12 0.0211053f
Ctic3248 VSS__retained_fullchip_sg13g2_antennanp_1027_200_891_000 i_core_t2f_mode_33__Xi_core_u_t2f 0.312895f
Ctic3249 VSS__retained_fullchip_sg13g2_antennanp_1027_200_891_000 i_core_temp_out_o 0.0501053f
Ctic3250 VSS__retained_fullchip_sg13g2_antennanp_1027_200_891_000 i_core_temp_out_o__Xpad17_temp_out 0.000842105f
Ctic3251 VSS__retained_fullchip_sg13g2_antennanp_1027_200_891_000 i_core_trip_d 0.00552632f
Ctic3252 VSS__retained_fullchip_sg13g2_antennanp_1027_200_891_000 i_core_trip_set__Xpad13_trip_set 0.000105263f
Ctic3253 VSS__retained_fullchip_sg13g2_antennanp_1027_200_891_000 i_core_tripped__retained_fullchip_sg13g2_antennanp_1027_200_891_000 0.156526f
Ctic3254 VSS__retained_fullchip_sg13g2_antennanp_1027_200_891_000 i_core_vref__Xi_core_u_t2f 0.000947368f
Ctic3255 VSS__retained_fullchip_sg13g2_antennanp_1027_200_891_000 i_core_vref__Xpad18_vref 0.0726842f
Ctic3256 VSS__retained_fullchip_sg13g2_antennanp_1027_200_891_000 i_core_vref_buf 0.161211f
Ctic3257 VSS__retained_fullchip_sg13g2_antennanp_1027_200_891_000 net__Xi_core_u_digital_1 0.352316f
Ctic3258 _nc7__Xpad22_hbt_e i_core_sdi_i 0.000666667f
Ctic3259 _nc7__Xpad22_hbt_e i_core_sdi_i__Xpad15_sdi 0.000666667f
Ctic3260 _nc7__Xpad22_hbt_e i_core_sdi_i__retained_fullchip_sg13g2_antennanp_1024_320_891_000 0.000666667f
Ctic3261 _nc8__Xpad23_hbt_b i_core_sdi_i 0.000666667f
Ctic3262 _nc8__Xpad23_hbt_b i_core_sdi_i__Xpad15_sdi 0.000666667f
Ctic3263 _nc8__Xpad23_hbt_b i_core_sdi_i__retained_fullchip_sg13g2_antennanp_1024_320_891_000 0.000666667f
Ctic3264 _nc9__Xpad24_hbt_c i_core_sdi_i 0.000666667f
Ctic3265 _nc9__Xpad24_hbt_c i_core_sdi_i__Xpad15_sdi 0.000666667f
Ctic3266 _nc9__Xpad24_hbt_c i_core_sdi_i__retained_fullchip_sg13g2_antennanp_1024_320_891_000 0.000666667f
Ctic3267 en_i fault_n_o 1.60375f
Ctic3268 en_i gate_o 0.20875f
Ctic3269 en_i i_core_bgr_r4_33__Xi_core_u_ls_r4 0.0075f
Ctic3270 en_i i_core_clr_d 0.102f
Ctic3271 en_i i_core_cmp_clk 0.13575f
Ctic3272 en_i i_core_cmp_hard 1.36475f
Ctic3273 en_i i_core_cmp_soft 0.111f
Ctic3274 en_i i_core_dac_hard_0_ 11.447f
Ctic3275 en_i i_core_dac_hard_1_ 0.01225f
Ctic3276 en_i i_core_dac_hard_2_ 0.013f
Ctic3277 en_i i_core_dac_hard_3_ 0.0425f
Ctic3278 en_i i_core_dac_hard_4_ 0.01225f
Ctic3279 en_i i_core_dac_hard_5_ 0.0125f
Ctic3280 en_i i_core_dac_hard_6_ 0.02825f
Ctic3281 en_i i_core_dac_hard_7_ 0.012f
Ctic3283 en_i i_core_iptat__Xi_core_u_sense 0.00775f
Ctic3284 en_i i_core_isense 3.3305f
Ctic3285 en_i i_core_osc_clk 0.00725f
Ctic3286 en_i i_core_osc_en 0.00775f
Ctic3287 en_i i_core_osc_trim_1_ 0.008f
Ctic3288 en_i i_core_osc_trim_3_ 0.0075f
Ctic3289 en_i i_core_pbias 0.0485f
Ctic3290 en_i i_core_pcasc 0.0155f
Ctic3291 en_i i_core_sdi_i 0.43675f
Ctic3292 en_i i_core_t2f_en_12 0.02125f
Ctic3293 en_i i_core_t2f_en_33 0.1605f
Ctic3294 en_i i_core_t2f_mode_12 0.001f
Ctic3295 en_i i_core_t2f_mode_33 0.0765f
Ctic3296 en_i i_core_trip_d 0.0065f
Ctic3297 en_i i_core_tripped 0.29625f
Ctic3298 en_i i_core_vref__Xi_core_u_sense 0.0095f
Ctic3299 en_i i_core_vref_buf 0.03925f
Ctic3300 en_i net 0.015f
Ctic3301 en_i__Xi_core_u_gate fault_n_o 1.60375f
Ctic3302 en_i__Xi_core_u_gate gate_o 0.20875f
Ctic3303 en_i__Xi_core_u_gate i_core_bgr_r4_33__Xi_core_u_ls_r4 0.0075f
Ctic3304 en_i__Xi_core_u_gate i_core_clr_d__Xi_core_u_gate 0.102f
Ctic3305 en_i__Xi_core_u_gate i_core_cmp_clk 0.13575f
Ctic3306 en_i__Xi_core_u_gate i_core_cmp_hard__Xi_core_u_gate 1.36475f
Ctic3307 en_i__Xi_core_u_gate i_core_cmp_soft 0.111f
Ctic3308 en_i__Xi_core_u_gate i_core_dac_hard_0_ 11.447f
Ctic3309 en_i__Xi_core_u_gate i_core_dac_hard_1_ 0.01225f
Ctic3310 en_i__Xi_core_u_gate i_core_dac_hard_2_ 0.013f
Ctic3311 en_i__Xi_core_u_gate i_core_dac_hard_3_ 0.0425f
Ctic3312 en_i__Xi_core_u_gate i_core_dac_hard_4_ 0.01225f
Ctic3313 en_i__Xi_core_u_gate i_core_dac_hard_5_ 0.0125f
Ctic3314 en_i__Xi_core_u_gate i_core_dac_hard_6_ 0.02825f
Ctic3315 en_i__Xi_core_u_gate i_core_dac_hard_7_ 0.012f
Ctic3317 en_i__Xi_core_u_gate i_core_iptat__Xi_core_u_sense 0.00775f
Ctic3318 en_i__Xi_core_u_gate i_core_isense 3.3305f
Ctic3319 en_i__Xi_core_u_gate i_core_osc_clk 0.00725f
Ctic3320 en_i__Xi_core_u_gate i_core_osc_en 0.00775f
Ctic3321 en_i__Xi_core_u_gate i_core_osc_trim_1_ 0.008f
Ctic3322 en_i__Xi_core_u_gate i_core_osc_trim_3_ 0.0075f
Ctic3323 en_i__Xi_core_u_gate i_core_pbias 0.0485f
Ctic3324 en_i__Xi_core_u_gate i_core_pcasc 0.0155f
Ctic3325 en_i__Xi_core_u_gate i_core_sdi_i 0.43675f
Ctic3326 en_i__Xi_core_u_gate i_core_t2f_en_12__Xi_core_u_ls_en 0.02125f
Ctic3327 en_i__Xi_core_u_gate i_core_t2f_en_33 0.1605f
Ctic3328 en_i__Xi_core_u_gate i_core_t2f_mode_12__Xi_core_u_ls_mode 0.001f
Ctic3329 en_i__Xi_core_u_gate i_core_t2f_mode_33 0.0765f
Ctic3330 en_i__Xi_core_u_gate i_core_trip_d__Xi_core_u_gate 0.0065f
Ctic3331 en_i__Xi_core_u_gate i_core_tripped 0.29625f
Ctic3332 en_i__Xi_core_u_gate i_core_vref__Xi_core_u_sense 0.0095f
Ctic3333 en_i__Xi_core_u_gate i_core_vref_buf 0.03925f
Ctic3334 en_i__Xi_core_u_gate net 0.015f
Ctic3335 en_i__Xpad12_en fault_n_o__Xpad11_fault_n 1.60375f
Ctic3336 en_i__Xpad12_en gate_o__Xpad10_gate 0.20875f
Ctic3337 en_i__Xpad12_en i_core_bgr_r4_33 0.0075f
Ctic3338 en_i__Xpad12_en i_core_clr_d 0.102f
Ctic3339 en_i__Xpad12_en i_core_cmp_clk__Xi_core_u_trip 0.13575f
Ctic3340 en_i__Xpad12_en i_core_cmp_hard__Xi_core_u_trip 1.36475f
Ctic3341 en_i__Xpad12_en i_core_cmp_soft__retained_fullchip_sg13g2_antennanp_1022_880_891_000 0.111f
Ctic3342 en_i__Xpad12_en i_core_dac_hard_0___Xi_core_u_trip 11.447f
Ctic3343 en_i__Xpad12_en i_core_dac_hard_1___Xi_core_u_trip 0.01225f
Ctic3344 en_i__Xpad12_en i_core_dac_hard_2___Xi_core_u_trip 0.013f
Ctic3345 en_i__Xpad12_en i_core_dac_hard_3___Xi_core_u_trip 0.0425f
Ctic3346 en_i__Xpad12_en i_core_dac_hard_4___Xi_core_u_trip 0.01225f
Ctic3347 en_i__Xpad12_en i_core_dac_hard_5___Xi_core_u_trip 0.0125f
Ctic3348 en_i__Xpad12_en i_core_dac_hard_6___Xi_core_u_trip 0.02825f
Ctic3349 en_i__Xpad12_en i_core_dac_hard_7___Xi_core_u_trip 0.012f
Ctic3351 en_i__Xpad12_en i_core_iptat__Xi_core_u_sense 0.00775f
Ctic3352 en_i__Xpad12_en i_core_isense__Xi_core_u_trip 3.3305f
Ctic3353 en_i__Xpad12_en i_core_osc_clk__Xi_core_u_osc 0.00725f
Ctic3354 en_i__Xpad12_en i_core_osc_en__Xi_core_u_osc 0.00775f
Ctic3355 en_i__Xpad12_en i_core_osc_trim_1___Xi_core_u_osc 0.008f
Ctic3356 en_i__Xpad12_en i_core_osc_trim_3___Xi_core_u_osc 0.0075f
Ctic3357 en_i__Xpad12_en i_core_pbias__Xi_core_u_t2f 0.0485f
Ctic3358 en_i__Xpad12_en i_core_pcasc__Xi_core_u_t2f 0.0155f
Ctic3359 en_i__Xpad12_en i_core_sdi_i__retained_fullchip_sg13g2_antennanp_1024_320_891_000 0.43675f
Ctic3360 en_i__Xpad12_en i_core_t2f_en_12 0.02125f
Ctic3361 en_i__Xpad12_en i_core_t2f_en_33__Xi_core_u_t2f 0.1605f
Ctic3362 en_i__Xpad12_en i_core_t2f_mode_12 0.001f
Ctic3363 en_i__Xpad12_en i_core_t2f_mode_33__Xi_core_u_t2f 0.0765f
Ctic3364 en_i__Xpad12_en i_core_trip_d 0.0065f
Ctic3365 en_i__Xpad12_en i_core_tripped__retained_fullchip_sg13g2_antennanp_1027_200_891_000 0.29625f
Ctic3366 en_i__Xpad12_en i_core_vref__Xpad18_vref 0.0095f
Ctic3367 en_i__Xpad12_en i_core_vref_buf__Xi_core_u_trip 0.03925f
Ctic3368 en_i__Xpad12_en net__Xi_core_u_digital_1 0.015f
Ctic3369 en_i__retained_fullchip_sg13g2_antennanp_1020_000_891_000 fault_n_o__Xpad11_fault_n 1.60375f
Ctic3370 en_i__retained_fullchip_sg13g2_antennanp_1020_000_891_000 gate_o__Xpad10_gate 0.20875f
Ctic3371 en_i__retained_fullchip_sg13g2_antennanp_1020_000_891_000 i_core_bgr_r4_33 0.0075f
Ctic3372 en_i__retained_fullchip_sg13g2_antennanp_1020_000_891_000 i_core_clr_d 0.102f
Ctic3373 en_i__retained_fullchip_sg13g2_antennanp_1020_000_891_000 i_core_cmp_clk__Xi_core_u_trip 0.13575f
Ctic3374 en_i__retained_fullchip_sg13g2_antennanp_1020_000_891_000 i_core_cmp_hard__Xi_core_u_trip 1.36475f
Ctic3375 en_i__retained_fullchip_sg13g2_antennanp_1020_000_891_000 i_core_cmp_soft__retained_fullchip_sg13g2_antennanp_1021_440_891_000 0.111f
Ctic3376 en_i__retained_fullchip_sg13g2_antennanp_1020_000_891_000 i_core_dac_hard_0___Xi_core_u_trip 11.447f
Ctic3377 en_i__retained_fullchip_sg13g2_antennanp_1020_000_891_000 i_core_dac_hard_1___Xi_core_u_trip 0.01225f
Ctic3378 en_i__retained_fullchip_sg13g2_antennanp_1020_000_891_000 i_core_dac_hard_2___Xi_core_u_trip 0.013f
Ctic3379 en_i__retained_fullchip_sg13g2_antennanp_1020_000_891_000 i_core_dac_hard_3___Xi_core_u_trip 0.0425f
Ctic3380 en_i__retained_fullchip_sg13g2_antennanp_1020_000_891_000 i_core_dac_hard_4___Xi_core_u_trip 0.01225f
Ctic3381 en_i__retained_fullchip_sg13g2_antennanp_1020_000_891_000 i_core_dac_hard_5___Xi_core_u_trip 0.0125f
Ctic3382 en_i__retained_fullchip_sg13g2_antennanp_1020_000_891_000 i_core_dac_hard_6___Xi_core_u_trip 0.02825f
Ctic3383 en_i__retained_fullchip_sg13g2_antennanp_1020_000_891_000 i_core_dac_hard_7___Xi_core_u_trip 0.012f
Ctic3385 en_i__retained_fullchip_sg13g2_antennanp_1020_000_891_000 i_core_iptat__Xi_core_u_sense 0.00775f
Ctic3386 en_i__retained_fullchip_sg13g2_antennanp_1020_000_891_000 i_core_isense 3.3305f
Ctic3387 en_i__retained_fullchip_sg13g2_antennanp_1020_000_891_000 i_core_osc_clk__Xi_core_u_osc 0.00725f
Ctic3388 en_i__retained_fullchip_sg13g2_antennanp_1020_000_891_000 i_core_osc_en__Xi_core_u_osc 0.00775f
Ctic3389 en_i__retained_fullchip_sg13g2_antennanp_1020_000_891_000 i_core_osc_trim_1___Xi_core_u_osc 0.008f
Ctic3390 en_i__retained_fullchip_sg13g2_antennanp_1020_000_891_000 i_core_osc_trim_3___Xi_core_u_osc 0.0075f
Ctic3391 en_i__retained_fullchip_sg13g2_antennanp_1020_000_891_000 i_core_pbias__Xi_core_u_t2f 0.0485f
Ctic3392 en_i__retained_fullchip_sg13g2_antennanp_1020_000_891_000 i_core_pcasc__Xi_core_u_t2f 0.0155f
Ctic3393 en_i__retained_fullchip_sg13g2_antennanp_1020_000_891_000 i_core_sdi_i__retained_fullchip_sg13g2_antennanp_1024_320_891_000 0.43675f
Ctic3394 en_i__retained_fullchip_sg13g2_antennanp_1020_000_891_000 i_core_t2f_en_12 0.02125f
Ctic3395 en_i__retained_fullchip_sg13g2_antennanp_1020_000_891_000 i_core_t2f_en_33__Xi_core_u_t2f 0.1605f
Ctic3396 en_i__retained_fullchip_sg13g2_antennanp_1020_000_891_000 i_core_t2f_mode_12 0.001f
Ctic3397 en_i__retained_fullchip_sg13g2_antennanp_1020_000_891_000 i_core_t2f_mode_33__Xi_core_u_t2f 0.0765f
Ctic3398 en_i__retained_fullchip_sg13g2_antennanp_1020_000_891_000 i_core_trip_d 0.0065f
Ctic3399 en_i__retained_fullchip_sg13g2_antennanp_1020_000_891_000 i_core_tripped__retained_fullchip_sg13g2_antennanp_1027_200_891_000 0.29625f
Ctic3400 en_i__retained_fullchip_sg13g2_antennanp_1020_000_891_000 i_core_vref__Xpad18_vref 0.0095f
Ctic3401 en_i__retained_fullchip_sg13g2_antennanp_1020_000_891_000 i_core_vref_buf 0.03925f
Ctic3402 en_i__retained_fullchip_sg13g2_antennanp_1020_000_891_000 net__Xi_core_u_digital_1 0.015f
Ctic3403 fault_n_o gate_o 1.154f
Ctic3404 fault_n_o gate_o__Xpad10_gate 0.017f
Ctic3405 fault_n_o i_core_bgr_r4_33__Xi_core_u_ls_r4 0.013f
Ctic3406 fault_n_o i_core_cmp_clk 0.761f
Ctic3407 fault_n_o i_core_cmp_hard 4.424f
Ctic3408 fault_n_o i_core_cmp_soft__retained_fullchip_sg13g2_antennanp_1021_440_891_000 0.029f
Ctic3409 fault_n_o i_core_dac_hard_0_ 0.0285f
Ctic3410 fault_n_o i_core_dac_hard_1_ 0.0285f
Ctic3411 fault_n_o i_core_dac_hard_2_ 0.0535f
Ctic3412 fault_n_o i_core_dac_hard_3_ 0.022f
Ctic3413 fault_n_o i_core_dac_hard_4_ 0.021f
Ctic3414 fault_n_o i_core_dac_hard_5_ 0.0245f
Ctic3415 fault_n_o i_core_dac_hard_6_ 0.0475f
Ctic3416 fault_n_o i_core_dac_hard_7_ 0.0235f
Ctic3417 fault_n_o i_core_iptat__Xi_core_u_sense 0.0375f
Ctic3418 fault_n_o i_core_isense 2.183f
Ctic3419 fault_n_o i_core_osc_trim_0_ 0.0225f
Ctic3420 fault_n_o i_core_osc_trim_2_ 0.0195f
Ctic3421 fault_n_o i_core_t2f_en_33 0.017f
Ctic3422 fault_n_o i_core_t2f_mode_33 0.0165f
Ctic3423 fault_n_o i_core_tripped__Xi_core_u_gate 0.193f
Ctic3424 fault_n_o i_core_vref__Xi_core_u_sense 0.013f
Ctic3425 fault_n_o i_core_vref_buf 0.057f
Ctic3426 fault_n_o net 0.0635f
Ctic3427 fault_n_o__Xpad11_fault_n gate_o__Xpad10_gate 1.171f
Ctic3428 fault_n_o__Xpad11_fault_n i_core_bgr_r4_33 0.013f
Ctic3429 fault_n_o__Xpad11_fault_n i_core_cmp_clk__Xi_core_u_trip 0.761f
Ctic3430 fault_n_o__Xpad11_fault_n i_core_cmp_hard__Xi_core_u_trip 4.424f
Ctic3431 fault_n_o__Xpad11_fault_n i_core_cmp_soft__retained_fullchip_sg13g2_antennanp_1022_880_891_000 0.029f
Ctic3432 fault_n_o__Xpad11_fault_n i_core_dac_hard_0___Xi_core_u_trip 0.0285f
Ctic3433 fault_n_o__Xpad11_fault_n i_core_dac_hard_1___Xi_core_u_trip 0.0285f
Ctic3434 fault_n_o__Xpad11_fault_n i_core_dac_hard_2___Xi_core_u_trip 0.0535f
Ctic3435 fault_n_o__Xpad11_fault_n i_core_dac_hard_3___Xi_core_u_trip 0.022f
Ctic3436 fault_n_o__Xpad11_fault_n i_core_dac_hard_4___Xi_core_u_trip 0.021f
Ctic3437 fault_n_o__Xpad11_fault_n i_core_dac_hard_5___Xi_core_u_trip 0.0245f
Ctic3438 fault_n_o__Xpad11_fault_n i_core_dac_hard_6___Xi_core_u_trip 0.0475f
Ctic3439 fault_n_o__Xpad11_fault_n i_core_dac_hard_7___Xi_core_u_trip 0.0235f
Ctic3440 fault_n_o__Xpad11_fault_n i_core_iptat__Xi_core_u_sense 0.0375f
Ctic3441 fault_n_o__Xpad11_fault_n i_core_isense 2.183f
Ctic3442 fault_n_o__Xpad11_fault_n i_core_osc_trim_0___Xi_core_u_osc 0.0225f
Ctic3443 fault_n_o__Xpad11_fault_n i_core_osc_trim_2___Xi_core_u_osc 0.0195f
Ctic3444 fault_n_o__Xpad11_fault_n i_core_t2f_en_33__Xi_core_u_t2f 0.017f
Ctic3445 fault_n_o__Xpad11_fault_n i_core_t2f_mode_33__Xi_core_u_t2f 0.0165f
Ctic3446 fault_n_o__Xpad11_fault_n i_core_tripped__retained_fullchip_sg13g2_antennanp_1027_200_891_000 0.193f
Ctic3447 fault_n_o__Xpad11_fault_n i_core_vref__Xi_core_u_sense 0.013f
Ctic3448 fault_n_o__Xpad11_fault_n i_core_vref_buf 0.057f
Ctic3450 fault_n_o__Xpad11_fault_n net__Xi_core_u_digital_1 0.0635f
Ctic3451 gate_o i_core_cmp_clk 1.677f
Ctic3452 gate_o i_core_cmp_hard 0.048f
Ctic3453 gate_o i_core_cmp_soft__retained_fullchip_sg13g2_antennanp_1021_440_891_000 0.0255f
Ctic3455 gate_o i_core_dac_hard_1_ 0.036f
Ctic3456 gate_o i_core_dac_hard_2_ 23.287f
Ctic3457 gate_o i_core_dac_hard_3_ 0.818f
Ctic3458 gate_o i_core_dac_hard_4_ 0.024f
Ctic3459 gate_o i_core_dac_hard_5_ 0.025f
Ctic3460 gate_o i_core_dac_hard_6_ 0.235f
Ctic3461 gate_o i_core_dac_hard_7_ 0.024f
Ctic3462 gate_o i_core_iptat__Xi_core_u_sense 0.422f
Ctic3463 gate_o i_core_isense 0.0145f
Ctic3464 gate_o i_core_osc_trim_0_ 0.0295f
Ctic3465 gate_o i_core_osc_trim_2_ 0.0305f
Ctic3466 gate_o i_core_t2f_en_33 0.0245f
Ctic3467 gate_o i_core_t2f_mode_33 0.0785f
Ctic3468 gate_o i_core_tripped__Xi_core_u_gate 0.9305f
Ctic3469 gate_o i_core_vref__Xi_core_u_sense 0.015f
Ctic3470 gate_o i_core_vref_buf 0.0815f
Ctic3471 gate_o net 0.1855f
Ctic3472 gate_o__Xpad10_gate i_core_cmp_clk__Xi_core_u_trip 1.677f
Ctic3473 gate_o__Xpad10_gate i_core_cmp_hard__Xi_core_u_trip 0.048f
Ctic3474 gate_o__Xpad10_gate i_core_cmp_soft__retained_fullchip_sg13g2_antennanp_1022_880_891_000 0.0255f
Ctic3476 gate_o__Xpad10_gate i_core_dac_hard_1___Xi_core_u_trip 0.036f
Ctic3477 gate_o__Xpad10_gate i_core_dac_hard_2___Xi_core_u_trip 23.287f
Ctic3478 gate_o__Xpad10_gate i_core_dac_hard_3___Xi_core_u_trip 0.818f
Ctic3479 gate_o__Xpad10_gate i_core_dac_hard_4___Xi_core_u_trip 0.024f
Ctic3480 gate_o__Xpad10_gate i_core_dac_hard_5___Xi_core_u_trip 0.025f
Ctic3481 gate_o__Xpad10_gate i_core_dac_hard_6___Xi_core_u_trip 0.235f
Ctic3482 gate_o__Xpad10_gate i_core_dac_hard_7___Xi_core_u_trip 0.024f
Ctic3483 gate_o__Xpad10_gate i_core_iptat__Xi_core_u_sense 0.422f
Ctic3484 gate_o__Xpad10_gate i_core_isense 0.0145f
Ctic3485 gate_o__Xpad10_gate i_core_osc_trim_0_ 0.0295f
Ctic3486 gate_o__Xpad10_gate i_core_osc_trim_2_ 0.0305f
Ctic3487 gate_o__Xpad10_gate i_core_t2f_en_33__Xi_core_u_t2f 0.0245f
Ctic3488 gate_o__Xpad10_gate i_core_t2f_mode_33__Xi_core_u_t2f 0.0785f
Ctic3489 gate_o__Xpad10_gate i_core_tripped__retained_fullchip_sg13g2_antennanp_1027_200_891_000 0.9305f
Ctic3490 gate_o__Xpad10_gate i_core_vref__Xi_core_u_sense 0.015f
Ctic3491 gate_o__Xpad10_gate i_core_vref_buf 0.0815f
Ctic3493 gate_o__Xpad10_gate net__Xi_core_u_digital_1 0.1855f
Ctic3494 i_core_bgr_r4_12 i_core_bgr_r4_33__Xi_core_u_ls_r4 0.0175f
Ctic3495 i_core_bgr_r4_12 i_core_clr_d 0.0285f
Ctic3496 i_core_bgr_r4_12 i_core_cmp_clk 0.0145f
Ctic3497 i_core_bgr_r4_12 i_core_cmp_hard 0.8075f
Ctic3498 i_core_bgr_r4_12 i_core_fast_en 1.32f
Ctic3499 i_core_bgr_r4_12 i_core_osc_clk 1.556f
Ctic3500 i_core_bgr_r4_12 i_core_osc_en 0.859f
Ctic3501 i_core_bgr_r4_12 i_core_osc_trim_1_ 0.0145f
Ctic3502 i_core_bgr_r4_12 i_core_osc_trim_3_ 2.748f
Ctic3503 i_core_bgr_r4_12 i_core_t2f_en_12 0.042f
Ctic3504 i_core_bgr_r4_12 i_core_t2f_en_33 0.025f
Ctic3505 i_core_bgr_r4_12 i_core_t2f_mode_12 0.6715f
Ctic3506 i_core_bgr_r4_12 i_core_trip_d 0.0135f
Ctic3507 i_core_bgr_r4_12 i_core_tripped 0.032f
Ctic3508 i_core_bgr_r4_12__Xi_core_u_ls_r4 i_core_bgr_r4_33__Xi_core_u_ls_r4 0.0175f
Ctic3509 i_core_bgr_r4_12__Xi_core_u_ls_r4 i_core_clr_d__Xi_core_u_gate 0.0285f
Ctic3510 i_core_bgr_r4_12__Xi_core_u_ls_r4 i_core_cmp_clk 0.0145f
Ctic3511 i_core_bgr_r4_12__Xi_core_u_ls_r4 i_core_cmp_hard__Xi_core_u_gate 0.8075f
Ctic3512 i_core_bgr_r4_12__Xi_core_u_ls_r4 i_core_fast_en__Xi_core_u_gate 1.32f
Ctic3513 i_core_bgr_r4_12__Xi_core_u_ls_r4 i_core_osc_clk 1.556f
Ctic3514 i_core_bgr_r4_12__Xi_core_u_ls_r4 i_core_osc_en 0.859f
Ctic3515 i_core_bgr_r4_12__Xi_core_u_ls_r4 i_core_osc_trim_1_ 0.0145f
Ctic3516 i_core_bgr_r4_12__Xi_core_u_ls_r4 i_core_osc_trim_3_ 2.748f
Ctic3517 i_core_bgr_r4_12__Xi_core_u_ls_r4 i_core_t2f_en_12__Xi_core_u_ls_en 0.042f
Ctic3518 i_core_bgr_r4_12__Xi_core_u_ls_r4 i_core_t2f_en_33 0.025f
Ctic3519 i_core_bgr_r4_12__Xi_core_u_ls_r4 i_core_t2f_mode_12__Xi_core_u_ls_mode 0.6715f
Ctic3520 i_core_bgr_r4_12__Xi_core_u_ls_r4 i_core_trip_d__Xi_core_u_gate 0.0135f
Ctic3521 i_core_bgr_r4_12__Xi_core_u_ls_r4 i_core_tripped 0.032f
Ctic3522 i_core_bgr_r4_33 i_core_clr_d 3.7715f
Ctic3523 i_core_bgr_r4_33 i_core_cmp_clk__Xi_core_u_trip 0.0135f
Ctic3524 i_core_bgr_r4_33 i_core_cmp_hard__Xi_core_u_trip 0.012f
Ctic3525 i_core_bgr_r4_33 i_core_cmp_soft__Xi_core_u_trip 0.0105f
Ctic3526 i_core_bgr_r4_33 i_core_dac_hard_0_ 0.0135f
Ctic3527 i_core_bgr_r4_33 i_core_dac_hard_1_ 0.0105f
Ctic3528 i_core_bgr_r4_33 i_core_dac_hard_2_ 0.0105f
Ctic3529 i_core_bgr_r4_33 i_core_dac_hard_3_ 0.435f
Ctic3530 i_core_bgr_r4_33 i_core_dac_hard_4_ 0.0095f
Ctic3531 i_core_bgr_r4_33 i_core_dac_hard_5_ 0.0145f
Ctic3532 i_core_bgr_r4_33 i_core_dac_hard_6_ 0.016f
Ctic3533 i_core_bgr_r4_33 i_core_dac_hard_7_ 0.0185f
Ctic3534 i_core_bgr_r4_33 i_core_dac_soft_0___Xi_core_u_trip 0.0115f
Ctic3535 i_core_bgr_r4_33 i_core_dac_soft_1___Xi_core_u_trip 0.497f
Ctic3536 i_core_bgr_r4_33 i_core_dac_soft_2___Xi_core_u_trip 0.012f
Ctic3537 i_core_bgr_r4_33 i_core_dac_soft_3___Xi_core_u_trip 0.0095f
Ctic3538 i_core_bgr_r4_33 i_core_dac_soft_4___Xi_core_u_trip 0.0135f
Ctic3539 i_core_bgr_r4_33 i_core_dac_soft_5___Xi_core_u_trip 0.0125f
Ctic3540 i_core_bgr_r4_33 i_core_dac_soft_6___Xi_core_u_trip 0.0105f
Ctic3541 i_core_bgr_r4_33 i_core_dac_soft_7___Xi_core_u_trip 0.0105f
Ctic3542 i_core_bgr_r4_33 i_core_dvbe__Xi_core_u_bgr 0.0005f
Ctic3543 i_core_bgr_r4_33 i_core_fast_en 0.01f
Ctic3544 i_core_bgr_r4_33 i_core_iptat 0.019f
Ctic3545 i_core_bgr_r4_33 i_core_osc_clk__Xi_core_u_osc 0.7775f
Ctic3546 i_core_bgr_r4_33 i_core_osc_en__Xi_core_u_osc 0.045f
Ctic3547 i_core_bgr_r4_33 i_core_osc_trim_0___Xi_core_u_osc 0.604f
Ctic3548 i_core_bgr_r4_33 i_core_osc_trim_1___Xi_core_u_osc 1.0735f
Ctic3549 i_core_bgr_r4_33 i_core_osc_trim_2___Xi_core_u_osc 0.014f
Ctic3550 i_core_bgr_r4_33 i_core_osc_trim_3___Xi_core_u_osc 0.0355f
Ctic3551 i_core_bgr_r4_33 i_core_pbias 0.0155f
Ctic3552 i_core_bgr_r4_33 i_core_pcasc 0.233f
Ctic3553 i_core_bgr_r4_33 i_core_sdo_o 0.227f
Ctic3554 i_core_bgr_r4_33 i_core_t2f_en_12 0.0755f
Ctic3555 i_core_bgr_r4_33 i_core_t2f_en_33__Xi_core_u_t2f 0.191f
Ctic3556 i_core_bgr_r4_33 i_core_t2f_mode_12 0.255f
Ctic3557 i_core_bgr_r4_33 i_core_trip_d 0.0195f
Ctic3558 i_core_bgr_r4_33 i_core_tripped__Xi_core_u_gate 0.0365f
Ctic3559 i_core_bgr_r4_33 i_core_vref 0.5f
Ctic3560 i_core_bgr_r4_33 net 0.077f
Ctic3561 i_core_bgr_r4_33__Xi_core_u_ls_r4 i_core_clr_d__Xi_core_u_gate 3.7715f
Ctic3562 i_core_bgr_r4_33__Xi_core_u_ls_r4 i_core_cmp_clk 0.0135f
Ctic3563 i_core_bgr_r4_33__Xi_core_u_ls_r4 i_core_cmp_hard__Xi_core_u_gate 0.012f
Ctic3564 i_core_bgr_r4_33__Xi_core_u_ls_r4 i_core_cmp_soft 0.0105f
Ctic3565 i_core_bgr_r4_33__Xi_core_u_ls_r4 i_core_dac_hard_0_ 0.0135f
Ctic3566 i_core_bgr_r4_33__Xi_core_u_ls_r4 i_core_dac_hard_1_ 0.0105f
Ctic3567 i_core_bgr_r4_33__Xi_core_u_ls_r4 i_core_dac_hard_2_ 0.0105f
Ctic3568 i_core_bgr_r4_33__Xi_core_u_ls_r4 i_core_dac_hard_3_ 0.435f
Ctic3569 i_core_bgr_r4_33__Xi_core_u_ls_r4 i_core_dac_hard_4_ 0.0095f
Ctic3570 i_core_bgr_r4_33__Xi_core_u_ls_r4 i_core_dac_hard_5_ 0.0145f
Ctic3571 i_core_bgr_r4_33__Xi_core_u_ls_r4 i_core_dac_hard_6_ 0.016f
Ctic3572 i_core_bgr_r4_33__Xi_core_u_ls_r4 i_core_dac_hard_7_ 0.0185f
Ctic3573 i_core_bgr_r4_33__Xi_core_u_ls_r4 i_core_dac_soft_0___Xi_core_u_trip 0.0115f
Ctic3574 i_core_bgr_r4_33__Xi_core_u_ls_r4 i_core_dac_soft_1___Xi_core_u_trip 0.497f
Ctic3575 i_core_bgr_r4_33__Xi_core_u_ls_r4 i_core_dac_soft_2___Xi_core_u_trip 0.012f
Ctic3576 i_core_bgr_r4_33__Xi_core_u_ls_r4 i_core_dac_soft_3___Xi_core_u_trip 0.0095f
Ctic3577 i_core_bgr_r4_33__Xi_core_u_ls_r4 i_core_dac_soft_4___Xi_core_u_trip 0.0135f
Ctic3578 i_core_bgr_r4_33__Xi_core_u_ls_r4 i_core_dac_soft_5___Xi_core_u_trip 0.0125f
Ctic3579 i_core_bgr_r4_33__Xi_core_u_ls_r4 i_core_dac_soft_6___Xi_core_u_trip 0.0105f
Ctic3580 i_core_bgr_r4_33__Xi_core_u_ls_r4 i_core_dac_soft_7___Xi_core_u_trip 0.0105f
Ctic3581 i_core_bgr_r4_33__Xi_core_u_ls_r4 i_core_dvbe__Xi_core_u_bgr 0.0005f
Ctic3582 i_core_bgr_r4_33__Xi_core_u_ls_r4 i_core_fast_en__Xi_core_u_gate 0.01f
Ctic3583 i_core_bgr_r4_33__Xi_core_u_ls_r4 i_core_iptat__Xi_core_u_sense 0.019f
Ctic3584 i_core_bgr_r4_33__Xi_core_u_ls_r4 i_core_osc_clk 0.7775f
Ctic3585 i_core_bgr_r4_33__Xi_core_u_ls_r4 i_core_osc_en 0.045f
Ctic3586 i_core_bgr_r4_33__Xi_core_u_ls_r4 i_core_osc_trim_0_ 0.604f
Ctic3587 i_core_bgr_r4_33__Xi_core_u_ls_r4 i_core_osc_trim_1_ 1.0735f
Ctic3588 i_core_bgr_r4_33__Xi_core_u_ls_r4 i_core_osc_trim_2_ 0.014f
Ctic3589 i_core_bgr_r4_33__Xi_core_u_ls_r4 i_core_osc_trim_3_ 0.0355f
Ctic3590 i_core_bgr_r4_33__Xi_core_u_ls_r4 i_core_pbias 0.0155f
Ctic3591 i_core_bgr_r4_33__Xi_core_u_ls_r4 i_core_pcasc 0.233f
Ctic3592 i_core_bgr_r4_33__Xi_core_u_ls_r4 i_core_sdo_o 0.227f
Ctic3593 i_core_bgr_r4_33__Xi_core_u_ls_r4 i_core_t2f_en_12__Xi_core_u_ls_en 0.0755f
Ctic3594 i_core_bgr_r4_33__Xi_core_u_ls_r4 i_core_t2f_en_33 0.191f
Ctic3595 i_core_bgr_r4_33__Xi_core_u_ls_r4 i_core_t2f_mode_12__Xi_core_u_ls_mode 0.255f
Ctic3596 i_core_bgr_r4_33__Xi_core_u_ls_r4 i_core_trip_d__Xi_core_u_gate 0.0195f
Ctic3597 i_core_bgr_r4_33__Xi_core_u_ls_r4 i_core_tripped 0.0365f
Ctic3598 i_core_bgr_r4_33__Xi_core_u_ls_r4 i_core_vref__Xi_core_u_sense 0.5f
Ctic3599 i_core_bgr_r4_33__Xi_core_u_ls_r4 net 0.077f
Ctic3600 i_core_clr_d i_core_cmp_clk 0.0145f
Ctic3601 i_core_clr_d i_core_cmp_hard 0.034f
Ctic3602 i_core_clr_d i_core_fast_en 0.4905f
Ctic3603 i_core_clr_d i_core_osc_clk 0.0085f
Ctic3604 i_core_clr_d i_core_osc_en 0.0125f
Ctic3605 i_core_clr_d i_core_osc_trim_1_ 2.088f
Ctic3606 i_core_clr_d i_core_osc_trim_3_ 0.0095f
Ctic3607 i_core_clr_d i_core_t2f_en_12 0.0395f
Ctic3608 i_core_clr_d i_core_t2f_mode_12 0.126f
Ctic3609 i_core_clr_d i_core_trip_d 4.654f
Ctic3610 i_core_clr_d i_core_tripped 0.0115f
Ctic3611 i_core_clr_d__Xi_core_u_gate i_core_cmp_clk 0.0145f
Ctic3612 i_core_clr_d__Xi_core_u_gate i_core_cmp_hard__Xi_core_u_gate 0.034f
Ctic3613 i_core_clr_d__Xi_core_u_gate i_core_fast_en__Xi_core_u_gate 0.4905f
Ctic3614 i_core_clr_d__Xi_core_u_gate i_core_osc_clk 0.0085f
Ctic3615 i_core_clr_d__Xi_core_u_gate i_core_osc_en 0.0125f
Ctic3616 i_core_clr_d__Xi_core_u_gate i_core_osc_trim_1_ 2.088f
Ctic3617 i_core_clr_d__Xi_core_u_gate i_core_osc_trim_3_ 0.0095f
Ctic3618 i_core_clr_d__Xi_core_u_gate i_core_t2f_en_12__Xi_core_u_ls_en 0.0395f
Ctic3619 i_core_clr_d__Xi_core_u_gate i_core_t2f_mode_12__Xi_core_u_ls_mode 0.126f
Ctic3620 i_core_clr_d__Xi_core_u_gate i_core_trip_d__Xi_core_u_gate 4.654f
Ctic3621 i_core_clr_d__Xi_core_u_gate i_core_tripped 0.0115f
Ctic3622 i_core_cmp_clk i_core_cmp_hard 20.4895f
Ctic3623 i_core_cmp_clk i_core_cmp_soft 0.1145f
Ctic3624 i_core_cmp_clk i_core_dac_hard_0_ 0.003f
Ctic3625 i_core_cmp_clk i_core_dac_hard_1_ 0.04f
Ctic3626 i_core_cmp_clk i_core_dac_hard_2_ 0.001f
Ctic3627 i_core_cmp_clk i_core_dac_hard_3_ 0.002f
Ctic3628 i_core_cmp_clk i_core_dac_hard_4_ 0.0095f
Ctic3629 i_core_cmp_clk i_core_dac_hard_5_ 8.6745f
Ctic3630 i_core_cmp_clk i_core_dac_hard_6_ 0.013f
Ctic3631 i_core_cmp_clk i_core_dac_hard_7_ 10.505f
Ctic3632 i_core_cmp_clk i_core_fast_en 0.0345f
Ctic3633 i_core_cmp_clk i_core_iptat__Xi_core_u_sense 0.0115f
Ctic3634 i_core_cmp_clk i_core_isense 0.0105f
Ctic3635 i_core_cmp_clk i_core_osc_clk 0.0135f
Ctic3636 i_core_cmp_clk i_core_osc_en 0.0665f
Ctic3638 i_core_cmp_clk i_core_osc_trim_3_ 0.002f
Ctic3639 i_core_cmp_clk i_core_t2f_en_12 0.007f
Ctic3640 i_core_cmp_clk i_core_t2f_en_33 0.442f
Ctic3641 i_core_cmp_clk i_core_t2f_mode_12 0.0015f
Ctic3642 i_core_cmp_clk i_core_t2f_mode_33 0.103f
Ctic3643 i_core_cmp_clk i_core_trip_d 0.0145f
Ctic3644 i_core_cmp_clk i_core_tripped 0.1465f
Ctic3645 i_core_cmp_clk i_core_vref__Xi_core_u_sense 0.013f
Ctic3646 i_core_cmp_clk i_core_vref_buf 0.0135f
Ctic3647 i_core_cmp_clk net 0.5265f
Ctic3648 i_core_cmp_clk__Xi_core_u_trip i_core_cmp_hard__Xi_core_u_trip 20.4895f
Ctic3649 i_core_cmp_clk__Xi_core_u_trip i_core_cmp_soft__Xi_core_u_trip 0.1145f
Ctic3650 i_core_cmp_clk__Xi_core_u_trip i_core_dac_hard_0___Xi_core_u_trip 0.003f
Ctic3651 i_core_cmp_clk__Xi_core_u_trip i_core_dac_hard_1___Xi_core_u_trip 0.04f
Ctic3652 i_core_cmp_clk__Xi_core_u_trip i_core_dac_hard_2___Xi_core_u_trip 0.001f
Ctic3653 i_core_cmp_clk__Xi_core_u_trip i_core_dac_hard_3___Xi_core_u_trip 0.002f
Ctic3654 i_core_cmp_clk__Xi_core_u_trip i_core_dac_hard_4___Xi_core_u_trip 0.0095f
Ctic3655 i_core_cmp_clk__Xi_core_u_trip i_core_dac_hard_5___Xi_core_u_trip 8.6745f
Ctic3656 i_core_cmp_clk__Xi_core_u_trip i_core_dac_hard_6___Xi_core_u_trip 0.013f
Ctic3657 i_core_cmp_clk__Xi_core_u_trip i_core_dac_hard_7___Xi_core_u_trip 10.505f
Ctic3658 i_core_cmp_clk__Xi_core_u_trip i_core_fast_en__Xi_core_u_gate 0.0345f
Ctic3659 i_core_cmp_clk__Xi_core_u_trip i_core_iptat 0.0115f
Ctic3660 i_core_cmp_clk__Xi_core_u_trip i_core_isense__Xi_core_u_trip 0.0105f
Ctic3661 i_core_cmp_clk__Xi_core_u_trip i_core_osc_clk__Xi_core_u_osc 0.0135f
Ctic3662 i_core_cmp_clk__Xi_core_u_trip i_core_osc_en__Xi_core_u_osc 0.0665f
Ctic3664 i_core_cmp_clk__Xi_core_u_trip i_core_osc_trim_3___Xi_core_u_osc 0.002f
Ctic3665 i_core_cmp_clk__Xi_core_u_trip i_core_t2f_en_12 0.007f
Ctic3666 i_core_cmp_clk__Xi_core_u_trip i_core_t2f_en_33__Xi_core_u_t2f 0.442f
Ctic3667 i_core_cmp_clk__Xi_core_u_trip i_core_t2f_mode_12 0.0015f
Ctic3668 i_core_cmp_clk__Xi_core_u_trip i_core_t2f_mode_33__Xi_core_u_t2f 0.103f
Ctic3669 i_core_cmp_clk__Xi_core_u_trip i_core_trip_d 0.0145f
Ctic3670 i_core_cmp_clk__Xi_core_u_trip i_core_tripped__retained_fullchip_sg13g2_antennanp_1027_200_891_000 0.1465f
Ctic3671 i_core_cmp_clk__Xi_core_u_trip i_core_vref__Xpad18_vref 0.013f
Ctic3672 i_core_cmp_clk__Xi_core_u_trip i_core_vref_buf__Xi_core_u_trip 0.0135f
Ctic3673 i_core_cmp_clk__Xi_core_u_trip net__Xi_core_u_digital_1 0.5265f
Ctic3674 i_core_cmp_hard i_core_cmp_soft 0.245f
Ctic3675 i_core_cmp_hard i_core_dac_hard_0_ 0.001f
Ctic3676 i_core_cmp_hard i_core_dac_hard_1_ 0.005f
Ctic3677 i_core_cmp_hard i_core_dac_hard_2_ 0.000333333f
Ctic3678 i_core_cmp_hard i_core_dac_hard_3_ 15.698f
Ctic3679 i_core_cmp_hard i_core_dac_hard_4_ 0.347667f
Ctic3680 i_core_cmp_hard i_core_dac_hard_5_ 0.015f
Ctic3681 i_core_cmp_hard i_core_dac_hard_6_ 0.002f
Ctic3682 i_core_cmp_hard i_core_dac_hard_7_ 0.0176667f
Ctic3683 i_core_cmp_hard i_core_fast_en 0.099f
Ctic3684 i_core_cmp_hard i_core_iptat__Xi_core_u_sense 0.00633333f
Ctic3685 i_core_cmp_hard i_core_isense 0.00533333f
Ctic3686 i_core_cmp_hard i_core_osc_clk 0.008f
Ctic3687 i_core_cmp_hard i_core_osc_en 0.542667f
Ctic3688 i_core_cmp_hard i_core_osc_trim_1_ 0.0216667f
Ctic3689 i_core_cmp_hard i_core_osc_trim_3_ 0.01f
Ctic3690 i_core_cmp_hard i_core_t2f_en_12 0.00966667f
Ctic3691 i_core_cmp_hard i_core_t2f_en_33 0.00833333f
Ctic3692 i_core_cmp_hard i_core_t2f_mode_12 0.011f
Ctic3693 i_core_cmp_hard i_core_t2f_mode_33 0.001f
Ctic3694 i_core_cmp_hard i_core_trip_d 0.213f
Ctic3695 i_core_cmp_hard i_core_tripped 15.772f
Ctic3696 i_core_cmp_hard i_core_vref__Xi_core_u_sense 0.0103333f
Ctic3697 i_core_cmp_hard i_core_vref_buf 0.008f
Ctic3698 i_core_cmp_hard net 0.0223333f
Ctic3699 i_core_cmp_hard__Xi_core_u_gate i_core_cmp_soft 0.245f
Ctic3700 i_core_cmp_hard__Xi_core_u_gate i_core_dac_hard_0_ 0.001f
Ctic3701 i_core_cmp_hard__Xi_core_u_gate i_core_dac_hard_1_ 0.005f
Ctic3702 i_core_cmp_hard__Xi_core_u_gate i_core_dac_hard_2_ 0.000333333f
Ctic3703 i_core_cmp_hard__Xi_core_u_gate i_core_dac_hard_3_ 15.698f
Ctic3704 i_core_cmp_hard__Xi_core_u_gate i_core_dac_hard_4_ 0.347667f
Ctic3705 i_core_cmp_hard__Xi_core_u_gate i_core_dac_hard_5_ 0.015f
Ctic3706 i_core_cmp_hard__Xi_core_u_gate i_core_dac_hard_6_ 0.002f
Ctic3707 i_core_cmp_hard__Xi_core_u_gate i_core_dac_hard_7_ 0.0176667f
Ctic3708 i_core_cmp_hard__Xi_core_u_gate i_core_fast_en__Xi_core_u_gate 0.099f
Ctic3709 i_core_cmp_hard__Xi_core_u_gate i_core_iptat__Xi_core_u_sense 0.00633333f
Ctic3710 i_core_cmp_hard__Xi_core_u_gate i_core_isense 0.00533333f
Ctic3711 i_core_cmp_hard__Xi_core_u_gate i_core_osc_clk 0.008f
Ctic3712 i_core_cmp_hard__Xi_core_u_gate i_core_osc_en 0.542667f
Ctic3713 i_core_cmp_hard__Xi_core_u_gate i_core_osc_trim_1_ 0.0216667f
Ctic3714 i_core_cmp_hard__Xi_core_u_gate i_core_osc_trim_3_ 0.01f
Ctic3715 i_core_cmp_hard__Xi_core_u_gate i_core_t2f_en_12__Xi_core_u_ls_en 0.00966667f
Ctic3716 i_core_cmp_hard__Xi_core_u_gate i_core_t2f_en_33 0.00833333f
Ctic3717 i_core_cmp_hard__Xi_core_u_gate i_core_t2f_mode_12__Xi_core_u_ls_mode 0.011f
Ctic3718 i_core_cmp_hard__Xi_core_u_gate i_core_t2f_mode_33 0.001f
Ctic3719 i_core_cmp_hard__Xi_core_u_gate i_core_trip_d__Xi_core_u_gate 0.213f
Ctic3720 i_core_cmp_hard__Xi_core_u_gate i_core_tripped 15.772f
Ctic3721 i_core_cmp_hard__Xi_core_u_gate i_core_vref__Xi_core_u_sense 0.0103333f
Ctic3722 i_core_cmp_hard__Xi_core_u_gate i_core_vref_buf 0.008f
Ctic3723 i_core_cmp_hard__Xi_core_u_gate net 0.0223333f
Ctic3724 i_core_cmp_hard__Xi_core_u_trip i_core_cmp_soft__Xi_core_u_trip 0.245f
Ctic3725 i_core_cmp_hard__Xi_core_u_trip i_core_dac_hard_0___Xi_core_u_trip 0.001f
Ctic3726 i_core_cmp_hard__Xi_core_u_trip i_core_dac_hard_1___Xi_core_u_trip 0.005f
Ctic3727 i_core_cmp_hard__Xi_core_u_trip i_core_dac_hard_2___Xi_core_u_trip 0.000333333f
Ctic3728 i_core_cmp_hard__Xi_core_u_trip i_core_dac_hard_3___Xi_core_u_trip 15.698f
Ctic3729 i_core_cmp_hard__Xi_core_u_trip i_core_dac_hard_4___Xi_core_u_trip 0.347667f
Ctic3730 i_core_cmp_hard__Xi_core_u_trip i_core_dac_hard_5___Xi_core_u_trip 0.015f
Ctic3731 i_core_cmp_hard__Xi_core_u_trip i_core_dac_hard_6___Xi_core_u_trip 0.002f
Ctic3732 i_core_cmp_hard__Xi_core_u_trip i_core_dac_hard_7___Xi_core_u_trip 0.0176667f
Ctic3733 i_core_cmp_hard__Xi_core_u_trip i_core_fast_en__Xi_core_u_gate 0.099f
Ctic3734 i_core_cmp_hard__Xi_core_u_trip i_core_iptat 0.00633333f
Ctic3735 i_core_cmp_hard__Xi_core_u_trip i_core_isense__Xi_core_u_trip 0.00533333f
Ctic3736 i_core_cmp_hard__Xi_core_u_trip i_core_osc_clk__Xi_core_u_osc 0.008f
Ctic3737 i_core_cmp_hard__Xi_core_u_trip i_core_osc_en__Xi_core_u_osc 0.542667f
Ctic3738 i_core_cmp_hard__Xi_core_u_trip i_core_osc_trim_1___Xi_core_u_osc 0.0216667f
Ctic3739 i_core_cmp_hard__Xi_core_u_trip i_core_osc_trim_3___Xi_core_u_osc 0.01f
Ctic3740 i_core_cmp_hard__Xi_core_u_trip i_core_t2f_en_12 0.00966667f
Ctic3741 i_core_cmp_hard__Xi_core_u_trip i_core_t2f_en_33__Xi_core_u_t2f 0.00833333f
Ctic3742 i_core_cmp_hard__Xi_core_u_trip i_core_t2f_mode_12 0.011f
Ctic3743 i_core_cmp_hard__Xi_core_u_trip i_core_t2f_mode_33__Xi_core_u_t2f 0.001f
Ctic3744 i_core_cmp_hard__Xi_core_u_trip i_core_trip_d 0.213f
Ctic3745 i_core_cmp_hard__Xi_core_u_trip i_core_tripped__retained_fullchip_sg13g2_antennanp_1027_200_891_000 15.772f
Ctic3746 i_core_cmp_hard__Xi_core_u_trip i_core_vref__Xpad18_vref 0.0103333f
Ctic3747 i_core_cmp_hard__Xi_core_u_trip i_core_vref_buf__Xi_core_u_trip 0.008f
Ctic3748 i_core_cmp_hard__Xi_core_u_trip net__Xi_core_u_digital_1 0.0223333f
Ctic3749 i_core_cmp_soft i_core_dac_hard_0_ 20.9232f
Ctic3750 i_core_cmp_soft i_core_dac_hard_1_ 21.01f
Ctic3751 i_core_cmp_soft i_core_dac_hard_2_ 0.02375f
Ctic3752 i_core_cmp_soft i_core_dac_hard_3_ 0.00375f
Ctic3753 i_core_cmp_soft i_core_dac_hard_4_ 0.004f
Ctic3754 i_core_cmp_soft i_core_dac_hard_5_ 0.00475f
Ctic3755 i_core_cmp_soft i_core_dac_hard_6_ 0.03125f
Ctic3756 i_core_cmp_soft i_core_dac_hard_7_ 0.076f
Ctic3757 i_core_cmp_soft i_core_dac_soft_0_ 0.01775f
Ctic3758 i_core_cmp_soft i_core_dac_soft_1_ 0.13925f
Ctic3759 i_core_cmp_soft i_core_dac_soft_2_ 0.2035f
Ctic3760 i_core_cmp_soft i_core_dac_soft_3_ 0.194f
Ctic3761 i_core_cmp_soft i_core_dac_soft_4_ 0.00925f
Ctic3762 i_core_cmp_soft i_core_dac_soft_5_ 0.0035f
Ctic3763 i_core_cmp_soft i_core_dac_soft_6_ 0.01575f
Ctic3764 i_core_cmp_soft i_core_dac_soft_7_ 0.00275f
Ctic3765 i_core_cmp_soft i_core_iptat 0.00575f
Ctic3766 i_core_cmp_soft i_core_isense 0.0065f
Ctic3767 i_core_cmp_soft i_core_osc_clk 0.005f
Ctic3768 i_core_cmp_soft i_core_osc_en 0.0035f
Ctic3769 i_core_cmp_soft i_core_osc_trim_0_ 0.00275f
Ctic3770 i_core_cmp_soft i_core_osc_trim_1_ 0.00275f
Ctic3771 i_core_cmp_soft i_core_osc_trim_2_ 0.006f
Ctic3772 i_core_cmp_soft i_core_osc_trim_3_ 0.00275f
Ctic3773 i_core_cmp_soft i_core_sclk_i 13.1783f
Ctic3774 i_core_cmp_soft i_core_sdi_i 1.2645f
Ctic3775 i_core_cmp_soft i_core_sdo_o 0.0125f
Ctic3776 i_core_cmp_soft i_core_tripped 0.0025f
Ctic3777 i_core_cmp_soft i_core_vref 0.0045f
Ctic3778 i_core_cmp_soft i_core_vref_buf 0.0525f
Ctic3779 i_core_cmp_soft__Xi_core_u_trip i_core_dac_hard_0___Xi_core_u_trip 20.9232f
Ctic3780 i_core_cmp_soft__Xi_core_u_trip i_core_dac_hard_1___Xi_core_u_trip 21.01f
Ctic3781 i_core_cmp_soft__Xi_core_u_trip i_core_dac_hard_2___Xi_core_u_trip 0.02375f
Ctic3782 i_core_cmp_soft__Xi_core_u_trip i_core_dac_hard_3___Xi_core_u_trip 0.00375f
Ctic3783 i_core_cmp_soft__Xi_core_u_trip i_core_dac_hard_4___Xi_core_u_trip 0.004f
Ctic3784 i_core_cmp_soft__Xi_core_u_trip i_core_dac_hard_5___Xi_core_u_trip 0.00475f
Ctic3785 i_core_cmp_soft__Xi_core_u_trip i_core_dac_hard_6___Xi_core_u_trip 0.03125f
Ctic3786 i_core_cmp_soft__Xi_core_u_trip i_core_dac_hard_7___Xi_core_u_trip 0.076f
Ctic3787 i_core_cmp_soft__Xi_core_u_trip i_core_dac_soft_0___Xi_core_u_trip 0.01775f
Ctic3788 i_core_cmp_soft__Xi_core_u_trip i_core_dac_soft_1___Xi_core_u_trip 0.13925f
Ctic3789 i_core_cmp_soft__Xi_core_u_trip i_core_dac_soft_2___Xi_core_u_trip 0.2035f
Ctic3790 i_core_cmp_soft__Xi_core_u_trip i_core_dac_soft_3___Xi_core_u_trip 0.194f
Ctic3791 i_core_cmp_soft__Xi_core_u_trip i_core_dac_soft_4___Xi_core_u_trip 0.00925f
Ctic3792 i_core_cmp_soft__Xi_core_u_trip i_core_dac_soft_5___Xi_core_u_trip 0.0035f
Ctic3793 i_core_cmp_soft__Xi_core_u_trip i_core_dac_soft_6___Xi_core_u_trip 0.01575f
Ctic3794 i_core_cmp_soft__Xi_core_u_trip i_core_dac_soft_7___Xi_core_u_trip 0.00275f
Ctic3795 i_core_cmp_soft__Xi_core_u_trip i_core_iptat 0.00575f
Ctic3796 i_core_cmp_soft__Xi_core_u_trip i_core_isense__Xi_core_u_trip 0.0065f
Ctic3797 i_core_cmp_soft__Xi_core_u_trip i_core_osc_clk__Xi_core_u_osc 0.005f
Ctic3798 i_core_cmp_soft__Xi_core_u_trip i_core_osc_en__Xi_core_u_osc 0.0035f
Ctic3799 i_core_cmp_soft__Xi_core_u_trip i_core_osc_trim_0___Xi_core_u_osc 0.00275f
Ctic3800 i_core_cmp_soft__Xi_core_u_trip i_core_osc_trim_1___Xi_core_u_osc 0.00275f
Ctic3801 i_core_cmp_soft__Xi_core_u_trip i_core_osc_trim_2___Xi_core_u_osc 0.006f
Ctic3802 i_core_cmp_soft__Xi_core_u_trip i_core_osc_trim_3___Xi_core_u_osc 0.00275f
Ctic3803 i_core_cmp_soft__Xi_core_u_trip i_core_sclk_i 13.1783f
Ctic3804 i_core_cmp_soft__Xi_core_u_trip i_core_sdi_i__retained_fullchip_sg13g2_antennanp_1024_320_891_000 1.2645f
Ctic3805 i_core_cmp_soft__Xi_core_u_trip i_core_sdo_o__Xpad16_sdo 0.0125f
Ctic3806 i_core_cmp_soft__Xi_core_u_trip i_core_tripped__retained_fullchip_sg13g2_antennanp_1027_200_891_000 0.0025f
Ctic3807 i_core_cmp_soft__Xi_core_u_trip i_core_vref__Xpad18_vref 0.0045f
Ctic3808 i_core_cmp_soft__Xi_core_u_trip i_core_vref_buf__Xi_core_u_trip 0.0525f
Ctic3809 i_core_cmp_soft__retained_fullchip_sg13g2_antennanp_1021_440_891_000 i_core_dac_hard_0___Xi_core_u_trip 20.9232f
Ctic3810 i_core_cmp_soft__retained_fullchip_sg13g2_antennanp_1021_440_891_000 i_core_dac_hard_1___Xi_core_u_trip 21.01f
Ctic3811 i_core_cmp_soft__retained_fullchip_sg13g2_antennanp_1021_440_891_000 i_core_dac_hard_2___Xi_core_u_trip 0.02375f
Ctic3812 i_core_cmp_soft__retained_fullchip_sg13g2_antennanp_1021_440_891_000 i_core_dac_hard_3___Xi_core_u_trip 0.00375f
Ctic3813 i_core_cmp_soft__retained_fullchip_sg13g2_antennanp_1021_440_891_000 i_core_dac_hard_4___Xi_core_u_trip 0.004f
Ctic3814 i_core_cmp_soft__retained_fullchip_sg13g2_antennanp_1021_440_891_000 i_core_dac_hard_5___Xi_core_u_trip 0.00475f
Ctic3815 i_core_cmp_soft__retained_fullchip_sg13g2_antennanp_1021_440_891_000 i_core_dac_hard_6___Xi_core_u_trip 0.03125f
Ctic3816 i_core_cmp_soft__retained_fullchip_sg13g2_antennanp_1021_440_891_000 i_core_dac_hard_7___Xi_core_u_trip 0.076f
Ctic3817 i_core_cmp_soft__retained_fullchip_sg13g2_antennanp_1021_440_891_000 i_core_dac_soft_0___Xi_core_u_trip 0.01775f
Ctic3818 i_core_cmp_soft__retained_fullchip_sg13g2_antennanp_1021_440_891_000 i_core_dac_soft_1___Xi_core_u_trip 0.13925f
Ctic3819 i_core_cmp_soft__retained_fullchip_sg13g2_antennanp_1021_440_891_000 i_core_dac_soft_2___Xi_core_u_trip 0.2035f
Ctic3820 i_core_cmp_soft__retained_fullchip_sg13g2_antennanp_1021_440_891_000 i_core_dac_soft_3___Xi_core_u_trip 0.194f
Ctic3821 i_core_cmp_soft__retained_fullchip_sg13g2_antennanp_1021_440_891_000 i_core_dac_soft_4___Xi_core_u_trip 0.00925f
Ctic3822 i_core_cmp_soft__retained_fullchip_sg13g2_antennanp_1021_440_891_000 i_core_dac_soft_5___Xi_core_u_trip 0.0035f
Ctic3823 i_core_cmp_soft__retained_fullchip_sg13g2_antennanp_1021_440_891_000 i_core_dac_soft_6___Xi_core_u_trip 0.01575f
Ctic3824 i_core_cmp_soft__retained_fullchip_sg13g2_antennanp_1021_440_891_000 i_core_dac_soft_7___Xi_core_u_trip 0.00275f
Ctic3825 i_core_cmp_soft__retained_fullchip_sg13g2_antennanp_1021_440_891_000 i_core_iptat__Xi_core_u_sense 0.00575f
Ctic3826 i_core_cmp_soft__retained_fullchip_sg13g2_antennanp_1021_440_891_000 i_core_isense 0.0065f
Ctic3827 i_core_cmp_soft__retained_fullchip_sg13g2_antennanp_1021_440_891_000 i_core_osc_clk__Xi_core_u_osc 0.005f
Ctic3828 i_core_cmp_soft__retained_fullchip_sg13g2_antennanp_1021_440_891_000 i_core_osc_en__Xi_core_u_osc 0.0035f
Ctic3829 i_core_cmp_soft__retained_fullchip_sg13g2_antennanp_1021_440_891_000 i_core_osc_trim_0___Xi_core_u_osc 0.00275f
Ctic3830 i_core_cmp_soft__retained_fullchip_sg13g2_antennanp_1021_440_891_000 i_core_osc_trim_1___Xi_core_u_osc 0.00275f
Ctic3831 i_core_cmp_soft__retained_fullchip_sg13g2_antennanp_1021_440_891_000 i_core_osc_trim_2___Xi_core_u_osc 0.006f
Ctic3832 i_core_cmp_soft__retained_fullchip_sg13g2_antennanp_1021_440_891_000 i_core_osc_trim_3___Xi_core_u_osc 0.00275f
Ctic3833 i_core_cmp_soft__retained_fullchip_sg13g2_antennanp_1021_440_891_000 i_core_sclk_i 13.1783f
Ctic3834 i_core_cmp_soft__retained_fullchip_sg13g2_antennanp_1021_440_891_000 i_core_sdi_i__retained_fullchip_sg13g2_antennanp_1024_320_891_000 1.2645f
Ctic3835 i_core_cmp_soft__retained_fullchip_sg13g2_antennanp_1021_440_891_000 i_core_sdo_o__Xpad16_sdo 0.0125f
Ctic3836 i_core_cmp_soft__retained_fullchip_sg13g2_antennanp_1021_440_891_000 i_core_tripped__retained_fullchip_sg13g2_antennanp_1027_200_891_000 0.0025f
Ctic3837 i_core_cmp_soft__retained_fullchip_sg13g2_antennanp_1021_440_891_000 i_core_vref__Xpad18_vref 0.0045f
Ctic3838 i_core_cmp_soft__retained_fullchip_sg13g2_antennanp_1021_440_891_000 i_core_vref_buf 0.0525f
Ctic3839 i_core_cmp_soft__retained_fullchip_sg13g2_antennanp_1022_880_891_000 i_core_dac_hard_0___Xi_core_u_trip 20.9232f
Ctic3840 i_core_cmp_soft__retained_fullchip_sg13g2_antennanp_1022_880_891_000 i_core_dac_hard_1___Xi_core_u_trip 21.01f
Ctic3841 i_core_cmp_soft__retained_fullchip_sg13g2_antennanp_1022_880_891_000 i_core_dac_hard_2___Xi_core_u_trip 0.02375f
Ctic3842 i_core_cmp_soft__retained_fullchip_sg13g2_antennanp_1022_880_891_000 i_core_dac_hard_3___Xi_core_u_trip 0.00375f
Ctic3843 i_core_cmp_soft__retained_fullchip_sg13g2_antennanp_1022_880_891_000 i_core_dac_hard_4___Xi_core_u_trip 0.004f
Ctic3844 i_core_cmp_soft__retained_fullchip_sg13g2_antennanp_1022_880_891_000 i_core_dac_hard_5___Xi_core_u_trip 0.00475f
Ctic3845 i_core_cmp_soft__retained_fullchip_sg13g2_antennanp_1022_880_891_000 i_core_dac_hard_6___Xi_core_u_trip 0.03125f
Ctic3846 i_core_cmp_soft__retained_fullchip_sg13g2_antennanp_1022_880_891_000 i_core_dac_hard_7___Xi_core_u_trip 0.076f
Ctic3847 i_core_cmp_soft__retained_fullchip_sg13g2_antennanp_1022_880_891_000 i_core_dac_soft_0___Xi_core_u_trip 0.01775f
Ctic3848 i_core_cmp_soft__retained_fullchip_sg13g2_antennanp_1022_880_891_000 i_core_dac_soft_1___Xi_core_u_trip 0.13925f
Ctic3849 i_core_cmp_soft__retained_fullchip_sg13g2_antennanp_1022_880_891_000 i_core_dac_soft_2___Xi_core_u_trip 0.2035f
Ctic3850 i_core_cmp_soft__retained_fullchip_sg13g2_antennanp_1022_880_891_000 i_core_dac_soft_3___Xi_core_u_trip 0.194f
Ctic3851 i_core_cmp_soft__retained_fullchip_sg13g2_antennanp_1022_880_891_000 i_core_dac_soft_4___Xi_core_u_trip 0.00925f
Ctic3852 i_core_cmp_soft__retained_fullchip_sg13g2_antennanp_1022_880_891_000 i_core_dac_soft_5___Xi_core_u_trip 0.0035f
Ctic3853 i_core_cmp_soft__retained_fullchip_sg13g2_antennanp_1022_880_891_000 i_core_dac_soft_6___Xi_core_u_trip 0.01575f
Ctic3854 i_core_cmp_soft__retained_fullchip_sg13g2_antennanp_1022_880_891_000 i_core_dac_soft_7___Xi_core_u_trip 0.00275f
Ctic3855 i_core_cmp_soft__retained_fullchip_sg13g2_antennanp_1022_880_891_000 i_core_iptat__Xi_core_u_sense 0.00575f
Ctic3856 i_core_cmp_soft__retained_fullchip_sg13g2_antennanp_1022_880_891_000 i_core_isense 0.0065f
Ctic3857 i_core_cmp_soft__retained_fullchip_sg13g2_antennanp_1022_880_891_000 i_core_osc_clk__Xi_core_u_osc 0.005f
Ctic3858 i_core_cmp_soft__retained_fullchip_sg13g2_antennanp_1022_880_891_000 i_core_osc_en__Xi_core_u_osc 0.0035f
Ctic3859 i_core_cmp_soft__retained_fullchip_sg13g2_antennanp_1022_880_891_000 i_core_osc_trim_0___Xi_core_u_osc 0.00275f
Ctic3860 i_core_cmp_soft__retained_fullchip_sg13g2_antennanp_1022_880_891_000 i_core_osc_trim_1___Xi_core_u_osc 0.00275f
Ctic3861 i_core_cmp_soft__retained_fullchip_sg13g2_antennanp_1022_880_891_000 i_core_osc_trim_2___Xi_core_u_osc 0.006f
Ctic3862 i_core_cmp_soft__retained_fullchip_sg13g2_antennanp_1022_880_891_000 i_core_osc_trim_3___Xi_core_u_osc 0.00275f
Ctic3863 i_core_cmp_soft__retained_fullchip_sg13g2_antennanp_1022_880_891_000 i_core_sclk_i 13.1783f
Ctic3864 i_core_cmp_soft__retained_fullchip_sg13g2_antennanp_1022_880_891_000 i_core_sdi_i__retained_fullchip_sg13g2_antennanp_1024_320_891_000 1.2645f
Ctic3865 i_core_cmp_soft__retained_fullchip_sg13g2_antennanp_1022_880_891_000 i_core_sdo_o__Xpad16_sdo 0.0125f
Ctic3866 i_core_cmp_soft__retained_fullchip_sg13g2_antennanp_1022_880_891_000 i_core_tripped__retained_fullchip_sg13g2_antennanp_1027_200_891_000 0.0025f
Ctic3867 i_core_cmp_soft__retained_fullchip_sg13g2_antennanp_1022_880_891_000 i_core_vref__Xpad18_vref 0.0045f
Ctic3868 i_core_cmp_soft__retained_fullchip_sg13g2_antennanp_1022_880_891_000 i_core_vref_buf 0.0525f
Ctic3869 i_core_dac_hard_0_ i_core_dac_hard_1_ 1.331f
Ctic3870 i_core_dac_hard_0_ i_core_dac_hard_2_ 0.0815f
Ctic3871 i_core_dac_hard_0_ i_core_dac_hard_3_ 0.018f
Ctic3872 i_core_dac_hard_0_ i_core_dac_hard_4_ 0.0105f
Ctic3873 i_core_dac_hard_0_ i_core_dac_hard_5_ 0.01f
Ctic3874 i_core_dac_hard_0_ i_core_dac_hard_6_ 0.065f
Ctic3875 i_core_dac_hard_0_ i_core_dac_hard_7_ 0.0655f
Ctic3876 i_core_dac_hard_0_ i_core_dac_soft_0_ 0.0975f
Ctic3877 i_core_dac_hard_0_ i_core_dac_soft_1_ 0.0575f
Ctic3878 i_core_dac_hard_0_ i_core_dac_soft_2_ 0.045f
Ctic3879 i_core_dac_hard_0_ i_core_dac_soft_3_ 0.0135f
Ctic3880 i_core_dac_hard_0_ i_core_dac_soft_4_ 0.0095f
Ctic3881 i_core_dac_hard_0_ i_core_dac_soft_5_ 0.01f
Ctic3882 i_core_dac_hard_0_ i_core_dac_soft_6_ 0.0275f
Ctic3883 i_core_dac_hard_0_ i_core_dac_soft_7_ 0.0085f
Ctic3884 i_core_dac_hard_0_ i_core_iptat 0.0125f
Ctic3885 i_core_dac_hard_0_ i_core_isense__Xi_core_u_trip 0.515f
Ctic3886 i_core_dac_hard_0_ i_core_osc_clk 0.0135f
Ctic3887 i_core_dac_hard_0_ i_core_osc_en 0.01f
Ctic3888 i_core_dac_hard_0_ i_core_osc_trim_0_ 0.0085f
Ctic3889 i_core_dac_hard_0_ i_core_osc_trim_1_ 0.0085f
Ctic3890 i_core_dac_hard_0_ i_core_osc_trim_2_ 0.015f
Ctic3891 i_core_dac_hard_0_ i_core_osc_trim_3_ 0.0085f
Ctic3892 i_core_dac_hard_0_ i_core_sclk_i 0.0115f
Ctic3893 i_core_dac_hard_0_ i_core_sdo_o 0.1545f
Ctic3894 i_core_dac_hard_0_ i_core_vref 0.012f
Ctic3895 i_core_dac_hard_0_ i_core_vref_buf__Xi_core_u_trip 0.099f
Ctic3896 i_core_dac_hard_0___Xi_core_u_trip i_core_dac_hard_1___Xi_core_u_trip 1.331f
Ctic3897 i_core_dac_hard_0___Xi_core_u_trip i_core_dac_hard_2___Xi_core_u_trip 0.0815f
Ctic3898 i_core_dac_hard_0___Xi_core_u_trip i_core_dac_hard_3___Xi_core_u_trip 0.018f
Ctic3899 i_core_dac_hard_0___Xi_core_u_trip i_core_dac_hard_4___Xi_core_u_trip 0.0105f
Ctic3900 i_core_dac_hard_0___Xi_core_u_trip i_core_dac_hard_5___Xi_core_u_trip 0.01f
Ctic3901 i_core_dac_hard_0___Xi_core_u_trip i_core_dac_hard_6___Xi_core_u_trip 0.065f
Ctic3902 i_core_dac_hard_0___Xi_core_u_trip i_core_dac_hard_7___Xi_core_u_trip 0.0655f
Ctic3903 i_core_dac_hard_0___Xi_core_u_trip i_core_dac_soft_0___Xi_core_u_trip 0.0975f
Ctic3904 i_core_dac_hard_0___Xi_core_u_trip i_core_dac_soft_1___Xi_core_u_trip 0.0575f
Ctic3905 i_core_dac_hard_0___Xi_core_u_trip i_core_dac_soft_2___Xi_core_u_trip 0.045f
Ctic3906 i_core_dac_hard_0___Xi_core_u_trip i_core_dac_soft_3___Xi_core_u_trip 0.0135f
Ctic3907 i_core_dac_hard_0___Xi_core_u_trip i_core_dac_soft_4___Xi_core_u_trip 0.0095f
Ctic3908 i_core_dac_hard_0___Xi_core_u_trip i_core_dac_soft_5___Xi_core_u_trip 0.01f
Ctic3909 i_core_dac_hard_0___Xi_core_u_trip i_core_dac_soft_6___Xi_core_u_trip 0.0275f
Ctic3910 i_core_dac_hard_0___Xi_core_u_trip i_core_dac_soft_7___Xi_core_u_trip 0.0085f
Ctic3911 i_core_dac_hard_0___Xi_core_u_trip i_core_iptat__Xi_core_u_sense 0.0125f
Ctic3912 i_core_dac_hard_0___Xi_core_u_trip i_core_isense 0.515f
Ctic3913 i_core_dac_hard_0___Xi_core_u_trip i_core_osc_clk__Xi_core_u_osc 0.0135f
Ctic3914 i_core_dac_hard_0___Xi_core_u_trip i_core_osc_en 0.01f
Ctic3915 i_core_dac_hard_0___Xi_core_u_trip i_core_osc_trim_0_ 0.0085f
Ctic3916 i_core_dac_hard_0___Xi_core_u_trip i_core_osc_trim_1_ 0.0085f
Ctic3917 i_core_dac_hard_0___Xi_core_u_trip i_core_osc_trim_2_ 0.015f
Ctic3918 i_core_dac_hard_0___Xi_core_u_trip i_core_osc_trim_3_ 0.0085f
Ctic3919 i_core_dac_hard_0___Xi_core_u_trip i_core_sclk_i 0.0115f
Ctic3920 i_core_dac_hard_0___Xi_core_u_trip i_core_sdo_o 0.1545f
Ctic3921 i_core_dac_hard_0___Xi_core_u_trip i_core_vref__Xi_core_u_sense 0.012f
Ctic3922 i_core_dac_hard_0___Xi_core_u_trip i_core_vref_buf 0.099f
Ctic3923 i_core_dac_hard_1_ i_core_dac_hard_2_ 7.876f
Ctic3924 i_core_dac_hard_1_ i_core_dac_hard_3_ 0.0165f
Ctic3925 i_core_dac_hard_1_ i_core_dac_hard_4_ 0.0115f
Ctic3926 i_core_dac_hard_1_ i_core_dac_hard_5_ 0.011f
Ctic3927 i_core_dac_hard_1_ i_core_dac_hard_6_ 0.0815f
Ctic3928 i_core_dac_hard_1_ i_core_dac_hard_7_ 0.05f
Ctic3929 i_core_dac_hard_1_ i_core_dac_soft_0_ 16.5785f
Ctic3930 i_core_dac_hard_1_ i_core_dac_soft_1_ 0.0105f
Ctic3931 i_core_dac_hard_1_ i_core_dac_soft_2_ 0.0935f
Ctic3932 i_core_dac_hard_1_ i_core_dac_soft_3_ 0.0065f
Ctic3933 i_core_dac_hard_1_ i_core_dac_soft_4_ 0.008f
Ctic3934 i_core_dac_hard_1_ i_core_dac_soft_5_ 0.008f
Ctic3935 i_core_dac_hard_1_ i_core_dac_soft_6_ 0.025f
Ctic3936 i_core_dac_hard_1_ i_core_dac_soft_7_ 0.0065f
Ctic3937 i_core_dac_hard_1_ i_core_iptat 0.0125f
Ctic3938 i_core_dac_hard_1_ i_core_isense__Xi_core_u_trip 0.013f
Ctic3939 i_core_dac_hard_1_ i_core_osc_clk 0.0115f
Ctic3940 i_core_dac_hard_1_ i_core_osc_en 0.008f
Ctic3941 i_core_dac_hard_1_ i_core_osc_trim_0_ 0.0065f
Ctic3942 i_core_dac_hard_1_ i_core_osc_trim_1_ 0.0065f
Ctic3943 i_core_dac_hard_1_ i_core_osc_trim_2_ 0.013f
Ctic3944 i_core_dac_hard_1_ i_core_osc_trim_3_ 0.0065f
Ctic3945 i_core_dac_hard_1_ i_core_sclk_i 0.011f
Ctic3946 i_core_dac_hard_1_ i_core_sdo_o 0.019f
Ctic3947 i_core_dac_hard_1_ i_core_vref 0.01f
Ctic3948 i_core_dac_hard_1_ i_core_vref_buf__Xi_core_u_trip 0.1995f
Ctic3949 i_core_dac_hard_1___Xi_core_u_trip i_core_dac_hard_2___Xi_core_u_trip 7.876f
Ctic3950 i_core_dac_hard_1___Xi_core_u_trip i_core_dac_hard_3___Xi_core_u_trip 0.0165f
Ctic3951 i_core_dac_hard_1___Xi_core_u_trip i_core_dac_hard_4___Xi_core_u_trip 0.0115f
Ctic3952 i_core_dac_hard_1___Xi_core_u_trip i_core_dac_hard_5___Xi_core_u_trip 0.011f
Ctic3953 i_core_dac_hard_1___Xi_core_u_trip i_core_dac_hard_6___Xi_core_u_trip 0.0815f
Ctic3954 i_core_dac_hard_1___Xi_core_u_trip i_core_dac_hard_7___Xi_core_u_trip 0.05f
Ctic3955 i_core_dac_hard_1___Xi_core_u_trip i_core_dac_soft_0___Xi_core_u_trip 16.5785f
Ctic3956 i_core_dac_hard_1___Xi_core_u_trip i_core_dac_soft_1___Xi_core_u_trip 0.0105f
Ctic3957 i_core_dac_hard_1___Xi_core_u_trip i_core_dac_soft_2___Xi_core_u_trip 0.0935f
Ctic3958 i_core_dac_hard_1___Xi_core_u_trip i_core_dac_soft_3___Xi_core_u_trip 0.0065f
Ctic3959 i_core_dac_hard_1___Xi_core_u_trip i_core_dac_soft_4___Xi_core_u_trip 0.008f
Ctic3960 i_core_dac_hard_1___Xi_core_u_trip i_core_dac_soft_5___Xi_core_u_trip 0.008f
Ctic3961 i_core_dac_hard_1___Xi_core_u_trip i_core_dac_soft_6___Xi_core_u_trip 0.025f
Ctic3962 i_core_dac_hard_1___Xi_core_u_trip i_core_dac_soft_7___Xi_core_u_trip 0.0065f
Ctic3963 i_core_dac_hard_1___Xi_core_u_trip i_core_iptat__Xi_core_u_sense 0.0125f
Ctic3964 i_core_dac_hard_1___Xi_core_u_trip i_core_isense 0.013f
Ctic3965 i_core_dac_hard_1___Xi_core_u_trip i_core_osc_clk__Xi_core_u_osc 0.0115f
Ctic3966 i_core_dac_hard_1___Xi_core_u_trip i_core_osc_en 0.008f
Ctic3967 i_core_dac_hard_1___Xi_core_u_trip i_core_osc_trim_0_ 0.0065f
Ctic3968 i_core_dac_hard_1___Xi_core_u_trip i_core_osc_trim_1_ 0.0065f
Ctic3969 i_core_dac_hard_1___Xi_core_u_trip i_core_osc_trim_2_ 0.013f
Ctic3970 i_core_dac_hard_1___Xi_core_u_trip i_core_osc_trim_3_ 0.0065f
Ctic3971 i_core_dac_hard_1___Xi_core_u_trip i_core_sclk_i 0.011f
Ctic3972 i_core_dac_hard_1___Xi_core_u_trip i_core_sdo_o 0.019f
Ctic3973 i_core_dac_hard_1___Xi_core_u_trip i_core_vref__Xi_core_u_sense 0.01f
Ctic3974 i_core_dac_hard_1___Xi_core_u_trip i_core_vref_buf 0.1995f
Ctic3975 i_core_dac_hard_2_ i_core_dac_hard_3_ 0.67f
Ctic3976 i_core_dac_hard_2_ i_core_dac_hard_4_ 0.582f
Ctic3977 i_core_dac_hard_2_ i_core_dac_hard_5_ 0.014f
Ctic3978 i_core_dac_hard_2_ i_core_dac_hard_6_ 0.144f
Ctic3979 i_core_dac_hard_2_ i_core_dac_hard_7_ 0.0715f
Ctic3980 i_core_dac_hard_2_ i_core_dac_soft_0_ 14.972f
Ctic3981 i_core_dac_hard_2_ i_core_dac_soft_1_ 0.1265f
Ctic3982 i_core_dac_hard_2_ i_core_dac_soft_2_ 0.1465f
Ctic3983 i_core_dac_hard_2_ i_core_dac_soft_3_ 0.0065f
Ctic3984 i_core_dac_hard_2_ i_core_dac_soft_4_ 16.74f
Ctic3985 i_core_dac_hard_2_ i_core_dac_soft_5_ 0.008f
Ctic3986 i_core_dac_hard_2_ i_core_dac_soft_6_ 0.026f
Ctic3987 i_core_dac_hard_2_ i_core_dac_soft_7_ 0.0065f
Ctic3988 i_core_dac_hard_2_ i_core_iptat 0.067f
Ctic3989 i_core_dac_hard_2_ i_core_isense__Xi_core_u_trip 0.013f
Ctic3990 i_core_dac_hard_2_ i_core_osc_clk 0.0115f
Ctic3991 i_core_dac_hard_2_ i_core_osc_en 0.008f
Ctic3992 i_core_dac_hard_2_ i_core_osc_trim_0_ 0.0065f
Ctic3993 i_core_dac_hard_2_ i_core_osc_trim_1_ 0.0065f
Ctic3994 i_core_dac_hard_2_ i_core_osc_trim_2_ 0.013f
Ctic3995 i_core_dac_hard_2_ i_core_osc_trim_3_ 0.0065f
Ctic3996 i_core_dac_hard_2_ i_core_sclk_i 0.2815f
Ctic3997 i_core_dac_hard_2_ i_core_sdo_o 0.022f
Ctic3998 i_core_dac_hard_2_ i_core_vref 0.01f
Ctic3999 i_core_dac_hard_2_ i_core_vref_buf__Xi_core_u_trip 0.1015f
Ctic4000 i_core_dac_hard_2___Xi_core_u_trip i_core_dac_hard_3___Xi_core_u_trip 0.67f
Ctic4001 i_core_dac_hard_2___Xi_core_u_trip i_core_dac_hard_4___Xi_core_u_trip 0.582f
Ctic4002 i_core_dac_hard_2___Xi_core_u_trip i_core_dac_hard_5___Xi_core_u_trip 0.014f
Ctic4003 i_core_dac_hard_2___Xi_core_u_trip i_core_dac_hard_6___Xi_core_u_trip 0.144f
Ctic4004 i_core_dac_hard_2___Xi_core_u_trip i_core_dac_hard_7___Xi_core_u_trip 0.0715f
Ctic4005 i_core_dac_hard_2___Xi_core_u_trip i_core_dac_soft_0___Xi_core_u_trip 14.972f
Ctic4006 i_core_dac_hard_2___Xi_core_u_trip i_core_dac_soft_1___Xi_core_u_trip 0.1265f
Ctic4007 i_core_dac_hard_2___Xi_core_u_trip i_core_dac_soft_2___Xi_core_u_trip 0.1465f
Ctic4008 i_core_dac_hard_2___Xi_core_u_trip i_core_dac_soft_3___Xi_core_u_trip 0.0065f
Ctic4009 i_core_dac_hard_2___Xi_core_u_trip i_core_dac_soft_4___Xi_core_u_trip 16.74f
Ctic4010 i_core_dac_hard_2___Xi_core_u_trip i_core_dac_soft_5___Xi_core_u_trip 0.008f
Ctic4011 i_core_dac_hard_2___Xi_core_u_trip i_core_dac_soft_6___Xi_core_u_trip 0.026f
Ctic4012 i_core_dac_hard_2___Xi_core_u_trip i_core_dac_soft_7___Xi_core_u_trip 0.0065f
Ctic4013 i_core_dac_hard_2___Xi_core_u_trip i_core_iptat__Xi_core_u_sense 0.067f
Ctic4014 i_core_dac_hard_2___Xi_core_u_trip i_core_isense 0.013f
Ctic4015 i_core_dac_hard_2___Xi_core_u_trip i_core_osc_clk__Xi_core_u_osc 0.0115f
Ctic4016 i_core_dac_hard_2___Xi_core_u_trip i_core_osc_en 0.008f
Ctic4017 i_core_dac_hard_2___Xi_core_u_trip i_core_osc_trim_0_ 0.0065f
Ctic4018 i_core_dac_hard_2___Xi_core_u_trip i_core_osc_trim_1_ 0.0065f
Ctic4019 i_core_dac_hard_2___Xi_core_u_trip i_core_osc_trim_2_ 0.013f
Ctic4020 i_core_dac_hard_2___Xi_core_u_trip i_core_osc_trim_3_ 0.0065f
Ctic4021 i_core_dac_hard_2___Xi_core_u_trip i_core_sclk_i 0.2815f
Ctic4022 i_core_dac_hard_2___Xi_core_u_trip i_core_sdo_o 0.022f
Ctic4023 i_core_dac_hard_2___Xi_core_u_trip i_core_vref__Xi_core_u_sense 0.01f
Ctic4024 i_core_dac_hard_2___Xi_core_u_trip i_core_vref_buf 0.1015f
Ctic4025 i_core_dac_hard_3_ i_core_dac_hard_4_ 0.7615f
Ctic4026 i_core_dac_hard_3_ i_core_dac_hard_5_ 0.0355f
Ctic4027 i_core_dac_hard_3_ i_core_dac_hard_6_ 1.579f
Ctic4028 i_core_dac_hard_3_ i_core_dac_hard_7_ 0.061f
Ctic4029 i_core_dac_hard_3_ i_core_dac_soft_1___Xi_core_u_trip 0.026f
Ctic4030 i_core_dac_hard_3_ i_core_dac_soft_2___Xi_core_u_trip 0.0795f
Ctic4031 i_core_dac_hard_3_ i_core_dac_soft_3___Xi_core_u_trip 0.028f
Ctic4032 i_core_dac_hard_3_ i_core_dac_soft_4___Xi_core_u_trip 0.142f
Ctic4033 i_core_dac_hard_3_ i_core_dac_soft_5___Xi_core_u_trip 0.2135f
Ctic4034 i_core_dac_hard_3_ i_core_dac_soft_7___Xi_core_u_trip 1.7075f
Ctic4035 i_core_dac_hard_3_ i_core_iptat__Xi_core_u_sense 8.311f
Ctic4036 i_core_dac_hard_3_ i_core_isense 0.008f
Ctic4037 i_core_dac_hard_3_ i_core_osc_clk 0.0455f
Ctic4038 i_core_dac_hard_3_ i_core_osc_en 0.0455f
Ctic4039 i_core_dac_hard_3_ i_core_osc_trim_0_ 0.0265f
Ctic4040 i_core_dac_hard_3_ i_core_osc_trim_1_ 0.0365f
Ctic4041 i_core_dac_hard_3_ i_core_osc_trim_2_ 0.1115f
Ctic4042 i_core_dac_hard_3_ i_core_osc_trim_3_ 0.038f
Ctic4043 i_core_dac_hard_3_ i_core_t2f_en_33 0.0005f
Ctic4044 i_core_dac_hard_3_ i_core_t2f_mode_33 0.0005f
Ctic4045 i_core_dac_hard_3_ i_core_tripped 0.028f
Ctic4046 i_core_dac_hard_3_ i_core_vref__Xi_core_u_sense 0.012f
Ctic4047 i_core_dac_hard_3_ i_core_vref_buf 0.012f
Ctic4048 i_core_dac_hard_3_ net 0.127f
Ctic4049 i_core_dac_hard_3___Xi_core_u_trip i_core_dac_hard_4___Xi_core_u_trip 0.7615f
Ctic4050 i_core_dac_hard_3___Xi_core_u_trip i_core_dac_hard_5___Xi_core_u_trip 0.0355f
Ctic4051 i_core_dac_hard_3___Xi_core_u_trip i_core_dac_hard_6___Xi_core_u_trip 1.579f
Ctic4052 i_core_dac_hard_3___Xi_core_u_trip i_core_dac_hard_7___Xi_core_u_trip 0.061f
Ctic4053 i_core_dac_hard_3___Xi_core_u_trip i_core_dac_soft_1___Xi_core_u_trip 0.026f
Ctic4054 i_core_dac_hard_3___Xi_core_u_trip i_core_dac_soft_2___Xi_core_u_trip 0.0795f
Ctic4055 i_core_dac_hard_3___Xi_core_u_trip i_core_dac_soft_3___Xi_core_u_trip 0.028f
Ctic4056 i_core_dac_hard_3___Xi_core_u_trip i_core_dac_soft_4___Xi_core_u_trip 0.142f
Ctic4057 i_core_dac_hard_3___Xi_core_u_trip i_core_dac_soft_5___Xi_core_u_trip 0.2135f
Ctic4058 i_core_dac_hard_3___Xi_core_u_trip i_core_dac_soft_7___Xi_core_u_trip 1.7075f
Ctic4059 i_core_dac_hard_3___Xi_core_u_trip i_core_iptat__Xi_core_u_sense 8.311f
Ctic4060 i_core_dac_hard_3___Xi_core_u_trip i_core_isense 0.008f
Ctic4061 i_core_dac_hard_3___Xi_core_u_trip i_core_osc_clk__Xi_core_u_osc 0.0455f
Ctic4062 i_core_dac_hard_3___Xi_core_u_trip i_core_osc_en 0.0455f
Ctic4063 i_core_dac_hard_3___Xi_core_u_trip i_core_osc_trim_0_ 0.0265f
Ctic4064 i_core_dac_hard_3___Xi_core_u_trip i_core_osc_trim_1_ 0.0365f
Ctic4065 i_core_dac_hard_3___Xi_core_u_trip i_core_osc_trim_2_ 0.1115f
Ctic4066 i_core_dac_hard_3___Xi_core_u_trip i_core_osc_trim_3_ 0.038f
Ctic4067 i_core_dac_hard_3___Xi_core_u_trip i_core_t2f_en_33__Xi_core_u_t2f 0.0005f
Ctic4068 i_core_dac_hard_3___Xi_core_u_trip i_core_t2f_mode_33__Xi_core_u_t2f 0.0005f
Ctic4069 i_core_dac_hard_3___Xi_core_u_trip i_core_tripped__retained_fullchip_sg13g2_antennanp_1027_200_891_000 0.028f
Ctic4070 i_core_dac_hard_3___Xi_core_u_trip i_core_vref__Xi_core_u_sense 0.012f
Ctic4071 i_core_dac_hard_3___Xi_core_u_trip i_core_vref_buf 0.012f
Ctic4072 i_core_dac_hard_3___Xi_core_u_trip net__Xi_core_u_digital_1 0.127f
Ctic4073 i_core_dac_hard_4_ i_core_dac_hard_5_ 10.6905f
Ctic4074 i_core_dac_hard_4_ i_core_dac_hard_6_ 4.099f
Ctic4075 i_core_dac_hard_4_ i_core_dac_hard_7_ 0.308f
Ctic4076 i_core_dac_hard_4_ i_core_dac_soft_1_ 0.129f
Ctic4077 i_core_dac_hard_4_ i_core_dac_soft_2_ 16.379f
Ctic4078 i_core_dac_hard_4_ i_core_dac_soft_3_ 16.984f
Ctic4079 i_core_dac_hard_4_ i_core_dac_soft_4_ 0.0005f
Ctic4080 i_core_dac_hard_4_ i_core_dac_soft_5_ 0.0645f
Ctic4081 i_core_dac_hard_4_ i_core_dac_soft_6_ 0.1015f
Ctic4082 i_core_dac_hard_4_ i_core_dac_soft_7_ 0.404f
Ctic4083 i_core_dac_hard_4_ i_core_iptat 0.1025f
Ctic4084 i_core_dac_hard_4_ i_core_isense__Xi_core_u_trip 0.0115f
Ctic4085 i_core_dac_hard_4_ i_core_osc_clk 0.0095f
Ctic4086 i_core_dac_hard_4_ i_core_osc_en 0.0065f
Ctic4087 i_core_dac_hard_4_ i_core_osc_trim_0_ 0.0055f
Ctic4088 i_core_dac_hard_4_ i_core_osc_trim_1_ 0.0055f
Ctic4089 i_core_dac_hard_4_ i_core_osc_trim_2_ 0.011f
Ctic4090 i_core_dac_hard_4_ i_core_osc_trim_3_ 0.0055f
Ctic4091 i_core_dac_hard_4_ i_core_sdo_o 0.025f
Ctic4092 i_core_dac_hard_4_ i_core_t2f_en_33 0.0005f
Ctic4093 i_core_dac_hard_4_ i_core_t2f_mode_33 0.001f
Ctic4094 i_core_dac_hard_4_ i_core_tripped__Xi_core_u_gate 0.2765f
Ctic4095 i_core_dac_hard_4_ i_core_vref 0.0085f
Ctic4096 i_core_dac_hard_4_ i_core_vref_buf__Xi_core_u_trip 0.015f
Ctic4097 i_core_dac_hard_4_ net 0.006f
Ctic4098 i_core_dac_hard_4___Xi_core_u_trip i_core_dac_hard_5___Xi_core_u_trip 10.6905f
Ctic4099 i_core_dac_hard_4___Xi_core_u_trip i_core_dac_hard_6___Xi_core_u_trip 4.099f
Ctic4100 i_core_dac_hard_4___Xi_core_u_trip i_core_dac_hard_7___Xi_core_u_trip 0.308f
Ctic4101 i_core_dac_hard_4___Xi_core_u_trip i_core_dac_soft_1___Xi_core_u_trip 0.129f
Ctic4102 i_core_dac_hard_4___Xi_core_u_trip i_core_dac_soft_2___Xi_core_u_trip 16.379f
Ctic4103 i_core_dac_hard_4___Xi_core_u_trip i_core_dac_soft_3___Xi_core_u_trip 16.984f
Ctic4104 i_core_dac_hard_4___Xi_core_u_trip i_core_dac_soft_4___Xi_core_u_trip 0.0005f
Ctic4105 i_core_dac_hard_4___Xi_core_u_trip i_core_dac_soft_5___Xi_core_u_trip 0.0645f
Ctic4106 i_core_dac_hard_4___Xi_core_u_trip i_core_dac_soft_6___Xi_core_u_trip 0.1015f
Ctic4107 i_core_dac_hard_4___Xi_core_u_trip i_core_dac_soft_7___Xi_core_u_trip 0.404f
Ctic4108 i_core_dac_hard_4___Xi_core_u_trip i_core_iptat__Xi_core_u_sense 0.1025f
Ctic4109 i_core_dac_hard_4___Xi_core_u_trip i_core_isense 0.0115f
Ctic4110 i_core_dac_hard_4___Xi_core_u_trip i_core_osc_clk__Xi_core_u_osc 0.0095f
Ctic4111 i_core_dac_hard_4___Xi_core_u_trip i_core_osc_en 0.0065f
Ctic4112 i_core_dac_hard_4___Xi_core_u_trip i_core_osc_trim_0_ 0.0055f
Ctic4113 i_core_dac_hard_4___Xi_core_u_trip i_core_osc_trim_1_ 0.0055f
Ctic4114 i_core_dac_hard_4___Xi_core_u_trip i_core_osc_trim_2_ 0.011f
Ctic4115 i_core_dac_hard_4___Xi_core_u_trip i_core_osc_trim_3_ 0.0055f
Ctic4116 i_core_dac_hard_4___Xi_core_u_trip i_core_sdo_o 0.025f
Ctic4117 i_core_dac_hard_4___Xi_core_u_trip i_core_t2f_en_33__Xi_core_u_t2f 0.0005f
Ctic4118 i_core_dac_hard_4___Xi_core_u_trip i_core_t2f_mode_33__Xi_core_u_t2f 0.001f
Ctic4119 i_core_dac_hard_4___Xi_core_u_trip i_core_tripped__retained_fullchip_sg13g2_antennanp_1027_200_891_000 0.2765f
Ctic4120 i_core_dac_hard_4___Xi_core_u_trip i_core_vref__Xi_core_u_sense 0.0085f
Ctic4121 i_core_dac_hard_4___Xi_core_u_trip i_core_vref_buf 0.015f
Ctic4122 i_core_dac_hard_4___Xi_core_u_trip net__Xi_core_u_digital_1 0.006f
Ctic4123 i_core_dac_hard_5_ i_core_dac_hard_6_ 0.1525f
Ctic4124 i_core_dac_hard_5_ i_core_dac_hard_7_ 1.0945f
Ctic4125 i_core_dac_hard_5_ i_core_dac_soft_1_ 0.033f
Ctic4126 i_core_dac_hard_5_ i_core_dac_soft_2_ 0.0005f
Ctic4127 i_core_dac_hard_5_ i_core_dac_soft_3_ 17.1885f
Ctic4128 i_core_dac_hard_5_ i_core_dac_soft_4_ 0.001f
Ctic4129 i_core_dac_hard_5_ i_core_dac_soft_5_ 0.381f
Ctic4130 i_core_dac_hard_5_ i_core_dac_soft_6_ 0.0015f
Ctic4131 i_core_dac_hard_5_ i_core_dac_soft_7_ 0.096f
Ctic4132 i_core_dac_hard_5_ i_core_iptat 0.0115f
Ctic4133 i_core_dac_hard_5_ i_core_isense__Xi_core_u_trip 0.0105f
Ctic4134 i_core_dac_hard_5_ i_core_osc_clk 0.012f
Ctic4135 i_core_dac_hard_5_ i_core_osc_en 0.0095f
Ctic4136 i_core_dac_hard_5_ i_core_osc_trim_0_ 0.008f
Ctic4137 i_core_dac_hard_5_ i_core_osc_trim_1_ 0.0095f
Ctic4138 i_core_dac_hard_5_ i_core_osc_trim_2_ 0.014f
Ctic4139 i_core_dac_hard_5_ i_core_osc_trim_3_ 0.0475f
Ctic4141 i_core_dac_hard_5_ i_core_sdo_o 0.0035f
Ctic4142 i_core_dac_hard_5_ i_core_t2f_en_33 0.2695f
Ctic4143 i_core_dac_hard_5_ i_core_t2f_mode_33 0.501f
Ctic4144 i_core_dac_hard_5_ i_core_tripped__Xi_core_u_gate 0.296f
Ctic4145 i_core_dac_hard_5_ i_core_vref 0.011f
Ctic4146 i_core_dac_hard_5_ i_core_vref_buf__Xi_core_u_trip 0.0135f
Ctic4147 i_core_dac_hard_5_ net 0.074f
Ctic4148 i_core_dac_hard_5___Xi_core_u_trip i_core_dac_hard_6___Xi_core_u_trip 0.1525f
Ctic4149 i_core_dac_hard_5___Xi_core_u_trip i_core_dac_hard_7___Xi_core_u_trip 1.0945f
Ctic4150 i_core_dac_hard_5___Xi_core_u_trip i_core_dac_soft_1___Xi_core_u_trip 0.033f
Ctic4151 i_core_dac_hard_5___Xi_core_u_trip i_core_dac_soft_2___Xi_core_u_trip 0.0005f
Ctic4152 i_core_dac_hard_5___Xi_core_u_trip i_core_dac_soft_3___Xi_core_u_trip 17.1885f
Ctic4153 i_core_dac_hard_5___Xi_core_u_trip i_core_dac_soft_4___Xi_core_u_trip 0.001f
Ctic4154 i_core_dac_hard_5___Xi_core_u_trip i_core_dac_soft_5___Xi_core_u_trip 0.381f
Ctic4155 i_core_dac_hard_5___Xi_core_u_trip i_core_dac_soft_6___Xi_core_u_trip 0.0015f
Ctic4156 i_core_dac_hard_5___Xi_core_u_trip i_core_dac_soft_7___Xi_core_u_trip 0.096f
Ctic4157 i_core_dac_hard_5___Xi_core_u_trip i_core_iptat__Xi_core_u_sense 0.0115f
Ctic4158 i_core_dac_hard_5___Xi_core_u_trip i_core_isense 0.0105f
Ctic4159 i_core_dac_hard_5___Xi_core_u_trip i_core_osc_clk__Xi_core_u_osc 0.012f
Ctic4160 i_core_dac_hard_5___Xi_core_u_trip i_core_osc_en 0.0095f
Ctic4161 i_core_dac_hard_5___Xi_core_u_trip i_core_osc_trim_0_ 0.008f
Ctic4162 i_core_dac_hard_5___Xi_core_u_trip i_core_osc_trim_1_ 0.0095f
Ctic4163 i_core_dac_hard_5___Xi_core_u_trip i_core_osc_trim_2_ 0.014f
Ctic4164 i_core_dac_hard_5___Xi_core_u_trip i_core_osc_trim_3_ 0.0475f
Ctic4166 i_core_dac_hard_5___Xi_core_u_trip i_core_sdo_o 0.0035f
Ctic4167 i_core_dac_hard_5___Xi_core_u_trip i_core_t2f_en_33__Xi_core_u_t2f 0.2695f
Ctic4168 i_core_dac_hard_5___Xi_core_u_trip i_core_t2f_mode_33__Xi_core_u_t2f 0.501f
Ctic4169 i_core_dac_hard_5___Xi_core_u_trip i_core_tripped__retained_fullchip_sg13g2_antennanp_1027_200_891_000 0.296f
Ctic4170 i_core_dac_hard_5___Xi_core_u_trip i_core_vref__Xi_core_u_sense 0.011f
Ctic4171 i_core_dac_hard_5___Xi_core_u_trip i_core_vref_buf 0.0135f
Ctic4172 i_core_dac_hard_5___Xi_core_u_trip net__Xi_core_u_digital_1 0.074f
Ctic4173 i_core_dac_hard_6_ i_core_dac_hard_7_ 2.516f
Ctic4174 i_core_dac_hard_6_ i_core_dac_soft_0_ 0.0145f
Ctic4175 i_core_dac_hard_6_ i_core_dac_soft_1_ 0.7335f
Ctic4176 i_core_dac_hard_6_ i_core_dac_soft_2_ 1.2755f
Ctic4177 i_core_dac_hard_6_ i_core_dac_soft_3_ 0.013f
Ctic4178 i_core_dac_hard_6_ i_core_dac_soft_4_ 0.7165f
Ctic4179 i_core_dac_hard_6_ i_core_dac_soft_5_ 0.027f
Ctic4180 i_core_dac_hard_6_ i_core_dac_soft_6_ 0.0045f
Ctic4181 i_core_dac_hard_6_ i_core_dac_soft_7_ 8.595f
Ctic4182 i_core_dac_hard_6_ i_core_iptat 0.166f
Ctic4183 i_core_dac_hard_6_ i_core_isense__Xi_core_u_trip 0.0175f
Ctic4184 i_core_dac_hard_6_ i_core_osc_clk 0.0155f
Ctic4185 i_core_dac_hard_6_ i_core_osc_en 0.013f
Ctic4186 i_core_dac_hard_6_ i_core_osc_trim_0_ 0.0115f
Ctic4187 i_core_dac_hard_6_ i_core_osc_trim_1_ 0.0115f
Ctic4188 i_core_dac_hard_6_ i_core_osc_trim_2_ 0.017f
Ctic4189 i_core_dac_hard_6_ i_core_osc_trim_3_ 0.0115f
Ctic4190 i_core_dac_hard_6_ i_core_sdo_o 0.0435f
Ctic4191 i_core_dac_hard_6_ i_core_t2f_en_33 0.0005f
Ctic4192 i_core_dac_hard_6_ i_core_t2f_mode_33 0.001f
Ctic4193 i_core_dac_hard_6_ i_core_tripped__Xi_core_u_gate 0.001f
Ctic4194 i_core_dac_hard_6_ i_core_vref 0.0145f
Ctic4195 i_core_dac_hard_6_ i_core_vref_buf__Xi_core_u_trip 0.5785f
Ctic4196 i_core_dac_hard_6___Xi_core_u_trip i_core_dac_hard_7___Xi_core_u_trip 2.516f
Ctic4197 i_core_dac_hard_6___Xi_core_u_trip i_core_dac_soft_0___Xi_core_u_trip 0.0145f
Ctic4198 i_core_dac_hard_6___Xi_core_u_trip i_core_dac_soft_1___Xi_core_u_trip 0.7335f
Ctic4199 i_core_dac_hard_6___Xi_core_u_trip i_core_dac_soft_2___Xi_core_u_trip 1.2755f
Ctic4200 i_core_dac_hard_6___Xi_core_u_trip i_core_dac_soft_3___Xi_core_u_trip 0.013f
Ctic4201 i_core_dac_hard_6___Xi_core_u_trip i_core_dac_soft_4___Xi_core_u_trip 0.7165f
Ctic4202 i_core_dac_hard_6___Xi_core_u_trip i_core_dac_soft_5___Xi_core_u_trip 0.027f
Ctic4203 i_core_dac_hard_6___Xi_core_u_trip i_core_dac_soft_6___Xi_core_u_trip 0.0045f
Ctic4204 i_core_dac_hard_6___Xi_core_u_trip i_core_dac_soft_7___Xi_core_u_trip 8.595f
Ctic4205 i_core_dac_hard_6___Xi_core_u_trip i_core_iptat__Xi_core_u_sense 0.166f
Ctic4206 i_core_dac_hard_6___Xi_core_u_trip i_core_isense 0.0175f
Ctic4207 i_core_dac_hard_6___Xi_core_u_trip i_core_osc_clk__Xi_core_u_osc 0.0155f
Ctic4208 i_core_dac_hard_6___Xi_core_u_trip i_core_osc_en 0.013f
Ctic4209 i_core_dac_hard_6___Xi_core_u_trip i_core_osc_trim_0_ 0.0115f
Ctic4210 i_core_dac_hard_6___Xi_core_u_trip i_core_osc_trim_1_ 0.0115f
Ctic4211 i_core_dac_hard_6___Xi_core_u_trip i_core_osc_trim_2_ 0.017f
Ctic4212 i_core_dac_hard_6___Xi_core_u_trip i_core_osc_trim_3_ 0.0115f
Ctic4213 i_core_dac_hard_6___Xi_core_u_trip i_core_sdo_o 0.0435f
Ctic4214 i_core_dac_hard_6___Xi_core_u_trip i_core_t2f_en_33__Xi_core_u_t2f 0.0005f
Ctic4215 i_core_dac_hard_6___Xi_core_u_trip i_core_t2f_mode_33__Xi_core_u_t2f 0.001f
Ctic4216 i_core_dac_hard_6___Xi_core_u_trip i_core_tripped__retained_fullchip_sg13g2_antennanp_1027_200_891_000 0.001f
Ctic4217 i_core_dac_hard_6___Xi_core_u_trip i_core_vref__Xi_core_u_sense 0.0145f
Ctic4218 i_core_dac_hard_6___Xi_core_u_trip i_core_vref_buf 0.5785f
Ctic4219 i_core_dac_hard_7_ i_core_dac_soft_0_ 0.035f
Ctic4220 i_core_dac_hard_7_ i_core_dac_soft_1_ 0.135f
Ctic4221 i_core_dac_hard_7_ i_core_dac_soft_2_ 1.0365f
Ctic4222 i_core_dac_hard_7_ i_core_dac_soft_3_ 0.2095f
Ctic4223 i_core_dac_hard_7_ i_core_dac_soft_4_ 0.107f
Ctic4224 i_core_dac_hard_7_ i_core_dac_soft_5_ 0.012f
Ctic4225 i_core_dac_hard_7_ i_core_dac_soft_6_ 0.075f
Ctic4226 i_core_dac_hard_7_ i_core_dac_soft_7_ 0.0525f
Ctic4227 i_core_dac_hard_7_ i_core_iptat 0.014f
Ctic4228 i_core_dac_hard_7_ i_core_isense__Xi_core_u_trip 0.013f
Ctic4229 i_core_dac_hard_7_ i_core_osc_clk 0.0245f
Ctic4230 i_core_dac_hard_7_ i_core_osc_en 0.033f
Ctic4231 i_core_dac_hard_7_ i_core_osc_trim_0_ 0.012f
Ctic4232 i_core_dac_hard_7_ i_core_osc_trim_1_ 0.0235f
Ctic4233 i_core_dac_hard_7_ i_core_osc_trim_2_ 0.018f
Ctic4234 i_core_dac_hard_7_ i_core_osc_trim_3_ 0.047f
Ctic4235 i_core_dac_hard_7_ i_core_sclk_i 0.0465f
Ctic4236 i_core_dac_hard_7_ i_core_sdo_o 0.0885f
Ctic4237 i_core_dac_hard_7_ i_core_t2f_en_33 0.0105f
Ctic4238 i_core_dac_hard_7_ i_core_t2f_mode_33 0.014f
Ctic4239 i_core_dac_hard_7_ i_core_tripped__Xi_core_u_gate 0.011f
Ctic4240 i_core_dac_hard_7_ i_core_vref 0.0505f
Ctic4241 i_core_dac_hard_7_ i_core_vref_buf__Xi_core_u_trip 0.016f
Ctic4242 i_core_dac_hard_7_ net 0.2875f
Ctic4243 i_core_dac_hard_7___Xi_core_u_trip i_core_dac_soft_0___Xi_core_u_trip 0.035f
Ctic4244 i_core_dac_hard_7___Xi_core_u_trip i_core_dac_soft_1___Xi_core_u_trip 0.135f
Ctic4245 i_core_dac_hard_7___Xi_core_u_trip i_core_dac_soft_2___Xi_core_u_trip 1.0365f
Ctic4246 i_core_dac_hard_7___Xi_core_u_trip i_core_dac_soft_3___Xi_core_u_trip 0.2095f
Ctic4247 i_core_dac_hard_7___Xi_core_u_trip i_core_dac_soft_4___Xi_core_u_trip 0.107f
Ctic4248 i_core_dac_hard_7___Xi_core_u_trip i_core_dac_soft_5___Xi_core_u_trip 0.012f
Ctic4249 i_core_dac_hard_7___Xi_core_u_trip i_core_dac_soft_6___Xi_core_u_trip 0.075f
Ctic4250 i_core_dac_hard_7___Xi_core_u_trip i_core_dac_soft_7___Xi_core_u_trip 0.0525f
Ctic4251 i_core_dac_hard_7___Xi_core_u_trip i_core_iptat__Xi_core_u_sense 0.014f
Ctic4252 i_core_dac_hard_7___Xi_core_u_trip i_core_isense 0.013f
Ctic4253 i_core_dac_hard_7___Xi_core_u_trip i_core_osc_clk__Xi_core_u_osc 0.0245f
Ctic4254 i_core_dac_hard_7___Xi_core_u_trip i_core_osc_en__Xi_core_u_osc 0.033f
Ctic4255 i_core_dac_hard_7___Xi_core_u_trip i_core_osc_trim_0_ 0.012f
Ctic4256 i_core_dac_hard_7___Xi_core_u_trip i_core_osc_trim_1_ 0.0235f
Ctic4257 i_core_dac_hard_7___Xi_core_u_trip i_core_osc_trim_2_ 0.018f
Ctic4258 i_core_dac_hard_7___Xi_core_u_trip i_core_osc_trim_3_ 0.047f
Ctic4259 i_core_dac_hard_7___Xi_core_u_trip i_core_sclk_i 0.0465f
Ctic4260 i_core_dac_hard_7___Xi_core_u_trip i_core_sdo_o 0.0885f
Ctic4261 i_core_dac_hard_7___Xi_core_u_trip i_core_t2f_en_33__Xi_core_u_t2f 0.0105f
Ctic4262 i_core_dac_hard_7___Xi_core_u_trip i_core_t2f_mode_33__Xi_core_u_t2f 0.014f
Ctic4263 i_core_dac_hard_7___Xi_core_u_trip i_core_tripped__retained_fullchip_sg13g2_antennanp_1027_200_891_000 0.011f
Ctic4264 i_core_dac_hard_7___Xi_core_u_trip i_core_vref__Xi_core_u_sense 0.0505f
Ctic4265 i_core_dac_hard_7___Xi_core_u_trip i_core_vref_buf 0.016f
Ctic4266 i_core_dac_hard_7___Xi_core_u_trip net__Xi_core_u_digital_1 0.2875f
Ctic4267 i_core_dac_soft_0_ i_core_dac_soft_1_ 0.648f
Ctic4268 i_core_dac_soft_0_ i_core_dac_soft_2_ 0.048f
Ctic4269 i_core_dac_soft_0_ i_core_dac_soft_3_ 0.0645f
Ctic4270 i_core_dac_soft_0_ i_core_dac_soft_4_ 0.026f
Ctic4271 i_core_dac_soft_0_ i_core_dac_soft_5_ 0.011f
Ctic4272 i_core_dac_soft_0_ i_core_dac_soft_6_ 0.0235f
Ctic4273 i_core_dac_soft_0_ i_core_dac_soft_7_ 0.011f
Ctic4274 i_core_dac_soft_0_ i_core_iptat 0.0005f
Ctic4275 i_core_dac_soft_0_ i_core_isense__Xi_core_u_trip 0.0075f
Ctic4276 i_core_dac_soft_0_ i_core_osc_clk 0.0155f
Ctic4277 i_core_dac_soft_0_ i_core_osc_en 0.012f
Ctic4278 i_core_dac_soft_0_ i_core_osc_trim_0_ 0.012f
Ctic4279 i_core_dac_soft_0_ i_core_osc_trim_1_ 0.0115f
Ctic4280 i_core_dac_soft_0_ i_core_osc_trim_2_ 0.016f
Ctic4281 i_core_dac_soft_0_ i_core_osc_trim_3_ 0.011f
Ctic4282 i_core_dac_soft_0_ i_core_sclk_i 0.013f
Ctic4283 i_core_dac_soft_0_ i_core_sdo_o 0.045f
Ctic4284 i_core_dac_soft_0_ i_core_vref 0.021f
Ctic4285 i_core_dac_soft_0_ i_core_vref_buf__Xi_core_u_trip 0.0085f
Ctic4286 i_core_dac_soft_0___Xi_core_u_trip i_core_dac_soft_1___Xi_core_u_trip 0.648f
Ctic4287 i_core_dac_soft_0___Xi_core_u_trip i_core_dac_soft_2___Xi_core_u_trip 0.048f
Ctic4288 i_core_dac_soft_0___Xi_core_u_trip i_core_dac_soft_3___Xi_core_u_trip 0.0645f
Ctic4289 i_core_dac_soft_0___Xi_core_u_trip i_core_dac_soft_4___Xi_core_u_trip 0.026f
Ctic4290 i_core_dac_soft_0___Xi_core_u_trip i_core_dac_soft_5___Xi_core_u_trip 0.011f
Ctic4291 i_core_dac_soft_0___Xi_core_u_trip i_core_dac_soft_6___Xi_core_u_trip 0.0235f
Ctic4292 i_core_dac_soft_0___Xi_core_u_trip i_core_dac_soft_7___Xi_core_u_trip 0.011f
Ctic4293 i_core_dac_soft_0___Xi_core_u_trip i_core_iptat__Xi_core_u_sense 0.0005f
Ctic4294 i_core_dac_soft_0___Xi_core_u_trip i_core_isense 0.0075f
Ctic4295 i_core_dac_soft_0___Xi_core_u_trip i_core_osc_clk__Xi_core_u_osc 0.0155f
Ctic4296 i_core_dac_soft_0___Xi_core_u_trip i_core_osc_en 0.012f
Ctic4297 i_core_dac_soft_0___Xi_core_u_trip i_core_osc_trim_0_ 0.012f
Ctic4298 i_core_dac_soft_0___Xi_core_u_trip i_core_osc_trim_1_ 0.0115f
Ctic4299 i_core_dac_soft_0___Xi_core_u_trip i_core_osc_trim_2_ 0.016f
Ctic4300 i_core_dac_soft_0___Xi_core_u_trip i_core_osc_trim_3_ 0.011f
Ctic4301 i_core_dac_soft_0___Xi_core_u_trip i_core_sclk_i 0.013f
Ctic4302 i_core_dac_soft_0___Xi_core_u_trip i_core_sdo_o 0.045f
Ctic4303 i_core_dac_soft_0___Xi_core_u_trip i_core_vref__Xi_core_u_sense 0.021f
Ctic4304 i_core_dac_soft_0___Xi_core_u_trip i_core_vref_buf 0.0085f
Ctic4305 i_core_dac_soft_1_ i_core_dac_soft_2_ 0.336f
Ctic4306 i_core_dac_soft_1_ i_core_dac_soft_3_ 0.7165f
Ctic4307 i_core_dac_soft_1_ i_core_dac_soft_4_ 0.035f
Ctic4308 i_core_dac_soft_1_ i_core_dac_soft_5_ 12.087f
Ctic4309 i_core_dac_soft_1_ i_core_dac_soft_6_ 0.2345f
Ctic4310 i_core_dac_soft_1_ i_core_dac_soft_7_ 12.9085f
Ctic4311 i_core_dac_soft_1_ i_core_iptat 0.0005f
Ctic4312 i_core_dac_soft_1_ i_core_isense__Xi_core_u_trip 0.0065f
Ctic4313 i_core_dac_soft_1_ i_core_osc_clk 0.014f
Ctic4314 i_core_dac_soft_1_ i_core_osc_en 0.011f
Ctic4315 i_core_dac_soft_1_ i_core_osc_trim_0_ 0.0095f
Ctic4316 i_core_dac_soft_1_ i_core_osc_trim_1_ 0.0095f
Ctic4317 i_core_dac_soft_1_ i_core_osc_trim_2_ 0.016f
Ctic4318 i_core_dac_soft_1_ i_core_osc_trim_3_ 0.0105f
Ctic4319 i_core_dac_soft_1_ i_core_sclk_i 0.0195f
Ctic4320 i_core_dac_soft_1_ i_core_sdo_o 0.1545f
Ctic4321 i_core_dac_soft_1_ i_core_vref 0.0745f
Ctic4322 i_core_dac_soft_1_ i_core_vref_buf__Xi_core_u_trip 0.0075f
Ctic4323 i_core_dac_soft_1_ net 0.0005f
Ctic4324 i_core_dac_soft_1___Xi_core_u_trip i_core_dac_soft_2___Xi_core_u_trip 0.336f
Ctic4325 i_core_dac_soft_1___Xi_core_u_trip i_core_dac_soft_3___Xi_core_u_trip 0.7165f
Ctic4326 i_core_dac_soft_1___Xi_core_u_trip i_core_dac_soft_4___Xi_core_u_trip 0.035f
Ctic4327 i_core_dac_soft_1___Xi_core_u_trip i_core_dac_soft_5___Xi_core_u_trip 12.087f
Ctic4328 i_core_dac_soft_1___Xi_core_u_trip i_core_dac_soft_6___Xi_core_u_trip 0.2345f
Ctic4329 i_core_dac_soft_1___Xi_core_u_trip i_core_dac_soft_7___Xi_core_u_trip 12.9085f
Ctic4330 i_core_dac_soft_1___Xi_core_u_trip i_core_iptat__Xi_core_u_sense 0.0005f
Ctic4331 i_core_dac_soft_1___Xi_core_u_trip i_core_isense 0.0065f
Ctic4332 i_core_dac_soft_1___Xi_core_u_trip i_core_osc_clk__Xi_core_u_osc 0.014f
Ctic4333 i_core_dac_soft_1___Xi_core_u_trip i_core_osc_en 0.011f
Ctic4334 i_core_dac_soft_1___Xi_core_u_trip i_core_osc_trim_0_ 0.0095f
Ctic4335 i_core_dac_soft_1___Xi_core_u_trip i_core_osc_trim_1_ 0.0095f
Ctic4336 i_core_dac_soft_1___Xi_core_u_trip i_core_osc_trim_2_ 0.016f
Ctic4337 i_core_dac_soft_1___Xi_core_u_trip i_core_osc_trim_3_ 0.0105f
Ctic4338 i_core_dac_soft_1___Xi_core_u_trip i_core_sclk_i 0.0195f
Ctic4339 i_core_dac_soft_1___Xi_core_u_trip i_core_sdo_o 0.1545f
Ctic4340 i_core_dac_soft_1___Xi_core_u_trip i_core_vref__Xi_core_u_sense 0.0745f
Ctic4341 i_core_dac_soft_1___Xi_core_u_trip i_core_vref_buf 0.0075f
Ctic4342 i_core_dac_soft_1___Xi_core_u_trip net 0.0005f
Ctic4343 i_core_dac_soft_2_ i_core_dac_soft_3_ 1.577f
Ctic4344 i_core_dac_soft_2_ i_core_dac_soft_4_ 0.06f
Ctic4345 i_core_dac_soft_2_ i_core_dac_soft_5_ 0.009f
Ctic4346 i_core_dac_soft_2_ i_core_dac_soft_6_ 0.0275f
Ctic4347 i_core_dac_soft_2_ i_core_dac_soft_7_ 0.0285f
Ctic4348 i_core_dac_soft_2_ i_core_iptat 0.0005f
Ctic4349 i_core_dac_soft_2_ i_core_isense__Xi_core_u_trip 0.0065f
Ctic4350 i_core_dac_soft_2_ i_core_osc_clk 0.0115f
Ctic4351 i_core_dac_soft_2_ i_core_osc_en 0.009f
Ctic4352 i_core_dac_soft_2_ i_core_osc_trim_0_ 0.0075f
Ctic4353 i_core_dac_soft_2_ i_core_osc_trim_1_ 0.0075f
Ctic4354 i_core_dac_soft_2_ i_core_osc_trim_2_ 0.1475f
Ctic4355 i_core_dac_soft_2_ i_core_osc_trim_3_ 0.0075f
Ctic4356 i_core_dac_soft_2_ i_core_sclk_i 0.0255f
Ctic4357 i_core_dac_soft_2_ i_core_sdo_o 0.0665f
Ctic4358 i_core_dac_soft_2_ i_core_vref 0.0105f
Ctic4359 i_core_dac_soft_2_ i_core_vref_buf__Xi_core_u_trip 0.0075f
Ctic4361 i_core_dac_soft_2___Xi_core_u_trip i_core_dac_soft_3___Xi_core_u_trip 1.577f
Ctic4362 i_core_dac_soft_2___Xi_core_u_trip i_core_dac_soft_4___Xi_core_u_trip 0.06f
Ctic4363 i_core_dac_soft_2___Xi_core_u_trip i_core_dac_soft_5___Xi_core_u_trip 0.009f
Ctic4364 i_core_dac_soft_2___Xi_core_u_trip i_core_dac_soft_6___Xi_core_u_trip 0.0275f
Ctic4365 i_core_dac_soft_2___Xi_core_u_trip i_core_dac_soft_7___Xi_core_u_trip 0.0285f
Ctic4366 i_core_dac_soft_2___Xi_core_u_trip i_core_iptat__Xi_core_u_sense 0.0005f
Ctic4367 i_core_dac_soft_2___Xi_core_u_trip i_core_isense 0.0065f
Ctic4368 i_core_dac_soft_2___Xi_core_u_trip i_core_osc_clk__Xi_core_u_osc 0.0115f
Ctic4369 i_core_dac_soft_2___Xi_core_u_trip i_core_osc_en 0.009f
Ctic4370 i_core_dac_soft_2___Xi_core_u_trip i_core_osc_trim_0_ 0.0075f
Ctic4371 i_core_dac_soft_2___Xi_core_u_trip i_core_osc_trim_1_ 0.0075f
Ctic4372 i_core_dac_soft_2___Xi_core_u_trip i_core_osc_trim_2_ 0.1475f
Ctic4373 i_core_dac_soft_2___Xi_core_u_trip i_core_osc_trim_3_ 0.0075f
Ctic4374 i_core_dac_soft_2___Xi_core_u_trip i_core_sclk_i 0.0255f
Ctic4375 i_core_dac_soft_2___Xi_core_u_trip i_core_sdo_o 0.0665f
Ctic4376 i_core_dac_soft_2___Xi_core_u_trip i_core_vref__Xi_core_u_sense 0.0105f
Ctic4377 i_core_dac_soft_2___Xi_core_u_trip i_core_vref_buf 0.0075f
Ctic4379 i_core_dac_soft_3_ i_core_dac_soft_4_ 0.1285f
Ctic4380 i_core_dac_soft_3_ i_core_dac_soft_5_ 1.434f
Ctic4381 i_core_dac_soft_3_ i_core_dac_soft_6_ 0.007f
Ctic4382 i_core_dac_soft_3_ i_core_dac_soft_7_ 0.0685f
Ctic4383 i_core_dac_soft_3_ i_core_iptat 0.0005f
Ctic4384 i_core_dac_soft_3_ i_core_isense__Xi_core_u_trip 0.0065f
Ctic4385 i_core_dac_soft_3_ i_core_osc_clk 0.0095f
Ctic4386 i_core_dac_soft_3_ i_core_osc_en 0.0065f
Ctic4387 i_core_dac_soft_3_ i_core_osc_trim_0_ 0.0055f
Ctic4388 i_core_dac_soft_3_ i_core_osc_trim_1_ 0.0065f
Ctic4389 i_core_dac_soft_3_ i_core_osc_trim_2_ 0.0225f
Ctic4390 i_core_dac_soft_3_ i_core_osc_trim_3_ 0.007f
Ctic4391 i_core_dac_soft_3_ i_core_sclk_i 0.0125f
Ctic4392 i_core_dac_soft_3_ i_core_sdo_o 0.004f
Ctic4393 i_core_dac_soft_3_ i_core_vref 0.0085f
Ctic4394 i_core_dac_soft_3_ i_core_vref_buf__Xi_core_u_trip 0.008f
Ctic4395 i_core_dac_soft_3_ net 0.0005f
Ctic4396 i_core_dac_soft_3___Xi_core_u_trip i_core_dac_soft_4___Xi_core_u_trip 0.1285f
Ctic4397 i_core_dac_soft_3___Xi_core_u_trip i_core_dac_soft_5___Xi_core_u_trip 1.434f
Ctic4398 i_core_dac_soft_3___Xi_core_u_trip i_core_dac_soft_6___Xi_core_u_trip 0.007f
Ctic4399 i_core_dac_soft_3___Xi_core_u_trip i_core_dac_soft_7___Xi_core_u_trip 0.0685f
Ctic4400 i_core_dac_soft_3___Xi_core_u_trip i_core_iptat__Xi_core_u_sense 0.0005f
Ctic4401 i_core_dac_soft_3___Xi_core_u_trip i_core_isense 0.0065f
Ctic4402 i_core_dac_soft_3___Xi_core_u_trip i_core_osc_clk__Xi_core_u_osc 0.0095f
Ctic4403 i_core_dac_soft_3___Xi_core_u_trip i_core_osc_en 0.0065f
Ctic4404 i_core_dac_soft_3___Xi_core_u_trip i_core_osc_trim_0_ 0.0055f
Ctic4405 i_core_dac_soft_3___Xi_core_u_trip i_core_osc_trim_1_ 0.0065f
Ctic4406 i_core_dac_soft_3___Xi_core_u_trip i_core_osc_trim_2_ 0.0225f
Ctic4407 i_core_dac_soft_3___Xi_core_u_trip i_core_osc_trim_3_ 0.007f
Ctic4408 i_core_dac_soft_3___Xi_core_u_trip i_core_sclk_i 0.0125f
Ctic4409 i_core_dac_soft_3___Xi_core_u_trip i_core_sdo_o 0.004f
Ctic4410 i_core_dac_soft_3___Xi_core_u_trip i_core_vref__Xi_core_u_sense 0.0085f
Ctic4411 i_core_dac_soft_3___Xi_core_u_trip i_core_vref_buf 0.008f
Ctic4412 i_core_dac_soft_3___Xi_core_u_trip net 0.0005f
Ctic4413 i_core_dac_soft_4_ i_core_dac_soft_5_ 0.521f
Ctic4414 i_core_dac_soft_4_ i_core_dac_soft_6_ 0.088f
Ctic4415 i_core_dac_soft_4_ i_core_dac_soft_7_ 0.1335f
Ctic4416 i_core_dac_soft_4_ i_core_iptat 0.019f
Ctic4417 i_core_dac_soft_4_ i_core_isense__Xi_core_u_trip 0.007f
Ctic4418 i_core_dac_soft_4_ i_core_osc_clk 0.013f
Ctic4419 i_core_dac_soft_4_ i_core_osc_en 0.0095f
Ctic4420 i_core_dac_soft_4_ i_core_osc_trim_0_ 0.008f
Ctic4421 i_core_dac_soft_4_ i_core_osc_trim_1_ 0.008f
Ctic4422 i_core_dac_soft_4_ i_core_osc_trim_2_ 0.015f
Ctic4423 i_core_dac_soft_4_ i_core_osc_trim_3_ 0.008f
Ctic4424 i_core_dac_soft_4_ i_core_sdo_o 0.026f
Ctic4425 i_core_dac_soft_4_ i_core_vref 0.012f
Ctic4426 i_core_dac_soft_4_ i_core_vref_buf__Xi_core_u_trip 0.941f
Ctic4427 i_core_dac_soft_4___Xi_core_u_trip i_core_dac_soft_5___Xi_core_u_trip 0.521f
Ctic4428 i_core_dac_soft_4___Xi_core_u_trip i_core_dac_soft_6___Xi_core_u_trip 0.088f
Ctic4429 i_core_dac_soft_4___Xi_core_u_trip i_core_dac_soft_7___Xi_core_u_trip 0.1335f
Ctic4430 i_core_dac_soft_4___Xi_core_u_trip i_core_iptat__Xi_core_u_sense 0.019f
Ctic4431 i_core_dac_soft_4___Xi_core_u_trip i_core_isense 0.007f
Ctic4432 i_core_dac_soft_4___Xi_core_u_trip i_core_osc_clk__Xi_core_u_osc 0.013f
Ctic4433 i_core_dac_soft_4___Xi_core_u_trip i_core_osc_en 0.0095f
Ctic4434 i_core_dac_soft_4___Xi_core_u_trip i_core_osc_trim_0_ 0.008f
Ctic4435 i_core_dac_soft_4___Xi_core_u_trip i_core_osc_trim_1_ 0.008f
Ctic4436 i_core_dac_soft_4___Xi_core_u_trip i_core_osc_trim_2_ 0.015f
Ctic4437 i_core_dac_soft_4___Xi_core_u_trip i_core_osc_trim_3_ 0.008f
Ctic4438 i_core_dac_soft_4___Xi_core_u_trip i_core_sdo_o 0.026f
Ctic4439 i_core_dac_soft_4___Xi_core_u_trip i_core_vref__Xi_core_u_sense 0.012f
Ctic4440 i_core_dac_soft_4___Xi_core_u_trip i_core_vref_buf 0.941f
Ctic4441 i_core_dac_soft_5_ i_core_dac_soft_6_ 0.163f
Ctic4442 i_core_dac_soft_5_ i_core_dac_soft_7_ 3.0115f
Ctic4443 i_core_dac_soft_5_ i_core_iptat 0.032f
Ctic4444 i_core_dac_soft_5_ i_core_isense__Xi_core_u_trip 0.0065f
Ctic4445 i_core_dac_soft_5_ i_core_osc_clk 0.013f
Ctic4446 i_core_dac_soft_5_ i_core_osc_en 0.0095f
Ctic4447 i_core_dac_soft_5_ i_core_osc_trim_0_ 0.0065f
Ctic4448 i_core_dac_soft_5_ i_core_osc_trim_1_ 0.008f
Ctic4449 i_core_dac_soft_5_ i_core_osc_trim_2_ 0.026f
Ctic4450 i_core_dac_soft_5_ i_core_osc_trim_3_ 3.2465f
Ctic4451 i_core_dac_soft_5_ i_core_sdo_o 0.0145f
Ctic4452 i_core_dac_soft_5_ i_core_vref 0.01f
Ctic4453 i_core_dac_soft_5_ i_core_vref_buf__Xi_core_u_trip 0.023f
Ctic4454 i_core_dac_soft_5_ net 0.381f
Ctic4455 i_core_dac_soft_5___Xi_core_u_trip i_core_dac_soft_6___Xi_core_u_trip 0.163f
Ctic4456 i_core_dac_soft_5___Xi_core_u_trip i_core_dac_soft_7___Xi_core_u_trip 3.0115f
Ctic4457 i_core_dac_soft_5___Xi_core_u_trip i_core_iptat__Xi_core_u_sense 0.032f
Ctic4458 i_core_dac_soft_5___Xi_core_u_trip i_core_isense 0.0065f
Ctic4459 i_core_dac_soft_5___Xi_core_u_trip i_core_osc_clk__Xi_core_u_osc 0.013f
Ctic4460 i_core_dac_soft_5___Xi_core_u_trip i_core_osc_en 0.0095f
Ctic4461 i_core_dac_soft_5___Xi_core_u_trip i_core_osc_trim_0_ 0.0065f
Ctic4462 i_core_dac_soft_5___Xi_core_u_trip i_core_osc_trim_1_ 0.008f
Ctic4463 i_core_dac_soft_5___Xi_core_u_trip i_core_osc_trim_2_ 0.026f
Ctic4464 i_core_dac_soft_5___Xi_core_u_trip i_core_osc_trim_3_ 3.2465f
Ctic4465 i_core_dac_soft_5___Xi_core_u_trip i_core_sdo_o 0.0145f
Ctic4466 i_core_dac_soft_5___Xi_core_u_trip i_core_vref__Xi_core_u_sense 0.01f
Ctic4467 i_core_dac_soft_5___Xi_core_u_trip i_core_vref_buf 0.023f
Ctic4468 i_core_dac_soft_5___Xi_core_u_trip net 0.381f
Ctic4469 i_core_dac_soft_6_ i_core_dac_soft_7_ 0.602f
Ctic4470 i_core_dac_soft_6_ i_core_iptat 0.0005f
Ctic4471 i_core_dac_soft_6_ i_core_isense__Xi_core_u_trip 0.0065f
Ctic4472 i_core_dac_soft_6_ i_core_osc_clk 0.103f
Ctic4473 i_core_dac_soft_6_ i_core_osc_en 0.0165f
Ctic4474 i_core_dac_soft_6_ i_core_osc_trim_0_ 0.011f
Ctic4475 i_core_dac_soft_6_ i_core_osc_trim_1_ 0.0115f
Ctic4476 i_core_dac_soft_6_ i_core_osc_trim_2_ 0.0255f
Ctic4477 i_core_dac_soft_6_ i_core_osc_trim_3_ 0.0125f
Ctic4478 i_core_dac_soft_6_ i_core_sdo_o 4.197f
Ctic4479 i_core_dac_soft_6_ i_core_vref 0.0165f
Ctic4480 i_core_dac_soft_6_ i_core_vref_buf__Xi_core_u_trip 0.012f
Ctic4481 i_core_dac_soft_6___Xi_core_u_trip i_core_dac_soft_7___Xi_core_u_trip 0.602f
Ctic4482 i_core_dac_soft_6___Xi_core_u_trip i_core_iptat__Xi_core_u_sense 0.0005f
Ctic4483 i_core_dac_soft_6___Xi_core_u_trip i_core_isense 0.0065f
Ctic4484 i_core_dac_soft_6___Xi_core_u_trip i_core_osc_clk__Xi_core_u_osc 0.103f
Ctic4485 i_core_dac_soft_6___Xi_core_u_trip i_core_osc_en 0.0165f
Ctic4486 i_core_dac_soft_6___Xi_core_u_trip i_core_osc_trim_0_ 0.011f
Ctic4487 i_core_dac_soft_6___Xi_core_u_trip i_core_osc_trim_1_ 0.0115f
Ctic4488 i_core_dac_soft_6___Xi_core_u_trip i_core_osc_trim_2_ 0.0255f
Ctic4489 i_core_dac_soft_6___Xi_core_u_trip i_core_osc_trim_3_ 0.0125f
Ctic4490 i_core_dac_soft_6___Xi_core_u_trip i_core_sdo_o 4.197f
Ctic4491 i_core_dac_soft_6___Xi_core_u_trip i_core_vref__Xi_core_u_sense 0.0165f
Ctic4492 i_core_dac_soft_6___Xi_core_u_trip i_core_vref_buf 0.012f
Ctic4493 i_core_dac_soft_7_ i_core_iptat 0.0005f
Ctic4494 i_core_dac_soft_7_ i_core_isense__Xi_core_u_trip 0.0095f
Ctic4495 i_core_dac_soft_7_ i_core_osc_clk 0.0165f
Ctic4496 i_core_dac_soft_7_ i_core_osc_en 0.013f
Ctic4497 i_core_dac_soft_7_ i_core_osc_trim_0_ 0.007f
Ctic4498 i_core_dac_soft_7_ i_core_osc_trim_1_ 1.5705f
Ctic4499 i_core_dac_soft_7_ i_core_osc_trim_2_ 0.0165f
Ctic4500 i_core_dac_soft_7_ i_core_osc_trim_3_ 1.576f
Ctic4501 i_core_dac_soft_7_ i_core_sdo_o 0.112f
Ctic4502 i_core_dac_soft_7_ i_core_vref 0.0105f
Ctic4503 i_core_dac_soft_7_ i_core_vref_buf__Xi_core_u_trip 0.015f
Ctic4504 i_core_dac_soft_7_ net 0.0005f
Ctic4505 i_core_dac_soft_7___Xi_core_u_trip i_core_iptat__Xi_core_u_sense 0.0005f
Ctic4506 i_core_dac_soft_7___Xi_core_u_trip i_core_isense 0.0095f
Ctic4507 i_core_dac_soft_7___Xi_core_u_trip i_core_osc_clk__Xi_core_u_osc 0.0165f
Ctic4508 i_core_dac_soft_7___Xi_core_u_trip i_core_osc_en 0.013f
Ctic4509 i_core_dac_soft_7___Xi_core_u_trip i_core_osc_trim_0_ 0.007f
Ctic4510 i_core_dac_soft_7___Xi_core_u_trip i_core_osc_trim_1_ 1.5705f
Ctic4511 i_core_dac_soft_7___Xi_core_u_trip i_core_osc_trim_2_ 0.0165f
Ctic4512 i_core_dac_soft_7___Xi_core_u_trip i_core_osc_trim_3_ 1.576f
Ctic4513 i_core_dac_soft_7___Xi_core_u_trip i_core_sdo_o 0.112f
Ctic4514 i_core_dac_soft_7___Xi_core_u_trip i_core_vref__Xi_core_u_sense 0.0105f
Ctic4515 i_core_dac_soft_7___Xi_core_u_trip i_core_vref_buf 0.015f
Ctic4516 i_core_dac_soft_7___Xi_core_u_trip net 0.0005f
Ctic4517 i_core_dvbe__Xi_core_u_bgr i_core_sdo_o 0.0005f
Ctic4518 i_core_dvbe__Xi_core_u_bgr i_core_sdo_o__Xpad16_sdo 0.0005f
Ctic4519 i_core_fast_en i_core_osc_clk 1.3175f
Ctic4520 i_core_fast_en i_core_osc_en 0.044f
Ctic4521 i_core_fast_en i_core_osc_trim_3_ 0.115f
Ctic4522 i_core_fast_en i_core_t2f_en_12 0.022f
Ctic4523 i_core_fast_en i_core_t2f_mode_12 0.014f
Ctic4524 i_core_fast_en i_core_trip_d 1.2025f
Ctic4526 i_core_fast_en__Xi_core_u_gate i_core_osc_clk 1.3175f
Ctic4527 i_core_fast_en__Xi_core_u_gate i_core_osc_en 0.044f
Ctic4528 i_core_fast_en__Xi_core_u_gate i_core_osc_trim_3_ 0.115f
Ctic4529 i_core_fast_en__Xi_core_u_gate i_core_t2f_en_12__Xi_core_u_ls_en 0.022f
Ctic4530 i_core_fast_en__Xi_core_u_gate i_core_t2f_mode_12__Xi_core_u_ls_mode 0.014f
Ctic4531 i_core_fast_en__Xi_core_u_gate i_core_trip_d__Xi_core_u_gate 1.2025f
Ctic4533 i_core_iptat i_core_isense__Xi_core_u_trip 5.4915f
Ctic4534 i_core_iptat i_core_osc_clk__Xi_core_u_osc 0.016f
Ctic4535 i_core_iptat i_core_osc_en__Xi_core_u_osc 0.0125f
Ctic4536 i_core_iptat i_core_osc_trim_0___Xi_core_u_osc 0.011f
Ctic4537 i_core_iptat i_core_osc_trim_1___Xi_core_u_osc 0.0125f
Ctic4538 i_core_iptat i_core_osc_trim_2___Xi_core_u_osc 0.022f
Ctic4539 i_core_iptat i_core_osc_trim_3___Xi_core_u_osc 0.0125f
Ctic4540 i_core_iptat i_core_pbias 0.1855f
Ctic4542 i_core_iptat i_core_sdo_o 0.029f
Ctic4543 i_core_iptat i_core_t2f_en_33__Xi_core_u_t2f 0.009f
Ctic4544 i_core_iptat i_core_t2f_mode_33__Xi_core_u_t2f 0.009f
Ctic4545 i_core_iptat i_core_tripped__Xi_core_u_gate 0.0095f
Ctic4546 i_core_iptat i_core_vref 0.2265f
Ctic4547 i_core_iptat i_core_vref_buf__Xi_core_u_trip 0.143f
Ctic4548 i_core_iptat net 0.012f
Ctic4549 i_core_iptat__Xi_core_u_sense i_core_isense 5.4915f
Ctic4550 i_core_iptat__Xi_core_u_sense i_core_osc_clk__Xi_core_u_osc 0.016f
Ctic4551 i_core_iptat__Xi_core_u_sense i_core_osc_en 0.0125f
Ctic4552 i_core_iptat__Xi_core_u_sense i_core_osc_trim_0_ 0.011f
Ctic4553 i_core_iptat__Xi_core_u_sense i_core_osc_trim_1_ 0.0125f
Ctic4554 i_core_iptat__Xi_core_u_sense i_core_osc_trim_2_ 0.022f
Ctic4555 i_core_iptat__Xi_core_u_sense i_core_osc_trim_3_ 0.0125f
Ctic4556 i_core_iptat__Xi_core_u_sense i_core_pbias 0.1855f
Ctic4558 i_core_iptat__Xi_core_u_sense i_core_sdo_o 0.029f
Ctic4559 i_core_iptat__Xi_core_u_sense i_core_t2f_en_33 0.009f
Ctic4560 i_core_iptat__Xi_core_u_sense i_core_t2f_mode_33 0.009f
Ctic4561 i_core_iptat__Xi_core_u_sense i_core_tripped__Xi_core_u_gate 0.0095f
Ctic4562 i_core_iptat__Xi_core_u_sense i_core_vref__Xi_core_u_sense 0.2265f
Ctic4563 i_core_iptat__Xi_core_u_sense i_core_vref_buf 0.143f
Ctic4564 i_core_iptat__Xi_core_u_sense net 0.012f
Ctic4565 i_core_isense i_core_pbias 0.0255f
Ctic4566 i_core_isense i_core_t2f_en_33 0.008f
Ctic4567 i_core_isense i_core_t2f_mode_33 0.008f
Ctic4568 i_core_isense i_core_tripped__Xi_core_u_gate 0.008f
Ctic4569 i_core_isense i_core_vref__Xi_core_u_sense 0.0145f
Ctic4570 i_core_isense i_core_vref_buf 13.9285f
Ctic4571 i_core_isense net 0.011f
Ctic4572 i_core_isense__Xi_core_u_trip i_core_pbias 0.0255f
Ctic4573 i_core_isense__Xi_core_u_trip i_core_t2f_en_33__Xi_core_u_t2f 0.008f
Ctic4574 i_core_isense__Xi_core_u_trip i_core_t2f_mode_33__Xi_core_u_t2f 0.008f
Ctic4575 i_core_isense__Xi_core_u_trip i_core_tripped__Xi_core_u_gate 0.008f
Ctic4576 i_core_isense__Xi_core_u_trip i_core_vref 0.0145f
Ctic4577 i_core_isense__Xi_core_u_trip i_core_vref_buf__Xi_core_u_trip 13.9285f
Ctic4578 i_core_isense__Xi_core_u_trip net 0.011f
Ctic4579 i_core_osc_clk i_core_osc_en 7.487f
Ctic4580 i_core_osc_clk i_core_osc_trim_0_ 0.0255f
Ctic4581 i_core_osc_clk i_core_osc_trim_1_ 7.4945f
Ctic4582 i_core_osc_clk i_core_osc_trim_2_ 1.4035f
Ctic4583 i_core_osc_clk i_core_osc_trim_3_ 13.9255f
Ctic4584 i_core_osc_clk i_core_pbias 0.017f
Ctic4585 i_core_osc_clk i_core_pcasc 0.015f
Ctic4586 i_core_osc_clk i_core_sdi_i 0.846f
Ctic4587 i_core_osc_clk i_core_sdo_o 0.065f
Ctic4588 i_core_osc_clk i_core_t2f_en_12__Xi_core_u_ls_en 0.1005f
Ctic4589 i_core_osc_clk i_core_t2f_mode_12__Xi_core_u_ls_mode 0.062f
Ctic4590 i_core_osc_clk i_core_trip_d__Xi_core_u_gate 3.697f
Ctic4591 i_core_osc_clk i_core_tripped 0.213f
Ctic4592 i_core_osc_clk i_core_vref__Xi_core_u_sense 19.156f
Ctic4593 i_core_osc_clk net 0.0345f
Ctic4594 i_core_osc_clk__Xi_core_u_osc i_core_osc_en__Xi_core_u_osc 7.487f
Ctic4595 i_core_osc_clk__Xi_core_u_osc i_core_osc_trim_0___Xi_core_u_osc 0.0255f
Ctic4596 i_core_osc_clk__Xi_core_u_osc i_core_osc_trim_1___Xi_core_u_osc 7.4945f
Ctic4597 i_core_osc_clk__Xi_core_u_osc i_core_osc_trim_2___Xi_core_u_osc 1.4035f
Ctic4598 i_core_osc_clk__Xi_core_u_osc i_core_osc_trim_3___Xi_core_u_osc 13.9255f
Ctic4599 i_core_osc_clk__Xi_core_u_osc i_core_pbias__Xi_core_u_t2f 0.017f
Ctic4600 i_core_osc_clk__Xi_core_u_osc i_core_pcasc__Xi_core_u_t2f 0.015f
Ctic4601 i_core_osc_clk__Xi_core_u_osc i_core_sdi_i__retained_fullchip_sg13g2_antennanp_1024_320_891_000 0.846f
Ctic4602 i_core_osc_clk__Xi_core_u_osc i_core_sdo_o__Xpad16_sdo 0.065f
Ctic4603 i_core_osc_clk__Xi_core_u_osc i_core_t2f_en_12 0.1005f
Ctic4604 i_core_osc_clk__Xi_core_u_osc i_core_t2f_mode_12 0.062f
Ctic4605 i_core_osc_clk__Xi_core_u_osc i_core_trip_d 3.697f
Ctic4606 i_core_osc_clk__Xi_core_u_osc i_core_tripped__retained_fullchip_sg13g2_antennanp_1027_200_891_000 0.213f
Ctic4607 i_core_osc_clk__Xi_core_u_osc i_core_vref__Xpad18_vref 19.156f
Ctic4608 i_core_osc_clk__Xi_core_u_osc net__Xi_core_u_digital_1 0.0345f
Ctic4609 i_core_osc_en i_core_osc_trim_0_ 0.1215f
Ctic4610 i_core_osc_en i_core_osc_trim_1_ 3.1435f
Ctic4611 i_core_osc_en i_core_osc_trim_2_ 0.196f
Ctic4612 i_core_osc_en i_core_osc_trim_3_ 25.3265f
Ctic4613 i_core_osc_en i_core_pbias 0.0125f
Ctic4614 i_core_osc_en i_core_pcasc 0.011f
Ctic4615 i_core_osc_en i_core_sdi_i 0.015f
Ctic4616 i_core_osc_en i_core_sdo_o 0.1025f
Ctic4617 i_core_osc_en i_core_t2f_en_12 0.015f
Ctic4618 i_core_osc_en i_core_t2f_mode_12 0.015f
Ctic4619 i_core_osc_en i_core_trip_d 0.0125f
Ctic4620 i_core_osc_en i_core_tripped 0.0425f
Ctic4621 i_core_osc_en i_core_vref__Xi_core_u_sense 0.0235f
Ctic4622 i_core_osc_en net 0.158f
Ctic4623 i_core_osc_en__Xi_core_u_osc i_core_osc_trim_0___Xi_core_u_osc 0.1215f
Ctic4624 i_core_osc_en__Xi_core_u_osc i_core_osc_trim_1___Xi_core_u_osc 3.1435f
Ctic4625 i_core_osc_en__Xi_core_u_osc i_core_osc_trim_2___Xi_core_u_osc 0.196f
Ctic4626 i_core_osc_en__Xi_core_u_osc i_core_osc_trim_3___Xi_core_u_osc 25.3265f
Ctic4627 i_core_osc_en__Xi_core_u_osc i_core_pbias 0.0125f
Ctic4628 i_core_osc_en__Xi_core_u_osc i_core_pcasc 0.011f
Ctic4629 i_core_osc_en__Xi_core_u_osc i_core_sdi_i__Xpad15_sdi 0.015f
Ctic4630 i_core_osc_en__Xi_core_u_osc i_core_sdo_o__Xpad16_sdo 0.1025f
Ctic4631 i_core_osc_en__Xi_core_u_osc i_core_t2f_en_12 0.015f
Ctic4632 i_core_osc_en__Xi_core_u_osc i_core_t2f_mode_12 0.015f
Ctic4633 i_core_osc_en__Xi_core_u_osc i_core_trip_d 0.0125f
Ctic4634 i_core_osc_en__Xi_core_u_osc i_core_tripped__retained_fullchip_sg13g2_antennanp_1027_200_891_000 0.0425f
Ctic4635 i_core_osc_en__Xi_core_u_osc i_core_vref 0.0235f
Ctic4636 i_core_osc_en__Xi_core_u_osc net__Xi_core_u_digital_1 0.158f
Ctic4637 i_core_osc_trim_0_ i_core_osc_trim_1_ 23.237f
Ctic4638 i_core_osc_trim_0_ i_core_osc_trim_2_ 0.7475f
Ctic4639 i_core_osc_trim_0_ i_core_osc_trim_3_ 0.0355f
Ctic4640 i_core_osc_trim_0_ i_core_pbias 0.011f
Ctic4641 i_core_osc_trim_0_ i_core_pcasc 0.2695f
Ctic4642 i_core_osc_trim_0_ i_core_sdi_i 0.021f
Ctic4643 i_core_osc_trim_0_ i_core_sdo_o 0.478f
Ctic4644 i_core_osc_trim_0_ i_core_tripped 0.0265f
Ctic4645 i_core_osc_trim_0_ i_core_vref__Xi_core_u_sense 13.709f
Ctic4646 i_core_osc_trim_0_ net 0.011f
Ctic4647 i_core_osc_trim_0___Xi_core_u_osc i_core_osc_trim_1___Xi_core_u_osc 23.237f
Ctic4648 i_core_osc_trim_0___Xi_core_u_osc i_core_osc_trim_2___Xi_core_u_osc 0.7475f
Ctic4649 i_core_osc_trim_0___Xi_core_u_osc i_core_osc_trim_3___Xi_core_u_osc 0.0355f
Ctic4650 i_core_osc_trim_0___Xi_core_u_osc i_core_pbias 0.011f
Ctic4651 i_core_osc_trim_0___Xi_core_u_osc i_core_pcasc 0.2695f
Ctic4652 i_core_osc_trim_0___Xi_core_u_osc i_core_sdi_i__Xpad15_sdi 0.021f
Ctic4653 i_core_osc_trim_0___Xi_core_u_osc i_core_sdo_o__Xpad16_sdo 0.478f
Ctic4654 i_core_osc_trim_0___Xi_core_u_osc i_core_tripped__retained_fullchip_sg13g2_antennanp_1027_200_891_000 0.0265f
Ctic4655 i_core_osc_trim_0___Xi_core_u_osc i_core_vref 13.709f
Ctic4656 i_core_osc_trim_0___Xi_core_u_osc net__Xi_core_u_digital_1 0.011f
Ctic4657 i_core_osc_trim_1_ i_core_osc_trim_2_ 0.104f
Ctic4658 i_core_osc_trim_1_ i_core_osc_trim_3_ 5.6405f
Ctic4659 i_core_osc_trim_1_ i_core_pbias 0.012f
Ctic4660 i_core_osc_trim_1_ i_core_pcasc 0.0115f
Ctic4661 i_core_osc_trim_1_ i_core_sdi_i 0.0155f
Ctic4662 i_core_osc_trim_1_ i_core_sdo_o 0.1825f
Ctic4663 i_core_osc_trim_1_ i_core_t2f_en_12 0.11f
Ctic4664 i_core_osc_trim_1_ i_core_t2f_mode_12 0.0285f
Ctic4665 i_core_osc_trim_1_ i_core_trip_d 1.979f
Ctic4666 i_core_osc_trim_1_ i_core_tripped 0.193f
Ctic4667 i_core_osc_trim_1_ i_core_vref__Xi_core_u_sense 6.3825f
Ctic4668 i_core_osc_trim_1_ net 0.2145f
Ctic4669 i_core_osc_trim_1___Xi_core_u_osc i_core_osc_trim_2___Xi_core_u_osc 0.104f
Ctic4670 i_core_osc_trim_1___Xi_core_u_osc i_core_osc_trim_3___Xi_core_u_osc 5.6405f
Ctic4671 i_core_osc_trim_1___Xi_core_u_osc i_core_pbias 0.012f
Ctic4672 i_core_osc_trim_1___Xi_core_u_osc i_core_pcasc 0.0115f
Ctic4673 i_core_osc_trim_1___Xi_core_u_osc i_core_sdi_i__Xpad15_sdi 0.0155f
Ctic4674 i_core_osc_trim_1___Xi_core_u_osc i_core_sdo_o__Xpad16_sdo 0.1825f
Ctic4675 i_core_osc_trim_1___Xi_core_u_osc i_core_t2f_en_12 0.11f
Ctic4676 i_core_osc_trim_1___Xi_core_u_osc i_core_t2f_mode_12 0.0285f
Ctic4677 i_core_osc_trim_1___Xi_core_u_osc i_core_trip_d 1.979f
Ctic4678 i_core_osc_trim_1___Xi_core_u_osc i_core_tripped__retained_fullchip_sg13g2_antennanp_1027_200_891_000 0.193f
Ctic4679 i_core_osc_trim_1___Xi_core_u_osc i_core_vref 6.3825f
Ctic4680 i_core_osc_trim_1___Xi_core_u_osc net__Xi_core_u_digital_1 0.2145f
Ctic4681 i_core_osc_trim_2_ i_core_osc_trim_3_ 0.172f
Ctic4682 i_core_osc_trim_2_ i_core_pbias 6.7055f
Ctic4683 i_core_osc_trim_2_ i_core_pcasc 0.013f
Ctic4684 i_core_osc_trim_2_ i_core_sdi_i 0.019f
Ctic4685 i_core_osc_trim_2_ i_core_tripped 0.023f
Ctic4686 i_core_osc_trim_2_ i_core_vref__Xi_core_u_sense 0.0325f
Ctic4687 i_core_osc_trim_2_ i_core_vref_buf 0.623f
Ctic4688 i_core_osc_trim_2_ net 0.0195f
Ctic4689 i_core_osc_trim_2___Xi_core_u_osc i_core_osc_trim_3___Xi_core_u_osc 0.172f
Ctic4690 i_core_osc_trim_2___Xi_core_u_osc i_core_pbias 6.7055f
Ctic4691 i_core_osc_trim_2___Xi_core_u_osc i_core_pcasc 0.013f
Ctic4692 i_core_osc_trim_2___Xi_core_u_osc i_core_sdi_i__Xpad15_sdi 0.019f
Ctic4693 i_core_osc_trim_2___Xi_core_u_osc i_core_tripped__retained_fullchip_sg13g2_antennanp_1027_200_891_000 0.023f
Ctic4694 i_core_osc_trim_2___Xi_core_u_osc i_core_vref 0.0325f
Ctic4695 i_core_osc_trim_2___Xi_core_u_osc i_core_vref_buf__Xi_core_u_trip 0.623f
Ctic4696 i_core_osc_trim_2___Xi_core_u_osc net__Xi_core_u_digital_1 0.0195f
Ctic4697 i_core_osc_trim_3_ i_core_pbias 0.0125f
Ctic4698 i_core_osc_trim_3_ i_core_pcasc 0.0095f
Ctic4699 i_core_osc_trim_3_ i_core_sdi_i 0.013f
Ctic4700 i_core_osc_trim_3_ i_core_sdo_o 0.133f
Ctic4701 i_core_osc_trim_3_ i_core_t2f_en_12 0.0115f
Ctic4702 i_core_osc_trim_3_ i_core_t2f_mode_12 0.0115f
Ctic4703 i_core_osc_trim_3_ i_core_trip_d 0.01f
Ctic4704 i_core_osc_trim_3_ i_core_tripped 0.215f
Ctic4705 i_core_osc_trim_3_ i_core_vref__Xi_core_u_sense 6.38f
Ctic4706 i_core_osc_trim_3_ net 3.2695f
Ctic4707 i_core_osc_trim_3___Xi_core_u_osc i_core_pbias 0.0125f
Ctic4708 i_core_osc_trim_3___Xi_core_u_osc i_core_pcasc 0.0095f
Ctic4709 i_core_osc_trim_3___Xi_core_u_osc i_core_sdi_i__Xpad15_sdi 0.013f
Ctic4710 i_core_osc_trim_3___Xi_core_u_osc i_core_sdo_o__Xpad16_sdo 0.133f
Ctic4711 i_core_osc_trim_3___Xi_core_u_osc i_core_t2f_en_12 0.0115f
Ctic4712 i_core_osc_trim_3___Xi_core_u_osc i_core_t2f_mode_12 0.0115f
Ctic4713 i_core_osc_trim_3___Xi_core_u_osc i_core_trip_d 0.01f
Ctic4714 i_core_osc_trim_3___Xi_core_u_osc i_core_tripped__retained_fullchip_sg13g2_antennanp_1027_200_891_000 0.215f
Ctic4715 i_core_osc_trim_3___Xi_core_u_osc i_core_vref 6.38f
Ctic4716 i_core_osc_trim_3___Xi_core_u_osc net__Xi_core_u_digital_1 3.2695f
Ctic4717 i_core_pbias i_core_pcasc 36.229f
Ctic4718 i_core_pbias i_core_sdi_i__Xpad15_sdi 0.323f
Ctic4719 i_core_pbias i_core_sdo_o 0.0245f
Ctic4720 i_core_pbias i_core_t2f_en_33__Xi_core_u_t2f 0.063f
Ctic4721 i_core_pbias i_core_t2f_mode_33__Xi_core_u_t2f 1.501f
Ctic4722 i_core_pbias i_core_vref 19.417f
Ctic4723 i_core_pbias i_core_vref__Xi_core_u_t2f 0.0305f
Ctic4724 i_core_pbias i_core_vref_buf__Xi_core_u_trip 0.0975f
Ctic4725 i_core_pbias__Xi_core_u_t2f i_core_pcasc__Xi_core_u_t2f 36.229f
Ctic4726 i_core_pbias__Xi_core_u_t2f i_core_sdi_i__retained_fullchip_sg13g2_antennanp_1024_320_891_000 0.323f
Ctic4727 i_core_pbias__Xi_core_u_t2f i_core_sdo_o__Xpad16_sdo 0.0245f
Ctic4728 i_core_pbias__Xi_core_u_t2f i_core_t2f_en_33__Xi_core_u_t2f 0.063f
Ctic4729 i_core_pbias__Xi_core_u_t2f i_core_t2f_mode_33__Xi_core_u_t2f 1.501f
Ctic4730 i_core_pbias__Xi_core_u_t2f i_core_vref__Xi_core_u_t2f 0.0305f
Ctic4731 i_core_pbias__Xi_core_u_t2f i_core_vref__Xpad18_vref 19.417f
Ctic4732 i_core_pbias__Xi_core_u_t2f i_core_vref_buf__Xi_core_u_trip 0.0975f
Ctic4733 i_core_pcasc i_core_sdi_i__Xpad15_sdi 0.0455f
Ctic4734 i_core_pcasc i_core_sdo_o 0.188f
Ctic4735 i_core_pcasc i_core_t2f_en_33__Xi_core_u_t2f 0.1605f
Ctic4736 i_core_pcasc i_core_t2f_mode_33__Xi_core_u_t2f 0.038f
Ctic4737 i_core_pcasc i_core_vref 0.26f
Ctic4738 i_core_pcasc i_core_vref__Xi_core_u_t2f 0.015f
Ctic4739 i_core_pcasc__Xi_core_u_t2f i_core_sdi_i__retained_fullchip_sg13g2_antennanp_1024_320_891_000 0.0455f
Ctic4740 i_core_pcasc__Xi_core_u_t2f i_core_sdo_o__Xpad16_sdo 0.188f
Ctic4741 i_core_pcasc__Xi_core_u_t2f i_core_t2f_en_33__Xi_core_u_t2f 0.1605f
Ctic4742 i_core_pcasc__Xi_core_u_t2f i_core_t2f_mode_33__Xi_core_u_t2f 0.038f
Ctic4743 i_core_pcasc__Xi_core_u_t2f i_core_vref__Xi_core_u_t2f 0.015f
Ctic4744 i_core_pcasc__Xi_core_u_t2f i_core_vref__Xpad18_vref 0.26f
Ctic4745 i_core_sclk_i i_core_sdi_i 24.5355f
Ctic4746 i_core_sclk_i i_core_trip_set__Xpad13_trip_set 0.0145f
Ctic4747 i_core_sclk_i__Xpad14_sclk i_core_sdi_i 0.0106667f
Ctic4748 i_core_sclk_i__Xpad14_sclk i_core_sdi_i__Xpad15_sdi 24.5462f
Ctic4749 i_core_sclk_i__Xpad14_sclk i_core_sdi_i__retained_fullchip_sg13g2_antennanp_1024_320_891_000 0.0106667f
Ctic4750 i_core_sclk_i__Xpad14_sclk i_core_trip_set__Xpad13_trip_set 0.0145f
Ctic4751 i_core_sdi_i i_core_sdo_o 0.286333f
Ctic4752 i_core_sdi_i i_core_sdo_o__Xpad16_sdo 0.00533333f
Ctic4753 i_core_sdi_i i_core_trip_set__Xpad13_trip_set 0.034f
Ctic4754 i_core_sdi_i i_core_tripped 0.00433333f
Ctic4755 i_core_sdi_i i_core_vref 0.0486667f
Ctic4756 i_core_sdi_i__Xpad15_sdi i_core_sdo_o__Xpad16_sdo 0.291667f
Ctic4757 i_core_sdi_i__Xpad15_sdi i_core_trip_set__Xpad13_trip_set 0.034f
Ctic4758 i_core_sdi_i__Xpad15_sdi i_core_tripped__Xi_core_u_gate 0.00433333f
Ctic4759 i_core_sdi_i__Xpad15_sdi i_core_vref 0.0486667f
Ctic4760 i_core_sdi_i__retained_fullchip_sg13g2_antennanp_1024_320_891_000 i_core_sdo_o__Xpad16_sdo 0.291667f
Ctic4761 i_core_sdi_i__retained_fullchip_sg13g2_antennanp_1024_320_891_000 i_core_trip_set__Xpad13_trip_set 0.034f
Ctic4762 i_core_sdi_i__retained_fullchip_sg13g2_antennanp_1024_320_891_000 i_core_tripped__retained_fullchip_sg13g2_antennanp_1027_200_891_000 0.00433333f
Ctic4763 i_core_sdi_i__retained_fullchip_sg13g2_antennanp_1024_320_891_000 i_core_vref__Xpad18_vref 0.0486667f
Ctic4764 i_core_sdo_o i_core_vref 0.628f
Ctic4765 i_core_sdo_o__Xpad16_sdo i_core_vref 0.628f
Ctic4766 i_core_t2f_en_12 i_core_t2f_mode_12 8.451f
Ctic4767 i_core_t2f_en_12 i_core_trip_d 0.052f
Ctic4768 i_core_t2f_en_12 i_core_tripped 3.2085f
Ctic4769 i_core_t2f_en_12 net 0.008f
Ctic4770 i_core_t2f_en_12__Xi_core_u_ls_en i_core_t2f_mode_12__Xi_core_u_ls_mode 8.451f
Ctic4771 i_core_t2f_en_12__Xi_core_u_ls_en i_core_trip_d__Xi_core_u_gate 0.052f
Ctic4772 i_core_t2f_en_12__Xi_core_u_ls_en i_core_tripped 3.2085f
Ctic4773 i_core_t2f_en_12__Xi_core_u_ls_en net 0.008f
Ctic4774 i_core_t2f_en_33 i_core_t2f_mode_12__Xi_core_u_ls_mode 3.164f
Ctic4775 i_core_t2f_en_33 i_core_t2f_mode_33 40.6035f
Ctic4776 i_core_t2f_en_33 i_core_temp_out_o__Xpad17_temp_out 0.251f
Ctic4777 i_core_t2f_en_33 i_core_tripped 0.2085f
Ctic4778 i_core_t2f_en_33 i_core_vref__Xi_core_u_sense 0.0165f
Ctic4779 i_core_t2f_en_33 i_core_vref__Xi_core_u_t2f 0.0105f
Ctic4780 i_core_t2f_en_33 i_core_vref_buf 0.012f
Ctic4781 i_core_t2f_en_33 net 27.6395f
Ctic4782 i_core_t2f_en_33__Xi_core_u_t2f i_core_t2f_mode_12 3.164f
Ctic4783 i_core_t2f_en_33__Xi_core_u_t2f i_core_t2f_mode_33__Xi_core_u_t2f 40.6035f
Ctic4784 i_core_t2f_en_33__Xi_core_u_t2f i_core_temp_out_o 0.251f
Ctic4785 i_core_t2f_en_33__Xi_core_u_t2f i_core_tripped__retained_fullchip_sg13g2_antennanp_1027_200_891_000 0.2085f
Ctic4786 i_core_t2f_en_33__Xi_core_u_t2f i_core_vref__Xi_core_u_t2f 0.0105f
Ctic4787 i_core_t2f_en_33__Xi_core_u_t2f i_core_vref__Xpad18_vref 0.0165f
Ctic4788 i_core_t2f_en_33__Xi_core_u_t2f i_core_vref_buf__Xi_core_u_trip 0.012f
Ctic4789 i_core_t2f_en_33__Xi_core_u_t2f net__Xi_core_u_digital_1 27.6395f
Ctic4790 i_core_t2f_mode_12 i_core_t2f_mode_33 0.0005f
Ctic4791 i_core_t2f_mode_12 i_core_trip_d 0.0155f
Ctic4792 i_core_t2f_mode_12 i_core_tripped 0.0135f
Ctic4793 i_core_t2f_mode_12__Xi_core_u_ls_mode i_core_t2f_mode_33 0.0005f
Ctic4794 i_core_t2f_mode_12__Xi_core_u_ls_mode i_core_trip_d__Xi_core_u_gate 0.0155f
Ctic4795 i_core_t2f_mode_12__Xi_core_u_ls_mode i_core_tripped 0.0135f
Ctic4796 i_core_t2f_mode_33 i_core_tripped 25.717f
Ctic4797 i_core_t2f_mode_33 i_core_vref__Xi_core_u_sense 0.017f
Ctic4798 i_core_t2f_mode_33 i_core_vref_buf 0.012f
Ctic4799 i_core_t2f_mode_33 net 0.0135f
Ctic4800 i_core_t2f_mode_33__Xi_core_u_t2f i_core_tripped__retained_fullchip_sg13g2_antennanp_1027_200_891_000 25.717f
Ctic4801 i_core_t2f_mode_33__Xi_core_u_t2f i_core_vref__Xpad18_vref 0.017f
Ctic4802 i_core_t2f_mode_33__Xi_core_u_t2f i_core_vref_buf__Xi_core_u_trip 0.012f
Ctic4803 i_core_t2f_mode_33__Xi_core_u_t2f net__Xi_core_u_digital_1 0.0135f
Ctic4804 i_core_temp_out_o i_core_vref__Xpad18_vref 0.0375f
Ctic4805 i_core_temp_out_o__Xpad17_temp_out i_core_vref__Xpad18_vref 0.0375f
Ctic4806 i_core_trip_d i_core_tripped 0.087f
Ctic4807 i_core_trip_d__Xi_core_u_gate i_core_tripped 0.087f
Ctic4808 i_core_tripped i_core_vref__Xi_core_u_sense 0.0123333f
Ctic4809 i_core_tripped i_core_vref_buf 0.008f
Ctic4810 i_core_tripped net 0.934667f
Ctic4811 i_core_tripped__Xi_core_u_gate i_core_vref__Xi_core_u_sense 0.0123333f
Ctic4812 i_core_tripped__Xi_core_u_gate i_core_vref_buf 0.008f
Ctic4813 i_core_tripped__Xi_core_u_gate net 0.934667f
Ctic4814 i_core_tripped__retained_fullchip_sg13g2_antennanp_1027_200_891_000 i_core_vref__Xpad18_vref 0.0123333f
Ctic4815 i_core_tripped__retained_fullchip_sg13g2_antennanp_1027_200_891_000 i_core_vref_buf 0.008f
Ctic4816 i_core_tripped__retained_fullchip_sg13g2_antennanp_1027_200_891_000 net__Xi_core_u_digital_1 0.934667f
Ctic4817 i_core_vref i_core_vref_buf__Xi_core_u_trip 0.0123333f
Ctic4818 i_core_vref net 0.222f
Ctic4819 i_core_vref__Xi_core_u_sense i_core_vref_buf 0.0123333f
Ctic4820 i_core_vref__Xi_core_u_sense net 0.222f
Ctic4821 i_core_vref__Xpad18_vref i_core_vref_buf__Xi_core_u_trip 0.0123333f
Ctic4822 i_core_vref__Xpad18_vref net__Xi_core_u_digital_1 0.222f
Ctic4823 i_core_vref_buf net 0.015f
Ctic4824 i_core_vref_buf__Xi_core_u_trip net 0.015f
