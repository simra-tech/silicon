* Extracted by KLayout with SG13G2 LVS runset on : 19/09/2026 13:02

.SUBCKT g1_dose_macro D_ELT D_STD G_SHARED vss
M$1 vss G_SHARED D_STD vss sg13_lv_nmos L=0.13u W=3.98u AS=1.3532p AD=1.3532p
+ PS=8.64u PD=8.64u rfmode=0
M$2 vss G_SHARED D_ELT vss sg13_hv_nmos L=0.45u W=3.98u AS=1.3532p AD=1.3532p
+ PS=8.64u PD=8.64u rfmode=0
.ENDS g1_dose_macro
