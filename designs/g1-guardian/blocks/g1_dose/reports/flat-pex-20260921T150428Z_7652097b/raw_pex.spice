*********************************************************
*** NGSPICE file created by KLayout-PEX 0.3.12
*** -----------------------------------------------------
***     Extraction Engine: KPEX/2.5D
***     Technology: ihp_sg13g2
***     Date: 2026-09-21 17:04:39
*********************************************************

.SUBCKT g1_dose_macro D_ELT D_STD G_SHARED vss
M$1 D_STD G_SHARED vss vss sg13_lv_nmos L=0.13U W=3.98U AS=1.3532P AD=1.3532P
+ PS=8.64U PD=8.64U rfmode=0
M$2 D_ELT G_SHARED vss vss sg13_hv_nmos L=0.45U W=3.98U AS=1.3532P AD=1.3532P
+ PS=8.64U PD=8.64U rfmode=0
Cext_1 D_ELT D_STD 183.569a
Cext_2 D_ELT G_SHARED 452.582a
Cext_3 D_ELT vss 641.602a
Cext_4 D_ELT VSUBS 893.031a
Cext_5 D_STD G_SHARED 101.248a
Cext_6 D_STD vss 1.15067f
Cext_7 D_STD VSUBS 1.66786f
Cext_8 G_SHARED vss 508.305a
Cext_9 G_SHARED VSUBS 2.14893f
Cext_10 VSUBS vss 5.52927f
.ENDS g1_dose_macro
