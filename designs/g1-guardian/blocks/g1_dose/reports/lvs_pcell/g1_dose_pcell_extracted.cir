* Extracted by KLayout with SG13G2 LVS runset on : 18/09/2026 20:40

.SUBCKT g1_dose_pair_pcell D_ELT D_STD G_SHARED VSS
M$1 VSS G_SHARED D_STD VSS sg13_lv_nmos L=0.13u W=3.98u AS=1.3532p AD=1.3532p
+ PS=8.64u PD=8.64u rfmode=0
M$2 VSS G_SHARED D_ELT VSS sg13_hv_nmos L=0.45u W=3.98u AS=1.3532p AD=1.3532p
+ PS=8.64u PD=8.64u rfmode=0
.ENDS g1_dose_pair_pcell
