* Derived from ../reports/lvs_pair/g1_dose_extracted.cir by make_sim_netlist.sh (device names and pin order edited for ngspice, see script)
* Extracted by KLayout with SG13G2 LVS runset on : 18/09/2026 20:29

.SUBCKT g1_dose_pair D_ELT D_STD G_SHARED VSS
XMELT D_ELT G_SHARED VSS VSS sg13_lv_nmos L=0.496231155779u W=3.98u AS=3.231p
+ AD=0.1764p PS=15.26u PD=1.68u rfmode=0
XMSTD D_STD G_SHARED VSS VSS sg13_lv_nmos L=0.5u W=3.98u AS=1.3532p AD=1.3532p
+ PS=8.64u PD=8.64u rfmode=0
.ENDS g1_dose_pair
