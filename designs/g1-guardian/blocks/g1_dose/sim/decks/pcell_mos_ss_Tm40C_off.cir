* G1_DOSE g1_dose_pair_pcell off-current baseline: corner mos_ss, T = -40 C
.lib /foss/pdks/ihp-sg13g2/libs.tech/ngspice/models/cornerMOSlv.lib mos_ss
.lib /foss/pdks/ihp-sg13g2/libs.tech/ngspice/models/cornerMOShv.lib mos_ss
.include ../g1_dose_pair_pcell_extracted.cir
.option gmin=1e-16 abstol=1e-16 reltol=1e-4
.temp -40
X1 D_ELT D_STD G_SHARED VSS g1_dose_pair_pcell
Vg G_SHARED 0 dc 0
Vs VSS 0 dc 0
Vda D_ELT 0 dc 0.1
Vdb D_STD 0 dc 0.1
.control
pre_osdi /foss/pdks/ihp-sg13g2/libs.tech/ngspice/osdi/psp103.osdi
set filetype=ascii
set wr_singlescale
set wr_vecnames
alter vda dc = 0.1
alter vdb dc = 0.1
op
let id_hv_v01 = -i(vda)
let id_lv_v01 = -i(vdb)
let ratio_v01 = id_lv_v01/id_hv_v01
print id_hv_v01 id_lv_v01 ratio_v01
alter vda dc = 1.2
alter vdb dc = 1.2
op
let id_hv_v12 = -i(vda)
let id_lv_v12 = -i(vdb)
let ratio_v12 = id_lv_v12/id_hv_v12
print id_hv_v12 id_lv_v12 ratio_v12
alter vda dc = 3.3
op
let id_hv_v33 = -i(vda)
print id_hv_v33
alter vda dc = 0.1
alter vdb dc = 0.1
dc Vg -0.3 3.3 0.01
let id_hv = -i(vda)
let id_lv = -i(vdb)
wrdata pcell_mos_ss_Tm40C_idvg_v01.dat id_hv id_lv
.endc
.end
