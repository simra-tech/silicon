* ngspice translation of raw_pex.spice
* Source SHA256 1f005f77f09d98d63fb279ad776ee8067a728846d4c96e0b5d52c9953078cfeb
.SUBCKT g1_dose_macro D_ELT D_STD G_SHARED vss
XM1 D_STD G_SHARED vss vss sg13_lv_nmos L=0.13U W=3.98U AS=1.3532P AD=1.3532P PS=8.64U PD=8.64U rfmode=0 mm_ok=0
XM2 D_ELT G_SHARED vss vss sg13_hv_nmos L=0.45U W=3.98U AS=1.3532P AD=1.3532P PS=8.64U PD=8.64U rfmode=0 mm_ok=0
Cext_1 D_ELT D_STD 1.83569e-16
Cext_2 D_ELT G_SHARED 4.52582e-16
Cext_3 D_ELT vss 6.41602e-16
Cext_4 D_ELT vss 8.93031e-16
Cext_5 D_STD G_SHARED 1.01248e-16
Cext_6 D_STD vss 1.15067f
Cext_7 D_STD vss 1.66786f
Cext_8 G_SHARED vss 5.08305e-16
Cext_9 G_SHARED vss 2.14893f
Cext_10 vss vss 5.52927f
.ENDS g1_dose_macro
