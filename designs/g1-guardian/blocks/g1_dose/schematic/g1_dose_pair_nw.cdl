* G1_DOSE optional variant: narrow and wide LV NMOS at minimum L, shared gate, source and body on VSS.
* Narrow drain on the pad named D_ELT (pin 21), wide drain on D_STD (pin 20).
.subckt g1_dose_pair_nw D_ELT D_STD G_SHARED VSS
MNARROW D_ELT G_SHARED VSS VSS sg13_lv_nmos w=0.3u l=0.13u ng=1 m=1
MWIDE D_STD G_SHARED VSS VSS sg13_lv_nmos w=3.98u l=0.13u ng=1 m=1
.ends g1_dose_pair_nw
