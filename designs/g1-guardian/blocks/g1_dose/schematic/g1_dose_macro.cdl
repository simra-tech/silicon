* G1_DOSE macro netlist (CDL) for LVS of layout/g1_dose_macro.gds: the g1_dose_pair_pcell devices with the
* macro pin names (Metal3 stubs G_SHARED, D_STD, D_ELT on the west edge; vss bar on the south edge).
.subckt g1_dose_macro D_ELT D_STD G_SHARED vss
MHV D_ELT G_SHARED vss vss sg13_hv_nmos w=3.98u l=0.45u ng=1 m=1
MLV D_STD G_SHARED vss vss sg13_lv_nmos w=3.98u l=0.13u ng=1 m=1
.ends g1_dose_macro
