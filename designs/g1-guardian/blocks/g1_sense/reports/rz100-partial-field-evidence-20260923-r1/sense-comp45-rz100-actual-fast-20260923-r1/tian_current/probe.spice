** sch_path: ${CONTAINER_REPOSITORY_ROOT}/designs/g1-guardian/blocks/g1_sense/schematic/g1_sense.sch
.subckt g1_sense sense_p sense_n vref iptat isense vped vref_buf vdd vss
*.ipin sense_p
*.ipin sense_n
*.ipin vref
*.ipin iptat
*.opin isense
*.opin vped
*.opin vref_buf
*.iopin vdd
*.iopin vss
XR1N0 sense_n vn vss rppd w=2u l=76.7u m=1 b=0 mm_ok=1
XR2N0 vn R2N_0 vss rppd w=2u l=76.7u m=1 b=0 mm_ok=1
XR2N1 R2N_0 R2N_1 vss rppd w=2u l=76.7u m=1 b=0 mm_ok=1
XR2N2 R2N_1 R2N_2 vss rppd w=2u l=76.7u m=1 b=0 mm_ok=1
XR2N3 R2N_2 R2N_3 vss rppd w=2u l=76.7u m=1 b=0 mm_ok=1
XR2N4 R2N_3 R2N_4 vss rppd w=2u l=76.7u m=1 b=0 mm_ok=1
XR2N5 R2N_4 R2N_5 vss rppd w=2u l=76.7u m=1 b=0 mm_ok=1
XR2N6 R2N_5 R2N_6 vss rppd w=2u l=76.7u m=1 b=0 mm_ok=1
XR2N7 R2N_6 R2N_7 vss rppd w=2u l=76.7u m=1 b=0 mm_ok=1
XR2N8 R2N_7 R2N_8 vss rppd w=2u l=76.7u m=1 b=0 mm_ok=1
XR2N9 R2N_8 R2N_9 vss rppd w=2u l=76.7u m=1 b=0 mm_ok=1
XR2N10 R2N_9 R2N_10 vss rppd w=2u l=76.7u m=1 b=0 mm_ok=1
XR2N11 R2N_10 R2N_11 vss rppd w=2u l=76.7u m=1 b=0 mm_ok=1
XR2N12 R2N_11 R2N_12 vss rppd w=2u l=76.7u m=1 b=0 mm_ok=1
XR2N13 R2N_12 R2N_13 vss rppd w=2u l=76.7u m=1 b=0 mm_ok=1
XR2N14 R2N_13 R2N_14 vss rppd w=2u l=76.7u m=1 b=0 mm_ok=1
XR2N15 R2N_14 R2N_15 vss rppd w=2u l=76.7u m=1 b=0 mm_ok=1
XR2N16 R2N_15 R2N_16 vss rppd w=2u l=76.7u m=1 b=0 mm_ok=1
XR2N17 R2N_16 R2N_17 vss rppd w=2u l=76.7u m=1 b=0 mm_ok=1
XR2N18 R2N_17 R2N_18 vss rppd w=2u l=76.7u m=1 b=0 mm_ok=1
XR2N19 R2N_18 isense vss rppd w=2u l=76.7u m=1 b=0 mm_ok=1
XR1P0 sense_p vp vss rppd w=2u l=76.7u m=1 b=0 mm_ok=1
XR2P0 vp R2P_0 vss rppd w=2u l=76.7u m=1 b=0 mm_ok=1
XR2P1 R2P_0 R2P_1 vss rppd w=2u l=76.7u m=1 b=0 mm_ok=1
XR2P2 R2P_1 R2P_2 vss rppd w=2u l=76.7u m=1 b=0 mm_ok=1
XR2P3 R2P_2 R2P_3 vss rppd w=2u l=76.7u m=1 b=0 mm_ok=1
XR2P4 R2P_3 R2P_4 vss rppd w=2u l=76.7u m=1 b=0 mm_ok=1
XR2P5 R2P_4 R2P_5 vss rppd w=2u l=76.7u m=1 b=0 mm_ok=1
XR2P6 R2P_5 R2P_6 vss rppd w=2u l=76.7u m=1 b=0 mm_ok=1
XR2P7 R2P_6 R2P_7 vss rppd w=2u l=76.7u m=1 b=0 mm_ok=1
XR2P8 R2P_7 R2P_8 vss rppd w=2u l=76.7u m=1 b=0 mm_ok=1
XR2P9 R2P_8 R2P_9 vss rppd w=2u l=76.7u m=1 b=0 mm_ok=1
XR2P10 R2P_9 R2P_10 vss rppd w=2u l=76.7u m=1 b=0 mm_ok=1
XR2P11 R2P_10 R2P_11 vss rppd w=2u l=76.7u m=1 b=0 mm_ok=1
XR2P12 R2P_11 R2P_12 vss rppd w=2u l=76.7u m=1 b=0 mm_ok=1
XR2P13 R2P_12 R2P_13 vss rppd w=2u l=76.7u m=1 b=0 mm_ok=1
XR2P14 R2P_13 R2P_14 vss rppd w=2u l=76.7u m=1 b=0 mm_ok=1
XR2P15 R2P_14 R2P_15 vss rppd w=2u l=76.7u m=1 b=0 mm_ok=1
XR2P16 R2P_15 R2P_16 vss rppd w=2u l=76.7u m=1 b=0 mm_ok=1
XR2P17 R2P_16 R2P_17 vss rppd w=2u l=76.7u m=1 b=0 mm_ok=1
XR2P18 R2P_17 R2P_18 vss rppd w=2u l=76.7u m=1 b=0 mm_ok=1
XR2P19 R2P_18 vped vss rppd w=2u l=76.7u m=1 b=0 mm_ok=1
XRD10 vref_buf RD1_0 vss rppd w=2u l=76.7u m=1 b=0 mm_ok=1
XRD11 RD1_0 vped_ref vss rppd w=2u l=76.7u m=1 b=0 mm_ok=1
XRD20 vped_ref RD2_0 vss rppd w=2u l=76.7u m=1 b=0 mm_ok=1
XRD21 RD2_0 RD2_1 vss rppd w=2u l=76.7u m=1 b=0 mm_ok=1
XRD22 RD2_1 RD2_2 vss rppd w=2u l=76.7u m=1 b=0 mm_ok=1
XRD23 RD2_2 RD2_3 vss rppd w=2u l=76.7u m=1 b=0 mm_ok=1
XRD24 RD2_3 RD2_4 vss rppd w=2u l=76.7u m=1 b=0 mm_ok=1
XRD25 RD2_4 RD2_5 vss rppd w=2u l=76.7u m=1 b=0 mm_ok=1
XRD26 RD2_5 RD2_6 vss rppd w=2u l=76.7u m=1 b=0 mm_ok=1
XRD27 RD2_6 RD2_7 vss rppd w=2u l=76.7u m=1 b=0 mm_ok=1
XRD28 RD2_7 RD2_8 vss rppd w=2u l=76.7u m=1 b=0 mm_ok=1
XRD29 RD2_8 RD2_9 vss rppd w=2u l=76.7u m=1 b=0 mm_ok=1
XRD210 RD2_9 RD2_10 vss rppd w=2u l=76.7u m=1 b=0 mm_ok=1
XRD211 RD2_10 RD2_11 vss rppd w=2u l=76.7u m=1 b=0 mm_ok=1
XRD212 RD2_11 RD2_12 vss rppd w=2u l=76.7u m=1 b=0 mm_ok=1
XRD213 RD2_12 RD2_13 vss rppd w=2u l=76.7u m=1 b=0 mm_ok=1
XRD214 RD2_13 RD2_14 vss rppd w=2u l=76.7u m=1 b=0 mm_ok=1
XRD215 RD2_14 RD2_15 vss rppd w=2u l=76.7u m=1 b=0 mm_ok=1
XRD216 RD2_15 RD2_16 vss rppd w=2u l=76.7u m=1 b=0 mm_ok=1
XRD217 RD2_16 RD2_17 vss rppd w=2u l=76.7u m=1 b=0 mm_ok=1
XRD218 RD2_17 RD2_18 vss rppd w=2u l=76.7u m=1 b=0 mm_ok=1
XRD219 RD2_18 RD2_19 vss rppd w=2u l=76.7u m=1 b=0 mm_ok=1
XRD220 RD2_19 RD2_20 vss rppd w=2u l=76.7u m=1 b=0 mm_ok=1
XRD221 RD2_20 RD2_21 vss rppd w=2u l=76.7u m=1 b=0 mm_ok=1
XRD222 RD2_21 RD2_22 vss rppd w=2u l=76.7u m=1 b=0 mm_ok=1
XRD223 RD2_22 RD2_23 vss rppd w=2u l=76.7u m=1 b=0 mm_ok=1
XRD224 RD2_23 RD2_24 vss rppd w=2u l=76.7u m=1 b=0 mm_ok=1
XRD225 RD2_24 RD2_25 vss rppd w=2u l=76.7u m=1 b=0 mm_ok=1
XRD226 RD2_25 RD2_26 vss rppd w=2u l=76.7u m=1 b=0 mm_ok=1
XRD227 RD2_26 RD2_27 vss rppd w=2u l=76.7u m=1 b=0 mm_ok=1
XRD228 RD2_27 RD2_28 vss rppd w=2u l=76.7u m=1 b=0 mm_ok=1
XRD229 RD2_28 RD2_29 vss rppd w=2u l=76.7u m=1 b=0 mm_ok=1
XRD230 RD2_29 RD2_30 vss rppd w=2u l=76.7u m=1 b=0 mm_ok=1
XRD231 RD2_30 RD2_31 vss rppd w=2u l=76.7u m=1 b=0 mm_ok=1
XRD232 RD2_31 RD2_32 vss rppd w=2u l=76.7u m=1 b=0 mm_ok=1
XRD233 RD2_32 RD2_33 vss rppd w=2u l=76.7u m=1 b=0 mm_ok=1
XRD234 RD2_33 RD2_34 vss rppd w=2u l=76.7u m=1 b=0 mm_ok=1
XRD235 RD2_34 RD2_35 vss rppd w=2u l=76.7u m=1 b=0 mm_ok=1
XRD236 RD2_35 RD2_36 vss rppd w=2u l=76.7u m=1 b=0 mm_ok=1
XRD237 RD2_36 RD2_37 vss rppd w=2u l=76.7u m=1 b=0 mm_ok=1
XRD238 RD2_37 RD2_38 vss rppd w=2u l=76.7u m=1 b=0 mm_ok=1
XRD239 RD2_38 RD2_39 vss rppd w=2u l=76.7u m=1 b=0 mm_ok=1
XRD240 RD2_39 RD2_40 vss rppd w=2u l=76.7u m=1 b=0 mm_ok=1
XRD241 RD2_40 RD2_41 vss rppd w=2u l=76.7u m=1 b=0 mm_ok=1
XRD242 RD2_41 RD2_42 vss rppd w=2u l=76.7u m=1 b=0 mm_ok=1
XRD243 RD2_42 RD2_43 vss rppd w=2u l=76.7u m=1 b=0 mm_ok=1
XRD244 RD2_43 RD2_44 vss rppd w=2u l=76.7u m=1 b=0 mm_ok=1
XRD245 RD2_44 RD2_45 vss rppd w=2u l=76.7u m=1 b=0 mm_ok=1
XRD246 RD2_45 RD2_46 vss rppd w=2u l=76.7u m=1 b=0 mm_ok=1
XRD247 RD2_46 RD2_47 vss rppd w=2u l=76.7u m=1 b=0 mm_ok=1
XRD248 RD2_47 RD2_48 vss rppd w=2u l=76.7u m=1 b=0 mm_ok=1
XRD249 RD2_48 RD2_49 vss rppd w=2u l=76.7u m=1 b=0 mm_ok=1
XRD250 RD2_49 vss vss rppd w=2u l=76.7u m=1 b=0 mm_ok=1
XMBI iptat iptat vss vss sg13_hv_nmos w=3.3u l=1u ng=1 m=1 mm_ok=1
XOTA vp main_loop_e iptat isense vdd vss __pex_xota_cz __pex_xota_fn __pex_xota_fp __pex_xota_mir __pex_xota_out1 __pex_xota_pc1 __pex_xota_pc2 __pex_xota_tail __pex_xota_vbnc __pex_xota_vbp __pex_xota_vbpc g1_ota_main_candidate
XBUF vped_ref vped iptat vped vdd vss __pex_xbuf_cz __pex_xbuf_fn __pex_xbuf_fp __pex_xbuf_mir __pex_xbuf_out1 __pex_xbuf_pc1 __pex_xbuf_pc2 __pex_xbuf_tail __pex_xbuf_vbnc __pex_xbuf_vbp __pex_xbuf_vbpc g1_ota
XREF vref vref_buf iptat vref_buf vdd vss __pex_xref_cz __pex_xref_fn __pex_xref_fp __pex_xref_mir __pex_xref_out1 __pex_xref_pc1 __pex_xref_pc2 __pex_xref_tail __pex_xref_vbnc __pex_xref_vbp __pex_xref_vbpc g1_ota
* Own-native incomplete R100 field; unbound VSUBS excluded explicitly.
CPRIVATE_ACTUAL_0000 iptat isense 2.6615255984145098e-14
CPRIVATE_ACTUAL_0001 iptat R2N_9 1.690455404460626e-17
CPRIVATE_ACTUAL_0002 iptat R2P_9 5.0565950495847619e-19
CPRIVATE_ACTUAL_0003 iptat RD2_38 3.864370720455729e-19
CPRIVATE_ACTUAL_0004 iptat vn 4.2836630650033384e-16
CPRIVATE_ACTUAL_0005 iptat vp 4.6440031274651938e-16
CPRIVATE_ACTUAL_0006 iptat vped_ref 2.3411821973583331e-15
CPRIVATE_ACTUAL_0007 iptat __pex_xbuf_cz 8.2708013691999869e-17
CPRIVATE_ACTUAL_0008 iptat __pex_xbuf_fn 4.5653719573276342e-15
CPRIVATE_ACTUAL_0009 iptat __pex_xbuf_fp 5.1636709312303142e-15
CPRIVATE_ACTUAL_0010 iptat __pex_xbuf_mir 7.0324010472070101e-17
CPRIVATE_ACTUAL_0011 iptat __pex_xbuf_out1 3.7809884532503612e-16
CPRIVATE_ACTUAL_0012 iptat __pex_xbuf_vbnc 1.1839588594237454e-15
CPRIVATE_ACTUAL_0013 iptat __pex_xbuf_vbp 4.533297972738636e-16
CPRIVATE_ACTUAL_0014 iptat __pex_xbuf_vbpc 5.2729691288363851e-16
CPRIVATE_ACTUAL_0015 iptat __pex_xota_cz 9.9649538357249679e-16
CPRIVATE_ACTUAL_0016 iptat __pex_xota_fn 3.1671926764013907e-14
CPRIVATE_ACTUAL_0017 iptat __pex_xota_fp 3.7619662507539279e-14
CPRIVATE_ACTUAL_0018 iptat __pex_xota_mir 6.2342127360283104e-15
CPRIVATE_ACTUAL_0019 iptat __pex_xota_out1 3.6064919468797051e-16
CPRIVATE_ACTUAL_0020 iptat __pex_xota_pc1 2.3137432591740915e-16
CPRIVATE_ACTUAL_0021 iptat __pex_xota_pc2 1.8737768456194633e-16
CPRIVATE_ACTUAL_0022 iptat __pex_xota_tail 2.951392336571695e-14
CPRIVATE_ACTUAL_0023 iptat __pex_xota_vbnc 2.79285564543474e-14
CPRIVATE_ACTUAL_0024 iptat __pex_xota_vbp 4.0218968621274552e-15
CPRIVATE_ACTUAL_0025 iptat __pex_xota_vbpc 4.0459304684824499e-15
CPRIVATE_ACTUAL_0026 iptat __pex_xref_cz 8.2708013691999869e-17
CPRIVATE_ACTUAL_0027 iptat __pex_xref_fn 4.5653719573276342e-15
CPRIVATE_ACTUAL_0028 iptat __pex_xref_fp 5.1636709312303142e-15
CPRIVATE_ACTUAL_0029 iptat __pex_xref_mir 7.0501657618695903e-17
CPRIVATE_ACTUAL_0030 iptat __pex_xref_out1 3.8416983461390832e-16
CPRIVATE_ACTUAL_0031 iptat __pex_xref_vbnc 1.1839728144248128e-15
CPRIVATE_ACTUAL_0032 iptat __pex_xref_vbp 4.5737712346644511e-16
CPRIVATE_ACTUAL_0033 iptat __pex_xref_vbpc 5.2729691288363851e-16
CPRIVATE_ACTUAL_0034 iptat vdd 8.2094601303920669e-15
CPRIVATE_ACTUAL_0035 iptat vped 3.507410281833212e-14
CPRIVATE_ACTUAL_0036 iptat vref 1.7861314616829857e-14
CPRIVATE_ACTUAL_0037 iptat vref_buf 1.0000548342164307e-14
CPRIVATE_ACTUAL_0038 iptat vss 8.6992955923918823e-14
CPRIVATE_ACTUAL_0039 isense R2N_11 3.9914859948708299e-17
CPRIVATE_ACTUAL_0040 isense R2N_13 3.9914859948708299e-17
CPRIVATE_ACTUAL_0041 isense R2N_15 4.0849154614820043e-17
CPRIVATE_ACTUAL_0042 isense R2N_17 8.0351715873014825e-17
CPRIVATE_ACTUAL_0043 isense R2N_9 1.1831471903498355e-14
CPRIVATE_ACTUAL_0044 isense R2P_11 1.5734183957006054e-17
CPRIVATE_ACTUAL_0045 isense R2P_13 1.5734183957006054e-17
CPRIVATE_ACTUAL_0046 isense R2P_15 1.5734183957006054e-17
CPRIVATE_ACTUAL_0047 isense R2P_17 1.5734183957006054e-17
CPRIVATE_ACTUAL_0048 isense R2P_9 7.1085622815423533e-15
CPRIVATE_ACTUAL_0049 isense RD2_26 1.5734183957006054e-17
CPRIVATE_ACTUAL_0050 isense RD2_28 1.5734183957006054e-17
CPRIVATE_ACTUAL_0051 isense RD2_30 1.5734183957006054e-17
CPRIVATE_ACTUAL_0052 isense RD2_32 1.5734183957006054e-17
CPRIVATE_ACTUAL_0053 isense RD2_34 1.5734183957006054e-17
CPRIVATE_ACTUAL_0054 isense RD2_36 1.5734183957006054e-17
CPRIVATE_ACTUAL_0055 isense RD2_38 5.1210801135081397e-16
CPRIVATE_ACTUAL_0056 isense vn 2.7751385006869193e-16
CPRIVATE_ACTUAL_0057 isense vp 5.4156152919417818e-16
CPRIVATE_ACTUAL_0058 isense vped_ref 9.6000647765071132e-16
CPRIVATE_ACTUAL_0059 isense __pex_xota_cz 8.9542959420307997e-15
CPRIVATE_ACTUAL_0060 isense __pex_xota_fn 3.0486554410785055e-16
CPRIVATE_ACTUAL_0061 isense __pex_xota_fp 3.5819917825519324e-16
CPRIVATE_ACTUAL_0062 isense __pex_xota_mir 2.799915549104483e-14
CPRIVATE_ACTUAL_0063 isense __pex_xota_out1 4.0096714455157356e-14
CPRIVATE_ACTUAL_0064 isense __pex_xota_pc1 3.0852136893517966e-16
CPRIVATE_ACTUAL_0065 isense __pex_xota_pc2 3.0742800966553896e-16
CPRIVATE_ACTUAL_0066 isense __pex_xota_tail 4.0413889659398023e-16
CPRIVATE_ACTUAL_0067 isense __pex_xota_vbnc 3.9823201080322138e-16
CPRIVATE_ACTUAL_0068 isense __pex_xota_vbp 4.6935722358757848e-16
CPRIVATE_ACTUAL_0069 isense __pex_xota_vbpc 6.3428532147393883e-16
CPRIVATE_ACTUAL_0070 isense vdd 6.4255665577305393e-15
CPRIVATE_ACTUAL_0071 isense vped 1.9272409783563709e-14
CPRIVATE_ACTUAL_0072 isense vref 3.7987409096432605e-17
CPRIVATE_ACTUAL_0073 isense vref_buf 1.6937704080572692e-16
CPRIVATE_ACTUAL_0074 isense vss 7.1941778665018761e-15
CPRIVATE_ACTUAL_0075 R2N_0 R2N_2 2.8783514977198263e-17
CPRIVATE_ACTUAL_0076 R2N_0 RD2_12 6.29192357589258e-17
CPRIVATE_ACTUAL_0077 R2N_0 vss 4.9335294187215841e-17
CPRIVATE_ACTUAL_0078 R2N_1 R2N_3 2.8783514977198263e-17
CPRIVATE_ACTUAL_0079 R2N_1 R2N_9 8.8626358801443755e-18
CPRIVATE_ACTUAL_0080 R2N_1 R2P_10 1.2635065365534439e-17
CPRIVATE_ACTUAL_0081 R2N_1 R2P_12 1.2635065365534439e-17
CPRIVATE_ACTUAL_0082 R2N_1 R2P_9 5.6317178357245963e-18
CPRIVATE_ACTUAL_0083 R2N_1 RD2_25 2.7969805703612976e-18
CPRIVATE_ACTUAL_0084 R2N_1 vn 1.1955712577377391e-16
CPRIVATE_ACTUAL_0085 R2N_1 vp 1.5589170767081062e-17
CPRIVATE_ACTUAL_0086 R2N_10 R2N_12 2.8783514977198263e-17
CPRIVATE_ACTUAL_0087 R2N_10 R2P_1 1.2635065365534439e-17
CPRIVATE_ACTUAL_0088 R2N_10 R2P_9 1.9395762621885486e-18
CPRIVATE_ACTUAL_0089 R2N_10 RD1_0 2.8783514977198263e-17
CPRIVATE_ACTUAL_0090 R2N_10 RD2_25 9.8244995100010629e-18
CPRIVATE_ACTUAL_0091 R2N_10 vp 1.3549095129709017e-17
CPRIVATE_ACTUAL_0092 R2N_11 R2N_13 2.8783514977198263e-17
CPRIVATE_ACTUAL_0093 R2N_11 R2N_9 4.043685592430652e-17
CPRIVATE_ACTUAL_0094 R2N_11 RD2_38 2.1309017937260634e-18
CPRIVATE_ACTUAL_0095 R2N_11 vdd 1.7765022428373586e-17
CPRIVATE_ACTUAL_0096 R2N_11 vref 4.9046063508995013e-19
CPRIVATE_ACTUAL_0097 R2N_11 vss 4.2138608744002442e-17
CPRIVATE_ACTUAL_0098 R2N_12 R2N_14 2.8783514977198263e-17
CPRIVATE_ACTUAL_0099 R2N_12 R2P_1 1.2635065365534439e-17
CPRIVATE_ACTUAL_0100 R2N_12 R2P_3 1.2635065365534439e-17
CPRIVATE_ACTUAL_0101 R2N_12 R2P_9 2.1484822244087282e-18
CPRIVATE_ACTUAL_0102 R2N_12 RD2_25 9.926013800327423e-18
CPRIVATE_ACTUAL_0103 R2N_13 R2N_15 2.8783514977198263e-17
CPRIVATE_ACTUAL_0104 R2N_13 R2N_9 9.3429466611174052e-19
CPRIVATE_ACTUAL_0105 R2N_13 RD2_38 2.1309017937260634e-18
CPRIVATE_ACTUAL_0106 R2N_13 vdd 1.7765022428373586e-17
CPRIVATE_ACTUAL_0107 R2N_13 vref 4.9046063508995013e-19
CPRIVATE_ACTUAL_0108 R2N_13 vss 4.2138608744002442e-17
CPRIVATE_ACTUAL_0109 R2N_14 R2N_16 2.8783514977198263e-17
CPRIVATE_ACTUAL_0110 R2N_14 R2P_3 1.2635065365534439e-17
CPRIVATE_ACTUAL_0111 R2N_14 R2P_5 1.2635065365534439e-17
CPRIVATE_ACTUAL_0112 R2N_14 R2P_9 2.1484822244087282e-18
CPRIVATE_ACTUAL_0113 R2N_14 RD2_25 9.926013800327423e-18
CPRIVATE_ACTUAL_0114 R2N_15 R2N_17 2.8783514977198263e-17
CPRIVATE_ACTUAL_0115 R2N_15 RD2_38 2.1309017937260634e-18
CPRIVATE_ACTUAL_0116 R2N_15 vdd 1.7765022428373586e-17
CPRIVATE_ACTUAL_0117 R2N_15 vref 4.9046063508995013e-19
CPRIVATE_ACTUAL_0118 R2N_15 vss 4.2138608744002442e-17
CPRIVATE_ACTUAL_0119 R2N_16 R2N_18 2.8783514977198263e-17
CPRIVATE_ACTUAL_0120 R2N_16 R2P_5 1.2635065365534439e-17
CPRIVATE_ACTUAL_0121 R2N_16 R2P_7 1.2635065365534439e-17
CPRIVATE_ACTUAL_0122 R2N_16 R2P_9 2.1484822244087282e-18
CPRIVATE_ACTUAL_0123 R2N_16 RD2_25 9.926013800327423e-18
CPRIVATE_ACTUAL_0124 R2N_17 RD2_38 2.1309017937260634e-18
CPRIVATE_ACTUAL_0125 R2N_17 vdd 1.7765022428373586e-17
CPRIVATE_ACTUAL_0126 R2N_17 vref 4.9046063508995013e-19
CPRIVATE_ACTUAL_0127 R2N_17 vss 4.2138608744002442e-17
CPRIVATE_ACTUAL_0128 R2N_18 R2P_7 1.2635065365534439e-17
CPRIVATE_ACTUAL_0129 R2N_18 R2P_9 1.5703432325377109e-17
CPRIVATE_ACTUAL_0130 R2N_18 RD2_25 9.8244995100010629e-18
CPRIVATE_ACTUAL_0131 R2N_18 RD2_39 2.8783514977198263e-17
CPRIVATE_ACTUAL_0132 R2N_2 R2N_4 2.8783514977198263e-17
CPRIVATE_ACTUAL_0133 R2N_2 RD2_12 2.3416674500731037e-17
CPRIVATE_ACTUAL_0134 R2N_2 vss 4.9335294187215841e-17
CPRIVATE_ACTUAL_0135 R2N_3 R2N_5 2.8783514977198263e-17
CPRIVATE_ACTUAL_0136 R2N_3 R2N_9 8.8626358801443755e-18
CPRIVATE_ACTUAL_0137 R2N_3 R2P_12 1.2635065365534439e-17
CPRIVATE_ACTUAL_0138 R2N_3 R2P_14 1.2635065365534439e-17
CPRIVATE_ACTUAL_0139 R2N_3 R2P_9 5.6317178357245963e-18
CPRIVATE_ACTUAL_0140 R2N_3 RD2_25 2.7969805703612976e-18
CPRIVATE_ACTUAL_0141 R2N_3 vn 8.0054564515579111e-17
CPRIVATE_ACTUAL_0142 R2N_3 vp 1.5589170767081062e-17
CPRIVATE_ACTUAL_0143 R2N_4 R2N_6 2.8783514977198263e-17
CPRIVATE_ACTUAL_0144 R2N_4 RD2_12 2.2482379834619296e-17
CPRIVATE_ACTUAL_0145 R2N_4 vss 4.9335294187215841e-17
CPRIVATE_ACTUAL_0146 R2N_5 R2N_7 2.8783514977198263e-17
CPRIVATE_ACTUAL_0147 R2N_5 R2N_9 9.7969305462561168e-18
CPRIVATE_ACTUAL_0148 R2N_5 R2P_14 1.2635065365534439e-17
CPRIVATE_ACTUAL_0149 R2N_5 R2P_16 1.2635065365534439e-17
CPRIVATE_ACTUAL_0150 R2N_5 R2P_9 5.6317178357245963e-18
CPRIVATE_ACTUAL_0151 R2N_5 RD2_25 2.7969805703612976e-18
CPRIVATE_ACTUAL_0152 R2N_5 vn 7.9120269849467385e-17
CPRIVATE_ACTUAL_0153 R2N_5 vp 1.5589170767081062e-17
CPRIVATE_ACTUAL_0154 R2N_6 R2N_8 2.8783514977198263e-17
CPRIVATE_ACTUAL_0155 R2N_6 RD2_12 2.2482379834619296e-17
CPRIVATE_ACTUAL_0156 R2N_6 sense_n 9.3429466611174052e-19
CPRIVATE_ACTUAL_0157 R2N_6 vss 4.9335294187215841e-17
CPRIVATE_ACTUAL_0158 R2N_7 R2N_9 4.9299491804450894e-17
CPRIVATE_ACTUAL_0159 R2N_7 R2P_16 1.2635065365534439e-17
CPRIVATE_ACTUAL_0160 R2N_7 R2P_18 1.2635065365534439e-17
CPRIVATE_ACTUAL_0161 R2N_7 R2P_9 5.6317178357245963e-18
CPRIVATE_ACTUAL_0162 R2N_7 RD2_25 2.7969805703612976e-18
CPRIVATE_ACTUAL_0163 R2N_7 vn 7.9120269849467385e-17
CPRIVATE_ACTUAL_0164 R2N_7 vp 1.5589170767081062e-17
CPRIVATE_ACTUAL_0165 R2N_8 RD2_12 2.2482379834619296e-17
CPRIVATE_ACTUAL_0166 R2N_8 sense_n 4.043685592430652e-17
CPRIVATE_ACTUAL_0167 R2N_8 vss 4.9335294187215841e-17
CPRIVATE_ACTUAL_0168 R2N_9 R2P_10 1.508630330664018e-18
CPRIVATE_ACTUAL_0169 R2N_9 R2P_11 7.9166903873169885e-17
CPRIVATE_ACTUAL_0170 R2N_9 R2P_12 1.6713957728393994e-18
CPRIVATE_ACTUAL_0171 R2N_9 R2P_13 7.9166903873169885e-17
CPRIVATE_ACTUAL_0172 R2N_9 R2P_14 1.6713957728393994e-18
CPRIVATE_ACTUAL_0173 R2N_9 R2P_15 7.9166903873169885e-17
CPRIVATE_ACTUAL_0174 R2N_9 R2P_16 1.6713957728393994e-18
CPRIVATE_ACTUAL_0175 R2N_9 R2P_17 7.9166903873169885e-17
CPRIVATE_ACTUAL_0176 R2N_9 R2P_18 1.4273531086006607e-17
CPRIVATE_ACTUAL_0177 R2N_9 R2P_9 1.6262198676925834e-14
CPRIVATE_ACTUAL_0178 R2N_9 RD2_1 8.8626358801443755e-18
CPRIVATE_ACTUAL_0179 R2N_9 RD2_11 8.640545922349876e-18
CPRIVATE_ACTUAL_0180 R2N_9 RD2_25 3.7106780481306947e-18
CPRIVATE_ACTUAL_0181 R2N_9 RD2_26 7.9166903873169885e-17
CPRIVATE_ACTUAL_0182 R2N_9 RD2_27 1.6713957728393994e-18
CPRIVATE_ACTUAL_0183 R2N_9 RD2_28 7.9166903873169885e-17
CPRIVATE_ACTUAL_0184 R2N_9 RD2_29 1.6713957728393994e-18
CPRIVATE_ACTUAL_0185 R2N_9 RD2_3 8.8626358801443755e-18
CPRIVATE_ACTUAL_0186 R2N_9 RD2_30 7.9166903873169885e-17
CPRIVATE_ACTUAL_0187 R2N_9 RD2_31 1.6713957728393994e-18
CPRIVATE_ACTUAL_0188 R2N_9 RD2_32 7.9166903873169885e-17
CPRIVATE_ACTUAL_0189 R2N_9 RD2_33 1.6713957728393994e-18
CPRIVATE_ACTUAL_0190 R2N_9 RD2_34 7.9166903873169885e-17
CPRIVATE_ACTUAL_0191 R2N_9 RD2_35 1.6713957728393994e-18
CPRIVATE_ACTUAL_0192 R2N_9 RD2_36 7.9166903873169885e-17
CPRIVATE_ACTUAL_0193 R2N_9 RD2_37 1.508630330664018e-18
CPRIVATE_ACTUAL_0194 R2N_9 RD2_38 1.3604173976232062e-16
CPRIVATE_ACTUAL_0195 R2N_9 RD2_5 8.8626358801443755e-18
CPRIVATE_ACTUAL_0196 R2N_9 RD2_7 8.8626358801443755e-18
CPRIVATE_ACTUAL_0197 R2N_9 RD2_9 8.8626358801443755e-18
CPRIVATE_ACTUAL_0198 R2N_9 vn 2.4251593589099659e-16
CPRIVATE_ACTUAL_0199 R2N_9 vp 1.0770669259983272e-14
CPRIVATE_ACTUAL_0200 R2N_9 vped_ref 1.0830403752467414e-15
CPRIVATE_ACTUAL_0201 R2N_9 vdd 4.166284047808483e-16
CPRIVATE_ACTUAL_0202 R2N_9 vped 1.4429966095487807e-16
CPRIVATE_ACTUAL_0203 R2N_9 vref 1.5174567285804876e-19
CPRIVATE_ACTUAL_0204 R2N_9 vref_buf 1.3428480160901776e-16
CPRIVATE_ACTUAL_0205 R2N_9 vss 7.0943551746523832e-16
CPRIVATE_ACTUAL_0206 R2P_0 R2P_2 2.8783514977198263e-17
CPRIVATE_ACTUAL_0207 R2P_0 RD2_12 8.945794837938531e-18
CPRIVATE_ACTUAL_0208 R2P_0 sense_n 7.9166903873169885e-17
CPRIVATE_ACTUAL_0209 R2P_0 sense_p 5.6171039881312567e-17
CPRIVATE_ACTUAL_0210 R2P_0 vss 4.9335294187215841e-17
CPRIVATE_ACTUAL_0211 R2P_1 R2P_3 2.8783514977198263e-17
CPRIVATE_ACTUAL_0212 R2P_1 R2P_9 1.4164683642597459e-17
CPRIVATE_ACTUAL_0213 R2P_1 RD2_25 2.7969805703612976e-18
CPRIVATE_ACTUAL_0214 R2P_1 vp 4.043685592430652e-17
CPRIVATE_ACTUAL_0215 R2P_10 R2P_12 2.8783514977198263e-17
CPRIVATE_ACTUAL_0216 R2P_10 R2P_9 1.9395762621885486e-18
CPRIVATE_ACTUAL_0217 R2P_10 RD2_25 5.026135543430758e-17
CPRIVATE_ACTUAL_0218 R2P_10 vn 1.3664923260308325e-17
CPRIVATE_ACTUAL_0219 R2P_10 vp 1.1216018118111733e-18
CPRIVATE_ACTUAL_0220 R2P_11 R2P_13 2.8783514977198263e-17
CPRIVATE_ACTUAL_0221 R2P_11 R2P_9 4.043685592430652e-17
CPRIVATE_ACTUAL_0222 R2P_11 RD2_38 2.1309017937260634e-18
CPRIVATE_ACTUAL_0223 R2P_11 vped_ref 2.8235277344779033e-18
CPRIVATE_ACTUAL_0224 R2P_11 vdd 1.6760039739679768e-17
CPRIVATE_ACTUAL_0225 R2P_11 vped 5.684861239089716e-18
CPRIVATE_ACTUAL_0226 R2P_11 vref 4.9046063508995013e-19
CPRIVATE_ACTUAL_0227 R2P_11 vref_buf 3.8986522990528892e-18
CPRIVATE_ACTUAL_0228 R2P_11 vss 4.2138608744002442e-17
CPRIVATE_ACTUAL_0229 R2P_12 R2P_14 2.8783514977198263e-17
CPRIVATE_ACTUAL_0230 R2P_12 R2P_9 2.1484822244087282e-18
CPRIVATE_ACTUAL_0231 R2P_12 RD2_25 1.0860308466439163e-17
CPRIVATE_ACTUAL_0232 R2P_12 vn 1.0221237089117864e-18
CPRIVATE_ACTUAL_0233 R2P_12 vp 1.2517410256440914e-18
CPRIVATE_ACTUAL_0234 R2P_13 R2P_15 2.8783514977198263e-17
CPRIVATE_ACTUAL_0235 R2P_13 R2P_9 9.3429466611174052e-19
CPRIVATE_ACTUAL_0236 R2P_13 RD2_38 2.1309017937260634e-18
CPRIVATE_ACTUAL_0237 R2P_13 vped_ref 2.8235277344779033e-18
CPRIVATE_ACTUAL_0238 R2P_13 vdd 1.6760039739679768e-17
CPRIVATE_ACTUAL_0239 R2P_13 vped 5.684861239089716e-18
CPRIVATE_ACTUAL_0240 R2P_13 vref 4.9046063508995013e-19
CPRIVATE_ACTUAL_0241 R2P_13 vref_buf 3.8986522990528892e-18
CPRIVATE_ACTUAL_0242 R2P_13 vss 4.2138608744002442e-17
CPRIVATE_ACTUAL_0243 R2P_14 R2P_16 2.8783514977198263e-17
CPRIVATE_ACTUAL_0244 R2P_14 R2P_9 2.1484822244087282e-18
CPRIVATE_ACTUAL_0245 R2P_14 RD2_25 9.926013800327423e-18
CPRIVATE_ACTUAL_0246 R2P_14 vn 1.0221237089117864e-18
CPRIVATE_ACTUAL_0247 R2P_14 vp 1.2517410256440914e-18
CPRIVATE_ACTUAL_0248 R2P_15 R2P_17 2.8783514977198263e-17
CPRIVATE_ACTUAL_0249 R2P_15 RD2_38 2.1309017937260634e-18
CPRIVATE_ACTUAL_0250 R2P_15 vped_ref 2.8235277344779033e-18
CPRIVATE_ACTUAL_0251 R2P_15 vdd 1.6760039739679768e-17
CPRIVATE_ACTUAL_0252 R2P_15 vped 6.6191559052014557e-18
CPRIVATE_ACTUAL_0253 R2P_15 vref 4.9046063508995013e-19
CPRIVATE_ACTUAL_0254 R2P_15 vref_buf 3.8986522990528892e-18
CPRIVATE_ACTUAL_0255 R2P_15 vss 4.2138608744002442e-17
CPRIVATE_ACTUAL_0256 R2P_16 R2P_18 2.8783514977198263e-17
CPRIVATE_ACTUAL_0257 R2P_16 R2P_9 2.1484822244087282e-18
CPRIVATE_ACTUAL_0258 R2P_16 RD2_25 9.926013800327423e-18
CPRIVATE_ACTUAL_0259 R2P_16 vn 1.0221237089117864e-18
CPRIVATE_ACTUAL_0260 R2P_16 vp 1.2517410256440914e-18
CPRIVATE_ACTUAL_0261 R2P_17 RD2_38 2.1309017937260634e-18
CPRIVATE_ACTUAL_0262 R2P_17 vped_ref 2.8235277344779033e-18
CPRIVATE_ACTUAL_0263 R2P_17 vdd 1.6760039739679768e-17
CPRIVATE_ACTUAL_0264 R2P_17 vped 4.6121717163396235e-17
CPRIVATE_ACTUAL_0265 R2P_17 vref 4.9046063508995013e-19
CPRIVATE_ACTUAL_0266 R2P_17 vref_buf 3.8986522990528892e-18
CPRIVATE_ACTUAL_0267 R2P_17 vss 4.2138608744002442e-17
CPRIVATE_ACTUAL_0268 R2P_18 R2P_9 1.9395762621885486e-18
CPRIVATE_ACTUAL_0269 R2P_18 RD1_0 2.8783514977198263e-17
CPRIVATE_ACTUAL_0270 R2P_18 RD2_25 9.8244995100010629e-18
CPRIVATE_ACTUAL_0271 R2P_18 vn 7.2091012016005564e-19
CPRIVATE_ACTUAL_0272 R2P_18 vp 1.1216018118111733e-18
CPRIVATE_ACTUAL_0273 R2P_2 R2P_4 2.8783514977198263e-17
CPRIVATE_ACTUAL_0274 R2P_2 RD2_12 8.945794837938531e-18
CPRIVATE_ACTUAL_0275 R2P_2 sense_n 7.9166903873169885e-17
CPRIVATE_ACTUAL_0276 R2P_2 sense_p 1.6668478623117795e-17
CPRIVATE_ACTUAL_0277 R2P_2 vss 4.9335294187215841e-17
CPRIVATE_ACTUAL_0278 R2P_3 R2P_5 2.8783514977198263e-17
CPRIVATE_ACTUAL_0279 R2P_3 R2P_9 1.4164683642597459e-17
CPRIVATE_ACTUAL_0280 R2P_3 RD2_25 2.7969805703612976e-18
CPRIVATE_ACTUAL_0281 R2P_3 vp 9.3429466611174052e-19
CPRIVATE_ACTUAL_0282 R2P_4 R2P_6 2.8783514977198263e-17
CPRIVATE_ACTUAL_0283 R2P_4 RD2_12 8.945794837938531e-18
CPRIVATE_ACTUAL_0284 R2P_4 sense_n 7.9166903873169885e-17
CPRIVATE_ACTUAL_0285 R2P_4 sense_p 1.5734183957006054e-17
CPRIVATE_ACTUAL_0286 R2P_4 vss 4.9335294187215841e-17
CPRIVATE_ACTUAL_0287 R2P_5 R2P_7 2.8783514977198263e-17
CPRIVATE_ACTUAL_0288 R2P_5 R2P_9 1.5098978308709198e-17
CPRIVATE_ACTUAL_0289 R2P_5 RD2_25 2.7969805703612976e-18
CPRIVATE_ACTUAL_0290 R2P_6 R2P_8 2.8783514977198263e-17
CPRIVATE_ACTUAL_0291 R2P_6 RD2_12 8.945794837938531e-18
CPRIVATE_ACTUAL_0292 R2P_6 sense_n 7.9166903873169885e-17
CPRIVATE_ACTUAL_0293 R2P_6 sense_p 1.5734183957006054e-17
CPRIVATE_ACTUAL_0294 R2P_6 vss 4.9335294187215841e-17
CPRIVATE_ACTUAL_0295 R2P_7 R2P_9 5.4601539566903976e-17
CPRIVATE_ACTUAL_0296 R2P_7 RD2_25 2.7969805703612976e-18
CPRIVATE_ACTUAL_0297 R2P_8 RD2_12 8.945794837938531e-18
CPRIVATE_ACTUAL_0298 R2P_8 RD2_24 2.8783514977198263e-17
CPRIVATE_ACTUAL_0299 R2P_8 sense_n 7.9166903873169885e-17
CPRIVATE_ACTUAL_0300 R2P_8 sense_p 1.5734183957006054e-17
CPRIVATE_ACTUAL_0301 R2P_8 vss 4.9335294187215841e-17
CPRIVATE_ACTUAL_0302 R2P_9 RD1_0 1.7306702999683695e-18
CPRIVATE_ACTUAL_0303 R2P_9 RD2_1 5.6317178357245963e-18
CPRIVATE_ACTUAL_0304 R2P_9 RD2_11 5.4883972300891471e-18
CPRIVATE_ACTUAL_0305 R2P_9 RD2_25 2.7259683895645207e-15
CPRIVATE_ACTUAL_0306 R2P_9 RD2_26 4.9382650762245051e-17
CPRIVATE_ACTUAL_0307 R2P_9 RD2_27 5.3976900376449027e-18
CPRIVATE_ACTUAL_0308 R2P_9 RD2_28 9.8800895040502723e-18
CPRIVATE_ACTUAL_0309 R2P_9 RD2_29 5.3976900376449027e-18
CPRIVATE_ACTUAL_0310 R2P_9 RD2_3 5.6317178357245963e-18
CPRIVATE_ACTUAL_0311 R2P_9 RD2_30 8.945794837938531e-18
CPRIVATE_ACTUAL_0312 R2P_9 RD2_31 5.3976900376449027e-18
CPRIVATE_ACTUAL_0313 R2P_9 RD2_32 8.945794837938531e-18
CPRIVATE_ACTUAL_0314 R2P_9 RD2_33 5.3976900376449027e-18
CPRIVATE_ACTUAL_0315 R2P_9 RD2_34 8.945794837938531e-18
CPRIVATE_ACTUAL_0316 R2P_9 RD2_35 5.3976900376449027e-18
CPRIVATE_ACTUAL_0317 R2P_9 RD2_36 8.945794837938531e-18
CPRIVATE_ACTUAL_0318 R2P_9 RD2_37 4.2860734388201272e-18
CPRIVATE_ACTUAL_0319 R2P_9 RD2_38 4.6914990689475601e-17
CPRIVATE_ACTUAL_0320 R2P_9 RD2_5 5.6317178357245963e-18
CPRIVATE_ACTUAL_0321 R2P_9 RD2_7 5.6317178357245963e-18
CPRIVATE_ACTUAL_0322 R2P_9 RD2_9 5.6317178357245963e-18
CPRIVATE_ACTUAL_0323 R2P_9 vn 8.2439507722598944e-18
CPRIVATE_ACTUAL_0324 R2P_9 vp 3.7285068670531056e-16
CPRIVATE_ACTUAL_0325 R2P_9 vped_ref 4.240478329713459e-15
CPRIVATE_ACTUAL_0326 R2P_9 vdd 3.8796207756386718e-16
CPRIVATE_ACTUAL_0327 R2P_9 vped 6.8968964394520173e-15
CPRIVATE_ACTUAL_0328 R2P_9 vref 6.5110804048049518e-19
CPRIVATE_ACTUAL_0329 R2P_9 vref_buf 2.0182447578558598e-17
CPRIVATE_ACTUAL_0330 R2P_9 vss 5.7425858000503889e-16
CPRIVATE_ACTUAL_0331 RD1_0 RD2_25 9.7229852196747028e-18
CPRIVATE_ACTUAL_0332 RD1_0 vn 1.3048937273000351e-17
CPRIVATE_ACTUAL_0333 RD1_0 vp 1.4292692078192708e-17
CPRIVATE_ACTUAL_0334 RD2_0 RD2_2 2.8783514977198263e-17
CPRIVATE_ACTUAL_0335 RD2_0 vss 5.0729520320669986e-17
CPRIVATE_ACTUAL_0336 RD2_1 RD2_3 2.8783514977198263e-17
CPRIVATE_ACTUAL_0337 RD2_1 RD2_35 1.2635065365534439e-17
CPRIVATE_ACTUAL_0338 RD2_1 RD2_37 1.2635065365534439e-17
CPRIVATE_ACTUAL_0339 RD2_1 vn 7.9120269849467385e-17
CPRIVATE_ACTUAL_0340 RD2_1 vp 1.5589170767081062e-17
CPRIVATE_ACTUAL_0341 RD2_1 vped_ref 4.043685592430652e-17
CPRIVATE_ACTUAL_0342 RD2_10 RD2_12 4.043685592430652e-17
CPRIVATE_ACTUAL_0343 RD2_10 RD2_8 2.8783514977198263e-17
CPRIVATE_ACTUAL_0344 RD2_10 vss 4.9335294187215841e-17
CPRIVATE_ACTUAL_0345 RD2_11 RD2_25 1.5315836310546772e-17
CPRIVATE_ACTUAL_0346 RD2_11 RD2_27 1.2635065365534439e-17
CPRIVATE_ACTUAL_0347 RD2_11 RD2_9 2.8783514977198263e-17
CPRIVATE_ACTUAL_0348 RD2_11 vn 1.1941722370266636e-16
CPRIVATE_ACTUAL_0349 RD2_11 vp 1.547574814456872e-17
CPRIVATE_ACTUAL_0350 RD2_12 RD2_14 4.9382650762245051e-17
CPRIVATE_ACTUAL_0351 RD2_12 RD2_16 9.8800895040502723e-18
CPRIVATE_ACTUAL_0352 RD2_12 RD2_18 8.945794837938531e-18
CPRIVATE_ACTUAL_0353 RD2_12 RD2_20 8.945794837938531e-18
CPRIVATE_ACTUAL_0354 RD2_12 RD2_22 8.945794837938531e-18
CPRIVATE_ACTUAL_0355 RD2_12 RD2_24 8.945794837938531e-18
CPRIVATE_ACTUAL_0356 RD2_12 RD2_8 9.3429466611174052e-19
CPRIVATE_ACTUAL_0357 RD2_12 sense_n 2.6321793889619638e-16
CPRIVATE_ACTUAL_0358 RD2_12 sense_p 8.9729832715667199e-15
CPRIVATE_ACTUAL_0359 RD2_12 vss 6.7840394054169157e-16
CPRIVATE_ACTUAL_0360 RD2_13 RD2_15 2.8783514977198263e-17
CPRIVATE_ACTUAL_0361 RD2_13 RD2_49 1.2635065365534439e-17
CPRIVATE_ACTUAL_0362 RD2_13 vss 1.3942261334541519e-18
CPRIVATE_ACTUAL_0363 RD2_14 RD2_16 2.8783514977198263e-17
CPRIVATE_ACTUAL_0364 RD2_14 sense_n 7.9166903873169885e-17
CPRIVATE_ACTUAL_0365 RD2_14 sense_p 1.5734183957006054e-17
CPRIVATE_ACTUAL_0366 RD2_14 vss 4.9335294187215841e-17
CPRIVATE_ACTUAL_0367 RD2_15 RD2_17 2.8783514977198263e-17
CPRIVATE_ACTUAL_0368 RD2_15 RD2_47 1.2635065365534439e-17
CPRIVATE_ACTUAL_0369 RD2_15 RD2_49 1.2635065365534439e-17
CPRIVATE_ACTUAL_0370 RD2_16 RD2_18 2.8783514977198263e-17
CPRIVATE_ACTUAL_0371 RD2_16 sense_n 7.9166903873169885e-17
CPRIVATE_ACTUAL_0372 RD2_16 sense_p 1.5734183957006054e-17
CPRIVATE_ACTUAL_0373 RD2_16 vss 4.9335294187215841e-17
CPRIVATE_ACTUAL_0374 RD2_17 RD2_19 2.8783514977198263e-17
CPRIVATE_ACTUAL_0375 RD2_17 RD2_45 1.2635065365534439e-17
CPRIVATE_ACTUAL_0376 RD2_17 RD2_47 1.2635065365534439e-17
CPRIVATE_ACTUAL_0377 RD2_18 RD2_20 2.8783514977198263e-17
CPRIVATE_ACTUAL_0378 RD2_18 sense_n 7.9166903873169885e-17
CPRIVATE_ACTUAL_0379 RD2_18 sense_p 1.5734183957006054e-17
CPRIVATE_ACTUAL_0380 RD2_18 vss 4.9335294187215841e-17
CPRIVATE_ACTUAL_0381 RD2_19 RD2_21 2.8783514977198263e-17
CPRIVATE_ACTUAL_0382 RD2_19 RD2_43 1.2635065365534439e-17
CPRIVATE_ACTUAL_0383 RD2_19 RD2_45 1.2635065365534439e-17
CPRIVATE_ACTUAL_0384 RD2_2 RD2_4 2.8783514977198263e-17
CPRIVATE_ACTUAL_0385 RD2_2 vss 4.9335294187215841e-17
CPRIVATE_ACTUAL_0386 RD2_20 RD2_22 2.8783514977198263e-17
CPRIVATE_ACTUAL_0387 RD2_20 sense_n 7.9166903873169885e-17
CPRIVATE_ACTUAL_0388 RD2_20 sense_p 1.5734183957006054e-17
CPRIVATE_ACTUAL_0389 RD2_20 vss 4.9335294187215841e-17
CPRIVATE_ACTUAL_0390 RD2_21 RD2_23 2.8783514977198263e-17
CPRIVATE_ACTUAL_0391 RD2_21 RD2_25 9.3429466611174052e-19
CPRIVATE_ACTUAL_0392 RD2_21 RD2_41 1.2635065365534439e-17
CPRIVATE_ACTUAL_0393 RD2_21 RD2_43 1.2635065365534439e-17
CPRIVATE_ACTUAL_0394 RD2_22 RD2_24 2.8783514977198263e-17
CPRIVATE_ACTUAL_0395 RD2_22 sense_n 7.9166903873169885e-17
CPRIVATE_ACTUAL_0396 RD2_22 sense_p 1.5734183957006054e-17
CPRIVATE_ACTUAL_0397 RD2_22 vss 4.9335294187215841e-17
CPRIVATE_ACTUAL_0398 RD2_23 RD2_25 4.043685592430652e-17
CPRIVATE_ACTUAL_0399 RD2_23 RD2_39 1.2635065365534439e-17
CPRIVATE_ACTUAL_0400 RD2_23 RD2_41 1.2635065365534439e-17
CPRIVATE_ACTUAL_0401 RD2_24 sense_n 7.9166903873169885e-17
CPRIVATE_ACTUAL_0402 RD2_24 sense_p 1.5734183957006054e-17
CPRIVATE_ACTUAL_0403 RD2_24 vss 4.9335294187215841e-17
CPRIVATE_ACTUAL_0404 RD2_25 RD2_27 4.043685592430652e-17
CPRIVATE_ACTUAL_0405 RD2_25 RD2_29 9.3429466611174052e-19
CPRIVATE_ACTUAL_0406 RD2_25 RD2_39 1.8003595913480636e-17
CPRIVATE_ACTUAL_0407 RD2_25 vn 3.5905166995635511e-18
CPRIVATE_ACTUAL_0408 RD2_25 vp 4.4775459682126928e-18
CPRIVATE_ACTUAL_0409 RD2_26 RD2_28 2.8783514977198263e-17
CPRIVATE_ACTUAL_0410 RD2_26 RD2_38 2.1309017937260634e-18
CPRIVATE_ACTUAL_0411 RD2_26 vped_ref 2.8235277344779033e-18
CPRIVATE_ACTUAL_0412 RD2_26 vdd 1.6760039739679768e-17
CPRIVATE_ACTUAL_0413 RD2_26 vped 5.684861239089716e-18
CPRIVATE_ACTUAL_0414 RD2_26 vref 4.9046063508995013e-19
CPRIVATE_ACTUAL_0415 RD2_26 vref_buf 3.8986522990528892e-18
CPRIVATE_ACTUAL_0416 RD2_26 vss 4.2138608744002442e-17
CPRIVATE_ACTUAL_0417 RD2_27 RD2_29 2.8783514977198263e-17
CPRIVATE_ACTUAL_0418 RD2_27 RD2_9 1.2635065365534439e-17
CPRIVATE_ACTUAL_0419 RD2_27 vn 1.0221237089117864e-18
CPRIVATE_ACTUAL_0420 RD2_27 vp 1.2517410256440914e-18
CPRIVATE_ACTUAL_0421 RD2_28 RD2_30 2.8783514977198263e-17
CPRIVATE_ACTUAL_0422 RD2_28 RD2_38 2.1309017937260634e-18
CPRIVATE_ACTUAL_0423 RD2_28 vped_ref 2.8235277344779033e-18
CPRIVATE_ACTUAL_0424 RD2_28 vdd 1.6760039739679768e-17
CPRIVATE_ACTUAL_0425 RD2_28 vped 5.684861239089716e-18
CPRIVATE_ACTUAL_0426 RD2_28 vref 4.9046063508995013e-19
CPRIVATE_ACTUAL_0427 RD2_28 vref_buf 3.8986522990528892e-18
CPRIVATE_ACTUAL_0428 RD2_28 vss 4.2138608744002442e-17
CPRIVATE_ACTUAL_0429 RD2_29 RD2_31 2.8783514977198263e-17
CPRIVATE_ACTUAL_0430 RD2_29 RD2_7 1.2635065365534439e-17
CPRIVATE_ACTUAL_0431 RD2_29 RD2_9 1.2635065365534439e-17
CPRIVATE_ACTUAL_0432 RD2_29 vn 1.0221237089117864e-18
CPRIVATE_ACTUAL_0433 RD2_29 vp 1.2517410256440914e-18
CPRIVATE_ACTUAL_0434 RD2_3 RD2_33 1.2635065365534439e-17
CPRIVATE_ACTUAL_0435 RD2_3 RD2_35 1.2635065365534439e-17
CPRIVATE_ACTUAL_0436 RD2_3 RD2_5 2.8783514977198263e-17
CPRIVATE_ACTUAL_0437 RD2_3 vn 7.9120269849467385e-17
CPRIVATE_ACTUAL_0438 RD2_3 vp 1.5589170767081062e-17
CPRIVATE_ACTUAL_0439 RD2_3 vped_ref 9.3429466611174052e-19
CPRIVATE_ACTUAL_0440 RD2_30 RD2_32 2.8783514977198263e-17
CPRIVATE_ACTUAL_0441 RD2_30 RD2_38 2.1309017937260634e-18
CPRIVATE_ACTUAL_0442 RD2_30 vped_ref 2.8235277344779033e-18
CPRIVATE_ACTUAL_0443 RD2_30 vdd 1.6760039739679768e-17
CPRIVATE_ACTUAL_0444 RD2_30 vped 5.684861239089716e-18
CPRIVATE_ACTUAL_0445 RD2_30 vref 4.9046063508995013e-19
CPRIVATE_ACTUAL_0446 RD2_30 vref_buf 3.8986522990528892e-18
CPRIVATE_ACTUAL_0447 RD2_30 vss 4.2138608744002442e-17
CPRIVATE_ACTUAL_0448 RD2_31 RD2_33 2.8783514977198263e-17
CPRIVATE_ACTUAL_0449 RD2_31 RD2_5 1.2635065365534439e-17
CPRIVATE_ACTUAL_0450 RD2_31 RD2_7 1.2635065365534439e-17
CPRIVATE_ACTUAL_0451 RD2_31 vn 1.0221237089117864e-18
CPRIVATE_ACTUAL_0452 RD2_31 vp 1.2517410256440914e-18
CPRIVATE_ACTUAL_0453 RD2_32 RD2_34 2.8783514977198263e-17
CPRIVATE_ACTUAL_0454 RD2_32 RD2_38 2.1309017937260634e-18
CPRIVATE_ACTUAL_0455 RD2_32 vped_ref 2.8235277344779033e-18
CPRIVATE_ACTUAL_0456 RD2_32 vdd 1.6760039739679768e-17
CPRIVATE_ACTUAL_0457 RD2_32 vped 5.684861239089716e-18
CPRIVATE_ACTUAL_0458 RD2_32 vref 4.9046063508995013e-19
CPRIVATE_ACTUAL_0459 RD2_32 vref_buf 3.8986522990528892e-18
CPRIVATE_ACTUAL_0460 RD2_32 vss 4.2138608744002442e-17
CPRIVATE_ACTUAL_0461 RD2_33 RD2_35 2.8783514977198263e-17
CPRIVATE_ACTUAL_0462 RD2_33 RD2_5 1.2635065365534439e-17
CPRIVATE_ACTUAL_0463 RD2_33 vn 1.0221237089117864e-18
CPRIVATE_ACTUAL_0464 RD2_33 vp 1.2517410256440914e-18
CPRIVATE_ACTUAL_0465 RD2_34 RD2_36 2.8783514977198263e-17
CPRIVATE_ACTUAL_0466 RD2_34 RD2_38 3.0651964598378039e-18
CPRIVATE_ACTUAL_0467 RD2_34 vped_ref 2.8235277344779033e-18
CPRIVATE_ACTUAL_0468 RD2_34 vdd 1.6760039739679768e-17
CPRIVATE_ACTUAL_0469 RD2_34 vped 5.684861239089716e-18
CPRIVATE_ACTUAL_0470 RD2_34 vref 4.9046063508995013e-19
CPRIVATE_ACTUAL_0471 RD2_34 vref_buf 3.8986522990528892e-18
CPRIVATE_ACTUAL_0472 RD2_34 vss 4.2138608744002442e-17
CPRIVATE_ACTUAL_0473 RD2_35 RD2_37 2.8783514977198263e-17
CPRIVATE_ACTUAL_0474 RD2_35 vn 1.0221237089117864e-18
CPRIVATE_ACTUAL_0475 RD2_35 vp 1.2517410256440914e-18
CPRIVATE_ACTUAL_0476 RD2_36 RD2_38 4.2567757718032579e-17
CPRIVATE_ACTUAL_0477 RD2_36 vped_ref 2.8235277344779033e-18
CPRIVATE_ACTUAL_0478 RD2_36 vdd 1.6760039739679768e-17
CPRIVATE_ACTUAL_0479 RD2_36 vped 5.684861239089716e-18
CPRIVATE_ACTUAL_0480 RD2_36 vref 4.9046063508995013e-19
CPRIVATE_ACTUAL_0481 RD2_36 vref_buf 3.8986522990528892e-18
CPRIVATE_ACTUAL_0482 RD2_36 vss 4.2138608744002442e-17
CPRIVATE_ACTUAL_0483 RD2_37 vn 7.2091012016005564e-19
CPRIVATE_ACTUAL_0484 RD2_37 vp 1.1216018118111733e-18
CPRIVATE_ACTUAL_0485 RD2_37 vped_ref 1.5528699164329555e-17
CPRIVATE_ACTUAL_0486 RD2_37 vss 2.2257870864646799e-18
CPRIVATE_ACTUAL_0487 RD2_38 RD2_40 4.043685592430652e-17
CPRIVATE_ACTUAL_0488 RD2_38 RD2_42 9.3429466611174052e-19
CPRIVATE_ACTUAL_0489 RD2_38 vped_ref 9.3470665380333308e-15
CPRIVATE_ACTUAL_0490 RD2_38 vdd 1.9160554950618814e-16
CPRIVATE_ACTUAL_0491 RD2_38 vped 4.6122827459468136e-17
CPRIVATE_ACTUAL_0492 RD2_38 vref 5.9204317158664004e-19
CPRIVATE_ACTUAL_0493 RD2_38 vref_buf 4.6359592835324238e-17
CPRIVATE_ACTUAL_0494 RD2_38 vss 1.4128334625865686e-14
CPRIVATE_ACTUAL_0495 RD2_39 RD2_41 2.8783514977198263e-17
CPRIVATE_ACTUAL_0496 RD2_4 RD2_6 2.8783514977198263e-17
CPRIVATE_ACTUAL_0497 RD2_4 vss 4.9335294187215841e-17
CPRIVATE_ACTUAL_0498 RD2_40 RD2_42 2.8783514977198263e-17
CPRIVATE_ACTUAL_0499 RD2_40 vdd 1.7765022428373586e-17
CPRIVATE_ACTUAL_0500 RD2_40 vref 4.9046063508995013e-19
CPRIVATE_ACTUAL_0501 RD2_40 vss 4.4631144879529243e-17
CPRIVATE_ACTUAL_0502 RD2_41 RD2_43 2.8783514977198263e-17
CPRIVATE_ACTUAL_0503 RD2_42 RD2_44 2.8783514977198263e-17
CPRIVATE_ACTUAL_0504 RD2_42 vdd 1.7765022428373586e-17
CPRIVATE_ACTUAL_0505 RD2_42 vref 4.9046063508995013e-19
CPRIVATE_ACTUAL_0506 RD2_42 vss 4.4631144879529243e-17
CPRIVATE_ACTUAL_0507 RD2_43 RD2_45 2.8783514977198263e-17
CPRIVATE_ACTUAL_0508 RD2_44 RD2_46 2.8783514977198263e-17
CPRIVATE_ACTUAL_0509 RD2_44 vdd 1.7765022428373586e-17
CPRIVATE_ACTUAL_0510 RD2_44 vref 4.9046063508995013e-19
CPRIVATE_ACTUAL_0511 RD2_44 vss 4.4631144879529243e-17
CPRIVATE_ACTUAL_0512 RD2_45 RD2_47 2.8783514977198263e-17
CPRIVATE_ACTUAL_0513 RD2_46 RD2_48 2.8783514977198263e-17
CPRIVATE_ACTUAL_0514 RD2_46 vdd 1.7765022428373586e-17
CPRIVATE_ACTUAL_0515 RD2_46 vref 4.9046063508995013e-19
CPRIVATE_ACTUAL_0516 RD2_46 vss 4.5565439545640982e-17
CPRIVATE_ACTUAL_0517 RD2_47 RD2_49 2.8783514977198263e-17
CPRIVATE_ACTUAL_0518 RD2_48 vdd 1.7765022428373586e-17
CPRIVATE_ACTUAL_0519 RD2_48 vref 4.9046063508995013e-19
CPRIVATE_ACTUAL_0520 RD2_48 vss 8.5068000803835763e-17
CPRIVATE_ACTUAL_0521 RD2_5 RD2_7 2.8783514977198263e-17
CPRIVATE_ACTUAL_0522 RD2_5 vn 7.9120269849467385e-17
CPRIVATE_ACTUAL_0523 RD2_5 vp 1.5589170767081062e-17
CPRIVATE_ACTUAL_0524 RD2_6 RD2_8 2.8783514977198263e-17
CPRIVATE_ACTUAL_0525 RD2_6 vss 4.9335294187215841e-17
CPRIVATE_ACTUAL_0526 RD2_7 RD2_9 2.8783514977198263e-17
CPRIVATE_ACTUAL_0527 RD2_7 vn 7.9120269849467385e-17
CPRIVATE_ACTUAL_0528 RD2_7 vp 1.5589170767081062e-17
CPRIVATE_ACTUAL_0529 RD2_8 vss 4.9335294187215841e-17
CPRIVATE_ACTUAL_0530 RD2_9 vn 8.0054564515579111e-17
CPRIVATE_ACTUAL_0531 RD2_9 vp 1.5589170767081062e-17
CPRIVATE_ACTUAL_0532 vn vp 6.562626132354483e-14
CPRIVATE_ACTUAL_0533 vn vped_ref 1.4381648704519098e-16
CPRIVATE_ACTUAL_0534 vn __pex_xota_cz 9.079180142513873e-16
CPRIVATE_ACTUAL_0535 vn __pex_xota_fn 4.3561335209921938e-14
CPRIVATE_ACTUAL_0536 vn __pex_xota_fp 3.1618770375190769e-14
CPRIVATE_ACTUAL_0537 vn __pex_xota_mir 9.8604457696627045e-17
CPRIVATE_ACTUAL_0538 vn __pex_xota_out1 1.141397783047391e-16
CPRIVATE_ACTUAL_0539 vn __pex_xota_pc1 9.6918492499306929e-17
CPRIVATE_ACTUAL_0540 vn __pex_xota_pc2 9.6835850575683233e-17
CPRIVATE_ACTUAL_0541 vn __pex_xota_tail 2.0648411821712224e-14
CPRIVATE_ACTUAL_0542 vn __pex_xota_vbnc 1.1646983073051626e-16
CPRIVATE_ACTUAL_0543 vn __pex_xota_vbp 1.5277549461676855e-16
CPRIVATE_ACTUAL_0544 vn __pex_xota_vbpc 2.1574563330401749e-16
CPRIVATE_ACTUAL_0545 vn vdd 1.2230236833787441e-14
CPRIVATE_ACTUAL_0546 vn vss 1.7778962837942165e-15
CPRIVATE_ACTUAL_0547 vp vped_ref 1.5453363689860282e-15
CPRIVATE_ACTUAL_0548 vp __pex_xota_cz 9.1117064747637111e-16
CPRIVATE_ACTUAL_0549 vp __pex_xota_fn 9.9945123758857199e-15
CPRIVATE_ACTUAL_0550 vp __pex_xota_fp 4.3017836413846952e-14
CPRIVATE_ACTUAL_0551 vp __pex_xota_mir 2.7798636647994463e-14
CPRIVATE_ACTUAL_0552 vp __pex_xota_out1 1.1525287179836214e-16
CPRIVATE_ACTUAL_0553 vp __pex_xota_pc1 9.7622807776329171e-17
CPRIVATE_ACTUAL_0554 vp __pex_xota_pc2 9.7470450981992718e-17
CPRIVATE_ACTUAL_0555 vp __pex_xota_tail 2.8345568727447257e-14
CPRIVATE_ACTUAL_0556 vp __pex_xota_vbnc 1.1657217432342224e-16
CPRIVATE_ACTUAL_0557 vp __pex_xota_vbp 1.5375576033936733e-16
CPRIVATE_ACTUAL_0558 vp __pex_xota_vbpc 2.1585429208763828e-16
CPRIVATE_ACTUAL_0559 vp vdd 1.2210324386368279e-14
CPRIVATE_ACTUAL_0560 vp vss 9.3450044840320296e-16
CPRIVATE_ACTUAL_0561 vped_ref __pex_xbuf_cz 1.6649773095857244e-15
CPRIVATE_ACTUAL_0562 vped_ref __pex_xbuf_fn 8.8140740561331286e-16
CPRIVATE_ACTUAL_0563 vped_ref __pex_xbuf_fp 8.3389034239732802e-15
CPRIVATE_ACTUAL_0564 vped_ref __pex_xbuf_mir 3.885316580127279e-17
CPRIVATE_ACTUAL_0565 vped_ref __pex_xbuf_out1 6.3150709378714865e-16
CPRIVATE_ACTUAL_0566 vped_ref __pex_xbuf_pc1 1.7131748099554916e-17
CPRIVATE_ACTUAL_0567 vped_ref __pex_xbuf_pc2 1.2066604565735062e-17
CPRIVATE_ACTUAL_0568 vped_ref __pex_xbuf_tail 7.5920782182630281e-15
CPRIVATE_ACTUAL_0569 vped_ref __pex_xbuf_vbnc 5.7581600697517837e-17
CPRIVATE_ACTUAL_0570 vped_ref __pex_xbuf_vbp 5.6935238819839289e-16
CPRIVATE_ACTUAL_0571 vped_ref __pex_xbuf_vbpc 6.0375813570473608e-17
CPRIVATE_ACTUAL_0572 vped_ref __pex_xref_out1 4.0790675471918185e-18
CPRIVATE_ACTUAL_0573 vped_ref __pex_xref_vbp 2.7193783647945457e-18
CPRIVATE_ACTUAL_0574 vped_ref vdd 4.5870439696337261e-15
CPRIVATE_ACTUAL_0575 vped_ref vped 3.8878155440726533e-14
CPRIVATE_ACTUAL_0576 vped_ref vref 5.1996849450301729e-17
CPRIVATE_ACTUAL_0577 vped_ref vref_buf 1.6070872444211998e-14
CPRIVATE_ACTUAL_0578 vped_ref vss 4.8856521988151763e-15
CPRIVATE_ACTUAL_0579 __pex_xbuf_cz __pex_xbuf_fn 4.1600358058433743e-16
CPRIVATE_ACTUAL_0580 __pex_xbuf_cz __pex_xbuf_fp 5.2178846826277083e-16
CPRIVATE_ACTUAL_0581 __pex_xbuf_cz __pex_xbuf_mir 6.8686023891370731e-16
CPRIVATE_ACTUAL_0582 __pex_xbuf_cz __pex_xbuf_out1 1.4107504939161872e-15
CPRIVATE_ACTUAL_0583 __pex_xbuf_cz __pex_xbuf_pc1 2.8419083883196668e-16
CPRIVATE_ACTUAL_0584 __pex_xbuf_cz __pex_xbuf_pc2 2.8271080657386918e-16
CPRIVATE_ACTUAL_0585 __pex_xbuf_cz __pex_xbuf_tail 2.1865838020109092e-15
CPRIVATE_ACTUAL_0586 __pex_xbuf_cz __pex_xbuf_vbnc 1.9970606836044174e-16
CPRIVATE_ACTUAL_0587 __pex_xbuf_cz __pex_xbuf_vbp 5.5545046728446318e-16
CPRIVATE_ACTUAL_0588 __pex_xbuf_cz __pex_xbuf_vbpc 1.7782430378792624e-15
CPRIVATE_ACTUAL_0589 __pex_xbuf_cz vdd 1.3660750854384457e-15
CPRIVATE_ACTUAL_0590 __pex_xbuf_cz vped 6.76330471848977e-15
CPRIVATE_ACTUAL_0591 __pex_xbuf_cz vss 5.2856044646856227e-16
CPRIVATE_ACTUAL_0592 __pex_xbuf_fn __pex_xbuf_fp 4.6644826718728916e-16
CPRIVATE_ACTUAL_0593 __pex_xbuf_fn __pex_xbuf_mir 1.6571782942453273e-15
CPRIVATE_ACTUAL_0594 __pex_xbuf_fn __pex_xbuf_out1 1.0612999653746638e-18
CPRIVATE_ACTUAL_0595 __pex_xbuf_fn __pex_xbuf_pc1 2.4387132242287894e-18
CPRIVATE_ACTUAL_0596 __pex_xbuf_fn __pex_xbuf_tail 1.4372030466088735e-15
CPRIVATE_ACTUAL_0597 __pex_xbuf_fn __pex_xbuf_vbnc 2.0177884219622318e-15
CPRIVATE_ACTUAL_0598 __pex_xbuf_fn __pex_xbuf_vbp 6.9397535445754319e-16
CPRIVATE_ACTUAL_0599 __pex_xbuf_fn __pex_xbuf_vbpc 2.1397220838664246e-15
CPRIVATE_ACTUAL_0600 __pex_xbuf_fn vdd 8.967488103106638e-15
CPRIVATE_ACTUAL_0601 __pex_xbuf_fn vped 7.9712800552129203e-15
CPRIVATE_ACTUAL_0602 __pex_xbuf_fn vss 3.3763809618099582e-15
CPRIVATE_ACTUAL_0603 __pex_xbuf_fp __pex_xbuf_mir 3.0786019856719217e-17
CPRIVATE_ACTUAL_0604 __pex_xbuf_fp __pex_xbuf_out1 3.2590711139865343e-15
CPRIVATE_ACTUAL_0605 __pex_xbuf_fp __pex_xbuf_pc2 2.6906776647249045e-18
CPRIVATE_ACTUAL_0606 __pex_xbuf_fp __pex_xbuf_tail 2.6321618979668769e-15
CPRIVATE_ACTUAL_0607 __pex_xbuf_fp __pex_xbuf_vbnc 1.8217002749577206e-15
CPRIVATE_ACTUAL_0608 __pex_xbuf_fp __pex_xbuf_vbp 9.5914172670847972e-17
CPRIVATE_ACTUAL_0609 __pex_xbuf_fp __pex_xbuf_vbpc 9.2569495508543413e-19
CPRIVATE_ACTUAL_0610 __pex_xbuf_fp vdd 8.9453851643579833e-15
CPRIVATE_ACTUAL_0611 __pex_xbuf_fp vped 2.5115678886795252e-15
CPRIVATE_ACTUAL_0612 __pex_xbuf_fp vss 2.8975024228238635e-15
CPRIVATE_ACTUAL_0613 __pex_xbuf_mir __pex_xbuf_out1 1.5905825407799093e-15
CPRIVATE_ACTUAL_0614 __pex_xbuf_mir __pex_xbuf_pc1 6.1205756532440482e-15
CPRIVATE_ACTUAL_0615 __pex_xbuf_mir __pex_xbuf_pc2 3.6786460889989472e-15
CPRIVATE_ACTUAL_0616 __pex_xbuf_mir __pex_xbuf_tail 1.6209107220550952e-18
CPRIVATE_ACTUAL_0617 __pex_xbuf_mir __pex_xbuf_vbnc 3.2207881784654123e-15
CPRIVATE_ACTUAL_0618 __pex_xbuf_mir __pex_xbuf_vbp 2.8575736548365458e-16
CPRIVATE_ACTUAL_0619 __pex_xbuf_mir __pex_xbuf_vbpc 5.2816897786435711e-15
CPRIVATE_ACTUAL_0620 __pex_xbuf_mir vdd 1.267603277765206e-14
CPRIVATE_ACTUAL_0621 __pex_xbuf_mir vped 1.149979872342398e-15
CPRIVATE_ACTUAL_0622 __pex_xbuf_mir vss 1.5393898653685976e-15
CPRIVATE_ACTUAL_0623 __pex_xbuf_out1 __pex_xbuf_pc2 2.4420349859479519e-15
CPRIVATE_ACTUAL_0624 __pex_xbuf_out1 __pex_xbuf_tail 7.7226557270744333e-16
CPRIVATE_ACTUAL_0625 __pex_xbuf_out1 __pex_xbuf_vbnc 2.3757889534072793e-15
CPRIVATE_ACTUAL_0626 __pex_xbuf_out1 __pex_xbuf_vbp 1.375929328085554e-16
CPRIVATE_ACTUAL_0627 __pex_xbuf_out1 __pex_xbuf_vbpc 3.5910640893439183e-15
CPRIVATE_ACTUAL_0628 __pex_xbuf_out1 vdd 1.1328858943269544e-14
CPRIVATE_ACTUAL_0629 __pex_xbuf_out1 vped 1.3231235686833579e-14
CPRIVATE_ACTUAL_0630 __pex_xbuf_out1 vss 1.3317344992536794e-15
CPRIVATE_ACTUAL_0631 __pex_xbuf_pc1 __pex_xbuf_pc2 1.8573252736051761e-16
CPRIVATE_ACTUAL_0632 __pex_xbuf_pc1 __pex_xbuf_vbnc 3.3081279021419309e-19
CPRIVATE_ACTUAL_0633 __pex_xbuf_pc1 __pex_xbuf_vbpc 5.6038489877658796e-15
CPRIVATE_ACTUAL_0634 __pex_xbuf_pc1 vdd 6.8321403019732564e-15
CPRIVATE_ACTUAL_0635 __pex_xbuf_pc1 vped 2.2018031021456948e-16
CPRIVATE_ACTUAL_0636 __pex_xbuf_pc1 vss 2.8277049420894222e-17
CPRIVATE_ACTUAL_0637 __pex_xbuf_pc2 __pex_xbuf_vbnc 2.2054186014279538e-19
CPRIVATE_ACTUAL_0638 __pex_xbuf_pc2 __pex_xbuf_vbpc 4.9701624688166383e-15
CPRIVATE_ACTUAL_0639 __pex_xbuf_pc2 vdd 6.769143262668701e-15
CPRIVATE_ACTUAL_0640 __pex_xbuf_pc2 vped 3.879912866750198e-16
CPRIVATE_ACTUAL_0641 __pex_xbuf_pc2 vss 2.1992743327585341e-17
CPRIVATE_ACTUAL_0642 __pex_xbuf_tail __pex_xbuf_vbnc 2.5094343298473971e-16
CPRIVATE_ACTUAL_0643 __pex_xbuf_tail __pex_xbuf_vbp 7.5050843747257526e-15
CPRIVATE_ACTUAL_0644 __pex_xbuf_tail __pex_xbuf_vbpc 5.5415848671338616e-17
CPRIVATE_ACTUAL_0645 __pex_xbuf_tail vdd 6.7548304489666601e-15
CPRIVATE_ACTUAL_0646 __pex_xbuf_tail vped 6.1188631316012697e-15
CPRIVATE_ACTUAL_0647 __pex_xbuf_tail vss 6.7144317843765569e-17
CPRIVATE_ACTUAL_0648 __pex_xbuf_vbnc __pex_xbuf_vbp 2.0792551347512787e-15
CPRIVATE_ACTUAL_0649 __pex_xbuf_vbnc __pex_xbuf_vbpc 4.2050924834328263e-15
CPRIVATE_ACTUAL_0650 __pex_xbuf_vbnc vdd 1.3861938554634314e-15
CPRIVATE_ACTUAL_0651 __pex_xbuf_vbnc vped 2.5900515858269604e-16
CPRIVATE_ACTUAL_0652 __pex_xbuf_vbnc vss 4.9738361098742054e-15
CPRIVATE_ACTUAL_0653 __pex_xbuf_vbp __pex_xbuf_vbpc 5.5124429275953527e-15
CPRIVATE_ACTUAL_0654 __pex_xbuf_vbp vdd 9.1506114617097546e-15
CPRIVATE_ACTUAL_0655 __pex_xbuf_vbp vped 6.0125885248344037e-16
CPRIVATE_ACTUAL_0656 __pex_xbuf_vbp vss 7.543251305474715e-16
CPRIVATE_ACTUAL_0657 __pex_xbuf_vbpc vdd 1.4110808653162406e-15
CPRIVATE_ACTUAL_0658 __pex_xbuf_vbpc vped 2.3003360106345748e-15
CPRIVATE_ACTUAL_0659 __pex_xbuf_vbpc vss 9.9514565764827193e-16
CPRIVATE_ACTUAL_0660 __pex_xota_cz __pex_xota_fn 2.869178836968214e-14
CPRIVATE_ACTUAL_0661 __pex_xota_cz __pex_xota_fp 1.0152338280148621e-15
CPRIVATE_ACTUAL_0662 __pex_xota_cz __pex_xota_mir 8.6433168807737329e-16
CPRIVATE_ACTUAL_0663 __pex_xota_cz __pex_xota_out1 3.7967318896428733e-15
CPRIVATE_ACTUAL_0664 __pex_xota_cz __pex_xota_pc1 8.2305186810707076e-16
CPRIVATE_ACTUAL_0665 __pex_xota_cz __pex_xota_pc2 8.1770568277268833e-16
CPRIVATE_ACTUAL_0666 __pex_xota_cz __pex_xota_tail 9.9071204492145638e-16
CPRIVATE_ACTUAL_0667 __pex_xota_cz __pex_xota_vbnc 8.978036953425479e-16
CPRIVATE_ACTUAL_0668 __pex_xota_cz __pex_xota_vbp 9.7250863603291963e-16
CPRIVATE_ACTUAL_0669 __pex_xota_cz __pex_xota_vbpc 1.044063472128934e-15
CPRIVATE_ACTUAL_0670 __pex_xota_cz vdd 1.299600625056918e-15
CPRIVATE_ACTUAL_0671 __pex_xota_cz vss 2.5325693779339794e-15
CPRIVATE_ACTUAL_0672 __pex_xota_fn __pex_xota_fp 3.5420000750463336e-14
CPRIVATE_ACTUAL_0673 __pex_xota_fn __pex_xota_mir 1.6653033712295618e-15
CPRIVATE_ACTUAL_0674 __pex_xota_fn __pex_xota_out1 1.5995716261219716e-16
CPRIVATE_ACTUAL_0675 __pex_xota_fn __pex_xota_pc1 1.4509718946312374e-16
CPRIVATE_ACTUAL_0676 __pex_xota_fn __pex_xota_pc2 1.4506518440019909e-16
CPRIVATE_ACTUAL_0677 __pex_xota_fn __pex_xota_tail 6.2127484644595334e-15
CPRIVATE_ACTUAL_0678 __pex_xota_fn __pex_xota_vbnc 4.0971559428641169e-15
CPRIVATE_ACTUAL_0679 __pex_xota_fn __pex_xota_vbp 1.9755511528802055e-16
CPRIVATE_ACTUAL_0680 __pex_xota_fn __pex_xota_vbpc 2.6089487284699427e-16
CPRIVATE_ACTUAL_0681 __pex_xota_fn vdd 3.0991388154487041e-14
CPRIVATE_ACTUAL_0682 __pex_xota_fn vss 6.9064721264706718e-15
CPRIVATE_ACTUAL_0683 __pex_xota_fp __pex_xota_mir 2.8940709932641503e-16
CPRIVATE_ACTUAL_0684 __pex_xota_fp __pex_xota_out1 1.6274882897900956e-15
CPRIVATE_ACTUAL_0685 __pex_xota_fp __pex_xota_pc1 1.9979668067401192e-16
CPRIVATE_ACTUAL_0686 __pex_xota_fp __pex_xota_pc2 1.9955842362272471e-16
CPRIVATE_ACTUAL_0687 __pex_xota_fp __pex_xota_tail 1.0070780498636736e-14
CPRIVATE_ACTUAL_0688 __pex_xota_fp __pex_xota_vbnc 3.7729738625108499e-15
CPRIVATE_ACTUAL_0689 __pex_xota_fp __pex_xota_vbp 2.6315254227004816e-16
CPRIVATE_ACTUAL_0690 __pex_xota_fp __pex_xota_vbpc 4.4002331327435838e-16
CPRIVATE_ACTUAL_0691 __pex_xota_fp vdd 3.1345942167599317e-14
CPRIVATE_ACTUAL_0692 __pex_xota_fp vss 6.6935766467592466e-15
CPRIVATE_ACTUAL_0693 __pex_xota_mir __pex_xota_out1 5.2542748990317423e-16
CPRIVATE_ACTUAL_0694 __pex_xota_mir __pex_xota_pc1 3.7768355858118676e-14
CPRIVATE_ACTUAL_0695 __pex_xota_mir __pex_xota_pc2 3.4094431879351033e-14
CPRIVATE_ACTUAL_0696 __pex_xota_mir __pex_xota_tail 2.5513951737145702e-16
CPRIVATE_ACTUAL_0697 __pex_xota_mir __pex_xota_vbnc 3.9567439298500255e-15
CPRIVATE_ACTUAL_0698 __pex_xota_mir __pex_xota_vbp 2.344716567128555e-16
CPRIVATE_ACTUAL_0699 __pex_xota_mir __pex_xota_vbpc 4.0078367238058855e-14
CPRIVATE_ACTUAL_0700 __pex_xota_mir vdd 6.6438258856595333e-14
CPRIVATE_ACTUAL_0701 __pex_xota_mir vss 3.7047125170192478e-15
CPRIVATE_ACTUAL_0702 __pex_xota_out1 __pex_xota_pc1 2.8077137088404606e-14
CPRIVATE_ACTUAL_0703 __pex_xota_out1 __pex_xota_pc2 6.7560896681161621e-15
CPRIVATE_ACTUAL_0704 __pex_xota_out1 __pex_xota_tail 1.8726745434922658e-16
CPRIVATE_ACTUAL_0705 __pex_xota_out1 __pex_xota_vbnc 4.0698056271444953e-15
CPRIVATE_ACTUAL_0706 __pex_xota_out1 __pex_xota_vbp 4.7870130194980653e-16
CPRIVATE_ACTUAL_0707 __pex_xota_out1 __pex_xota_vbpc 3.4284654672685279e-14
CPRIVATE_ACTUAL_0708 __pex_xota_out1 vdd 1.4875521649024661e-14
CPRIVATE_ACTUAL_0709 __pex_xota_out1 vss 8.6907121568780518e-16
CPRIVATE_ACTUAL_0710 __pex_xota_pc1 __pex_xota_pc2 3.1406085668970065e-14
CPRIVATE_ACTUAL_0711 __pex_xota_pc1 __pex_xota_tail 7.0063316498451439e-17
CPRIVATE_ACTUAL_0712 __pex_xota_pc1 __pex_xota_vbnc 1.175659154672698e-16
CPRIVATE_ACTUAL_0713 __pex_xota_pc1 __pex_xota_vbp 1.7349084916011166e-16
CPRIVATE_ACTUAL_0714 __pex_xota_pc1 __pex_xota_vbpc 2.9168913811304475e-14
CPRIVATE_ACTUAL_0715 __pex_xota_pc1 vdd 8.8916215636099683e-15
CPRIVATE_ACTUAL_0716 __pex_xota_pc1 vss 6.1841331984510842e-15
CPRIVATE_ACTUAL_0717 __pex_xota_pc2 __pex_xota_tail 2.7767999394724128e-14
CPRIVATE_ACTUAL_0718 __pex_xota_pc2 __pex_xota_vbnc 1.184163219375428e-16
CPRIVATE_ACTUAL_0719 __pex_xota_pc2 __pex_xota_vbp 1.766167926136532e-16
CPRIVATE_ACTUAL_0720 __pex_xota_pc2 __pex_xota_vbpc 2.3842291064798146e-14
CPRIVATE_ACTUAL_0721 __pex_xota_pc2 vdd 1.3864189213752773e-14
CPRIVATE_ACTUAL_0722 __pex_xota_pc2 vss 3.3435617560755555e-16
CPRIVATE_ACTUAL_0723 __pex_xota_tail __pex_xota_vbnc 1.7511737602080958e-16
CPRIVATE_ACTUAL_0724 __pex_xota_tail __pex_xota_vbp 8.0695750864872795e-15
CPRIVATE_ACTUAL_0725 __pex_xota_tail __pex_xota_vbpc 3.8901377998952777e-16
CPRIVATE_ACTUAL_0726 __pex_xota_tail vdd 2.4276478824877696e-14
CPRIVATE_ACTUAL_0727 __pex_xota_tail vss 2.8835578659065592e-15
CPRIVATE_ACTUAL_0728 __pex_xota_vbnc __pex_xota_vbp 3.2314675941508943e-14
CPRIVATE_ACTUAL_0729 __pex_xota_vbnc __pex_xota_vbpc 2.6795333915523813e-16
CPRIVATE_ACTUAL_0730 __pex_xota_vbnc vdd 1.9111369539172871e-15
CPRIVATE_ACTUAL_0731 __pex_xota_vbnc vss 3.8410550749171975e-15
CPRIVATE_ACTUAL_0732 __pex_xota_vbp __pex_xota_vbpc 2.797659605219807e-14
CPRIVATE_ACTUAL_0733 __pex_xota_vbp vdd 1.4251435850277838e-14
CPRIVATE_ACTUAL_0734 __pex_xota_vbp vss 1.3001306721279223e-15
CPRIVATE_ACTUAL_0735 __pex_xota_vbpc vdd 4.145676365301398e-14
CPRIVATE_ACTUAL_0736 __pex_xota_vbpc vss 1.0860884966717066e-15
CPRIVATE_ACTUAL_0737 __pex_xref_cz __pex_xref_fn 4.1600358058433743e-16
CPRIVATE_ACTUAL_0738 __pex_xref_cz __pex_xref_fp 5.2178846826277083e-16
CPRIVATE_ACTUAL_0739 __pex_xref_cz __pex_xref_mir 6.8686023891370731e-16
CPRIVATE_ACTUAL_0740 __pex_xref_cz __pex_xref_out1 1.4107504939161872e-15
CPRIVATE_ACTUAL_0741 __pex_xref_cz __pex_xref_pc1 2.8419083883196668e-16
CPRIVATE_ACTUAL_0742 __pex_xref_cz __pex_xref_pc2 2.8271080657386918e-16
CPRIVATE_ACTUAL_0743 __pex_xref_cz __pex_xref_tail 2.2007216812763486e-15
CPRIVATE_ACTUAL_0744 __pex_xref_cz __pex_xref_vbnc 1.9970606836044174e-16
CPRIVATE_ACTUAL_0745 __pex_xref_cz __pex_xref_vbp 5.772480831574148e-16
CPRIVATE_ACTUAL_0746 __pex_xref_cz __pex_xref_vbpc 1.7782430378792624e-15
CPRIVATE_ACTUAL_0747 __pex_xref_cz vdd 6.0100229939234704e-16
CPRIVATE_ACTUAL_0748 __pex_xref_cz vref 1.6649773095857244e-15
CPRIVATE_ACTUAL_0749 __pex_xref_cz vref_buf 6.76330471848977e-15
CPRIVATE_ACTUAL_0750 __pex_xref_cz vss 5.2856044646856227e-16
CPRIVATE_ACTUAL_0751 __pex_xref_fn __pex_xref_fp 4.6644826718728916e-16
CPRIVATE_ACTUAL_0752 __pex_xref_fn __pex_xref_mir 1.6571782942453273e-15
CPRIVATE_ACTUAL_0753 __pex_xref_fn __pex_xref_out1 1.0612999653746638e-18
CPRIVATE_ACTUAL_0754 __pex_xref_fn __pex_xref_pc1 2.4387132242287894e-18
CPRIVATE_ACTUAL_0755 __pex_xref_fn __pex_xref_tail 1.4372030466088735e-15
CPRIVATE_ACTUAL_0756 __pex_xref_fn __pex_xref_vbnc 2.0177884219622318e-15
CPRIVATE_ACTUAL_0757 __pex_xref_fn __pex_xref_vbp 6.9397535445754319e-16
CPRIVATE_ACTUAL_0758 __pex_xref_fn __pex_xref_vbpc 2.1397220838664246e-15
CPRIVATE_ACTUAL_0759 __pex_xref_fn vdd 8.8226951104384233e-15
CPRIVATE_ACTUAL_0760 __pex_xref_fn vref 8.8140740561331286e-16
CPRIVATE_ACTUAL_0761 __pex_xref_fn vref_buf 7.9712800552129219e-15
CPRIVATE_ACTUAL_0762 __pex_xref_fn vss 3.3770383701699124e-15
CPRIVATE_ACTUAL_0763 __pex_xref_fp __pex_xref_mir 3.0786019856719217e-17
CPRIVATE_ACTUAL_0764 __pex_xref_fp __pex_xref_out1 3.2590711139865343e-15
CPRIVATE_ACTUAL_0765 __pex_xref_fp __pex_xref_pc2 2.6906776647249045e-18
CPRIVATE_ACTUAL_0766 __pex_xref_fp __pex_xref_tail 2.6321618979668769e-15
CPRIVATE_ACTUAL_0767 __pex_xref_fp __pex_xref_vbnc 1.8217002749577206e-15
CPRIVATE_ACTUAL_0768 __pex_xref_fp __pex_xref_vbp 9.6286555307460115e-17
CPRIVATE_ACTUAL_0769 __pex_xref_fp __pex_xref_vbpc 9.2569495508543413e-19
CPRIVATE_ACTUAL_0770 __pex_xref_fp vdd 8.8204047382987901e-15
CPRIVATE_ACTUAL_0771 __pex_xref_fp vref 8.3389232267492798e-15
CPRIVATE_ACTUAL_0772 __pex_xref_fp vref_buf 2.5116583013452928e-15
CPRIVATE_ACTUAL_0773 __pex_xref_fp vss 2.9032760668432019e-15
CPRIVATE_ACTUAL_0774 __pex_xref_mir __pex_xref_out1 1.5905825407799093e-15
CPRIVATE_ACTUAL_0775 __pex_xref_mir __pex_xref_pc1 6.1205756532440482e-15
CPRIVATE_ACTUAL_0776 __pex_xref_mir __pex_xref_pc2 3.6786460889989472e-15
CPRIVATE_ACTUAL_0777 __pex_xref_mir __pex_xref_tail 1.6209107220550952e-18
CPRIVATE_ACTUAL_0778 __pex_xref_mir __pex_xref_vbnc 3.2207881784654123e-15
CPRIVATE_ACTUAL_0779 __pex_xref_mir __pex_xref_vbp 2.8575736548365458e-16
CPRIVATE_ACTUAL_0780 __pex_xref_mir __pex_xref_vbpc 5.2818127717541782e-15
CPRIVATE_ACTUAL_0781 __pex_xref_mir vdd 1.2436484678208698e-14
CPRIVATE_ACTUAL_0782 __pex_xref_mir vref 3.885316580127279e-17
CPRIVATE_ACTUAL_0783 __pex_xref_mir vref_buf 1.149979872342398e-15
CPRIVATE_ACTUAL_0784 __pex_xref_mir vss 1.5395277717234755e-15
CPRIVATE_ACTUAL_0785 __pex_xref_out1 __pex_xref_pc2 2.4420349859479519e-15
CPRIVATE_ACTUAL_0786 __pex_xref_out1 __pex_xref_tail 7.7226557270744333e-16
CPRIVATE_ACTUAL_0787 __pex_xref_out1 __pex_xref_vbnc 2.3757889534072793e-15
CPRIVATE_ACTUAL_0788 __pex_xref_out1 __pex_xref_vbp 1.375929328085554e-16
CPRIVATE_ACTUAL_0789 __pex_xref_out1 __pex_xref_vbpc 3.5910640893439183e-15
CPRIVATE_ACTUAL_0790 __pex_xref_out1 vdd 1.1328858943269542e-14
CPRIVATE_ACTUAL_0791 __pex_xref_out1 vped 9.9739015585942035e-18
CPRIVATE_ACTUAL_0792 __pex_xref_out1 vref 6.3150709378714865e-16
CPRIVATE_ACTUAL_0793 __pex_xref_out1 vref_buf 1.3231235686833579e-14
CPRIVATE_ACTUAL_0794 __pex_xref_out1 vss 1.3317344992536794e-15
CPRIVATE_ACTUAL_0795 __pex_xref_pc1 __pex_xref_pc2 1.8573252736051761e-16
CPRIVATE_ACTUAL_0796 __pex_xref_pc1 __pex_xref_vbnc 3.3081279021419309e-19
CPRIVATE_ACTUAL_0797 __pex_xref_pc1 __pex_xref_vbpc 5.6038489877658796e-15
CPRIVATE_ACTUAL_0798 __pex_xref_pc1 vdd 6.769143262668701e-15
CPRIVATE_ACTUAL_0799 __pex_xref_pc1 vref 1.7131748099554916e-17
CPRIVATE_ACTUAL_0800 __pex_xref_pc1 vref_buf 2.2025603559152215e-16
CPRIVATE_ACTUAL_0801 __pex_xref_pc1 vss 2.8277049420894222e-17
CPRIVATE_ACTUAL_0802 __pex_xref_pc2 __pex_xref_vbnc 2.2054186014279538e-19
CPRIVATE_ACTUAL_0803 __pex_xref_pc2 __pex_xref_vbpc 4.9701624688166383e-15
CPRIVATE_ACTUAL_0804 __pex_xref_pc2 vdd 6.769143262668701e-15
CPRIVATE_ACTUAL_0805 __pex_xref_pc2 vref 1.2066604565735062e-17
CPRIVATE_ACTUAL_0806 __pex_xref_pc2 vref_buf 3.879912866750198e-16
CPRIVATE_ACTUAL_0807 __pex_xref_pc2 vss 2.1992743327585341e-17
CPRIVATE_ACTUAL_0808 __pex_xref_tail __pex_xref_vbnc 2.5094343298473971e-16
CPRIVATE_ACTUAL_0809 __pex_xref_tail __pex_xref_vbp 7.505691753639377e-15
CPRIVATE_ACTUAL_0810 __pex_xref_tail __pex_xref_vbpc 5.5415848671338616e-17
CPRIVATE_ACTUAL_0811 __pex_xref_tail vdd 5.2003596462227636e-15
CPRIVATE_ACTUAL_0812 __pex_xref_tail vref 7.5925814934492073e-15
CPRIVATE_ACTUAL_0813 __pex_xref_tail vref_buf 6.1275882645478314e-15
CPRIVATE_ACTUAL_0814 __pex_xref_tail vss 6.7144317843765569e-17
CPRIVATE_ACTUAL_0815 __pex_xref_vbnc __pex_xref_vbp 2.0792551347512787e-15
CPRIVATE_ACTUAL_0816 __pex_xref_vbnc __pex_xref_vbpc 4.2050924834328263e-15
CPRIVATE_ACTUAL_0817 __pex_xref_vbnc vdd 1.035191683739565e-15
CPRIVATE_ACTUAL_0818 __pex_xref_vbnc vref 5.7581600697517837e-17
CPRIVATE_ACTUAL_0819 __pex_xref_vbnc vref_buf 2.5900515858269604e-16
CPRIVATE_ACTUAL_0820 __pex_xref_vbnc vss 4.9899895682805914e-15
CPRIVATE_ACTUAL_0821 __pex_xref_vbp __pex_xref_vbpc 5.5124429275953527e-15
CPRIVATE_ACTUAL_0822 __pex_xref_vbp vdd 7.634377087553735e-15
CPRIVATE_ACTUAL_0823 __pex_xref_vbp vped 6.6492677057294685e-18
CPRIVATE_ACTUAL_0824 __pex_xref_vbp vref 5.6950203088601338e-16
CPRIVATE_ACTUAL_0825 __pex_xref_vbp vref_buf 6.1426028996965005e-16
CPRIVATE_ACTUAL_0826 __pex_xref_vbp vss 8.1148082623974094e-16
CPRIVATE_ACTUAL_0827 __pex_xref_vbpc vdd 1.0271120465092014e-15
CPRIVATE_ACTUAL_0828 __pex_xref_vbpc vref 6.0375813570473608e-17
CPRIVATE_ACTUAL_0829 __pex_xref_vbpc vref_buf 2.3003360106345748e-15
CPRIVATE_ACTUAL_0830 __pex_xref_vbpc vss 1.0413335848942751e-15
CPRIVATE_ACTUAL_0831 sense_n sense_p 1.1009506323835119e-14
CPRIVATE_ACTUAL_0832 sense_n vss 1.653255412953017e-16
CPRIVATE_ACTUAL_0833 sense_p vss 2.3830479962368245e-16
CPRIVATE_ACTUAL_0834 vdd vped 9.3970621164769394e-15
CPRIVATE_ACTUAL_0835 vdd vref 9.8764463109408827e-15
CPRIVATE_ACTUAL_0836 vdd vref_buf 2.6088001365925534e-14
CPRIVATE_ACTUAL_0837 vdd vss 1.5990764185777149e-13
CPRIVATE_ACTUAL_0838 vped vref 1.3271319094115828e-16
CPRIVATE_ACTUAL_0839 vped vref_buf 2.8271982221266771e-14
CPRIVATE_ACTUAL_0840 vped vss 7.3217548851127624e-15
CPRIVATE_ACTUAL_0841 vref vref_buf 1.4748591295714054e-14
CPRIVATE_ACTUAL_0842 vref vss 1.3178245320563408e-14
CPRIVATE_ACTUAL_0843 vref_buf vss 6.9621717092382757e-15
Vmain_probe main_loop_e vn dc 0 ac {pv}
Imain_probe vss main_loop_e dc 0 ac {pi}
.ends

* expanding   symbol:  g1_ota.sym # of pins=6
** sym_path: ${CONTAINER_REPOSITORY_ROOT}/designs/g1-guardian/blocks/g1_sense/schematic/g1_ota.sym
** sch_path: ${CONTAINER_REPOSITORY_ROOT}/designs/g1-guardian/blocks/g1_sense/schematic/g1_ota.sch
.subckt g1_ota inp inn vbn out vdd vss cz fn fp mir out1 pc1 pc2 tail vbnc vbp vbpc
*.ipin inp
*.ipin inn
*.ipin vbn
*.opin out
*.iopin vdd
*.iopin vss
XMB2 vbp vbn vss vss sg13_hv_nmos w=8u l=1u ng=2 m=1 mm_ok=1
XMB3 vbp vbp vdd vdd sg13_hv_pmos w=16u l=1u ng=4 m=1 mm_ok=1
XMB5 vbnc vbp vdd vdd sg13_hv_pmos w=16u l=1u ng=4 m=1 mm_ok=1
XMB4 vbnc vbnc vss vss sg13_hv_nmos w=1.6u l=1u ng=1 m=1 mm_ok=1
XMB6 vbpc vbn vss vss sg13_hv_nmos w=8u l=1u ng=2 m=1 mm_ok=1
XMB7 vbpc vbpc vdd vdd sg13_hv_pmos w=3.2u l=1u ng=1 m=1 mm_ok=1
XMT tail vbp vdd vdd sg13_hv_pmos w=128u l=1u ng=16 m=1 mm_ok=1
XM1 fn inn tail vdd sg13_hv_pmos w=96u l=2u ng=16 m=1 mm_ok=1
XM2 fp inp tail vdd sg13_hv_pmos w=96u l=2u ng=16 m=1 mm_ok=1
XM3 fn vbn vss vss sg13_hv_nmos w=80u l=1u ng=10 m=1 mm_ok=1
XM4 fp vbn vss vss sg13_hv_nmos w=80u l=1u ng=10 m=1 mm_ok=1
XM13 mir vbnc fn vss sg13_hv_nmos w=48u l=1u ng=6 m=1 mm_ok=1
XM16 out1 vbnc fp vss sg13_hv_nmos w=48u l=1u ng=6 m=1 mm_ok=1
XM14 pc1 mir vdd vdd sg13_hv_pmos w=96u l=1u ng=12 m=1 mm_ok=1
XM11 pc2 mir vdd vdd sg13_hv_pmos w=96u l=1u ng=12 m=1 mm_ok=1
XM15 mir vbpc pc1 vdd sg13_hv_pmos w=96u l=1u ng=12 m=1 mm_ok=1
XM12 out1 vbpc pc2 vdd sg13_hv_pmos w=96u l=1u ng=12 m=1 mm_ok=1
XM20 out out1 vdd vdd sg13_hv_pmos w=192u l=1u ng=24 m=1 mm_ok=1
XM21 out vbn vss vss sg13_hv_nmos w=96u l=1u ng=12 m=1 mm_ok=1
XRZ out1 cz vss rppd w=1u l=6.2u m=1 b=0 mm_ok=1
XCC cz out cap_cmim w=23u l=23u m=1 mm_ok=1
.ends

* Isolated main OTA geometry/compensation sensitivity; no layout adoption.
.subckt g1_ota_main_candidate inp inn vbn out vdd vss cz fn fp mir out1 pc1 pc2 tail vbnc vbp vbpc
*.ipin inp
*.ipin inn
*.ipin vbn
*.opin out
*.iopin vdd
*.iopin vss
XMB2 vbp vbn vss vss sg13_hv_nmos w=8u l=1u ng=2 m=1 mm_ok=1
XMB3 vbp vbp vdd vdd sg13_hv_pmos w=16u l=1u ng=4 m=1 mm_ok=1
XMB5 vbnc vbp vdd vdd sg13_hv_pmos w=16u l=1u ng=4 m=1 mm_ok=1
XMB4 vbnc vbnc vss vss sg13_hv_nmos w=1.6u l=1u ng=1 m=1 mm_ok=1
XMB6 vbpc vbn vss vss sg13_hv_nmos w=8u l=1u ng=2 m=1 mm_ok=1
XMB7 vbpc vbpc vdd vdd sg13_hv_pmos w=3.2u l=1u ng=1 m=1 mm_ok=1
XMT tail vbp vdd vdd sg13_hv_pmos w=128u l=1u ng=16 m=1 mm_ok=1
XM1 fn inn tail vdd sg13_hv_pmos w=384u l=2u ng=64 m=1 mm_ok=1
XM2 fp inp tail vdd sg13_hv_pmos w=384u l=2u ng=64 m=1 mm_ok=1
XM3 fn vbn vss vss sg13_hv_nmos w=320u l=4u ng=40 m=1 mm_ok=1
XM4 fp vbn vss vss sg13_hv_nmos w=320u l=4u ng=40 m=1 mm_ok=1
XM13 mir vbnc fn vss sg13_hv_nmos w=48u l=1u ng=6 m=1 mm_ok=1
XM16 out1 vbnc fp vss sg13_hv_nmos w=48u l=1u ng=6 m=1 mm_ok=1
XM14 pc1 mir vdd vdd sg13_hv_pmos w=384u l=4u ng=48 m=1 mm_ok=1
XM11 pc2 mir vdd vdd sg13_hv_pmos w=384u l=4u ng=48 m=1 mm_ok=1
XM15 mir vbpc pc1 vdd sg13_hv_pmos w=384u l=4u ng=48 m=1 mm_ok=1
XM12 out1 vbpc pc2 vdd sg13_hv_pmos w=384u l=4u ng=48 m=1 mm_ok=1
XM20 out out1 vdd vdd sg13_hv_pmos w=192u l=1u ng=24 m=1 mm_ok=1
XM21 out vbn vss vss sg13_hv_nmos w=96u l=1u ng=12 m=1 mm_ok=1
XRZ out1 cz vss rppd w=1u l=100u m=1 b=0 mm_ok=1
XCC cz out cap_cmim w=45u l=23u m=1 mm_ok=1
.ends
