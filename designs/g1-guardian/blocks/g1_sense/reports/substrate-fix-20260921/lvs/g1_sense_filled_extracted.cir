* Extracted by KLayout with SG13G2 LVS runset on : 21/09/2026 16:10

.SUBCKT g1_sense iptat isense sense_n sense_p vdd vped vref vref_buf vss
X$732 vss iptat vref_buf vdd vref_buf vref g1_ota
X$733 vss iptat vped vdd vped \$41 g1_ota
X$3546 vss iptat isense vdd \$30 \$31 g1_ota
M$1 vss iptat iptat vss sg13_hv_nmos L=1u W=3.3u AS=1.122p AD=1.122p PS=7.28u
+ PD=7.28u rfmode=0
R$2 \$84 vss vss rppd w=2u l=76.7u ps=0u b=0 m=1
R$3 \$12 \$41 vss rppd w=2u l=76.7u ps=0u b=0 m=1
R$4 \$82 \$93 vss rppd w=2u l=76.7u ps=0u b=0 m=1
R$5 \$83 \$97 vss rppd w=2u l=76.7u ps=0u b=0 m=1
R$6 \$78 \$97 vss rppd w=2u l=76.7u ps=0u b=0 m=1
R$7 \$13 \$49 vss rppd w=2u l=76.7u ps=0u b=0 m=1
R$8 \$64 \$108 vss rppd w=2u l=76.7u ps=0u b=0 m=1
R$9 \$20 \$56 vss rppd w=2u l=76.7u ps=0u b=0 m=1
R$10 \$20 \$59 vss rppd w=2u l=76.7u ps=0u b=0 m=1
R$11 \$21 \$59 vss rppd w=2u l=76.7u ps=0u b=0 m=1
R$12 \$21 \$58 vss rppd w=2u l=76.7u ps=0u b=0 m=1
R$13 \$22 \$38 vss rppd w=2u l=76.7u ps=0u b=0 m=1
R$14 \$83 \$93 vss rppd w=2u l=76.7u ps=0u b=0 m=1
R$15 \$82 \$94 vss rppd w=2u l=76.7u ps=0u b=0 m=1
R$16 \$81 \$94 vss rppd w=2u l=76.7u ps=0u b=0 m=1
R$17 \$81 \$95 vss rppd w=2u l=76.7u ps=0u b=0 m=1
R$18 \$84 \$95 vss rppd w=2u l=76.7u ps=0u b=0 m=1
R$19 \$65 \$108 vss rppd w=2u l=76.7u ps=0u b=0 m=1
R$20 \$65 \$107 vss rppd w=2u l=76.7u ps=0u b=0 m=1
R$21 \$66 \$107 vss rppd w=2u l=76.7u ps=0u b=0 m=1
R$22 \$66 \$106 vss rppd w=2u l=76.7u ps=0u b=0 m=1
R$23 \$67 \$106 vss rppd w=2u l=76.7u ps=0u b=0 m=1
R$24 \$68 \$110 vss rppd w=2u l=76.7u ps=0u b=0 m=1
R$25 \$22 \$58 vss rppd w=2u l=76.7u ps=0u b=0 m=1
R$26 \$6 \$42 vss rppd w=2u l=76.7u ps=0u b=0 m=1
R$27 \$6 \$45 vss rppd w=2u l=76.7u ps=0u b=0 m=1
R$28 \$7 \$45 vss rppd w=2u l=76.7u ps=0u b=0 m=1
R$29 \$7 \$44 vss rppd w=2u l=76.7u ps=0u b=0 m=1
R$30 \$8 \$44 vss rppd w=2u l=76.7u ps=0u b=0 m=1
R$31 \$8 \$43 vss rppd w=2u l=76.7u ps=0u b=0 m=1
R$32 \$9 \$43 vss rppd w=2u l=76.7u ps=0u b=0 m=1
R$33 \$9 \$47 vss rppd w=2u l=76.7u ps=0u b=0 m=1
R$34 \$10 \$47 vss rppd w=2u l=76.7u ps=0u b=0 m=1
R$35 \$10 \$46 vss rppd w=2u l=76.7u ps=0u b=0 m=1
R$36 \$11 \$46 vss rppd w=2u l=76.7u ps=0u b=0 m=1
R$37 \$67 \$110 vss rppd w=2u l=76.7u ps=0u b=0 m=1
R$38 \$27 \$39 vss rppd w=2u l=76.7u ps=0u b=0 m=1
R$39 \$27 \$51 vss rppd w=2u l=76.7u ps=0u b=0 m=1
R$40 \$26 \$51 vss rppd w=2u l=76.7u ps=0u b=0 m=1
R$41 \$26 \$48 vss rppd w=2u l=76.7u ps=0u b=0 m=1
R$42 \$25 \$48 vss rppd w=2u l=76.7u ps=0u b=0 m=1
R$43 \$25 \$60 vss rppd w=2u l=76.7u ps=0u b=0 m=1
R$44 \$24 \$60 vss rppd w=2u l=76.7u ps=0u b=0 m=1
R$45 \$24 \$61 vss rppd w=2u l=76.7u ps=0u b=0 m=1
R$46 \$23 \$61 vss rppd w=2u l=76.7u ps=0u b=0 m=1
R$47 \$23 \$31 vss rppd w=2u l=76.7u ps=0u b=0 m=1
R$48 sense_p \$31 vss rppd w=2u l=76.7u ps=0u b=0 m=1
R$49 sense_n \$30 vss rppd w=2u l=76.7u ps=0u b=0 m=1
R$50 \$11 \$40 vss rppd w=2u l=76.7u ps=0u b=0 m=1
R$51 \$3 \$55 vss rppd w=2u l=76.7u ps=0u b=0 m=1
R$52 \$75 \$98 vss rppd w=2u l=76.7u ps=0u b=0 m=1
R$53 \$75 \$99 vss rppd w=2u l=76.7u ps=0u b=0 m=1
R$54 \$80 \$99 vss rppd w=2u l=76.7u ps=0u b=0 m=1
R$55 \$80 isense vss rppd w=2u l=76.7u ps=0u b=0 m=1
R$56 \$79 \$87 vss rppd w=2u l=76.7u ps=0u b=0 m=1
R$57 \$17 \$55 vss rppd w=2u l=76.7u ps=0u b=0 m=1
R$58 \$79 \$96 vss rppd w=2u l=76.7u ps=0u b=0 m=1
R$59 \$78 \$96 vss rppd w=2u l=76.7u ps=0u b=0 m=1
R$60 \$17 \$52 vss rppd w=2u l=76.7u ps=0u b=0 m=1
R$61 \$76 \$98 vss rppd w=2u l=76.7u ps=0u b=0 m=1
R$62 \$16 \$53 vss rppd w=2u l=76.7u ps=0u b=0 m=1
R$63 \$15 \$53 vss rppd w=2u l=76.7u ps=0u b=0 m=1
R$64 \$15 \$54 vss rppd w=2u l=76.7u ps=0u b=0 m=1
R$65 \$14 \$54 vss rppd w=2u l=76.7u ps=0u b=0 m=1
R$66 \$14 \$49 vss rppd w=2u l=76.7u ps=0u b=0 m=1
R$67 \$3 \$42 vss rppd w=2u l=76.7u ps=0u b=0 m=1
R$68 \$13 \$50 vss rppd w=2u l=76.7u ps=0u b=0 m=1
R$69 \$12 \$50 vss rppd w=2u l=76.7u ps=0u b=0 m=1
R$70 \$63 \$87 vss rppd w=2u l=76.7u ps=0u b=0 m=1
R$71 \$64 \$109 vss rppd w=2u l=76.7u ps=0u b=0 m=1
R$72 \$16 \$52 vss rppd w=2u l=76.7u ps=0u b=0 m=1
R$73 \$63 \$109 vss rppd w=2u l=76.7u ps=0u b=0 m=1
R$74 \$40 \$111 vss rppd w=2u l=76.7u ps=0u b=0 m=1
R$75 \$62 \$39 vss rppd w=2u l=76.7u ps=0u b=0 m=1
R$76 \$62 \$104 vss rppd w=2u l=76.7u ps=0u b=0 m=1
R$77 \$71 \$104 vss rppd w=2u l=76.7u ps=0u b=0 m=1
R$78 \$71 \$105 vss rppd w=2u l=76.7u ps=0u b=0 m=1
R$79 \$70 \$105 vss rppd w=2u l=76.7u ps=0u b=0 m=1
R$80 \$70 \$102 vss rppd w=2u l=76.7u ps=0u b=0 m=1
R$81 \$69 \$102 vss rppd w=2u l=76.7u ps=0u b=0 m=1
R$82 \$69 \$103 vss rppd w=2u l=76.7u ps=0u b=0 m=1
R$83 \$74 \$103 vss rppd w=2u l=76.7u ps=0u b=0 m=1
R$84 \$74 vped vss rppd w=2u l=76.7u ps=0u b=0 m=1
R$85 \$19 \$56 vss rppd w=2u l=76.7u ps=0u b=0 m=1
R$86 \$73 vref_buf vss rppd w=2u l=76.7u ps=0u b=0 m=1
R$87 \$73 \$41 vss rppd w=2u l=76.7u ps=0u b=0 m=1
R$88 \$72 \$38 vss rppd w=2u l=76.7u ps=0u b=0 m=1
R$89 \$19 \$57 vss rppd w=2u l=76.7u ps=0u b=0 m=1
R$90 \$18 \$57 vss rppd w=2u l=76.7u ps=0u b=0 m=1
R$91 \$18 \$30 vss rppd w=2u l=76.7u ps=0u b=0 m=1
R$92 \$72 \$100 vss rppd w=2u l=76.7u ps=0u b=0 m=1
R$93 \$77 \$100 vss rppd w=2u l=76.7u ps=0u b=0 m=1
R$94 \$77 \$101 vss rppd w=2u l=76.7u ps=0u b=0 m=1
R$95 \$68 \$111 vss rppd w=2u l=76.7u ps=0u b=0 m=1
R$96 \$76 \$101 vss rppd w=2u l=76.7u ps=0u b=0 m=1
.ENDS g1_sense

.SUBCKT g1_ota vss vbn out vdd inn inp
C$1 \$32 out cap_cmim w=23u l=23u A=529p P=92u m=1
R$2 \$33 \$32 vss rppd w=1u l=6.2u ps=0u b=0 m=1
M$3 vdd \$33 out vdd sg13_hv_pmos L=1u W=192u AS=37.68p AD=37.68p PS=209.42u
+ PD=209.42u rfmode=0
M$27 vdd \$3 \$28 vdd sg13_hv_pmos L=1u W=128u AS=25.52p AD=25.52p PS=142.38u
+ PD=142.38u rfmode=0
M$43 vdd \$3 \$5 vdd sg13_hv_pmos L=1u W=16u AS=4.24p AD=4.24p PS=25.06u
+ PD=25.06u rfmode=0
M$45 vdd \$3 \$3 vdd sg13_hv_pmos L=1u W=16u AS=4.24p AD=4.24p PS=25.06u
+ PD=25.06u rfmode=0
M$47 vdd \$2 \$2 vdd sg13_hv_pmos L=1u W=3.2u AS=1.088p AD=1.088p PS=7.08u
+ PD=7.08u rfmode=0
M$48 \$28 inn \$4 vdd sg13_hv_pmos L=2u W=96u AS=19.14p AD=19.14p PS=108.38u
+ PD=108.38u rfmode=0
M$50 \$28 inp \$7 vdd sg13_hv_pmos L=2u W=96u AS=18.24p AD=18.24p PS=102.08u
+ PD=102.08u rfmode=0
M$80 vdd \$19 \$25 vdd sg13_hv_pmos L=1u W=96u AS=19.44p AD=19.44p PS=108.86u
+ PD=108.86u rfmode=0
M$92 \$25 \$2 \$19 vdd sg13_hv_pmos L=1u W=96u AS=19.44p AD=19.44p PS=108.86u
+ PD=108.86u rfmode=0
M$104 \$26 \$2 \$33 vdd sg13_hv_pmos L=1u W=96u AS=19.44p AD=19.44p PS=108.86u
+ PD=108.86u rfmode=0
M$116 vdd \$19 \$26 vdd sg13_hv_pmos L=1u W=96u AS=19.44p AD=19.44p PS=108.86u
+ PD=108.86u rfmode=0
M$128 vss vbn out vss sg13_hv_nmos L=1u W=96u AS=19.44p AD=19.44p PS=108.86u
+ PD=108.86u rfmode=0
M$140 \$4 \$5 \$19 vss sg13_hv_nmos L=1u W=48u AS=10.32p AD=10.32p PS=58.58u
+ PD=58.58u rfmode=0
M$146 \$7 \$5 \$33 vss sg13_hv_nmos L=1u W=48u AS=10.32p AD=10.32p PS=58.58u
+ PD=58.58u rfmode=0
M$152 vss vbn \$4 vss sg13_hv_nmos L=1u W=80u AS=16.4p AD=16.4p PS=92.1u
+ PD=92.1u rfmode=0
M$162 vss vbn \$7 vss sg13_hv_nmos L=1u W=80u AS=16.4p AD=16.4p PS=92.1u
+ PD=92.1u rfmode=0
M$172 vss vbn \$3 vss sg13_hv_nmos L=1u W=8u AS=2.72p AD=2.72p PS=16.68u
+ PD=16.68u rfmode=0
M$173 vss vbn \$2 vss sg13_hv_nmos L=1u W=8u AS=2.72p AD=2.72p PS=16.68u
+ PD=16.68u rfmode=0
M$174 vss \$5 \$5 vss sg13_hv_nmos L=1u W=1.6u AS=0.544p AD=0.544p PS=3.88u
+ PD=3.88u rfmode=0
.ENDS g1_ota
