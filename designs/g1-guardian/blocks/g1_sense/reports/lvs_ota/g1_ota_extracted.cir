* Extracted by KLayout with SG13G2 LVS runset on : 19/09/2026 09:35

.SUBCKT g1_ota inn inp out vbn vdd vss
C$1 \$32 out cap_cmim w=23u l=23u A=529p P=92u m=1
R$2 \$33 \$32 vss rppd w=1u l=6.2u ps=0u b=0 m=1
M$3 vdd \$33 out vdd sg13_hv_pmos L=1u W=192u AS=37.68p AD=37.68p PS=209.42u
+ PD=209.42u rfmode=0
M$27 vdd \$3 \$28 vdd sg13_hv_pmos L=1u W=128u AS=25.52p AD=25.52p PS=142.38u
+ PD=142.38u rfmode=0
M$43 vdd \$3 \$5 vdd sg13_hv_pmos L=1u W=16u AS=4.24p AD=4.24p PS=25.06u
+ PD=25.06u rfmode=0
M$45 vdd \$3 \$3 vdd sg13_hv_pmos L=1u W=16u AS=4.24p AD=4.24p PS=25.06u
+ PD=25.06u rfmode=0
M$47 vdd \$2 \$2 vdd sg13_hv_pmos L=1u W=3.2u AS=1.088p AD=1.088p PS=7.08u
+ PD=7.08u rfmode=0
M$48 \$28 inn \$4 vdd sg13_hv_pmos L=2u W=96u AS=19.14p AD=19.14p PS=108.38u
+ PD=108.38u rfmode=0
M$50 \$28 inp \$7 vdd sg13_hv_pmos L=2u W=96u AS=18.24p AD=18.24p PS=102.08u
+ PD=102.08u rfmode=0
M$80 \$25 \$2 \$19 vdd sg13_hv_pmos L=1u W=96u AS=19.44p AD=19.44p PS=108.86u
+ PD=108.86u rfmode=0
M$92 vdd \$19 \$25 vdd sg13_hv_pmos L=1u W=96u AS=19.44p AD=19.44p PS=108.86u
+ PD=108.86u rfmode=0
M$104 vdd \$19 \$26 vdd sg13_hv_pmos L=1u W=96u AS=19.44p AD=19.44p PS=108.86u
+ PD=108.86u rfmode=0
M$116 \$26 \$2 \$33 vdd sg13_hv_pmos L=1u W=96u AS=19.44p AD=19.44p PS=108.86u
+ PD=108.86u rfmode=0
M$128 vss vbn out vss sg13_hv_nmos L=1u W=96u AS=19.44p AD=19.44p PS=108.86u
+ PD=108.86u rfmode=0
M$140 \$4 \$5 \$19 vss sg13_hv_nmos L=1u W=48u AS=10.32p AD=10.32p PS=58.58u
+ PD=58.58u rfmode=0
M$146 \$7 \$5 \$33 vss sg13_hv_nmos L=1u W=48u AS=10.32p AD=10.32p PS=58.58u
+ PD=58.58u rfmode=0
M$152 vss vbn \$4 vss sg13_hv_nmos L=1u W=80u AS=16.4p AD=16.4p PS=92.1u
+ PD=92.1u rfmode=0
M$162 vss vbn \$7 vss sg13_hv_nmos L=1u W=80u AS=16.4p AD=16.4p PS=92.1u
+ PD=92.1u rfmode=0
M$172 vss vbn \$3 vss sg13_hv_nmos L=1u W=8u AS=2.72p AD=2.72p PS=16.68u
+ PD=16.68u rfmode=0
M$173 vss vbn \$2 vss sg13_hv_nmos L=1u W=8u AS=2.72p AD=2.72p PS=16.68u
+ PD=16.68u rfmode=0
M$174 vss \$5 \$5 vss sg13_hv_nmos L=1u W=1.6u AS=0.544p AD=0.544p PS=3.88u
+ PD=3.88u rfmode=0
.ENDS g1_ota
