*********************************************************
*** NGSPICE file created by KLayout-PEX 0.3.12
*** -----------------------------------------------------
***     Extraction Engine: KPEX/2.5D
***     Technology: ihp_sg13g2
***     Date: 2026-09-19 10:00:15
*********************************************************

.SUBCKT g1_sense iptat isense sense_n sense_p vdd vped vref vref_buf vss
M$1 \$4 \$4 vss vss sg13_hv_nmos L=1U W=1.6U AS=0.544P AD=0.544P PS=3.88U
+ PD=3.88U rfmode=0
M$2 \$3 iptat vss vss sg13_hv_nmos L=1U W=8U AS=2.72P AD=2.72P PS=16.68U
+ PD=16.68U rfmode=0
M$3 \$2 iptat vss vss sg13_hv_nmos L=1U W=8U AS=2.72P AD=2.72P PS=16.68U
+ PD=16.68U rfmode=0
M$4 \$5 iptat vss vss sg13_hv_nmos L=1U W=8U AS=2.72P AD=1.52P PS=16.68U
+ PD=8.38U rfmode=0
M$5 vss iptat \$5 vss sg13_hv_nmos L=1U W=8U AS=1.52P AD=1.52P PS=8.38U
+ PD=8.38U rfmode=0
M$6 \$5 iptat vss vss sg13_hv_nmos L=1U W=8U AS=1.52P AD=1.52P PS=8.38U
+ PD=8.38U rfmode=0
M$7 vss iptat \$5 vss sg13_hv_nmos L=1U W=8U AS=1.52P AD=1.52P PS=8.38U
+ PD=8.38U rfmode=0
M$8 \$5 iptat vss vss sg13_hv_nmos L=1U W=8U AS=1.52P AD=1.52P PS=8.38U
+ PD=8.38U rfmode=0
M$9 vss iptat \$5 vss sg13_hv_nmos L=1U W=8U AS=1.52P AD=1.52P PS=8.38U
+ PD=8.38U rfmode=0
M$10 \$5 iptat vss vss sg13_hv_nmos L=1U W=8U AS=1.52P AD=1.52P PS=8.38U
+ PD=8.38U rfmode=0
M$11 vss iptat \$5 vss sg13_hv_nmos L=1U W=8U AS=1.52P AD=1.52P PS=8.38U
+ PD=8.38U rfmode=0
M$12 \$5 iptat vss vss sg13_hv_nmos L=1U W=8U AS=1.52P AD=1.52P PS=8.38U
+ PD=8.38U rfmode=0
M$13 vss iptat \$5 vss sg13_hv_nmos L=1U W=8U AS=1.52P AD=2.72P PS=8.38U
+ PD=16.68U rfmode=0
M$14 \$34 \$4 \$5 vss sg13_hv_nmos L=1U W=8U AS=2.72P AD=1.52P PS=16.68U
+ PD=8.38U rfmode=0
M$15 \$5 \$4 \$34 vss sg13_hv_nmos L=1U W=8U AS=1.52P AD=1.52P PS=8.38U
+ PD=8.38U rfmode=0
M$16 \$34 \$4 \$5 vss sg13_hv_nmos L=1U W=8U AS=1.52P AD=1.52P PS=8.38U
+ PD=8.38U rfmode=0
M$17 \$5 \$4 \$34 vss sg13_hv_nmos L=1U W=8U AS=1.52P AD=1.52P PS=8.38U
+ PD=8.38U rfmode=0
M$18 \$34 \$4 \$5 vss sg13_hv_nmos L=1U W=8U AS=1.52P AD=1.52P PS=8.38U
+ PD=8.38U rfmode=0
M$19 \$5 \$4 \$34 vss sg13_hv_nmos L=1U W=8U AS=1.52P AD=2.72P PS=8.38U
+ PD=16.68U rfmode=0
M$20 \$35 \$4 \$6 vss sg13_hv_nmos L=1U W=8U AS=2.72P AD=1.52P PS=16.68U
+ PD=8.38U rfmode=0
M$21 \$6 \$4 \$35 vss sg13_hv_nmos L=1U W=8U AS=1.52P AD=1.52P PS=8.38U
+ PD=8.38U rfmode=0
M$22 \$35 \$4 \$6 vss sg13_hv_nmos L=1U W=8U AS=1.52P AD=1.52P PS=8.38U
+ PD=8.38U rfmode=0
M$23 \$6 \$4 \$35 vss sg13_hv_nmos L=1U W=8U AS=1.52P AD=1.52P PS=8.38U
+ PD=8.38U rfmode=0
M$24 \$35 \$4 \$6 vss sg13_hv_nmos L=1U W=8U AS=1.52P AD=1.52P PS=8.38U
+ PD=8.38U rfmode=0
M$25 \$6 \$4 \$35 vss sg13_hv_nmos L=1U W=8U AS=1.52P AD=2.72P PS=8.38U
+ PD=16.68U rfmode=0
M$26 \$6 iptat vss vss sg13_hv_nmos L=1U W=8U AS=2.72P AD=1.52P PS=16.68U
+ PD=8.38U rfmode=0
M$27 vss iptat \$6 vss sg13_hv_nmos L=1U W=8U AS=1.52P AD=1.52P PS=8.38U
+ PD=8.38U rfmode=0
M$28 \$6 iptat vss vss sg13_hv_nmos L=1U W=8U AS=1.52P AD=1.52P PS=8.38U
+ PD=8.38U rfmode=0
M$29 vss iptat \$6 vss sg13_hv_nmos L=1U W=8U AS=1.52P AD=1.52P PS=8.38U
+ PD=8.38U rfmode=0
M$30 \$6 iptat vss vss sg13_hv_nmos L=1U W=8U AS=1.52P AD=1.52P PS=8.38U
+ PD=8.38U rfmode=0
M$31 vss iptat \$6 vss sg13_hv_nmos L=1U W=8U AS=1.52P AD=1.52P PS=8.38U
+ PD=8.38U rfmode=0
M$32 \$6 iptat vss vss sg13_hv_nmos L=1U W=8U AS=1.52P AD=1.52P PS=8.38U
+ PD=8.38U rfmode=0
M$33 vss iptat \$6 vss sg13_hv_nmos L=1U W=8U AS=1.52P AD=1.52P PS=8.38U
+ PD=8.38U rfmode=0
M$34 \$6 iptat vss vss sg13_hv_nmos L=1U W=8U AS=1.52P AD=1.52P PS=8.38U
+ PD=8.38U rfmode=0
M$35 vss iptat \$6 vss sg13_hv_nmos L=1U W=8U AS=1.52P AD=2.72P PS=8.38U
+ PD=16.68U rfmode=0
M$36 isense iptat vss vss sg13_hv_nmos L=1U W=8U AS=2.72P AD=1.52P PS=16.68U
+ PD=8.38U rfmode=0
M$37 vss iptat isense vss sg13_hv_nmos L=1U W=8U AS=1.52P AD=1.52P PS=8.38U
+ PD=8.38U rfmode=0
M$38 isense iptat vss vss sg13_hv_nmos L=1U W=8U AS=1.52P AD=1.52P PS=8.38U
+ PD=8.38U rfmode=0
M$39 vss iptat isense vss sg13_hv_nmos L=1U W=8U AS=1.52P AD=1.52P PS=8.38U
+ PD=8.38U rfmode=0
M$40 isense iptat vss vss sg13_hv_nmos L=1U W=8U AS=1.52P AD=1.52P PS=8.38U
+ PD=8.38U rfmode=0
M$41 vss iptat isense vss sg13_hv_nmos L=1U W=8U AS=1.52P AD=1.52P PS=8.38U
+ PD=8.38U rfmode=0
M$42 isense iptat vss vss sg13_hv_nmos L=1U W=8U AS=1.52P AD=1.52P PS=8.38U
+ PD=8.38U rfmode=0
M$43 vss iptat isense vss sg13_hv_nmos L=1U W=8U AS=1.52P AD=1.52P PS=8.38U
+ PD=8.38U rfmode=0
M$44 isense iptat vss vss sg13_hv_nmos L=1U W=8U AS=1.52P AD=1.52P PS=8.38U
+ PD=8.38U rfmode=0
M$45 vss iptat isense vss sg13_hv_nmos L=1U W=8U AS=1.52P AD=1.52P PS=8.38U
+ PD=8.38U rfmode=0
M$46 isense iptat vss vss sg13_hv_nmos L=1U W=8U AS=1.52P AD=1.52P PS=8.38U
+ PD=8.38U rfmode=0
M$47 vss iptat isense vss sg13_hv_nmos L=1U W=8U AS=1.52P AD=2.72P PS=8.38U
+ PD=16.68U rfmode=0
M$48 \$140 \$140 vss vss sg13_hv_nmos L=1U W=1.6U AS=0.544P AD=0.544P PS=3.88U
+ PD=3.88U rfmode=0
M$49 \$138 iptat vss vss sg13_hv_nmos L=1U W=8U AS=2.72P AD=2.72P PS=16.68U
+ PD=16.68U rfmode=0
M$50 \$137 iptat vss vss sg13_hv_nmos L=1U W=8U AS=2.72P AD=2.72P PS=16.68U
+ PD=16.68U rfmode=0
M$51 \$139 iptat vss vss sg13_hv_nmos L=1U W=8U AS=2.72P AD=1.52P PS=16.68U
+ PD=8.38U rfmode=0
M$52 vss iptat \$139 vss sg13_hv_nmos L=1U W=8U AS=1.52P AD=1.52P PS=8.38U
+ PD=8.38U rfmode=0
M$53 \$139 iptat vss vss sg13_hv_nmos L=1U W=8U AS=1.52P AD=1.52P PS=8.38U
+ PD=8.38U rfmode=0
M$54 vss iptat \$139 vss sg13_hv_nmos L=1U W=8U AS=1.52P AD=1.52P PS=8.38U
+ PD=8.38U rfmode=0
M$55 \$139 iptat vss vss sg13_hv_nmos L=1U W=8U AS=1.52P AD=1.52P PS=8.38U
+ PD=8.38U rfmode=0
M$56 vss iptat \$139 vss sg13_hv_nmos L=1U W=8U AS=1.52P AD=1.52P PS=8.38U
+ PD=8.38U rfmode=0
M$57 \$139 iptat vss vss sg13_hv_nmos L=1U W=8U AS=1.52P AD=1.52P PS=8.38U
+ PD=8.38U rfmode=0
M$58 vss iptat \$139 vss sg13_hv_nmos L=1U W=8U AS=1.52P AD=1.52P PS=8.38U
+ PD=8.38U rfmode=0
M$59 \$139 iptat vss vss sg13_hv_nmos L=1U W=8U AS=1.52P AD=1.52P PS=8.38U
+ PD=8.38U rfmode=0
M$60 vss iptat \$139 vss sg13_hv_nmos L=1U W=8U AS=1.52P AD=2.72P PS=8.38U
+ PD=16.68U rfmode=0
M$61 \$143 \$140 \$139 vss sg13_hv_nmos L=1U W=8U AS=2.72P AD=1.52P PS=16.68U
+ PD=8.38U rfmode=0
M$62 \$139 \$140 \$143 vss sg13_hv_nmos L=1U W=8U AS=1.52P AD=1.52P PS=8.38U
+ PD=8.38U rfmode=0
M$63 \$143 \$140 \$139 vss sg13_hv_nmos L=1U W=8U AS=1.52P AD=1.52P PS=8.38U
+ PD=8.38U rfmode=0
M$64 \$139 \$140 \$143 vss sg13_hv_nmos L=1U W=8U AS=1.52P AD=1.52P PS=8.38U
+ PD=8.38U rfmode=0
M$65 \$143 \$140 \$139 vss sg13_hv_nmos L=1U W=8U AS=1.52P AD=1.52P PS=8.38U
+ PD=8.38U rfmode=0
M$66 \$139 \$140 \$143 vss sg13_hv_nmos L=1U W=8U AS=1.52P AD=2.72P PS=8.38U
+ PD=16.68U rfmode=0
M$67 \$144 \$140 \$141 vss sg13_hv_nmos L=1U W=8U AS=2.72P AD=1.52P PS=16.68U
+ PD=8.38U rfmode=0
M$68 \$141 \$140 \$144 vss sg13_hv_nmos L=1U W=8U AS=1.52P AD=1.52P PS=8.38U
+ PD=8.38U rfmode=0
M$69 \$144 \$140 \$141 vss sg13_hv_nmos L=1U W=8U AS=1.52P AD=1.52P PS=8.38U
+ PD=8.38U rfmode=0
M$70 \$141 \$140 \$144 vss sg13_hv_nmos L=1U W=8U AS=1.52P AD=1.52P PS=8.38U
+ PD=8.38U rfmode=0
M$71 \$144 \$140 \$141 vss sg13_hv_nmos L=1U W=8U AS=1.52P AD=1.52P PS=8.38U
+ PD=8.38U rfmode=0
M$72 \$141 \$140 \$144 vss sg13_hv_nmos L=1U W=8U AS=1.52P AD=2.72P PS=8.38U
+ PD=16.68U rfmode=0
M$73 \$141 iptat vss vss sg13_hv_nmos L=1U W=8U AS=2.72P AD=1.52P PS=16.68U
+ PD=8.38U rfmode=0
M$74 vss iptat \$141 vss sg13_hv_nmos L=1U W=8U AS=1.52P AD=1.52P PS=8.38U
+ PD=8.38U rfmode=0
M$75 \$141 iptat vss vss sg13_hv_nmos L=1U W=8U AS=1.52P AD=1.52P PS=8.38U
+ PD=8.38U rfmode=0
M$76 vss iptat \$141 vss sg13_hv_nmos L=1U W=8U AS=1.52P AD=1.52P PS=8.38U
+ PD=8.38U rfmode=0
M$77 \$141 iptat vss vss sg13_hv_nmos L=1U W=8U AS=1.52P AD=1.52P PS=8.38U
+ PD=8.38U rfmode=0
M$78 vss iptat \$141 vss sg13_hv_nmos L=1U W=8U AS=1.52P AD=1.52P PS=8.38U
+ PD=8.38U rfmode=0
M$79 \$141 iptat vss vss sg13_hv_nmos L=1U W=8U AS=1.52P AD=1.52P PS=8.38U
+ PD=8.38U rfmode=0
M$80 vss iptat \$141 vss sg13_hv_nmos L=1U W=8U AS=1.52P AD=1.52P PS=8.38U
+ PD=8.38U rfmode=0
M$81 \$141 iptat vss vss sg13_hv_nmos L=1U W=8U AS=1.52P AD=1.52P PS=8.38U
+ PD=8.38U rfmode=0
M$82 vss iptat \$141 vss sg13_hv_nmos L=1U W=8U AS=1.52P AD=2.72P PS=8.38U
+ PD=16.68U rfmode=0
M$83 vped iptat vss vss sg13_hv_nmos L=1U W=8U AS=2.72P AD=1.52P PS=16.68U
+ PD=8.38U rfmode=0
M$84 vss iptat vped vss sg13_hv_nmos L=1U W=8U AS=1.52P AD=1.52P PS=8.38U
+ PD=8.38U rfmode=0
M$85 vped iptat vss vss sg13_hv_nmos L=1U W=8U AS=1.52P AD=1.52P PS=8.38U
+ PD=8.38U rfmode=0
M$86 vss iptat vped vss sg13_hv_nmos L=1U W=8U AS=1.52P AD=1.52P PS=8.38U
+ PD=8.38U rfmode=0
M$87 vped iptat vss vss sg13_hv_nmos L=1U W=8U AS=1.52P AD=1.52P PS=8.38U
+ PD=8.38U rfmode=0
M$88 vss iptat vped vss sg13_hv_nmos L=1U W=8U AS=1.52P AD=1.52P PS=8.38U
+ PD=8.38U rfmode=0
M$89 vped iptat vss vss sg13_hv_nmos L=1U W=8U AS=1.52P AD=1.52P PS=8.38U
+ PD=8.38U rfmode=0
M$90 vss iptat vped vss sg13_hv_nmos L=1U W=8U AS=1.52P AD=1.52P PS=8.38U
+ PD=8.38U rfmode=0
M$91 vped iptat vss vss sg13_hv_nmos L=1U W=8U AS=1.52P AD=1.52P PS=8.38U
+ PD=8.38U rfmode=0
M$92 vss iptat vped vss sg13_hv_nmos L=1U W=8U AS=1.52P AD=1.52P PS=8.38U
+ PD=8.38U rfmode=0
M$93 vped iptat vss vss sg13_hv_nmos L=1U W=8U AS=1.52P AD=1.52P PS=8.38U
+ PD=8.38U rfmode=0
M$94 vss iptat vped vss sg13_hv_nmos L=1U W=8U AS=1.52P AD=2.72P PS=8.38U
+ PD=16.68U rfmode=0
M$95 iptat iptat vss vss sg13_hv_nmos L=1U W=3.3U AS=1.122P AD=1.122P PS=7.28U
+ PD=7.28U rfmode=0
M$96 \$246 \$246 vss vss sg13_hv_nmos L=1U W=1.6U AS=0.544P AD=0.544P PS=3.88U
+ PD=3.88U rfmode=0
M$97 \$244 iptat vss vss sg13_hv_nmos L=1U W=8U AS=2.72P AD=2.72P PS=16.68U
+ PD=16.68U rfmode=0
M$98 \$243 iptat vss vss sg13_hv_nmos L=1U W=8U AS=2.72P AD=2.72P PS=16.68U
+ PD=16.68U rfmode=0
M$99 \$245 iptat vss vss sg13_hv_nmos L=1U W=8U AS=2.72P AD=1.52P PS=16.68U
+ PD=8.38U rfmode=0
M$100 vss iptat \$245 vss sg13_hv_nmos L=1U W=8U AS=1.52P AD=1.52P PS=8.38U
+ PD=8.38U rfmode=0
M$101 \$245 iptat vss vss sg13_hv_nmos L=1U W=8U AS=1.52P AD=1.52P PS=8.38U
+ PD=8.38U rfmode=0
M$102 vss iptat \$245 vss sg13_hv_nmos L=1U W=8U AS=1.52P AD=1.52P PS=8.38U
+ PD=8.38U rfmode=0
M$103 \$245 iptat vss vss sg13_hv_nmos L=1U W=8U AS=1.52P AD=1.52P PS=8.38U
+ PD=8.38U rfmode=0
M$104 vss iptat \$245 vss sg13_hv_nmos L=1U W=8U AS=1.52P AD=1.52P PS=8.38U
+ PD=8.38U rfmode=0
M$105 \$245 iptat vss vss sg13_hv_nmos L=1U W=8U AS=1.52P AD=1.52P PS=8.38U
+ PD=8.38U rfmode=0
M$106 vss iptat \$245 vss sg13_hv_nmos L=1U W=8U AS=1.52P AD=1.52P PS=8.38U
+ PD=8.38U rfmode=0
M$107 \$245 iptat vss vss sg13_hv_nmos L=1U W=8U AS=1.52P AD=1.52P PS=8.38U
+ PD=8.38U rfmode=0
M$108 vss iptat \$245 vss sg13_hv_nmos L=1U W=8U AS=1.52P AD=2.72P PS=8.38U
+ PD=16.68U rfmode=0
M$109 \$249 \$246 \$245 vss sg13_hv_nmos L=1U W=8U AS=2.72P AD=1.52P PS=16.68U
+ PD=8.38U rfmode=0
M$110 \$245 \$246 \$249 vss sg13_hv_nmos L=1U W=8U AS=1.52P AD=1.52P PS=8.38U
+ PD=8.38U rfmode=0
M$111 \$249 \$246 \$245 vss sg13_hv_nmos L=1U W=8U AS=1.52P AD=1.52P PS=8.38U
+ PD=8.38U rfmode=0
M$112 \$245 \$246 \$249 vss sg13_hv_nmos L=1U W=8U AS=1.52P AD=1.52P PS=8.38U
+ PD=8.38U rfmode=0
M$113 \$249 \$246 \$245 vss sg13_hv_nmos L=1U W=8U AS=1.52P AD=1.52P PS=8.38U
+ PD=8.38U rfmode=0
M$114 \$245 \$246 \$249 vss sg13_hv_nmos L=1U W=8U AS=1.52P AD=2.72P PS=8.38U
+ PD=16.68U rfmode=0
M$115 \$250 \$246 \$247 vss sg13_hv_nmos L=1U W=8U AS=2.72P AD=1.52P PS=16.68U
+ PD=8.38U rfmode=0
M$116 \$247 \$246 \$250 vss sg13_hv_nmos L=1U W=8U AS=1.52P AD=1.52P PS=8.38U
+ PD=8.38U rfmode=0
M$117 \$250 \$246 \$247 vss sg13_hv_nmos L=1U W=8U AS=1.52P AD=1.52P PS=8.38U
+ PD=8.38U rfmode=0
M$118 \$247 \$246 \$250 vss sg13_hv_nmos L=1U W=8U AS=1.52P AD=1.52P PS=8.38U
+ PD=8.38U rfmode=0
M$119 \$250 \$246 \$247 vss sg13_hv_nmos L=1U W=8U AS=1.52P AD=1.52P PS=8.38U
+ PD=8.38U rfmode=0
M$120 \$247 \$246 \$250 vss sg13_hv_nmos L=1U W=8U AS=1.52P AD=2.72P PS=8.38U
+ PD=16.68U rfmode=0
M$121 \$247 iptat vss vss sg13_hv_nmos L=1U W=8U AS=2.72P AD=1.52P PS=16.68U
+ PD=8.38U rfmode=0
M$122 vss iptat \$247 vss sg13_hv_nmos L=1U W=8U AS=1.52P AD=1.52P PS=8.38U
+ PD=8.38U rfmode=0
M$123 \$247 iptat vss vss sg13_hv_nmos L=1U W=8U AS=1.52P AD=1.52P PS=8.38U
+ PD=8.38U rfmode=0
M$124 vss iptat \$247 vss sg13_hv_nmos L=1U W=8U AS=1.52P AD=1.52P PS=8.38U
+ PD=8.38U rfmode=0
M$125 \$247 iptat vss vss sg13_hv_nmos L=1U W=8U AS=1.52P AD=1.52P PS=8.38U
+ PD=8.38U rfmode=0
M$126 vss iptat \$247 vss sg13_hv_nmos L=1U W=8U AS=1.52P AD=1.52P PS=8.38U
+ PD=8.38U rfmode=0
M$127 \$247 iptat vss vss sg13_hv_nmos L=1U W=8U AS=1.52P AD=1.52P PS=8.38U
+ PD=8.38U rfmode=0
M$128 vss iptat \$247 vss sg13_hv_nmos L=1U W=8U AS=1.52P AD=1.52P PS=8.38U
+ PD=8.38U rfmode=0
M$129 \$247 iptat vss vss sg13_hv_nmos L=1U W=8U AS=1.52P AD=1.52P PS=8.38U
+ PD=8.38U rfmode=0
M$130 vss iptat \$247 vss sg13_hv_nmos L=1U W=8U AS=1.52P AD=2.72P PS=8.38U
+ PD=16.68U rfmode=0
M$131 vref_buf iptat vss vss sg13_hv_nmos L=1U W=8U AS=2.72P AD=1.52P PS=16.68U
+ PD=8.38U rfmode=0
M$132 vss iptat vref_buf vss sg13_hv_nmos L=1U W=8U AS=1.52P AD=1.52P PS=8.38U
+ PD=8.38U rfmode=0
M$133 vref_buf iptat vss vss sg13_hv_nmos L=1U W=8U AS=1.52P AD=1.52P PS=8.38U
+ PD=8.38U rfmode=0
M$134 vss iptat vref_buf vss sg13_hv_nmos L=1U W=8U AS=1.52P AD=1.52P PS=8.38U
+ PD=8.38U rfmode=0
M$135 vref_buf iptat vss vss sg13_hv_nmos L=1U W=8U AS=1.52P AD=1.52P PS=8.38U
+ PD=8.38U rfmode=0
M$136 vss iptat vref_buf vss sg13_hv_nmos L=1U W=8U AS=1.52P AD=1.52P PS=8.38U
+ PD=8.38U rfmode=0
M$137 vref_buf iptat vss vss sg13_hv_nmos L=1U W=8U AS=1.52P AD=1.52P PS=8.38U
+ PD=8.38U rfmode=0
M$138 vss iptat vref_buf vss sg13_hv_nmos L=1U W=8U AS=1.52P AD=1.52P PS=8.38U
+ PD=8.38U rfmode=0
M$139 vref_buf iptat vss vss sg13_hv_nmos L=1U W=8U AS=1.52P AD=1.52P PS=8.38U
+ PD=8.38U rfmode=0
M$140 vss iptat vref_buf vss sg13_hv_nmos L=1U W=8U AS=1.52P AD=1.52P PS=8.38U
+ PD=8.38U rfmode=0
M$141 vref_buf iptat vss vss sg13_hv_nmos L=1U W=8U AS=1.52P AD=1.52P PS=8.38U
+ PD=8.38U rfmode=0
M$142 vss iptat vref_buf vss sg13_hv_nmos L=1U W=8U AS=1.52P AD=2.72P PS=8.38U
+ PD=16.68U rfmode=0
M$143 \$57 \$34 vdd vdd sg13_hv_pmos L=1U W=8U AS=2.72P AD=1.52P PS=16.68U
+ PD=8.38U rfmode=0
M$144 vdd \$34 \$57 vdd sg13_hv_pmos L=1U W=8U AS=1.52P AD=1.52P PS=8.38U
+ PD=8.38U rfmode=0
M$145 \$57 \$34 vdd vdd sg13_hv_pmos L=1U W=8U AS=1.52P AD=1.52P PS=8.38U
+ PD=8.38U rfmode=0
M$146 vdd \$34 \$57 vdd sg13_hv_pmos L=1U W=8U AS=1.52P AD=1.52P PS=8.38U
+ PD=8.38U rfmode=0
M$147 \$57 \$34 vdd vdd sg13_hv_pmos L=1U W=8U AS=1.52P AD=1.52P PS=8.38U
+ PD=8.38U rfmode=0
M$148 vdd \$34 \$57 vdd sg13_hv_pmos L=1U W=8U AS=1.52P AD=1.52P PS=8.38U
+ PD=8.38U rfmode=0
M$149 \$57 \$34 vdd vdd sg13_hv_pmos L=1U W=8U AS=1.52P AD=1.52P PS=8.38U
+ PD=8.38U rfmode=0
M$150 vdd \$34 \$57 vdd sg13_hv_pmos L=1U W=8U AS=1.52P AD=1.52P PS=8.38U
+ PD=8.38U rfmode=0
M$151 \$57 \$34 vdd vdd sg13_hv_pmos L=1U W=8U AS=1.52P AD=1.52P PS=8.38U
+ PD=8.38U rfmode=0
M$152 vdd \$34 \$57 vdd sg13_hv_pmos L=1U W=8U AS=1.52P AD=1.52P PS=8.38U
+ PD=8.38U rfmode=0
M$153 \$57 \$34 vdd vdd sg13_hv_pmos L=1U W=8U AS=1.52P AD=1.52P PS=8.38U
+ PD=8.38U rfmode=0
M$154 vdd \$34 \$57 vdd sg13_hv_pmos L=1U W=8U AS=1.52P AD=2.72P PS=8.38U
+ PD=16.68U rfmode=0
M$155 \$34 \$2 \$57 vdd sg13_hv_pmos L=1U W=8U AS=2.72P AD=1.52P PS=16.68U
+ PD=8.38U rfmode=0
M$156 \$57 \$2 \$34 vdd sg13_hv_pmos L=1U W=8U AS=1.52P AD=1.52P PS=8.38U
+ PD=8.38U rfmode=0
M$157 \$34 \$2 \$57 vdd sg13_hv_pmos L=1U W=8U AS=1.52P AD=1.52P PS=8.38U
+ PD=8.38U rfmode=0
M$158 \$57 \$2 \$34 vdd sg13_hv_pmos L=1U W=8U AS=1.52P AD=1.52P PS=8.38U
+ PD=8.38U rfmode=0
M$159 \$34 \$2 \$57 vdd sg13_hv_pmos L=1U W=8U AS=1.52P AD=1.52P PS=8.38U
+ PD=8.38U rfmode=0
M$160 \$57 \$2 \$34 vdd sg13_hv_pmos L=1U W=8U AS=1.52P AD=1.52P PS=8.38U
+ PD=8.38U rfmode=0
M$161 \$34 \$2 \$57 vdd sg13_hv_pmos L=1U W=8U AS=1.52P AD=1.52P PS=8.38U
+ PD=8.38U rfmode=0
M$162 \$57 \$2 \$34 vdd sg13_hv_pmos L=1U W=8U AS=1.52P AD=1.52P PS=8.38U
+ PD=8.38U rfmode=0
M$163 \$34 \$2 \$57 vdd sg13_hv_pmos L=1U W=8U AS=1.52P AD=1.52P PS=8.38U
+ PD=8.38U rfmode=0
M$164 \$57 \$2 \$34 vdd sg13_hv_pmos L=1U W=8U AS=1.52P AD=1.52P PS=8.38U
+ PD=8.38U rfmode=0
M$165 \$34 \$2 \$57 vdd sg13_hv_pmos L=1U W=8U AS=1.52P AD=1.52P PS=8.38U
+ PD=8.38U rfmode=0
M$166 \$57 \$2 \$34 vdd sg13_hv_pmos L=1U W=8U AS=1.52P AD=2.72P PS=8.38U
+ PD=16.68U rfmode=0
M$167 \$35 \$2 \$58 vdd sg13_hv_pmos L=1U W=8U AS=2.72P AD=1.52P PS=16.68U
+ PD=8.38U rfmode=0
M$168 \$58 \$2 \$35 vdd sg13_hv_pmos L=1U W=8U AS=1.52P AD=1.52P PS=8.38U
+ PD=8.38U rfmode=0
M$169 \$35 \$2 \$58 vdd sg13_hv_pmos L=1U W=8U AS=1.52P AD=1.52P PS=8.38U
+ PD=8.38U rfmode=0
M$170 \$58 \$2 \$35 vdd sg13_hv_pmos L=1U W=8U AS=1.52P AD=1.52P PS=8.38U
+ PD=8.38U rfmode=0
M$171 \$35 \$2 \$58 vdd sg13_hv_pmos L=1U W=8U AS=1.52P AD=1.52P PS=8.38U
+ PD=8.38U rfmode=0
M$172 \$58 \$2 \$35 vdd sg13_hv_pmos L=1U W=8U AS=1.52P AD=1.52P PS=8.38U
+ PD=8.38U rfmode=0
M$173 \$35 \$2 \$58 vdd sg13_hv_pmos L=1U W=8U AS=1.52P AD=1.52P PS=8.38U
+ PD=8.38U rfmode=0
M$174 \$58 \$2 \$35 vdd sg13_hv_pmos L=1U W=8U AS=1.52P AD=1.52P PS=8.38U
+ PD=8.38U rfmode=0
M$175 \$35 \$2 \$58 vdd sg13_hv_pmos L=1U W=8U AS=1.52P AD=1.52P PS=8.38U
+ PD=8.38U rfmode=0
M$176 \$58 \$2 \$35 vdd sg13_hv_pmos L=1U W=8U AS=1.52P AD=1.52P PS=8.38U
+ PD=8.38U rfmode=0
M$177 \$35 \$2 \$58 vdd sg13_hv_pmos L=1U W=8U AS=1.52P AD=1.52P PS=8.38U
+ PD=8.38U rfmode=0
M$178 \$58 \$2 \$35 vdd sg13_hv_pmos L=1U W=8U AS=1.52P AD=2.72P PS=8.38U
+ PD=16.68U rfmode=0
M$179 \$58 \$34 vdd vdd sg13_hv_pmos L=1U W=8U AS=2.72P AD=1.52P PS=16.68U
+ PD=8.38U rfmode=0
M$180 vdd \$34 \$58 vdd sg13_hv_pmos L=1U W=8U AS=1.52P AD=1.52P PS=8.38U
+ PD=8.38U rfmode=0
M$181 \$58 \$34 vdd vdd sg13_hv_pmos L=1U W=8U AS=1.52P AD=1.52P PS=8.38U
+ PD=8.38U rfmode=0
M$182 vdd \$34 \$58 vdd sg13_hv_pmos L=1U W=8U AS=1.52P AD=1.52P PS=8.38U
+ PD=8.38U rfmode=0
M$183 \$58 \$34 vdd vdd sg13_hv_pmos L=1U W=8U AS=1.52P AD=1.52P PS=8.38U
+ PD=8.38U rfmode=0
M$184 vdd \$34 \$58 vdd sg13_hv_pmos L=1U W=8U AS=1.52P AD=1.52P PS=8.38U
+ PD=8.38U rfmode=0
M$185 \$58 \$34 vdd vdd sg13_hv_pmos L=1U W=8U AS=1.52P AD=1.52P PS=8.38U
+ PD=8.38U rfmode=0
M$186 vdd \$34 \$58 vdd sg13_hv_pmos L=1U W=8U AS=1.52P AD=1.52P PS=8.38U
+ PD=8.38U rfmode=0
M$187 \$58 \$34 vdd vdd sg13_hv_pmos L=1U W=8U AS=1.52P AD=1.52P PS=8.38U
+ PD=8.38U rfmode=0
M$188 vdd \$34 \$58 vdd sg13_hv_pmos L=1U W=8U AS=1.52P AD=1.52P PS=8.38U
+ PD=8.38U rfmode=0
M$189 \$58 \$34 vdd vdd sg13_hv_pmos L=1U W=8U AS=1.52P AD=1.52P PS=8.38U
+ PD=8.38U rfmode=0
M$190 vdd \$34 \$58 vdd sg13_hv_pmos L=1U W=8U AS=1.52P AD=2.72P PS=8.38U
+ PD=16.68U rfmode=0
M$191 \$5 \$69 \$68 vdd sg13_hv_pmos L=2U W=6U AS=2.04P AD=1.14P PS=12.68U
+ PD=6.38U rfmode=0
M$192 \$68 \$69 \$5 vdd sg13_hv_pmos L=2U W=6U AS=1.14P AD=1.14P PS=6.38U
+ PD=6.38U rfmode=0
M$193 \$6 \$74 \$68 vdd sg13_hv_pmos L=2U W=6U AS=1.14P AD=1.14P PS=6.38U
+ PD=6.38U rfmode=0
M$194 \$68 \$74 \$6 vdd sg13_hv_pmos L=2U W=6U AS=1.14P AD=1.14P PS=6.38U
+ PD=6.38U rfmode=0
M$195 \$6 \$74 \$68 vdd sg13_hv_pmos L=2U W=6U AS=1.14P AD=1.14P PS=6.38U
+ PD=6.38U rfmode=0
M$196 \$68 \$74 \$6 vdd sg13_hv_pmos L=2U W=6U AS=1.14P AD=1.14P PS=6.38U
+ PD=6.38U rfmode=0
M$197 \$5 \$69 \$68 vdd sg13_hv_pmos L=2U W=6U AS=1.14P AD=1.14P PS=6.38U
+ PD=6.38U rfmode=0
M$198 \$68 \$69 \$5 vdd sg13_hv_pmos L=2U W=6U AS=1.14P AD=1.14P PS=6.38U
+ PD=6.38U rfmode=0
M$199 \$5 \$69 \$68 vdd sg13_hv_pmos L=2U W=6U AS=1.14P AD=1.14P PS=6.38U
+ PD=6.38U rfmode=0
M$200 \$68 \$69 \$5 vdd sg13_hv_pmos L=2U W=6U AS=1.14P AD=1.14P PS=6.38U
+ PD=6.38U rfmode=0
M$201 \$6 \$74 \$68 vdd sg13_hv_pmos L=2U W=6U AS=1.14P AD=1.14P PS=6.38U
+ PD=6.38U rfmode=0
M$202 \$68 \$74 \$6 vdd sg13_hv_pmos L=2U W=6U AS=1.14P AD=1.14P PS=6.38U
+ PD=6.38U rfmode=0
M$203 \$6 \$74 \$68 vdd sg13_hv_pmos L=2U W=6U AS=1.14P AD=1.14P PS=6.38U
+ PD=6.38U rfmode=0
M$204 \$68 \$74 \$6 vdd sg13_hv_pmos L=2U W=6U AS=1.14P AD=1.14P PS=6.38U
+ PD=6.38U rfmode=0
M$205 \$5 \$69 \$68 vdd sg13_hv_pmos L=2U W=6U AS=1.14P AD=1.14P PS=6.38U
+ PD=6.38U rfmode=0
M$206 \$68 \$69 \$5 vdd sg13_hv_pmos L=2U W=6U AS=1.14P AD=1.14P PS=6.38U
+ PD=6.38U rfmode=0
M$207 \$5 \$69 \$68 vdd sg13_hv_pmos L=2U W=6U AS=1.14P AD=1.14P PS=6.38U
+ PD=6.38U rfmode=0
M$208 \$68 \$69 \$5 vdd sg13_hv_pmos L=2U W=6U AS=1.14P AD=1.14P PS=6.38U
+ PD=6.38U rfmode=0
M$209 \$6 \$74 \$68 vdd sg13_hv_pmos L=2U W=6U AS=1.14P AD=1.14P PS=6.38U
+ PD=6.38U rfmode=0
M$210 \$68 \$74 \$6 vdd sg13_hv_pmos L=2U W=6U AS=1.14P AD=1.14P PS=6.38U
+ PD=6.38U rfmode=0
M$211 \$6 \$74 \$68 vdd sg13_hv_pmos L=2U W=6U AS=1.14P AD=1.14P PS=6.38U
+ PD=6.38U rfmode=0
M$212 \$68 \$74 \$6 vdd sg13_hv_pmos L=2U W=6U AS=1.14P AD=1.14P PS=6.38U
+ PD=6.38U rfmode=0
M$213 \$5 \$69 \$68 vdd sg13_hv_pmos L=2U W=6U AS=1.14P AD=1.14P PS=6.38U
+ PD=6.38U rfmode=0
M$214 \$68 \$69 \$5 vdd sg13_hv_pmos L=2U W=6U AS=1.14P AD=1.14P PS=6.38U
+ PD=6.38U rfmode=0
M$215 \$5 \$69 \$68 vdd sg13_hv_pmos L=2U W=6U AS=1.14P AD=1.14P PS=6.38U
+ PD=6.38U rfmode=0
M$216 \$68 \$69 \$5 vdd sg13_hv_pmos L=2U W=6U AS=1.14P AD=1.14P PS=6.38U
+ PD=6.38U rfmode=0
M$217 \$6 \$74 \$68 vdd sg13_hv_pmos L=2U W=6U AS=1.14P AD=1.14P PS=6.38U
+ PD=6.38U rfmode=0
M$218 \$68 \$74 \$6 vdd sg13_hv_pmos L=2U W=6U AS=1.14P AD=1.14P PS=6.38U
+ PD=6.38U rfmode=0
M$219 \$6 \$74 \$68 vdd sg13_hv_pmos L=2U W=6U AS=1.14P AD=1.14P PS=6.38U
+ PD=6.38U rfmode=0
M$220 \$68 \$74 \$6 vdd sg13_hv_pmos L=2U W=6U AS=1.14P AD=1.14P PS=6.38U
+ PD=6.38U rfmode=0
M$221 \$5 \$69 \$68 vdd sg13_hv_pmos L=2U W=6U AS=1.14P AD=1.14P PS=6.38U
+ PD=6.38U rfmode=0
M$222 \$68 \$69 \$5 vdd sg13_hv_pmos L=2U W=6U AS=1.14P AD=2.04P PS=6.38U
+ PD=12.68U rfmode=0
M$223 \$2 \$2 vdd vdd sg13_hv_pmos L=1U W=3.2U AS=1.088P AD=1.088P PS=7.08U
+ PD=7.08U rfmode=0
M$224 \$4 \$3 vdd vdd sg13_hv_pmos L=1U W=8U AS=2.72P AD=1.52P PS=16.68U
+ PD=8.38U rfmode=0
M$225 vdd \$3 \$4 vdd sg13_hv_pmos L=1U W=8U AS=1.52P AD=2.72P PS=8.38U
+ PD=16.68U rfmode=0
M$226 \$3 \$3 vdd vdd sg13_hv_pmos L=1U W=8U AS=2.72P AD=1.52P PS=16.68U
+ PD=8.38U rfmode=0
M$227 vdd \$3 \$3 vdd sg13_hv_pmos L=1U W=8U AS=1.52P AD=2.72P PS=8.38U
+ PD=16.68U rfmode=0
M$228 \$68 \$3 vdd vdd sg13_hv_pmos L=1U W=8U AS=2.72P AD=1.52P PS=16.68U
+ PD=8.38U rfmode=0
M$229 vdd \$3 \$68 vdd sg13_hv_pmos L=1U W=8U AS=1.52P AD=1.52P PS=8.38U
+ PD=8.38U rfmode=0
M$230 \$68 \$3 vdd vdd sg13_hv_pmos L=1U W=8U AS=1.52P AD=1.52P PS=8.38U
+ PD=8.38U rfmode=0
M$231 vdd \$3 \$68 vdd sg13_hv_pmos L=1U W=8U AS=1.52P AD=1.52P PS=8.38U
+ PD=8.38U rfmode=0
M$232 \$68 \$3 vdd vdd sg13_hv_pmos L=1U W=8U AS=1.52P AD=1.52P PS=8.38U
+ PD=8.38U rfmode=0
M$233 vdd \$3 \$68 vdd sg13_hv_pmos L=1U W=8U AS=1.52P AD=1.52P PS=8.38U
+ PD=8.38U rfmode=0
M$234 \$68 \$3 vdd vdd sg13_hv_pmos L=1U W=8U AS=1.52P AD=1.52P PS=8.38U
+ PD=8.38U rfmode=0
M$235 vdd \$3 \$68 vdd sg13_hv_pmos L=1U W=8U AS=1.52P AD=1.52P PS=8.38U
+ PD=8.38U rfmode=0
M$236 \$68 \$3 vdd vdd sg13_hv_pmos L=1U W=8U AS=1.52P AD=1.52P PS=8.38U
+ PD=8.38U rfmode=0
M$237 vdd \$3 \$68 vdd sg13_hv_pmos L=1U W=8U AS=1.52P AD=1.52P PS=8.38U
+ PD=8.38U rfmode=0
M$238 \$68 \$3 vdd vdd sg13_hv_pmos L=1U W=8U AS=1.52P AD=1.52P PS=8.38U
+ PD=8.38U rfmode=0
M$239 vdd \$3 \$68 vdd sg13_hv_pmos L=1U W=8U AS=1.52P AD=1.52P PS=8.38U
+ PD=8.38U rfmode=0
M$240 \$68 \$3 vdd vdd sg13_hv_pmos L=1U W=8U AS=1.52P AD=1.52P PS=8.38U
+ PD=8.38U rfmode=0
M$241 vdd \$3 \$68 vdd sg13_hv_pmos L=1U W=8U AS=1.52P AD=1.52P PS=8.38U
+ PD=8.38U rfmode=0
M$242 \$68 \$3 vdd vdd sg13_hv_pmos L=1U W=8U AS=1.52P AD=1.52P PS=8.38U
+ PD=8.38U rfmode=0
M$243 vdd \$3 \$68 vdd sg13_hv_pmos L=1U W=8U AS=1.52P AD=2.72P PS=8.38U
+ PD=16.68U rfmode=0
M$244 isense \$35 vdd vdd sg13_hv_pmos L=1U W=8U AS=2.72P AD=1.52P PS=16.68U
+ PD=8.38U rfmode=0
M$245 vdd \$35 isense vdd sg13_hv_pmos L=1U W=8U AS=1.52P AD=1.52P PS=8.38U
+ PD=8.38U rfmode=0
M$246 isense \$35 vdd vdd sg13_hv_pmos L=1U W=8U AS=1.52P AD=1.52P PS=8.38U
+ PD=8.38U rfmode=0
M$247 vdd \$35 isense vdd sg13_hv_pmos L=1U W=8U AS=1.52P AD=1.52P PS=8.38U
+ PD=8.38U rfmode=0
M$248 isense \$35 vdd vdd sg13_hv_pmos L=1U W=8U AS=1.52P AD=1.52P PS=8.38U
+ PD=8.38U rfmode=0
M$249 vdd \$35 isense vdd sg13_hv_pmos L=1U W=8U AS=1.52P AD=1.52P PS=8.38U
+ PD=8.38U rfmode=0
M$250 isense \$35 vdd vdd sg13_hv_pmos L=1U W=8U AS=1.52P AD=1.52P PS=8.38U
+ PD=8.38U rfmode=0
M$251 vdd \$35 isense vdd sg13_hv_pmos L=1U W=8U AS=1.52P AD=1.52P PS=8.38U
+ PD=8.38U rfmode=0
M$252 isense \$35 vdd vdd sg13_hv_pmos L=1U W=8U AS=1.52P AD=1.52P PS=8.38U
+ PD=8.38U rfmode=0
M$253 vdd \$35 isense vdd sg13_hv_pmos L=1U W=8U AS=1.52P AD=1.52P PS=8.38U
+ PD=8.38U rfmode=0
M$254 isense \$35 vdd vdd sg13_hv_pmos L=1U W=8U AS=1.52P AD=1.52P PS=8.38U
+ PD=8.38U rfmode=0
M$255 vdd \$35 isense vdd sg13_hv_pmos L=1U W=8U AS=1.52P AD=1.52P PS=8.38U
+ PD=8.38U rfmode=0
M$256 isense \$35 vdd vdd sg13_hv_pmos L=1U W=8U AS=1.52P AD=1.52P PS=8.38U
+ PD=8.38U rfmode=0
M$257 vdd \$35 isense vdd sg13_hv_pmos L=1U W=8U AS=1.52P AD=1.52P PS=8.38U
+ PD=8.38U rfmode=0
M$258 isense \$35 vdd vdd sg13_hv_pmos L=1U W=8U AS=1.52P AD=1.52P PS=8.38U
+ PD=8.38U rfmode=0
M$259 vdd \$35 isense vdd sg13_hv_pmos L=1U W=8U AS=1.52P AD=1.52P PS=8.38U
+ PD=8.38U rfmode=0
M$260 isense \$35 vdd vdd sg13_hv_pmos L=1U W=8U AS=1.52P AD=1.52P PS=8.38U
+ PD=8.38U rfmode=0
M$261 vdd \$35 isense vdd sg13_hv_pmos L=1U W=8U AS=1.52P AD=1.52P PS=8.38U
+ PD=8.38U rfmode=0
M$262 isense \$35 vdd vdd sg13_hv_pmos L=1U W=8U AS=1.52P AD=1.52P PS=8.38U
+ PD=8.38U rfmode=0
M$263 vdd \$35 isense vdd sg13_hv_pmos L=1U W=8U AS=1.52P AD=1.52P PS=8.38U
+ PD=8.38U rfmode=0
M$264 isense \$35 vdd vdd sg13_hv_pmos L=1U W=8U AS=1.52P AD=1.52P PS=8.38U
+ PD=8.38U rfmode=0
M$265 vdd \$35 isense vdd sg13_hv_pmos L=1U W=8U AS=1.52P AD=1.52P PS=8.38U
+ PD=8.38U rfmode=0
M$266 isense \$35 vdd vdd sg13_hv_pmos L=1U W=8U AS=1.52P AD=1.52P PS=8.38U
+ PD=8.38U rfmode=0
M$267 vdd \$35 isense vdd sg13_hv_pmos L=1U W=8U AS=1.52P AD=2.72P PS=8.38U
+ PD=16.68U rfmode=0
M$268 \$162 \$143 vdd vdd sg13_hv_pmos L=1U W=8U AS=2.72P AD=1.52P PS=16.68U
+ PD=8.38U rfmode=0
M$269 vdd \$143 \$162 vdd sg13_hv_pmos L=1U W=8U AS=1.52P AD=1.52P PS=8.38U
+ PD=8.38U rfmode=0
M$270 \$162 \$143 vdd vdd sg13_hv_pmos L=1U W=8U AS=1.52P AD=1.52P PS=8.38U
+ PD=8.38U rfmode=0
M$271 vdd \$143 \$162 vdd sg13_hv_pmos L=1U W=8U AS=1.52P AD=1.52P PS=8.38U
+ PD=8.38U rfmode=0
M$272 \$162 \$143 vdd vdd sg13_hv_pmos L=1U W=8U AS=1.52P AD=1.52P PS=8.38U
+ PD=8.38U rfmode=0
M$273 vdd \$143 \$162 vdd sg13_hv_pmos L=1U W=8U AS=1.52P AD=1.52P PS=8.38U
+ PD=8.38U rfmode=0
M$274 \$162 \$143 vdd vdd sg13_hv_pmos L=1U W=8U AS=1.52P AD=1.52P PS=8.38U
+ PD=8.38U rfmode=0
M$275 vdd \$143 \$162 vdd sg13_hv_pmos L=1U W=8U AS=1.52P AD=1.52P PS=8.38U
+ PD=8.38U rfmode=0
M$276 \$162 \$143 vdd vdd sg13_hv_pmos L=1U W=8U AS=1.52P AD=1.52P PS=8.38U
+ PD=8.38U rfmode=0
M$277 vdd \$143 \$162 vdd sg13_hv_pmos L=1U W=8U AS=1.52P AD=1.52P PS=8.38U
+ PD=8.38U rfmode=0
M$278 \$162 \$143 vdd vdd sg13_hv_pmos L=1U W=8U AS=1.52P AD=1.52P PS=8.38U
+ PD=8.38U rfmode=0
M$279 vdd \$143 \$162 vdd sg13_hv_pmos L=1U W=8U AS=1.52P AD=2.72P PS=8.38U
+ PD=16.68U rfmode=0
M$280 \$143 \$137 \$162 vdd sg13_hv_pmos L=1U W=8U AS=2.72P AD=1.52P PS=16.68U
+ PD=8.38U rfmode=0
M$281 \$162 \$137 \$143 vdd sg13_hv_pmos L=1U W=8U AS=1.52P AD=1.52P PS=8.38U
+ PD=8.38U rfmode=0
M$282 \$143 \$137 \$162 vdd sg13_hv_pmos L=1U W=8U AS=1.52P AD=1.52P PS=8.38U
+ PD=8.38U rfmode=0
M$283 \$162 \$137 \$143 vdd sg13_hv_pmos L=1U W=8U AS=1.52P AD=1.52P PS=8.38U
+ PD=8.38U rfmode=0
M$284 \$143 \$137 \$162 vdd sg13_hv_pmos L=1U W=8U AS=1.52P AD=1.52P PS=8.38U
+ PD=8.38U rfmode=0
M$285 \$162 \$137 \$143 vdd sg13_hv_pmos L=1U W=8U AS=1.52P AD=1.52P PS=8.38U
+ PD=8.38U rfmode=0
M$286 \$143 \$137 \$162 vdd sg13_hv_pmos L=1U W=8U AS=1.52P AD=1.52P PS=8.38U
+ PD=8.38U rfmode=0
M$287 \$162 \$137 \$143 vdd sg13_hv_pmos L=1U W=8U AS=1.52P AD=1.52P PS=8.38U
+ PD=8.38U rfmode=0
M$288 \$143 \$137 \$162 vdd sg13_hv_pmos L=1U W=8U AS=1.52P AD=1.52P PS=8.38U
+ PD=8.38U rfmode=0
M$289 \$162 \$137 \$143 vdd sg13_hv_pmos L=1U W=8U AS=1.52P AD=1.52P PS=8.38U
+ PD=8.38U rfmode=0
M$290 \$143 \$137 \$162 vdd sg13_hv_pmos L=1U W=8U AS=1.52P AD=1.52P PS=8.38U
+ PD=8.38U rfmode=0
M$291 \$162 \$137 \$143 vdd sg13_hv_pmos L=1U W=8U AS=1.52P AD=2.72P PS=8.38U
+ PD=16.68U rfmode=0
M$292 \$144 \$137 \$163 vdd sg13_hv_pmos L=1U W=8U AS=2.72P AD=1.52P PS=16.68U
+ PD=8.38U rfmode=0
M$293 \$163 \$137 \$144 vdd sg13_hv_pmos L=1U W=8U AS=1.52P AD=1.52P PS=8.38U
+ PD=8.38U rfmode=0
M$294 \$144 \$137 \$163 vdd sg13_hv_pmos L=1U W=8U AS=1.52P AD=1.52P PS=8.38U
+ PD=8.38U rfmode=0
M$295 \$163 \$137 \$144 vdd sg13_hv_pmos L=1U W=8U AS=1.52P AD=1.52P PS=8.38U
+ PD=8.38U rfmode=0
M$296 \$144 \$137 \$163 vdd sg13_hv_pmos L=1U W=8U AS=1.52P AD=1.52P PS=8.38U
+ PD=8.38U rfmode=0
M$297 \$163 \$137 \$144 vdd sg13_hv_pmos L=1U W=8U AS=1.52P AD=1.52P PS=8.38U
+ PD=8.38U rfmode=0
M$298 \$144 \$137 \$163 vdd sg13_hv_pmos L=1U W=8U AS=1.52P AD=1.52P PS=8.38U
+ PD=8.38U rfmode=0
M$299 \$163 \$137 \$144 vdd sg13_hv_pmos L=1U W=8U AS=1.52P AD=1.52P PS=8.38U
+ PD=8.38U rfmode=0
M$300 \$144 \$137 \$163 vdd sg13_hv_pmos L=1U W=8U AS=1.52P AD=1.52P PS=8.38U
+ PD=8.38U rfmode=0
M$301 \$163 \$137 \$144 vdd sg13_hv_pmos L=1U W=8U AS=1.52P AD=1.52P PS=8.38U
+ PD=8.38U rfmode=0
M$302 \$144 \$137 \$163 vdd sg13_hv_pmos L=1U W=8U AS=1.52P AD=1.52P PS=8.38U
+ PD=8.38U rfmode=0
M$303 \$163 \$137 \$144 vdd sg13_hv_pmos L=1U W=8U AS=1.52P AD=2.72P PS=8.38U
+ PD=16.68U rfmode=0
M$304 \$163 \$143 vdd vdd sg13_hv_pmos L=1U W=8U AS=2.72P AD=1.52P PS=16.68U
+ PD=8.38U rfmode=0
M$305 vdd \$143 \$163 vdd sg13_hv_pmos L=1U W=8U AS=1.52P AD=1.52P PS=8.38U
+ PD=8.38U rfmode=0
M$306 \$163 \$143 vdd vdd sg13_hv_pmos L=1U W=8U AS=1.52P AD=1.52P PS=8.38U
+ PD=8.38U rfmode=0
M$307 vdd \$143 \$163 vdd sg13_hv_pmos L=1U W=8U AS=1.52P AD=1.52P PS=8.38U
+ PD=8.38U rfmode=0
M$308 \$163 \$143 vdd vdd sg13_hv_pmos L=1U W=8U AS=1.52P AD=1.52P PS=8.38U
+ PD=8.38U rfmode=0
M$309 vdd \$143 \$163 vdd sg13_hv_pmos L=1U W=8U AS=1.52P AD=1.52P PS=8.38U
+ PD=8.38U rfmode=0
M$310 \$163 \$143 vdd vdd sg13_hv_pmos L=1U W=8U AS=1.52P AD=1.52P PS=8.38U
+ PD=8.38U rfmode=0
M$311 vdd \$143 \$163 vdd sg13_hv_pmos L=1U W=8U AS=1.52P AD=1.52P PS=8.38U
+ PD=8.38U rfmode=0
M$312 \$163 \$143 vdd vdd sg13_hv_pmos L=1U W=8U AS=1.52P AD=1.52P PS=8.38U
+ PD=8.38U rfmode=0
M$313 vdd \$143 \$163 vdd sg13_hv_pmos L=1U W=8U AS=1.52P AD=1.52P PS=8.38U
+ PD=8.38U rfmode=0
M$314 \$163 \$143 vdd vdd sg13_hv_pmos L=1U W=8U AS=1.52P AD=1.52P PS=8.38U
+ PD=8.38U rfmode=0
M$315 vdd \$143 \$163 vdd sg13_hv_pmos L=1U W=8U AS=1.52P AD=2.72P PS=8.38U
+ PD=16.68U rfmode=0
M$316 \$139 vped \$202 vdd sg13_hv_pmos L=2U W=6U AS=2.04P AD=1.14P PS=12.68U
+ PD=6.38U rfmode=0
M$317 \$202 vped \$139 vdd sg13_hv_pmos L=2U W=6U AS=1.14P AD=1.14P PS=6.38U
+ PD=6.38U rfmode=0
M$318 \$141 \$228 \$202 vdd sg13_hv_pmos L=2U W=6U AS=1.14P AD=1.14P PS=6.38U
+ PD=6.38U rfmode=0
M$319 \$202 \$228 \$141 vdd sg13_hv_pmos L=2U W=6U AS=1.14P AD=1.14P PS=6.38U
+ PD=6.38U rfmode=0
M$320 \$141 \$228 \$202 vdd sg13_hv_pmos L=2U W=6U AS=1.14P AD=1.14P PS=6.38U
+ PD=6.38U rfmode=0
M$321 \$202 \$228 \$141 vdd sg13_hv_pmos L=2U W=6U AS=1.14P AD=1.14P PS=6.38U
+ PD=6.38U rfmode=0
M$322 \$139 vped \$202 vdd sg13_hv_pmos L=2U W=6U AS=1.14P AD=1.14P PS=6.38U
+ PD=6.38U rfmode=0
M$323 \$202 vped \$139 vdd sg13_hv_pmos L=2U W=6U AS=1.14P AD=1.14P PS=6.38U
+ PD=6.38U rfmode=0
M$324 \$139 vped \$202 vdd sg13_hv_pmos L=2U W=6U AS=1.14P AD=1.14P PS=6.38U
+ PD=6.38U rfmode=0
M$325 \$202 vped \$139 vdd sg13_hv_pmos L=2U W=6U AS=1.14P AD=1.14P PS=6.38U
+ PD=6.38U rfmode=0
M$326 \$141 \$228 \$202 vdd sg13_hv_pmos L=2U W=6U AS=1.14P AD=1.14P PS=6.38U
+ PD=6.38U rfmode=0
M$327 \$202 \$228 \$141 vdd sg13_hv_pmos L=2U W=6U AS=1.14P AD=1.14P PS=6.38U
+ PD=6.38U rfmode=0
M$328 \$141 \$228 \$202 vdd sg13_hv_pmos L=2U W=6U AS=1.14P AD=1.14P PS=6.38U
+ PD=6.38U rfmode=0
M$329 \$202 \$228 \$141 vdd sg13_hv_pmos L=2U W=6U AS=1.14P AD=1.14P PS=6.38U
+ PD=6.38U rfmode=0
M$330 \$139 vped \$202 vdd sg13_hv_pmos L=2U W=6U AS=1.14P AD=1.14P PS=6.38U
+ PD=6.38U rfmode=0
M$331 \$202 vped \$139 vdd sg13_hv_pmos L=2U W=6U AS=1.14P AD=1.14P PS=6.38U
+ PD=6.38U rfmode=0
M$332 \$139 vped \$202 vdd sg13_hv_pmos L=2U W=6U AS=1.14P AD=1.14P PS=6.38U
+ PD=6.38U rfmode=0
M$333 \$202 vped \$139 vdd sg13_hv_pmos L=2U W=6U AS=1.14P AD=1.14P PS=6.38U
+ PD=6.38U rfmode=0
M$334 \$141 \$228 \$202 vdd sg13_hv_pmos L=2U W=6U AS=1.14P AD=1.14P PS=6.38U
+ PD=6.38U rfmode=0
M$335 \$202 \$228 \$141 vdd sg13_hv_pmos L=2U W=6U AS=1.14P AD=1.14P PS=6.38U
+ PD=6.38U rfmode=0
M$336 \$141 \$228 \$202 vdd sg13_hv_pmos L=2U W=6U AS=1.14P AD=1.14P PS=6.38U
+ PD=6.38U rfmode=0
M$337 \$202 \$228 \$141 vdd sg13_hv_pmos L=2U W=6U AS=1.14P AD=1.14P PS=6.38U
+ PD=6.38U rfmode=0
M$338 \$139 vped \$202 vdd sg13_hv_pmos L=2U W=6U AS=1.14P AD=1.14P PS=6.38U
+ PD=6.38U rfmode=0
M$339 \$202 vped \$139 vdd sg13_hv_pmos L=2U W=6U AS=1.14P AD=1.14P PS=6.38U
+ PD=6.38U rfmode=0
M$340 \$139 vped \$202 vdd sg13_hv_pmos L=2U W=6U AS=1.14P AD=1.14P PS=6.38U
+ PD=6.38U rfmode=0
M$341 \$202 vped \$139 vdd sg13_hv_pmos L=2U W=6U AS=1.14P AD=1.14P PS=6.38U
+ PD=6.38U rfmode=0
M$342 \$141 \$228 \$202 vdd sg13_hv_pmos L=2U W=6U AS=1.14P AD=1.14P PS=6.38U
+ PD=6.38U rfmode=0
M$343 \$202 \$228 \$141 vdd sg13_hv_pmos L=2U W=6U AS=1.14P AD=1.14P PS=6.38U
+ PD=6.38U rfmode=0
M$344 \$141 \$228 \$202 vdd sg13_hv_pmos L=2U W=6U AS=1.14P AD=1.14P PS=6.38U
+ PD=6.38U rfmode=0
M$345 \$202 \$228 \$141 vdd sg13_hv_pmos L=2U W=6U AS=1.14P AD=1.14P PS=6.38U
+ PD=6.38U rfmode=0
M$346 \$139 vped \$202 vdd sg13_hv_pmos L=2U W=6U AS=1.14P AD=1.14P PS=6.38U
+ PD=6.38U rfmode=0
M$347 \$202 vped \$139 vdd sg13_hv_pmos L=2U W=6U AS=1.14P AD=2.04P PS=6.38U
+ PD=12.68U rfmode=0
M$348 \$137 \$137 vdd vdd sg13_hv_pmos L=1U W=3.2U AS=1.088P AD=1.088P PS=7.08U
+ PD=7.08U rfmode=0
M$349 \$140 \$138 vdd vdd sg13_hv_pmos L=1U W=8U AS=2.72P AD=1.52P PS=16.68U
+ PD=8.38U rfmode=0
M$350 vdd \$138 \$140 vdd sg13_hv_pmos L=1U W=8U AS=1.52P AD=2.72P PS=8.38U
+ PD=16.68U rfmode=0
M$351 \$138 \$138 vdd vdd sg13_hv_pmos L=1U W=8U AS=2.72P AD=1.52P PS=16.68U
+ PD=8.38U rfmode=0
M$352 vdd \$138 \$138 vdd sg13_hv_pmos L=1U W=8U AS=1.52P AD=2.72P PS=8.38U
+ PD=16.68U rfmode=0
M$353 \$202 \$138 vdd vdd sg13_hv_pmos L=1U W=8U AS=2.72P AD=1.52P PS=16.68U
+ PD=8.38U rfmode=0
M$354 vdd \$138 \$202 vdd sg13_hv_pmos L=1U W=8U AS=1.52P AD=1.52P PS=8.38U
+ PD=8.38U rfmode=0
M$355 \$202 \$138 vdd vdd sg13_hv_pmos L=1U W=8U AS=1.52P AD=1.52P PS=8.38U
+ PD=8.38U rfmode=0
M$356 vdd \$138 \$202 vdd sg13_hv_pmos L=1U W=8U AS=1.52P AD=1.52P PS=8.38U
+ PD=8.38U rfmode=0
M$357 \$202 \$138 vdd vdd sg13_hv_pmos L=1U W=8U AS=1.52P AD=1.52P PS=8.38U
+ PD=8.38U rfmode=0
M$358 vdd \$138 \$202 vdd sg13_hv_pmos L=1U W=8U AS=1.52P AD=1.52P PS=8.38U
+ PD=8.38U rfmode=0
M$359 \$202 \$138 vdd vdd sg13_hv_pmos L=1U W=8U AS=1.52P AD=1.52P PS=8.38U
+ PD=8.38U rfmode=0
M$360 vdd \$138 \$202 vdd sg13_hv_pmos L=1U W=8U AS=1.52P AD=1.52P PS=8.38U
+ PD=8.38U rfmode=0
M$361 \$202 \$138 vdd vdd sg13_hv_pmos L=1U W=8U AS=1.52P AD=1.52P PS=8.38U
+ PD=8.38U rfmode=0
M$362 vdd \$138 \$202 vdd sg13_hv_pmos L=1U W=8U AS=1.52P AD=1.52P PS=8.38U
+ PD=8.38U rfmode=0
M$363 \$202 \$138 vdd vdd sg13_hv_pmos L=1U W=8U AS=1.52P AD=1.52P PS=8.38U
+ PD=8.38U rfmode=0
M$364 vdd \$138 \$202 vdd sg13_hv_pmos L=1U W=8U AS=1.52P AD=1.52P PS=8.38U
+ PD=8.38U rfmode=0
M$365 \$202 \$138 vdd vdd sg13_hv_pmos L=1U W=8U AS=1.52P AD=1.52P PS=8.38U
+ PD=8.38U rfmode=0
M$366 vdd \$138 \$202 vdd sg13_hv_pmos L=1U W=8U AS=1.52P AD=1.52P PS=8.38U
+ PD=8.38U rfmode=0
M$367 \$202 \$138 vdd vdd sg13_hv_pmos L=1U W=8U AS=1.52P AD=1.52P PS=8.38U
+ PD=8.38U rfmode=0
M$368 vdd \$138 \$202 vdd sg13_hv_pmos L=1U W=8U AS=1.52P AD=2.72P PS=8.38U
+ PD=16.68U rfmode=0
M$369 vped \$144 vdd vdd sg13_hv_pmos L=1U W=8U AS=2.72P AD=1.52P PS=16.68U
+ PD=8.38U rfmode=0
M$370 vdd \$144 vped vdd sg13_hv_pmos L=1U W=8U AS=1.52P AD=1.52P PS=8.38U
+ PD=8.38U rfmode=0
M$371 vped \$144 vdd vdd sg13_hv_pmos L=1U W=8U AS=1.52P AD=1.52P PS=8.38U
+ PD=8.38U rfmode=0
M$372 vdd \$144 vped vdd sg13_hv_pmos L=1U W=8U AS=1.52P AD=1.52P PS=8.38U
+ PD=8.38U rfmode=0
M$373 vped \$144 vdd vdd sg13_hv_pmos L=1U W=8U AS=1.52P AD=1.52P PS=8.38U
+ PD=8.38U rfmode=0
M$374 vdd \$144 vped vdd sg13_hv_pmos L=1U W=8U AS=1.52P AD=1.52P PS=8.38U
+ PD=8.38U rfmode=0
M$375 vped \$144 vdd vdd sg13_hv_pmos L=1U W=8U AS=1.52P AD=1.52P PS=8.38U
+ PD=8.38U rfmode=0
M$376 vdd \$144 vped vdd sg13_hv_pmos L=1U W=8U AS=1.52P AD=1.52P PS=8.38U
+ PD=8.38U rfmode=0
M$377 vped \$144 vdd vdd sg13_hv_pmos L=1U W=8U AS=1.52P AD=1.52P PS=8.38U
+ PD=8.38U rfmode=0
M$378 vdd \$144 vped vdd sg13_hv_pmos L=1U W=8U AS=1.52P AD=1.52P PS=8.38U
+ PD=8.38U rfmode=0
M$379 vped \$144 vdd vdd sg13_hv_pmos L=1U W=8U AS=1.52P AD=1.52P PS=8.38U
+ PD=8.38U rfmode=0
M$380 vdd \$144 vped vdd sg13_hv_pmos L=1U W=8U AS=1.52P AD=1.52P PS=8.38U
+ PD=8.38U rfmode=0
M$381 vped \$144 vdd vdd sg13_hv_pmos L=1U W=8U AS=1.52P AD=1.52P PS=8.38U
+ PD=8.38U rfmode=0
M$382 vdd \$144 vped vdd sg13_hv_pmos L=1U W=8U AS=1.52P AD=1.52P PS=8.38U
+ PD=8.38U rfmode=0
M$383 vped \$144 vdd vdd sg13_hv_pmos L=1U W=8U AS=1.52P AD=1.52P PS=8.38U
+ PD=8.38U rfmode=0
M$384 vdd \$144 vped vdd sg13_hv_pmos L=1U W=8U AS=1.52P AD=1.52P PS=8.38U
+ PD=8.38U rfmode=0
M$385 vped \$144 vdd vdd sg13_hv_pmos L=1U W=8U AS=1.52P AD=1.52P PS=8.38U
+ PD=8.38U rfmode=0
M$386 vdd \$144 vped vdd sg13_hv_pmos L=1U W=8U AS=1.52P AD=1.52P PS=8.38U
+ PD=8.38U rfmode=0
M$387 vped \$144 vdd vdd sg13_hv_pmos L=1U W=8U AS=1.52P AD=1.52P PS=8.38U
+ PD=8.38U rfmode=0
M$388 vdd \$144 vped vdd sg13_hv_pmos L=1U W=8U AS=1.52P AD=1.52P PS=8.38U
+ PD=8.38U rfmode=0
M$389 vped \$144 vdd vdd sg13_hv_pmos L=1U W=8U AS=1.52P AD=1.52P PS=8.38U
+ PD=8.38U rfmode=0
M$390 vdd \$144 vped vdd sg13_hv_pmos L=1U W=8U AS=1.52P AD=1.52P PS=8.38U
+ PD=8.38U rfmode=0
M$391 vped \$144 vdd vdd sg13_hv_pmos L=1U W=8U AS=1.52P AD=1.52P PS=8.38U
+ PD=8.38U rfmode=0
M$392 vdd \$144 vped vdd sg13_hv_pmos L=1U W=8U AS=1.52P AD=2.72P PS=8.38U
+ PD=16.68U rfmode=0
M$393 \$315 \$249 vdd vdd sg13_hv_pmos L=1U W=8U AS=2.72P AD=1.52P PS=16.68U
+ PD=8.38U rfmode=0
M$394 vdd \$249 \$315 vdd sg13_hv_pmos L=1U W=8U AS=1.52P AD=1.52P PS=8.38U
+ PD=8.38U rfmode=0
M$395 \$315 \$249 vdd vdd sg13_hv_pmos L=1U W=8U AS=1.52P AD=1.52P PS=8.38U
+ PD=8.38U rfmode=0
M$396 vdd \$249 \$315 vdd sg13_hv_pmos L=1U W=8U AS=1.52P AD=1.52P PS=8.38U
+ PD=8.38U rfmode=0
M$397 \$315 \$249 vdd vdd sg13_hv_pmos L=1U W=8U AS=1.52P AD=1.52P PS=8.38U
+ PD=8.38U rfmode=0
M$398 vdd \$249 \$315 vdd sg13_hv_pmos L=1U W=8U AS=1.52P AD=1.52P PS=8.38U
+ PD=8.38U rfmode=0
M$399 \$315 \$249 vdd vdd sg13_hv_pmos L=1U W=8U AS=1.52P AD=1.52P PS=8.38U
+ PD=8.38U rfmode=0
M$400 vdd \$249 \$315 vdd sg13_hv_pmos L=1U W=8U AS=1.52P AD=1.52P PS=8.38U
+ PD=8.38U rfmode=0
M$401 \$315 \$249 vdd vdd sg13_hv_pmos L=1U W=8U AS=1.52P AD=1.52P PS=8.38U
+ PD=8.38U rfmode=0
M$402 vdd \$249 \$315 vdd sg13_hv_pmos L=1U W=8U AS=1.52P AD=1.52P PS=8.38U
+ PD=8.38U rfmode=0
M$403 \$315 \$249 vdd vdd sg13_hv_pmos L=1U W=8U AS=1.52P AD=1.52P PS=8.38U
+ PD=8.38U rfmode=0
M$404 vdd \$249 \$315 vdd sg13_hv_pmos L=1U W=8U AS=1.52P AD=2.72P PS=8.38U
+ PD=16.68U rfmode=0
M$405 \$249 \$243 \$315 vdd sg13_hv_pmos L=1U W=8U AS=2.72P AD=1.52P PS=16.68U
+ PD=8.38U rfmode=0
M$406 \$315 \$243 \$249 vdd sg13_hv_pmos L=1U W=8U AS=1.52P AD=1.52P PS=8.38U
+ PD=8.38U rfmode=0
M$407 \$249 \$243 \$315 vdd sg13_hv_pmos L=1U W=8U AS=1.52P AD=1.52P PS=8.38U
+ PD=8.38U rfmode=0
M$408 \$315 \$243 \$249 vdd sg13_hv_pmos L=1U W=8U AS=1.52P AD=1.52P PS=8.38U
+ PD=8.38U rfmode=0
M$409 \$249 \$243 \$315 vdd sg13_hv_pmos L=1U W=8U AS=1.52P AD=1.52P PS=8.38U
+ PD=8.38U rfmode=0
M$410 \$315 \$243 \$249 vdd sg13_hv_pmos L=1U W=8U AS=1.52P AD=1.52P PS=8.38U
+ PD=8.38U rfmode=0
M$411 \$249 \$243 \$315 vdd sg13_hv_pmos L=1U W=8U AS=1.52P AD=1.52P PS=8.38U
+ PD=8.38U rfmode=0
M$412 \$315 \$243 \$249 vdd sg13_hv_pmos L=1U W=8U AS=1.52P AD=1.52P PS=8.38U
+ PD=8.38U rfmode=0
M$413 \$249 \$243 \$315 vdd sg13_hv_pmos L=1U W=8U AS=1.52P AD=1.52P PS=8.38U
+ PD=8.38U rfmode=0
M$414 \$315 \$243 \$249 vdd sg13_hv_pmos L=1U W=8U AS=1.52P AD=1.52P PS=8.38U
+ PD=8.38U rfmode=0
M$415 \$249 \$243 \$315 vdd sg13_hv_pmos L=1U W=8U AS=1.52P AD=1.52P PS=8.38U
+ PD=8.38U rfmode=0
M$416 \$315 \$243 \$249 vdd sg13_hv_pmos L=1U W=8U AS=1.52P AD=2.72P PS=8.38U
+ PD=16.68U rfmode=0
M$417 \$250 \$243 \$316 vdd sg13_hv_pmos L=1U W=8U AS=2.72P AD=1.52P PS=16.68U
+ PD=8.38U rfmode=0
M$418 \$316 \$243 \$250 vdd sg13_hv_pmos L=1U W=8U AS=1.52P AD=1.52P PS=8.38U
+ PD=8.38U rfmode=0
M$419 \$250 \$243 \$316 vdd sg13_hv_pmos L=1U W=8U AS=1.52P AD=1.52P PS=8.38U
+ PD=8.38U rfmode=0
M$420 \$316 \$243 \$250 vdd sg13_hv_pmos L=1U W=8U AS=1.52P AD=1.52P PS=8.38U
+ PD=8.38U rfmode=0
M$421 \$250 \$243 \$316 vdd sg13_hv_pmos L=1U W=8U AS=1.52P AD=1.52P PS=8.38U
+ PD=8.38U rfmode=0
M$422 \$316 \$243 \$250 vdd sg13_hv_pmos L=1U W=8U AS=1.52P AD=1.52P PS=8.38U
+ PD=8.38U rfmode=0
M$423 \$250 \$243 \$316 vdd sg13_hv_pmos L=1U W=8U AS=1.52P AD=1.52P PS=8.38U
+ PD=8.38U rfmode=0
M$424 \$316 \$243 \$250 vdd sg13_hv_pmos L=1U W=8U AS=1.52P AD=1.52P PS=8.38U
+ PD=8.38U rfmode=0
M$425 \$250 \$243 \$316 vdd sg13_hv_pmos L=1U W=8U AS=1.52P AD=1.52P PS=8.38U
+ PD=8.38U rfmode=0
M$426 \$316 \$243 \$250 vdd sg13_hv_pmos L=1U W=8U AS=1.52P AD=1.52P PS=8.38U
+ PD=8.38U rfmode=0
M$427 \$250 \$243 \$316 vdd sg13_hv_pmos L=1U W=8U AS=1.52P AD=1.52P PS=8.38U
+ PD=8.38U rfmode=0
M$428 \$316 \$243 \$250 vdd sg13_hv_pmos L=1U W=8U AS=1.52P AD=2.72P PS=8.38U
+ PD=16.68U rfmode=0
M$429 \$316 \$249 vdd vdd sg13_hv_pmos L=1U W=8U AS=2.72P AD=1.52P PS=16.68U
+ PD=8.38U rfmode=0
M$430 vdd \$249 \$316 vdd sg13_hv_pmos L=1U W=8U AS=1.52P AD=1.52P PS=8.38U
+ PD=8.38U rfmode=0
M$431 \$316 \$249 vdd vdd sg13_hv_pmos L=1U W=8U AS=1.52P AD=1.52P PS=8.38U
+ PD=8.38U rfmode=0
M$432 vdd \$249 \$316 vdd sg13_hv_pmos L=1U W=8U AS=1.52P AD=1.52P PS=8.38U
+ PD=8.38U rfmode=0
M$433 \$316 \$249 vdd vdd sg13_hv_pmos L=1U W=8U AS=1.52P AD=1.52P PS=8.38U
+ PD=8.38U rfmode=0
M$434 vdd \$249 \$316 vdd sg13_hv_pmos L=1U W=8U AS=1.52P AD=1.52P PS=8.38U
+ PD=8.38U rfmode=0
M$435 \$316 \$249 vdd vdd sg13_hv_pmos L=1U W=8U AS=1.52P AD=1.52P PS=8.38U
+ PD=8.38U rfmode=0
M$436 vdd \$249 \$316 vdd sg13_hv_pmos L=1U W=8U AS=1.52P AD=1.52P PS=8.38U
+ PD=8.38U rfmode=0
M$437 \$316 \$249 vdd vdd sg13_hv_pmos L=1U W=8U AS=1.52P AD=1.52P PS=8.38U
+ PD=8.38U rfmode=0
M$438 vdd \$249 \$316 vdd sg13_hv_pmos L=1U W=8U AS=1.52P AD=1.52P PS=8.38U
+ PD=8.38U rfmode=0
M$439 \$316 \$249 vdd vdd sg13_hv_pmos L=1U W=8U AS=1.52P AD=1.52P PS=8.38U
+ PD=8.38U rfmode=0
M$440 vdd \$249 \$316 vdd sg13_hv_pmos L=1U W=8U AS=1.52P AD=2.72P PS=8.38U
+ PD=16.68U rfmode=0
M$441 \$245 vref_buf \$326 vdd sg13_hv_pmos L=2U W=6U AS=2.04P AD=1.14P
+ PS=12.68U PD=6.38U rfmode=0
M$442 \$326 vref_buf \$245 vdd sg13_hv_pmos L=2U W=6U AS=1.14P AD=1.14P
+ PS=6.38U PD=6.38U rfmode=0
M$443 \$247 vref \$326 vdd sg13_hv_pmos L=2U W=6U AS=1.14P AD=1.14P PS=6.38U
+ PD=6.38U rfmode=0
M$444 \$326 vref \$247 vdd sg13_hv_pmos L=2U W=6U AS=1.14P AD=1.14P PS=6.38U
+ PD=6.38U rfmode=0
M$445 \$247 vref \$326 vdd sg13_hv_pmos L=2U W=6U AS=1.14P AD=1.14P PS=6.38U
+ PD=6.38U rfmode=0
M$446 \$326 vref \$247 vdd sg13_hv_pmos L=2U W=6U AS=1.14P AD=1.14P PS=6.38U
+ PD=6.38U rfmode=0
M$447 \$245 vref_buf \$326 vdd sg13_hv_pmos L=2U W=6U AS=1.14P AD=1.14P
+ PS=6.38U PD=6.38U rfmode=0
M$448 \$326 vref_buf \$245 vdd sg13_hv_pmos L=2U W=6U AS=1.14P AD=1.14P
+ PS=6.38U PD=6.38U rfmode=0
M$449 \$245 vref_buf \$326 vdd sg13_hv_pmos L=2U W=6U AS=1.14P AD=1.14P
+ PS=6.38U PD=6.38U rfmode=0
M$450 \$326 vref_buf \$245 vdd sg13_hv_pmos L=2U W=6U AS=1.14P AD=1.14P
+ PS=6.38U PD=6.38U rfmode=0
M$451 \$247 vref \$326 vdd sg13_hv_pmos L=2U W=6U AS=1.14P AD=1.14P PS=6.38U
+ PD=6.38U rfmode=0
M$452 \$326 vref \$247 vdd sg13_hv_pmos L=2U W=6U AS=1.14P AD=1.14P PS=6.38U
+ PD=6.38U rfmode=0
M$453 \$247 vref \$326 vdd sg13_hv_pmos L=2U W=6U AS=1.14P AD=1.14P PS=6.38U
+ PD=6.38U rfmode=0
M$454 \$326 vref \$247 vdd sg13_hv_pmos L=2U W=6U AS=1.14P AD=1.14P PS=6.38U
+ PD=6.38U rfmode=0
M$455 \$245 vref_buf \$326 vdd sg13_hv_pmos L=2U W=6U AS=1.14P AD=1.14P
+ PS=6.38U PD=6.38U rfmode=0
M$456 \$326 vref_buf \$245 vdd sg13_hv_pmos L=2U W=6U AS=1.14P AD=1.14P
+ PS=6.38U PD=6.38U rfmode=0
M$457 \$245 vref_buf \$326 vdd sg13_hv_pmos L=2U W=6U AS=1.14P AD=1.14P
+ PS=6.38U PD=6.38U rfmode=0
M$458 \$326 vref_buf \$245 vdd sg13_hv_pmos L=2U W=6U AS=1.14P AD=1.14P
+ PS=6.38U PD=6.38U rfmode=0
M$459 \$247 vref \$326 vdd sg13_hv_pmos L=2U W=6U AS=1.14P AD=1.14P PS=6.38U
+ PD=6.38U rfmode=0
M$460 \$326 vref \$247 vdd sg13_hv_pmos L=2U W=6U AS=1.14P AD=1.14P PS=6.38U
+ PD=6.38U rfmode=0
M$461 \$247 vref \$326 vdd sg13_hv_pmos L=2U W=6U AS=1.14P AD=1.14P PS=6.38U
+ PD=6.38U rfmode=0
M$462 \$326 vref \$247 vdd sg13_hv_pmos L=2U W=6U AS=1.14P AD=1.14P PS=6.38U
+ PD=6.38U rfmode=0
M$463 \$245 vref_buf \$326 vdd sg13_hv_pmos L=2U W=6U AS=1.14P AD=1.14P
+ PS=6.38U PD=6.38U rfmode=0
M$464 \$326 vref_buf \$245 vdd sg13_hv_pmos L=2U W=6U AS=1.14P AD=1.14P
+ PS=6.38U PD=6.38U rfmode=0
M$465 \$245 vref_buf \$326 vdd sg13_hv_pmos L=2U W=6U AS=1.14P AD=1.14P
+ PS=6.38U PD=6.38U rfmode=0
M$466 \$326 vref_buf \$245 vdd sg13_hv_pmos L=2U W=6U AS=1.14P AD=1.14P
+ PS=6.38U PD=6.38U rfmode=0
M$467 \$247 vref \$326 vdd sg13_hv_pmos L=2U W=6U AS=1.14P AD=1.14P PS=6.38U
+ PD=6.38U rfmode=0
M$468 \$326 vref \$247 vdd sg13_hv_pmos L=2U W=6U AS=1.14P AD=1.14P PS=6.38U
+ PD=6.38U rfmode=0
M$469 \$247 vref \$326 vdd sg13_hv_pmos L=2U W=6U AS=1.14P AD=1.14P PS=6.38U
+ PD=6.38U rfmode=0
M$470 \$326 vref \$247 vdd sg13_hv_pmos L=2U W=6U AS=1.14P AD=1.14P PS=6.38U
+ PD=6.38U rfmode=0
M$471 \$245 vref_buf \$326 vdd sg13_hv_pmos L=2U W=6U AS=1.14P AD=1.14P
+ PS=6.38U PD=6.38U rfmode=0
M$472 \$326 vref_buf \$245 vdd sg13_hv_pmos L=2U W=6U AS=1.14P AD=2.04P
+ PS=6.38U PD=12.68U rfmode=0
M$473 \$243 \$243 vdd vdd sg13_hv_pmos L=1U W=3.2U AS=1.088P AD=1.088P PS=7.08U
+ PD=7.08U rfmode=0
M$474 \$246 \$244 vdd vdd sg13_hv_pmos L=1U W=8U AS=2.72P AD=1.52P PS=16.68U
+ PD=8.38U rfmode=0
M$475 vdd \$244 \$246 vdd sg13_hv_pmos L=1U W=8U AS=1.52P AD=2.72P PS=8.38U
+ PD=16.68U rfmode=0
M$476 \$244 \$244 vdd vdd sg13_hv_pmos L=1U W=8U AS=2.72P AD=1.52P PS=16.68U
+ PD=8.38U rfmode=0
M$477 vdd \$244 \$244 vdd sg13_hv_pmos L=1U W=8U AS=1.52P AD=2.72P PS=8.38U
+ PD=16.68U rfmode=0
M$478 \$326 \$244 vdd vdd sg13_hv_pmos L=1U W=8U AS=2.72P AD=1.52P PS=16.68U
+ PD=8.38U rfmode=0
M$479 vdd \$244 \$326 vdd sg13_hv_pmos L=1U W=8U AS=1.52P AD=1.52P PS=8.38U
+ PD=8.38U rfmode=0
M$480 \$326 \$244 vdd vdd sg13_hv_pmos L=1U W=8U AS=1.52P AD=1.52P PS=8.38U
+ PD=8.38U rfmode=0
M$481 vdd \$244 \$326 vdd sg13_hv_pmos L=1U W=8U AS=1.52P AD=1.52P PS=8.38U
+ PD=8.38U rfmode=0
M$482 \$326 \$244 vdd vdd sg13_hv_pmos L=1U W=8U AS=1.52P AD=1.52P PS=8.38U
+ PD=8.38U rfmode=0
M$483 vdd \$244 \$326 vdd sg13_hv_pmos L=1U W=8U AS=1.52P AD=1.52P PS=8.38U
+ PD=8.38U rfmode=0
M$484 \$326 \$244 vdd vdd sg13_hv_pmos L=1U W=8U AS=1.52P AD=1.52P PS=8.38U
+ PD=8.38U rfmode=0
M$485 vdd \$244 \$326 vdd sg13_hv_pmos L=1U W=8U AS=1.52P AD=1.52P PS=8.38U
+ PD=8.38U rfmode=0
M$486 \$326 \$244 vdd vdd sg13_hv_pmos L=1U W=8U AS=1.52P AD=1.52P PS=8.38U
+ PD=8.38U rfmode=0
M$487 vdd \$244 \$326 vdd sg13_hv_pmos L=1U W=8U AS=1.52P AD=1.52P PS=8.38U
+ PD=8.38U rfmode=0
M$488 \$326 \$244 vdd vdd sg13_hv_pmos L=1U W=8U AS=1.52P AD=1.52P PS=8.38U
+ PD=8.38U rfmode=0
M$489 vdd \$244 \$326 vdd sg13_hv_pmos L=1U W=8U AS=1.52P AD=1.52P PS=8.38U
+ PD=8.38U rfmode=0
M$490 \$326 \$244 vdd vdd sg13_hv_pmos L=1U W=8U AS=1.52P AD=1.52P PS=8.38U
+ PD=8.38U rfmode=0
M$491 vdd \$244 \$326 vdd sg13_hv_pmos L=1U W=8U AS=1.52P AD=1.52P PS=8.38U
+ PD=8.38U rfmode=0
M$492 \$326 \$244 vdd vdd sg13_hv_pmos L=1U W=8U AS=1.52P AD=1.52P PS=8.38U
+ PD=8.38U rfmode=0
M$493 vdd \$244 \$326 vdd sg13_hv_pmos L=1U W=8U AS=1.52P AD=2.72P PS=8.38U
+ PD=16.68U rfmode=0
M$494 vref_buf \$250 vdd vdd sg13_hv_pmos L=1U W=8U AS=2.72P AD=1.52P PS=16.68U
+ PD=8.38U rfmode=0
M$495 vdd \$250 vref_buf vdd sg13_hv_pmos L=1U W=8U AS=1.52P AD=1.52P PS=8.38U
+ PD=8.38U rfmode=0
M$496 vref_buf \$250 vdd vdd sg13_hv_pmos L=1U W=8U AS=1.52P AD=1.52P PS=8.38U
+ PD=8.38U rfmode=0
M$497 vdd \$250 vref_buf vdd sg13_hv_pmos L=1U W=8U AS=1.52P AD=1.52P PS=8.38U
+ PD=8.38U rfmode=0
M$498 vref_buf \$250 vdd vdd sg13_hv_pmos L=1U W=8U AS=1.52P AD=1.52P PS=8.38U
+ PD=8.38U rfmode=0
M$499 vdd \$250 vref_buf vdd sg13_hv_pmos L=1U W=8U AS=1.52P AD=1.52P PS=8.38U
+ PD=8.38U rfmode=0
M$500 vref_buf \$250 vdd vdd sg13_hv_pmos L=1U W=8U AS=1.52P AD=1.52P PS=8.38U
+ PD=8.38U rfmode=0
M$501 vdd \$250 vref_buf vdd sg13_hv_pmos L=1U W=8U AS=1.52P AD=1.52P PS=8.38U
+ PD=8.38U rfmode=0
M$502 vref_buf \$250 vdd vdd sg13_hv_pmos L=1U W=8U AS=1.52P AD=1.52P PS=8.38U
+ PD=8.38U rfmode=0
M$503 vdd \$250 vref_buf vdd sg13_hv_pmos L=1U W=8U AS=1.52P AD=1.52P PS=8.38U
+ PD=8.38U rfmode=0
M$504 vref_buf \$250 vdd vdd sg13_hv_pmos L=1U W=8U AS=1.52P AD=1.52P PS=8.38U
+ PD=8.38U rfmode=0
M$505 vdd \$250 vref_buf vdd sg13_hv_pmos L=1U W=8U AS=1.52P AD=1.52P PS=8.38U
+ PD=8.38U rfmode=0
M$506 vref_buf \$250 vdd vdd sg13_hv_pmos L=1U W=8U AS=1.52P AD=1.52P PS=8.38U
+ PD=8.38U rfmode=0
M$507 vdd \$250 vref_buf vdd sg13_hv_pmos L=1U W=8U AS=1.52P AD=1.52P PS=8.38U
+ PD=8.38U rfmode=0
M$508 vref_buf \$250 vdd vdd sg13_hv_pmos L=1U W=8U AS=1.52P AD=1.52P PS=8.38U
+ PD=8.38U rfmode=0
M$509 vdd \$250 vref_buf vdd sg13_hv_pmos L=1U W=8U AS=1.52P AD=1.52P PS=8.38U
+ PD=8.38U rfmode=0
M$510 vref_buf \$250 vdd vdd sg13_hv_pmos L=1U W=8U AS=1.52P AD=1.52P PS=8.38U
+ PD=8.38U rfmode=0
M$511 vdd \$250 vref_buf vdd sg13_hv_pmos L=1U W=8U AS=1.52P AD=1.52P PS=8.38U
+ PD=8.38U rfmode=0
M$512 vref_buf \$250 vdd vdd sg13_hv_pmos L=1U W=8U AS=1.52P AD=1.52P PS=8.38U
+ PD=8.38U rfmode=0
M$513 vdd \$250 vref_buf vdd sg13_hv_pmos L=1U W=8U AS=1.52P AD=1.52P PS=8.38U
+ PD=8.38U rfmode=0
M$514 vref_buf \$250 vdd vdd sg13_hv_pmos L=1U W=8U AS=1.52P AD=1.52P PS=8.38U
+ PD=8.38U rfmode=0
M$515 vdd \$250 vref_buf vdd sg13_hv_pmos L=1U W=8U AS=1.52P AD=1.52P PS=8.38U
+ PD=8.38U rfmode=0
M$516 vref_buf \$250 vdd vdd sg13_hv_pmos L=1U W=8U AS=1.52P AD=1.52P PS=8.38U
+ PD=8.38U rfmode=0
M$517 vdd \$250 vref_buf vdd sg13_hv_pmos L=1U W=8U AS=1.52P AD=2.72P PS=8.38U
+ PD=16.68U rfmode=0
R$518 \$8 \$228 vss 2 rppd l=76.7 ps=0 b=0 m=1
R$519 \$8 \$168 vss 2 rppd l=76.7 ps=0 b=0 m=1
R$520 \$9 \$168 vss 2 rppd l=76.7 ps=0 b=0 m=1
R$521 \$9 \$169 vss 2 rppd l=76.7 ps=0 b=0 m=1
R$522 \$10 \$169 vss 2 rppd l=76.7 ps=0 b=0 m=1
R$523 \$10 \$170 vss 2 rppd l=76.7 ps=0 b=0 m=1
R$524 \$11 \$170 vss 2 rppd l=76.7 ps=0 b=0 m=1
R$525 \$11 \$171 vss 2 rppd l=76.7 ps=0 b=0 m=1
R$526 \$12 \$171 vss 2 rppd l=76.7 ps=0 b=0 m=1
R$527 \$12 \$172 vss 2 rppd l=76.7 ps=0 b=0 m=1
R$528 \$13 \$172 vss 2 rppd l=76.7 ps=0 b=0 m=1
R$529 \$13 \$173 vss 2 rppd l=76.7 ps=0 b=0 m=1
R$530 \$14 \$173 vss 2 rppd l=76.7 ps=0 b=0 m=1
R$531 \$15 \$69 vss 2 rppd l=76.7 ps=0 b=0 m=1
R$532 \$15 \$174 vss 2 rppd l=76.7 ps=0 b=0 m=1
R$533 \$16 \$174 vss 2 rppd l=76.7 ps=0 b=0 m=1
R$534 \$16 \$175 vss 2 rppd l=76.7 ps=0 b=0 m=1
R$535 \$17 \$175 vss 2 rppd l=76.7 ps=0 b=0 m=1
R$536 \$17 \$176 vss 2 rppd l=76.7 ps=0 b=0 m=1
R$537 \$18 \$176 vss 2 rppd l=76.7 ps=0 b=0 m=1
R$538 \$18 \$177 vss 2 rppd l=76.7 ps=0 b=0 m=1
R$539 \$19 \$177 vss 2 rppd l=76.7 ps=0 b=0 m=1
R$540 \$19 \$178 vss 2 rppd l=76.7 ps=0 b=0 m=1
R$541 sense_n \$69 vss 2 rppd l=76.7 ps=0 b=0 m=1
R$542 sense_p \$74 vss 2 rppd l=76.7 ps=0 b=0 m=1
R$543 \$22 \$74 vss 2 rppd l=76.7 ps=0 b=0 m=1
R$544 \$22 \$179 vss 2 rppd l=76.7 ps=0 b=0 m=1
R$545 \$23 \$179 vss 2 rppd l=76.7 ps=0 b=0 m=1
R$546 \$23 \$180 vss 2 rppd l=76.7 ps=0 b=0 m=1
R$547 \$24 \$180 vss 2 rppd l=76.7 ps=0 b=0 m=1
R$548 \$24 \$181 vss 2 rppd l=76.7 ps=0 b=0 m=1
R$549 \$25 \$181 vss 2 rppd l=76.7 ps=0 b=0 m=1
R$550 \$25 \$182 vss 2 rppd l=76.7 ps=0 b=0 m=1
R$551 \$26 \$182 vss 2 rppd l=76.7 ps=0 b=0 m=1
R$552 \$26 \$183 vss 2 rppd l=76.7 ps=0 b=0 m=1
R$553 \$27 \$184 vss 2 rppd l=76.7 ps=0 b=0 m=1
R$554 \$27 \$185 vss 2 rppd l=76.7 ps=0 b=0 m=1
R$555 \$28 \$185 vss 2 rppd l=76.7 ps=0 b=0 m=1
R$556 \$28 \$186 vss 2 rppd l=76.7 ps=0 b=0 m=1
R$557 \$29 \$186 vss 2 rppd l=76.7 ps=0 b=0 m=1
R$558 \$29 \$187 vss 2 rppd l=76.7 ps=0 b=0 m=1
R$559 \$30 \$187 vss 2 rppd l=76.7 ps=0 b=0 m=1
R$560 \$30 \$188 vss 2 rppd l=76.7 ps=0 b=0 m=1
R$561 \$31 \$188 vss 2 rppd l=76.7 ps=0 b=0 m=1
R$562 \$31 \$189 vss 2 rppd l=76.7 ps=0 b=0 m=1
R$563 \$32 \$189 vss 2 rppd l=76.7 ps=0 b=0 m=1
R$564 \$32 \$190 vss 2 rppd l=76.7 ps=0 b=0 m=1
R$565 \$14 \$190 vss 2 rppd l=76.7 ps=0 b=0 m=1
R$566 \$144 \$229 vss 1 rppd l=6.2 ps=0 b=0 m=1
R$567 \$35 \$75 vss 1 rppd l=6.2 ps=0 b=0 m=1
R$568 \$203 \$351 vss 2 rppd l=76.7 ps=0 b=0 m=1
R$569 \$203 \$352 vss 2 rppd l=76.7 ps=0 b=0 m=1
R$570 \$204 \$352 vss 2 rppd l=76.7 ps=0 b=0 m=1
R$571 \$204 \$353 vss 2 rppd l=76.7 ps=0 b=0 m=1
R$572 \$205 \$353 vss 2 rppd l=76.7 ps=0 b=0 m=1
R$573 \$205 \$354 vss 2 rppd l=76.7 ps=0 b=0 m=1
R$574 \$206 \$354 vss 2 rppd l=76.7 ps=0 b=0 m=1
R$575 \$206 \$355 vss 2 rppd l=76.7 ps=0 b=0 m=1
R$576 \$207 \$355 vss 2 rppd l=76.7 ps=0 b=0 m=1
R$577 \$207 \$356 vss 2 rppd l=76.7 ps=0 b=0 m=1
R$578 \$208 \$356 vss 2 rppd l=76.7 ps=0 b=0 m=1
R$579 \$208 \$357 vss 2 rppd l=76.7 ps=0 b=0 m=1
R$580 \$184 \$357 vss 2 rppd l=76.7 ps=0 b=0 m=1
R$581 \$209 \$183 vss 2 rppd l=76.7 ps=0 b=0 m=1
R$582 \$209 \$358 vss 2 rppd l=76.7 ps=0 b=0 m=1
R$583 \$210 \$358 vss 2 rppd l=76.7 ps=0 b=0 m=1
R$584 \$210 \$359 vss 2 rppd l=76.7 ps=0 b=0 m=1
R$585 \$211 \$359 vss 2 rppd l=76.7 ps=0 b=0 m=1
R$586 \$211 \$360 vss 2 rppd l=76.7 ps=0 b=0 m=1
R$587 \$212 \$360 vss 2 rppd l=76.7 ps=0 b=0 m=1
R$588 \$212 \$361 vss 2 rppd l=76.7 ps=0 b=0 m=1
R$589 \$213 \$361 vss 2 rppd l=76.7 ps=0 b=0 m=1
R$590 \$213 vped vss 2 rppd l=76.7 ps=0 b=0 m=1
R$591 \$214 vref_buf vss 2 rppd l=76.7 ps=0 b=0 m=1
R$592 \$214 \$228 vss 2 rppd l=76.7 ps=0 b=0 m=1
R$593 \$215 \$178 vss 2 rppd l=76.7 ps=0 b=0 m=1
R$594 \$215 \$362 vss 2 rppd l=76.7 ps=0 b=0 m=1
R$595 \$216 \$362 vss 2 rppd l=76.7 ps=0 b=0 m=1
R$596 \$216 \$363 vss 2 rppd l=76.7 ps=0 b=0 m=1
R$597 \$217 \$363 vss 2 rppd l=76.7 ps=0 b=0 m=1
R$598 \$217 \$364 vss 2 rppd l=76.7 ps=0 b=0 m=1
R$599 \$218 \$364 vss 2 rppd l=76.7 ps=0 b=0 m=1
R$600 \$218 \$365 vss 2 rppd l=76.7 ps=0 b=0 m=1
R$601 \$219 \$365 vss 2 rppd l=76.7 ps=0 b=0 m=1
R$602 \$219 isense vss 2 rppd l=76.7 ps=0 b=0 m=1
R$603 \$220 \$351 vss 2 rppd l=76.7 ps=0 b=0 m=1
R$604 \$220 \$366 vss 2 rppd l=76.7 ps=0 b=0 m=1
R$605 \$221 \$366 vss 2 rppd l=76.7 ps=0 b=0 m=1
R$606 \$221 \$367 vss 2 rppd l=76.7 ps=0 b=0 m=1
R$607 \$222 \$367 vss 2 rppd l=76.7 ps=0 b=0 m=1
R$608 \$222 \$368 vss 2 rppd l=76.7 ps=0 b=0 m=1
R$609 \$223 \$368 vss 2 rppd l=76.7 ps=0 b=0 m=1
R$610 \$223 \$369 vss 2 rppd l=76.7 ps=0 b=0 m=1
R$611 \$224 \$369 vss 2 rppd l=76.7 ps=0 b=0 m=1
R$612 \$224 \$370 vss 2 rppd l=76.7 ps=0 b=0 m=1
R$613 \$225 \$370 vss 2 rppd l=76.7 ps=0 b=0 m=1
R$614 \$225 vss vss 2 rppd l=76.7 ps=0 b=0 m=1
R$615 \$250 \$332 vss 1 rppd l=6.2 ps=0 b=0 m=1
Cext_1 \$10 \$11 28.7835a
Cext_2 \$10 \$9 28.7835a
Cext_3 \$10 vss 53.6189a
Cext_4 \$10 VSUBS 858.397a
Cext_5 \$11 \$12 28.7835a
Cext_6 \$11 vss 53.6189a
Cext_7 \$11 VSUBS 858.397a
Cext_8 \$12 \$13 28.7835a
Cext_9 \$12 \$14 0.934295a
Cext_10 \$12 vss 53.6189a
Cext_11 \$12 VSUBS 858.397a
Cext_12 \$13 \$14 40.4369a
Cext_13 \$13 vss 53.6189a
Cext_14 \$13 VSUBS 858.397a
Cext_15 \$137 \$138 5.68933f
Cext_16 \$137 \$139 1.93792f
Cext_17 \$137 \$140 4.37941f
Cext_18 \$137 \$141 1.30439a
Cext_19 \$137 \$143 5.2825f
Cext_20 \$137 \$144 3.59141f
Cext_21 \$137 \$162 5.60355f
Cext_22 \$137 \$163 4.97002f
Cext_23 \$137 \$202 65.7574a
Cext_24 \$137 \$228 72.0384a
Cext_25 \$137 \$229 338.807a
Cext_26 \$137 iptat 466.031a
Cext_27 \$137 isense 31.2958a
Cext_28 \$137 vdd 959.591a
Cext_29 \$137 vped 3.47289f
Cext_30 \$137 vss 846.778a
Cext_31 \$137 VSUBS 32.7246f
Cext_32 \$138 \$139 695.042a
Cext_33 \$138 \$140 1.78423f
Cext_34 \$138 \$141 81.65a
Cext_35 \$138 \$143 286.223a
Cext_36 \$138 \$144 137.593a
Cext_37 \$138 \$202 7.38946f
Cext_38 \$138 \$228 469.847a
Cext_39 \$138 \$229 291.726a
Cext_40 \$138 iptat 418.944a
Cext_41 \$138 isense 0.157254a
Cext_42 \$138 vdd 7.61671f
Cext_43 \$138 vped 822.098a
Cext_44 \$138 vref_buf 2.10685a
Cext_45 \$138 vss 546.872a
Cext_46 \$138 VSUBS 27.3072f
Cext_47 \$139 \$140 2.01779f
Cext_48 \$139 \$141 465.164a
Cext_49 \$139 \$143 1.68398f
Cext_50 \$139 \$144 0.966982a
Cext_51 \$139 \$162 4.3649a
Cext_52 \$139 \$202 1.4372f
Cext_53 \$139 \$228 997.702a
Cext_54 \$139 \$229 103.033a
Cext_55 \$139 iptat 4.5513f
Cext_56 \$139 isense 178.932a
Cext_57 \$139 vdd 9.09587f
Cext_58 \$139 vped 8.40015f
Cext_59 \$139 vss 2.78817f
Cext_60 \$139 VSUBS 8.08647f
Cext_61 \$14 \$15 62.9192a
Cext_62 \$14 \$16 23.4167a
Cext_63 \$14 \$17 22.4824a
Cext_64 \$14 \$18 22.4824a
Cext_65 \$14 \$19 22.4824a
Cext_66 \$14 \$22 8.94579a
Cext_67 \$14 \$23 8.94579a
Cext_68 \$14 \$24 8.94579a
Cext_69 \$14 \$25 8.94579a
Cext_70 \$14 \$26 8.94579a
Cext_71 \$14 \$27 8.94579a
Cext_72 \$14 \$28 8.94579a
Cext_73 \$14 \$29 8.94579a
Cext_74 \$14 \$30 8.94579a
Cext_75 \$14 \$31 9.88009a
Cext_76 \$14 \$32 49.3827a
Cext_77 \$14 sense_n 263.218a
Cext_78 \$14 sense_p 8.97298f
Cext_79 \$14 vss 847.658a
Cext_80 \$14 VSUBS 5.59589f
Cext_81 \$140 \$141 1.83357f
Cext_82 \$140 \$143 3.15168f
Cext_83 \$140 \$144 2.37443f
Cext_84 \$140 \$162 0.441084a
Cext_85 \$140 \$163 0.220542a
Cext_86 \$140 \$202 263.257a
Cext_87 \$140 \$228 92.0037a
Cext_88 \$140 \$229 170.258a
Cext_89 \$140 iptat 1.23563f
Cext_90 \$140 isense 9.09638a
Cext_91 \$140 vdd 913.163a
Cext_92 \$140 vped 268.061a
Cext_93 \$140 vss 4.48555f
Cext_94 \$140 VSUBS 18.7693f
Cext_95 \$141 \$143 56.3514a
Cext_96 \$141 \$144 3.29635f
Cext_97 \$141 \$163 4.74202a
Cext_98 \$141 \$202 2.60276f
Cext_99 \$141 \$228 8.68417f
Cext_100 \$141 \$229 206.331a
Cext_101 \$141 iptat 5.16367f
Cext_102 \$141 isense 218.054a
Cext_103 \$141 vdd 7.9618f
Cext_104 \$141 vped 2.99821f
Cext_105 \$141 vss 2.75716f
Cext_106 \$141 VSUBS 8.04219f
Cext_107 \$143 \$144 1.61266f
Cext_108 \$143 \$162 6.12058f
Cext_109 \$143 \$163 3.67869f
Cext_110 \$143 \$202 1.51285a
Cext_111 \$143 \$228 44.448a
Cext_112 \$143 \$229 54.6553a
Cext_113 \$143 iptat 78.0763a
Cext_114 \$143 vdd 12.1579f
Cext_115 \$143 vped 1.87683f
Cext_116 \$143 vss 1.30411f
Cext_117 \$143 VSUBS 34.4511f
Cext_118 \$144 \$163 2.44226f
Cext_119 \$144 \$202 776.999a
Cext_120 \$144 \$228 608.21a
Cext_121 \$144 \$229 1.04438f
Cext_122 \$144 iptat 376a
Cext_123 \$144 vdd 11.1361f
Cext_124 \$144 vped 13.9381f
Cext_125 \$144 vref_buf 2.52822a
Cext_126 \$144 vss 1.3079f
Cext_127 \$144 VSUBS 34.702f
Cext_128 \$15 \$16 28.7835a
Cext_129 \$15 vss 53.6189a
Cext_130 \$15 VSUBS 858.397a
Cext_131 \$16 \$17 28.7835a
Cext_132 \$16 vss 53.6189a
Cext_133 \$16 VSUBS 858.397a
Cext_134 \$162 \$163 185.733a
Cext_135 \$162 \$228 16.3a
Cext_136 \$162 \$229 29.5855a
Cext_137 \$162 vdd 6.77016f
Cext_138 \$162 vped 539.472a
Cext_139 \$162 vss 19.3341a
Cext_140 \$162 VSUBS 3.39035f
Cext_141 \$163 \$228 16.3a
Cext_142 \$163 \$229 27.9988a
Cext_143 \$163 vdd 6.77016f
Cext_144 \$163 vped 701.209a
Cext_145 \$163 vss 23.7652a
Cext_146 \$163 VSUBS 3.39125f
Cext_147 \$168 \$169 28.7835a
Cext_148 \$168 \$178 8.86264a
Cext_149 \$168 \$183 5.63172a
Cext_150 \$168 \$203 12.6351a
Cext_151 \$168 \$204 12.6351a
Cext_152 \$168 \$228 40.4369a
Cext_153 \$168 \$69 79.1203a
Cext_154 \$168 \$74 15.5892a
Cext_155 \$168 VSUBS 890.098a
Cext_156 \$169 \$170 28.7835a
Cext_157 \$169 \$178 8.86264a
Cext_158 \$169 \$183 5.63172a
Cext_159 \$169 \$204 12.6351a
Cext_160 \$169 \$205 12.6351a
Cext_161 \$169 \$228 0.934295a
Cext_162 \$169 \$69 79.1203a
Cext_163 \$169 \$74 15.5892a
Cext_164 \$169 VSUBS 890.098a
Cext_165 \$17 \$18 28.7835a
Cext_166 \$17 vss 53.6189a
Cext_167 \$17 VSUBS 858.397a
Cext_168 \$170 \$171 28.7835a
Cext_169 \$170 \$178 8.86264a
Cext_170 \$170 \$183 5.63172a
Cext_171 \$170 \$205 12.6351a
Cext_172 \$170 \$206 12.6351a
Cext_173 \$170 \$69 79.1203a
Cext_174 \$170 \$74 15.5892a
Cext_175 \$170 VSUBS 890.098a
Cext_176 \$171 \$172 28.7835a
Cext_177 \$171 \$178 8.86264a
Cext_178 \$171 \$183 5.63172a
Cext_179 \$171 \$206 12.6351a
Cext_180 \$171 \$207 12.6351a
Cext_181 \$171 \$69 79.1203a
Cext_182 \$171 \$74 15.5892a
Cext_183 \$171 VSUBS 890.098a
Cext_184 \$172 \$173 28.7835a
Cext_185 \$172 \$178 8.86264a
Cext_186 \$172 \$183 5.63172a
Cext_187 \$172 \$207 12.6351a
Cext_188 \$172 \$208 12.6351a
Cext_189 \$172 \$69 80.0546a
Cext_190 \$172 \$74 15.5892a
Cext_191 \$172 VSUBS 890.098a
Cext_192 \$173 \$178 8.64055a
Cext_193 \$173 \$183 5.4884a
Cext_194 \$173 \$184 15.3158a
Cext_195 \$173 \$208 12.6351a
Cext_196 \$173 \$69 119.417a
Cext_197 \$173 \$74 15.4757a
Cext_198 \$173 VSUBS 890.079a
Cext_199 \$174 \$175 28.7835a
Cext_200 \$174 \$178 8.86264a
Cext_201 \$174 \$183 5.63172a
Cext_202 \$174 \$184 2.79698a
Cext_203 \$174 \$209 12.6351a
Cext_204 \$174 \$210 12.6351a
Cext_205 \$174 \$69 119.557a
Cext_206 \$174 \$74 15.5892a
Cext_207 \$174 VSUBS 890.098a
Cext_208 \$175 \$176 28.7835a
Cext_209 \$175 \$178 8.86264a
Cext_210 \$175 \$183 5.63172a
Cext_211 \$175 \$184 2.79698a
Cext_212 \$175 \$210 12.6351a
Cext_213 \$175 \$211 12.6351a
Cext_214 \$175 \$69 80.0546a
Cext_215 \$175 \$74 15.5892a
Cext_216 \$175 VSUBS 890.098a
Cext_217 \$176 \$177 28.7835a
Cext_218 \$176 \$178 9.79693a
Cext_219 \$176 \$183 5.63172a
Cext_220 \$176 \$184 2.79698a
Cext_221 \$176 \$211 12.6351a
Cext_222 \$176 \$212 12.6351a
Cext_223 \$176 \$69 79.1203a
Cext_224 \$176 \$74 15.5892a
Cext_225 \$176 VSUBS 890.098a
Cext_226 \$177 \$178 49.2995a
Cext_227 \$177 \$183 5.63172a
Cext_228 \$177 \$184 2.79698a
Cext_229 \$177 \$212 12.6351a
Cext_230 \$177 \$213 12.6351a
Cext_231 \$177 \$69 79.1203a
Cext_232 \$177 \$74 15.5892a
Cext_233 \$177 VSUBS 890.098a
Cext_234 \$178 \$183 16.2552f
Cext_235 \$178 \$184 3.71068a
Cext_236 \$178 \$203 1.50863a
Cext_237 \$178 \$204 1.6714a
Cext_238 \$178 \$205 1.6714a
Cext_239 \$178 \$206 1.6714a
Cext_240 \$178 \$207 1.6714a
Cext_241 \$178 \$208 1.6714a
Cext_242 \$178 \$209 1.50863a
Cext_243 \$178 \$210 1.6714a
Cext_244 \$178 \$211 1.6714a
Cext_245 \$178 \$212 1.6714a
Cext_246 \$178 \$213 14.2735a
Cext_247 \$178 \$228 338.144a
Cext_248 \$178 \$229 2.32786a
Cext_249 \$178 \$332 2.32786a
Cext_250 \$178 \$351 136.042a
Cext_251 \$178 \$352 79.1669a
Cext_252 \$178 \$353 79.1669a
Cext_253 \$178 \$354 79.1669a
Cext_254 \$178 \$355 79.1669a
Cext_255 \$178 \$356 79.1669a
Cext_256 \$178 \$357 79.1669a
Cext_257 \$178 \$358 79.1669a
Cext_258 \$178 \$359 79.1669a
Cext_259 \$178 \$360 79.1669a
Cext_260 \$178 \$361 79.1669a
Cext_261 \$178 \$362 40.4369a
Cext_262 \$178 \$363 0.934295a
Cext_263 \$178 \$69 206.894a
Cext_264 \$178 \$74 10.677f
Cext_265 \$178 iptat 0.397379a
Cext_266 \$178 isense 13.8055f
Cext_267 \$178 vped 358.841a
Cext_268 \$178 vref 214.404a
Cext_269 \$178 vref_buf 335.47a
Cext_270 \$178 vss 230.807a
Cext_271 \$178 VSUBS 6.4212f
Cext_272 \$179 \$180 28.7835a
Cext_273 \$179 \$183 14.1647a
Cext_274 \$179 \$184 2.79698a
Cext_275 \$179 \$215 12.6351a
Cext_276 \$179 \$216 12.6351a
Cext_277 \$179 \$74 40.4369a
Cext_278 \$179 VSUBS 890.098a
Cext_279 \$18 \$19 28.7835a
Cext_280 \$18 sense_n 0.934295a
Cext_281 \$18 vss 53.6189a
Cext_282 \$18 VSUBS 858.397a
Cext_283 \$180 \$181 28.7835a
Cext_284 \$180 \$183 14.1647a
Cext_285 \$180 \$184 2.79698a
Cext_286 \$180 \$216 12.6351a
Cext_287 \$180 \$217 12.6351a
Cext_288 \$180 \$74 0.934295a
Cext_289 \$180 VSUBS 890.098a
Cext_290 \$181 \$182 28.7835a
Cext_291 \$181 \$183 15.099a
Cext_292 \$181 \$184 2.79698a
Cext_293 \$181 \$217 12.6351a
Cext_294 \$181 \$218 12.6351a
Cext_295 \$181 VSUBS 890.098a
Cext_296 \$182 \$183 54.6015a
Cext_297 \$182 \$184 2.79698a
Cext_298 \$182 \$218 12.6351a
Cext_299 \$182 \$219 12.6351a
Cext_300 \$182 VSUBS 890.098a
Cext_301 \$183 \$184 2.72597f
Cext_302 \$183 \$203 4.28607a
Cext_303 \$183 \$204 5.39769a
Cext_304 \$183 \$205 5.39769a
Cext_305 \$183 \$206 5.39769a
Cext_306 \$183 \$207 5.39769a
Cext_307 \$183 \$208 5.39769a
Cext_308 \$183 \$209 1.93958a
Cext_309 \$183 \$210 2.14848a
Cext_310 \$183 \$211 2.14848a
Cext_311 \$183 \$212 2.14848a
Cext_312 \$183 \$213 1.93958a
Cext_313 \$183 \$214 1.73067a
Cext_314 \$183 \$215 1.93958a
Cext_315 \$183 \$216 2.14848a
Cext_316 \$183 \$217 2.14848a
Cext_317 \$183 \$218 2.14848a
Cext_318 \$183 \$219 15.7034a
Cext_319 \$183 \$228 1.8519f
Cext_320 \$183 \$229 1.77561a
Cext_321 \$183 \$332 1.77561a
Cext_322 \$183 \$351 46.915a
Cext_323 \$183 \$352 8.94579a
Cext_324 \$183 \$353 8.94579a
Cext_325 \$183 \$354 8.94579a
Cext_326 \$183 \$355 8.94579a
Cext_327 \$183 \$356 9.88009a
Cext_328 \$183 \$357 49.3827a
Cext_329 \$183 \$358 40.4369a
Cext_330 \$183 \$359 0.934295a
Cext_331 \$183 \$69 7.88132a
Cext_332 \$183 \$74 369.18a
Cext_333 \$183 iptat 0.252304a
Cext_334 \$183 isense 7.1058f
Cext_335 \$183 vdd 9.64002a
Cext_336 \$183 vped 12.78f
Cext_337 \$183 vref 100.089a
Cext_338 \$183 vref_buf 186.413a
Cext_339 \$183 vss 214.575a
Cext_340 \$183 VSUBS 5.94174f
Cext_341 \$184 \$185 40.4369a
Cext_342 \$184 \$186 0.934295a
Cext_343 \$184 \$207 0.934295a
Cext_344 \$184 \$208 40.4369a
Cext_345 \$184 \$209 50.2614a
Cext_346 \$184 \$210 10.8603a
Cext_347 \$184 \$211 9.92601a
Cext_348 \$184 \$212 9.92601a
Cext_349 \$184 \$213 9.8245a
Cext_350 \$184 \$214 9.72299a
Cext_351 \$184 \$215 9.8245a
Cext_352 \$184 \$216 9.92601a
Cext_353 \$184 \$217 9.92601a
Cext_354 \$184 \$218 9.92601a
Cext_355 \$184 \$219 9.8245a
Cext_356 \$184 \$220 18.0036a
Cext_357 \$184 \$69 3.59052a
Cext_358 \$184 \$74 4.47755a
Cext_359 \$184 VSUBS 4.18826f
Cext_360 \$185 \$186 28.7835a
Cext_361 \$185 \$220 12.6351a
Cext_362 \$185 \$221 12.6351a
Cext_363 \$185 VSUBS 890.098a
Cext_364 \$186 \$187 28.7835a
Cext_365 \$186 \$221 12.6351a
Cext_366 \$186 \$222 12.6351a
Cext_367 \$186 VSUBS 890.098a
Cext_368 \$187 \$188 28.7835a
Cext_369 \$187 \$222 12.6351a
Cext_370 \$187 \$223 12.6351a
Cext_371 \$187 VSUBS 890.098a
Cext_372 \$188 \$189 28.7835a
Cext_373 \$188 \$223 12.6351a
Cext_374 \$188 \$224 12.6351a
Cext_375 \$188 VSUBS 890.098a
Cext_376 \$189 \$190 28.7835a
Cext_377 \$189 \$224 12.6351a
Cext_378 \$189 \$225 12.6351a
Cext_379 \$189 VSUBS 890.098a
Cext_380 \$19 sense_n 40.4369a
Cext_381 \$19 vss 53.6189a
Cext_382 \$19 VSUBS 858.397a
Cext_383 \$190 \$225 12.6351a
Cext_384 \$190 vss 1.39423a
Cext_385 \$190 VSUBS 912.14a
Cext_386 \$2 \$3 5.68933f
Cext_387 \$2 \$34 5.2825f
Cext_388 \$2 \$35 3.59141f
Cext_389 \$2 \$4 4.37941f
Cext_390 \$2 \$5 1.93792f
Cext_391 \$2 \$57 5.60355f
Cext_392 \$2 \$58 4.97002f
Cext_393 \$2 \$6 1.30439a
Cext_394 \$2 \$68 65.7574a
Cext_395 \$2 \$69 999.089a
Cext_396 \$2 \$74 72.0384a
Cext_397 \$2 \$75 338.807a
Cext_398 \$2 iptat 502.475a
Cext_399 \$2 isense 2.4738f
Cext_400 \$2 vdd 956.474a
Cext_401 \$2 vss 852.576a
Cext_402 \$2 VSUBS 32.7164f
Cext_403 \$202 \$228 7.43578f
Cext_404 \$202 \$229 636.336a
Cext_405 \$202 vdd 5.16353f
Cext_406 \$202 vped 8.28455f
Cext_407 \$202 vss 0.57638a
Cext_408 \$202 VSUBS 6.21154f
Cext_409 \$203 \$204 28.7835a
Cext_410 \$203 \$228 15.5287a
Cext_411 \$203 \$69 0.72091a
Cext_412 \$203 \$74 1.1216a
Cext_413 \$203 vss 2.22579a
Cext_414 \$203 VSUBS 908.543a
Cext_415 \$204 \$205 28.7835a
Cext_416 \$204 \$69 1.02212a
Cext_417 \$204 \$74 1.25174a
Cext_418 \$204 VSUBS 890.098a
Cext_419 \$205 \$206 28.7835a
Cext_420 \$205 \$69 1.02212a
Cext_421 \$205 \$74 1.25174a
Cext_422 \$205 VSUBS 890.098a
Cext_423 \$206 \$207 28.7835a
Cext_424 \$206 \$69 1.02212a
Cext_425 \$206 \$74 1.25174a
Cext_426 \$206 VSUBS 890.098a
Cext_427 \$207 \$208 28.7835a
Cext_428 \$207 \$69 1.02212a
Cext_429 \$207 \$74 1.25174a
Cext_430 \$207 VSUBS 890.098a
Cext_431 \$208 \$69 1.02212a
Cext_432 \$208 \$74 1.25174a
Cext_433 \$208 VSUBS 890.098a
Cext_434 \$209 \$210 28.7835a
Cext_435 \$209 \$69 13.6649a
Cext_436 \$209 \$74 1.1216a
Cext_437 \$209 VSUBS 890.079a
Cext_438 \$210 \$211 28.7835a
Cext_439 \$210 \$69 1.02212a
Cext_440 \$210 \$74 1.25174a
Cext_441 \$210 VSUBS 890.098a
Cext_442 \$211 \$212 28.7835a
Cext_443 \$211 \$69 1.02212a
Cext_444 \$211 \$74 1.25174a
Cext_445 \$211 VSUBS 890.098a
Cext_446 \$212 \$213 28.7835a
Cext_447 \$212 \$69 1.02212a
Cext_448 \$212 \$74 1.25174a
Cext_449 \$212 VSUBS 890.098a
Cext_450 \$213 \$214 28.7835a
Cext_451 \$213 \$69 0.72091a
Cext_452 \$213 \$74 1.1216a
Cext_453 \$213 VSUBS 890.079a
Cext_454 \$214 \$215 28.7835a
Cext_455 \$214 \$69 13.0489a
Cext_456 \$214 \$74 14.2927a
Cext_457 \$214 VSUBS 890.06a
Cext_458 \$215 \$216 28.7835a
Cext_459 \$215 \$74 13.5491a
Cext_460 \$215 VSUBS 890.079a
Cext_461 \$216 \$217 28.7835a
Cext_462 \$216 VSUBS 890.098a
Cext_463 \$217 \$218 28.7835a
Cext_464 \$217 VSUBS 890.098a
Cext_465 \$218 \$219 28.7835a
Cext_466 \$218 VSUBS 890.098a
Cext_467 \$219 \$220 28.7835a
Cext_468 \$219 VSUBS 890.079a
Cext_469 \$22 \$23 28.7835a
Cext_470 \$22 sense_n 79.1669a
Cext_471 \$22 sense_p 56.171a
Cext_472 \$22 vss 53.6189a
Cext_473 \$22 VSUBS 858.397a
Cext_474 \$220 \$221 28.7835a
Cext_475 \$220 VSUBS 890.079a
Cext_476 \$221 \$222 28.7835a
Cext_477 \$221 VSUBS 890.098a
Cext_478 \$222 \$223 28.7835a
Cext_479 \$222 VSUBS 890.098a
Cext_480 \$223 \$224 28.7835a
Cext_481 \$223 VSUBS 890.098a
Cext_482 \$224 \$225 28.7835a
Cext_483 \$224 VSUBS 890.098a
Cext_484 \$225 VSUBS 908.974a
Cext_485 \$228 \$229 699.548a
Cext_486 \$228 \$351 9.34707f
Cext_487 \$228 \$352 2.82353a
Cext_488 \$228 \$353 2.82353a
Cext_489 \$228 \$354 2.82353a
Cext_490 \$228 \$355 2.82353a
Cext_491 \$228 \$356 2.82353a
Cext_492 \$228 \$357 2.82353a
Cext_493 \$228 \$358 2.82353a
Cext_494 \$228 \$359 2.82353a
Cext_495 \$228 \$360 2.82353a
Cext_496 \$228 \$361 2.82353a
Cext_497 \$228 \$69 135.536a
Cext_498 \$228 \$74 50.1832a
Cext_499 \$228 iptat 64.1129a
Cext_500 \$228 isense 192.488a
Cext_501 \$228 vdd 605.861a
Cext_502 \$228 vped 11.9422f
Cext_503 \$228 vref 99.9546a
Cext_504 \$228 vref_buf 14.665f
Cext_505 \$228 vss 1.26659f
Cext_506 \$228 VSUBS 31.8353f
Cext_507 \$229 iptat 71.9816a
Cext_508 \$229 isense 4.0948a
Cext_509 \$229 vdd 444.371a
Cext_510 \$229 vped 25.9562f
Cext_511 \$229 vss 330.248a
Cext_512 \$229 VSUBS 2.2978f
Cext_513 \$23 \$24 28.7835a
Cext_514 \$23 sense_n 79.1669a
Cext_515 \$23 sense_p 16.6685a
Cext_516 \$23 vss 53.6189a
Cext_517 \$23 VSUBS 858.397a
Cext_518 \$24 \$25 28.7835a
Cext_519 \$24 sense_n 79.1669a
Cext_520 \$24 sense_p 15.7342a
Cext_521 \$24 vss 53.6189a
Cext_522 \$24 VSUBS 858.397a
Cext_523 \$243 \$244 5.68933f
Cext_524 \$243 \$245 1.93792f
Cext_525 \$243 \$246 4.37941f
Cext_526 \$243 \$247 1.30439a
Cext_527 \$243 \$249 5.2825f
Cext_528 \$243 \$250 3.59141f
Cext_529 \$243 \$315 5.60355f
Cext_530 \$243 \$316 4.97002f
Cext_531 \$243 \$326 65.7574a
Cext_532 \$243 \$332 338.807a
Cext_533 \$243 iptat 466.031a
Cext_534 \$243 vdd 959.591a
Cext_535 \$243 vped 0.13223a
Cext_536 \$243 vref 72.0384a
Cext_537 \$243 vref_buf 3.5165f
Cext_538 \$243 vss 846.778a
Cext_539 \$243 VSUBS 32.7119f
Cext_540 \$244 \$245 695.042a
Cext_541 \$244 \$246 1.78423f
Cext_542 \$244 \$247 81.65a
Cext_543 \$244 \$249 286.223a
Cext_544 \$244 \$250 137.593a
Cext_545 \$244 \$326 7.38946f
Cext_546 \$244 \$332 291.726a
Cext_547 \$244 iptat 418.944a
Cext_548 \$244 vdd 7.61671f
Cext_549 \$244 vped 0.10451a
Cext_550 \$244 vref 557.647a
Cext_551 \$244 vref_buf 711.053a
Cext_552 \$244 vss 546.872a
Cext_553 \$244 VSUBS 27.3068f
Cext_554 \$245 \$246 2.01779f
Cext_555 \$245 \$247 465.164a
Cext_556 \$245 \$249 1.68398f
Cext_557 \$245 \$250 0.966982a
Cext_558 \$245 \$315 4.3649a
Cext_559 \$245 \$326 1.4372f
Cext_560 \$245 \$332 103.033a
Cext_561 \$245 iptat 4.5513f
Cext_562 \$245 vdd 9.09587f
Cext_563 \$245 vped 0.172488a
Cext_564 \$245 vref 997.702a
Cext_565 \$245 vref_buf 8.67093f
Cext_566 \$245 vss 2.78817f
Cext_567 \$245 VSUBS 8.01601f
Cext_568 \$246 \$247 1.83357f
Cext_569 \$246 \$249 3.15168f
Cext_570 \$246 \$250 2.37443f
Cext_571 \$246 \$315 0.441084a
Cext_572 \$246 \$316 0.220542a
Cext_573 \$246 \$326 263.257a
Cext_574 \$246 \$332 170.258a
Cext_575 \$246 iptat 1.23563f
Cext_576 \$246 vdd 913.163a
Cext_577 \$246 vref 92.3065a
Cext_578 \$246 vref_buf 279.326a
Cext_579 \$246 vss 4.48555f
Cext_580 \$246 VSUBS 18.7663f
Cext_581 \$247 \$249 56.3514a
Cext_582 \$247 \$250 3.29635f
Cext_583 \$247 \$316 4.74202a
Cext_584 \$247 \$326 2.60276f
Cext_585 \$247 \$332 206.331a
Cext_586 \$247 iptat 5.16367f
Cext_587 \$247 vdd 7.9618f
Cext_588 \$247 vped 0.10451a
Cext_589 \$247 vref 8.68417f
Cext_590 \$247 vref_buf 3.28718f
Cext_591 \$247 vss 2.75716f
Cext_592 \$247 VSUBS 7.96326f
Cext_593 \$249 \$250 1.61266f
Cext_594 \$249 \$315 6.12058f
Cext_595 \$249 \$316 3.67869f
Cext_596 \$249 \$326 1.51285a
Cext_597 \$249 \$332 54.6553a
Cext_598 \$249 iptat 78.0763a
Cext_599 \$249 vdd 12.1579f
Cext_600 \$249 vref 44.448a
Cext_601 \$249 vref_buf 1.87683f
Cext_602 \$249 vss 1.30411f
Cext_603 \$249 VSUBS 34.4511f
Cext_604 \$25 \$26 28.7835a
Cext_605 \$25 sense_n 79.1669a
Cext_606 \$25 sense_p 15.7342a
Cext_607 \$25 vss 53.6189a
Cext_608 \$25 VSUBS 858.397a
Cext_609 \$250 \$316 2.44226f
Cext_610 \$250 \$326 776.999a
Cext_611 \$250 \$332 1.04438f
Cext_612 \$250 iptat 374.264a
Cext_613 \$250 isense 0.642539a
Cext_614 \$250 vdd 11.1361f
Cext_615 \$250 vref 713.207a
Cext_616 \$250 vref_buf 13.805f
Cext_617 \$250 vss 1.3079f
Cext_618 \$250 VSUBS 34.702f
Cext_619 \$26 \$27 28.7835a
Cext_620 \$26 sense_n 79.1669a
Cext_621 \$26 sense_p 15.7342a
Cext_622 \$26 vss 53.6189a
Cext_623 \$26 VSUBS 858.397a
Cext_624 \$27 \$28 28.7835a
Cext_625 \$27 sense_n 79.1669a
Cext_626 \$27 sense_p 15.7342a
Cext_627 \$27 vss 53.6189a
Cext_628 \$27 VSUBS 858.397a
Cext_629 \$28 \$29 28.7835a
Cext_630 \$28 sense_n 79.1669a
Cext_631 \$28 sense_p 15.7342a
Cext_632 \$28 vss 53.6189a
Cext_633 \$28 VSUBS 858.397a
Cext_634 \$29 \$30 28.7835a
Cext_635 \$29 sense_n 79.1669a
Cext_636 \$29 sense_p 15.7342a
Cext_637 \$29 vss 53.6189a
Cext_638 \$29 VSUBS 858.397a
Cext_639 \$3 \$34 286.223a
Cext_640 \$3 \$35 137.593a
Cext_641 \$3 \$4 1.78423f
Cext_642 \$3 \$5 695.042a
Cext_643 \$3 \$6 81.65a
Cext_644 \$3 \$68 7.38946f
Cext_645 \$3 \$69 96.0317a
Cext_646 \$3 \$74 469.847a
Cext_647 \$3 \$75 291.726a
Cext_648 \$3 iptat 419.144a
Cext_649 \$3 isense 682.96a
Cext_650 \$3 vdd 7.61671f
Cext_651 \$3 vss 550.753a
Cext_652 \$3 VSUBS 27.3052f
Cext_653 \$30 \$31 28.7835a
Cext_654 \$30 sense_n 79.1669a
Cext_655 \$30 sense_p 15.7342a
Cext_656 \$30 vss 53.6189a
Cext_657 \$30 VSUBS 858.397a
Cext_658 \$31 \$32 28.7835a
Cext_659 \$31 sense_n 79.1669a
Cext_660 \$31 sense_p 15.7342a
Cext_661 \$31 vss 53.6189a
Cext_662 \$31 VSUBS 858.397a
Cext_663 \$315 \$316 185.733a
Cext_664 \$315 \$332 29.5855a
Cext_665 \$315 vdd 6.77016f
Cext_666 \$315 vref 16.3a
Cext_667 \$315 vref_buf 539.472a
Cext_668 \$315 vss 19.3341a
Cext_669 \$315 VSUBS 3.39035f
Cext_670 \$316 \$332 27.9988a
Cext_671 \$316 vdd 6.77016f
Cext_672 \$316 vref 16.3a
Cext_673 \$316 vref_buf 701.209a
Cext_674 \$316 vss 23.7652a
Cext_675 \$316 VSUBS 3.39125f
Cext_676 \$32 sense_n 79.1669a
Cext_677 \$32 sense_p 15.7342a
Cext_678 \$32 vss 53.6189a
Cext_679 \$32 VSUBS 858.397a
Cext_680 \$326 \$332 636.336a
Cext_681 \$326 vdd 5.16353f
Cext_682 \$326 vref 7.4382f
Cext_683 \$326 vref_buf 8.28143f
Cext_684 \$326 vss 0.57638a
Cext_685 \$326 VSUBS 6.21154f
Cext_686 \$332 iptat 51.4496a
Cext_687 \$332 isense 11.6406a
Cext_688 \$332 vdd 444.371a
Cext_689 \$332 vref 699.548a
Cext_690 \$332 vref_buf 25.9562f
Cext_691 \$332 vss 330.248a
Cext_692 \$332 VSUBS 2.30651f
Cext_693 \$34 \$35 1.61266f
Cext_694 \$34 \$4 3.15168f
Cext_695 \$34 \$5 1.68398f
Cext_696 \$34 \$57 6.12058f
Cext_697 \$34 \$58 3.67869f
Cext_698 \$34 \$6 56.3514a
Cext_699 \$34 \$68 1.51285a
Cext_700 \$34 \$69 174.127a
Cext_701 \$34 \$74 44.448a
Cext_702 \$34 \$75 54.6553a
Cext_703 \$34 iptat 78.0763a
Cext_704 \$34 isense 1.7027f
Cext_705 \$34 vdd 12.1579f
Cext_706 \$34 vss 1.30411f
Cext_707 \$34 VSUBS 34.4511f
Cext_708 \$35 \$4 2.37443f
Cext_709 \$35 \$5 0.966982a
Cext_710 \$35 \$58 2.44226f
Cext_711 \$35 \$6 3.29635f
Cext_712 \$35 \$68 776.999a
Cext_713 \$35 \$69 485.172a
Cext_714 \$35 \$74 608.21a
Cext_715 \$35 \$75 1.04438f
Cext_716 \$35 iptat 376a
Cext_717 \$35 isense 13.4016f
Cext_718 \$35 vdd 11.1361f
Cext_719 \$35 vss 1.3079f
Cext_720 \$35 VSUBS 34.702f
Cext_721 \$351 \$352 42.5678a
Cext_722 \$351 \$353 3.0652a
Cext_723 \$351 \$354 2.1309a
Cext_724 \$351 \$355 2.1309a
Cext_725 \$351 \$356 2.1309a
Cext_726 \$351 \$357 2.1309a
Cext_727 \$351 \$358 2.1309a
Cext_728 \$351 \$359 2.1309a
Cext_729 \$351 \$360 2.1309a
Cext_730 \$351 \$361 2.1309a
Cext_731 \$351 \$362 2.1309a
Cext_732 \$351 \$363 2.1309a
Cext_733 \$351 \$364 2.1309a
Cext_734 \$351 \$365 2.1309a
Cext_735 \$351 \$366 40.4369a
Cext_736 \$351 \$367 0.934295a
Cext_737 \$351 isense 511.837a
Cext_738 \$351 vdd 30.2984a
Cext_739 \$351 vped 45.9221a
Cext_740 \$351 vref_buf 46.3596a
Cext_741 \$351 vss 13.7095f
Cext_742 \$351 VSUBS 2.99008f
Cext_743 \$352 \$353 28.7835a
Cext_744 \$352 isense 15.7342a
Cext_745 \$352 vped 5.68486a
Cext_746 \$352 vref_buf 3.89865a
Cext_747 \$352 vss 24.5892a
Cext_748 \$352 VSUBS 888.636a
Cext_749 \$353 \$354 28.7835a
Cext_750 \$353 isense 15.7342a
Cext_751 \$353 vped 5.68486a
Cext_752 \$353 vref_buf 3.89865a
Cext_753 \$353 vss 24.5892a
Cext_754 \$353 VSUBS 888.636a
Cext_755 \$354 \$355 28.7835a
Cext_756 \$354 isense 15.7342a
Cext_757 \$354 vped 5.68486a
Cext_758 \$354 vref_buf 3.89865a
Cext_759 \$354 vss 24.5892a
Cext_760 \$354 VSUBS 888.636a
Cext_761 \$355 \$356 28.7835a
Cext_762 \$355 isense 15.7342a
Cext_763 \$355 vped 5.68486a
Cext_764 \$355 vref_buf 3.89865a
Cext_765 \$355 vss 24.5892a
Cext_766 \$355 VSUBS 888.636a
Cext_767 \$356 \$357 28.7835a
Cext_768 \$356 isense 15.7342a
Cext_769 \$356 vped 5.68486a
Cext_770 \$356 vref_buf 3.89865a
Cext_771 \$356 vss 24.5892a
Cext_772 \$356 VSUBS 888.636a
Cext_773 \$357 isense 15.7342a
Cext_774 \$357 vped 5.68486a
Cext_775 \$357 vref_buf 3.89865a
Cext_776 \$357 vss 24.5892a
Cext_777 \$357 VSUBS 888.636a
Cext_778 \$358 \$359 28.7835a
Cext_779 \$358 isense 15.7342a
Cext_780 \$358 vped 5.68486a
Cext_781 \$358 vref_buf 3.89865a
Cext_782 \$358 vss 24.5892a
Cext_783 \$358 VSUBS 888.636a
Cext_784 \$359 \$360 28.7835a
Cext_785 \$359 isense 15.7342a
Cext_786 \$359 vped 5.68486a
Cext_787 \$359 vref_buf 3.89865a
Cext_788 \$359 vss 24.5892a
Cext_789 \$359 VSUBS 888.636a
Cext_790 \$360 \$361 28.7835a
Cext_791 \$360 isense 15.7342a
Cext_792 \$360 vped 6.61916a
Cext_793 \$360 vref_buf 3.89865a
Cext_794 \$360 vss 24.5892a
Cext_795 \$360 VSUBS 888.636a
Cext_796 \$361 isense 15.7342a
Cext_797 \$361 vped 46.1217a
Cext_798 \$361 vref_buf 3.89865a
Cext_799 \$361 vss 24.5892a
Cext_800 \$361 VSUBS 888.636a
Cext_801 \$362 \$363 28.7835a
Cext_802 \$362 isense 39.9149a
Cext_803 \$362 vss 24.5892a
Cext_804 \$362 VSUBS 888.636a
Cext_805 \$363 \$364 28.7835a
Cext_806 \$363 isense 39.9149a
Cext_807 \$363 vss 24.5892a
Cext_808 \$363 VSUBS 888.636a
Cext_809 \$364 \$365 28.7835a
Cext_810 \$364 isense 40.8492a
Cext_811 \$364 vss 24.5892a
Cext_812 \$364 VSUBS 888.636a
Cext_813 \$365 isense 80.3517a
Cext_814 \$365 vss 24.5892a
Cext_815 \$365 VSUBS 888.636a
Cext_816 \$366 \$367 28.7835a
Cext_817 \$366 vss 27.0818a
Cext_818 \$366 VSUBS 888.636a
Cext_819 \$367 \$368 28.7835a
Cext_820 \$367 vss 27.0818a
Cext_821 \$367 VSUBS 888.636a
Cext_822 \$368 \$369 28.7835a
Cext_823 \$368 vss 27.0818a
Cext_824 \$368 VSUBS 888.636a
Cext_825 \$369 \$370 28.7835a
Cext_826 \$369 vss 28.0161a
Cext_827 \$369 VSUBS 888.636a
Cext_828 \$370 vss 67.5186a
Cext_829 \$370 VSUBS 888.636a
Cext_830 \$4 \$5 2.01779f
Cext_831 \$4 \$57 0.441084a
Cext_832 \$4 \$58 0.220542a
Cext_833 \$4 \$6 1.83357f
Cext_834 \$4 \$68 263.257a
Cext_835 \$4 \$69 70.4886a
Cext_836 \$4 \$74 92.0037a
Cext_837 \$4 \$75 170.258a
Cext_838 \$4 iptat 1.24586f
Cext_839 \$4 isense 197.412a
Cext_840 \$4 vdd 913.163a
Cext_841 \$4 vss 4.49669f
Cext_842 \$4 VSUBS 18.7667f
Cext_843 \$5 \$57 4.3649a
Cext_844 \$5 \$6 465.164a
Cext_845 \$5 \$68 1.4372f
Cext_846 \$5 \$69 7.89555f
Cext_847 \$5 \$74 997.702a
Cext_848 \$5 \$75 103.033a
Cext_849 \$5 iptat 4.76738f
Cext_850 \$5 isense 504.596a
Cext_851 \$5 vdd 9.09137f
Cext_852 \$5 vss 2.80722f
Cext_853 \$5 VSUBS 8.05144f
Cext_854 \$57 \$58 185.733a
Cext_855 \$57 \$69 127.338a
Cext_856 \$57 \$74 16.3a
Cext_857 \$57 \$75 29.5855a
Cext_858 \$57 isense 412.134a
Cext_859 \$57 vdd 6.77016f
Cext_860 \$57 vss 19.3341a
Cext_861 \$57 VSUBS 3.39035f
Cext_862 \$58 \$6 4.74202a
Cext_863 \$58 \$69 135.256a
Cext_864 \$58 \$74 16.3a
Cext_865 \$58 \$75 27.9988a
Cext_866 \$58 isense 565.953a
Cext_867 \$58 vdd 6.77016f
Cext_868 \$58 vss 23.7652a
Cext_869 \$58 VSUBS 3.39125f
Cext_870 \$6 \$68 2.60276f
Cext_871 \$6 \$69 927.311a
Cext_872 \$6 \$74 8.68417f
Cext_873 \$6 \$75 206.331a
Cext_874 \$6 iptat 5.41275f
Cext_875 \$6 isense 2.07089f
Cext_876 \$6 vdd 7.9618f
Cext_877 \$6 vss 2.77191f
Cext_878 \$6 VSUBS 8.00449f
Cext_879 \$68 \$69 5.24503f
Cext_880 \$68 \$74 7.43578f
Cext_881 \$68 \$75 636.336a
Cext_882 \$68 isense 3.03824f
Cext_883 \$68 vdd 5.16353f
Cext_884 \$68 vss 0.57638a
Cext_885 \$68 VSUBS 6.21154f
Cext_886 \$69 \$74 15.7858f
Cext_887 \$69 \$75 668.305a
Cext_888 \$69 iptat 3.63261f
Cext_889 \$69 isense 5.2024f
Cext_890 \$69 vdd 703.675a
Cext_891 \$69 vped 298.351a
Cext_892 \$69 vss 313.12a
Cext_893 \$69 VSUBS 32.2801f
Cext_894 \$74 \$75 702.569a
Cext_895 \$74 iptat 60.2308a
Cext_896 \$74 isense 4.86474f
Cext_897 \$74 vdd 582.149a
Cext_898 \$74 vped 154.668a
Cext_899 \$74 vss 543.241a
Cext_900 \$74 VSUBS 31.2424f
Cext_901 \$75 iptat 71.9523a
Cext_902 \$75 isense 24.8871f
Cext_903 \$75 vdd 444.301a
Cext_904 \$75 vss 330.231a
Cext_905 \$75 VSUBS 2.29408f
Cext_906 \$8 \$9 28.7835a
Cext_907 \$8 vss 55.8447a
Cext_908 \$8 VSUBS 876.861a
Cext_909 \$9 vss 53.6189a
Cext_910 \$9 VSUBS 858.397a
Cext_911 iptat isense 6.58395f
Cext_912 iptat vdd 1.49664f
Cext_913 iptat vped 5.34149f
Cext_914 iptat vref_buf 5.65772f
Cext_915 iptat vss 37.152f
Cext_916 isense vdd 8.57406f
Cext_917 isense vped 1.32533f
Cext_918 isense vref 156.172a
Cext_919 isense vref_buf 337.211a
Cext_920 isense vss 6.32093f
Cext_921 sense_n sense_p 10.9643f
Cext_922 sense_n vss 204.723a
Cext_923 sense_p vss 317.301a
Cext_924 vdd vped 9.17952f
Cext_925 vdd vref 1.32734f
Cext_926 vdd vref_buf 8.66436f
Cext_927 vdd vss 44.5306f
Cext_928 vped vref 100.025a
Cext_929 vped vref_buf 13.0031f
Cext_930 vped vss 6.53995f
Cext_931 vref vref_buf 7.38296f
Cext_932 vref vss 1.76698f
Cext_933 vref_buf vss 7.55178f
Cext_934 VSUBS iptat 148.353f
Cext_935 VSUBS isense 22.4734f
Cext_936 VSUBS sense_n 3.99032f
Cext_937 VSUBS sense_p 2.70136f
Cext_938 VSUBS vdd 155.299f
Cext_939 VSUBS vped 44.7312f
Cext_940 VSUBS vref 35.6348f
Cext_941 VSUBS vref_buf 44.8196f
Cext_942 VSUBS vss 282.343f
.ENDS g1_sense
