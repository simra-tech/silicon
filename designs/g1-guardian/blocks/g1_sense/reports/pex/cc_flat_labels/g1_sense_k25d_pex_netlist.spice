*********************************************************
*** NGSPICE file created by KLayout-PEX 0.3.12
*** -----------------------------------------------------
***     Extraction Engine: KPEX/2.5D
***     Technology: ihp_sg13g2
***     Date: 2026-09-19 09:44:20
*********************************************************

.SUBCKT g1_sense inn inn|out|vped inn|out|vref_buf inp inp$1 inp|vref iptat|vbn
+ isense|out sense_n sense_p vdd vss
M$1 \$4 \$4 vss vss sg13_hv_nmos L=1U W=1.6U AS=0.544P AD=0.544P PS=3.88U
+ PD=3.88U rfmode=0
M$2 \$3 iptat|vbn vss vss sg13_hv_nmos L=1U W=8U AS=2.72P AD=2.72P PS=16.68U
+ PD=16.68U rfmode=0
M$3 \$2 iptat|vbn vss vss sg13_hv_nmos L=1U W=8U AS=2.72P AD=2.72P PS=16.68U
+ PD=16.68U rfmode=0
M$4 \$5 iptat|vbn vss vss sg13_hv_nmos L=1U W=8U AS=2.72P AD=1.52P PS=16.68U
+ PD=8.38U rfmode=0
M$5 vss iptat|vbn \$5 vss sg13_hv_nmos L=1U W=8U AS=1.52P AD=1.52P PS=8.38U
+ PD=8.38U rfmode=0
M$6 \$5 iptat|vbn vss vss sg13_hv_nmos L=1U W=8U AS=1.52P AD=1.52P PS=8.38U
+ PD=8.38U rfmode=0
M$7 vss iptat|vbn \$5 vss sg13_hv_nmos L=1U W=8U AS=1.52P AD=1.52P PS=8.38U
+ PD=8.38U rfmode=0
M$8 \$5 iptat|vbn vss vss sg13_hv_nmos L=1U W=8U AS=1.52P AD=1.52P PS=8.38U
+ PD=8.38U rfmode=0
M$9 vss iptat|vbn \$5 vss sg13_hv_nmos L=1U W=8U AS=1.52P AD=1.52P PS=8.38U
+ PD=8.38U rfmode=0
M$10 \$5 iptat|vbn vss vss sg13_hv_nmos L=1U W=8U AS=1.52P AD=1.52P PS=8.38U
+ PD=8.38U rfmode=0
M$11 vss iptat|vbn \$5 vss sg13_hv_nmos L=1U W=8U AS=1.52P AD=1.52P PS=8.38U
+ PD=8.38U rfmode=0
M$12 \$5 iptat|vbn vss vss sg13_hv_nmos L=1U W=8U AS=1.52P AD=1.52P PS=8.38U
+ PD=8.38U rfmode=0
M$13 vss iptat|vbn \$5 vss sg13_hv_nmos L=1U W=8U AS=1.52P AD=2.72P PS=8.38U
+ PD=16.68U rfmode=0
M$14 \$34 \$4 \$5 vss sg13_hv_nmos L=1U W=8U AS=2.72P AD=1.52P PS=16.68U
+ PD=8.38U rfmode=0
M$15 \$5 \$4 \$34 vss sg13_hv_nmos L=1U W=8U AS=1.52P AD=1.52P PS=8.38U
+ PD=8.38U rfmode=0
M$16 \$34 \$4 \$5 vss sg13_hv_nmos L=1U W=8U AS=1.52P AD=1.52P PS=8.38U
+ PD=8.38U rfmode=0
M$17 \$5 \$4 \$34 vss sg13_hv_nmos L=1U W=8U AS=1.52P AD=1.52P PS=8.38U
+ PD=8.38U rfmode=0
M$18 \$34 \$4 \$5 vss sg13_hv_nmos L=1U W=8U AS=1.52P AD=1.52P PS=8.38U
+ PD=8.38U rfmode=0
M$19 \$5 \$4 \$34 vss sg13_hv_nmos L=1U W=8U AS=1.52P AD=2.72P PS=8.38U
+ PD=16.68U rfmode=0
M$20 \$35 \$4 \$6 vss sg13_hv_nmos L=1U W=8U AS=2.72P AD=1.52P PS=16.68U
+ PD=8.38U rfmode=0
M$21 \$6 \$4 \$35 vss sg13_hv_nmos L=1U W=8U AS=1.52P AD=1.52P PS=8.38U
+ PD=8.38U rfmode=0
M$22 \$35 \$4 \$6 vss sg13_hv_nmos L=1U W=8U AS=1.52P AD=1.52P PS=8.38U
+ PD=8.38U rfmode=0
M$23 \$6 \$4 \$35 vss sg13_hv_nmos L=1U W=8U AS=1.52P AD=1.52P PS=8.38U
+ PD=8.38U rfmode=0
M$24 \$35 \$4 \$6 vss sg13_hv_nmos L=1U W=8U AS=1.52P AD=1.52P PS=8.38U
+ PD=8.38U rfmode=0
M$25 \$6 \$4 \$35 vss sg13_hv_nmos L=1U W=8U AS=1.52P AD=2.72P PS=8.38U
+ PD=16.68U rfmode=0
M$26 \$6 iptat|vbn vss vss sg13_hv_nmos L=1U W=8U AS=2.72P AD=1.52P PS=16.68U
+ PD=8.38U rfmode=0
M$27 vss iptat|vbn \$6 vss sg13_hv_nmos L=1U W=8U AS=1.52P AD=1.52P PS=8.38U
+ PD=8.38U rfmode=0
M$28 \$6 iptat|vbn vss vss sg13_hv_nmos L=1U W=8U AS=1.52P AD=1.52P PS=8.38U
+ PD=8.38U rfmode=0
M$29 vss iptat|vbn \$6 vss sg13_hv_nmos L=1U W=8U AS=1.52P AD=1.52P PS=8.38U
+ PD=8.38U rfmode=0
M$30 \$6 iptat|vbn vss vss sg13_hv_nmos L=1U W=8U AS=1.52P AD=1.52P PS=8.38U
+ PD=8.38U rfmode=0
M$31 vss iptat|vbn \$6 vss sg13_hv_nmos L=1U W=8U AS=1.52P AD=1.52P PS=8.38U
+ PD=8.38U rfmode=0
M$32 \$6 iptat|vbn vss vss sg13_hv_nmos L=1U W=8U AS=1.52P AD=1.52P PS=8.38U
+ PD=8.38U rfmode=0
M$33 vss iptat|vbn \$6 vss sg13_hv_nmos L=1U W=8U AS=1.52P AD=1.52P PS=8.38U
+ PD=8.38U rfmode=0
M$34 \$6 iptat|vbn vss vss sg13_hv_nmos L=1U W=8U AS=1.52P AD=1.52P PS=8.38U
+ PD=8.38U rfmode=0
M$35 vss iptat|vbn \$6 vss sg13_hv_nmos L=1U W=8U AS=1.52P AD=2.72P PS=8.38U
+ PD=16.68U rfmode=0
M$36 isense|out iptat|vbn vss vss sg13_hv_nmos L=1U W=8U AS=2.72P AD=1.52P
+ PS=16.68U PD=8.38U rfmode=0
M$37 vss iptat|vbn isense|out vss sg13_hv_nmos L=1U W=8U AS=1.52P AD=1.52P
+ PS=8.38U PD=8.38U rfmode=0
M$38 isense|out iptat|vbn vss vss sg13_hv_nmos L=1U W=8U AS=1.52P AD=1.52P
+ PS=8.38U PD=8.38U rfmode=0
M$39 vss iptat|vbn isense|out vss sg13_hv_nmos L=1U W=8U AS=1.52P AD=1.52P
+ PS=8.38U PD=8.38U rfmode=0
M$40 isense|out iptat|vbn vss vss sg13_hv_nmos L=1U W=8U AS=1.52P AD=1.52P
+ PS=8.38U PD=8.38U rfmode=0
M$41 vss iptat|vbn isense|out vss sg13_hv_nmos L=1U W=8U AS=1.52P AD=1.52P
+ PS=8.38U PD=8.38U rfmode=0
M$42 isense|out iptat|vbn vss vss sg13_hv_nmos L=1U W=8U AS=1.52P AD=1.52P
+ PS=8.38U PD=8.38U rfmode=0
M$43 vss iptat|vbn isense|out vss sg13_hv_nmos L=1U W=8U AS=1.52P AD=1.52P
+ PS=8.38U PD=8.38U rfmode=0
M$44 isense|out iptat|vbn vss vss sg13_hv_nmos L=1U W=8U AS=1.52P AD=1.52P
+ PS=8.38U PD=8.38U rfmode=0
M$45 vss iptat|vbn isense|out vss sg13_hv_nmos L=1U W=8U AS=1.52P AD=1.52P
+ PS=8.38U PD=8.38U rfmode=0
M$46 isense|out iptat|vbn vss vss sg13_hv_nmos L=1U W=8U AS=1.52P AD=1.52P
+ PS=8.38U PD=8.38U rfmode=0
M$47 vss iptat|vbn isense|out vss sg13_hv_nmos L=1U W=8U AS=1.52P AD=2.72P
+ PS=8.38U PD=16.68U rfmode=0
M$48 \$140 \$140 vss vss sg13_hv_nmos L=1U W=1.6U AS=0.544P AD=0.544P PS=3.88U
+ PD=3.88U rfmode=0
M$49 \$138 iptat|vbn vss vss sg13_hv_nmos L=1U W=8U AS=2.72P AD=2.72P PS=16.68U
+ PD=16.68U rfmode=0
M$50 \$137 iptat|vbn vss vss sg13_hv_nmos L=1U W=8U AS=2.72P AD=2.72P PS=16.68U
+ PD=16.68U rfmode=0
M$51 \$139 iptat|vbn vss vss sg13_hv_nmos L=1U W=8U AS=2.72P AD=1.52P PS=16.68U
+ PD=8.38U rfmode=0
M$52 vss iptat|vbn \$139 vss sg13_hv_nmos L=1U W=8U AS=1.52P AD=1.52P PS=8.38U
+ PD=8.38U rfmode=0
M$53 \$139 iptat|vbn vss vss sg13_hv_nmos L=1U W=8U AS=1.52P AD=1.52P PS=8.38U
+ PD=8.38U rfmode=0
M$54 vss iptat|vbn \$139 vss sg13_hv_nmos L=1U W=8U AS=1.52P AD=1.52P PS=8.38U
+ PD=8.38U rfmode=0
M$55 \$139 iptat|vbn vss vss sg13_hv_nmos L=1U W=8U AS=1.52P AD=1.52P PS=8.38U
+ PD=8.38U rfmode=0
M$56 vss iptat|vbn \$139 vss sg13_hv_nmos L=1U W=8U AS=1.52P AD=1.52P PS=8.38U
+ PD=8.38U rfmode=0
M$57 \$139 iptat|vbn vss vss sg13_hv_nmos L=1U W=8U AS=1.52P AD=1.52P PS=8.38U
+ PD=8.38U rfmode=0
M$58 vss iptat|vbn \$139 vss sg13_hv_nmos L=1U W=8U AS=1.52P AD=1.52P PS=8.38U
+ PD=8.38U rfmode=0
M$59 \$139 iptat|vbn vss vss sg13_hv_nmos L=1U W=8U AS=1.52P AD=1.52P PS=8.38U
+ PD=8.38U rfmode=0
M$60 vss iptat|vbn \$139 vss sg13_hv_nmos L=1U W=8U AS=1.52P AD=2.72P PS=8.38U
+ PD=16.68U rfmode=0
M$61 \$143 \$140 \$139 vss sg13_hv_nmos L=1U W=8U AS=2.72P AD=1.52P PS=16.68U
+ PD=8.38U rfmode=0
M$62 \$139 \$140 \$143 vss sg13_hv_nmos L=1U W=8U AS=1.52P AD=1.52P PS=8.38U
+ PD=8.38U rfmode=0
M$63 \$143 \$140 \$139 vss sg13_hv_nmos L=1U W=8U AS=1.52P AD=1.52P PS=8.38U
+ PD=8.38U rfmode=0
M$64 \$139 \$140 \$143 vss sg13_hv_nmos L=1U W=8U AS=1.52P AD=1.52P PS=8.38U
+ PD=8.38U rfmode=0
M$65 \$143 \$140 \$139 vss sg13_hv_nmos L=1U W=8U AS=1.52P AD=1.52P PS=8.38U
+ PD=8.38U rfmode=0
M$66 \$139 \$140 \$143 vss sg13_hv_nmos L=1U W=8U AS=1.52P AD=2.72P PS=8.38U
+ PD=16.68U rfmode=0
M$67 \$144 \$140 \$141 vss sg13_hv_nmos L=1U W=8U AS=2.72P AD=1.52P PS=16.68U
+ PD=8.38U rfmode=0
M$68 \$141 \$140 \$144 vss sg13_hv_nmos L=1U W=8U AS=1.52P AD=1.52P PS=8.38U
+ PD=8.38U rfmode=0
M$69 \$144 \$140 \$141 vss sg13_hv_nmos L=1U W=8U AS=1.52P AD=1.52P PS=8.38U
+ PD=8.38U rfmode=0
M$70 \$141 \$140 \$144 vss sg13_hv_nmos L=1U W=8U AS=1.52P AD=1.52P PS=8.38U
+ PD=8.38U rfmode=0
M$71 \$144 \$140 \$141 vss sg13_hv_nmos L=1U W=8U AS=1.52P AD=1.52P PS=8.38U
+ PD=8.38U rfmode=0
M$72 \$141 \$140 \$144 vss sg13_hv_nmos L=1U W=8U AS=1.52P AD=2.72P PS=8.38U
+ PD=16.68U rfmode=0
M$73 \$141 iptat|vbn vss vss sg13_hv_nmos L=1U W=8U AS=2.72P AD=1.52P PS=16.68U
+ PD=8.38U rfmode=0
M$74 vss iptat|vbn \$141 vss sg13_hv_nmos L=1U W=8U AS=1.52P AD=1.52P PS=8.38U
+ PD=8.38U rfmode=0
M$75 \$141 iptat|vbn vss vss sg13_hv_nmos L=1U W=8U AS=1.52P AD=1.52P PS=8.38U
+ PD=8.38U rfmode=0
M$76 vss iptat|vbn \$141 vss sg13_hv_nmos L=1U W=8U AS=1.52P AD=1.52P PS=8.38U
+ PD=8.38U rfmode=0
M$77 \$141 iptat|vbn vss vss sg13_hv_nmos L=1U W=8U AS=1.52P AD=1.52P PS=8.38U
+ PD=8.38U rfmode=0
M$78 vss iptat|vbn \$141 vss sg13_hv_nmos L=1U W=8U AS=1.52P AD=1.52P PS=8.38U
+ PD=8.38U rfmode=0
M$79 \$141 iptat|vbn vss vss sg13_hv_nmos L=1U W=8U AS=1.52P AD=1.52P PS=8.38U
+ PD=8.38U rfmode=0
M$80 vss iptat|vbn \$141 vss sg13_hv_nmos L=1U W=8U AS=1.52P AD=1.52P PS=8.38U
+ PD=8.38U rfmode=0
M$81 \$141 iptat|vbn vss vss sg13_hv_nmos L=1U W=8U AS=1.52P AD=1.52P PS=8.38U
+ PD=8.38U rfmode=0
M$82 vss iptat|vbn \$141 vss sg13_hv_nmos L=1U W=8U AS=1.52P AD=2.72P PS=8.38U
+ PD=16.68U rfmode=0
M$83 inn|out|vped iptat|vbn vss vss sg13_hv_nmos L=1U W=8U AS=2.72P AD=1.52P
+ PS=16.68U PD=8.38U rfmode=0
M$84 vss iptat|vbn inn|out|vped vss sg13_hv_nmos L=1U W=8U AS=1.52P AD=1.52P
+ PS=8.38U PD=8.38U rfmode=0
M$85 inn|out|vped iptat|vbn vss vss sg13_hv_nmos L=1U W=8U AS=1.52P AD=1.52P
+ PS=8.38U PD=8.38U rfmode=0
M$86 vss iptat|vbn inn|out|vped vss sg13_hv_nmos L=1U W=8U AS=1.52P AD=1.52P
+ PS=8.38U PD=8.38U rfmode=0
M$87 inn|out|vped iptat|vbn vss vss sg13_hv_nmos L=1U W=8U AS=1.52P AD=1.52P
+ PS=8.38U PD=8.38U rfmode=0
M$88 vss iptat|vbn inn|out|vped vss sg13_hv_nmos L=1U W=8U AS=1.52P AD=1.52P
+ PS=8.38U PD=8.38U rfmode=0
M$89 inn|out|vped iptat|vbn vss vss sg13_hv_nmos L=1U W=8U AS=1.52P AD=1.52P
+ PS=8.38U PD=8.38U rfmode=0
M$90 vss iptat|vbn inn|out|vped vss sg13_hv_nmos L=1U W=8U AS=1.52P AD=1.52P
+ PS=8.38U PD=8.38U rfmode=0
M$91 inn|out|vped iptat|vbn vss vss sg13_hv_nmos L=1U W=8U AS=1.52P AD=1.52P
+ PS=8.38U PD=8.38U rfmode=0
M$92 vss iptat|vbn inn|out|vped vss sg13_hv_nmos L=1U W=8U AS=1.52P AD=1.52P
+ PS=8.38U PD=8.38U rfmode=0
M$93 inn|out|vped iptat|vbn vss vss sg13_hv_nmos L=1U W=8U AS=1.52P AD=1.52P
+ PS=8.38U PD=8.38U rfmode=0
M$94 vss iptat|vbn inn|out|vped vss sg13_hv_nmos L=1U W=8U AS=1.52P AD=2.72P
+ PS=8.38U PD=16.68U rfmode=0
M$95 iptat|vbn iptat|vbn vss vss sg13_hv_nmos L=1U W=3.3U AS=1.122P AD=1.122P
+ PS=7.28U PD=7.28U rfmode=0
M$96 \$246 \$246 vss vss sg13_hv_nmos L=1U W=1.6U AS=0.544P AD=0.544P PS=3.88U
+ PD=3.88U rfmode=0
M$97 \$244 iptat|vbn vss vss sg13_hv_nmos L=1U W=8U AS=2.72P AD=2.72P PS=16.68U
+ PD=16.68U rfmode=0
M$98 \$243 iptat|vbn vss vss sg13_hv_nmos L=1U W=8U AS=2.72P AD=2.72P PS=16.68U
+ PD=16.68U rfmode=0
M$99 \$245 iptat|vbn vss vss sg13_hv_nmos L=1U W=8U AS=2.72P AD=1.52P PS=16.68U
+ PD=8.38U rfmode=0
M$100 vss iptat|vbn \$245 vss sg13_hv_nmos L=1U W=8U AS=1.52P AD=1.52P PS=8.38U
+ PD=8.38U rfmode=0
M$101 \$245 iptat|vbn vss vss sg13_hv_nmos L=1U W=8U AS=1.52P AD=1.52P PS=8.38U
+ PD=8.38U rfmode=0
M$102 vss iptat|vbn \$245 vss sg13_hv_nmos L=1U W=8U AS=1.52P AD=1.52P PS=8.38U
+ PD=8.38U rfmode=0
M$103 \$245 iptat|vbn vss vss sg13_hv_nmos L=1U W=8U AS=1.52P AD=1.52P PS=8.38U
+ PD=8.38U rfmode=0
M$104 vss iptat|vbn \$245 vss sg13_hv_nmos L=1U W=8U AS=1.52P AD=1.52P PS=8.38U
+ PD=8.38U rfmode=0
M$105 \$245 iptat|vbn vss vss sg13_hv_nmos L=1U W=8U AS=1.52P AD=1.52P PS=8.38U
+ PD=8.38U rfmode=0
M$106 vss iptat|vbn \$245 vss sg13_hv_nmos L=1U W=8U AS=1.52P AD=1.52P PS=8.38U
+ PD=8.38U rfmode=0
M$107 \$245 iptat|vbn vss vss sg13_hv_nmos L=1U W=8U AS=1.52P AD=1.52P PS=8.38U
+ PD=8.38U rfmode=0
M$108 vss iptat|vbn \$245 vss sg13_hv_nmos L=1U W=8U AS=1.52P AD=2.72P PS=8.38U
+ PD=16.68U rfmode=0
M$109 \$249 \$246 \$245 vss sg13_hv_nmos L=1U W=8U AS=2.72P AD=1.52P PS=16.68U
+ PD=8.38U rfmode=0
M$110 \$245 \$246 \$249 vss sg13_hv_nmos L=1U W=8U AS=1.52P AD=1.52P PS=8.38U
+ PD=8.38U rfmode=0
M$111 \$249 \$246 \$245 vss sg13_hv_nmos L=1U W=8U AS=1.52P AD=1.52P PS=8.38U
+ PD=8.38U rfmode=0
M$112 \$245 \$246 \$249 vss sg13_hv_nmos L=1U W=8U AS=1.52P AD=1.52P PS=8.38U
+ PD=8.38U rfmode=0
M$113 \$249 \$246 \$245 vss sg13_hv_nmos L=1U W=8U AS=1.52P AD=1.52P PS=8.38U
+ PD=8.38U rfmode=0
M$114 \$245 \$246 \$249 vss sg13_hv_nmos L=1U W=8U AS=1.52P AD=2.72P PS=8.38U
+ PD=16.68U rfmode=0
M$115 \$250 \$246 \$247 vss sg13_hv_nmos L=1U W=8U AS=2.72P AD=1.52P PS=16.68U
+ PD=8.38U rfmode=0
M$116 \$247 \$246 \$250 vss sg13_hv_nmos L=1U W=8U AS=1.52P AD=1.52P PS=8.38U
+ PD=8.38U rfmode=0
M$117 \$250 \$246 \$247 vss sg13_hv_nmos L=1U W=8U AS=1.52P AD=1.52P PS=8.38U
+ PD=8.38U rfmode=0
M$118 \$247 \$246 \$250 vss sg13_hv_nmos L=1U W=8U AS=1.52P AD=1.52P PS=8.38U
+ PD=8.38U rfmode=0
M$119 \$250 \$246 \$247 vss sg13_hv_nmos L=1U W=8U AS=1.52P AD=1.52P PS=8.38U
+ PD=8.38U rfmode=0
M$120 \$247 \$246 \$250 vss sg13_hv_nmos L=1U W=8U AS=1.52P AD=2.72P PS=8.38U
+ PD=16.68U rfmode=0
M$121 \$247 iptat|vbn vss vss sg13_hv_nmos L=1U W=8U AS=2.72P AD=1.52P
+ PS=16.68U PD=8.38U rfmode=0
M$122 vss iptat|vbn \$247 vss sg13_hv_nmos L=1U W=8U AS=1.52P AD=1.52P PS=8.38U
+ PD=8.38U rfmode=0
M$123 \$247 iptat|vbn vss vss sg13_hv_nmos L=1U W=8U AS=1.52P AD=1.52P PS=8.38U
+ PD=8.38U rfmode=0
M$124 vss iptat|vbn \$247 vss sg13_hv_nmos L=1U W=8U AS=1.52P AD=1.52P PS=8.38U
+ PD=8.38U rfmode=0
M$125 \$247 iptat|vbn vss vss sg13_hv_nmos L=1U W=8U AS=1.52P AD=1.52P PS=8.38U
+ PD=8.38U rfmode=0
M$126 vss iptat|vbn \$247 vss sg13_hv_nmos L=1U W=8U AS=1.52P AD=1.52P PS=8.38U
+ PD=8.38U rfmode=0
M$127 \$247 iptat|vbn vss vss sg13_hv_nmos L=1U W=8U AS=1.52P AD=1.52P PS=8.38U
+ PD=8.38U rfmode=0
M$128 vss iptat|vbn \$247 vss sg13_hv_nmos L=1U W=8U AS=1.52P AD=1.52P PS=8.38U
+ PD=8.38U rfmode=0
M$129 \$247 iptat|vbn vss vss sg13_hv_nmos L=1U W=8U AS=1.52P AD=1.52P PS=8.38U
+ PD=8.38U rfmode=0
M$130 vss iptat|vbn \$247 vss sg13_hv_nmos L=1U W=8U AS=1.52P AD=2.72P PS=8.38U
+ PD=16.68U rfmode=0
M$131 inn|out|vref_buf iptat|vbn vss vss sg13_hv_nmos L=1U W=8U AS=2.72P
+ AD=1.52P PS=16.68U PD=8.38U rfmode=0
M$132 vss iptat|vbn inn|out|vref_buf vss sg13_hv_nmos L=1U W=8U AS=1.52P
+ AD=1.52P PS=8.38U PD=8.38U rfmode=0
M$133 inn|out|vref_buf iptat|vbn vss vss sg13_hv_nmos L=1U W=8U AS=1.52P
+ AD=1.52P PS=8.38U PD=8.38U rfmode=0
M$134 vss iptat|vbn inn|out|vref_buf vss sg13_hv_nmos L=1U W=8U AS=1.52P
+ AD=1.52P PS=8.38U PD=8.38U rfmode=0
M$135 inn|out|vref_buf iptat|vbn vss vss sg13_hv_nmos L=1U W=8U AS=1.52P
+ AD=1.52P PS=8.38U PD=8.38U rfmode=0
M$136 vss iptat|vbn inn|out|vref_buf vss sg13_hv_nmos L=1U W=8U AS=1.52P
+ AD=1.52P PS=8.38U PD=8.38U rfmode=0
M$137 inn|out|vref_buf iptat|vbn vss vss sg13_hv_nmos L=1U W=8U AS=1.52P
+ AD=1.52P PS=8.38U PD=8.38U rfmode=0
M$138 vss iptat|vbn inn|out|vref_buf vss sg13_hv_nmos L=1U W=8U AS=1.52P
+ AD=1.52P PS=8.38U PD=8.38U rfmode=0
M$139 inn|out|vref_buf iptat|vbn vss vss sg13_hv_nmos L=1U W=8U AS=1.52P
+ AD=1.52P PS=8.38U PD=8.38U rfmode=0
M$140 vss iptat|vbn inn|out|vref_buf vss sg13_hv_nmos L=1U W=8U AS=1.52P
+ AD=1.52P PS=8.38U PD=8.38U rfmode=0
M$141 inn|out|vref_buf iptat|vbn vss vss sg13_hv_nmos L=1U W=8U AS=1.52P
+ AD=1.52P PS=8.38U PD=8.38U rfmode=0
M$142 vss iptat|vbn inn|out|vref_buf vss sg13_hv_nmos L=1U W=8U AS=1.52P
+ AD=2.72P PS=8.38U PD=16.68U rfmode=0
M$143 \$57 \$34 vdd vdd sg13_hv_pmos L=1U W=8U AS=2.72P AD=1.52P PS=16.68U
+ PD=8.38U rfmode=0
M$144 vdd \$34 \$57 vdd sg13_hv_pmos L=1U W=8U AS=1.52P AD=1.52P PS=8.38U
+ PD=8.38U rfmode=0
M$145 \$57 \$34 vdd vdd sg13_hv_pmos L=1U W=8U AS=1.52P AD=1.52P PS=8.38U
+ PD=8.38U rfmode=0
M$146 vdd \$34 \$57 vdd sg13_hv_pmos L=1U W=8U AS=1.52P AD=1.52P PS=8.38U
+ PD=8.38U rfmode=0
M$147 \$57 \$34 vdd vdd sg13_hv_pmos L=1U W=8U AS=1.52P AD=1.52P PS=8.38U
+ PD=8.38U rfmode=0
M$148 vdd \$34 \$57 vdd sg13_hv_pmos L=1U W=8U AS=1.52P AD=1.52P PS=8.38U
+ PD=8.38U rfmode=0
M$149 \$57 \$34 vdd vdd sg13_hv_pmos L=1U W=8U AS=1.52P AD=1.52P PS=8.38U
+ PD=8.38U rfmode=0
M$150 vdd \$34 \$57 vdd sg13_hv_pmos L=1U W=8U AS=1.52P AD=1.52P PS=8.38U
+ PD=8.38U rfmode=0
M$151 \$57 \$34 vdd vdd sg13_hv_pmos L=1U W=8U AS=1.52P AD=1.52P PS=8.38U
+ PD=8.38U rfmode=0
M$152 vdd \$34 \$57 vdd sg13_hv_pmos L=1U W=8U AS=1.52P AD=1.52P PS=8.38U
+ PD=8.38U rfmode=0
M$153 \$57 \$34 vdd vdd sg13_hv_pmos L=1U W=8U AS=1.52P AD=1.52P PS=8.38U
+ PD=8.38U rfmode=0
M$154 vdd \$34 \$57 vdd sg13_hv_pmos L=1U W=8U AS=1.52P AD=2.72P PS=8.38U
+ PD=16.68U rfmode=0
M$155 \$34 \$2 \$57 vdd sg13_hv_pmos L=1U W=8U AS=2.72P AD=1.52P PS=16.68U
+ PD=8.38U rfmode=0
M$156 \$57 \$2 \$34 vdd sg13_hv_pmos L=1U W=8U AS=1.52P AD=1.52P PS=8.38U
+ PD=8.38U rfmode=0
M$157 \$34 \$2 \$57 vdd sg13_hv_pmos L=1U W=8U AS=1.52P AD=1.52P PS=8.38U
+ PD=8.38U rfmode=0
M$158 \$57 \$2 \$34 vdd sg13_hv_pmos L=1U W=8U AS=1.52P AD=1.52P PS=8.38U
+ PD=8.38U rfmode=0
M$159 \$34 \$2 \$57 vdd sg13_hv_pmos L=1U W=8U AS=1.52P AD=1.52P PS=8.38U
+ PD=8.38U rfmode=0
M$160 \$57 \$2 \$34 vdd sg13_hv_pmos L=1U W=8U AS=1.52P AD=1.52P PS=8.38U
+ PD=8.38U rfmode=0
M$161 \$34 \$2 \$57 vdd sg13_hv_pmos L=1U W=8U AS=1.52P AD=1.52P PS=8.38U
+ PD=8.38U rfmode=0
M$162 \$57 \$2 \$34 vdd sg13_hv_pmos L=1U W=8U AS=1.52P AD=1.52P PS=8.38U
+ PD=8.38U rfmode=0
M$163 \$34 \$2 \$57 vdd sg13_hv_pmos L=1U W=8U AS=1.52P AD=1.52P PS=8.38U
+ PD=8.38U rfmode=0
M$164 \$57 \$2 \$34 vdd sg13_hv_pmos L=1U W=8U AS=1.52P AD=1.52P PS=8.38U
+ PD=8.38U rfmode=0
M$165 \$34 \$2 \$57 vdd sg13_hv_pmos L=1U W=8U AS=1.52P AD=1.52P PS=8.38U
+ PD=8.38U rfmode=0
M$166 \$57 \$2 \$34 vdd sg13_hv_pmos L=1U W=8U AS=1.52P AD=2.72P PS=8.38U
+ PD=16.68U rfmode=0
M$167 \$35 \$2 \$58 vdd sg13_hv_pmos L=1U W=8U AS=2.72P AD=1.52P PS=16.68U
+ PD=8.38U rfmode=0
M$168 \$58 \$2 \$35 vdd sg13_hv_pmos L=1U W=8U AS=1.52P AD=1.52P PS=8.38U
+ PD=8.38U rfmode=0
M$169 \$35 \$2 \$58 vdd sg13_hv_pmos L=1U W=8U AS=1.52P AD=1.52P PS=8.38U
+ PD=8.38U rfmode=0
M$170 \$58 \$2 \$35 vdd sg13_hv_pmos L=1U W=8U AS=1.52P AD=1.52P PS=8.38U
+ PD=8.38U rfmode=0
M$171 \$35 \$2 \$58 vdd sg13_hv_pmos L=1U W=8U AS=1.52P AD=1.52P PS=8.38U
+ PD=8.38U rfmode=0
M$172 \$58 \$2 \$35 vdd sg13_hv_pmos L=1U W=8U AS=1.52P AD=1.52P PS=8.38U
+ PD=8.38U rfmode=0
M$173 \$35 \$2 \$58 vdd sg13_hv_pmos L=1U W=8U AS=1.52P AD=1.52P PS=8.38U
+ PD=8.38U rfmode=0
M$174 \$58 \$2 \$35 vdd sg13_hv_pmos L=1U W=8U AS=1.52P AD=1.52P PS=8.38U
+ PD=8.38U rfmode=0
M$175 \$35 \$2 \$58 vdd sg13_hv_pmos L=1U W=8U AS=1.52P AD=1.52P PS=8.38U
+ PD=8.38U rfmode=0
M$176 \$58 \$2 \$35 vdd sg13_hv_pmos L=1U W=8U AS=1.52P AD=1.52P PS=8.38U
+ PD=8.38U rfmode=0
M$177 \$35 \$2 \$58 vdd sg13_hv_pmos L=1U W=8U AS=1.52P AD=1.52P PS=8.38U
+ PD=8.38U rfmode=0
M$178 \$58 \$2 \$35 vdd sg13_hv_pmos L=1U W=8U AS=1.52P AD=2.72P PS=8.38U
+ PD=16.68U rfmode=0
M$179 \$58 \$34 vdd vdd sg13_hv_pmos L=1U W=8U AS=2.72P AD=1.52P PS=16.68U
+ PD=8.38U rfmode=0
M$180 vdd \$34 \$58 vdd sg13_hv_pmos L=1U W=8U AS=1.52P AD=1.52P PS=8.38U
+ PD=8.38U rfmode=0
M$181 \$58 \$34 vdd vdd sg13_hv_pmos L=1U W=8U AS=1.52P AD=1.52P PS=8.38U
+ PD=8.38U rfmode=0
M$182 vdd \$34 \$58 vdd sg13_hv_pmos L=1U W=8U AS=1.52P AD=1.52P PS=8.38U
+ PD=8.38U rfmode=0
M$183 \$58 \$34 vdd vdd sg13_hv_pmos L=1U W=8U AS=1.52P AD=1.52P PS=8.38U
+ PD=8.38U rfmode=0
M$184 vdd \$34 \$58 vdd sg13_hv_pmos L=1U W=8U AS=1.52P AD=1.52P PS=8.38U
+ PD=8.38U rfmode=0
M$185 \$58 \$34 vdd vdd sg13_hv_pmos L=1U W=8U AS=1.52P AD=1.52P PS=8.38U
+ PD=8.38U rfmode=0
M$186 vdd \$34 \$58 vdd sg13_hv_pmos L=1U W=8U AS=1.52P AD=1.52P PS=8.38U
+ PD=8.38U rfmode=0
M$187 \$58 \$34 vdd vdd sg13_hv_pmos L=1U W=8U AS=1.52P AD=1.52P PS=8.38U
+ PD=8.38U rfmode=0
M$188 vdd \$34 \$58 vdd sg13_hv_pmos L=1U W=8U AS=1.52P AD=1.52P PS=8.38U
+ PD=8.38U rfmode=0
M$189 \$58 \$34 vdd vdd sg13_hv_pmos L=1U W=8U AS=1.52P AD=1.52P PS=8.38U
+ PD=8.38U rfmode=0
M$190 vdd \$34 \$58 vdd sg13_hv_pmos L=1U W=8U AS=1.52P AD=2.72P PS=8.38U
+ PD=16.68U rfmode=0
M$191 \$5 inn \$68 vdd sg13_hv_pmos L=2U W=6U AS=2.04P AD=1.14P PS=12.68U
+ PD=6.38U rfmode=0
M$192 \$68 inn \$5 vdd sg13_hv_pmos L=2U W=6U AS=1.14P AD=1.14P PS=6.38U
+ PD=6.38U rfmode=0
M$193 \$6 inp \$68 vdd sg13_hv_pmos L=2U W=6U AS=1.14P AD=1.14P PS=6.38U
+ PD=6.38U rfmode=0
M$194 \$68 inp \$6 vdd sg13_hv_pmos L=2U W=6U AS=1.14P AD=1.14P PS=6.38U
+ PD=6.38U rfmode=0
M$195 \$6 inp \$68 vdd sg13_hv_pmos L=2U W=6U AS=1.14P AD=1.14P PS=6.38U
+ PD=6.38U rfmode=0
M$196 \$68 inp \$6 vdd sg13_hv_pmos L=2U W=6U AS=1.14P AD=1.14P PS=6.38U
+ PD=6.38U rfmode=0
M$197 \$5 inn \$68 vdd sg13_hv_pmos L=2U W=6U AS=1.14P AD=1.14P PS=6.38U
+ PD=6.38U rfmode=0
M$198 \$68 inn \$5 vdd sg13_hv_pmos L=2U W=6U AS=1.14P AD=1.14P PS=6.38U
+ PD=6.38U rfmode=0
M$199 \$5 inn \$68 vdd sg13_hv_pmos L=2U W=6U AS=1.14P AD=1.14P PS=6.38U
+ PD=6.38U rfmode=0
M$200 \$68 inn \$5 vdd sg13_hv_pmos L=2U W=6U AS=1.14P AD=1.14P PS=6.38U
+ PD=6.38U rfmode=0
M$201 \$6 inp \$68 vdd sg13_hv_pmos L=2U W=6U AS=1.14P AD=1.14P PS=6.38U
+ PD=6.38U rfmode=0
M$202 \$68 inp \$6 vdd sg13_hv_pmos L=2U W=6U AS=1.14P AD=1.14P PS=6.38U
+ PD=6.38U rfmode=0
M$203 \$6 inp \$68 vdd sg13_hv_pmos L=2U W=6U AS=1.14P AD=1.14P PS=6.38U
+ PD=6.38U rfmode=0
M$204 \$68 inp \$6 vdd sg13_hv_pmos L=2U W=6U AS=1.14P AD=1.14P PS=6.38U
+ PD=6.38U rfmode=0
M$205 \$5 inn \$68 vdd sg13_hv_pmos L=2U W=6U AS=1.14P AD=1.14P PS=6.38U
+ PD=6.38U rfmode=0
M$206 \$68 inn \$5 vdd sg13_hv_pmos L=2U W=6U AS=1.14P AD=1.14P PS=6.38U
+ PD=6.38U rfmode=0
M$207 \$5 inn \$68 vdd sg13_hv_pmos L=2U W=6U AS=1.14P AD=1.14P PS=6.38U
+ PD=6.38U rfmode=0
M$208 \$68 inn \$5 vdd sg13_hv_pmos L=2U W=6U AS=1.14P AD=1.14P PS=6.38U
+ PD=6.38U rfmode=0
M$209 \$6 inp \$68 vdd sg13_hv_pmos L=2U W=6U AS=1.14P AD=1.14P PS=6.38U
+ PD=6.38U rfmode=0
M$210 \$68 inp \$6 vdd sg13_hv_pmos L=2U W=6U AS=1.14P AD=1.14P PS=6.38U
+ PD=6.38U rfmode=0
M$211 \$6 inp \$68 vdd sg13_hv_pmos L=2U W=6U AS=1.14P AD=1.14P PS=6.38U
+ PD=6.38U rfmode=0
M$212 \$68 inp \$6 vdd sg13_hv_pmos L=2U W=6U AS=1.14P AD=1.14P PS=6.38U
+ PD=6.38U rfmode=0
M$213 \$5 inn \$68 vdd sg13_hv_pmos L=2U W=6U AS=1.14P AD=1.14P PS=6.38U
+ PD=6.38U rfmode=0
M$214 \$68 inn \$5 vdd sg13_hv_pmos L=2U W=6U AS=1.14P AD=1.14P PS=6.38U
+ PD=6.38U rfmode=0
M$215 \$5 inn \$68 vdd sg13_hv_pmos L=2U W=6U AS=1.14P AD=1.14P PS=6.38U
+ PD=6.38U rfmode=0
M$216 \$68 inn \$5 vdd sg13_hv_pmos L=2U W=6U AS=1.14P AD=1.14P PS=6.38U
+ PD=6.38U rfmode=0
M$217 \$6 inp \$68 vdd sg13_hv_pmos L=2U W=6U AS=1.14P AD=1.14P PS=6.38U
+ PD=6.38U rfmode=0
M$218 \$68 inp \$6 vdd sg13_hv_pmos L=2U W=6U AS=1.14P AD=1.14P PS=6.38U
+ PD=6.38U rfmode=0
M$219 \$6 inp \$68 vdd sg13_hv_pmos L=2U W=6U AS=1.14P AD=1.14P PS=6.38U
+ PD=6.38U rfmode=0
M$220 \$68 inp \$6 vdd sg13_hv_pmos L=2U W=6U AS=1.14P AD=1.14P PS=6.38U
+ PD=6.38U rfmode=0
M$221 \$5 inn \$68 vdd sg13_hv_pmos L=2U W=6U AS=1.14P AD=1.14P PS=6.38U
+ PD=6.38U rfmode=0
M$222 \$68 inn \$5 vdd sg13_hv_pmos L=2U W=6U AS=1.14P AD=2.04P PS=6.38U
+ PD=12.68U rfmode=0
M$223 \$2 \$2 vdd vdd sg13_hv_pmos L=1U W=3.2U AS=1.088P AD=1.088P PS=7.08U
+ PD=7.08U rfmode=0
M$224 \$4 \$3 vdd vdd sg13_hv_pmos L=1U W=8U AS=2.72P AD=1.52P PS=16.68U
+ PD=8.38U rfmode=0
M$225 vdd \$3 \$4 vdd sg13_hv_pmos L=1U W=8U AS=1.52P AD=2.72P PS=8.38U
+ PD=16.68U rfmode=0
M$226 \$3 \$3 vdd vdd sg13_hv_pmos L=1U W=8U AS=2.72P AD=1.52P PS=16.68U
+ PD=8.38U rfmode=0
M$227 vdd \$3 \$3 vdd sg13_hv_pmos L=1U W=8U AS=1.52P AD=2.72P PS=8.38U
+ PD=16.68U rfmode=0
M$228 \$68 \$3 vdd vdd sg13_hv_pmos L=1U W=8U AS=2.72P AD=1.52P PS=16.68U
+ PD=8.38U rfmode=0
M$229 vdd \$3 \$68 vdd sg13_hv_pmos L=1U W=8U AS=1.52P AD=1.52P PS=8.38U
+ PD=8.38U rfmode=0
M$230 \$68 \$3 vdd vdd sg13_hv_pmos L=1U W=8U AS=1.52P AD=1.52P PS=8.38U
+ PD=8.38U rfmode=0
M$231 vdd \$3 \$68 vdd sg13_hv_pmos L=1U W=8U AS=1.52P AD=1.52P PS=8.38U
+ PD=8.38U rfmode=0
M$232 \$68 \$3 vdd vdd sg13_hv_pmos L=1U W=8U AS=1.52P AD=1.52P PS=8.38U
+ PD=8.38U rfmode=0
M$233 vdd \$3 \$68 vdd sg13_hv_pmos L=1U W=8U AS=1.52P AD=1.52P PS=8.38U
+ PD=8.38U rfmode=0
M$234 \$68 \$3 vdd vdd sg13_hv_pmos L=1U W=8U AS=1.52P AD=1.52P PS=8.38U
+ PD=8.38U rfmode=0
M$235 vdd \$3 \$68 vdd sg13_hv_pmos L=1U W=8U AS=1.52P AD=1.52P PS=8.38U
+ PD=8.38U rfmode=0
M$236 \$68 \$3 vdd vdd sg13_hv_pmos L=1U W=8U AS=1.52P AD=1.52P PS=8.38U
+ PD=8.38U rfmode=0
M$237 vdd \$3 \$68 vdd sg13_hv_pmos L=1U W=8U AS=1.52P AD=1.52P PS=8.38U
+ PD=8.38U rfmode=0
M$238 \$68 \$3 vdd vdd sg13_hv_pmos L=1U W=8U AS=1.52P AD=1.52P PS=8.38U
+ PD=8.38U rfmode=0
M$239 vdd \$3 \$68 vdd sg13_hv_pmos L=1U W=8U AS=1.52P AD=1.52P PS=8.38U
+ PD=8.38U rfmode=0
M$240 \$68 \$3 vdd vdd sg13_hv_pmos L=1U W=8U AS=1.52P AD=1.52P PS=8.38U
+ PD=8.38U rfmode=0
M$241 vdd \$3 \$68 vdd sg13_hv_pmos L=1U W=8U AS=1.52P AD=1.52P PS=8.38U
+ PD=8.38U rfmode=0
M$242 \$68 \$3 vdd vdd sg13_hv_pmos L=1U W=8U AS=1.52P AD=1.52P PS=8.38U
+ PD=8.38U rfmode=0
M$243 vdd \$3 \$68 vdd sg13_hv_pmos L=1U W=8U AS=1.52P AD=2.72P PS=8.38U
+ PD=16.68U rfmode=0
M$244 isense|out \$35 vdd vdd sg13_hv_pmos L=1U W=8U AS=2.72P AD=1.52P
+ PS=16.68U PD=8.38U rfmode=0
M$245 vdd \$35 isense|out vdd sg13_hv_pmos L=1U W=8U AS=1.52P AD=1.52P PS=8.38U
+ PD=8.38U rfmode=0
M$246 isense|out \$35 vdd vdd sg13_hv_pmos L=1U W=8U AS=1.52P AD=1.52P PS=8.38U
+ PD=8.38U rfmode=0
M$247 vdd \$35 isense|out vdd sg13_hv_pmos L=1U W=8U AS=1.52P AD=1.52P PS=8.38U
+ PD=8.38U rfmode=0
M$248 isense|out \$35 vdd vdd sg13_hv_pmos L=1U W=8U AS=1.52P AD=1.52P PS=8.38U
+ PD=8.38U rfmode=0
M$249 vdd \$35 isense|out vdd sg13_hv_pmos L=1U W=8U AS=1.52P AD=1.52P PS=8.38U
+ PD=8.38U rfmode=0
M$250 isense|out \$35 vdd vdd sg13_hv_pmos L=1U W=8U AS=1.52P AD=1.52P PS=8.38U
+ PD=8.38U rfmode=0
M$251 vdd \$35 isense|out vdd sg13_hv_pmos L=1U W=8U AS=1.52P AD=1.52P PS=8.38U
+ PD=8.38U rfmode=0
M$252 isense|out \$35 vdd vdd sg13_hv_pmos L=1U W=8U AS=1.52P AD=1.52P PS=8.38U
+ PD=8.38U rfmode=0
M$253 vdd \$35 isense|out vdd sg13_hv_pmos L=1U W=8U AS=1.52P AD=1.52P PS=8.38U
+ PD=8.38U rfmode=0
M$254 isense|out \$35 vdd vdd sg13_hv_pmos L=1U W=8U AS=1.52P AD=1.52P PS=8.38U
+ PD=8.38U rfmode=0
M$255 vdd \$35 isense|out vdd sg13_hv_pmos L=1U W=8U AS=1.52P AD=1.52P PS=8.38U
+ PD=8.38U rfmode=0
M$256 isense|out \$35 vdd vdd sg13_hv_pmos L=1U W=8U AS=1.52P AD=1.52P PS=8.38U
+ PD=8.38U rfmode=0
M$257 vdd \$35 isense|out vdd sg13_hv_pmos L=1U W=8U AS=1.52P AD=1.52P PS=8.38U
+ PD=8.38U rfmode=0
M$258 isense|out \$35 vdd vdd sg13_hv_pmos L=1U W=8U AS=1.52P AD=1.52P PS=8.38U
+ PD=8.38U rfmode=0
M$259 vdd \$35 isense|out vdd sg13_hv_pmos L=1U W=8U AS=1.52P AD=1.52P PS=8.38U
+ PD=8.38U rfmode=0
M$260 isense|out \$35 vdd vdd sg13_hv_pmos L=1U W=8U AS=1.52P AD=1.52P PS=8.38U
+ PD=8.38U rfmode=0
M$261 vdd \$35 isense|out vdd sg13_hv_pmos L=1U W=8U AS=1.52P AD=1.52P PS=8.38U
+ PD=8.38U rfmode=0
M$262 isense|out \$35 vdd vdd sg13_hv_pmos L=1U W=8U AS=1.52P AD=1.52P PS=8.38U
+ PD=8.38U rfmode=0
M$263 vdd \$35 isense|out vdd sg13_hv_pmos L=1U W=8U AS=1.52P AD=1.52P PS=8.38U
+ PD=8.38U rfmode=0
M$264 isense|out \$35 vdd vdd sg13_hv_pmos L=1U W=8U AS=1.52P AD=1.52P PS=8.38U
+ PD=8.38U rfmode=0
M$265 vdd \$35 isense|out vdd sg13_hv_pmos L=1U W=8U AS=1.52P AD=1.52P PS=8.38U
+ PD=8.38U rfmode=0
M$266 isense|out \$35 vdd vdd sg13_hv_pmos L=1U W=8U AS=1.52P AD=1.52P PS=8.38U
+ PD=8.38U rfmode=0
M$267 vdd \$35 isense|out vdd sg13_hv_pmos L=1U W=8U AS=1.52P AD=2.72P PS=8.38U
+ PD=16.68U rfmode=0
M$268 \$162 \$143 vdd vdd sg13_hv_pmos L=1U W=8U AS=2.72P AD=1.52P PS=16.68U
+ PD=8.38U rfmode=0
M$269 vdd \$143 \$162 vdd sg13_hv_pmos L=1U W=8U AS=1.52P AD=1.52P PS=8.38U
+ PD=8.38U rfmode=0
M$270 \$162 \$143 vdd vdd sg13_hv_pmos L=1U W=8U AS=1.52P AD=1.52P PS=8.38U
+ PD=8.38U rfmode=0
M$271 vdd \$143 \$162 vdd sg13_hv_pmos L=1U W=8U AS=1.52P AD=1.52P PS=8.38U
+ PD=8.38U rfmode=0
M$272 \$162 \$143 vdd vdd sg13_hv_pmos L=1U W=8U AS=1.52P AD=1.52P PS=8.38U
+ PD=8.38U rfmode=0
M$273 vdd \$143 \$162 vdd sg13_hv_pmos L=1U W=8U AS=1.52P AD=1.52P PS=8.38U
+ PD=8.38U rfmode=0
M$274 \$162 \$143 vdd vdd sg13_hv_pmos L=1U W=8U AS=1.52P AD=1.52P PS=8.38U
+ PD=8.38U rfmode=0
M$275 vdd \$143 \$162 vdd sg13_hv_pmos L=1U W=8U AS=1.52P AD=1.52P PS=8.38U
+ PD=8.38U rfmode=0
M$276 \$162 \$143 vdd vdd sg13_hv_pmos L=1U W=8U AS=1.52P AD=1.52P PS=8.38U
+ PD=8.38U rfmode=0
M$277 vdd \$143 \$162 vdd sg13_hv_pmos L=1U W=8U AS=1.52P AD=1.52P PS=8.38U
+ PD=8.38U rfmode=0
M$278 \$162 \$143 vdd vdd sg13_hv_pmos L=1U W=8U AS=1.52P AD=1.52P PS=8.38U
+ PD=8.38U rfmode=0
M$279 vdd \$143 \$162 vdd sg13_hv_pmos L=1U W=8U AS=1.52P AD=2.72P PS=8.38U
+ PD=16.68U rfmode=0
M$280 \$143 \$137 \$162 vdd sg13_hv_pmos L=1U W=8U AS=2.72P AD=1.52P PS=16.68U
+ PD=8.38U rfmode=0
M$281 \$162 \$137 \$143 vdd sg13_hv_pmos L=1U W=8U AS=1.52P AD=1.52P PS=8.38U
+ PD=8.38U rfmode=0
M$282 \$143 \$137 \$162 vdd sg13_hv_pmos L=1U W=8U AS=1.52P AD=1.52P PS=8.38U
+ PD=8.38U rfmode=0
M$283 \$162 \$137 \$143 vdd sg13_hv_pmos L=1U W=8U AS=1.52P AD=1.52P PS=8.38U
+ PD=8.38U rfmode=0
M$284 \$143 \$137 \$162 vdd sg13_hv_pmos L=1U W=8U AS=1.52P AD=1.52P PS=8.38U
+ PD=8.38U rfmode=0
M$285 \$162 \$137 \$143 vdd sg13_hv_pmos L=1U W=8U AS=1.52P AD=1.52P PS=8.38U
+ PD=8.38U rfmode=0
M$286 \$143 \$137 \$162 vdd sg13_hv_pmos L=1U W=8U AS=1.52P AD=1.52P PS=8.38U
+ PD=8.38U rfmode=0
M$287 \$162 \$137 \$143 vdd sg13_hv_pmos L=1U W=8U AS=1.52P AD=1.52P PS=8.38U
+ PD=8.38U rfmode=0
M$288 \$143 \$137 \$162 vdd sg13_hv_pmos L=1U W=8U AS=1.52P AD=1.52P PS=8.38U
+ PD=8.38U rfmode=0
M$289 \$162 \$137 \$143 vdd sg13_hv_pmos L=1U W=8U AS=1.52P AD=1.52P PS=8.38U
+ PD=8.38U rfmode=0
M$290 \$143 \$137 \$162 vdd sg13_hv_pmos L=1U W=8U AS=1.52P AD=1.52P PS=8.38U
+ PD=8.38U rfmode=0
M$291 \$162 \$137 \$143 vdd sg13_hv_pmos L=1U W=8U AS=1.52P AD=2.72P PS=8.38U
+ PD=16.68U rfmode=0
M$292 \$144 \$137 \$163 vdd sg13_hv_pmos L=1U W=8U AS=2.72P AD=1.52P PS=16.68U
+ PD=8.38U rfmode=0
M$293 \$163 \$137 \$144 vdd sg13_hv_pmos L=1U W=8U AS=1.52P AD=1.52P PS=8.38U
+ PD=8.38U rfmode=0
M$294 \$144 \$137 \$163 vdd sg13_hv_pmos L=1U W=8U AS=1.52P AD=1.52P PS=8.38U
+ PD=8.38U rfmode=0
M$295 \$163 \$137 \$144 vdd sg13_hv_pmos L=1U W=8U AS=1.52P AD=1.52P PS=8.38U
+ PD=8.38U rfmode=0
M$296 \$144 \$137 \$163 vdd sg13_hv_pmos L=1U W=8U AS=1.52P AD=1.52P PS=8.38U
+ PD=8.38U rfmode=0
M$297 \$163 \$137 \$144 vdd sg13_hv_pmos L=1U W=8U AS=1.52P AD=1.52P PS=8.38U
+ PD=8.38U rfmode=0
M$298 \$144 \$137 \$163 vdd sg13_hv_pmos L=1U W=8U AS=1.52P AD=1.52P PS=8.38U
+ PD=8.38U rfmode=0
M$299 \$163 \$137 \$144 vdd sg13_hv_pmos L=1U W=8U AS=1.52P AD=1.52P PS=8.38U
+ PD=8.38U rfmode=0
M$300 \$144 \$137 \$163 vdd sg13_hv_pmos L=1U W=8U AS=1.52P AD=1.52P PS=8.38U
+ PD=8.38U rfmode=0
M$301 \$163 \$137 \$144 vdd sg13_hv_pmos L=1U W=8U AS=1.52P AD=1.52P PS=8.38U
+ PD=8.38U rfmode=0
M$302 \$144 \$137 \$163 vdd sg13_hv_pmos L=1U W=8U AS=1.52P AD=1.52P PS=8.38U
+ PD=8.38U rfmode=0
M$303 \$163 \$137 \$144 vdd sg13_hv_pmos L=1U W=8U AS=1.52P AD=2.72P PS=8.38U
+ PD=16.68U rfmode=0
M$304 \$163 \$143 vdd vdd sg13_hv_pmos L=1U W=8U AS=2.72P AD=1.52P PS=16.68U
+ PD=8.38U rfmode=0
M$305 vdd \$143 \$163 vdd sg13_hv_pmos L=1U W=8U AS=1.52P AD=1.52P PS=8.38U
+ PD=8.38U rfmode=0
M$306 \$163 \$143 vdd vdd sg13_hv_pmos L=1U W=8U AS=1.52P AD=1.52P PS=8.38U
+ PD=8.38U rfmode=0
M$307 vdd \$143 \$163 vdd sg13_hv_pmos L=1U W=8U AS=1.52P AD=1.52P PS=8.38U
+ PD=8.38U rfmode=0
M$308 \$163 \$143 vdd vdd sg13_hv_pmos L=1U W=8U AS=1.52P AD=1.52P PS=8.38U
+ PD=8.38U rfmode=0
M$309 vdd \$143 \$163 vdd sg13_hv_pmos L=1U W=8U AS=1.52P AD=1.52P PS=8.38U
+ PD=8.38U rfmode=0
M$310 \$163 \$143 vdd vdd sg13_hv_pmos L=1U W=8U AS=1.52P AD=1.52P PS=8.38U
+ PD=8.38U rfmode=0
M$311 vdd \$143 \$163 vdd sg13_hv_pmos L=1U W=8U AS=1.52P AD=1.52P PS=8.38U
+ PD=8.38U rfmode=0
M$312 \$163 \$143 vdd vdd sg13_hv_pmos L=1U W=8U AS=1.52P AD=1.52P PS=8.38U
+ PD=8.38U rfmode=0
M$313 vdd \$143 \$163 vdd sg13_hv_pmos L=1U W=8U AS=1.52P AD=1.52P PS=8.38U
+ PD=8.38U rfmode=0
M$314 \$163 \$143 vdd vdd sg13_hv_pmos L=1U W=8U AS=1.52P AD=1.52P PS=8.38U
+ PD=8.38U rfmode=0
M$315 vdd \$143 \$163 vdd sg13_hv_pmos L=1U W=8U AS=1.52P AD=2.72P PS=8.38U
+ PD=16.68U rfmode=0
M$316 \$139 inn|out|vped \$202 vdd sg13_hv_pmos L=2U W=6U AS=2.04P AD=1.14P
+ PS=12.68U PD=6.38U rfmode=0
M$317 \$202 inn|out|vped \$139 vdd sg13_hv_pmos L=2U W=6U AS=1.14P AD=1.14P
+ PS=6.38U PD=6.38U rfmode=0
M$318 \$141 inp$1 \$202 vdd sg13_hv_pmos L=2U W=6U AS=1.14P AD=1.14P PS=6.38U
+ PD=6.38U rfmode=0
M$319 \$202 inp$1 \$141 vdd sg13_hv_pmos L=2U W=6U AS=1.14P AD=1.14P PS=6.38U
+ PD=6.38U rfmode=0
M$320 \$141 inp$1 \$202 vdd sg13_hv_pmos L=2U W=6U AS=1.14P AD=1.14P PS=6.38U
+ PD=6.38U rfmode=0
M$321 \$202 inp$1 \$141 vdd sg13_hv_pmos L=2U W=6U AS=1.14P AD=1.14P PS=6.38U
+ PD=6.38U rfmode=0
M$322 \$139 inn|out|vped \$202 vdd sg13_hv_pmos L=2U W=6U AS=1.14P AD=1.14P
+ PS=6.38U PD=6.38U rfmode=0
M$323 \$202 inn|out|vped \$139 vdd sg13_hv_pmos L=2U W=6U AS=1.14P AD=1.14P
+ PS=6.38U PD=6.38U rfmode=0
M$324 \$139 inn|out|vped \$202 vdd sg13_hv_pmos L=2U W=6U AS=1.14P AD=1.14P
+ PS=6.38U PD=6.38U rfmode=0
M$325 \$202 inn|out|vped \$139 vdd sg13_hv_pmos L=2U W=6U AS=1.14P AD=1.14P
+ PS=6.38U PD=6.38U rfmode=0
M$326 \$141 inp$1 \$202 vdd sg13_hv_pmos L=2U W=6U AS=1.14P AD=1.14P PS=6.38U
+ PD=6.38U rfmode=0
M$327 \$202 inp$1 \$141 vdd sg13_hv_pmos L=2U W=6U AS=1.14P AD=1.14P PS=6.38U
+ PD=6.38U rfmode=0
M$328 \$141 inp$1 \$202 vdd sg13_hv_pmos L=2U W=6U AS=1.14P AD=1.14P PS=6.38U
+ PD=6.38U rfmode=0
M$329 \$202 inp$1 \$141 vdd sg13_hv_pmos L=2U W=6U AS=1.14P AD=1.14P PS=6.38U
+ PD=6.38U rfmode=0
M$330 \$139 inn|out|vped \$202 vdd sg13_hv_pmos L=2U W=6U AS=1.14P AD=1.14P
+ PS=6.38U PD=6.38U rfmode=0
M$331 \$202 inn|out|vped \$139 vdd sg13_hv_pmos L=2U W=6U AS=1.14P AD=1.14P
+ PS=6.38U PD=6.38U rfmode=0
M$332 \$139 inn|out|vped \$202 vdd sg13_hv_pmos L=2U W=6U AS=1.14P AD=1.14P
+ PS=6.38U PD=6.38U rfmode=0
M$333 \$202 inn|out|vped \$139 vdd sg13_hv_pmos L=2U W=6U AS=1.14P AD=1.14P
+ PS=6.38U PD=6.38U rfmode=0
M$334 \$141 inp$1 \$202 vdd sg13_hv_pmos L=2U W=6U AS=1.14P AD=1.14P PS=6.38U
+ PD=6.38U rfmode=0
M$335 \$202 inp$1 \$141 vdd sg13_hv_pmos L=2U W=6U AS=1.14P AD=1.14P PS=6.38U
+ PD=6.38U rfmode=0
M$336 \$141 inp$1 \$202 vdd sg13_hv_pmos L=2U W=6U AS=1.14P AD=1.14P PS=6.38U
+ PD=6.38U rfmode=0
M$337 \$202 inp$1 \$141 vdd sg13_hv_pmos L=2U W=6U AS=1.14P AD=1.14P PS=6.38U
+ PD=6.38U rfmode=0
M$338 \$139 inn|out|vped \$202 vdd sg13_hv_pmos L=2U W=6U AS=1.14P AD=1.14P
+ PS=6.38U PD=6.38U rfmode=0
M$339 \$202 inn|out|vped \$139 vdd sg13_hv_pmos L=2U W=6U AS=1.14P AD=1.14P
+ PS=6.38U PD=6.38U rfmode=0
M$340 \$139 inn|out|vped \$202 vdd sg13_hv_pmos L=2U W=6U AS=1.14P AD=1.14P
+ PS=6.38U PD=6.38U rfmode=0
M$341 \$202 inn|out|vped \$139 vdd sg13_hv_pmos L=2U W=6U AS=1.14P AD=1.14P
+ PS=6.38U PD=6.38U rfmode=0
M$342 \$141 inp$1 \$202 vdd sg13_hv_pmos L=2U W=6U AS=1.14P AD=1.14P PS=6.38U
+ PD=6.38U rfmode=0
M$343 \$202 inp$1 \$141 vdd sg13_hv_pmos L=2U W=6U AS=1.14P AD=1.14P PS=6.38U
+ PD=6.38U rfmode=0
M$344 \$141 inp$1 \$202 vdd sg13_hv_pmos L=2U W=6U AS=1.14P AD=1.14P PS=6.38U
+ PD=6.38U rfmode=0
M$345 \$202 inp$1 \$141 vdd sg13_hv_pmos L=2U W=6U AS=1.14P AD=1.14P PS=6.38U
+ PD=6.38U rfmode=0
M$346 \$139 inn|out|vped \$202 vdd sg13_hv_pmos L=2U W=6U AS=1.14P AD=1.14P
+ PS=6.38U PD=6.38U rfmode=0
M$347 \$202 inn|out|vped \$139 vdd sg13_hv_pmos L=2U W=6U AS=1.14P AD=2.04P
+ PS=6.38U PD=12.68U rfmode=0
M$348 \$137 \$137 vdd vdd sg13_hv_pmos L=1U W=3.2U AS=1.088P AD=1.088P PS=7.08U
+ PD=7.08U rfmode=0
M$349 \$140 \$138 vdd vdd sg13_hv_pmos L=1U W=8U AS=2.72P AD=1.52P PS=16.68U
+ PD=8.38U rfmode=0
M$350 vdd \$138 \$140 vdd sg13_hv_pmos L=1U W=8U AS=1.52P AD=2.72P PS=8.38U
+ PD=16.68U rfmode=0
M$351 \$138 \$138 vdd vdd sg13_hv_pmos L=1U W=8U AS=2.72P AD=1.52P PS=16.68U
+ PD=8.38U rfmode=0
M$352 vdd \$138 \$138 vdd sg13_hv_pmos L=1U W=8U AS=1.52P AD=2.72P PS=8.38U
+ PD=16.68U rfmode=0
M$353 \$202 \$138 vdd vdd sg13_hv_pmos L=1U W=8U AS=2.72P AD=1.52P PS=16.68U
+ PD=8.38U rfmode=0
M$354 vdd \$138 \$202 vdd sg13_hv_pmos L=1U W=8U AS=1.52P AD=1.52P PS=8.38U
+ PD=8.38U rfmode=0
M$355 \$202 \$138 vdd vdd sg13_hv_pmos L=1U W=8U AS=1.52P AD=1.52P PS=8.38U
+ PD=8.38U rfmode=0
M$356 vdd \$138 \$202 vdd sg13_hv_pmos L=1U W=8U AS=1.52P AD=1.52P PS=8.38U
+ PD=8.38U rfmode=0
M$357 \$202 \$138 vdd vdd sg13_hv_pmos L=1U W=8U AS=1.52P AD=1.52P PS=8.38U
+ PD=8.38U rfmode=0
M$358 vdd \$138 \$202 vdd sg13_hv_pmos L=1U W=8U AS=1.52P AD=1.52P PS=8.38U
+ PD=8.38U rfmode=0
M$359 \$202 \$138 vdd vdd sg13_hv_pmos L=1U W=8U AS=1.52P AD=1.52P PS=8.38U
+ PD=8.38U rfmode=0
M$360 vdd \$138 \$202 vdd sg13_hv_pmos L=1U W=8U AS=1.52P AD=1.52P PS=8.38U
+ PD=8.38U rfmode=0
M$361 \$202 \$138 vdd vdd sg13_hv_pmos L=1U W=8U AS=1.52P AD=1.52P PS=8.38U
+ PD=8.38U rfmode=0
M$362 vdd \$138 \$202 vdd sg13_hv_pmos L=1U W=8U AS=1.52P AD=1.52P PS=8.38U
+ PD=8.38U rfmode=0
M$363 \$202 \$138 vdd vdd sg13_hv_pmos L=1U W=8U AS=1.52P AD=1.52P PS=8.38U
+ PD=8.38U rfmode=0
M$364 vdd \$138 \$202 vdd sg13_hv_pmos L=1U W=8U AS=1.52P AD=1.52P PS=8.38U
+ PD=8.38U rfmode=0
M$365 \$202 \$138 vdd vdd sg13_hv_pmos L=1U W=8U AS=1.52P AD=1.52P PS=8.38U
+ PD=8.38U rfmode=0
M$366 vdd \$138 \$202 vdd sg13_hv_pmos L=1U W=8U AS=1.52P AD=1.52P PS=8.38U
+ PD=8.38U rfmode=0
M$367 \$202 \$138 vdd vdd sg13_hv_pmos L=1U W=8U AS=1.52P AD=1.52P PS=8.38U
+ PD=8.38U rfmode=0
M$368 vdd \$138 \$202 vdd sg13_hv_pmos L=1U W=8U AS=1.52P AD=2.72P PS=8.38U
+ PD=16.68U rfmode=0
M$369 inn|out|vped \$144 vdd vdd sg13_hv_pmos L=1U W=8U AS=2.72P AD=1.52P
+ PS=16.68U PD=8.38U rfmode=0
M$370 vdd \$144 inn|out|vped vdd sg13_hv_pmos L=1U W=8U AS=1.52P AD=1.52P
+ PS=8.38U PD=8.38U rfmode=0
M$371 inn|out|vped \$144 vdd vdd sg13_hv_pmos L=1U W=8U AS=1.52P AD=1.52P
+ PS=8.38U PD=8.38U rfmode=0
M$372 vdd \$144 inn|out|vped vdd sg13_hv_pmos L=1U W=8U AS=1.52P AD=1.52P
+ PS=8.38U PD=8.38U rfmode=0
M$373 inn|out|vped \$144 vdd vdd sg13_hv_pmos L=1U W=8U AS=1.52P AD=1.52P
+ PS=8.38U PD=8.38U rfmode=0
M$374 vdd \$144 inn|out|vped vdd sg13_hv_pmos L=1U W=8U AS=1.52P AD=1.52P
+ PS=8.38U PD=8.38U rfmode=0
M$375 inn|out|vped \$144 vdd vdd sg13_hv_pmos L=1U W=8U AS=1.52P AD=1.52P
+ PS=8.38U PD=8.38U rfmode=0
M$376 vdd \$144 inn|out|vped vdd sg13_hv_pmos L=1U W=8U AS=1.52P AD=1.52P
+ PS=8.38U PD=8.38U rfmode=0
M$377 inn|out|vped \$144 vdd vdd sg13_hv_pmos L=1U W=8U AS=1.52P AD=1.52P
+ PS=8.38U PD=8.38U rfmode=0
M$378 vdd \$144 inn|out|vped vdd sg13_hv_pmos L=1U W=8U AS=1.52P AD=1.52P
+ PS=8.38U PD=8.38U rfmode=0
M$379 inn|out|vped \$144 vdd vdd sg13_hv_pmos L=1U W=8U AS=1.52P AD=1.52P
+ PS=8.38U PD=8.38U rfmode=0
M$380 vdd \$144 inn|out|vped vdd sg13_hv_pmos L=1U W=8U AS=1.52P AD=1.52P
+ PS=8.38U PD=8.38U rfmode=0
M$381 inn|out|vped \$144 vdd vdd sg13_hv_pmos L=1U W=8U AS=1.52P AD=1.52P
+ PS=8.38U PD=8.38U rfmode=0
M$382 vdd \$144 inn|out|vped vdd sg13_hv_pmos L=1U W=8U AS=1.52P AD=1.52P
+ PS=8.38U PD=8.38U rfmode=0
M$383 inn|out|vped \$144 vdd vdd sg13_hv_pmos L=1U W=8U AS=1.52P AD=1.52P
+ PS=8.38U PD=8.38U rfmode=0
M$384 vdd \$144 inn|out|vped vdd sg13_hv_pmos L=1U W=8U AS=1.52P AD=1.52P
+ PS=8.38U PD=8.38U rfmode=0
M$385 inn|out|vped \$144 vdd vdd sg13_hv_pmos L=1U W=8U AS=1.52P AD=1.52P
+ PS=8.38U PD=8.38U rfmode=0
M$386 vdd \$144 inn|out|vped vdd sg13_hv_pmos L=1U W=8U AS=1.52P AD=1.52P
+ PS=8.38U PD=8.38U rfmode=0
M$387 inn|out|vped \$144 vdd vdd sg13_hv_pmos L=1U W=8U AS=1.52P AD=1.52P
+ PS=8.38U PD=8.38U rfmode=0
M$388 vdd \$144 inn|out|vped vdd sg13_hv_pmos L=1U W=8U AS=1.52P AD=1.52P
+ PS=8.38U PD=8.38U rfmode=0
M$389 inn|out|vped \$144 vdd vdd sg13_hv_pmos L=1U W=8U AS=1.52P AD=1.52P
+ PS=8.38U PD=8.38U rfmode=0
M$390 vdd \$144 inn|out|vped vdd sg13_hv_pmos L=1U W=8U AS=1.52P AD=1.52P
+ PS=8.38U PD=8.38U rfmode=0
M$391 inn|out|vped \$144 vdd vdd sg13_hv_pmos L=1U W=8U AS=1.52P AD=1.52P
+ PS=8.38U PD=8.38U rfmode=0
M$392 vdd \$144 inn|out|vped vdd sg13_hv_pmos L=1U W=8U AS=1.52P AD=2.72P
+ PS=8.38U PD=16.68U rfmode=0
M$393 \$315 \$249 vdd vdd sg13_hv_pmos L=1U W=8U AS=2.72P AD=1.52P PS=16.68U
+ PD=8.38U rfmode=0
M$394 vdd \$249 \$315 vdd sg13_hv_pmos L=1U W=8U AS=1.52P AD=1.52P PS=8.38U
+ PD=8.38U rfmode=0
M$395 \$315 \$249 vdd vdd sg13_hv_pmos L=1U W=8U AS=1.52P AD=1.52P PS=8.38U
+ PD=8.38U rfmode=0
M$396 vdd \$249 \$315 vdd sg13_hv_pmos L=1U W=8U AS=1.52P AD=1.52P PS=8.38U
+ PD=8.38U rfmode=0
M$397 \$315 \$249 vdd vdd sg13_hv_pmos L=1U W=8U AS=1.52P AD=1.52P PS=8.38U
+ PD=8.38U rfmode=0
M$398 vdd \$249 \$315 vdd sg13_hv_pmos L=1U W=8U AS=1.52P AD=1.52P PS=8.38U
+ PD=8.38U rfmode=0
M$399 \$315 \$249 vdd vdd sg13_hv_pmos L=1U W=8U AS=1.52P AD=1.52P PS=8.38U
+ PD=8.38U rfmode=0
M$400 vdd \$249 \$315 vdd sg13_hv_pmos L=1U W=8U AS=1.52P AD=1.52P PS=8.38U
+ PD=8.38U rfmode=0
M$401 \$315 \$249 vdd vdd sg13_hv_pmos L=1U W=8U AS=1.52P AD=1.52P PS=8.38U
+ PD=8.38U rfmode=0
M$402 vdd \$249 \$315 vdd sg13_hv_pmos L=1U W=8U AS=1.52P AD=1.52P PS=8.38U
+ PD=8.38U rfmode=0
M$403 \$315 \$249 vdd vdd sg13_hv_pmos L=1U W=8U AS=1.52P AD=1.52P PS=8.38U
+ PD=8.38U rfmode=0
M$404 vdd \$249 \$315 vdd sg13_hv_pmos L=1U W=8U AS=1.52P AD=2.72P PS=8.38U
+ PD=16.68U rfmode=0
M$405 \$249 \$243 \$315 vdd sg13_hv_pmos L=1U W=8U AS=2.72P AD=1.52P PS=16.68U
+ PD=8.38U rfmode=0
M$406 \$315 \$243 \$249 vdd sg13_hv_pmos L=1U W=8U AS=1.52P AD=1.52P PS=8.38U
+ PD=8.38U rfmode=0
M$407 \$249 \$243 \$315 vdd sg13_hv_pmos L=1U W=8U AS=1.52P AD=1.52P PS=8.38U
+ PD=8.38U rfmode=0
M$408 \$315 \$243 \$249 vdd sg13_hv_pmos L=1U W=8U AS=1.52P AD=1.52P PS=8.38U
+ PD=8.38U rfmode=0
M$409 \$249 \$243 \$315 vdd sg13_hv_pmos L=1U W=8U AS=1.52P AD=1.52P PS=8.38U
+ PD=8.38U rfmode=0
M$410 \$315 \$243 \$249 vdd sg13_hv_pmos L=1U W=8U AS=1.52P AD=1.52P PS=8.38U
+ PD=8.38U rfmode=0
M$411 \$249 \$243 \$315 vdd sg13_hv_pmos L=1U W=8U AS=1.52P AD=1.52P PS=8.38U
+ PD=8.38U rfmode=0
M$412 \$315 \$243 \$249 vdd sg13_hv_pmos L=1U W=8U AS=1.52P AD=1.52P PS=8.38U
+ PD=8.38U rfmode=0
M$413 \$249 \$243 \$315 vdd sg13_hv_pmos L=1U W=8U AS=1.52P AD=1.52P PS=8.38U
+ PD=8.38U rfmode=0
M$414 \$315 \$243 \$249 vdd sg13_hv_pmos L=1U W=8U AS=1.52P AD=1.52P PS=8.38U
+ PD=8.38U rfmode=0
M$415 \$249 \$243 \$315 vdd sg13_hv_pmos L=1U W=8U AS=1.52P AD=1.52P PS=8.38U
+ PD=8.38U rfmode=0
M$416 \$315 \$243 \$249 vdd sg13_hv_pmos L=1U W=8U AS=1.52P AD=2.72P PS=8.38U
+ PD=16.68U rfmode=0
M$417 \$250 \$243 \$316 vdd sg13_hv_pmos L=1U W=8U AS=2.72P AD=1.52P PS=16.68U
+ PD=8.38U rfmode=0
M$418 \$316 \$243 \$250 vdd sg13_hv_pmos L=1U W=8U AS=1.52P AD=1.52P PS=8.38U
+ PD=8.38U rfmode=0
M$419 \$250 \$243 \$316 vdd sg13_hv_pmos L=1U W=8U AS=1.52P AD=1.52P PS=8.38U
+ PD=8.38U rfmode=0
M$420 \$316 \$243 \$250 vdd sg13_hv_pmos L=1U W=8U AS=1.52P AD=1.52P PS=8.38U
+ PD=8.38U rfmode=0
M$421 \$250 \$243 \$316 vdd sg13_hv_pmos L=1U W=8U AS=1.52P AD=1.52P PS=8.38U
+ PD=8.38U rfmode=0
M$422 \$316 \$243 \$250 vdd sg13_hv_pmos L=1U W=8U AS=1.52P AD=1.52P PS=8.38U
+ PD=8.38U rfmode=0
M$423 \$250 \$243 \$316 vdd sg13_hv_pmos L=1U W=8U AS=1.52P AD=1.52P PS=8.38U
+ PD=8.38U rfmode=0
M$424 \$316 \$243 \$250 vdd sg13_hv_pmos L=1U W=8U AS=1.52P AD=1.52P PS=8.38U
+ PD=8.38U rfmode=0
M$425 \$250 \$243 \$316 vdd sg13_hv_pmos L=1U W=8U AS=1.52P AD=1.52P PS=8.38U
+ PD=8.38U rfmode=0
M$426 \$316 \$243 \$250 vdd sg13_hv_pmos L=1U W=8U AS=1.52P AD=1.52P PS=8.38U
+ PD=8.38U rfmode=0
M$427 \$250 \$243 \$316 vdd sg13_hv_pmos L=1U W=8U AS=1.52P AD=1.52P PS=8.38U
+ PD=8.38U rfmode=0
M$428 \$316 \$243 \$250 vdd sg13_hv_pmos L=1U W=8U AS=1.52P AD=2.72P PS=8.38U
+ PD=16.68U rfmode=0
M$429 \$316 \$249 vdd vdd sg13_hv_pmos L=1U W=8U AS=2.72P AD=1.52P PS=16.68U
+ PD=8.38U rfmode=0
M$430 vdd \$249 \$316 vdd sg13_hv_pmos L=1U W=8U AS=1.52P AD=1.52P PS=8.38U
+ PD=8.38U rfmode=0
M$431 \$316 \$249 vdd vdd sg13_hv_pmos L=1U W=8U AS=1.52P AD=1.52P PS=8.38U
+ PD=8.38U rfmode=0
M$432 vdd \$249 \$316 vdd sg13_hv_pmos L=1U W=8U AS=1.52P AD=1.52P PS=8.38U
+ PD=8.38U rfmode=0
M$433 \$316 \$249 vdd vdd sg13_hv_pmos L=1U W=8U AS=1.52P AD=1.52P PS=8.38U
+ PD=8.38U rfmode=0
M$434 vdd \$249 \$316 vdd sg13_hv_pmos L=1U W=8U AS=1.52P AD=1.52P PS=8.38U
+ PD=8.38U rfmode=0
M$435 \$316 \$249 vdd vdd sg13_hv_pmos L=1U W=8U AS=1.52P AD=1.52P PS=8.38U
+ PD=8.38U rfmode=0
M$436 vdd \$249 \$316 vdd sg13_hv_pmos L=1U W=8U AS=1.52P AD=1.52P PS=8.38U
+ PD=8.38U rfmode=0
M$437 \$316 \$249 vdd vdd sg13_hv_pmos L=1U W=8U AS=1.52P AD=1.52P PS=8.38U
+ PD=8.38U rfmode=0
M$438 vdd \$249 \$316 vdd sg13_hv_pmos L=1U W=8U AS=1.52P AD=1.52P PS=8.38U
+ PD=8.38U rfmode=0
M$439 \$316 \$249 vdd vdd sg13_hv_pmos L=1U W=8U AS=1.52P AD=1.52P PS=8.38U
+ PD=8.38U rfmode=0
M$440 vdd \$249 \$316 vdd sg13_hv_pmos L=1U W=8U AS=1.52P AD=2.72P PS=8.38U
+ PD=16.68U rfmode=0
M$441 \$245 inn|out|vref_buf \$326 vdd sg13_hv_pmos L=2U W=6U AS=2.04P AD=1.14P
+ PS=12.68U PD=6.38U rfmode=0
M$442 \$326 inn|out|vref_buf \$245 vdd sg13_hv_pmos L=2U W=6U AS=1.14P AD=1.14P
+ PS=6.38U PD=6.38U rfmode=0
M$443 \$247 inp|vref \$326 vdd sg13_hv_pmos L=2U W=6U AS=1.14P AD=1.14P
+ PS=6.38U PD=6.38U rfmode=0
M$444 \$326 inp|vref \$247 vdd sg13_hv_pmos L=2U W=6U AS=1.14P AD=1.14P
+ PS=6.38U PD=6.38U rfmode=0
M$445 \$247 inp|vref \$326 vdd sg13_hv_pmos L=2U W=6U AS=1.14P AD=1.14P
+ PS=6.38U PD=6.38U rfmode=0
M$446 \$326 inp|vref \$247 vdd sg13_hv_pmos L=2U W=6U AS=1.14P AD=1.14P
+ PS=6.38U PD=6.38U rfmode=0
M$447 \$245 inn|out|vref_buf \$326 vdd sg13_hv_pmos L=2U W=6U AS=1.14P AD=1.14P
+ PS=6.38U PD=6.38U rfmode=0
M$448 \$326 inn|out|vref_buf \$245 vdd sg13_hv_pmos L=2U W=6U AS=1.14P AD=1.14P
+ PS=6.38U PD=6.38U rfmode=0
M$449 \$245 inn|out|vref_buf \$326 vdd sg13_hv_pmos L=2U W=6U AS=1.14P AD=1.14P
+ PS=6.38U PD=6.38U rfmode=0
M$450 \$326 inn|out|vref_buf \$245 vdd sg13_hv_pmos L=2U W=6U AS=1.14P AD=1.14P
+ PS=6.38U PD=6.38U rfmode=0
M$451 \$247 inp|vref \$326 vdd sg13_hv_pmos L=2U W=6U AS=1.14P AD=1.14P
+ PS=6.38U PD=6.38U rfmode=0
M$452 \$326 inp|vref \$247 vdd sg13_hv_pmos L=2U W=6U AS=1.14P AD=1.14P
+ PS=6.38U PD=6.38U rfmode=0
M$453 \$247 inp|vref \$326 vdd sg13_hv_pmos L=2U W=6U AS=1.14P AD=1.14P
+ PS=6.38U PD=6.38U rfmode=0
M$454 \$326 inp|vref \$247 vdd sg13_hv_pmos L=2U W=6U AS=1.14P AD=1.14P
+ PS=6.38U PD=6.38U rfmode=0
M$455 \$245 inn|out|vref_buf \$326 vdd sg13_hv_pmos L=2U W=6U AS=1.14P AD=1.14P
+ PS=6.38U PD=6.38U rfmode=0
M$456 \$326 inn|out|vref_buf \$245 vdd sg13_hv_pmos L=2U W=6U AS=1.14P AD=1.14P
+ PS=6.38U PD=6.38U rfmode=0
M$457 \$245 inn|out|vref_buf \$326 vdd sg13_hv_pmos L=2U W=6U AS=1.14P AD=1.14P
+ PS=6.38U PD=6.38U rfmode=0
M$458 \$326 inn|out|vref_buf \$245 vdd sg13_hv_pmos L=2U W=6U AS=1.14P AD=1.14P
+ PS=6.38U PD=6.38U rfmode=0
M$459 \$247 inp|vref \$326 vdd sg13_hv_pmos L=2U W=6U AS=1.14P AD=1.14P
+ PS=6.38U PD=6.38U rfmode=0
M$460 \$326 inp|vref \$247 vdd sg13_hv_pmos L=2U W=6U AS=1.14P AD=1.14P
+ PS=6.38U PD=6.38U rfmode=0
M$461 \$247 inp|vref \$326 vdd sg13_hv_pmos L=2U W=6U AS=1.14P AD=1.14P
+ PS=6.38U PD=6.38U rfmode=0
M$462 \$326 inp|vref \$247 vdd sg13_hv_pmos L=2U W=6U AS=1.14P AD=1.14P
+ PS=6.38U PD=6.38U rfmode=0
M$463 \$245 inn|out|vref_buf \$326 vdd sg13_hv_pmos L=2U W=6U AS=1.14P AD=1.14P
+ PS=6.38U PD=6.38U rfmode=0
M$464 \$326 inn|out|vref_buf \$245 vdd sg13_hv_pmos L=2U W=6U AS=1.14P AD=1.14P
+ PS=6.38U PD=6.38U rfmode=0
M$465 \$245 inn|out|vref_buf \$326 vdd sg13_hv_pmos L=2U W=6U AS=1.14P AD=1.14P
+ PS=6.38U PD=6.38U rfmode=0
M$466 \$326 inn|out|vref_buf \$245 vdd sg13_hv_pmos L=2U W=6U AS=1.14P AD=1.14P
+ PS=6.38U PD=6.38U rfmode=0
M$467 \$247 inp|vref \$326 vdd sg13_hv_pmos L=2U W=6U AS=1.14P AD=1.14P
+ PS=6.38U PD=6.38U rfmode=0
M$468 \$326 inp|vref \$247 vdd sg13_hv_pmos L=2U W=6U AS=1.14P AD=1.14P
+ PS=6.38U PD=6.38U rfmode=0
M$469 \$247 inp|vref \$326 vdd sg13_hv_pmos L=2U W=6U AS=1.14P AD=1.14P
+ PS=6.38U PD=6.38U rfmode=0
M$470 \$326 inp|vref \$247 vdd sg13_hv_pmos L=2U W=6U AS=1.14P AD=1.14P
+ PS=6.38U PD=6.38U rfmode=0
M$471 \$245 inn|out|vref_buf \$326 vdd sg13_hv_pmos L=2U W=6U AS=1.14P AD=1.14P
+ PS=6.38U PD=6.38U rfmode=0
M$472 \$326 inn|out|vref_buf \$245 vdd sg13_hv_pmos L=2U W=6U AS=1.14P AD=2.04P
+ PS=6.38U PD=12.68U rfmode=0
M$473 \$243 \$243 vdd vdd sg13_hv_pmos L=1U W=3.2U AS=1.088P AD=1.088P PS=7.08U
+ PD=7.08U rfmode=0
M$474 \$246 \$244 vdd vdd sg13_hv_pmos L=1U W=8U AS=2.72P AD=1.52P PS=16.68U
+ PD=8.38U rfmode=0
M$475 vdd \$244 \$246 vdd sg13_hv_pmos L=1U W=8U AS=1.52P AD=2.72P PS=8.38U
+ PD=16.68U rfmode=0
M$476 \$244 \$244 vdd vdd sg13_hv_pmos L=1U W=8U AS=2.72P AD=1.52P PS=16.68U
+ PD=8.38U rfmode=0
M$477 vdd \$244 \$244 vdd sg13_hv_pmos L=1U W=8U AS=1.52P AD=2.72P PS=8.38U
+ PD=16.68U rfmode=0
M$478 \$326 \$244 vdd vdd sg13_hv_pmos L=1U W=8U AS=2.72P AD=1.52P PS=16.68U
+ PD=8.38U rfmode=0
M$479 vdd \$244 \$326 vdd sg13_hv_pmos L=1U W=8U AS=1.52P AD=1.52P PS=8.38U
+ PD=8.38U rfmode=0
M$480 \$326 \$244 vdd vdd sg13_hv_pmos L=1U W=8U AS=1.52P AD=1.52P PS=8.38U
+ PD=8.38U rfmode=0
M$481 vdd \$244 \$326 vdd sg13_hv_pmos L=1U W=8U AS=1.52P AD=1.52P PS=8.38U
+ PD=8.38U rfmode=0
M$482 \$326 \$244 vdd vdd sg13_hv_pmos L=1U W=8U AS=1.52P AD=1.52P PS=8.38U
+ PD=8.38U rfmode=0
M$483 vdd \$244 \$326 vdd sg13_hv_pmos L=1U W=8U AS=1.52P AD=1.52P PS=8.38U
+ PD=8.38U rfmode=0
M$484 \$326 \$244 vdd vdd sg13_hv_pmos L=1U W=8U AS=1.52P AD=1.52P PS=8.38U
+ PD=8.38U rfmode=0
M$485 vdd \$244 \$326 vdd sg13_hv_pmos L=1U W=8U AS=1.52P AD=1.52P PS=8.38U
+ PD=8.38U rfmode=0
M$486 \$326 \$244 vdd vdd sg13_hv_pmos L=1U W=8U AS=1.52P AD=1.52P PS=8.38U
+ PD=8.38U rfmode=0
M$487 vdd \$244 \$326 vdd sg13_hv_pmos L=1U W=8U AS=1.52P AD=1.52P PS=8.38U
+ PD=8.38U rfmode=0
M$488 \$326 \$244 vdd vdd sg13_hv_pmos L=1U W=8U AS=1.52P AD=1.52P PS=8.38U
+ PD=8.38U rfmode=0
M$489 vdd \$244 \$326 vdd sg13_hv_pmos L=1U W=8U AS=1.52P AD=1.52P PS=8.38U
+ PD=8.38U rfmode=0
M$490 \$326 \$244 vdd vdd sg13_hv_pmos L=1U W=8U AS=1.52P AD=1.52P PS=8.38U
+ PD=8.38U rfmode=0
M$491 vdd \$244 \$326 vdd sg13_hv_pmos L=1U W=8U AS=1.52P AD=1.52P PS=8.38U
+ PD=8.38U rfmode=0
M$492 \$326 \$244 vdd vdd sg13_hv_pmos L=1U W=8U AS=1.52P AD=1.52P PS=8.38U
+ PD=8.38U rfmode=0
M$493 vdd \$244 \$326 vdd sg13_hv_pmos L=1U W=8U AS=1.52P AD=2.72P PS=8.38U
+ PD=16.68U rfmode=0
M$494 inn|out|vref_buf \$250 vdd vdd sg13_hv_pmos L=1U W=8U AS=2.72P AD=1.52P
+ PS=16.68U PD=8.38U rfmode=0
M$495 vdd \$250 inn|out|vref_buf vdd sg13_hv_pmos L=1U W=8U AS=1.52P AD=1.52P
+ PS=8.38U PD=8.38U rfmode=0
M$496 inn|out|vref_buf \$250 vdd vdd sg13_hv_pmos L=1U W=8U AS=1.52P AD=1.52P
+ PS=8.38U PD=8.38U rfmode=0
M$497 vdd \$250 inn|out|vref_buf vdd sg13_hv_pmos L=1U W=8U AS=1.52P AD=1.52P
+ PS=8.38U PD=8.38U rfmode=0
M$498 inn|out|vref_buf \$250 vdd vdd sg13_hv_pmos L=1U W=8U AS=1.52P AD=1.52P
+ PS=8.38U PD=8.38U rfmode=0
M$499 vdd \$250 inn|out|vref_buf vdd sg13_hv_pmos L=1U W=8U AS=1.52P AD=1.52P
+ PS=8.38U PD=8.38U rfmode=0
M$500 inn|out|vref_buf \$250 vdd vdd sg13_hv_pmos L=1U W=8U AS=1.52P AD=1.52P
+ PS=8.38U PD=8.38U rfmode=0
M$501 vdd \$250 inn|out|vref_buf vdd sg13_hv_pmos L=1U W=8U AS=1.52P AD=1.52P
+ PS=8.38U PD=8.38U rfmode=0
M$502 inn|out|vref_buf \$250 vdd vdd sg13_hv_pmos L=1U W=8U AS=1.52P AD=1.52P
+ PS=8.38U PD=8.38U rfmode=0
M$503 vdd \$250 inn|out|vref_buf vdd sg13_hv_pmos L=1U W=8U AS=1.52P AD=1.52P
+ PS=8.38U PD=8.38U rfmode=0
M$504 inn|out|vref_buf \$250 vdd vdd sg13_hv_pmos L=1U W=8U AS=1.52P AD=1.52P
+ PS=8.38U PD=8.38U rfmode=0
M$505 vdd \$250 inn|out|vref_buf vdd sg13_hv_pmos L=1U W=8U AS=1.52P AD=1.52P
+ PS=8.38U PD=8.38U rfmode=0
M$506 inn|out|vref_buf \$250 vdd vdd sg13_hv_pmos L=1U W=8U AS=1.52P AD=1.52P
+ PS=8.38U PD=8.38U rfmode=0
M$507 vdd \$250 inn|out|vref_buf vdd sg13_hv_pmos L=1U W=8U AS=1.52P AD=1.52P
+ PS=8.38U PD=8.38U rfmode=0
M$508 inn|out|vref_buf \$250 vdd vdd sg13_hv_pmos L=1U W=8U AS=1.52P AD=1.52P
+ PS=8.38U PD=8.38U rfmode=0
M$509 vdd \$250 inn|out|vref_buf vdd sg13_hv_pmos L=1U W=8U AS=1.52P AD=1.52P
+ PS=8.38U PD=8.38U rfmode=0
M$510 inn|out|vref_buf \$250 vdd vdd sg13_hv_pmos L=1U W=8U AS=1.52P AD=1.52P
+ PS=8.38U PD=8.38U rfmode=0
M$511 vdd \$250 inn|out|vref_buf vdd sg13_hv_pmos L=1U W=8U AS=1.52P AD=1.52P
+ PS=8.38U PD=8.38U rfmode=0
M$512 inn|out|vref_buf \$250 vdd vdd sg13_hv_pmos L=1U W=8U AS=1.52P AD=1.52P
+ PS=8.38U PD=8.38U rfmode=0
M$513 vdd \$250 inn|out|vref_buf vdd sg13_hv_pmos L=1U W=8U AS=1.52P AD=1.52P
+ PS=8.38U PD=8.38U rfmode=0
M$514 inn|out|vref_buf \$250 vdd vdd sg13_hv_pmos L=1U W=8U AS=1.52P AD=1.52P
+ PS=8.38U PD=8.38U rfmode=0
M$515 vdd \$250 inn|out|vref_buf vdd sg13_hv_pmos L=1U W=8U AS=1.52P AD=1.52P
+ PS=8.38U PD=8.38U rfmode=0
M$516 inn|out|vref_buf \$250 vdd vdd sg13_hv_pmos L=1U W=8U AS=1.52P AD=1.52P
+ PS=8.38U PD=8.38U rfmode=0
M$517 vdd \$250 inn|out|vref_buf vdd sg13_hv_pmos L=1U W=8U AS=1.52P AD=2.72P
+ PS=8.38U PD=16.68U rfmode=0
R$518 \$8 inp$1 vss 2 rppd l=76.7 ps=0 b=0 m=1
R$519 \$8 \$168 vss 2 rppd l=76.7 ps=0 b=0 m=1
R$520 \$9 \$168 vss 2 rppd l=76.7 ps=0 b=0 m=1
R$521 \$9 \$169 vss 2 rppd l=76.7 ps=0 b=0 m=1
R$522 \$10 \$169 vss 2 rppd l=76.7 ps=0 b=0 m=1
R$523 \$10 \$170 vss 2 rppd l=76.7 ps=0 b=0 m=1
R$524 \$11 \$170 vss 2 rppd l=76.7 ps=0 b=0 m=1
R$525 \$11 \$171 vss 2 rppd l=76.7 ps=0 b=0 m=1
R$526 \$12 \$171 vss 2 rppd l=76.7 ps=0 b=0 m=1
R$527 \$12 \$172 vss 2 rppd l=76.7 ps=0 b=0 m=1
R$528 \$13 \$172 vss 2 rppd l=76.7 ps=0 b=0 m=1
R$529 \$13 \$173 vss 2 rppd l=76.7 ps=0 b=0 m=1
R$530 \$14 \$173 vss 2 rppd l=76.7 ps=0 b=0 m=1
R$531 \$15 inn vss 2 rppd l=76.7 ps=0 b=0 m=1
R$532 \$15 \$174 vss 2 rppd l=76.7 ps=0 b=0 m=1
R$533 \$16 \$174 vss 2 rppd l=76.7 ps=0 b=0 m=1
R$534 \$16 \$175 vss 2 rppd l=76.7 ps=0 b=0 m=1
R$535 \$17 \$175 vss 2 rppd l=76.7 ps=0 b=0 m=1
R$536 \$17 \$176 vss 2 rppd l=76.7 ps=0 b=0 m=1
R$537 \$18 \$176 vss 2 rppd l=76.7 ps=0 b=0 m=1
R$538 \$18 \$177 vss 2 rppd l=76.7 ps=0 b=0 m=1
R$539 \$19 \$177 vss 2 rppd l=76.7 ps=0 b=0 m=1
R$540 \$19 \$178 vss 2 rppd l=76.7 ps=0 b=0 m=1
R$541 sense_n inn vss 2 rppd l=76.7 ps=0 b=0 m=1
R$542 sense_p inp vss 2 rppd l=76.7 ps=0 b=0 m=1
R$543 \$22 inp vss 2 rppd l=76.7 ps=0 b=0 m=1
R$544 \$22 \$179 vss 2 rppd l=76.7 ps=0 b=0 m=1
R$545 \$23 \$179 vss 2 rppd l=76.7 ps=0 b=0 m=1
R$546 \$23 \$180 vss 2 rppd l=76.7 ps=0 b=0 m=1
R$547 \$24 \$180 vss 2 rppd l=76.7 ps=0 b=0 m=1
R$548 \$24 \$181 vss 2 rppd l=76.7 ps=0 b=0 m=1
R$549 \$25 \$181 vss 2 rppd l=76.7 ps=0 b=0 m=1
R$550 \$25 \$182 vss 2 rppd l=76.7 ps=0 b=0 m=1
R$551 \$26 \$182 vss 2 rppd l=76.7 ps=0 b=0 m=1
R$552 \$26 \$183 vss 2 rppd l=76.7 ps=0 b=0 m=1
R$553 \$27 \$184 vss 2 rppd l=76.7 ps=0 b=0 m=1
R$554 \$27 \$185 vss 2 rppd l=76.7 ps=0 b=0 m=1
R$555 \$28 \$185 vss 2 rppd l=76.7 ps=0 b=0 m=1
R$556 \$28 \$186 vss 2 rppd l=76.7 ps=0 b=0 m=1
R$557 \$29 \$186 vss 2 rppd l=76.7 ps=0 b=0 m=1
R$558 \$29 \$187 vss 2 rppd l=76.7 ps=0 b=0 m=1
R$559 \$30 \$187 vss 2 rppd l=76.7 ps=0 b=0 m=1
R$560 \$30 \$188 vss 2 rppd l=76.7 ps=0 b=0 m=1
R$561 \$31 \$188 vss 2 rppd l=76.7 ps=0 b=0 m=1
R$562 \$31 \$189 vss 2 rppd l=76.7 ps=0 b=0 m=1
R$563 \$32 \$189 vss 2 rppd l=76.7 ps=0 b=0 m=1
R$564 \$32 \$190 vss 2 rppd l=76.7 ps=0 b=0 m=1
R$565 \$14 \$190 vss 2 rppd l=76.7 ps=0 b=0 m=1
R$566 \$144 \$229 vss 1 rppd l=6.2 ps=0 b=0 m=1
R$567 \$35 \$75 vss 1 rppd l=6.2 ps=0 b=0 m=1
R$568 \$203 \$351 vss 2 rppd l=76.7 ps=0 b=0 m=1
R$569 \$203 \$352 vss 2 rppd l=76.7 ps=0 b=0 m=1
R$570 \$204 \$352 vss 2 rppd l=76.7 ps=0 b=0 m=1
R$571 \$204 \$353 vss 2 rppd l=76.7 ps=0 b=0 m=1
R$572 \$205 \$353 vss 2 rppd l=76.7 ps=0 b=0 m=1
R$573 \$205 \$354 vss 2 rppd l=76.7 ps=0 b=0 m=1
R$574 \$206 \$354 vss 2 rppd l=76.7 ps=0 b=0 m=1
R$575 \$206 \$355 vss 2 rppd l=76.7 ps=0 b=0 m=1
R$576 \$207 \$355 vss 2 rppd l=76.7 ps=0 b=0 m=1
R$577 \$207 \$356 vss 2 rppd l=76.7 ps=0 b=0 m=1
R$578 \$208 \$356 vss 2 rppd l=76.7 ps=0 b=0 m=1
R$579 \$208 \$357 vss 2 rppd l=76.7 ps=0 b=0 m=1
R$580 \$184 \$357 vss 2 rppd l=76.7 ps=0 b=0 m=1
R$581 \$209 \$183 vss 2 rppd l=76.7 ps=0 b=0 m=1
R$582 \$209 \$358 vss 2 rppd l=76.7 ps=0 b=0 m=1
R$583 \$210 \$358 vss 2 rppd l=76.7 ps=0 b=0 m=1
R$584 \$210 \$359 vss 2 rppd l=76.7 ps=0 b=0 m=1
R$585 \$211 \$359 vss 2 rppd l=76.7 ps=0 b=0 m=1
R$586 \$211 \$360 vss 2 rppd l=76.7 ps=0 b=0 m=1
R$587 \$212 \$360 vss 2 rppd l=76.7 ps=0 b=0 m=1
R$588 \$212 \$361 vss 2 rppd l=76.7 ps=0 b=0 m=1
R$589 \$213 \$361 vss 2 rppd l=76.7 ps=0 b=0 m=1
R$590 \$213 inn|out|vped vss 2 rppd l=76.7 ps=0 b=0 m=1
R$591 \$214 inn|out|vref_buf vss 2 rppd l=76.7 ps=0 b=0 m=1
R$592 \$214 inp$1 vss 2 rppd l=76.7 ps=0 b=0 m=1
R$593 \$215 \$178 vss 2 rppd l=76.7 ps=0 b=0 m=1
R$594 \$215 \$362 vss 2 rppd l=76.7 ps=0 b=0 m=1
R$595 \$216 \$362 vss 2 rppd l=76.7 ps=0 b=0 m=1
R$596 \$216 \$363 vss 2 rppd l=76.7 ps=0 b=0 m=1
R$597 \$217 \$363 vss 2 rppd l=76.7 ps=0 b=0 m=1
R$598 \$217 \$364 vss 2 rppd l=76.7 ps=0 b=0 m=1
R$599 \$218 \$364 vss 2 rppd l=76.7 ps=0 b=0 m=1
R$600 \$218 \$365 vss 2 rppd l=76.7 ps=0 b=0 m=1
R$601 \$219 \$365 vss 2 rppd l=76.7 ps=0 b=0 m=1
R$602 \$219 isense|out vss 2 rppd l=76.7 ps=0 b=0 m=1
R$603 \$220 \$351 vss 2 rppd l=76.7 ps=0 b=0 m=1
R$604 \$220 \$366 vss 2 rppd l=76.7 ps=0 b=0 m=1
R$605 \$221 \$366 vss 2 rppd l=76.7 ps=0 b=0 m=1
R$606 \$221 \$367 vss 2 rppd l=76.7 ps=0 b=0 m=1
R$607 \$222 \$367 vss 2 rppd l=76.7 ps=0 b=0 m=1
R$608 \$222 \$368 vss 2 rppd l=76.7 ps=0 b=0 m=1
R$609 \$223 \$368 vss 2 rppd l=76.7 ps=0 b=0 m=1
R$610 \$223 \$369 vss 2 rppd l=76.7 ps=0 b=0 m=1
R$611 \$224 \$369 vss 2 rppd l=76.7 ps=0 b=0 m=1
R$612 \$224 \$370 vss 2 rppd l=76.7 ps=0 b=0 m=1
R$613 \$225 \$370 vss 2 rppd l=76.7 ps=0 b=0 m=1
R$614 \$225 vss vss 2 rppd l=76.7 ps=0 b=0 m=1
R$615 \$250 \$332 vss 1 rppd l=6.2 ps=0 b=0 m=1
Cext_1 \$10 \$11 28.7835a
Cext_2 \$10 \$9 28.7835a
Cext_3 \$10 vss 53.6189a
Cext_4 \$10 VSUBS 858.397a
Cext_5 \$11 \$12 28.7835a
Cext_6 \$11 vss 53.6189a
Cext_7 \$11 VSUBS 858.397a
Cext_8 \$12 \$13 28.7835a
Cext_9 \$12 \$14 0.934295a
Cext_10 \$12 vss 53.6189a
Cext_11 \$12 VSUBS 858.397a
Cext_12 \$13 \$14 40.4369a
Cext_13 \$13 vss 53.6189a
Cext_14 \$13 VSUBS 858.397a
Cext_15 \$137 \$138 5.68933f
Cext_16 \$137 \$139 1.93792f
Cext_17 \$137 \$140 4.37941f
Cext_18 \$137 \$141 1.30439a
Cext_19 \$137 \$143 5.2825f
Cext_20 \$137 \$144 3.59141f
Cext_21 \$137 \$162 5.60355f
Cext_22 \$137 \$163 4.97002f
Cext_23 \$137 \$202 65.7574a
Cext_24 \$137 \$229 338.807a
Cext_25 \$137 inn|out|vped 3.47289f
Cext_26 \$137 inp$1 72.0384a
Cext_27 \$137 iptat|vbn 466.031a
Cext_28 \$137 isense|out 31.2958a
Cext_29 \$137 vdd 959.591a
Cext_30 \$137 vss 846.778a
Cext_31 \$137 VSUBS 32.7246f
Cext_32 \$138 \$139 695.042a
Cext_33 \$138 \$140 1.78423f
Cext_34 \$138 \$141 81.65a
Cext_35 \$138 \$143 286.223a
Cext_36 \$138 \$144 137.593a
Cext_37 \$138 \$202 7.38946f
Cext_38 \$138 \$229 291.726a
Cext_39 \$138 inn|out|vped 822.098a
Cext_40 \$138 inn|out|vref_buf 2.10685a
Cext_41 \$138 inp$1 469.847a
Cext_42 \$138 iptat|vbn 418.944a
Cext_43 \$138 isense|out 0.157254a
Cext_44 \$138 vdd 7.61671f
Cext_45 \$138 vss 546.872a
Cext_46 \$138 VSUBS 27.3072f
Cext_47 \$139 \$140 2.01779f
Cext_48 \$139 \$141 465.164a
Cext_49 \$139 \$143 1.68398f
Cext_50 \$139 \$144 0.966982a
Cext_51 \$139 \$162 4.3649a
Cext_52 \$139 \$202 1.4372f
Cext_53 \$139 \$229 103.033a
Cext_54 \$139 inn|out|vped 8.40015f
Cext_55 \$139 inp$1 997.702a
Cext_56 \$139 iptat|vbn 4.5513f
Cext_57 \$139 isense|out 178.932a
Cext_58 \$139 vdd 9.09587f
Cext_59 \$139 vss 2.78817f
Cext_60 \$139 VSUBS 8.08647f
Cext_61 \$14 \$15 62.9192a
Cext_62 \$14 \$16 23.4167a
Cext_63 \$14 \$17 22.4824a
Cext_64 \$14 \$18 22.4824a
Cext_65 \$14 \$19 22.4824a
Cext_66 \$14 \$22 8.94579a
Cext_67 \$14 \$23 8.94579a
Cext_68 \$14 \$24 8.94579a
Cext_69 \$14 \$25 8.94579a
Cext_70 \$14 \$26 8.94579a
Cext_71 \$14 \$27 8.94579a
Cext_72 \$14 \$28 8.94579a
Cext_73 \$14 \$29 8.94579a
Cext_74 \$14 \$30 8.94579a
Cext_75 \$14 \$31 9.88009a
Cext_76 \$14 \$32 49.3827a
Cext_77 \$14 sense_n 263.218a
Cext_78 \$14 sense_p 8.97298f
Cext_79 \$14 vss 847.658a
Cext_80 \$14 VSUBS 5.59589f
Cext_81 \$140 \$141 1.83357f
Cext_82 \$140 \$143 3.15168f
Cext_83 \$140 \$144 2.37443f
Cext_84 \$140 \$162 0.441084a
Cext_85 \$140 \$163 0.220542a
Cext_86 \$140 \$202 263.257a
Cext_87 \$140 \$229 170.258a
Cext_88 \$140 inn|out|vped 268.061a
Cext_89 \$140 inp$1 92.0037a
Cext_90 \$140 iptat|vbn 1.23563f
Cext_91 \$140 isense|out 9.09638a
Cext_92 \$140 vdd 913.163a
Cext_93 \$140 vss 4.48555f
Cext_94 \$140 VSUBS 18.7693f
Cext_95 \$141 \$143 56.3514a
Cext_96 \$141 \$144 3.29635f
Cext_97 \$141 \$163 4.74202a
Cext_98 \$141 \$202 2.60276f
Cext_99 \$141 \$229 206.331a
Cext_100 \$141 inn|out|vped 2.99821f
Cext_101 \$141 inp$1 8.68417f
Cext_102 \$141 iptat|vbn 5.16367f
Cext_103 \$141 isense|out 218.054a
Cext_104 \$141 vdd 7.9618f
Cext_105 \$141 vss 2.75716f
Cext_106 \$141 VSUBS 8.04219f
Cext_107 \$143 \$144 1.61266f
Cext_108 \$143 \$162 6.12058f
Cext_109 \$143 \$163 3.67869f
Cext_110 \$143 \$202 1.51285a
Cext_111 \$143 \$229 54.6553a
Cext_112 \$143 inn|out|vped 1.87683f
Cext_113 \$143 inp$1 44.448a
Cext_114 \$143 iptat|vbn 78.0763a
Cext_115 \$143 vdd 12.1579f
Cext_116 \$143 vss 1.30411f
Cext_117 \$143 VSUBS 34.4511f
Cext_118 \$144 \$163 2.44226f
Cext_119 \$144 \$202 776.999a
Cext_120 \$144 \$229 1.04438f
Cext_121 \$144 inn|out|vped 13.9381f
Cext_122 \$144 inn|out|vref_buf 2.52822a
Cext_123 \$144 inp$1 608.21a
Cext_124 \$144 iptat|vbn 376a
Cext_125 \$144 vdd 11.1361f
Cext_126 \$144 vss 1.3079f
Cext_127 \$144 VSUBS 34.702f
Cext_128 \$15 \$16 28.7835a
Cext_129 \$15 vss 53.6189a
Cext_130 \$15 VSUBS 858.397a
Cext_131 \$16 \$17 28.7835a
Cext_132 \$16 vss 53.6189a
Cext_133 \$16 VSUBS 858.397a
Cext_134 \$162 \$163 185.733a
Cext_135 \$162 \$229 29.5855a
Cext_136 \$162 inn|out|vped 539.472a
Cext_137 \$162 inp$1 16.3a
Cext_138 \$162 vdd 6.77016f
Cext_139 \$162 vss 19.3341a
Cext_140 \$162 VSUBS 3.39035f
Cext_141 \$163 \$229 27.9988a
Cext_142 \$163 inn|out|vped 701.209a
Cext_143 \$163 inp$1 16.3a
Cext_144 \$163 vdd 6.77016f
Cext_145 \$163 vss 23.7652a
Cext_146 \$163 VSUBS 3.39125f
Cext_147 \$168 \$169 28.7835a
Cext_148 \$168 \$178 8.86264a
Cext_149 \$168 \$183 5.63172a
Cext_150 \$168 \$203 12.6351a
Cext_151 \$168 \$204 12.6351a
Cext_152 \$168 inn 79.1203a
Cext_153 \$168 inp$1 56.026a
Cext_154 \$168 VSUBS 890.098a
Cext_155 \$169 \$170 28.7835a
Cext_156 \$169 \$178 8.86264a
Cext_157 \$169 \$183 5.63172a
Cext_158 \$169 \$204 12.6351a
Cext_159 \$169 \$205 12.6351a
Cext_160 \$169 inn 79.1203a
Cext_161 \$169 inp$1 16.5235a
Cext_162 \$169 VSUBS 890.098a
Cext_163 \$17 \$18 28.7835a
Cext_164 \$17 vss 53.6189a
Cext_165 \$17 VSUBS 858.397a
Cext_166 \$170 \$171 28.7835a
Cext_167 \$170 \$178 8.86264a
Cext_168 \$170 \$183 5.63172a
Cext_169 \$170 \$205 12.6351a
Cext_170 \$170 \$206 12.6351a
Cext_171 \$170 inn 79.1203a
Cext_172 \$170 inp$1 15.5892a
Cext_173 \$170 VSUBS 890.098a
Cext_174 \$171 \$172 28.7835a
Cext_175 \$171 \$178 8.86264a
Cext_176 \$171 \$183 5.63172a
Cext_177 \$171 \$206 12.6351a
Cext_178 \$171 \$207 12.6351a
Cext_179 \$171 inn 79.1203a
Cext_180 \$171 inp$1 15.5892a
Cext_181 \$171 VSUBS 890.098a
Cext_182 \$172 \$173 28.7835a
Cext_183 \$172 \$178 8.86264a
Cext_184 \$172 \$183 5.63172a
Cext_185 \$172 \$207 12.6351a
Cext_186 \$172 \$208 12.6351a
Cext_187 \$172 inn 80.0546a
Cext_188 \$172 inp$1 15.5892a
Cext_189 \$172 VSUBS 890.098a
Cext_190 \$173 \$178 8.64055a
Cext_191 \$173 \$183 5.4884a
Cext_192 \$173 \$184 15.3158a
Cext_193 \$173 \$208 12.6351a
Cext_194 \$173 inn 119.417a
Cext_195 \$173 inp$1 15.4757a
Cext_196 \$173 VSUBS 890.079a
Cext_197 \$174 \$175 28.7835a
Cext_198 \$174 \$178 8.86264a
Cext_199 \$174 \$183 5.63172a
Cext_200 \$174 \$184 2.79698a
Cext_201 \$174 \$209 12.6351a
Cext_202 \$174 \$210 12.6351a
Cext_203 \$174 inn 119.557a
Cext_204 \$174 inp$1 15.5892a
Cext_205 \$174 VSUBS 890.098a
Cext_206 \$175 \$176 28.7835a
Cext_207 \$175 \$178 8.86264a
Cext_208 \$175 \$183 5.63172a
Cext_209 \$175 \$184 2.79698a
Cext_210 \$175 \$210 12.6351a
Cext_211 \$175 \$211 12.6351a
Cext_212 \$175 inn 80.0546a
Cext_213 \$175 inp$1 15.5892a
Cext_214 \$175 VSUBS 890.098a
Cext_215 \$176 \$177 28.7835a
Cext_216 \$176 \$178 9.79693a
Cext_217 \$176 \$183 5.63172a
Cext_218 \$176 \$184 2.79698a
Cext_219 \$176 \$211 12.6351a
Cext_220 \$176 \$212 12.6351a
Cext_221 \$176 inn 79.1203a
Cext_222 \$176 inp$1 15.5892a
Cext_223 \$176 VSUBS 890.098a
Cext_224 \$177 \$178 49.2995a
Cext_225 \$177 \$183 5.63172a
Cext_226 \$177 \$184 2.79698a
Cext_227 \$177 \$212 12.6351a
Cext_228 \$177 \$213 12.6351a
Cext_229 \$177 inn 79.1203a
Cext_230 \$177 inp$1 15.5892a
Cext_231 \$177 VSUBS 890.098a
Cext_232 \$178 \$183 16.2552f
Cext_233 \$178 \$184 3.71068a
Cext_234 \$178 \$203 1.50863a
Cext_235 \$178 \$204 1.6714a
Cext_236 \$178 \$205 1.6714a
Cext_237 \$178 \$206 1.6714a
Cext_238 \$178 \$207 1.6714a
Cext_239 \$178 \$208 1.6714a
Cext_240 \$178 \$209 1.50863a
Cext_241 \$178 \$210 1.6714a
Cext_242 \$178 \$211 1.6714a
Cext_243 \$178 \$212 1.6714a
Cext_244 \$178 \$213 14.2735a
Cext_245 \$178 \$229 2.32786a
Cext_246 \$178 \$332 2.32786a
Cext_247 \$178 \$351 136.042a
Cext_248 \$178 \$352 79.1669a
Cext_249 \$178 \$353 79.1669a
Cext_250 \$178 \$354 79.1669a
Cext_251 \$178 \$355 79.1669a
Cext_252 \$178 \$356 79.1669a
Cext_253 \$178 \$357 79.1669a
Cext_254 \$178 \$358 79.1669a
Cext_255 \$178 \$359 79.1669a
Cext_256 \$178 \$360 79.1669a
Cext_257 \$178 \$361 79.1669a
Cext_258 \$178 \$362 40.4369a
Cext_259 \$178 \$363 0.934295a
Cext_260 \$178 inn 206.894a
Cext_261 \$178 inn|out|vped 358.841a
Cext_262 \$178 inn|out|vref_buf 335.47a
Cext_263 \$178 inp$1 11.0151f
Cext_264 \$178 inp|vref 214.404a
Cext_265 \$178 iptat|vbn 0.397379a
Cext_266 \$178 isense|out 13.8055f
Cext_267 \$178 vss 230.807a
Cext_268 \$178 VSUBS 6.4212f
Cext_269 \$179 \$180 28.7835a
Cext_270 \$179 \$183 14.1647a
Cext_271 \$179 \$184 2.79698a
Cext_272 \$179 \$215 12.6351a
Cext_273 \$179 \$216 12.6351a
Cext_274 \$179 inp$1 40.4369a
Cext_275 \$179 VSUBS 890.098a
Cext_276 \$18 \$19 28.7835a
Cext_277 \$18 sense_n 0.934295a
Cext_278 \$18 vss 53.6189a
Cext_279 \$18 VSUBS 858.397a
Cext_280 \$180 \$181 28.7835a
Cext_281 \$180 \$183 14.1647a
Cext_282 \$180 \$184 2.79698a
Cext_283 \$180 \$216 12.6351a
Cext_284 \$180 \$217 12.6351a
Cext_285 \$180 inp$1 0.934295a
Cext_286 \$180 VSUBS 890.098a
Cext_287 \$181 \$182 28.7835a
Cext_288 \$181 \$183 15.099a
Cext_289 \$181 \$184 2.79698a
Cext_290 \$181 \$217 12.6351a
Cext_291 \$181 \$218 12.6351a
Cext_292 \$181 VSUBS 890.098a
Cext_293 \$182 \$183 54.6015a
Cext_294 \$182 \$184 2.79698a
Cext_295 \$182 \$218 12.6351a
Cext_296 \$182 \$219 12.6351a
Cext_297 \$182 VSUBS 890.098a
Cext_298 \$183 \$184 2.72597f
Cext_299 \$183 \$203 4.28607a
Cext_300 \$183 \$204 5.39769a
Cext_301 \$183 \$205 5.39769a
Cext_302 \$183 \$206 5.39769a
Cext_303 \$183 \$207 5.39769a
Cext_304 \$183 \$208 5.39769a
Cext_305 \$183 \$209 1.93958a
Cext_306 \$183 \$210 2.14848a
Cext_307 \$183 \$211 2.14848a
Cext_308 \$183 \$212 2.14848a
Cext_309 \$183 \$213 1.93958a
Cext_310 \$183 \$214 1.73067a
Cext_311 \$183 \$215 1.93958a
Cext_312 \$183 \$216 2.14848a
Cext_313 \$183 \$217 2.14848a
Cext_314 \$183 \$218 2.14848a
Cext_315 \$183 \$219 15.7034a
Cext_316 \$183 \$229 1.77561a
Cext_317 \$183 \$332 1.77561a
Cext_318 \$183 \$351 46.915a
Cext_319 \$183 \$352 8.94579a
Cext_320 \$183 \$353 8.94579a
Cext_321 \$183 \$354 8.94579a
Cext_322 \$183 \$355 8.94579a
Cext_323 \$183 \$356 9.88009a
Cext_324 \$183 \$357 49.3827a
Cext_325 \$183 \$358 40.4369a
Cext_326 \$183 \$359 0.934295a
Cext_327 \$183 inn 7.88132a
Cext_328 \$183 inn|out|vped 12.78f
Cext_329 \$183 inn|out|vref_buf 186.413a
Cext_330 \$183 inp$1 2.22108f
Cext_331 \$183 inp|vref 100.089a
Cext_332 \$183 iptat|vbn 0.252304a
Cext_333 \$183 isense|out 7.1058f
Cext_334 \$183 vdd 9.64002a
Cext_335 \$183 vss 214.575a
Cext_336 \$183 VSUBS 5.94174f
Cext_337 \$184 \$185 40.4369a
Cext_338 \$184 \$186 0.934295a
Cext_339 \$184 \$207 0.934295a
Cext_340 \$184 \$208 40.4369a
Cext_341 \$184 \$209 50.2614a
Cext_342 \$184 \$210 10.8603a
Cext_343 \$184 \$211 9.92601a
Cext_344 \$184 \$212 9.92601a
Cext_345 \$184 \$213 9.8245a
Cext_346 \$184 \$214 9.72299a
Cext_347 \$184 \$215 9.8245a
Cext_348 \$184 \$216 9.92601a
Cext_349 \$184 \$217 9.92601a
Cext_350 \$184 \$218 9.92601a
Cext_351 \$184 \$219 9.8245a
Cext_352 \$184 \$220 18.0036a
Cext_353 \$184 inn 3.59052a
Cext_354 \$184 inp$1 4.47755a
Cext_355 \$184 VSUBS 4.18826f
Cext_356 \$185 \$186 28.7835a
Cext_357 \$185 \$220 12.6351a
Cext_358 \$185 \$221 12.6351a
Cext_359 \$185 VSUBS 890.098a
Cext_360 \$186 \$187 28.7835a
Cext_361 \$186 \$221 12.6351a
Cext_362 \$186 \$222 12.6351a
Cext_363 \$186 VSUBS 890.098a
Cext_364 \$187 \$188 28.7835a
Cext_365 \$187 \$222 12.6351a
Cext_366 \$187 \$223 12.6351a
Cext_367 \$187 VSUBS 890.098a
Cext_368 \$188 \$189 28.7835a
Cext_369 \$188 \$223 12.6351a
Cext_370 \$188 \$224 12.6351a
Cext_371 \$188 VSUBS 890.098a
Cext_372 \$189 \$190 28.7835a
Cext_373 \$189 \$224 12.6351a
Cext_374 \$189 \$225 12.6351a
Cext_375 \$189 VSUBS 890.098a
Cext_376 \$19 sense_n 40.4369a
Cext_377 \$19 vss 53.6189a
Cext_378 \$19 VSUBS 858.397a
Cext_379 \$190 \$225 12.6351a
Cext_380 \$190 vss 1.39423a
Cext_381 \$190 VSUBS 912.14a
Cext_382 \$2 \$3 5.68933f
Cext_383 \$2 \$34 5.2825f
Cext_384 \$2 \$35 3.59141f
Cext_385 \$2 \$4 4.37941f
Cext_386 \$2 \$5 1.93792f
Cext_387 \$2 \$57 5.60355f
Cext_388 \$2 \$58 4.97002f
Cext_389 \$2 \$6 1.30439a
Cext_390 \$2 \$68 65.7574a
Cext_391 \$2 \$75 338.807a
Cext_392 \$2 inn 999.089a
Cext_393 \$2 inp$1 72.0384a
Cext_394 \$2 iptat|vbn 502.475a
Cext_395 \$2 isense|out 2.4738f
Cext_396 \$2 vdd 956.474a
Cext_397 \$2 vss 852.576a
Cext_398 \$2 VSUBS 32.7164f
Cext_399 \$202 \$229 636.336a
Cext_400 \$202 inn|out|vped 8.28455f
Cext_401 \$202 inp$1 7.43578f
Cext_402 \$202 vdd 5.16353f
Cext_403 \$202 vss 0.57638a
Cext_404 \$202 VSUBS 6.21154f
Cext_405 \$203 \$204 28.7835a
Cext_406 \$203 inn 0.72091a
Cext_407 \$203 inp$1 16.6503a
Cext_408 \$203 vss 2.22579a
Cext_409 \$203 VSUBS 908.543a
Cext_410 \$204 \$205 28.7835a
Cext_411 \$204 inn 1.02212a
Cext_412 \$204 inp$1 1.25174a
Cext_413 \$204 VSUBS 890.098a
Cext_414 \$205 \$206 28.7835a
Cext_415 \$205 inn 1.02212a
Cext_416 \$205 inp$1 1.25174a
Cext_417 \$205 VSUBS 890.098a
Cext_418 \$206 \$207 28.7835a
Cext_419 \$206 inn 1.02212a
Cext_420 \$206 inp$1 1.25174a
Cext_421 \$206 VSUBS 890.098a
Cext_422 \$207 \$208 28.7835a
Cext_423 \$207 inn 1.02212a
Cext_424 \$207 inp$1 1.25174a
Cext_425 \$207 VSUBS 890.098a
Cext_426 \$208 inn 1.02212a
Cext_427 \$208 inp$1 1.25174a
Cext_428 \$208 VSUBS 890.098a
Cext_429 \$209 \$210 28.7835a
Cext_430 \$209 inn 13.6649a
Cext_431 \$209 inp$1 1.1216a
Cext_432 \$209 VSUBS 890.079a
Cext_433 \$210 \$211 28.7835a
Cext_434 \$210 inn 1.02212a
Cext_435 \$210 inp$1 1.25174a
Cext_436 \$210 VSUBS 890.098a
Cext_437 \$211 \$212 28.7835a
Cext_438 \$211 inn 1.02212a
Cext_439 \$211 inp$1 1.25174a
Cext_440 \$211 VSUBS 890.098a
Cext_441 \$212 \$213 28.7835a
Cext_442 \$212 inn 1.02212a
Cext_443 \$212 inp$1 1.25174a
Cext_444 \$212 VSUBS 890.098a
Cext_445 \$213 \$214 28.7835a
Cext_446 \$213 inn 0.72091a
Cext_447 \$213 inp$1 1.1216a
Cext_448 \$213 VSUBS 890.079a
Cext_449 \$214 \$215 28.7835a
Cext_450 \$214 inn 13.0489a
Cext_451 \$214 inp$1 14.2927a
Cext_452 \$214 VSUBS 890.06a
Cext_453 \$215 \$216 28.7835a
Cext_454 \$215 inp$1 13.5491a
Cext_455 \$215 VSUBS 890.079a
Cext_456 \$216 \$217 28.7835a
Cext_457 \$216 VSUBS 890.098a
Cext_458 \$217 \$218 28.7835a
Cext_459 \$217 VSUBS 890.098a
Cext_460 \$218 \$219 28.7835a
Cext_461 \$218 VSUBS 890.098a
Cext_462 \$219 \$220 28.7835a
Cext_463 \$219 VSUBS 890.079a
Cext_464 \$22 \$23 28.7835a
Cext_465 \$22 sense_n 79.1669a
Cext_466 \$22 sense_p 56.171a
Cext_467 \$22 vss 53.6189a
Cext_468 \$22 VSUBS 858.397a
Cext_469 \$220 \$221 28.7835a
Cext_470 \$220 VSUBS 890.079a
Cext_471 \$221 \$222 28.7835a
Cext_472 \$221 VSUBS 890.098a
Cext_473 \$222 \$223 28.7835a
Cext_474 \$222 VSUBS 890.098a
Cext_475 \$223 \$224 28.7835a
Cext_476 \$223 VSUBS 890.098a
Cext_477 \$224 \$225 28.7835a
Cext_478 \$224 VSUBS 890.098a
Cext_479 \$225 VSUBS 908.974a
Cext_480 \$229 inn|out|vped 25.9562f
Cext_481 \$229 inp$1 699.548a
Cext_482 \$229 iptat|vbn 71.9816a
Cext_483 \$229 isense|out 4.0948a
Cext_484 \$229 vdd 444.371a
Cext_485 \$229 vss 330.248a
Cext_486 \$229 VSUBS 2.2978f
Cext_487 \$23 \$24 28.7835a
Cext_488 \$23 sense_n 79.1669a
Cext_489 \$23 sense_p 16.6685a
Cext_490 \$23 vss 53.6189a
Cext_491 \$23 VSUBS 858.397a
Cext_492 \$24 \$25 28.7835a
Cext_493 \$24 sense_n 79.1669a
Cext_494 \$24 sense_p 15.7342a
Cext_495 \$24 vss 53.6189a
Cext_496 \$24 VSUBS 858.397a
Cext_497 \$243 \$244 5.68933f
Cext_498 \$243 \$245 1.93792f
Cext_499 \$243 \$246 4.37941f
Cext_500 \$243 \$247 1.30439a
Cext_501 \$243 \$249 5.2825f
Cext_502 \$243 \$250 3.59141f
Cext_503 \$243 \$315 5.60355f
Cext_504 \$243 \$316 4.97002f
Cext_505 \$243 \$326 65.7574a
Cext_506 \$243 \$332 338.807a
Cext_507 \$243 inn|out|vped 0.13223a
Cext_508 \$243 inn|out|vref_buf 3.5165f
Cext_509 \$243 inp|vref 72.0384a
Cext_510 \$243 iptat|vbn 466.031a
Cext_511 \$243 vdd 959.591a
Cext_512 \$243 vss 846.778a
Cext_513 \$243 VSUBS 32.7119f
Cext_514 \$244 \$245 695.042a
Cext_515 \$244 \$246 1.78423f
Cext_516 \$244 \$247 81.65a
Cext_517 \$244 \$249 286.223a
Cext_518 \$244 \$250 137.593a
Cext_519 \$244 \$326 7.38946f
Cext_520 \$244 \$332 291.726a
Cext_521 \$244 inn|out|vped 0.10451a
Cext_522 \$244 inn|out|vref_buf 711.053a
Cext_523 \$244 inp|vref 557.647a
Cext_524 \$244 iptat|vbn 418.944a
Cext_525 \$244 vdd 7.61671f
Cext_526 \$244 vss 546.872a
Cext_527 \$244 VSUBS 27.3068f
Cext_528 \$245 \$246 2.01779f
Cext_529 \$245 \$247 465.164a
Cext_530 \$245 \$249 1.68398f
Cext_531 \$245 \$250 0.966982a
Cext_532 \$245 \$315 4.3649a
Cext_533 \$245 \$326 1.4372f
Cext_534 \$245 \$332 103.033a
Cext_535 \$245 inn|out|vped 0.172488a
Cext_536 \$245 inn|out|vref_buf 8.67093f
Cext_537 \$245 inp|vref 997.702a
Cext_538 \$245 iptat|vbn 4.5513f
Cext_539 \$245 vdd 9.09587f
Cext_540 \$245 vss 2.78817f
Cext_541 \$245 VSUBS 8.01601f
Cext_542 \$246 \$247 1.83357f
Cext_543 \$246 \$249 3.15168f
Cext_544 \$246 \$250 2.37443f
Cext_545 \$246 \$315 0.441084a
Cext_546 \$246 \$316 0.220542a
Cext_547 \$246 \$326 263.257a
Cext_548 \$246 \$332 170.258a
Cext_549 \$246 inn|out|vref_buf 279.326a
Cext_550 \$246 inp|vref 92.3065a
Cext_551 \$246 iptat|vbn 1.23563f
Cext_552 \$246 vdd 913.163a
Cext_553 \$246 vss 4.48555f
Cext_554 \$246 VSUBS 18.7663f
Cext_555 \$247 \$249 56.3514a
Cext_556 \$247 \$250 3.29635f
Cext_557 \$247 \$316 4.74202a
Cext_558 \$247 \$326 2.60276f
Cext_559 \$247 \$332 206.331a
Cext_560 \$247 inn|out|vped 0.10451a
Cext_561 \$247 inn|out|vref_buf 3.28718f
Cext_562 \$247 inp|vref 8.68417f
Cext_563 \$247 iptat|vbn 5.16367f
Cext_564 \$247 vdd 7.9618f
Cext_565 \$247 vss 2.75716f
Cext_566 \$247 VSUBS 7.96326f
Cext_567 \$249 \$250 1.61266f
Cext_568 \$249 \$315 6.12058f
Cext_569 \$249 \$316 3.67869f
Cext_570 \$249 \$326 1.51285a
Cext_571 \$249 \$332 54.6553a
Cext_572 \$249 inn|out|vref_buf 1.87683f
Cext_573 \$249 inp|vref 44.448a
Cext_574 \$249 iptat|vbn 78.0763a
Cext_575 \$249 vdd 12.1579f
Cext_576 \$249 vss 1.30411f
Cext_577 \$249 VSUBS 34.4511f
Cext_578 \$25 \$26 28.7835a
Cext_579 \$25 sense_n 79.1669a
Cext_580 \$25 sense_p 15.7342a
Cext_581 \$25 vss 53.6189a
Cext_582 \$25 VSUBS 858.397a
Cext_583 \$250 \$316 2.44226f
Cext_584 \$250 \$326 776.999a
Cext_585 \$250 \$332 1.04438f
Cext_586 \$250 inn|out|vref_buf 13.805f
Cext_587 \$250 inp|vref 713.207a
Cext_588 \$250 iptat|vbn 374.264a
Cext_589 \$250 isense|out 0.642539a
Cext_590 \$250 vdd 11.1361f
Cext_591 \$250 vss 1.3079f
Cext_592 \$250 VSUBS 34.702f
Cext_593 \$26 \$27 28.7835a
Cext_594 \$26 sense_n 79.1669a
Cext_595 \$26 sense_p 15.7342a
Cext_596 \$26 vss 53.6189a
Cext_597 \$26 VSUBS 858.397a
Cext_598 \$27 \$28 28.7835a
Cext_599 \$27 sense_n 79.1669a
Cext_600 \$27 sense_p 15.7342a
Cext_601 \$27 vss 53.6189a
Cext_602 \$27 VSUBS 858.397a
Cext_603 \$28 \$29 28.7835a
Cext_604 \$28 sense_n 79.1669a
Cext_605 \$28 sense_p 15.7342a
Cext_606 \$28 vss 53.6189a
Cext_607 \$28 VSUBS 858.397a
Cext_608 \$29 \$30 28.7835a
Cext_609 \$29 sense_n 79.1669a
Cext_610 \$29 sense_p 15.7342a
Cext_611 \$29 vss 53.6189a
Cext_612 \$29 VSUBS 858.397a
Cext_613 \$3 \$34 286.223a
Cext_614 \$3 \$35 137.593a
Cext_615 \$3 \$4 1.78423f
Cext_616 \$3 \$5 695.042a
Cext_617 \$3 \$6 81.65a
Cext_618 \$3 \$68 7.38946f
Cext_619 \$3 \$75 291.726a
Cext_620 \$3 inn 96.0317a
Cext_621 \$3 inp$1 469.847a
Cext_622 \$3 iptat|vbn 419.144a
Cext_623 \$3 isense|out 682.96a
Cext_624 \$3 vdd 7.61671f
Cext_625 \$3 vss 550.753a
Cext_626 \$3 VSUBS 27.3052f
Cext_627 \$30 \$31 28.7835a
Cext_628 \$30 sense_n 79.1669a
Cext_629 \$30 sense_p 15.7342a
Cext_630 \$30 vss 53.6189a
Cext_631 \$30 VSUBS 858.397a
Cext_632 \$31 \$32 28.7835a
Cext_633 \$31 sense_n 79.1669a
Cext_634 \$31 sense_p 15.7342a
Cext_635 \$31 vss 53.6189a
Cext_636 \$31 VSUBS 858.397a
Cext_637 \$315 \$316 185.733a
Cext_638 \$315 \$332 29.5855a
Cext_639 \$315 inn|out|vref_buf 539.472a
Cext_640 \$315 inp|vref 16.3a
Cext_641 \$315 vdd 6.77016f
Cext_642 \$315 vss 19.3341a
Cext_643 \$315 VSUBS 3.39035f
Cext_644 \$316 \$332 27.9988a
Cext_645 \$316 inn|out|vref_buf 701.209a
Cext_646 \$316 inp|vref 16.3a
Cext_647 \$316 vdd 6.77016f
Cext_648 \$316 vss 23.7652a
Cext_649 \$316 VSUBS 3.39125f
Cext_650 \$32 sense_n 79.1669a
Cext_651 \$32 sense_p 15.7342a
Cext_652 \$32 vss 53.6189a
Cext_653 \$32 VSUBS 858.397a
Cext_654 \$326 \$332 636.336a
Cext_655 \$326 inn|out|vref_buf 8.28143f
Cext_656 \$326 inp|vref 7.4382f
Cext_657 \$326 vdd 5.16353f
Cext_658 \$326 vss 0.57638a
Cext_659 \$326 VSUBS 6.21154f
Cext_660 \$332 inn|out|vref_buf 25.9562f
Cext_661 \$332 inp|vref 699.548a
Cext_662 \$332 iptat|vbn 51.4496a
Cext_663 \$332 isense|out 11.6406a
Cext_664 \$332 vdd 444.371a
Cext_665 \$332 vss 330.248a
Cext_666 \$332 VSUBS 2.30651f
Cext_667 \$34 \$35 1.61266f
Cext_668 \$34 \$4 3.15168f
Cext_669 \$34 \$5 1.68398f
Cext_670 \$34 \$57 6.12058f
Cext_671 \$34 \$58 3.67869f
Cext_672 \$34 \$6 56.3514a
Cext_673 \$34 \$68 1.51285a
Cext_674 \$34 \$75 54.6553a
Cext_675 \$34 inn 174.127a
Cext_676 \$34 inp$1 44.448a
Cext_677 \$34 iptat|vbn 78.0763a
Cext_678 \$34 isense|out 1.7027f
Cext_679 \$34 vdd 12.1579f
Cext_680 \$34 vss 1.30411f
Cext_681 \$34 VSUBS 34.4511f
Cext_682 \$35 \$4 2.37443f
Cext_683 \$35 \$5 0.966982a
Cext_684 \$35 \$58 2.44226f
Cext_685 \$35 \$6 3.29635f
Cext_686 \$35 \$68 776.999a
Cext_687 \$35 \$75 1.04438f
Cext_688 \$35 inn 485.172a
Cext_689 \$35 inp$1 608.21a
Cext_690 \$35 iptat|vbn 376a
Cext_691 \$35 isense|out 13.4016f
Cext_692 \$35 vdd 11.1361f
Cext_693 \$35 vss 1.3079f
Cext_694 \$35 VSUBS 34.702f
Cext_695 \$351 \$352 42.5678a
Cext_696 \$351 \$353 3.0652a
Cext_697 \$351 \$354 2.1309a
Cext_698 \$351 \$355 2.1309a
Cext_699 \$351 \$356 2.1309a
Cext_700 \$351 \$357 2.1309a
Cext_701 \$351 \$358 2.1309a
Cext_702 \$351 \$359 2.1309a
Cext_703 \$351 \$360 2.1309a
Cext_704 \$351 \$361 2.1309a
Cext_705 \$351 \$362 2.1309a
Cext_706 \$351 \$363 2.1309a
Cext_707 \$351 \$364 2.1309a
Cext_708 \$351 \$365 2.1309a
Cext_709 \$351 \$366 40.4369a
Cext_710 \$351 \$367 0.934295a
Cext_711 \$351 inn|out|vped 45.9221a
Cext_712 \$351 inn|out|vref_buf 46.3596a
Cext_713 \$351 inp$1 9.34707f
Cext_714 \$351 isense|out 511.837a
Cext_715 \$351 vdd 30.2984a
Cext_716 \$351 vss 13.7095f
Cext_717 \$351 VSUBS 2.99008f
Cext_718 \$352 \$353 28.7835a
Cext_719 \$352 inn|out|vped 5.68486a
Cext_720 \$352 inn|out|vref_buf 3.89865a
Cext_721 \$352 inp$1 2.82353a
Cext_722 \$352 isense|out 15.7342a
Cext_723 \$352 vss 24.5892a
Cext_724 \$352 VSUBS 888.636a
Cext_725 \$353 \$354 28.7835a
Cext_726 \$353 inn|out|vped 5.68486a
Cext_727 \$353 inn|out|vref_buf 3.89865a
Cext_728 \$353 inp$1 2.82353a
Cext_729 \$353 isense|out 15.7342a
Cext_730 \$353 vss 24.5892a
Cext_731 \$353 VSUBS 888.636a
Cext_732 \$354 \$355 28.7835a
Cext_733 \$354 inn|out|vped 5.68486a
Cext_734 \$354 inn|out|vref_buf 3.89865a
Cext_735 \$354 inp$1 2.82353a
Cext_736 \$354 isense|out 15.7342a
Cext_737 \$354 vss 24.5892a
Cext_738 \$354 VSUBS 888.636a
Cext_739 \$355 \$356 28.7835a
Cext_740 \$355 inn|out|vped 5.68486a
Cext_741 \$355 inn|out|vref_buf 3.89865a
Cext_742 \$355 inp$1 2.82353a
Cext_743 \$355 isense|out 15.7342a
Cext_744 \$355 vss 24.5892a
Cext_745 \$355 VSUBS 888.636a
Cext_746 \$356 \$357 28.7835a
Cext_747 \$356 inn|out|vped 5.68486a
Cext_748 \$356 inn|out|vref_buf 3.89865a
Cext_749 \$356 inp$1 2.82353a
Cext_750 \$356 isense|out 15.7342a
Cext_751 \$356 vss 24.5892a
Cext_752 \$356 VSUBS 888.636a
Cext_753 \$357 inn|out|vped 5.68486a
Cext_754 \$357 inn|out|vref_buf 3.89865a
Cext_755 \$357 inp$1 2.82353a
Cext_756 \$357 isense|out 15.7342a
Cext_757 \$357 vss 24.5892a
Cext_758 \$357 VSUBS 888.636a
Cext_759 \$358 \$359 28.7835a
Cext_760 \$358 inn|out|vped 5.68486a
Cext_761 \$358 inn|out|vref_buf 3.89865a
Cext_762 \$358 inp$1 2.82353a
Cext_763 \$358 isense|out 15.7342a
Cext_764 \$358 vss 24.5892a
Cext_765 \$358 VSUBS 888.636a
Cext_766 \$359 \$360 28.7835a
Cext_767 \$359 inn|out|vped 5.68486a
Cext_768 \$359 inn|out|vref_buf 3.89865a
Cext_769 \$359 inp$1 2.82353a
Cext_770 \$359 isense|out 15.7342a
Cext_771 \$359 vss 24.5892a
Cext_772 \$359 VSUBS 888.636a
Cext_773 \$360 \$361 28.7835a
Cext_774 \$360 inn|out|vped 6.61916a
Cext_775 \$360 inn|out|vref_buf 3.89865a
Cext_776 \$360 inp$1 2.82353a
Cext_777 \$360 isense|out 15.7342a
Cext_778 \$360 vss 24.5892a
Cext_779 \$360 VSUBS 888.636a
Cext_780 \$361 inn|out|vped 46.1217a
Cext_781 \$361 inn|out|vref_buf 3.89865a
Cext_782 \$361 inp$1 2.82353a
Cext_783 \$361 isense|out 15.7342a
Cext_784 \$361 vss 24.5892a
Cext_785 \$361 VSUBS 888.636a
Cext_786 \$362 \$363 28.7835a
Cext_787 \$362 isense|out 39.9149a
Cext_788 \$362 vss 24.5892a
Cext_789 \$362 VSUBS 888.636a
Cext_790 \$363 \$364 28.7835a
Cext_791 \$363 isense|out 39.9149a
Cext_792 \$363 vss 24.5892a
Cext_793 \$363 VSUBS 888.636a
Cext_794 \$364 \$365 28.7835a
Cext_795 \$364 isense|out 40.8492a
Cext_796 \$364 vss 24.5892a
Cext_797 \$364 VSUBS 888.636a
Cext_798 \$365 isense|out 80.3517a
Cext_799 \$365 vss 24.5892a
Cext_800 \$365 VSUBS 888.636a
Cext_801 \$366 \$367 28.7835a
Cext_802 \$366 vss 27.0818a
Cext_803 \$366 VSUBS 888.636a
Cext_804 \$367 \$368 28.7835a
Cext_805 \$367 vss 27.0818a
Cext_806 \$367 VSUBS 888.636a
Cext_807 \$368 \$369 28.7835a
Cext_808 \$368 vss 27.0818a
Cext_809 \$368 VSUBS 888.636a
Cext_810 \$369 \$370 28.7835a
Cext_811 \$369 vss 28.0161a
Cext_812 \$369 VSUBS 888.636a
Cext_813 \$370 vss 67.5186a
Cext_814 \$370 VSUBS 888.636a
Cext_815 \$4 \$5 2.01779f
Cext_816 \$4 \$57 0.441084a
Cext_817 \$4 \$58 0.220542a
Cext_818 \$4 \$6 1.83357f
Cext_819 \$4 \$68 263.257a
Cext_820 \$4 \$75 170.258a
Cext_821 \$4 inn 70.4886a
Cext_822 \$4 inp$1 92.0037a
Cext_823 \$4 iptat|vbn 1.24586f
Cext_824 \$4 isense|out 197.412a
Cext_825 \$4 vdd 913.163a
Cext_826 \$4 vss 4.49669f
Cext_827 \$4 VSUBS 18.7667f
Cext_828 \$5 \$57 4.3649a
Cext_829 \$5 \$6 465.164a
Cext_830 \$5 \$68 1.4372f
Cext_831 \$5 \$75 103.033a
Cext_832 \$5 inn 7.89555f
Cext_833 \$5 inp$1 997.702a
Cext_834 \$5 iptat|vbn 4.76738f
Cext_835 \$5 isense|out 504.596a
Cext_836 \$5 vdd 9.09137f
Cext_837 \$5 vss 2.80722f
Cext_838 \$5 VSUBS 8.05144f
Cext_839 \$57 \$58 185.733a
Cext_840 \$57 \$75 29.5855a
Cext_841 \$57 inn 127.338a
Cext_842 \$57 inp$1 16.3a
Cext_843 \$57 isense|out 412.134a
Cext_844 \$57 vdd 6.77016f
Cext_845 \$57 vss 19.3341a
Cext_846 \$57 VSUBS 3.39035f
Cext_847 \$58 \$6 4.74202a
Cext_848 \$58 \$75 27.9988a
Cext_849 \$58 inn 135.256a
Cext_850 \$58 inp$1 16.3a
Cext_851 \$58 isense|out 565.953a
Cext_852 \$58 vdd 6.77016f
Cext_853 \$58 vss 23.7652a
Cext_854 \$58 VSUBS 3.39125f
Cext_855 \$6 \$68 2.60276f
Cext_856 \$6 \$75 206.331a
Cext_857 \$6 inn 927.311a
Cext_858 \$6 inp$1 8.68417f
Cext_859 \$6 iptat|vbn 5.41275f
Cext_860 \$6 isense|out 2.07089f
Cext_861 \$6 vdd 7.9618f
Cext_862 \$6 vss 2.77191f
Cext_863 \$6 VSUBS 8.00449f
Cext_864 \$68 \$75 636.336a
Cext_865 \$68 inn 5.24503f
Cext_866 \$68 inp$1 7.43578f
Cext_867 \$68 isense|out 3.03824f
Cext_868 \$68 vdd 5.16353f
Cext_869 \$68 vss 0.57638a
Cext_870 \$68 VSUBS 6.21154f
Cext_871 \$75 inn 668.305a
Cext_872 \$75 inp$1 702.569a
Cext_873 \$75 iptat|vbn 71.9523a
Cext_874 \$75 isense|out 24.8871f
Cext_875 \$75 vdd 444.301a
Cext_876 \$75 vss 330.231a
Cext_877 \$75 VSUBS 2.29408f
Cext_878 \$8 \$9 28.7835a
Cext_879 \$8 vss 55.8447a
Cext_880 \$8 VSUBS 876.861a
Cext_881 \$9 vss 53.6189a
Cext_882 \$9 VSUBS 858.397a
Cext_883 inn inn|out|vped 298.351a
Cext_884 inn inp$1 15.9213f
Cext_885 inn iptat|vbn 3.63261f
Cext_886 inn isense|out 5.2024f
Cext_887 inn vdd 703.675a
Cext_888 inn vss 313.12a
Cext_889 inn|out|vped inn|out|vref_buf 13.0031f
Cext_890 inn|out|vped inp$1 12.0969f
Cext_891 inn|out|vped inp|vref 100.025a
Cext_892 inn|out|vped iptat|vbn 5.34149f
Cext_893 inn|out|vped isense|out 1.32533f
Cext_894 inn|out|vped vdd 9.17952f
Cext_895 inn|out|vped vss 6.53995f
Cext_896 inn|out|vref_buf inp$1 14.665f
Cext_897 inn|out|vref_buf inp|vref 7.38296f
Cext_898 inn|out|vref_buf iptat|vbn 5.65772f
Cext_899 inn|out|vref_buf isense|out 337.211a
Cext_900 inn|out|vref_buf vdd 8.66436f
Cext_901 inn|out|vref_buf vss 7.55178f
Cext_902 inp$1 inp|vref 99.9546a
Cext_903 inp$1 iptat|vbn 124.344a
Cext_904 inp$1 isense|out 5.05723f
Cext_905 inp$1 vdd 1.18801f
Cext_906 inp$1 vss 1.80983f
Cext_907 inp|vref isense|out 156.172a
Cext_908 inp|vref vdd 1.32734f
Cext_909 inp|vref vss 1.76698f
Cext_910 iptat|vbn isense|out 6.58395f
Cext_911 iptat|vbn vdd 1.49664f
Cext_912 iptat|vbn vss 37.152f
Cext_913 isense|out vdd 8.57406f
Cext_914 isense|out vss 6.32093f
Cext_915 sense_n sense_p 10.9643f
Cext_916 sense_n vss 204.723a
Cext_917 sense_p vss 317.301a
Cext_918 vdd vss 44.5306f
Cext_919 VSUBS inn 32.2801f
Cext_920 VSUBS inn|out|vped 44.7312f
Cext_921 VSUBS inn|out|vref_buf 44.8196f
Cext_922 VSUBS inp$1 63.0777f
Cext_923 VSUBS inp|vref 35.6348f
Cext_924 VSUBS iptat|vbn 148.353f
Cext_925 VSUBS isense|out 22.4734f
Cext_926 VSUBS sense_n 3.99032f
Cext_927 VSUBS sense_p 2.70136f
Cext_928 VSUBS vdd 155.299f
Cext_929 VSUBS vss 282.343f
.ENDS g1_sense
