*********************************************************
*** NGSPICE file created by KLayout-PEX 0.3.12
*** -----------------------------------------------------
***     Extraction Engine: KPEX/2.5D
***     Technology: ihp_sg13g2
***     Date: 2026-09-19 09:40:11
*********************************************************

.SUBCKT g1_sense iptat isense sense_n sense_p vdd vped vref vref_buf vss
X$1 vss iptat isense vdd \$30 \$31 g1_ota
X$2 vss iptat vref_buf vdd vref_buf vref g1_ota
X$3 vss iptat vped vdd vped \$40 g1_ota
M$1 iptat iptat vss vss sg13_hv_nmos L=1U W=3.3U AS=1.122P AD=1.122P PS=7.28U
+ PD=7.28U rfmode=0
R$2 \$8 \$40 vss 2 rppd l=76.7 ps=0 b=0 m=1
R$3 \$63 vss vss 2 rppd l=76.7 ps=0 b=0 m=1
R$4 sense_n \$30 vss 2 rppd l=76.7 ps=0 b=0 m=1
R$5 \$19 \$31 vss 2 rppd l=76.7 ps=0 b=0 m=1
R$6 \$19 \$57 vss 2 rppd l=76.7 ps=0 b=0 m=1
R$7 \$20 \$57 vss 2 rppd l=76.7 ps=0 b=0 m=1
R$8 \$20 \$56 vss 2 rppd l=76.7 ps=0 b=0 m=1
R$9 \$21 \$56 vss 2 rppd l=76.7 ps=0 b=0 m=1
R$10 \$21 \$61 vss 2 rppd l=76.7 ps=0 b=0 m=1
R$11 \$22 \$61 vss 2 rppd l=76.7 ps=0 b=0 m=1
R$12 \$22 \$60 vss 2 rppd l=76.7 ps=0 b=0 m=1
R$13 \$23 \$60 vss 2 rppd l=76.7 ps=0 b=0 m=1
R$14 \$23 \$41 vss 2 rppd l=76.7 ps=0 b=0 m=1
R$15 \$24 \$35 vss 2 rppd l=76.7 ps=0 b=0 m=1
R$16 \$24 \$46 vss 2 rppd l=76.7 ps=0 b=0 m=1
R$17 \$25 \$46 vss 2 rppd l=76.7 ps=0 b=0 m=1
R$18 \$25 \$47 vss 2 rppd l=76.7 ps=0 b=0 m=1
R$19 \$26 \$47 vss 2 rppd l=76.7 ps=0 b=0 m=1
R$20 \$26 \$43 vss 2 rppd l=76.7 ps=0 b=0 m=1
R$21 \$27 \$43 vss 2 rppd l=76.7 ps=0 b=0 m=1
R$22 \$27 \$44 vss 2 rppd l=76.7 ps=0 b=0 m=1
R$23 \$28 \$44 vss 2 rppd l=76.7 ps=0 b=0 m=1
R$24 \$28 \$45 vss 2 rppd l=76.7 ps=0 b=0 m=1
R$25 \$3 \$42 vss 2 rppd l=76.7 ps=0 b=0 m=1
R$26 sense_p \$31 vss 2 rppd l=76.7 ps=0 b=0 m=1
R$27 \$8 \$50 vss 2 rppd l=76.7 ps=0 b=0 m=1
R$28 \$9 \$50 vss 2 rppd l=76.7 ps=0 b=0 m=1
R$29 \$9 \$49 vss 2 rppd l=76.7 ps=0 b=0 m=1
R$30 \$10 \$49 vss 2 rppd l=76.7 ps=0 b=0 m=1
R$31 \$10 \$48 vss 2 rppd l=76.7 ps=0 b=0 m=1
R$32 \$11 \$48 vss 2 rppd l=76.7 ps=0 b=0 m=1
R$33 \$11 \$53 vss 2 rppd l=76.7 ps=0 b=0 m=1
R$34 \$12 \$53 vss 2 rppd l=76.7 ps=0 b=0 m=1
R$35 \$12 \$52 vss 2 rppd l=76.7 ps=0 b=0 m=1
R$36 \$13 \$52 vss 2 rppd l=76.7 ps=0 b=0 m=1
R$37 \$29 \$45 vss 2 rppd l=76.7 ps=0 b=0 m=1
R$38 \$3 \$51 vss 2 rppd l=76.7 ps=0 b=0 m=1
R$39 \$14 \$30 vss 2 rppd l=76.7 ps=0 b=0 m=1
R$40 \$14 \$58 vss 2 rppd l=76.7 ps=0 b=0 m=1
R$41 \$15 \$58 vss 2 rppd l=76.7 ps=0 b=0 m=1
R$42 \$15 \$59 vss 2 rppd l=76.7 ps=0 b=0 m=1
R$43 \$16 \$59 vss 2 rppd l=76.7 ps=0 b=0 m=1
R$44 \$16 \$55 vss 2 rppd l=76.7 ps=0 b=0 m=1
R$45 \$17 \$55 vss 2 rppd l=76.7 ps=0 b=0 m=1
R$46 \$17 \$54 vss 2 rppd l=76.7 ps=0 b=0 m=1
R$47 \$18 \$54 vss 2 rppd l=76.7 ps=0 b=0 m=1
R$48 \$18 \$34 vss 2 rppd l=76.7 ps=0 b=0 m=1
R$49 \$13 \$51 vss 2 rppd l=76.7 ps=0 b=0 m=1
R$50 \$74 \$40 vss 2 rppd l=76.7 ps=0 b=0 m=1
R$51 \$73 \$34 vss 2 rppd l=76.7 ps=0 b=0 m=1
R$52 \$73 \$110 vss 2 rppd l=76.7 ps=0 b=0 m=1
R$53 \$78 \$110 vss 2 rppd l=76.7 ps=0 b=0 m=1
R$54 \$78 \$111 vss 2 rppd l=76.7 ps=0 b=0 m=1
R$55 \$77 \$111 vss 2 rppd l=76.7 ps=0 b=0 m=1
R$56 \$77 \$109 vss 2 rppd l=76.7 ps=0 b=0 m=1
R$57 \$76 \$109 vss 2 rppd l=76.7 ps=0 b=0 m=1
R$58 \$76 \$108 vss 2 rppd l=76.7 ps=0 b=0 m=1
R$59 \$81 \$108 vss 2 rppd l=76.7 ps=0 b=0 m=1
R$60 \$81 isense vss 2 rppd l=76.7 ps=0 b=0 m=1
R$61 \$74 vref_buf vss 2 rppd l=76.7 ps=0 b=0 m=1
R$62 \$80 \$106 vss 2 rppd l=76.7 ps=0 b=0 m=1
R$63 \$79 \$106 vss 2 rppd l=76.7 ps=0 b=0 m=1
R$64 \$79 \$107 vss 2 rppd l=76.7 ps=0 b=0 m=1
R$65 \$84 \$107 vss 2 rppd l=76.7 ps=0 b=0 m=1
R$66 \$84 \$93 vss 2 rppd l=76.7 ps=0 b=0 m=1
R$67 \$83 \$93 vss 2 rppd l=76.7 ps=0 b=0 m=1
R$68 \$83 \$94 vss 2 rppd l=76.7 ps=0 b=0 m=1
R$69 \$82 \$94 vss 2 rppd l=76.7 ps=0 b=0 m=1
R$70 \$82 \$95 vss 2 rppd l=76.7 ps=0 b=0 m=1
R$71 \$63 \$95 vss 2 rppd l=76.7 ps=0 b=0 m=1
R$72 \$80 \$87 vss 2 rppd l=76.7 ps=0 b=0 m=1
R$73 \$29 \$42 vss 2 rppd l=76.7 ps=0 b=0 m=1
R$74 \$64 \$96 vss 2 rppd l=76.7 ps=0 b=0 m=1
R$75 \$65 \$96 vss 2 rppd l=76.7 ps=0 b=0 m=1
R$76 \$65 \$100 vss 2 rppd l=76.7 ps=0 b=0 m=1
R$77 \$66 \$100 vss 2 rppd l=76.7 ps=0 b=0 m=1
R$78 \$66 \$99 vss 2 rppd l=76.7 ps=0 b=0 m=1
R$79 \$67 \$99 vss 2 rppd l=76.7 ps=0 b=0 m=1
R$80 \$67 \$98 vss 2 rppd l=76.7 ps=0 b=0 m=1
R$81 \$68 \$98 vss 2 rppd l=76.7 ps=0 b=0 m=1
R$82 \$68 \$97 vss 2 rppd l=76.7 ps=0 b=0 m=1
R$83 \$69 \$97 vss 2 rppd l=76.7 ps=0 b=0 m=1
R$84 \$69 \$101 vss 2 rppd l=76.7 ps=0 b=0 m=1
R$85 \$35 \$101 vss 2 rppd l=76.7 ps=0 b=0 m=1
R$86 \$62 \$41 vss 2 rppd l=76.7 ps=0 b=0 m=1
R$87 \$62 \$104 vss 2 rppd l=76.7 ps=0 b=0 m=1
R$88 \$72 \$104 vss 2 rppd l=76.7 ps=0 b=0 m=1
R$89 \$72 \$103 vss 2 rppd l=76.7 ps=0 b=0 m=1
R$90 \$71 \$103 vss 2 rppd l=76.7 ps=0 b=0 m=1
R$91 \$71 \$102 vss 2 rppd l=76.7 ps=0 b=0 m=1
R$92 \$70 \$102 vss 2 rppd l=76.7 ps=0 b=0 m=1
R$93 \$70 \$105 vss 2 rppd l=76.7 ps=0 b=0 m=1
R$94 \$75 \$105 vss 2 rppd l=76.7 ps=0 b=0 m=1
R$95 \$64 \$87 vss 2 rppd l=76.7 ps=0 b=0 m=1
R$96 \$75 vped vss 2 rppd l=76.7 ps=0 b=0 m=1
Cext_1 \$10 \$11 28.7835a
Cext_2 \$10 \$9 28.7835a
Cext_3 \$10 vss 53.6189a
Cext_4 \$10 VSUBS 858.397a
Cext_5 \$100 \$34 79.1669a
Cext_6 \$100 \$40 2.82353a
Cext_7 \$100 \$41 8.94579a
Cext_8 \$100 \$87 3.0652a
Cext_9 \$100 \$96 28.7835a
Cext_10 \$100 \$99 28.7835a
Cext_11 \$100 isense 15.7342a
Cext_12 \$100 vped 5.68486a
Cext_13 \$100 vref_buf 3.89865a
Cext_14 \$100 vss 24.5892a
Cext_15 \$100 VSUBS 888.636a
Cext_16 \$101 \$34 79.1669a
Cext_17 \$101 \$40 2.82353a
Cext_18 \$101 \$41 49.3827a
Cext_19 \$101 \$87 2.1309a
Cext_20 \$101 \$97 28.7835a
Cext_21 \$101 isense 15.7342a
Cext_22 \$101 vped 5.68486a
Cext_23 \$101 vref_buf 3.89865a
Cext_24 \$101 vss 24.5892a
Cext_25 \$101 VSUBS 888.636a
Cext_26 \$102 \$103 28.7835a
Cext_27 \$102 \$105 28.7835a
Cext_28 \$102 \$34 79.1669a
Cext_29 \$102 \$40 2.82353a
Cext_30 \$102 \$87 2.1309a
Cext_31 \$102 isense 15.7342a
Cext_32 \$102 vped 6.61916a
Cext_33 \$102 vref_buf 3.89865a
Cext_34 \$102 vss 24.5892a
Cext_35 \$102 VSUBS 888.636a
Cext_36 \$103 \$104 28.7835a
Cext_37 \$103 \$34 79.1669a
Cext_38 \$103 \$40 2.82353a
Cext_39 \$103 \$41 0.934295a
Cext_40 \$103 \$87 2.1309a
Cext_41 \$103 isense 15.7342a
Cext_42 \$103 vped 5.68486a
Cext_43 \$103 vref_buf 3.89865a
Cext_44 \$103 vss 24.5892a
Cext_45 \$103 VSUBS 888.636a
Cext_46 \$104 \$34 79.1669a
Cext_47 \$104 \$40 2.82353a
Cext_48 \$104 \$41 40.4369a
Cext_49 \$104 \$87 2.1309a
Cext_50 \$104 isense 15.7342a
Cext_51 \$104 vped 5.68486a
Cext_52 \$104 vref_buf 3.89865a
Cext_53 \$104 vss 24.5892a
Cext_54 \$104 VSUBS 888.636a
Cext_55 \$105 \$34 79.1669a
Cext_56 \$105 \$40 2.82353a
Cext_57 \$105 \$87 2.1309a
Cext_58 \$105 isense 15.7342a
Cext_59 \$105 vped 46.1217a
Cext_60 \$105 vref_buf 3.89865a
Cext_61 \$105 vss 24.5892a
Cext_62 \$105 VSUBS 888.636a
Cext_63 \$106 \$107 28.7835a
Cext_64 \$106 \$87 40.4369a
Cext_65 \$106 vss 27.0818a
Cext_66 \$106 VSUBS 888.636a
Cext_67 \$107 \$87 0.934295a
Cext_68 \$107 \$93 28.7835a
Cext_69 \$107 vss 27.0818a
Cext_70 \$107 VSUBS 888.636a
Cext_71 \$108 \$109 28.7835a
Cext_72 \$108 \$87 2.1309a
Cext_73 \$108 isense 80.3517a
Cext_74 \$108 vss 24.5892a
Cext_75 \$108 VSUBS 888.636a
Cext_76 \$109 \$111 28.7835a
Cext_77 \$109 \$87 2.1309a
Cext_78 \$109 isense 40.8492a
Cext_79 \$109 vss 24.5892a
Cext_80 \$109 VSUBS 888.636a
Cext_81 \$11 \$12 28.7835a
Cext_82 \$11 vss 53.6189a
Cext_83 \$11 VSUBS 858.397a
Cext_84 \$110 \$111 28.7835a
Cext_85 \$110 \$34 40.4369a
Cext_86 \$110 \$87 2.1309a
Cext_87 \$110 isense 39.9149a
Cext_88 \$110 vss 24.5892a
Cext_89 \$110 VSUBS 888.636a
Cext_90 \$111 \$34 0.934295a
Cext_91 \$111 \$87 2.1309a
Cext_92 \$111 isense 39.9149a
Cext_93 \$111 vss 24.5892a
Cext_94 \$111 VSUBS 888.636a
Cext_95 \$12 \$13 28.7835a
Cext_96 \$12 \$3 0.934295a
Cext_97 \$12 vss 53.6189a
Cext_98 \$12 VSUBS 858.397a
Cext_99 \$13 \$3 40.4369a
Cext_100 \$13 vss 53.6189a
Cext_101 \$13 VSUBS 858.397a
Cext_102 \$14 \$15 28.7835a
Cext_103 \$14 \$3 62.9192a
Cext_104 \$14 vss 53.6189a
Cext_105 \$14 VSUBS 858.397a
Cext_106 \$15 \$16 28.7835a
Cext_107 \$15 \$3 23.4167a
Cext_108 \$15 vss 53.6189a
Cext_109 \$15 VSUBS 858.397a
Cext_110 \$16 \$17 28.7835a
Cext_111 \$16 \$3 22.4824a
Cext_112 \$16 vss 53.6189a
Cext_113 \$16 VSUBS 858.397a
Cext_114 \$17 \$18 28.7835a
Cext_115 \$17 \$3 22.4824a
Cext_116 \$17 sense_n 0.934295a
Cext_117 \$17 vss 53.6189a
Cext_118 \$17 VSUBS 858.397a
Cext_119 \$18 \$3 22.4824a
Cext_120 \$18 sense_n 40.4369a
Cext_121 \$18 vss 53.6189a
Cext_122 \$18 VSUBS 858.397a
Cext_123 \$19 \$2 15.8475f
Cext_124 \$19 \$20 28.7835a
Cext_125 \$19 \$25 18.3617f
Cext_126 \$19 \$26 11.0361f
Cext_127 \$19 \$27 4.53855a
Cext_128 \$19 \$3 867.614a
Cext_129 \$19 \$30 174.127a
Cext_130 \$19 \$31 44.448a
Cext_131 \$19 \$32 163.966a
Cext_132 \$19 \$33 4.83797f
Cext_133 \$19 \$4 5.05193f
Cext_134 \$19 \$40 44.448a
Cext_135 \$19 \$5 9.45503f
Cext_136 \$19 \$7 169.054a
Cext_137 \$19 iptat 234.229a
Cext_138 \$19 isense 1.7027f
Cext_139 \$19 sense_n 79.1669a
Cext_140 \$19 sense_p 56.171a
Cext_141 \$19 vdd 36.4736f
Cext_142 \$19 vped 1.87683f
Cext_143 \$19 vref 44.448a
Cext_144 \$19 vref_buf 1.87683f
Cext_145 \$19 vss 3.96596f
Cext_146 \$19 VSUBS 104.212f
Cext_147 \$2 \$25 16.8106f
Cext_148 \$2 \$26 14.9101f
Cext_149 \$2 \$27 197.272a
Cext_150 \$2 \$3 17.068f
Cext_151 \$2 \$30 999.089a
Cext_152 \$2 \$31 72.0384a
Cext_153 \$2 \$32 1.01642f
Cext_154 \$2 \$33 10.7742f
Cext_155 \$2 \$4 5.81376f
Cext_156 \$2 \$40 72.0384a
Cext_157 \$2 \$5 13.1382f
Cext_158 \$2 \$7 3.91317a
Cext_159 \$2 iptat 1.43454f
Cext_160 \$2 isense 2.50509f
Cext_161 \$2 vdd 2.87566f
Cext_162 \$2 vped 3.47302f
Cext_163 \$2 vref 72.0384a
Cext_164 \$2 vref_buf 3.5165f
Cext_165 \$2 vss 2.54613f
Cext_166 \$2 VSUBS 98.1528f
Cext_167 \$20 \$21 28.7835a
Cext_168 \$20 \$3 8.94579a
Cext_169 \$20 sense_n 79.1669a
Cext_170 \$20 sense_p 16.6685a
Cext_171 \$20 vss 53.6189a
Cext_172 \$20 VSUBS 858.397a
Cext_173 \$21 \$22 28.7835a
Cext_174 \$21 \$3 8.94579a
Cext_175 \$21 sense_n 79.1669a
Cext_176 \$21 sense_p 15.7342a
Cext_177 \$21 vss 53.6189a
Cext_178 \$21 VSUBS 858.397a
Cext_179 \$22 \$23 28.7835a
Cext_180 \$22 \$3 8.94579a
Cext_181 \$22 sense_n 79.1669a
Cext_182 \$22 sense_p 15.7342a
Cext_183 \$22 vss 53.6189a
Cext_184 \$22 VSUBS 858.397a
Cext_185 \$23 \$24 28.7835a
Cext_186 \$23 \$3 8.94579a
Cext_187 \$23 sense_n 79.1669a
Cext_188 \$23 sense_p 15.7342a
Cext_189 \$23 vss 53.6189a
Cext_190 \$23 VSUBS 858.397a
Cext_191 \$24 \$25 28.7835a
Cext_192 \$24 \$3 8.94579a
Cext_193 \$24 sense_n 79.1669a
Cext_194 \$24 sense_p 15.7342a
Cext_195 \$24 vss 53.6189a
Cext_196 \$24 VSUBS 858.397a
Cext_197 \$25 \$26 585.981a
Cext_198 \$25 \$3 8.94579a
Cext_199 \$25 \$30 127.338a
Cext_200 \$25 \$31 16.3a
Cext_201 \$25 \$32 88.7564a
Cext_202 \$25 \$4 13.0947a
Cext_203 \$25 \$40 16.3a
Cext_204 \$25 \$5 1.32325a
Cext_205 \$25 isense 412.134a
Cext_206 \$25 sense_n 79.1669a
Cext_207 \$25 sense_p 15.7342a
Cext_208 \$25 vdd 20.3105f
Cext_209 \$25 vped 539.472a
Cext_210 \$25 vref 16.3a
Cext_211 \$25 vref_buf 539.472a
Cext_212 \$25 vss 111.621a
Cext_213 \$25 VSUBS 11.0294f
Cext_214 \$26 \$27 28.7835a
Cext_215 \$26 \$3 8.94579a
Cext_216 \$26 \$30 135.256a
Cext_217 \$26 \$31 16.3a
Cext_218 \$26 \$32 83.9965a
Cext_219 \$26 \$33 7.32679f
Cext_220 \$26 \$40 16.3a
Cext_221 \$26 \$5 0.661626a
Cext_222 \$26 \$7 14.2261a
Cext_223 \$26 isense 565.953a
Cext_224 \$26 sense_n 79.1669a
Cext_225 \$26 sense_p 15.7342a
Cext_226 \$26 vdd 20.3105f
Cext_227 \$26 vped 701.209a
Cext_228 \$26 vref 16.3a
Cext_229 \$26 vref_buf 701.209a
Cext_230 \$26 vss 124.914a
Cext_231 \$26 VSUBS 11.0321f
Cext_232 \$27 \$28 28.7835a
Cext_233 \$27 \$3 22.1773f
Cext_234 \$27 \$30 5.24503f
Cext_235 \$27 \$31 7.43578f
Cext_236 \$27 \$32 1.90901f
Cext_237 \$27 \$33 2.331f
Cext_238 \$27 \$4 4.31161f
Cext_239 \$27 \$40 7.43578f
Cext_240 \$27 \$5 789.771a
Cext_241 \$27 \$7 7.80828f
Cext_242 \$27 isense 3.03824f
Cext_243 \$27 sense_n 79.1669a
Cext_244 \$27 sense_p 15.7342a
Cext_245 \$27 vdd 15.4906f
Cext_246 \$27 vped 8.28455f
Cext_247 \$27 vref 7.4382f
Cext_248 \$27 vref_buf 8.28143f
Cext_249 \$27 vss 55.348a
Cext_250 \$27 VSUBS 19.493f
Cext_251 \$28 \$29 28.7835a
Cext_252 \$28 \$3 9.88009a
Cext_253 \$28 sense_n 79.1669a
Cext_254 \$28 sense_p 15.7342a
Cext_255 \$28 vss 53.6189a
Cext_256 \$28 VSUBS 858.397a
Cext_257 \$29 \$3 49.3827a
Cext_258 \$29 sense_n 79.1669a
Cext_259 \$29 sense_p 15.7342a
Cext_260 \$29 vss 53.6189a
Cext_261 \$29 VSUBS 858.397a
Cext_262 \$3 \$30 96.0317a
Cext_263 \$3 \$31 469.847a
Cext_264 \$3 \$32 875.178a
Cext_265 \$3 \$33 412.779a
Cext_266 \$3 \$4 2.08513f
Cext_267 \$3 \$40 469.847a
Cext_268 \$3 \$5 5.35269f
Cext_269 \$3 \$7 244.95a
Cext_270 \$3 iptat 1.25703f
Cext_271 \$3 isense 683.117a
Cext_272 \$3 sense_n 263.218a
Cext_273 \$3 sense_p 8.97298f
Cext_274 \$3 vdd 22.8501f
Cext_275 \$3 vped 822.202a
Cext_276 \$3 vref 557.647a
Cext_277 \$3 vref_buf 713.159a
Cext_278 \$3 vss 2.49215f
Cext_279 \$3 VSUBS 87.5151f
Cext_280 \$30 \$31 15.7858f
Cext_281 \$30 \$32 668.305a
Cext_282 \$30 \$33 485.172a
Cext_283 \$30 \$34 206.894a
Cext_284 \$30 \$35 3.59052a
Cext_285 \$30 \$4 7.89555f
Cext_286 \$30 \$40 135.536a
Cext_287 \$30 \$41 7.88132a
Cext_288 \$30 \$48 79.1203a
Cext_289 \$30 \$49 79.1203a
Cext_290 \$30 \$5 70.4886a
Cext_291 \$30 \$50 79.1203a
Cext_292 \$30 \$51 119.417a
Cext_293 \$30 \$52 80.0546a
Cext_294 \$30 \$53 79.1203a
Cext_295 \$30 \$54 79.1203a
Cext_296 \$30 \$55 79.1203a
Cext_297 \$30 \$58 119.557a
Cext_298 \$30 \$59 80.0546a
Cext_299 \$30 \$62 13.6649a
Cext_300 \$30 \$64 0.72091a
Cext_301 \$30 \$65 1.02212a
Cext_302 \$30 \$66 1.02212a
Cext_303 \$30 \$67 1.02212a
Cext_304 \$30 \$68 1.02212a
Cext_305 \$30 \$69 1.02212a
Cext_306 \$30 \$7 927.311a
Cext_307 \$30 \$70 1.02212a
Cext_308 \$30 \$71 1.02212a
Cext_309 \$30 \$72 1.02212a
Cext_310 \$30 \$74 13.0489a
Cext_311 \$30 \$75 0.72091a
Cext_312 \$30 iptat 3.63261f
Cext_313 \$30 isense 5.2024f
Cext_314 \$30 vdd 703.675a
Cext_315 \$30 vped 298.351a
Cext_316 \$30 vss 313.12a
Cext_317 \$30 VSUBS 32.2801f
Cext_318 \$31 \$32 702.569a
Cext_319 \$31 \$33 608.21a
Cext_320 \$31 \$34 10.677f
Cext_321 \$31 \$35 4.47755a
Cext_322 \$31 \$4 997.702a
Cext_323 \$31 \$40 50.1832a
Cext_324 \$31 \$41 369.18a
Cext_325 \$31 \$48 15.5892a
Cext_326 \$31 \$49 15.5892a
Cext_327 \$31 \$5 92.0037a
Cext_328 \$31 \$50 15.5892a
Cext_329 \$31 \$51 15.4757a
Cext_330 \$31 \$52 15.5892a
Cext_331 \$31 \$53 15.5892a
Cext_332 \$31 \$54 15.5892a
Cext_333 \$31 \$55 15.5892a
Cext_334 \$31 \$56 0.934295a
Cext_335 \$31 \$57 40.4369a
Cext_336 \$31 \$58 15.5892a
Cext_337 \$31 \$59 15.5892a
Cext_338 \$31 \$62 1.1216a
Cext_339 \$31 \$64 1.1216a
Cext_340 \$31 \$65 1.25174a
Cext_341 \$31 \$66 1.25174a
Cext_342 \$31 \$67 1.25174a
Cext_343 \$31 \$68 1.25174a
Cext_344 \$31 \$69 1.25174a
Cext_345 \$31 \$7 8.68417f
Cext_346 \$31 \$70 1.25174a
Cext_347 \$31 \$71 1.25174a
Cext_348 \$31 \$72 1.25174a
Cext_349 \$31 \$73 13.5491a
Cext_350 \$31 \$74 14.2927a
Cext_351 \$31 \$75 1.1216a
Cext_352 \$31 iptat 60.2308a
Cext_353 \$31 isense 4.86474f
Cext_354 \$31 vdd 582.149a
Cext_355 \$31 vped 154.668a
Cext_356 \$31 vss 543.241a
Cext_357 \$31 VSUBS 31.2424f
Cext_358 \$32 \$33 3.13313f
Cext_359 \$32 \$34 4.65572a
Cext_360 \$32 \$4 309.098a
Cext_361 \$32 \$40 699.548a
Cext_362 \$32 \$41 3.55122a
Cext_363 \$32 \$5 510.775a
Cext_364 \$32 \$7 618.993a
Cext_365 \$32 iptat 195.383a
Cext_366 \$32 isense 24.9028f
Cext_367 \$32 vdd 1.33304f
Cext_368 \$32 vped 25.9562f
Cext_369 \$32 vref 699.548a
Cext_370 \$32 vref_buf 25.9562f
Cext_371 \$32 vss 990.727a
Cext_372 \$32 VSUBS 6.89839f
Cext_373 \$33 \$4 2.90095a
Cext_374 \$33 \$40 608.21a
Cext_375 \$33 \$5 7.1233f
Cext_376 \$33 \$7 9.88904f
Cext_377 \$33 iptat 1.12626f
Cext_378 \$33 isense 13.4022f
Cext_379 \$33 vdd 33.4083f
Cext_380 \$33 vped 13.9381f
Cext_381 \$33 vref 713.207a
Cext_382 \$33 vref_buf 13.8075f
Cext_383 \$33 vss 3.92371f
Cext_384 \$33 VSUBS 104.106f
Cext_385 \$34 \$35 3.71068a
Cext_386 \$34 \$40 338.144a
Cext_387 \$34 \$41 16.2552f
Cext_388 \$34 \$48 8.86264a
Cext_389 \$34 \$49 8.86264a
Cext_390 \$34 \$50 8.86264a
Cext_391 \$34 \$51 8.64055a
Cext_392 \$34 \$52 8.86264a
Cext_393 \$34 \$53 8.86264a
Cext_394 \$34 \$54 49.2995a
Cext_395 \$34 \$55 9.79693a
Cext_396 \$34 \$58 8.86264a
Cext_397 \$34 \$59 8.86264a
Cext_398 \$34 \$62 1.50863a
Cext_399 \$34 \$64 1.50863a
Cext_400 \$34 \$65 1.6714a
Cext_401 \$34 \$66 1.6714a
Cext_402 \$34 \$67 1.6714a
Cext_403 \$34 \$68 1.6714a
Cext_404 \$34 \$69 1.6714a
Cext_405 \$34 \$70 1.6714a
Cext_406 \$34 \$71 1.6714a
Cext_407 \$34 \$72 1.6714a
Cext_408 \$34 \$75 14.2735a
Cext_409 \$34 \$87 136.042a
Cext_410 \$34 \$96 79.1669a
Cext_411 \$34 \$97 79.1669a
Cext_412 \$34 \$98 79.1669a
Cext_413 \$34 \$99 79.1669a
Cext_414 \$34 iptat 0.397379a
Cext_415 \$34 isense 13.8055f
Cext_416 \$34 vped 358.841a
Cext_417 \$34 vref 214.404a
Cext_418 \$34 vref_buf 335.47a
Cext_419 \$34 vss 230.807a
Cext_420 \$34 VSUBS 6.4212f
Cext_421 \$35 \$41 2.72597f
Cext_422 \$35 \$46 40.4369a
Cext_423 \$35 \$47 0.934295a
Cext_424 \$35 \$51 15.3158a
Cext_425 \$35 \$54 2.79698a
Cext_426 \$35 \$55 2.79698a
Cext_427 \$35 \$56 2.79698a
Cext_428 \$35 \$57 2.79698a
Cext_429 \$35 \$58 2.79698a
Cext_430 \$35 \$59 2.79698a
Cext_431 \$35 \$60 2.79698a
Cext_432 \$35 \$61 2.79698a
Cext_433 \$35 \$62 50.2614a
Cext_434 \$35 \$68 0.934295a
Cext_435 \$35 \$69 40.4369a
Cext_436 \$35 \$70 9.92601a
Cext_437 \$35 \$71 9.92601a
Cext_438 \$35 \$72 10.8603a
Cext_439 \$35 \$73 9.8245a
Cext_440 \$35 \$74 9.72299a
Cext_441 \$35 \$75 9.8245a
Cext_442 \$35 \$76 9.92601a
Cext_443 \$35 \$77 9.92601a
Cext_444 \$35 \$78 9.92601a
Cext_445 \$35 \$80 18.0036a
Cext_446 \$35 \$81 9.8245a
Cext_447 \$35 VSUBS 4.18826f
Cext_448 \$4 \$40 997.702a
Cext_449 \$4 \$5 6.05337f
Cext_450 \$4 \$7 1.39549f
Cext_451 \$4 iptat 13.87f
Cext_452 \$4 isense 683.528a
Cext_453 \$4 vdd 27.2831f
Cext_454 \$4 vped 8.40032f
Cext_455 \$4 vref 997.702a
Cext_456 \$4 vref_buf 8.67093f
Cext_457 \$4 vss 8.38355f
Cext_458 \$4 VSUBS 24.1539f
Cext_459 \$40 \$41 1.8519f
Cext_460 \$40 \$49 0.934295a
Cext_461 \$40 \$5 92.0037a
Cext_462 \$40 \$50 40.4369a
Cext_463 \$40 \$64 15.5287a
Cext_464 \$40 \$7 8.68417f
Cext_465 \$40 \$87 9.34707f
Cext_466 \$40 \$96 2.82353a
Cext_467 \$40 \$97 2.82353a
Cext_468 \$40 \$98 2.82353a
Cext_469 \$40 \$99 2.82353a
Cext_470 \$40 iptat 64.1129a
Cext_471 \$40 isense 192.488a
Cext_472 \$40 vdd 605.861a
Cext_473 \$40 vped 11.9422f
Cext_474 \$40 vref 99.9546a
Cext_475 \$40 vref_buf 14.665f
Cext_476 \$40 vss 1.26659f
Cext_477 \$40 VSUBS 31.8353f
Cext_478 \$41 \$48 5.63172a
Cext_479 \$41 \$49 5.63172a
Cext_480 \$41 \$50 5.63172a
Cext_481 \$41 \$51 5.4884a
Cext_482 \$41 \$52 5.63172a
Cext_483 \$41 \$53 5.63172a
Cext_484 \$41 \$54 5.63172a
Cext_485 \$41 \$55 5.63172a
Cext_486 \$41 \$56 14.1647a
Cext_487 \$41 \$57 14.1647a
Cext_488 \$41 \$58 5.63172a
Cext_489 \$41 \$59 5.63172a
Cext_490 \$41 \$60 54.6015a
Cext_491 \$41 \$61 15.099a
Cext_492 \$41 \$62 1.93958a
Cext_493 \$41 \$64 4.28607a
Cext_494 \$41 \$65 5.39769a
Cext_495 \$41 \$66 5.39769a
Cext_496 \$41 \$67 5.39769a
Cext_497 \$41 \$68 5.39769a
Cext_498 \$41 \$69 5.39769a
Cext_499 \$41 \$70 2.14848a
Cext_500 \$41 \$71 2.14848a
Cext_501 \$41 \$72 2.14848a
Cext_502 \$41 \$73 1.93958a
Cext_503 \$41 \$74 1.73067a
Cext_504 \$41 \$75 1.93958a
Cext_505 \$41 \$76 2.14848a
Cext_506 \$41 \$77 2.14848a
Cext_507 \$41 \$78 2.14848a
Cext_508 \$41 \$81 15.7034a
Cext_509 \$41 \$87 46.915a
Cext_510 \$41 \$96 8.94579a
Cext_511 \$41 \$97 9.88009a
Cext_512 \$41 \$98 8.94579a
Cext_513 \$41 \$99 8.94579a
Cext_514 \$41 iptat 0.252304a
Cext_515 \$41 isense 7.1058f
Cext_516 \$41 vdd 9.64002a
Cext_517 \$41 vped 12.78f
Cext_518 \$41 vref 100.089a
Cext_519 \$41 vref_buf 186.413a
Cext_520 \$41 vss 214.575a
Cext_521 \$41 VSUBS 5.94174f
Cext_522 \$42 \$45 28.7835a
Cext_523 \$42 \$63 12.6351a
Cext_524 \$42 vss 1.39423a
Cext_525 \$42 VSUBS 912.14a
Cext_526 \$43 \$44 28.7835a
Cext_527 \$43 \$47 28.7835a
Cext_528 \$43 \$83 12.6351a
Cext_529 \$43 \$84 12.6351a
Cext_530 \$43 VSUBS 890.098a
Cext_531 \$44 \$45 28.7835a
Cext_532 \$44 \$82 12.6351a
Cext_533 \$44 \$83 12.6351a
Cext_534 \$44 VSUBS 890.098a
Cext_535 \$45 \$63 12.6351a
Cext_536 \$45 \$82 12.6351a
Cext_537 \$45 VSUBS 890.098a
Cext_538 \$46 \$47 28.7835a
Cext_539 \$46 \$79 12.6351a
Cext_540 \$46 \$80 12.6351a
Cext_541 \$46 VSUBS 890.098a
Cext_542 \$47 \$79 12.6351a
Cext_543 \$47 \$84 12.6351a
Cext_544 \$47 VSUBS 890.098a
Cext_545 \$48 \$49 28.7835a
Cext_546 \$48 \$53 28.7835a
Cext_547 \$48 \$66 12.6351a
Cext_548 \$48 \$67 12.6351a
Cext_549 \$48 VSUBS 890.098a
Cext_550 \$49 \$50 28.7835a
Cext_551 \$49 \$65 12.6351a
Cext_552 \$49 \$66 12.6351a
Cext_553 \$49 VSUBS 890.098a
Cext_554 \$5 \$7 5.5007f
Cext_555 \$5 iptat 3.71713f
Cext_556 \$5 isense 206.508a
Cext_557 \$5 vdd 2.73949f
Cext_558 \$5 vped 268.061a
Cext_559 \$5 vref 92.3065a
Cext_560 \$5 vref_buf 279.326a
Cext_561 \$5 vss 13.4678f
Cext_562 \$5 VSUBS 56.3023f
Cext_563 \$50 \$64 12.6351a
Cext_564 \$50 \$65 12.6351a
Cext_565 \$50 VSUBS 890.098a
Cext_566 \$51 \$52 28.7835a
Cext_567 \$51 \$69 12.6351a
Cext_568 \$51 VSUBS 890.079a
Cext_569 \$52 \$53 28.7835a
Cext_570 \$52 \$68 12.6351a
Cext_571 \$52 \$69 12.6351a
Cext_572 \$52 VSUBS 890.098a
Cext_573 \$53 \$67 12.6351a
Cext_574 \$53 \$68 12.6351a
Cext_575 \$53 VSUBS 890.098a
Cext_576 \$54 \$55 28.7835a
Cext_577 \$54 \$70 12.6351a
Cext_578 \$54 \$75 12.6351a
Cext_579 \$54 VSUBS 890.098a
Cext_580 \$55 \$59 28.7835a
Cext_581 \$55 \$70 12.6351a
Cext_582 \$55 \$71 12.6351a
Cext_583 \$55 VSUBS 890.098a
Cext_584 \$56 \$57 28.7835a
Cext_585 \$56 \$61 28.7835a
Cext_586 \$56 \$77 12.6351a
Cext_587 \$56 \$78 12.6351a
Cext_588 \$56 VSUBS 890.098a
Cext_589 \$57 \$73 12.6351a
Cext_590 \$57 \$78 12.6351a
Cext_591 \$57 VSUBS 890.098a
Cext_592 \$58 \$59 28.7835a
Cext_593 \$58 \$62 12.6351a
Cext_594 \$58 \$72 12.6351a
Cext_595 \$58 VSUBS 890.098a
Cext_596 \$59 \$71 12.6351a
Cext_597 \$59 \$72 12.6351a
Cext_598 \$59 VSUBS 890.098a
Cext_599 \$60 \$61 28.7835a
Cext_600 \$60 \$76 12.6351a
Cext_601 \$60 \$81 12.6351a
Cext_602 \$60 VSUBS 890.098a
Cext_603 \$61 \$76 12.6351a
Cext_604 \$61 \$77 12.6351a
Cext_605 \$61 VSUBS 890.098a
Cext_606 \$62 \$72 28.7835a
Cext_607 \$62 VSUBS 890.079a
Cext_608 \$63 \$82 28.7835a
Cext_609 \$63 VSUBS 908.974a
Cext_610 \$64 \$65 28.7835a
Cext_611 \$64 vss 2.22579a
Cext_612 \$64 VSUBS 908.543a
Cext_613 \$65 \$66 28.7835a
Cext_614 \$65 VSUBS 890.098a
Cext_615 \$66 \$67 28.7835a
Cext_616 \$66 VSUBS 890.098a
Cext_617 \$67 \$68 28.7835a
Cext_618 \$67 VSUBS 890.098a
Cext_619 \$68 \$69 28.7835a
Cext_620 \$68 VSUBS 890.098a
Cext_621 \$69 VSUBS 890.098a
Cext_622 \$7 iptat 15.7401f
Cext_623 \$7 isense 2.28895f
Cext_624 \$7 vdd 23.8854f
Cext_625 \$7 vped 2.99831f
Cext_626 \$7 vref 8.68417f
Cext_627 \$7 vref_buf 3.28718f
Cext_628 \$7 vss 8.28624f
Cext_629 \$7 VSUBS 24.0099f
Cext_630 \$70 \$71 28.7835a
Cext_631 \$70 \$75 28.7835a
Cext_632 \$70 VSUBS 890.098a
Cext_633 \$71 \$72 28.7835a
Cext_634 \$71 VSUBS 890.098a
Cext_635 \$72 VSUBS 890.098a
Cext_636 \$73 \$74 28.7835a
Cext_637 \$73 \$78 28.7835a
Cext_638 \$73 VSUBS 890.079a
Cext_639 \$74 \$75 28.7835a
Cext_640 \$74 VSUBS 890.06a
Cext_641 \$75 VSUBS 890.079a
Cext_642 \$76 \$77 28.7835a
Cext_643 \$76 \$81 28.7835a
Cext_644 \$76 VSUBS 890.098a
Cext_645 \$77 \$78 28.7835a
Cext_646 \$77 VSUBS 890.098a
Cext_647 \$78 VSUBS 890.098a
Cext_648 \$79 \$80 28.7835a
Cext_649 \$79 \$84 28.7835a
Cext_650 \$79 VSUBS 890.098a
Cext_651 \$8 \$9 28.7835a
Cext_652 \$8 vss 55.8447a
Cext_653 \$8 VSUBS 876.861a
Cext_654 \$80 \$81 28.7835a
Cext_655 \$80 VSUBS 890.079a
Cext_656 \$81 VSUBS 890.079a
Cext_657 \$82 \$83 28.7835a
Cext_658 \$82 VSUBS 890.098a
Cext_659 \$83 \$84 28.7835a
Cext_660 \$83 VSUBS 890.098a
Cext_661 \$84 VSUBS 890.098a
Cext_662 \$87 \$96 42.5678a
Cext_663 \$87 \$97 2.1309a
Cext_664 \$87 \$98 2.1309a
Cext_665 \$87 \$99 2.1309a
Cext_666 \$87 isense 511.837a
Cext_667 \$87 vdd 30.2984a
Cext_668 \$87 vped 45.9221a
Cext_669 \$87 vref_buf 46.3596a
Cext_670 \$87 vss 13.7095f
Cext_671 \$87 VSUBS 2.99008f
Cext_672 \$9 vss 53.6189a
Cext_673 \$9 VSUBS 858.397a
Cext_674 \$93 \$94 28.7835a
Cext_675 \$93 vss 27.0818a
Cext_676 \$93 VSUBS 888.636a
Cext_677 \$94 \$95 28.7835a
Cext_678 \$94 vss 28.0161a
Cext_679 \$94 VSUBS 888.636a
Cext_680 \$95 vss 67.5186a
Cext_681 \$95 VSUBS 888.636a
Cext_682 \$96 isense 15.7342a
Cext_683 \$96 vped 5.68486a
Cext_684 \$96 vref_buf 3.89865a
Cext_685 \$96 vss 24.5892a
Cext_686 \$96 VSUBS 888.636a
Cext_687 \$97 \$98 28.7835a
Cext_688 \$97 isense 15.7342a
Cext_689 \$97 vped 5.68486a
Cext_690 \$97 vref_buf 3.89865a
Cext_691 \$97 vss 24.5892a
Cext_692 \$97 VSUBS 888.636a
Cext_693 \$98 \$99 28.7835a
Cext_694 \$98 isense 15.7342a
Cext_695 \$98 vped 5.68486a
Cext_696 \$98 vref_buf 3.89865a
Cext_697 \$98 vss 24.5892a
Cext_698 \$98 VSUBS 888.636a
Cext_699 \$99 isense 15.7342a
Cext_700 \$99 vped 5.68486a
Cext_701 \$99 vref_buf 3.89865a
Cext_702 \$99 vss 24.5892a
Cext_703 \$99 VSUBS 888.636a
Cext_704 iptat isense 6.58395f
Cext_705 iptat vdd 1.49664f
Cext_706 iptat vped 5.34149f
Cext_707 iptat vref_buf 5.65772f
Cext_708 iptat vss 37.152f
Cext_709 isense vdd 8.57406f
Cext_710 isense vped 1.32533f
Cext_711 isense vref 156.172a
Cext_712 isense vref_buf 337.211a
Cext_713 isense vss 6.32093f
Cext_714 sense_n sense_p 10.9643f
Cext_715 sense_n vss 204.723a
Cext_716 sense_p vss 317.301a
Cext_717 vdd vped 9.17952f
Cext_718 vdd vref 1.32734f
Cext_719 vdd vref_buf 8.66436f
Cext_720 vdd vss 44.5306f
Cext_721 vped vref 100.025a
Cext_722 vped vref_buf 13.0031f
Cext_723 vped vss 6.53995f
Cext_724 vref vref_buf 7.38296f
Cext_725 vref vss 1.76698f
Cext_726 vref_buf vss 7.55178f
Cext_727 VSUBS iptat 148.353f
Cext_728 VSUBS isense 22.4734f
Cext_729 VSUBS sense_n 3.99032f
Cext_730 VSUBS sense_p 2.70136f
Cext_731 VSUBS vdd 155.299f
Cext_732 VSUBS vped 44.7312f
Cext_733 VSUBS vref 35.6348f
Cext_734 VSUBS vref_buf 44.8196f
Cext_735 VSUBS vss 282.343f
.ENDS g1_sense

.SUBCKT g1_ota vss vbn out vdd inn inp
R$1 \$33 \$32 vss 1 rppd l=6.2 ps=0 b=0 m=1
M$2 out \$33 vdd vdd sg13_hv_pmos L=1U W=8U AS=2.72P AD=1.52P PS=16.68U
+ PD=8.38U rfmode=0
M$3 vdd \$33 out vdd sg13_hv_pmos L=1U W=8U AS=1.52P AD=1.52P PS=8.38U PD=8.38U
+ rfmode=0
M$4 out \$33 vdd vdd sg13_hv_pmos L=1U W=8U AS=1.52P AD=1.52P PS=8.38U PD=8.38U
+ rfmode=0
M$5 vdd \$33 out vdd sg13_hv_pmos L=1U W=8U AS=1.52P AD=1.52P PS=8.38U PD=8.38U
+ rfmode=0
M$6 out \$33 vdd vdd sg13_hv_pmos L=1U W=8U AS=1.52P AD=1.52P PS=8.38U PD=8.38U
+ rfmode=0
M$7 vdd \$33 out vdd sg13_hv_pmos L=1U W=8U AS=1.52P AD=1.52P PS=8.38U PD=8.38U
+ rfmode=0
M$8 out \$33 vdd vdd sg13_hv_pmos L=1U W=8U AS=1.52P AD=1.52P PS=8.38U PD=8.38U
+ rfmode=0
M$9 vdd \$33 out vdd sg13_hv_pmos L=1U W=8U AS=1.52P AD=1.52P PS=8.38U PD=8.38U
+ rfmode=0
M$10 out \$33 vdd vdd sg13_hv_pmos L=1U W=8U AS=1.52P AD=1.52P PS=8.38U
+ PD=8.38U rfmode=0
M$11 vdd \$33 out vdd sg13_hv_pmos L=1U W=8U AS=1.52P AD=1.52P PS=8.38U
+ PD=8.38U rfmode=0
M$12 out \$33 vdd vdd sg13_hv_pmos L=1U W=8U AS=1.52P AD=1.52P PS=8.38U
+ PD=8.38U rfmode=0
M$13 vdd \$33 out vdd sg13_hv_pmos L=1U W=8U AS=1.52P AD=1.52P PS=8.38U
+ PD=8.38U rfmode=0
M$14 out \$33 vdd vdd sg13_hv_pmos L=1U W=8U AS=1.52P AD=1.52P PS=8.38U
+ PD=8.38U rfmode=0
M$15 vdd \$33 out vdd sg13_hv_pmos L=1U W=8U AS=1.52P AD=1.52P PS=8.38U
+ PD=8.38U rfmode=0
M$16 out \$33 vdd vdd sg13_hv_pmos L=1U W=8U AS=1.52P AD=1.52P PS=8.38U
+ PD=8.38U rfmode=0
M$17 vdd \$33 out vdd sg13_hv_pmos L=1U W=8U AS=1.52P AD=1.52P PS=8.38U
+ PD=8.38U rfmode=0
M$18 out \$33 vdd vdd sg13_hv_pmos L=1U W=8U AS=1.52P AD=1.52P PS=8.38U
+ PD=8.38U rfmode=0
M$19 vdd \$33 out vdd sg13_hv_pmos L=1U W=8U AS=1.52P AD=1.52P PS=8.38U
+ PD=8.38U rfmode=0
M$20 out \$33 vdd vdd sg13_hv_pmos L=1U W=8U AS=1.52P AD=1.52P PS=8.38U
+ PD=8.38U rfmode=0
M$21 vdd \$33 out vdd sg13_hv_pmos L=1U W=8U AS=1.52P AD=1.52P PS=8.38U
+ PD=8.38U rfmode=0
M$22 out \$33 vdd vdd sg13_hv_pmos L=1U W=8U AS=1.52P AD=1.52P PS=8.38U
+ PD=8.38U rfmode=0
M$23 vdd \$33 out vdd sg13_hv_pmos L=1U W=8U AS=1.52P AD=1.52P PS=8.38U
+ PD=8.38U rfmode=0
M$24 out \$33 vdd vdd sg13_hv_pmos L=1U W=8U AS=1.52P AD=1.52P PS=8.38U
+ PD=8.38U rfmode=0
M$25 vdd \$33 out vdd sg13_hv_pmos L=1U W=8U AS=1.52P AD=2.72P PS=8.38U
+ PD=16.68U rfmode=0
M$26 \$27 \$3 vdd vdd sg13_hv_pmos L=1U W=8U AS=2.72P AD=1.52P PS=16.68U
+ PD=8.38U rfmode=0
M$27 vdd \$3 \$27 vdd sg13_hv_pmos L=1U W=8U AS=1.52P AD=1.52P PS=8.38U
+ PD=8.38U rfmode=0
M$28 \$27 \$3 vdd vdd sg13_hv_pmos L=1U W=8U AS=1.52P AD=1.52P PS=8.38U
+ PD=8.38U rfmode=0
M$29 vdd \$3 \$27 vdd sg13_hv_pmos L=1U W=8U AS=1.52P AD=1.52P PS=8.38U
+ PD=8.38U rfmode=0
M$30 \$27 \$3 vdd vdd sg13_hv_pmos L=1U W=8U AS=1.52P AD=1.52P PS=8.38U
+ PD=8.38U rfmode=0
M$31 vdd \$3 \$27 vdd sg13_hv_pmos L=1U W=8U AS=1.52P AD=1.52P PS=8.38U
+ PD=8.38U rfmode=0
M$32 \$27 \$3 vdd vdd sg13_hv_pmos L=1U W=8U AS=1.52P AD=1.52P PS=8.38U
+ PD=8.38U rfmode=0
M$33 vdd \$3 \$27 vdd sg13_hv_pmos L=1U W=8U AS=1.52P AD=1.52P PS=8.38U
+ PD=8.38U rfmode=0
M$34 \$27 \$3 vdd vdd sg13_hv_pmos L=1U W=8U AS=1.52P AD=1.52P PS=8.38U
+ PD=8.38U rfmode=0
M$35 vdd \$3 \$27 vdd sg13_hv_pmos L=1U W=8U AS=1.52P AD=1.52P PS=8.38U
+ PD=8.38U rfmode=0
M$36 \$27 \$3 vdd vdd sg13_hv_pmos L=1U W=8U AS=1.52P AD=1.52P PS=8.38U
+ PD=8.38U rfmode=0
M$37 vdd \$3 \$27 vdd sg13_hv_pmos L=1U W=8U AS=1.52P AD=1.52P PS=8.38U
+ PD=8.38U rfmode=0
M$38 \$27 \$3 vdd vdd sg13_hv_pmos L=1U W=8U AS=1.52P AD=1.52P PS=8.38U
+ PD=8.38U rfmode=0
M$39 vdd \$3 \$27 vdd sg13_hv_pmos L=1U W=8U AS=1.52P AD=1.52P PS=8.38U
+ PD=8.38U rfmode=0
M$40 \$27 \$3 vdd vdd sg13_hv_pmos L=1U W=8U AS=1.52P AD=1.52P PS=8.38U
+ PD=8.38U rfmode=0
M$41 vdd \$3 \$27 vdd sg13_hv_pmos L=1U W=8U AS=1.52P AD=2.72P PS=8.38U
+ PD=16.68U rfmode=0
M$42 \$5 \$3 vdd vdd sg13_hv_pmos L=1U W=8U AS=2.72P AD=1.52P PS=16.68U
+ PD=8.38U rfmode=0
M$43 vdd \$3 \$5 vdd sg13_hv_pmos L=1U W=8U AS=1.52P AD=2.72P PS=8.38U
+ PD=16.68U rfmode=0
M$44 \$3 \$3 vdd vdd sg13_hv_pmos L=1U W=8U AS=2.72P AD=1.52P PS=16.68U
+ PD=8.38U rfmode=0
M$45 vdd \$3 \$3 vdd sg13_hv_pmos L=1U W=8U AS=1.52P AD=2.72P PS=8.38U
+ PD=16.68U rfmode=0
M$46 \$2 \$2 vdd vdd sg13_hv_pmos L=1U W=3.2U AS=1.088P AD=1.088P PS=7.08U
+ PD=7.08U rfmode=0
M$47 \$4 inn \$27 vdd sg13_hv_pmos L=2U W=6U AS=2.04P AD=1.14P PS=12.68U
+ PD=6.38U rfmode=0
M$48 \$27 inn \$4 vdd sg13_hv_pmos L=2U W=6U AS=1.14P AD=1.14P PS=6.38U
+ PD=6.38U rfmode=0
M$49 \$7 inp \$27 vdd sg13_hv_pmos L=2U W=6U AS=1.14P AD=1.14P PS=6.38U
+ PD=6.38U rfmode=0
M$50 \$27 inp \$7 vdd sg13_hv_pmos L=2U W=6U AS=1.14P AD=1.14P PS=6.38U
+ PD=6.38U rfmode=0
M$51 \$7 inp \$27 vdd sg13_hv_pmos L=2U W=6U AS=1.14P AD=1.14P PS=6.38U
+ PD=6.38U rfmode=0
M$52 \$27 inp \$7 vdd sg13_hv_pmos L=2U W=6U AS=1.14P AD=1.14P PS=6.38U
+ PD=6.38U rfmode=0
M$53 \$4 inn \$27 vdd sg13_hv_pmos L=2U W=6U AS=1.14P AD=1.14P PS=6.38U
+ PD=6.38U rfmode=0
M$54 \$27 inn \$4 vdd sg13_hv_pmos L=2U W=6U AS=1.14P AD=1.14P PS=6.38U
+ PD=6.38U rfmode=0
M$55 \$4 inn \$27 vdd sg13_hv_pmos L=2U W=6U AS=1.14P AD=1.14P PS=6.38U
+ PD=6.38U rfmode=0
M$56 \$27 inn \$4 vdd sg13_hv_pmos L=2U W=6U AS=1.14P AD=1.14P PS=6.38U
+ PD=6.38U rfmode=0
M$57 \$7 inp \$27 vdd sg13_hv_pmos L=2U W=6U AS=1.14P AD=1.14P PS=6.38U
+ PD=6.38U rfmode=0
M$58 \$27 inp \$7 vdd sg13_hv_pmos L=2U W=6U AS=1.14P AD=1.14P PS=6.38U
+ PD=6.38U rfmode=0
M$59 \$7 inp \$27 vdd sg13_hv_pmos L=2U W=6U AS=1.14P AD=1.14P PS=6.38U
+ PD=6.38U rfmode=0
M$60 \$27 inp \$7 vdd sg13_hv_pmos L=2U W=6U AS=1.14P AD=1.14P PS=6.38U
+ PD=6.38U rfmode=0
M$61 \$4 inn \$27 vdd sg13_hv_pmos L=2U W=6U AS=1.14P AD=1.14P PS=6.38U
+ PD=6.38U rfmode=0
M$62 \$27 inn \$4 vdd sg13_hv_pmos L=2U W=6U AS=1.14P AD=1.14P PS=6.38U
+ PD=6.38U rfmode=0
M$63 \$4 inn \$27 vdd sg13_hv_pmos L=2U W=6U AS=1.14P AD=1.14P PS=6.38U
+ PD=6.38U rfmode=0
M$64 \$27 inn \$4 vdd sg13_hv_pmos L=2U W=6U AS=1.14P AD=1.14P PS=6.38U
+ PD=6.38U rfmode=0
M$65 \$7 inp \$27 vdd sg13_hv_pmos L=2U W=6U AS=1.14P AD=1.14P PS=6.38U
+ PD=6.38U rfmode=0
M$66 \$27 inp \$7 vdd sg13_hv_pmos L=2U W=6U AS=1.14P AD=1.14P PS=6.38U
+ PD=6.38U rfmode=0
M$67 \$7 inp \$27 vdd sg13_hv_pmos L=2U W=6U AS=1.14P AD=1.14P PS=6.38U
+ PD=6.38U rfmode=0
M$68 \$27 inp \$7 vdd sg13_hv_pmos L=2U W=6U AS=1.14P AD=1.14P PS=6.38U
+ PD=6.38U rfmode=0
M$69 \$4 inn \$27 vdd sg13_hv_pmos L=2U W=6U AS=1.14P AD=1.14P PS=6.38U
+ PD=6.38U rfmode=0
M$70 \$27 inn \$4 vdd sg13_hv_pmos L=2U W=6U AS=1.14P AD=1.14P PS=6.38U
+ PD=6.38U rfmode=0
M$71 \$4 inn \$27 vdd sg13_hv_pmos L=2U W=6U AS=1.14P AD=1.14P PS=6.38U
+ PD=6.38U rfmode=0
M$72 \$27 inn \$4 vdd sg13_hv_pmos L=2U W=6U AS=1.14P AD=1.14P PS=6.38U
+ PD=6.38U rfmode=0
M$73 \$7 inp \$27 vdd sg13_hv_pmos L=2U W=6U AS=1.14P AD=1.14P PS=6.38U
+ PD=6.38U rfmode=0
M$74 \$27 inp \$7 vdd sg13_hv_pmos L=2U W=6U AS=1.14P AD=1.14P PS=6.38U
+ PD=6.38U rfmode=0
M$75 \$7 inp \$27 vdd sg13_hv_pmos L=2U W=6U AS=1.14P AD=1.14P PS=6.38U
+ PD=6.38U rfmode=0
M$76 \$27 inp \$7 vdd sg13_hv_pmos L=2U W=6U AS=1.14P AD=1.14P PS=6.38U
+ PD=6.38U rfmode=0
M$77 \$4 inn \$27 vdd sg13_hv_pmos L=2U W=6U AS=1.14P AD=1.14P PS=6.38U
+ PD=6.38U rfmode=0
M$78 \$27 inn \$4 vdd sg13_hv_pmos L=2U W=6U AS=1.14P AD=2.04P PS=6.38U
+ PD=12.68U rfmode=0
M$79 \$19 \$2 \$25 vdd sg13_hv_pmos L=1U W=8U AS=2.72P AD=1.52P PS=16.68U
+ PD=8.38U rfmode=0
M$80 \$25 \$2 \$19 vdd sg13_hv_pmos L=1U W=8U AS=1.52P AD=1.52P PS=8.38U
+ PD=8.38U rfmode=0
M$81 \$19 \$2 \$25 vdd sg13_hv_pmos L=1U W=8U AS=1.52P AD=1.52P PS=8.38U
+ PD=8.38U rfmode=0
M$82 \$25 \$2 \$19 vdd sg13_hv_pmos L=1U W=8U AS=1.52P AD=1.52P PS=8.38U
+ PD=8.38U rfmode=0
M$83 \$19 \$2 \$25 vdd sg13_hv_pmos L=1U W=8U AS=1.52P AD=1.52P PS=8.38U
+ PD=8.38U rfmode=0
M$84 \$25 \$2 \$19 vdd sg13_hv_pmos L=1U W=8U AS=1.52P AD=1.52P PS=8.38U
+ PD=8.38U rfmode=0
M$85 \$19 \$2 \$25 vdd sg13_hv_pmos L=1U W=8U AS=1.52P AD=1.52P PS=8.38U
+ PD=8.38U rfmode=0
M$86 \$25 \$2 \$19 vdd sg13_hv_pmos L=1U W=8U AS=1.52P AD=1.52P PS=8.38U
+ PD=8.38U rfmode=0
M$87 \$19 \$2 \$25 vdd sg13_hv_pmos L=1U W=8U AS=1.52P AD=1.52P PS=8.38U
+ PD=8.38U rfmode=0
M$88 \$25 \$2 \$19 vdd sg13_hv_pmos L=1U W=8U AS=1.52P AD=1.52P PS=8.38U
+ PD=8.38U rfmode=0
M$89 \$19 \$2 \$25 vdd sg13_hv_pmos L=1U W=8U AS=1.52P AD=1.52P PS=8.38U
+ PD=8.38U rfmode=0
M$90 \$25 \$2 \$19 vdd sg13_hv_pmos L=1U W=8U AS=1.52P AD=2.72P PS=8.38U
+ PD=16.68U rfmode=0
M$91 \$25 \$19 vdd vdd sg13_hv_pmos L=1U W=8U AS=2.72P AD=1.52P PS=16.68U
+ PD=8.38U rfmode=0
M$92 vdd \$19 \$25 vdd sg13_hv_pmos L=1U W=8U AS=1.52P AD=1.52P PS=8.38U
+ PD=8.38U rfmode=0
M$93 \$25 \$19 vdd vdd sg13_hv_pmos L=1U W=8U AS=1.52P AD=1.52P PS=8.38U
+ PD=8.38U rfmode=0
M$94 vdd \$19 \$25 vdd sg13_hv_pmos L=1U W=8U AS=1.52P AD=1.52P PS=8.38U
+ PD=8.38U rfmode=0
M$95 \$25 \$19 vdd vdd sg13_hv_pmos L=1U W=8U AS=1.52P AD=1.52P PS=8.38U
+ PD=8.38U rfmode=0
M$96 vdd \$19 \$25 vdd sg13_hv_pmos L=1U W=8U AS=1.52P AD=1.52P PS=8.38U
+ PD=8.38U rfmode=0
M$97 \$25 \$19 vdd vdd sg13_hv_pmos L=1U W=8U AS=1.52P AD=1.52P PS=8.38U
+ PD=8.38U rfmode=0
M$98 vdd \$19 \$25 vdd sg13_hv_pmos L=1U W=8U AS=1.52P AD=1.52P PS=8.38U
+ PD=8.38U rfmode=0
M$99 \$25 \$19 vdd vdd sg13_hv_pmos L=1U W=8U AS=1.52P AD=1.52P PS=8.38U
+ PD=8.38U rfmode=0
M$100 vdd \$19 \$25 vdd sg13_hv_pmos L=1U W=8U AS=1.52P AD=1.52P PS=8.38U
+ PD=8.38U rfmode=0
M$101 \$25 \$19 vdd vdd sg13_hv_pmos L=1U W=8U AS=1.52P AD=1.52P PS=8.38U
+ PD=8.38U rfmode=0
M$102 vdd \$19 \$25 vdd sg13_hv_pmos L=1U W=8U AS=1.52P AD=2.72P PS=8.38U
+ PD=16.68U rfmode=0
M$103 \$26 \$19 vdd vdd sg13_hv_pmos L=1U W=8U AS=2.72P AD=1.52P PS=16.68U
+ PD=8.38U rfmode=0
M$104 vdd \$19 \$26 vdd sg13_hv_pmos L=1U W=8U AS=1.52P AD=1.52P PS=8.38U
+ PD=8.38U rfmode=0
M$105 \$26 \$19 vdd vdd sg13_hv_pmos L=1U W=8U AS=1.52P AD=1.52P PS=8.38U
+ PD=8.38U rfmode=0
M$106 vdd \$19 \$26 vdd sg13_hv_pmos L=1U W=8U AS=1.52P AD=1.52P PS=8.38U
+ PD=8.38U rfmode=0
M$107 \$26 \$19 vdd vdd sg13_hv_pmos L=1U W=8U AS=1.52P AD=1.52P PS=8.38U
+ PD=8.38U rfmode=0
M$108 vdd \$19 \$26 vdd sg13_hv_pmos L=1U W=8U AS=1.52P AD=1.52P PS=8.38U
+ PD=8.38U rfmode=0
M$109 \$26 \$19 vdd vdd sg13_hv_pmos L=1U W=8U AS=1.52P AD=1.52P PS=8.38U
+ PD=8.38U rfmode=0
M$110 vdd \$19 \$26 vdd sg13_hv_pmos L=1U W=8U AS=1.52P AD=1.52P PS=8.38U
+ PD=8.38U rfmode=0
M$111 \$26 \$19 vdd vdd sg13_hv_pmos L=1U W=8U AS=1.52P AD=1.52P PS=8.38U
+ PD=8.38U rfmode=0
M$112 vdd \$19 \$26 vdd sg13_hv_pmos L=1U W=8U AS=1.52P AD=1.52P PS=8.38U
+ PD=8.38U rfmode=0
M$113 \$26 \$19 vdd vdd sg13_hv_pmos L=1U W=8U AS=1.52P AD=1.52P PS=8.38U
+ PD=8.38U rfmode=0
M$114 vdd \$19 \$26 vdd sg13_hv_pmos L=1U W=8U AS=1.52P AD=2.72P PS=8.38U
+ PD=16.68U rfmode=0
M$115 \$33 \$2 \$26 vdd sg13_hv_pmos L=1U W=8U AS=2.72P AD=1.52P PS=16.68U
+ PD=8.38U rfmode=0
M$116 \$26 \$2 \$33 vdd sg13_hv_pmos L=1U W=8U AS=1.52P AD=1.52P PS=8.38U
+ PD=8.38U rfmode=0
M$117 \$33 \$2 \$26 vdd sg13_hv_pmos L=1U W=8U AS=1.52P AD=1.52P PS=8.38U
+ PD=8.38U rfmode=0
M$118 \$26 \$2 \$33 vdd sg13_hv_pmos L=1U W=8U AS=1.52P AD=1.52P PS=8.38U
+ PD=8.38U rfmode=0
M$119 \$33 \$2 \$26 vdd sg13_hv_pmos L=1U W=8U AS=1.52P AD=1.52P PS=8.38U
+ PD=8.38U rfmode=0
M$120 \$26 \$2 \$33 vdd sg13_hv_pmos L=1U W=8U AS=1.52P AD=1.52P PS=8.38U
+ PD=8.38U rfmode=0
M$121 \$33 \$2 \$26 vdd sg13_hv_pmos L=1U W=8U AS=1.52P AD=1.52P PS=8.38U
+ PD=8.38U rfmode=0
M$122 \$26 \$2 \$33 vdd sg13_hv_pmos L=1U W=8U AS=1.52P AD=1.52P PS=8.38U
+ PD=8.38U rfmode=0
M$123 \$33 \$2 \$26 vdd sg13_hv_pmos L=1U W=8U AS=1.52P AD=1.52P PS=8.38U
+ PD=8.38U rfmode=0
M$124 \$26 \$2 \$33 vdd sg13_hv_pmos L=1U W=8U AS=1.52P AD=1.52P PS=8.38U
+ PD=8.38U rfmode=0
M$125 \$33 \$2 \$26 vdd sg13_hv_pmos L=1U W=8U AS=1.52P AD=1.52P PS=8.38U
+ PD=8.38U rfmode=0
M$126 \$26 \$2 \$33 vdd sg13_hv_pmos L=1U W=8U AS=1.52P AD=2.72P PS=8.38U
+ PD=16.68U rfmode=0
M$127 out vbn vss vss sg13_hv_nmos L=1U W=8U AS=2.72P AD=1.52P PS=16.68U
+ PD=8.38U rfmode=0
M$128 vss vbn out vss sg13_hv_nmos L=1U W=8U AS=1.52P AD=1.52P PS=8.38U
+ PD=8.38U rfmode=0
M$129 out vbn vss vss sg13_hv_nmos L=1U W=8U AS=1.52P AD=1.52P PS=8.38U
+ PD=8.38U rfmode=0
M$130 vss vbn out vss sg13_hv_nmos L=1U W=8U AS=1.52P AD=1.52P PS=8.38U
+ PD=8.38U rfmode=0
M$131 out vbn vss vss sg13_hv_nmos L=1U W=8U AS=1.52P AD=1.52P PS=8.38U
+ PD=8.38U rfmode=0
M$132 vss vbn out vss sg13_hv_nmos L=1U W=8U AS=1.52P AD=1.52P PS=8.38U
+ PD=8.38U rfmode=0
M$133 out vbn vss vss sg13_hv_nmos L=1U W=8U AS=1.52P AD=1.52P PS=8.38U
+ PD=8.38U rfmode=0
M$134 vss vbn out vss sg13_hv_nmos L=1U W=8U AS=1.52P AD=1.52P PS=8.38U
+ PD=8.38U rfmode=0
M$135 out vbn vss vss sg13_hv_nmos L=1U W=8U AS=1.52P AD=1.52P PS=8.38U
+ PD=8.38U rfmode=0
M$136 vss vbn out vss sg13_hv_nmos L=1U W=8U AS=1.52P AD=1.52P PS=8.38U
+ PD=8.38U rfmode=0
M$137 out vbn vss vss sg13_hv_nmos L=1U W=8U AS=1.52P AD=1.52P PS=8.38U
+ PD=8.38U rfmode=0
M$138 vss vbn out vss sg13_hv_nmos L=1U W=8U AS=1.52P AD=2.72P PS=8.38U
+ PD=16.68U rfmode=0
M$139 \$19 \$5 \$4 vss sg13_hv_nmos L=1U W=8U AS=2.72P AD=1.52P PS=16.68U
+ PD=8.38U rfmode=0
M$140 \$4 \$5 \$19 vss sg13_hv_nmos L=1U W=8U AS=1.52P AD=1.52P PS=8.38U
+ PD=8.38U rfmode=0
M$141 \$19 \$5 \$4 vss sg13_hv_nmos L=1U W=8U AS=1.52P AD=1.52P PS=8.38U
+ PD=8.38U rfmode=0
M$142 \$4 \$5 \$19 vss sg13_hv_nmos L=1U W=8U AS=1.52P AD=1.52P PS=8.38U
+ PD=8.38U rfmode=0
M$143 \$19 \$5 \$4 vss sg13_hv_nmos L=1U W=8U AS=1.52P AD=1.52P PS=8.38U
+ PD=8.38U rfmode=0
M$144 \$4 \$5 \$19 vss sg13_hv_nmos L=1U W=8U AS=1.52P AD=2.72P PS=8.38U
+ PD=16.68U rfmode=0
M$145 \$33 \$5 \$7 vss sg13_hv_nmos L=1U W=8U AS=2.72P AD=1.52P PS=16.68U
+ PD=8.38U rfmode=0
M$146 \$7 \$5 \$33 vss sg13_hv_nmos L=1U W=8U AS=1.52P AD=1.52P PS=8.38U
+ PD=8.38U rfmode=0
M$147 \$33 \$5 \$7 vss sg13_hv_nmos L=1U W=8U AS=1.52P AD=1.52P PS=8.38U
+ PD=8.38U rfmode=0
M$148 \$7 \$5 \$33 vss sg13_hv_nmos L=1U W=8U AS=1.52P AD=1.52P PS=8.38U
+ PD=8.38U rfmode=0
M$149 \$33 \$5 \$7 vss sg13_hv_nmos L=1U W=8U AS=1.52P AD=1.52P PS=8.38U
+ PD=8.38U rfmode=0
M$150 \$7 \$5 \$33 vss sg13_hv_nmos L=1U W=8U AS=1.52P AD=2.72P PS=8.38U
+ PD=16.68U rfmode=0
M$151 \$4 vbn vss vss sg13_hv_nmos L=1U W=8U AS=2.72P AD=1.52P PS=16.68U
+ PD=8.38U rfmode=0
M$152 vss vbn \$4 vss sg13_hv_nmos L=1U W=8U AS=1.52P AD=1.52P PS=8.38U
+ PD=8.38U rfmode=0
M$153 \$4 vbn vss vss sg13_hv_nmos L=1U W=8U AS=1.52P AD=1.52P PS=8.38U
+ PD=8.38U rfmode=0
M$154 vss vbn \$4 vss sg13_hv_nmos L=1U W=8U AS=1.52P AD=1.52P PS=8.38U
+ PD=8.38U rfmode=0
M$155 \$4 vbn vss vss sg13_hv_nmos L=1U W=8U AS=1.52P AD=1.52P PS=8.38U
+ PD=8.38U rfmode=0
M$156 vss vbn \$4 vss sg13_hv_nmos L=1U W=8U AS=1.52P AD=1.52P PS=8.38U
+ PD=8.38U rfmode=0
M$157 \$4 vbn vss vss sg13_hv_nmos L=1U W=8U AS=1.52P AD=1.52P PS=8.38U
+ PD=8.38U rfmode=0
M$158 vss vbn \$4 vss sg13_hv_nmos L=1U W=8U AS=1.52P AD=1.52P PS=8.38U
+ PD=8.38U rfmode=0
M$159 \$4 vbn vss vss sg13_hv_nmos L=1U W=8U AS=1.52P AD=1.52P PS=8.38U
+ PD=8.38U rfmode=0
M$160 vss vbn \$4 vss sg13_hv_nmos L=1U W=8U AS=1.52P AD=2.72P PS=8.38U
+ PD=16.68U rfmode=0
M$161 \$7 vbn vss vss sg13_hv_nmos L=1U W=8U AS=2.72P AD=1.52P PS=16.68U
+ PD=8.38U rfmode=0
M$162 vss vbn \$7 vss sg13_hv_nmos L=1U W=8U AS=1.52P AD=1.52P PS=8.38U
+ PD=8.38U rfmode=0
M$163 \$7 vbn vss vss sg13_hv_nmos L=1U W=8U AS=1.52P AD=1.52P PS=8.38U
+ PD=8.38U rfmode=0
M$164 vss vbn \$7 vss sg13_hv_nmos L=1U W=8U AS=1.52P AD=1.52P PS=8.38U
+ PD=8.38U rfmode=0
M$165 \$7 vbn vss vss sg13_hv_nmos L=1U W=8U AS=1.52P AD=1.52P PS=8.38U
+ PD=8.38U rfmode=0
M$166 vss vbn \$7 vss sg13_hv_nmos L=1U W=8U AS=1.52P AD=1.52P PS=8.38U
+ PD=8.38U rfmode=0
M$167 \$7 vbn vss vss sg13_hv_nmos L=1U W=8U AS=1.52P AD=1.52P PS=8.38U
+ PD=8.38U rfmode=0
M$168 vss vbn \$7 vss sg13_hv_nmos L=1U W=8U AS=1.52P AD=1.52P PS=8.38U
+ PD=8.38U rfmode=0
M$169 \$7 vbn vss vss sg13_hv_nmos L=1U W=8U AS=1.52P AD=1.52P PS=8.38U
+ PD=8.38U rfmode=0
M$170 vss vbn \$7 vss sg13_hv_nmos L=1U W=8U AS=1.52P AD=2.72P PS=8.38U
+ PD=16.68U rfmode=0
M$171 \$3 vbn vss vss sg13_hv_nmos L=1U W=8U AS=2.72P AD=2.72P PS=16.68U
+ PD=16.68U rfmode=0
M$172 \$2 vbn vss vss sg13_hv_nmos L=1U W=8U AS=2.72P AD=2.72P PS=16.68U
+ PD=16.68U rfmode=0
M$173 \$5 \$5 vss vss sg13_hv_nmos L=1U W=1.6U AS=0.544P AD=0.544P PS=3.88U
+ PD=3.88U rfmode=0
.ENDS g1_ota
