* Extracted by KLayout with SG13G2 LVS runset on : 19/09/2026 09:35

.SUBCKT g1_sense iptat isense sense_n sense_p vdd vped vref vref_buf vss
X$1 vss iptat isense vdd \$30 \$31 g1_ota
X$98 vss iptat vref_buf vdd vref_buf vref g1_ota
X$99 vss iptat vped vdd vped \$38 g1_ota
M$1 vss iptat iptat vss sg13_hv_nmos L=1u W=3.3u AS=1.122p AD=1.122p PS=7.28u
+ PD=7.28u rfmode=0
R$2 \$8 \$38 vss rppd w=2u l=76.7u ps=0u b=0 m=1
R$3 \$63 vss vss rppd w=2u l=76.7u ps=0u b=0 m=1
R$4 sense_n \$30 vss rppd w=2u l=76.7u ps=0u b=0 m=1
R$5 \$19 \$31 vss rppd w=2u l=76.7u ps=0u b=0 m=1
R$6 \$19 \$57 vss rppd w=2u l=76.7u ps=0u b=0 m=1
R$7 \$20 \$57 vss rppd w=2u l=76.7u ps=0u b=0 m=1
R$8 \$20 \$56 vss rppd w=2u l=76.7u ps=0u b=0 m=1
R$9 \$21 \$56 vss rppd w=2u l=76.7u ps=0u b=0 m=1
R$10 \$21 \$61 vss rppd w=2u l=76.7u ps=0u b=0 m=1
R$11 \$22 \$61 vss rppd w=2u l=76.7u ps=0u b=0 m=1
R$12 \$22 \$60 vss rppd w=2u l=76.7u ps=0u b=0 m=1
R$13 \$23 \$60 vss rppd w=2u l=76.7u ps=0u b=0 m=1
R$14 \$23 \$40 vss rppd w=2u l=76.7u ps=0u b=0 m=1
R$15 \$24 \$41 vss rppd w=2u l=76.7u ps=0u b=0 m=1
R$16 \$24 \$46 vss rppd w=2u l=76.7u ps=0u b=0 m=1
R$17 \$25 \$46 vss rppd w=2u l=76.7u ps=0u b=0 m=1
R$18 \$25 \$47 vss rppd w=2u l=76.7u ps=0u b=0 m=1
R$19 \$26 \$47 vss rppd w=2u l=76.7u ps=0u b=0 m=1
R$20 \$26 \$43 vss rppd w=2u l=76.7u ps=0u b=0 m=1
R$21 \$27 \$43 vss rppd w=2u l=76.7u ps=0u b=0 m=1
R$22 \$27 \$44 vss rppd w=2u l=76.7u ps=0u b=0 m=1
R$23 \$28 \$44 vss rppd w=2u l=76.7u ps=0u b=0 m=1
R$24 \$28 \$45 vss rppd w=2u l=76.7u ps=0u b=0 m=1
R$25 \$3 \$42 vss rppd w=2u l=76.7u ps=0u b=0 m=1
R$26 sense_p \$31 vss rppd w=2u l=76.7u ps=0u b=0 m=1
R$27 \$8 \$50 vss rppd w=2u l=76.7u ps=0u b=0 m=1
R$28 \$9 \$50 vss rppd w=2u l=76.7u ps=0u b=0 m=1
R$29 \$9 \$49 vss rppd w=2u l=76.7u ps=0u b=0 m=1
R$30 \$10 \$49 vss rppd w=2u l=76.7u ps=0u b=0 m=1
R$31 \$10 \$48 vss rppd w=2u l=76.7u ps=0u b=0 m=1
R$32 \$11 \$48 vss rppd w=2u l=76.7u ps=0u b=0 m=1
R$33 \$11 \$53 vss rppd w=2u l=76.7u ps=0u b=0 m=1
R$34 \$12 \$53 vss rppd w=2u l=76.7u ps=0u b=0 m=1
R$35 \$12 \$52 vss rppd w=2u l=76.7u ps=0u b=0 m=1
R$36 \$13 \$52 vss rppd w=2u l=76.7u ps=0u b=0 m=1
R$37 \$29 \$45 vss rppd w=2u l=76.7u ps=0u b=0 m=1
R$38 \$3 \$51 vss rppd w=2u l=76.7u ps=0u b=0 m=1
R$39 \$14 \$30 vss rppd w=2u l=76.7u ps=0u b=0 m=1
R$40 \$14 \$58 vss rppd w=2u l=76.7u ps=0u b=0 m=1
R$41 \$15 \$58 vss rppd w=2u l=76.7u ps=0u b=0 m=1
R$42 \$15 \$59 vss rppd w=2u l=76.7u ps=0u b=0 m=1
R$43 \$16 \$59 vss rppd w=2u l=76.7u ps=0u b=0 m=1
R$44 \$16 \$55 vss rppd w=2u l=76.7u ps=0u b=0 m=1
R$45 \$17 \$55 vss rppd w=2u l=76.7u ps=0u b=0 m=1
R$46 \$17 \$54 vss rppd w=2u l=76.7u ps=0u b=0 m=1
R$47 \$18 \$54 vss rppd w=2u l=76.7u ps=0u b=0 m=1
R$48 \$18 \$39 vss rppd w=2u l=76.7u ps=0u b=0 m=1
R$49 \$13 \$51 vss rppd w=2u l=76.7u ps=0u b=0 m=1
R$50 \$74 \$38 vss rppd w=2u l=76.7u ps=0u b=0 m=1
R$51 \$73 \$39 vss rppd w=2u l=76.7u ps=0u b=0 m=1
R$52 \$73 \$110 vss rppd w=2u l=76.7u ps=0u b=0 m=1
R$53 \$78 \$110 vss rppd w=2u l=76.7u ps=0u b=0 m=1
R$54 \$78 \$111 vss rppd w=2u l=76.7u ps=0u b=0 m=1
R$55 \$77 \$111 vss rppd w=2u l=76.7u ps=0u b=0 m=1
R$56 \$77 \$109 vss rppd w=2u l=76.7u ps=0u b=0 m=1
R$57 \$76 \$109 vss rppd w=2u l=76.7u ps=0u b=0 m=1
R$58 \$76 \$108 vss rppd w=2u l=76.7u ps=0u b=0 m=1
R$59 \$81 \$108 vss rppd w=2u l=76.7u ps=0u b=0 m=1
R$60 \$81 isense vss rppd w=2u l=76.7u ps=0u b=0 m=1
R$61 \$74 vref_buf vss rppd w=2u l=76.7u ps=0u b=0 m=1
R$62 \$80 \$106 vss rppd w=2u l=76.7u ps=0u b=0 m=1
R$63 \$79 \$106 vss rppd w=2u l=76.7u ps=0u b=0 m=1
R$64 \$79 \$107 vss rppd w=2u l=76.7u ps=0u b=0 m=1
R$65 \$84 \$107 vss rppd w=2u l=76.7u ps=0u b=0 m=1
R$66 \$84 \$93 vss rppd w=2u l=76.7u ps=0u b=0 m=1
R$67 \$83 \$93 vss rppd w=2u l=76.7u ps=0u b=0 m=1
R$68 \$83 \$94 vss rppd w=2u l=76.7u ps=0u b=0 m=1
R$69 \$82 \$94 vss rppd w=2u l=76.7u ps=0u b=0 m=1
R$70 \$82 \$95 vss rppd w=2u l=76.7u ps=0u b=0 m=1
R$71 \$63 \$95 vss rppd w=2u l=76.7u ps=0u b=0 m=1
R$72 \$80 \$87 vss rppd w=2u l=76.7u ps=0u b=0 m=1
R$73 \$29 \$42 vss rppd w=2u l=76.7u ps=0u b=0 m=1
R$74 \$64 \$96 vss rppd w=2u l=76.7u ps=0u b=0 m=1
R$75 \$65 \$96 vss rppd w=2u l=76.7u ps=0u b=0 m=1
R$76 \$65 \$100 vss rppd w=2u l=76.7u ps=0u b=0 m=1
R$77 \$66 \$100 vss rppd w=2u l=76.7u ps=0u b=0 m=1
R$78 \$66 \$99 vss rppd w=2u l=76.7u ps=0u b=0 m=1
R$79 \$67 \$99 vss rppd w=2u l=76.7u ps=0u b=0 m=1
R$80 \$67 \$98 vss rppd w=2u l=76.7u ps=0u b=0 m=1
R$81 \$68 \$98 vss rppd w=2u l=76.7u ps=0u b=0 m=1
R$82 \$68 \$97 vss rppd w=2u l=76.7u ps=0u b=0 m=1
R$83 \$69 \$97 vss rppd w=2u l=76.7u ps=0u b=0 m=1
R$84 \$69 \$101 vss rppd w=2u l=76.7u ps=0u b=0 m=1
R$85 \$41 \$101 vss rppd w=2u l=76.7u ps=0u b=0 m=1
R$86 \$62 \$40 vss rppd w=2u l=76.7u ps=0u b=0 m=1
R$87 \$62 \$104 vss rppd w=2u l=76.7u ps=0u b=0 m=1
R$88 \$72 \$104 vss rppd w=2u l=76.7u ps=0u b=0 m=1
R$89 \$72 \$103 vss rppd w=2u l=76.7u ps=0u b=0 m=1
R$90 \$71 \$103 vss rppd w=2u l=76.7u ps=0u b=0 m=1
R$91 \$71 \$102 vss rppd w=2u l=76.7u ps=0u b=0 m=1
R$92 \$70 \$102 vss rppd w=2u l=76.7u ps=0u b=0 m=1
R$93 \$70 \$105 vss rppd w=2u l=76.7u ps=0u b=0 m=1
R$94 \$75 \$105 vss rppd w=2u l=76.7u ps=0u b=0 m=1
R$95 \$64 \$87 vss rppd w=2u l=76.7u ps=0u b=0 m=1
R$96 \$75 vped vss rppd w=2u l=76.7u ps=0u b=0 m=1
.ENDS g1_sense

.SUBCKT g1_ota vss vbn out vdd inn inp
C$1 \$32 out cap_cmim w=23u l=23u A=529p P=92u m=1
R$2 \$33 \$32 vss rppd w=1u l=6.2u ps=0u b=0 m=1
M$3 vdd \$33 out vdd sg13_hv_pmos L=1u W=192u AS=37.68p AD=37.68p PS=209.42u
+ PD=209.42u rfmode=0
M$27 vdd \$3 \$28 vdd sg13_hv_pmos L=1u W=128u AS=25.52p AD=25.52p PS=142.38u
+ PD=142.38u rfmode=0
M$43 vdd \$3 \$5 vdd sg13_hv_pmos L=1u W=16u AS=4.24p AD=4.24p PS=25.06u
+ PD=25.06u rfmode=0
M$45 vdd \$3 \$3 vdd sg13_hv_pmos L=1u W=16u AS=4.24p AD=4.24p PS=25.06u
+ PD=25.06u rfmode=0
M$47 vdd \$2 \$2 vdd sg13_hv_pmos L=1u W=3.2u AS=1.088p AD=1.088p PS=7.08u
+ PD=7.08u rfmode=0
M$48 \$28 inn \$4 vdd sg13_hv_pmos L=2u W=96u AS=19.14p AD=19.14p PS=108.38u
+ PD=108.38u rfmode=0
M$50 \$28 inp \$7 vdd sg13_hv_pmos L=2u W=96u AS=18.24p AD=18.24p PS=102.08u
+ PD=102.08u rfmode=0
M$80 \$25 \$2 \$19 vdd sg13_hv_pmos L=1u W=96u AS=19.44p AD=19.44p PS=108.86u
+ PD=108.86u rfmode=0
M$92 vdd \$19 \$25 vdd sg13_hv_pmos L=1u W=96u AS=19.44p AD=19.44p PS=108.86u
+ PD=108.86u rfmode=0
M$104 vdd \$19 \$26 vdd sg13_hv_pmos L=1u W=96u AS=19.44p AD=19.44p PS=108.86u
+ PD=108.86u rfmode=0
M$116 \$26 \$2 \$33 vdd sg13_hv_pmos L=1u W=96u AS=19.44p AD=19.44p PS=108.86u
+ PD=108.86u rfmode=0
M$128 vss vbn out vss sg13_hv_nmos L=1u W=96u AS=19.44p AD=19.44p PS=108.86u
+ PD=108.86u rfmode=0
M$140 \$4 \$5 \$19 vss sg13_hv_nmos L=1u W=48u AS=10.32p AD=10.32p PS=58.58u
+ PD=58.58u rfmode=0
M$146 \$7 \$5 \$33 vss sg13_hv_nmos L=1u W=48u AS=10.32p AD=10.32p PS=58.58u
+ PD=58.58u rfmode=0
M$152 vss vbn \$4 vss sg13_hv_nmos L=1u W=80u AS=16.4p AD=16.4p PS=92.1u
+ PD=92.1u rfmode=0
M$162 vss vbn \$7 vss sg13_hv_nmos L=1u W=80u AS=16.4p AD=16.4p PS=92.1u
+ PD=92.1u rfmode=0
M$172 vss vbn \$3 vss sg13_hv_nmos L=1u W=8u AS=2.72p AD=2.72p PS=16.68u
+ PD=16.68u rfmode=0
M$173 vss vbn \$2 vss sg13_hv_nmos L=1u W=8u AS=2.72p AD=2.72p PS=16.68u
+ PD=16.68u rfmode=0
M$174 vss \$5 \$5 vss sg13_hv_nmos L=1u W=1.6u AS=0.544p AD=0.544p PS=3.88u
+ PD=3.88u rfmode=0
.ENDS g1_ota
