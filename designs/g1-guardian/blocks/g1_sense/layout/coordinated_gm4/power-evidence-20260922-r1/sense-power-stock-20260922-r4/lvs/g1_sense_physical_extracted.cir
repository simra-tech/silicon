* Extracted by KLayout with SG13G2 LVS runset on : 22/09/2026 23:03

.SUBCKT g1_sense_physical iptat isense sense_n sense_p vdd vped vref vref_buf
+ vss
X$1 vss \$72 vdd \$73 iptat isense g1_ota_main_candidate
X$2 iptat vped vss vdd vped \$74 g1_ota
X$4 iptat vref_buf vss vdd vref_buf vref g1_ota
R$1 \$8 \$74 vss rppd w=2u l=76.7u ps=0u b=0 m=1
R$2 \$8 \$43 vss rppd w=2u l=76.7u ps=0u b=0 m=1
R$3 \$9 \$43 vss rppd w=2u l=76.7u ps=0u b=0 m=1
R$4 \$9 \$44 vss rppd w=2u l=76.7u ps=0u b=0 m=1
R$5 \$10 \$44 vss rppd w=2u l=76.7u ps=0u b=0 m=1
R$6 \$10 \$45 vss rppd w=2u l=76.7u ps=0u b=0 m=1
R$7 \$11 \$45 vss rppd w=2u l=76.7u ps=0u b=0 m=1
R$8 \$11 \$46 vss rppd w=2u l=76.7u ps=0u b=0 m=1
R$9 \$12 \$46 vss rppd w=2u l=76.7u ps=0u b=0 m=1
R$10 \$12 \$47 vss rppd w=2u l=76.7u ps=0u b=0 m=1
R$11 \$13 \$47 vss rppd w=2u l=76.7u ps=0u b=0 m=1
R$12 \$13 \$48 vss rppd w=2u l=76.7u ps=0u b=0 m=1
R$13 \$14 \$48 vss rppd w=2u l=76.7u ps=0u b=0 m=1
R$14 \$15 \$72 vss rppd w=2u l=76.7u ps=0u b=0 m=1
R$15 \$15 \$49 vss rppd w=2u l=76.7u ps=0u b=0 m=1
R$16 \$16 \$49 vss rppd w=2u l=76.7u ps=0u b=0 m=1
R$17 \$16 \$50 vss rppd w=2u l=76.7u ps=0u b=0 m=1
R$18 \$17 \$50 vss rppd w=2u l=76.7u ps=0u b=0 m=1
R$19 \$17 \$51 vss rppd w=2u l=76.7u ps=0u b=0 m=1
R$20 \$18 \$51 vss rppd w=2u l=76.7u ps=0u b=0 m=1
R$21 \$18 \$52 vss rppd w=2u l=76.7u ps=0u b=0 m=1
R$22 \$19 \$52 vss rppd w=2u l=76.7u ps=0u b=0 m=1
R$23 \$19 \$53 vss rppd w=2u l=76.7u ps=0u b=0 m=1
R$24 sense_n \$72 vss rppd w=2u l=76.7u ps=0u b=0 m=1
R$25 sense_p \$73 vss rppd w=2u l=76.7u ps=0u b=0 m=1
R$26 \$22 \$73 vss rppd w=2u l=76.7u ps=0u b=0 m=1
R$27 \$22 \$54 vss rppd w=2u l=76.7u ps=0u b=0 m=1
R$28 \$23 \$54 vss rppd w=2u l=76.7u ps=0u b=0 m=1
R$29 \$23 \$55 vss rppd w=2u l=76.7u ps=0u b=0 m=1
R$30 \$24 \$55 vss rppd w=2u l=76.7u ps=0u b=0 m=1
R$31 \$24 \$56 vss rppd w=2u l=76.7u ps=0u b=0 m=1
R$32 \$25 \$56 vss rppd w=2u l=76.7u ps=0u b=0 m=1
R$33 \$25 \$57 vss rppd w=2u l=76.7u ps=0u b=0 m=1
R$34 \$26 \$57 vss rppd w=2u l=76.7u ps=0u b=0 m=1
R$35 \$26 \$58 vss rppd w=2u l=76.7u ps=0u b=0 m=1
R$36 \$27 \$59 vss rppd w=2u l=76.7u ps=0u b=0 m=1
R$37 \$27 \$60 vss rppd w=2u l=76.7u ps=0u b=0 m=1
R$38 \$28 \$60 vss rppd w=2u l=76.7u ps=0u b=0 m=1
R$39 \$28 \$61 vss rppd w=2u l=76.7u ps=0u b=0 m=1
R$40 \$29 \$61 vss rppd w=2u l=76.7u ps=0u b=0 m=1
R$41 \$29 \$62 vss rppd w=2u l=76.7u ps=0u b=0 m=1
R$42 \$30 \$62 vss rppd w=2u l=76.7u ps=0u b=0 m=1
R$43 \$30 \$63 vss rppd w=2u l=76.7u ps=0u b=0 m=1
R$44 \$31 \$63 vss rppd w=2u l=76.7u ps=0u b=0 m=1
R$45 \$31 \$64 vss rppd w=2u l=76.7u ps=0u b=0 m=1
R$46 \$32 \$64 vss rppd w=2u l=76.7u ps=0u b=0 m=1
R$47 \$32 \$65 vss rppd w=2u l=76.7u ps=0u b=0 m=1
R$48 \$14 \$65 vss rppd w=2u l=76.7u ps=0u b=0 m=1
R$49 \$75 \$131 vss rppd w=2u l=76.7u ps=0u b=0 m=1
R$50 \$75 \$132 vss rppd w=2u l=76.7u ps=0u b=0 m=1
R$51 \$76 \$132 vss rppd w=2u l=76.7u ps=0u b=0 m=1
R$52 \$76 \$133 vss rppd w=2u l=76.7u ps=0u b=0 m=1
R$53 \$77 \$133 vss rppd w=2u l=76.7u ps=0u b=0 m=1
R$54 \$77 \$134 vss rppd w=2u l=76.7u ps=0u b=0 m=1
R$55 \$78 \$134 vss rppd w=2u l=76.7u ps=0u b=0 m=1
R$56 \$78 \$135 vss rppd w=2u l=76.7u ps=0u b=0 m=1
R$57 \$79 \$135 vss rppd w=2u l=76.7u ps=0u b=0 m=1
R$58 \$79 \$136 vss rppd w=2u l=76.7u ps=0u b=0 m=1
R$59 \$80 \$136 vss rppd w=2u l=76.7u ps=0u b=0 m=1
R$60 \$80 \$137 vss rppd w=2u l=76.7u ps=0u b=0 m=1
R$61 \$59 \$137 vss rppd w=2u l=76.7u ps=0u b=0 m=1
R$62 \$81 \$58 vss rppd w=2u l=76.7u ps=0u b=0 m=1
R$63 \$81 \$138 vss rppd w=2u l=76.7u ps=0u b=0 m=1
R$64 \$82 \$138 vss rppd w=2u l=76.7u ps=0u b=0 m=1
R$65 \$82 \$139 vss rppd w=2u l=76.7u ps=0u b=0 m=1
R$66 \$83 \$139 vss rppd w=2u l=76.7u ps=0u b=0 m=1
R$67 \$83 \$140 vss rppd w=2u l=76.7u ps=0u b=0 m=1
R$68 \$84 \$140 vss rppd w=2u l=76.7u ps=0u b=0 m=1
R$69 \$84 \$141 vss rppd w=2u l=76.7u ps=0u b=0 m=1
R$70 \$85 \$141 vss rppd w=2u l=76.7u ps=0u b=0 m=1
R$71 \$85 vped vss rppd w=2u l=76.7u ps=0u b=0 m=1
R$72 \$86 vref_buf vss rppd w=2u l=76.7u ps=0u b=0 m=1
R$73 \$86 \$74 vss rppd w=2u l=76.7u ps=0u b=0 m=1
R$74 \$87 \$53 vss rppd w=2u l=76.7u ps=0u b=0 m=1
R$75 \$87 \$142 vss rppd w=2u l=76.7u ps=0u b=0 m=1
R$76 \$88 \$142 vss rppd w=2u l=76.7u ps=0u b=0 m=1
R$77 \$88 \$143 vss rppd w=2u l=76.7u ps=0u b=0 m=1
R$78 \$89 \$143 vss rppd w=2u l=76.7u ps=0u b=0 m=1
R$79 \$89 \$144 vss rppd w=2u l=76.7u ps=0u b=0 m=1
R$80 \$90 \$144 vss rppd w=2u l=76.7u ps=0u b=0 m=1
R$81 \$90 \$145 vss rppd w=2u l=76.7u ps=0u b=0 m=1
R$82 \$91 \$145 vss rppd w=2u l=76.7u ps=0u b=0 m=1
R$83 \$91 isense vss rppd w=2u l=76.7u ps=0u b=0 m=1
R$84 \$92 \$131 vss rppd w=2u l=76.7u ps=0u b=0 m=1
R$85 \$92 \$146 vss rppd w=2u l=76.7u ps=0u b=0 m=1
R$86 \$93 \$146 vss rppd w=2u l=76.7u ps=0u b=0 m=1
R$87 \$93 \$147 vss rppd w=2u l=76.7u ps=0u b=0 m=1
R$88 \$94 \$147 vss rppd w=2u l=76.7u ps=0u b=0 m=1
R$89 \$94 \$148 vss rppd w=2u l=76.7u ps=0u b=0 m=1
R$90 \$95 \$148 vss rppd w=2u l=76.7u ps=0u b=0 m=1
R$91 \$95 \$149 vss rppd w=2u l=76.7u ps=0u b=0 m=1
R$92 \$96 \$149 vss rppd w=2u l=76.7u ps=0u b=0 m=1
R$93 \$96 \$150 vss rppd w=2u l=76.7u ps=0u b=0 m=1
R$94 \$97 \$150 vss rppd w=2u l=76.7u ps=0u b=0 m=1
R$95 \$97 vss vss rppd w=2u l=76.7u ps=0u b=0 m=1
M$96 vss iptat iptat vss sg13_hv_nmos L=1u W=3.3u AS=1.122p AD=1.122p PS=7.28u
+ PD=7.28u rfmode=0
.ENDS g1_sense_physical

.SUBCKT g1_ota vbn out vss vdd inn inp
M$1 vss \$4 \$4 vss sg13_hv_nmos L=1u W=1.6u AS=0.544p AD=0.544p PS=3.88u
+ PD=3.88u rfmode=0
M$2 vss vbn \$2 vss sg13_hv_nmos L=1u W=8u AS=2.12p AD=2.12p PS=13.06u
+ PD=13.06u rfmode=0
M$4 vss vbn \$1 vss sg13_hv_nmos L=1u W=8u AS=2.12p AD=2.12p PS=13.06u
+ PD=13.06u rfmode=0
M$6 vss vbn \$3 vss sg13_hv_nmos L=1u W=80u AS=16.4p AD=16.4p PS=92.1u PD=92.1u
+ rfmode=0
M$16 \$3 \$4 \$9 vss sg13_hv_nmos L=1u W=48u AS=10.32p AD=10.32p PS=58.58u
+ PD=58.58u rfmode=0
M$22 \$6 \$4 \$10 vss sg13_hv_nmos L=1u W=48u AS=10.32p AD=10.32p PS=58.58u
+ PD=58.58u rfmode=0
M$28 vss vbn \$6 vss sg13_hv_nmos L=1u W=80u AS=16.4p AD=16.4p PS=92.1u
+ PD=92.1u rfmode=0
M$38 vss vbn out vss sg13_hv_nmos L=1u W=96u AS=19.44p AD=19.44p PS=108.86u
+ PD=108.86u rfmode=0
M$50 vdd \$9 \$30 vdd sg13_hv_pmos L=1u W=96u AS=19.44p AD=19.44p PS=108.86u
+ PD=108.86u rfmode=0
M$62 \$30 \$1 \$9 vdd sg13_hv_pmos L=1u W=96u AS=19.44p AD=19.44p PS=108.86u
+ PD=108.86u rfmode=0
M$74 \$31 \$1 \$10 vdd sg13_hv_pmos L=1u W=96u AS=19.44p AD=19.44p PS=108.86u
+ PD=108.86u rfmode=0
M$86 vdd \$9 \$31 vdd sg13_hv_pmos L=1u W=96u AS=19.44p AD=19.44p PS=108.86u
+ PD=108.86u rfmode=0
M$98 \$41 inn \$3 vdd sg13_hv_pmos L=2u W=96u AS=19.14p AD=19.14p PS=108.38u
+ PD=108.38u rfmode=0
M$100 \$41 inp \$6 vdd sg13_hv_pmos L=2u W=96u AS=19.14p AD=19.14p PS=108.38u
+ PD=108.38u rfmode=0
M$114 vdd \$1 \$1 vdd sg13_hv_pmos L=1u W=3.2u AS=1.088p AD=1.088p PS=7.08u
+ PD=7.08u rfmode=0
M$115 vdd \$2 \$4 vdd sg13_hv_pmos L=1u W=16u AS=3.64p AD=3.64p PS=21.82u
+ PD=21.82u rfmode=0
M$119 vdd \$2 \$2 vdd sg13_hv_pmos L=1u W=16u AS=3.64p AD=3.64p PS=21.82u
+ PD=21.82u rfmode=0
M$123 vdd \$2 \$41 vdd sg13_hv_pmos L=1u W=128u AS=25.52p AD=25.52p PS=142.38u
+ PD=142.38u rfmode=0
M$155 vdd \$10 out vdd sg13_hv_pmos L=1u W=192u AS=37.68p AD=37.68p PS=209.42u
+ PD=209.42u rfmode=0
R$179 \$10 \$29 vss rppd w=1u l=6.2u ps=0u b=0 m=1
C$180 \$29 out cap_cmim w=23u l=23u A=529p P=92u m=1
.ENDS g1_ota

.SUBCKT g1_ota_main_candidate vss inn vdd inp vbn out
M$1 vss vbn \$3 vss sg13_hv_nmos L=4u W=320u AS=62p AD=62p PS=343.5u PD=343.5u
+ rfmode=0
M$41 vss vbn \$6 vss sg13_hv_nmos L=4u W=320u AS=62p AD=62p PS=343.5u PD=343.5u
+ rfmode=0
M$81 vss vbn \$30 vss sg13_hv_nmos L=1u W=8u AS=2.12p AD=2.12p PS=13.06u
+ PD=13.06u rfmode=0
M$83 \$3 \$31 \$13 vss sg13_hv_nmos L=1u W=48u AS=10.32p AD=10.32p PS=58.58u
+ PD=58.58u rfmode=0
M$89 vss \$31 \$31 vss sg13_hv_nmos L=1u W=1.6u AS=0.544p AD=0.544p PS=3.88u
+ PD=3.88u rfmode=0
M$90 vss vbn \$17 vss sg13_hv_nmos L=1u W=8u AS=2.12p AD=2.12p PS=13.06u
+ PD=13.06u rfmode=0
M$92 \$6 \$31 \$21 vss sg13_hv_nmos L=1u W=48u AS=10.32p AD=10.32p PS=58.58u
+ PD=58.58u rfmode=0
M$98 vss vbn out vss sg13_hv_nmos L=1u W=96u AS=19.44p AD=19.44p PS=108.86u
+ PD=108.86u rfmode=0
M$110 \$5 inn \$3 vdd sg13_hv_pmos L=2u W=384u AS=73.86p AD=73.86p PS=414.62u
+ PD=414.62u rfmode=0
M$112 \$5 inp \$6 vdd sg13_hv_pmos L=2u W=384u AS=73.86p AD=73.86p PS=414.62u
+ PD=414.62u rfmode=0
M$174 \$14 \$17 \$13 vdd sg13_hv_pmos L=4u W=384u AS=74.16p AD=74.16p
+ PS=410.54u PD=410.54u rfmode=0
M$222 vdd \$13 \$14 vdd sg13_hv_pmos L=4u W=384u AS=74.16p AD=74.16p PS=410.54u
+ PD=410.54u rfmode=0
M$270 \$20 \$17 \$21 vdd sg13_hv_pmos L=4u W=384u AS=74.16p AD=74.16p
+ PS=410.54u PD=410.54u rfmode=0
M$318 vdd \$13 \$20 vdd sg13_hv_pmos L=4u W=384u AS=74.16p AD=74.16p PS=410.54u
+ PD=410.54u rfmode=0
M$430 vdd \$30 \$5 vdd sg13_hv_pmos L=1u W=128u AS=25.52p AD=25.52p PS=142.38u
+ PD=142.38u rfmode=0
M$446 vdd \$30 \$30 vdd sg13_hv_pmos L=1u W=16u AS=3.64p AD=3.64p PS=21.82u
+ PD=21.82u rfmode=0
M$450 vdd \$30 \$31 vdd sg13_hv_pmos L=1u W=16u AS=3.64p AD=3.64p PS=21.82u
+ PD=21.82u rfmode=0
M$454 vdd \$17 \$17 vdd sg13_hv_pmos L=1u W=3.2u AS=1.088p AD=1.088p PS=7.08u
+ PD=7.08u rfmode=0
M$455 vdd \$21 out vdd sg13_hv_pmos L=1u W=192u AS=37.68p AD=37.68p PS=209.42u
+ PD=209.42u rfmode=0
R$479 \$21 \$32 vss rppd w=1u l=6.2u ps=0u b=0 m=1
C$480 \$32 out cap_cmim w=69u l=23u A=1587p P=184u m=1
.ENDS g1_ota_main_candidate
