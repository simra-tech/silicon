.subckt g1_main_pair_stacked64 inn inp fn fp tail vdd vss
MM1 fn inn tail vdd sg13_hv_pmos w=384u l=2u m=1
MM2 fp inp tail vdd sg13_hv_pmos w=384u l=2u m=1
.ends g1_main_pair_stacked64
