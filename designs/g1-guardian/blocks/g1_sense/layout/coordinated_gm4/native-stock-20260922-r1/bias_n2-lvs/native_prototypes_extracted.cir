* Extracted by KLayout with SG13G2 LVS runset on : 22/09/2026 19:13

.SUBCKT bias_n2 d g vss
M$1 vss g d vss sg13_hv_nmos L=1u W=8u AS=2.12p AD=2.12p PS=13.06u PD=13.06u
+ rfmode=0
.ENDS bias_n2
