* Extracted by KLayout with SG13G2 LVS runset on : 22/09/2026 19:13

.SUBCKT pair_control16 fn fp inn inp tail vdd
M$1 tail inn fn vdd sg13_hv_pmos L=2u W=96u AS=19.14p AD=19.14p PS=108.38u
+ PD=108.38u rfmode=0
M$17 tail inp fp vdd sg13_hv_pmos L=2u W=96u AS=19.14p AD=19.14p PS=108.38u
+ PD=108.38u rfmode=0
.ENDS pair_control16
