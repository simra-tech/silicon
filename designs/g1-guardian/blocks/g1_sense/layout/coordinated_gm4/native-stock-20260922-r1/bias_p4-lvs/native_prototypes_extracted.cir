* Extracted by KLayout with SG13G2 LVS runset on : 22/09/2026 19:13

.SUBCKT bias_p4 d g vdd
M$1 vdd g d vdd sg13_hv_pmos L=1u W=16u AS=3.64p AD=3.64p PS=21.82u PD=21.82u
+ rfmode=0
.ENDS bias_p4
