.subckt g1_sense_physical sense_p sense_n vref iptat isense vped vref_buf vdd vss
RR1N0 sense_n vn vss rppd w=2u l=76.7u m=1 b=0
RR2N0 vn R2N_0 vss rppd w=2u l=76.7u m=1 b=0
RR2N1 R2N_0 R2N_1 vss rppd w=2u l=76.7u m=1 b=0
RR2N2 R2N_1 R2N_2 vss rppd w=2u l=76.7u m=1 b=0
RR2N3 R2N_2 R2N_3 vss rppd w=2u l=76.7u m=1 b=0
RR2N4 R2N_3 R2N_4 vss rppd w=2u l=76.7u m=1 b=0
RR2N5 R2N_4 R2N_5 vss rppd w=2u l=76.7u m=1 b=0
RR2N6 R2N_5 R2N_6 vss rppd w=2u l=76.7u m=1 b=0
RR2N7 R2N_6 R2N_7 vss rppd w=2u l=76.7u m=1 b=0
RR2N8 R2N_7 R2N_8 vss rppd w=2u l=76.7u m=1 b=0
RR2N9 R2N_8 R2N_9 vss rppd w=2u l=76.7u m=1 b=0
RR2N10 R2N_9 R2N_10 vss rppd w=2u l=76.7u m=1 b=0
RR2N11 R2N_10 R2N_11 vss rppd w=2u l=76.7u m=1 b=0
RR2N12 R2N_11 R2N_12 vss rppd w=2u l=76.7u m=1 b=0
RR2N13 R2N_12 R2N_13 vss rppd w=2u l=76.7u m=1 b=0
RR2N14 R2N_13 R2N_14 vss rppd w=2u l=76.7u m=1 b=0
RR2N15 R2N_14 R2N_15 vss rppd w=2u l=76.7u m=1 b=0
RR2N16 R2N_15 R2N_16 vss rppd w=2u l=76.7u m=1 b=0
RR2N17 R2N_16 R2N_17 vss rppd w=2u l=76.7u m=1 b=0
RR2N18 R2N_17 R2N_18 vss rppd w=2u l=76.7u m=1 b=0
RR2N19 R2N_18 isense vss rppd w=2u l=76.7u m=1 b=0
RR1P0 sense_p vp vss rppd w=2u l=76.7u m=1 b=0
RR2P0 vp R2P_0 vss rppd w=2u l=76.7u m=1 b=0
RR2P1 R2P_0 R2P_1 vss rppd w=2u l=76.7u m=1 b=0
RR2P2 R2P_1 R2P_2 vss rppd w=2u l=76.7u m=1 b=0
RR2P3 R2P_2 R2P_3 vss rppd w=2u l=76.7u m=1 b=0
RR2P4 R2P_3 R2P_4 vss rppd w=2u l=76.7u m=1 b=0
RR2P5 R2P_4 R2P_5 vss rppd w=2u l=76.7u m=1 b=0
RR2P6 R2P_5 R2P_6 vss rppd w=2u l=76.7u m=1 b=0
RR2P7 R2P_6 R2P_7 vss rppd w=2u l=76.7u m=1 b=0
RR2P8 R2P_7 R2P_8 vss rppd w=2u l=76.7u m=1 b=0
RR2P9 R2P_8 R2P_9 vss rppd w=2u l=76.7u m=1 b=0
RR2P10 R2P_9 R2P_10 vss rppd w=2u l=76.7u m=1 b=0
RR2P11 R2P_10 R2P_11 vss rppd w=2u l=76.7u m=1 b=0
RR2P12 R2P_11 R2P_12 vss rppd w=2u l=76.7u m=1 b=0
RR2P13 R2P_12 R2P_13 vss rppd w=2u l=76.7u m=1 b=0
RR2P14 R2P_13 R2P_14 vss rppd w=2u l=76.7u m=1 b=0
RR2P15 R2P_14 R2P_15 vss rppd w=2u l=76.7u m=1 b=0
RR2P16 R2P_15 R2P_16 vss rppd w=2u l=76.7u m=1 b=0
RR2P17 R2P_16 R2P_17 vss rppd w=2u l=76.7u m=1 b=0
RR2P18 R2P_17 R2P_18 vss rppd w=2u l=76.7u m=1 b=0
RR2P19 R2P_18 vped vss rppd w=2u l=76.7u m=1 b=0
RRD10 vref_buf RD1_0 vss rppd w=2u l=76.7u m=1 b=0
RRD11 RD1_0 vped_ref vss rppd w=2u l=76.7u m=1 b=0
RRD20 vped_ref RD2_0 vss rppd w=2u l=76.7u m=1 b=0
RRD21 RD2_0 RD2_1 vss rppd w=2u l=76.7u m=1 b=0
RRD22 RD2_1 RD2_2 vss rppd w=2u l=76.7u m=1 b=0
RRD23 RD2_2 RD2_3 vss rppd w=2u l=76.7u m=1 b=0
RRD24 RD2_3 RD2_4 vss rppd w=2u l=76.7u m=1 b=0
RRD25 RD2_4 RD2_5 vss rppd w=2u l=76.7u m=1 b=0
RRD26 RD2_5 RD2_6 vss rppd w=2u l=76.7u m=1 b=0
RRD27 RD2_6 RD2_7 vss rppd w=2u l=76.7u m=1 b=0
RRD28 RD2_7 RD2_8 vss rppd w=2u l=76.7u m=1 b=0
RRD29 RD2_8 RD2_9 vss rppd w=2u l=76.7u m=1 b=0
RRD210 RD2_9 RD2_10 vss rppd w=2u l=76.7u m=1 b=0
RRD211 RD2_10 RD2_11 vss rppd w=2u l=76.7u m=1 b=0
RRD212 RD2_11 RD2_12 vss rppd w=2u l=76.7u m=1 b=0
RRD213 RD2_12 RD2_13 vss rppd w=2u l=76.7u m=1 b=0
RRD214 RD2_13 RD2_14 vss rppd w=2u l=76.7u m=1 b=0
RRD215 RD2_14 RD2_15 vss rppd w=2u l=76.7u m=1 b=0
RRD216 RD2_15 RD2_16 vss rppd w=2u l=76.7u m=1 b=0
RRD217 RD2_16 RD2_17 vss rppd w=2u l=76.7u m=1 b=0
RRD218 RD2_17 RD2_18 vss rppd w=2u l=76.7u m=1 b=0
RRD219 RD2_18 RD2_19 vss rppd w=2u l=76.7u m=1 b=0
RRD220 RD2_19 RD2_20 vss rppd w=2u l=76.7u m=1 b=0
RRD221 RD2_20 RD2_21 vss rppd w=2u l=76.7u m=1 b=0
RRD222 RD2_21 RD2_22 vss rppd w=2u l=76.7u m=1 b=0
RRD223 RD2_22 RD2_23 vss rppd w=2u l=76.7u m=1 b=0
RRD224 RD2_23 RD2_24 vss rppd w=2u l=76.7u m=1 b=0
RRD225 RD2_24 RD2_25 vss rppd w=2u l=76.7u m=1 b=0
RRD226 RD2_25 RD2_26 vss rppd w=2u l=76.7u m=1 b=0
RRD227 RD2_26 RD2_27 vss rppd w=2u l=76.7u m=1 b=0
RRD228 RD2_27 RD2_28 vss rppd w=2u l=76.7u m=1 b=0
RRD229 RD2_28 RD2_29 vss rppd w=2u l=76.7u m=1 b=0
RRD230 RD2_29 RD2_30 vss rppd w=2u l=76.7u m=1 b=0
RRD231 RD2_30 RD2_31 vss rppd w=2u l=76.7u m=1 b=0
RRD232 RD2_31 RD2_32 vss rppd w=2u l=76.7u m=1 b=0
RRD233 RD2_32 RD2_33 vss rppd w=2u l=76.7u m=1 b=0
RRD234 RD2_33 RD2_34 vss rppd w=2u l=76.7u m=1 b=0
RRD235 RD2_34 RD2_35 vss rppd w=2u l=76.7u m=1 b=0
RRD236 RD2_35 RD2_36 vss rppd w=2u l=76.7u m=1 b=0
RRD237 RD2_36 RD2_37 vss rppd w=2u l=76.7u m=1 b=0
RRD238 RD2_37 RD2_38 vss rppd w=2u l=76.7u m=1 b=0
RRD239 RD2_38 RD2_39 vss rppd w=2u l=76.7u m=1 b=0
RRD240 RD2_39 RD2_40 vss rppd w=2u l=76.7u m=1 b=0
RRD241 RD2_40 RD2_41 vss rppd w=2u l=76.7u m=1 b=0
RRD242 RD2_41 RD2_42 vss rppd w=2u l=76.7u m=1 b=0
RRD243 RD2_42 RD2_43 vss rppd w=2u l=76.7u m=1 b=0
RRD244 RD2_43 RD2_44 vss rppd w=2u l=76.7u m=1 b=0
RRD245 RD2_44 RD2_45 vss rppd w=2u l=76.7u m=1 b=0
RRD246 RD2_45 RD2_46 vss rppd w=2u l=76.7u m=1 b=0
RRD247 RD2_46 RD2_47 vss rppd w=2u l=76.7u m=1 b=0
RRD248 RD2_47 RD2_48 vss rppd w=2u l=76.7u m=1 b=0
RRD249 RD2_48 RD2_49 vss rppd w=2u l=76.7u m=1 b=0
RRD250 RD2_49 vss vss rppd w=2u l=76.7u m=1 b=0
MMBI iptat iptat vss vss sg13_hv_nmos w=3.3u l=1u m=1
XOTA vp vn iptat isense vdd vss g1_ota_main_candidate
XBUF vped_ref vped iptat vped vdd vss g1_ota
XREF vref vref_buf iptat vref_buf vdd vss g1_ota
.ends
.subckt g1_ota inp inn vbn out vdd vss
MMB2 vbp vbn vss vss sg13_hv_nmos w=8u l=1u m=1
MMB3 vbp vbp vdd vdd sg13_hv_pmos w=16u l=1u m=1
MMB5 vbnc vbp vdd vdd sg13_hv_pmos w=16u l=1u m=1
MMB4 vbnc vbnc vss vss sg13_hv_nmos w=1.6u l=1u m=1
MMB6 vbpc vbn vss vss sg13_hv_nmos w=8u l=1u m=1
MMB7 vbpc vbpc vdd vdd sg13_hv_pmos w=3.2u l=1u m=1
MMT tail vbp vdd vdd sg13_hv_pmos w=128u l=1u m=1
MM1 fn inn tail vdd sg13_hv_pmos w=96u l=2u m=1
MM2 fp inp tail vdd sg13_hv_pmos w=96u l=2u m=1
MM3 fn vbn vss vss sg13_hv_nmos w=80u l=1u m=1
MM4 fp vbn vss vss sg13_hv_nmos w=80u l=1u m=1
MM13 mir vbnc fn vss sg13_hv_nmos w=48u l=1u m=1
MM16 out1 vbnc fp vss sg13_hv_nmos w=48u l=1u m=1
MM14 pc1 mir vdd vdd sg13_hv_pmos w=96u l=1u m=1
MM11 pc2 mir vdd vdd sg13_hv_pmos w=96u l=1u m=1
MM15 mir vbpc pc1 vdd sg13_hv_pmos w=96u l=1u m=1
MM12 out1 vbpc pc2 vdd sg13_hv_pmos w=96u l=1u m=1
MM20 out out1 vdd vdd sg13_hv_pmos w=192u l=1u m=1
MM21 out vbn vss vss sg13_hv_nmos w=96u l=1u m=1
RRZ out1 cz vss rppd w=1u l=6.2u m=1 b=0
CCC cz out cap_cmim w=23u l=23u m=1
.ends
.subckt g1_ota_main_candidate inp inn vbn out vdd vss
MMB2 vbp vbn vss vss sg13_hv_nmos w=8u l=1u m=1
MMB3 vbp vbp vdd vdd sg13_hv_pmos w=16u l=1u m=1
MMB5 vbnc vbp vdd vdd sg13_hv_pmos w=16u l=1u m=1
MMB4 vbnc vbnc vss vss sg13_hv_nmos w=1.6u l=1u m=1
MMB6 vbpc vbn vss vss sg13_hv_nmos w=8u l=1u m=1
MMB7 vbpc vbpc vdd vdd sg13_hv_pmos w=3.2u l=1u m=1
MMT tail vbp vdd vdd sg13_hv_pmos w=128u l=1u m=1
MM1 fn inn tail vdd sg13_hv_pmos w=384u l=2u m=1
MM2 fp inp tail vdd sg13_hv_pmos w=384u l=2u m=1
MM3 fn vbn vss vss sg13_hv_nmos w=320u l=4u m=1
MM4 fp vbn vss vss sg13_hv_nmos w=320u l=4u m=1
MM13 mir vbnc fn vss sg13_hv_nmos w=48u l=1u m=1
MM16 out1 vbnc fp vss sg13_hv_nmos w=48u l=1u m=1
MM14 pc1 mir vdd vdd sg13_hv_pmos w=384u l=4u m=1
MM11 pc2 mir vdd vdd sg13_hv_pmos w=384u l=4u m=1
MM15 mir vbpc pc1 vdd sg13_hv_pmos w=384u l=4u m=1
MM12 out1 vbpc pc2 vdd sg13_hv_pmos w=384u l=4u m=1
MM20 out out1 vdd vdd sg13_hv_pmos w=192u l=1u m=1
MM21 out vbn vss vss sg13_hv_nmos w=96u l=1u m=1
RRZ out1 cz vss rppd w=1u l=6.2u m=1 b=0
CCC cz out cap_cmim w=69u l=23u m=1
.ends
