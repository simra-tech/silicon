* Native PCell method-control declaration; not extracted golden
.subckt sense_mim_method_control top bottom
C1 top bottom cap_cmim w=7u l=7u m=1
.ends sense_mim_method_control
