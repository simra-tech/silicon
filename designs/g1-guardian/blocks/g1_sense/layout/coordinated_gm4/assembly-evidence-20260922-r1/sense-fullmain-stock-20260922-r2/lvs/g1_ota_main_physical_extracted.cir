* Extracted by KLayout with SG13G2 LVS runset on : 22/09/2026 21:05

.SUBCKT g1_ota_main_physical inn inp out vbn vdd vss
M$1 vss vbn \$3 vss sg13_hv_nmos L=4u W=320u AS=62p AD=62p PS=343.5u PD=343.5u
+ rfmode=0
M$41 vss vbn \$6 vss sg13_hv_nmos L=4u W=320u AS=62p AD=62p PS=343.5u PD=343.5u
+ rfmode=0
M$81 \$5 inn \$3 vdd sg13_hv_pmos L=2u W=384u AS=73.86p AD=73.86p PS=414.62u
+ PD=414.62u rfmode=0
M$83 \$5 inp \$6 vdd sg13_hv_pmos L=2u W=384u AS=73.86p AD=73.86p PS=414.62u
+ PD=414.62u rfmode=0
M$145 \$14 \$17 \$13 vdd sg13_hv_pmos L=4u W=384u AS=74.16p AD=74.16p
+ PS=410.54u PD=410.54u rfmode=0
M$193 vdd \$13 \$14 vdd sg13_hv_pmos L=4u W=384u AS=74.16p AD=74.16p PS=410.54u
+ PD=410.54u rfmode=0
M$241 \$20 \$17 \$21 vdd sg13_hv_pmos L=4u W=384u AS=74.16p AD=74.16p
+ PS=410.54u PD=410.54u rfmode=0
M$289 vdd \$13 \$20 vdd sg13_hv_pmos L=4u W=384u AS=74.16p AD=74.16p PS=410.54u
+ PD=410.54u rfmode=0
C$401 \$45 out cap_cmim w=69u l=23u A=1587p P=184u m=1
R$402 \$21 \$45 vss rppd w=1u l=6.2u ps=0u b=0 m=1
M$403 vss vbn out vss sg13_hv_nmos L=1u W=96u AS=19.44p AD=19.44p PS=108.86u
+ PD=108.86u rfmode=0
M$415 vdd \$21 out vdd sg13_hv_pmos L=1u W=192u AS=37.68p AD=37.68p PS=209.42u
+ PD=209.42u rfmode=0
M$439 \$3 \$31 \$13 vss sg13_hv_nmos L=1u W=48u AS=10.32p AD=10.32p PS=58.58u
+ PD=58.58u rfmode=0
M$445 \$6 \$31 \$21 vss sg13_hv_nmos L=1u W=48u AS=10.32p AD=10.32p PS=58.58u
+ PD=58.58u rfmode=0
M$451 vdd \$30 \$5 vdd sg13_hv_pmos L=1u W=128u AS=25.52p AD=25.52p PS=142.38u
+ PD=142.38u rfmode=0
M$467 vdd \$17 \$17 vdd sg13_hv_pmos L=1u W=3.2u AS=1.088p AD=1.088p PS=7.08u
+ PD=7.08u rfmode=0
M$468 vss \$31 \$31 vss sg13_hv_nmos L=1u W=1.6u AS=0.544p AD=0.544p PS=3.88u
+ PD=3.88u rfmode=0
M$469 vdd \$30 \$30 vdd sg13_hv_pmos L=1u W=16u AS=3.64p AD=3.64p PS=21.82u
+ PD=21.82u rfmode=0
M$473 vdd \$30 \$31 vdd sg13_hv_pmos L=1u W=16u AS=3.64p AD=3.64p PS=21.82u
+ PD=21.82u rfmode=0
M$477 vss vbn \$30 vss sg13_hv_nmos L=1u W=8u AS=2.12p AD=2.12p PS=13.06u
+ PD=13.06u rfmode=0
M$479 vss vbn \$17 vss sg13_hv_nmos L=1u W=8u AS=2.12p AD=2.12p PS=13.06u
+ PD=13.06u rfmode=0
.ENDS g1_ota_main_physical
