* Extracted by KLayout with SG13G2 LVS runset on : 22/09/2026 20:51

.SUBCKT g1_main_core8 fn fp inn inp mir out1 pc1 pc2 tail vbn vbpc vdd vss
M$1 vdd mir pc1 vdd sg13_hv_pmos L=4u W=384u AS=74.16p AD=74.16p PS=410.54u
+ PD=410.54u rfmode=0
M$49 pc2 vbpc out1 vdd sg13_hv_pmos L=4u W=384u AS=74.16p AD=74.16p PS=410.54u
+ PD=410.54u rfmode=0
M$97 pc1 vbpc mir vdd sg13_hv_pmos L=4u W=384u AS=74.16p AD=74.16p PS=410.54u
+ PD=410.54u rfmode=0
M$145 vdd mir pc2 vdd sg13_hv_pmos L=4u W=384u AS=74.16p AD=74.16p PS=410.54u
+ PD=410.54u rfmode=0
M$193 vss vbn fn vss sg13_hv_nmos L=4u W=320u AS=62p AD=62p PS=343.5u PD=343.5u
+ rfmode=0
M$233 vss vbn fp vss sg13_hv_nmos L=4u W=320u AS=62p AD=62p PS=343.5u PD=343.5u
+ rfmode=0
M$273 tail inn fn vdd sg13_hv_pmos L=2u W=384u AS=73.86p AD=73.86p PS=414.62u
+ PD=414.62u rfmode=0
M$275 tail inp fp vdd sg13_hv_pmos L=2u W=384u AS=73.86p AD=73.86p PS=414.62u
+ PD=414.62u rfmode=0
.ENDS g1_main_core8
