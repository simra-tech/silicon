.subckt g1_main_core8 fn fp inn inp mir out1 pc1 pc2 tail vbn vbpc vdd vss
MM1 fn inn tail vdd sg13_hv_pmos w=384u l=2u m=1
MM2 fp inp tail vdd sg13_hv_pmos w=384u l=2u m=1
MM3 fn vbn vss vss sg13_hv_nmos w=320u l=4u m=1
MM4 fp vbn vss vss sg13_hv_nmos w=320u l=4u m=1
MM14 pc1 mir vdd vdd sg13_hv_pmos w=384u l=4u m=1
MM11 pc2 mir vdd vdd sg13_hv_pmos w=384u l=4u m=1
MM15 mir vbpc pc1 vdd sg13_hv_pmos w=384u l=4u m=1
MM12 out1 vbpc pc2 vdd sg13_hv_pmos w=384u l=4u m=1
.ends g1_main_core8
