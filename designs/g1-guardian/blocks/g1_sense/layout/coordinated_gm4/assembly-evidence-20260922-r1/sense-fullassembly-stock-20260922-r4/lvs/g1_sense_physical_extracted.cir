* Extracted by KLayout with SG13G2 LVS runset on : 22/09/2026 21:35

.SUBCKT g1_sense_physical iptat isense sense_n sense_p vdd vped vref vref_buf
+ vss
X$1 vss \$53 vdd \$54 iptat isense g1_ota_main_candidate
X$2 iptat vped vss vdd vped \$55 g1_ota
X$4 iptat vref_buf vss vdd vref_buf vref g1_ota
R$1 \$2 \$55 vss rppd w=2u l=76.7u ps=0u b=0 m=1
R$2 \$2 \$27 vss rppd w=2u l=76.7u ps=0u b=0 m=1
R$3 \$3 \$27 vss rppd w=2u l=76.7u ps=0u b=0 m=1
R$4 \$3 \$28 vss rppd w=2u l=76.7u ps=0u b=0 m=1
R$5 \$4 \$28 vss rppd w=2u l=76.7u ps=0u b=0 m=1
R$6 \$4 \$29 vss rppd w=2u l=76.7u ps=0u b=0 m=1
R$7 \$5 \$29 vss rppd w=2u l=76.7u ps=0u b=0 m=1
R$8 \$5 \$30 vss rppd w=2u l=76.7u ps=0u b=0 m=1
R$9 \$6 \$30 vss rppd w=2u l=76.7u ps=0u b=0 m=1
R$10 \$6 \$31 vss rppd w=2u l=76.7u ps=0u b=0 m=1
R$11 \$7 \$31 vss rppd w=2u l=76.7u ps=0u b=0 m=1
R$12 \$7 \$32 vss rppd w=2u l=76.7u ps=0u b=0 m=1
R$13 \$8 \$32 vss rppd w=2u l=76.7u ps=0u b=0 m=1
R$14 \$9 \$53 vss rppd w=2u l=76.7u ps=0u b=0 m=1
R$15 \$9 \$33 vss rppd w=2u l=76.7u ps=0u b=0 m=1
R$16 \$10 \$33 vss rppd w=2u l=76.7u ps=0u b=0 m=1
R$17 \$10 \$34 vss rppd w=2u l=76.7u ps=0u b=0 m=1
R$18 \$11 \$34 vss rppd w=2u l=76.7u ps=0u b=0 m=1
R$19 \$11 \$35 vss rppd w=2u l=76.7u ps=0u b=0 m=1
R$20 \$12 \$35 vss rppd w=2u l=76.7u ps=0u b=0 m=1
R$21 \$12 \$36 vss rppd w=2u l=76.7u ps=0u b=0 m=1
R$22 \$13 \$36 vss rppd w=2u l=76.7u ps=0u b=0 m=1
R$23 \$13 \$37 vss rppd w=2u l=76.7u ps=0u b=0 m=1
R$24 sense_n \$53 vss rppd w=2u l=76.7u ps=0u b=0 m=1
R$25 sense_p \$54 vss rppd w=2u l=76.7u ps=0u b=0 m=1
R$26 \$16 \$54 vss rppd w=2u l=76.7u ps=0u b=0 m=1
R$27 \$16 \$38 vss rppd w=2u l=76.7u ps=0u b=0 m=1
R$28 \$17 \$38 vss rppd w=2u l=76.7u ps=0u b=0 m=1
R$29 \$17 \$39 vss rppd w=2u l=76.7u ps=0u b=0 m=1
R$30 \$18 \$39 vss rppd w=2u l=76.7u ps=0u b=0 m=1
R$31 \$18 \$40 vss rppd w=2u l=76.7u ps=0u b=0 m=1
R$32 \$19 \$40 vss rppd w=2u l=76.7u ps=0u b=0 m=1
R$33 \$19 \$41 vss rppd w=2u l=76.7u ps=0u b=0 m=1
R$34 \$20 \$41 vss rppd w=2u l=76.7u ps=0u b=0 m=1
R$35 \$20 \$42 vss rppd w=2u l=76.7u ps=0u b=0 m=1
R$36 \$21 \$56 vss rppd w=2u l=76.7u ps=0u b=0 m=1
R$37 \$21 \$43 vss rppd w=2u l=76.7u ps=0u b=0 m=1
R$38 \$22 \$43 vss rppd w=2u l=76.7u ps=0u b=0 m=1
R$39 \$22 \$44 vss rppd w=2u l=76.7u ps=0u b=0 m=1
R$40 \$23 \$44 vss rppd w=2u l=76.7u ps=0u b=0 m=1
R$41 \$23 \$45 vss rppd w=2u l=76.7u ps=0u b=0 m=1
R$42 \$24 \$45 vss rppd w=2u l=76.7u ps=0u b=0 m=1
R$43 \$24 \$46 vss rppd w=2u l=76.7u ps=0u b=0 m=1
R$44 \$25 \$46 vss rppd w=2u l=76.7u ps=0u b=0 m=1
R$45 \$25 \$47 vss rppd w=2u l=76.7u ps=0u b=0 m=1
R$46 \$26 \$47 vss rppd w=2u l=76.7u ps=0u b=0 m=1
R$47 \$26 \$48 vss rppd w=2u l=76.7u ps=0u b=0 m=1
R$48 \$8 \$48 vss rppd w=2u l=76.7u ps=0u b=0 m=1
R$49 \$57 \$82 vss rppd w=2u l=76.7u ps=0u b=0 m=1
R$50 \$57 \$83 vss rppd w=2u l=76.7u ps=0u b=0 m=1
R$51 \$58 \$83 vss rppd w=2u l=76.7u ps=0u b=0 m=1
R$52 \$58 \$84 vss rppd w=2u l=76.7u ps=0u b=0 m=1
R$53 \$59 \$84 vss rppd w=2u l=76.7u ps=0u b=0 m=1
R$54 \$59 \$85 vss rppd w=2u l=76.7u ps=0u b=0 m=1
R$55 \$60 \$85 vss rppd w=2u l=76.7u ps=0u b=0 m=1
R$56 \$60 \$86 vss rppd w=2u l=76.7u ps=0u b=0 m=1
R$57 \$61 \$86 vss rppd w=2u l=76.7u ps=0u b=0 m=1
R$58 \$61 \$87 vss rppd w=2u l=76.7u ps=0u b=0 m=1
R$59 \$62 \$87 vss rppd w=2u l=76.7u ps=0u b=0 m=1
R$60 \$62 \$88 vss rppd w=2u l=76.7u ps=0u b=0 m=1
R$61 \$56 \$88 vss rppd w=2u l=76.7u ps=0u b=0 m=1
R$62 \$63 \$42 vss rppd w=2u l=76.7u ps=0u b=0 m=1
R$63 \$63 \$89 vss rppd w=2u l=76.7u ps=0u b=0 m=1
R$64 \$64 \$89 vss rppd w=2u l=76.7u ps=0u b=0 m=1
R$65 \$64 \$90 vss rppd w=2u l=76.7u ps=0u b=0 m=1
R$66 \$65 \$90 vss rppd w=2u l=76.7u ps=0u b=0 m=1
R$67 \$65 \$91 vss rppd w=2u l=76.7u ps=0u b=0 m=1
R$68 \$66 \$91 vss rppd w=2u l=76.7u ps=0u b=0 m=1
R$69 \$66 \$92 vss rppd w=2u l=76.7u ps=0u b=0 m=1
R$70 \$67 \$92 vss rppd w=2u l=76.7u ps=0u b=0 m=1
R$71 \$67 vped vss rppd w=2u l=76.7u ps=0u b=0 m=1
R$72 \$68 vref_buf vss rppd w=2u l=76.7u ps=0u b=0 m=1
R$73 \$68 \$55 vss rppd w=2u l=76.7u ps=0u b=0 m=1
R$74 \$69 \$37 vss rppd w=2u l=76.7u ps=0u b=0 m=1
R$75 \$69 \$93 vss rppd w=2u l=76.7u ps=0u b=0 m=1
R$76 \$70 \$93 vss rppd w=2u l=76.7u ps=0u b=0 m=1
R$77 \$70 \$94 vss rppd w=2u l=76.7u ps=0u b=0 m=1
R$78 \$71 \$94 vss rppd w=2u l=76.7u ps=0u b=0 m=1
R$79 \$71 \$95 vss rppd w=2u l=76.7u ps=0u b=0 m=1
R$80 \$72 \$95 vss rppd w=2u l=76.7u ps=0u b=0 m=1
R$81 \$72 \$96 vss rppd w=2u l=76.7u ps=0u b=0 m=1
R$82 \$73 \$96 vss rppd w=2u l=76.7u ps=0u b=0 m=1
R$83 \$73 isense vss rppd w=2u l=76.7u ps=0u b=0 m=1
R$84 \$74 \$82 vss rppd w=2u l=76.7u ps=0u b=0 m=1
R$85 \$74 \$97 vss rppd w=2u l=76.7u ps=0u b=0 m=1
R$86 \$75 \$97 vss rppd w=2u l=76.7u ps=0u b=0 m=1
R$87 \$75 \$98 vss rppd w=2u l=76.7u ps=0u b=0 m=1
R$88 \$76 \$98 vss rppd w=2u l=76.7u ps=0u b=0 m=1
R$89 \$76 \$99 vss rppd w=2u l=76.7u ps=0u b=0 m=1
R$90 \$77 \$99 vss rppd w=2u l=76.7u ps=0u b=0 m=1
R$91 \$77 \$100 vss rppd w=2u l=76.7u ps=0u b=0 m=1
R$92 \$78 \$100 vss rppd w=2u l=76.7u ps=0u b=0 m=1
R$93 \$78 \$101 vss rppd w=2u l=76.7u ps=0u b=0 m=1
R$94 \$79 \$101 vss rppd w=2u l=76.7u ps=0u b=0 m=1
R$95 \$79 vss vss rppd w=2u l=76.7u ps=0u b=0 m=1
M$96 vss iptat iptat vss sg13_hv_nmos L=1u W=3.3u AS=1.122p AD=1.122p PS=7.28u
+ PD=7.28u rfmode=0
.ENDS g1_sense_physical

.SUBCKT g1_ota vbn out vss vdd inn inp
M$1 vss \$4 \$4 vss sg13_hv_nmos L=1u W=1.6u AS=0.544p AD=0.544p PS=3.88u
+ PD=3.88u rfmode=0
M$2 vss vbn \$2 vss sg13_hv_nmos L=1u W=8u AS=2.12p AD=2.12p PS=13.06u
+ PD=13.06u rfmode=0
M$4 vss vbn \$1 vss sg13_hv_nmos L=1u W=8u AS=2.12p AD=2.12p PS=13.06u
+ PD=13.06u rfmode=0
M$6 vss vbn \$3 vss sg13_hv_nmos L=1u W=80u AS=16.4p AD=16.4p PS=92.1u PD=92.1u
+ rfmode=0
M$16 \$3 \$4 \$9 vss sg13_hv_nmos L=1u W=48u AS=10.32p AD=10.32p PS=58.58u
+ PD=58.58u rfmode=0
M$22 \$6 \$4 \$10 vss sg13_hv_nmos L=1u W=48u AS=10.32p AD=10.32p PS=58.58u
+ PD=58.58u rfmode=0
M$28 vss vbn \$6 vss sg13_hv_nmos L=1u W=80u AS=16.4p AD=16.4p PS=92.1u
+ PD=92.1u rfmode=0
M$38 vss vbn out vss sg13_hv_nmos L=1u W=96u AS=19.44p AD=19.44p PS=108.86u
+ PD=108.86u rfmode=0
M$50 vdd \$9 \$30 vdd sg13_hv_pmos L=1u W=96u AS=19.44p AD=19.44p PS=108.86u
+ PD=108.86u rfmode=0
M$62 \$30 \$1 \$9 vdd sg13_hv_pmos L=1u W=96u AS=19.44p AD=19.44p PS=108.86u
+ PD=108.86u rfmode=0
M$74 \$31 \$1 \$10 vdd sg13_hv_pmos L=1u W=96u AS=19.44p AD=19.44p PS=108.86u
+ PD=108.86u rfmode=0
M$86 vdd \$9 \$31 vdd sg13_hv_pmos L=1u W=96u AS=19.44p AD=19.44p PS=108.86u
+ PD=108.86u rfmode=0
M$98 \$41 inn \$3 vdd sg13_hv_pmos L=2u W=96u AS=19.14p AD=19.14p PS=108.38u
+ PD=108.38u rfmode=0
M$100 \$41 inp \$6 vdd sg13_hv_pmos L=2u W=96u AS=19.14p AD=19.14p PS=108.38u
+ PD=108.38u rfmode=0
M$114 vdd \$1 \$1 vdd sg13_hv_pmos L=1u W=3.2u AS=1.088p AD=1.088p PS=7.08u
+ PD=7.08u rfmode=0
M$115 vdd \$2 \$4 vdd sg13_hv_pmos L=1u W=16u AS=3.64p AD=3.64p PS=21.82u
+ PD=21.82u rfmode=0
M$119 vdd \$2 \$2 vdd sg13_hv_pmos L=1u W=16u AS=3.64p AD=3.64p PS=21.82u
+ PD=21.82u rfmode=0
M$123 vdd \$2 \$41 vdd sg13_hv_pmos L=1u W=128u AS=25.52p AD=25.52p PS=142.38u
+ PD=142.38u rfmode=0
M$155 vdd \$10 out vdd sg13_hv_pmos L=1u W=192u AS=37.68p AD=37.68p PS=209.42u
+ PD=209.42u rfmode=0
R$179 \$10 \$29 vss rppd w=1u l=6.2u ps=0u b=0 m=1
C$180 \$29 out cap_cmim w=23u l=23u A=529p P=92u m=1
.ENDS g1_ota

.SUBCKT g1_ota_main_candidate vss inn vdd inp vbn out
M$1 vss vbn \$3 vss sg13_hv_nmos L=4u W=320u AS=62p AD=62p PS=343.5u PD=343.5u
+ rfmode=0
M$41 vss vbn \$6 vss sg13_hv_nmos L=4u W=320u AS=62p AD=62p PS=343.5u PD=343.5u
+ rfmode=0
M$81 vss vbn \$30 vss sg13_hv_nmos L=1u W=8u AS=2.12p AD=2.12p PS=13.06u
+ PD=13.06u rfmode=0
M$83 \$3 \$31 \$13 vss sg13_hv_nmos L=1u W=48u AS=10.32p AD=10.32p PS=58.58u
+ PD=58.58u rfmode=0
M$89 vss \$31 \$31 vss sg13_hv_nmos L=1u W=1.6u AS=0.544p AD=0.544p PS=3.88u
+ PD=3.88u rfmode=0
M$90 vss vbn \$17 vss sg13_hv_nmos L=1u W=8u AS=2.12p AD=2.12p PS=13.06u
+ PD=13.06u rfmode=0
M$92 \$6 \$31 \$21 vss sg13_hv_nmos L=1u W=48u AS=10.32p AD=10.32p PS=58.58u
+ PD=58.58u rfmode=0
M$98 vss vbn out vss sg13_hv_nmos L=1u W=96u AS=19.44p AD=19.44p PS=108.86u
+ PD=108.86u rfmode=0
M$110 \$5 inn \$3 vdd sg13_hv_pmos L=2u W=384u AS=73.86p AD=73.86p PS=414.62u
+ PD=414.62u rfmode=0
M$112 \$5 inp \$6 vdd sg13_hv_pmos L=2u W=384u AS=73.86p AD=73.86p PS=414.62u
+ PD=414.62u rfmode=0
M$174 \$14 \$17 \$13 vdd sg13_hv_pmos L=4u W=384u AS=74.16p AD=74.16p
+ PS=410.54u PD=410.54u rfmode=0
M$222 vdd \$13 \$14 vdd sg13_hv_pmos L=4u W=384u AS=74.16p AD=74.16p PS=410.54u
+ PD=410.54u rfmode=0
M$270 \$20 \$17 \$21 vdd sg13_hv_pmos L=4u W=384u AS=74.16p AD=74.16p
+ PS=410.54u PD=410.54u rfmode=0
M$318 vdd \$13 \$20 vdd sg13_hv_pmos L=4u W=384u AS=74.16p AD=74.16p PS=410.54u
+ PD=410.54u rfmode=0
M$430 vdd \$30 \$5 vdd sg13_hv_pmos L=1u W=128u AS=25.52p AD=25.52p PS=142.38u
+ PD=142.38u rfmode=0
M$446 vdd \$30 \$30 vdd sg13_hv_pmos L=1u W=16u AS=3.64p AD=3.64p PS=21.82u
+ PD=21.82u rfmode=0
M$450 vdd \$30 \$31 vdd sg13_hv_pmos L=1u W=16u AS=3.64p AD=3.64p PS=21.82u
+ PD=21.82u rfmode=0
M$454 vdd \$17 \$17 vdd sg13_hv_pmos L=1u W=3.2u AS=1.088p AD=1.088p PS=7.08u
+ PD=7.08u rfmode=0
M$455 vdd \$21 out vdd sg13_hv_pmos L=1u W=192u AS=37.68p AD=37.68p PS=209.42u
+ PD=209.42u rfmode=0
R$479 \$21 \$32 vss rppd w=1u l=6.2u ps=0u b=0 m=1
C$480 \$32 out cap_cmim w=69u l=23u A=1587p P=184u m=1
.ENDS g1_ota_main_candidate
