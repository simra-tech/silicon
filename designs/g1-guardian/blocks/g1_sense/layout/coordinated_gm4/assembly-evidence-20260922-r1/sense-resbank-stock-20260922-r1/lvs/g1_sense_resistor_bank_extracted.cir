* Extracted by KLayout with SG13G2 LVS runset on : 22/09/2026 21:11

.SUBCKT g1_sense_resistor_bank isense sense_n sense_p vn vp vped vped_ref
+ vref_buf vss
R$1 \$5 vped_ref vss rppd w=2u l=76.7u ps=0u b=0 m=1
R$2 \$79 vss vss rppd w=2u l=76.7u ps=0u b=0 m=1
R$3 \$16 vp vss rppd w=2u l=76.7u ps=0u b=0 m=1
R$4 \$16 \$50 vss rppd w=2u l=76.7u ps=0u b=0 m=1
R$5 \$17 \$50 vss rppd w=2u l=76.7u ps=0u b=0 m=1
R$6 \$17 \$49 vss rppd w=2u l=76.7u ps=0u b=0 m=1
R$7 \$18 \$49 vss rppd w=2u l=76.7u ps=0u b=0 m=1
R$8 \$18 \$48 vss rppd w=2u l=76.7u ps=0u b=0 m=1
R$9 \$19 \$48 vss rppd w=2u l=76.7u ps=0u b=0 m=1
R$10 \$19 \$47 vss rppd w=2u l=76.7u ps=0u b=0 m=1
R$11 \$20 \$47 vss rppd w=2u l=76.7u ps=0u b=0 m=1
R$12 \$20 \$28 vss rppd w=2u l=76.7u ps=0u b=0 m=1
R$13 \$21 \$56 vss rppd w=2u l=76.7u ps=0u b=0 m=1
R$14 \$22 \$56 vss rppd w=2u l=76.7u ps=0u b=0 m=1
R$15 \$22 \$55 vss rppd w=2u l=76.7u ps=0u b=0 m=1
R$16 \$23 \$55 vss rppd w=2u l=76.7u ps=0u b=0 m=1
R$17 \$23 \$52 vss rppd w=2u l=76.7u ps=0u b=0 m=1
R$18 \$24 \$52 vss rppd w=2u l=76.7u ps=0u b=0 m=1
R$19 \$24 \$51 vss rppd w=2u l=76.7u ps=0u b=0 m=1
R$20 \$25 \$51 vss rppd w=2u l=76.7u ps=0u b=0 m=1
R$21 \$25 \$53 vss rppd w=2u l=76.7u ps=0u b=0 m=1
R$22 \$26 \$53 vss rppd w=2u l=76.7u ps=0u b=0 m=1
R$23 \$26 \$54 vss rppd w=2u l=76.7u ps=0u b=0 m=1
R$24 \$21 \$33 vss rppd w=2u l=76.7u ps=0u b=0 m=1
R$25 \$5 \$41 vss rppd w=2u l=76.7u ps=0u b=0 m=1
R$26 \$6 \$41 vss rppd w=2u l=76.7u ps=0u b=0 m=1
R$27 \$6 \$40 vss rppd w=2u l=76.7u ps=0u b=0 m=1
R$28 \$7 \$40 vss rppd w=2u l=76.7u ps=0u b=0 m=1
R$29 \$7 \$39 vss rppd w=2u l=76.7u ps=0u b=0 m=1
R$30 \$8 \$39 vss rppd w=2u l=76.7u ps=0u b=0 m=1
R$31 \$8 \$38 vss rppd w=2u l=76.7u ps=0u b=0 m=1
R$32 \$9 \$38 vss rppd w=2u l=76.7u ps=0u b=0 m=1
R$33 \$9 \$37 vss rppd w=2u l=76.7u ps=0u b=0 m=1
R$34 \$10 \$37 vss rppd w=2u l=76.7u ps=0u b=0 m=1
R$35 \$10 \$42 vss rppd w=2u l=76.7u ps=0u b=0 m=1
R$36 sense_p vp vss rppd w=2u l=76.7u ps=0u b=0 m=1
R$37 \$11 vn vss rppd w=2u l=76.7u ps=0u b=0 m=1
R$38 \$11 \$46 vss rppd w=2u l=76.7u ps=0u b=0 m=1
R$39 \$12 \$46 vss rppd w=2u l=76.7u ps=0u b=0 m=1
R$40 \$12 \$45 vss rppd w=2u l=76.7u ps=0u b=0 m=1
R$41 \$13 \$45 vss rppd w=2u l=76.7u ps=0u b=0 m=1
R$42 \$13 \$44 vss rppd w=2u l=76.7u ps=0u b=0 m=1
R$43 \$14 \$44 vss rppd w=2u l=76.7u ps=0u b=0 m=1
R$44 \$14 \$43 vss rppd w=2u l=76.7u ps=0u b=0 m=1
R$45 \$15 \$43 vss rppd w=2u l=76.7u ps=0u b=0 m=1
R$46 \$15 \$27 vss rppd w=2u l=76.7u ps=0u b=0 m=1
R$47 sense_n vn vss rppd w=2u l=76.7u ps=0u b=0 m=1
R$48 \$2 \$42 vss rppd w=2u l=76.7u ps=0u b=0 m=1
R$49 \$58 vped_ref vss rppd w=2u l=76.7u ps=0u b=0 m=1
R$50 \$57 \$27 vss rppd w=2u l=76.7u ps=0u b=0 m=1
R$51 \$57 \$102 vss rppd w=2u l=76.7u ps=0u b=0 m=1
R$52 \$72 \$102 vss rppd w=2u l=76.7u ps=0u b=0 m=1
R$53 \$72 \$101 vss rppd w=2u l=76.7u ps=0u b=0 m=1
R$54 \$71 \$101 vss rppd w=2u l=76.7u ps=0u b=0 m=1
R$55 \$71 \$100 vss rppd w=2u l=76.7u ps=0u b=0 m=1
R$56 \$70 \$100 vss rppd w=2u l=76.7u ps=0u b=0 m=1
R$57 \$70 \$99 vss rppd w=2u l=76.7u ps=0u b=0 m=1
R$58 \$75 \$99 vss rppd w=2u l=76.7u ps=0u b=0 m=1
R$59 \$75 isense vss rppd w=2u l=76.7u ps=0u b=0 m=1
R$60 \$2 \$54 vss rppd w=2u l=76.7u ps=0u b=0 m=1
R$61 \$74 \$106 vss rppd w=2u l=76.7u ps=0u b=0 m=1
R$62 \$73 \$106 vss rppd w=2u l=76.7u ps=0u b=0 m=1
R$63 \$73 \$107 vss rppd w=2u l=76.7u ps=0u b=0 m=1
R$64 \$78 \$107 vss rppd w=2u l=76.7u ps=0u b=0 m=1
R$65 \$78 \$105 vss rppd w=2u l=76.7u ps=0u b=0 m=1
R$66 \$77 \$105 vss rppd w=2u l=76.7u ps=0u b=0 m=1
R$67 \$77 \$104 vss rppd w=2u l=76.7u ps=0u b=0 m=1
R$68 \$76 \$104 vss rppd w=2u l=76.7u ps=0u b=0 m=1
R$69 \$76 \$103 vss rppd w=2u l=76.7u ps=0u b=0 m=1
R$70 \$79 \$103 vss rppd w=2u l=76.7u ps=0u b=0 m=1
R$71 \$74 \$85 vss rppd w=2u l=76.7u ps=0u b=0 m=1
R$72 \$59 \$85 vss rppd w=2u l=76.7u ps=0u b=0 m=1
R$73 \$59 \$91 vss rppd w=2u l=76.7u ps=0u b=0 m=1
R$74 \$60 \$91 vss rppd w=2u l=76.7u ps=0u b=0 m=1
R$75 \$60 \$92 vss rppd w=2u l=76.7u ps=0u b=0 m=1
R$76 \$61 \$92 vss rppd w=2u l=76.7u ps=0u b=0 m=1
R$77 \$61 \$93 vss rppd w=2u l=76.7u ps=0u b=0 m=1
R$78 \$62 \$93 vss rppd w=2u l=76.7u ps=0u b=0 m=1
R$79 \$62 \$94 vss rppd w=2u l=76.7u ps=0u b=0 m=1
R$80 \$63 \$94 vss rppd w=2u l=76.7u ps=0u b=0 m=1
R$81 \$63 \$95 vss rppd w=2u l=76.7u ps=0u b=0 m=1
R$82 \$64 \$95 vss rppd w=2u l=76.7u ps=0u b=0 m=1
R$83 \$58 vref_buf vss rppd w=2u l=76.7u ps=0u b=0 m=1
R$84 \$33 \$96 vss rppd w=2u l=76.7u ps=0u b=0 m=1
R$85 \$65 \$28 vss rppd w=2u l=76.7u ps=0u b=0 m=1
R$86 \$65 \$90 vss rppd w=2u l=76.7u ps=0u b=0 m=1
R$87 \$66 \$90 vss rppd w=2u l=76.7u ps=0u b=0 m=1
R$88 \$66 \$89 vss rppd w=2u l=76.7u ps=0u b=0 m=1
R$89 \$67 \$89 vss rppd w=2u l=76.7u ps=0u b=0 m=1
R$90 \$67 \$98 vss rppd w=2u l=76.7u ps=0u b=0 m=1
R$91 \$68 \$98 vss rppd w=2u l=76.7u ps=0u b=0 m=1
R$92 \$68 \$97 vss rppd w=2u l=76.7u ps=0u b=0 m=1
R$93 \$69 \$97 vss rppd w=2u l=76.7u ps=0u b=0 m=1
R$94 \$69 vped vss rppd w=2u l=76.7u ps=0u b=0 m=1
R$95 \$64 \$96 vss rppd w=2u l=76.7u ps=0u b=0 m=1
.ENDS g1_sense_resistor_bank
