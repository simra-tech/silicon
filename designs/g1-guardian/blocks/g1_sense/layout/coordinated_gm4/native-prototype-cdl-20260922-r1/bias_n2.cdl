* Source-derived prototype reference; ng audit is separate. No explicit taps fitted.
.subckt bias_n2 d g vss
MMB2 d g vss vss sg13_hv_nmos w=8u l=1u m=1
.ends bias_n2
