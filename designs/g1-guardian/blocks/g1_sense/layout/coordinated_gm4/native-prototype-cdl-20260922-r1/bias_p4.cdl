* Source-derived prototype reference; ng audit is separate. No explicit taps fitted.
.subckt bias_p4 d g vdd vss
MMB5 d g vdd vdd sg13_hv_pmos w=16u l=1u m=1
.ends bias_p4
