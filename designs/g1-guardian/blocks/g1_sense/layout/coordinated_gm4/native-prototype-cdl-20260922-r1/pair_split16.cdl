* Source-derived prototype reference; ng audit is separate. No explicit taps fitted.
.subckt pair_split16 inp inn fn fp tail vdd vss
MM1 fn inn tail vdd sg13_hv_pmos w=96u l=2u m=1
MM2 fp inp tail vdd sg13_hv_pmos w=96u l=2u m=1
.ends pair_split16
