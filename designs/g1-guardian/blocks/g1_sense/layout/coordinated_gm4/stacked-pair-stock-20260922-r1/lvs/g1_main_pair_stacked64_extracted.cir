* Extracted by KLayout with SG13G2 LVS runset on : 22/09/2026 20:11

.SUBCKT g1_main_pair_stacked64 fn fp inn inp tail vdd
M$1 tail inn fn vdd sg13_hv_pmos L=2u W=384u AS=73.86p AD=73.86p PS=414.62u
+ PD=414.62u rfmode=0
M$3 tail inp fp vdd sg13_hv_pmos L=2u W=384u AS=73.86p AD=73.86p PS=414.62u
+ PD=414.62u rfmode=0
.ENDS g1_main_pair_stacked64
