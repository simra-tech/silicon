*********************************************************
*** NGSPICE file created by KLayout-PEX 0.3.12
*** -----------------------------------------------------
***     Extraction Engine: KPEX/2.5D
***     Technology: ihp_sg13g2
***     Date: 2026-09-21 17:04:41
*********************************************************

.SUBCKT g1_ls_up in out vdd vdda vss
M$1 \$4 in vss vss sg13_lv_nmos L=0.13U W=1U AS=0.34P AD=0.34P PS=2.68U
+ PD=2.68U rfmode=0
M$2 \$3 \$4 vss vss sg13_hv_nmos L=0.45U W=3.8U AS=1.292P AD=1.292P PS=8.28U
+ PD=8.28U rfmode=0
M$3 \$5 in vss vss sg13_hv_nmos L=0.45U W=3.8U AS=1.292P AD=1.292P PS=8.28U
+ PD=8.28U rfmode=0
M$4 out \$5 vss vss sg13_hv_nmos L=0.45U W=1.9U AS=0.646P AD=0.646P PS=4.48U
+ PD=4.48U rfmode=0
M$5 \$4 in vdd vdd sg13_lv_pmos L=0.13U W=2U AS=0.68P AD=0.68P PS=4.68U
+ PD=4.68U rfmode=0
M$6 out \$5 vdda vdda sg13_hv_pmos L=0.45U W=3.9U AS=1.326P AD=1.326P PS=8.48U
+ PD=8.48U rfmode=0
M$7 \$3 \$5 vdda vdda sg13_hv_pmos L=0.45U W=0.3U AS=0.102P AD=0.102P PS=1.28U
+ PD=1.28U rfmode=0
M$8 \$5 \$3 vdda vdda sg13_hv_pmos L=0.45U W=0.3U AS=0.102P AD=0.102P PS=1.28U
+ PD=1.28U rfmode=0
Cext_1 \$3 \$4 120.585a
Cext_2 \$3 \$5 520.224a
Cext_3 \$3 in 31.7187a
Cext_4 \$3 out 70.479a
Cext_5 \$3 vdda 70.0154a
Cext_6 \$3 vss 338.549a
Cext_7 \$3 VSUBS 394.361a
Cext_8 \$4 \$5 234.274a
Cext_9 \$4 in 388.706a
Cext_10 \$4 out 4.18793a
Cext_11 \$4 vdd 210.387a
Cext_12 \$4 vdda 24.4212a
Cext_13 \$4 vss 431.201a
Cext_14 \$4 VSUBS 1.26833f
Cext_15 \$5 in 101.229a
Cext_16 \$5 out 292.627a
Cext_17 \$5 vdd 0.153624a
Cext_18 \$5 vdda 480.472a
Cext_19 \$5 vss 675.817a
Cext_20 \$5 VSUBS 1.77214f
Cext_21 in vdd 32.872a
Cext_22 in vdda 1.16906a
Cext_23 in vss 343.92a
Cext_24 out vdda 239.298a
Cext_25 out vss 98.5541a
Cext_26 vdd vdda 18.3974a
Cext_27 vdda vss 12.3264a
Cext_28 VSUBS in 1.84407f
Cext_29 VSUBS out 623.79a
Cext_30 VSUBS vdd 332.051a
Cext_31 VSUBS vdda 1.0366f
Cext_32 VSUBS vss 1.33616f
.ENDS g1_ls_up
