* Extracted by KLayout with SG13G2 LVS runset on : 19/09/2026 13:01

.SUBCKT g1_ls_up in out vdd vdda vss
M$1 vdda \$4 out vdda sg13_hv_pmos L=0.45u W=3.9u AS=1.326p AD=1.326p PS=8.48u
+ PD=8.48u rfmode=0
M$2 vdda \$4 \$6 vdda sg13_hv_pmos L=0.45u W=0.3u AS=0.102p AD=0.102p PS=1.28u
+ PD=1.28u rfmode=0
M$3 vdda \$6 \$4 vdda sg13_hv_pmos L=0.45u W=0.3u AS=0.102p AD=0.102p PS=1.28u
+ PD=1.28u rfmode=0
M$4 vss \$4 out vss sg13_hv_nmos L=0.45u W=1.9u AS=0.646p AD=0.646p PS=4.48u
+ PD=4.48u rfmode=0
M$5 vss in \$4 vss sg13_hv_nmos L=0.45u W=3.8u AS=1.292p AD=1.292p PS=8.28u
+ PD=8.28u rfmode=0
M$6 vss \$3 \$6 vss sg13_hv_nmos L=0.45u W=3.8u AS=1.292p AD=1.292p PS=8.28u
+ PD=8.28u rfmode=0
M$7 vdd in \$3 vdd sg13_lv_pmos L=0.13u W=2u AS=0.68p AD=0.68p PS=4.68u
+ PD=4.68u rfmode=0
M$8 vss in \$3 vss sg13_lv_nmos L=0.13u W=1u AS=0.34p AD=0.34p PS=2.68u
+ PD=2.68u rfmode=0
.ENDS g1_ls_up
