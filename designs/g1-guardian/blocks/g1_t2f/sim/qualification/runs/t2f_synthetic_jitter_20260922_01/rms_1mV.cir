* G1_T2F post-layout testbench (g1_t2f_pex.spice, bandgap C-PEX view) post-layout f(T): hbt=hbt_typ mos=mos_tt res=res_typ cap=cap_typ vdd=3.3 V vdd12=1.2 V T=-40 C mode=ptat
.lib /foss/pdks/ihp-sg13g2/libs.tech/ngspice/models/cornerHBT.lib hbt_typ
.lib /foss/pdks/ihp-sg13g2/libs.tech/ngspice/models/cornerMOShv.lib mos_tt
.lib /foss/pdks/ihp-sg13g2/libs.tech/ngspice/models/cornerMOSlv.lib mos_tt
.lib /foss/pdks/ihp-sg13g2/libs.tech/ngspice/models/cornerRES.lib res_typ
.lib /foss/pdks/ihp-sg13g2/libs.tech/ngspice/models/cornerCAP.lib cap_typ
.include bgr.spice
.include t2f.spice
.option gmin=1e-15 abstol=1e-13 reltol=1e-4 vntol=1e-6 method=gear
.temp 25.0
.global sub!
Vsub sub! 0 dc 0
Vdd vdd 0 dc 3.3
Vdd12 vdd12 0 dc 1.2
Vr4 r4 0 dc 0
Ven en 0 pwl(0 0 1u 0 1.01u 3.3)
Vmode mode 0 dc 0
Xbgr vdd 0 r4 vref iptat pbias pcasc vbe dvbe g1_bgr
Vload iptat 0 dc 1.0
Xt2f vdd vdd12 0 pbias pcasc vref_injected en mode fout g1_t2f
* TEMP_OUT pad stand-in: ~50 fF of core wiring plus the IO cell input
Cout fout 0 50f
Vnoise vref_injected vref PWL(
+ 0 0
+ 2e-09 -3.27421590387818e-07
+ 4e-09 -8.3926025420219e-07
+ 6e-09 -2.45743250754663e-07
+ 8e-09 3.10404826521161e-06
+ 1e-08 4.04923215789074e-06
+ 1.2e-08 3.49455945045841e-06
+ 1.4e-08 4.30217266775271e-06
+ 1.6e-08 5.67337713663201e-06
+ 1.8e-08 7.38541126441148e-06
+ 2e-08 1.07557934512681e-05
+ 2.2e-08 1.37865896382769e-05
+ 2.4e-08 2.18378597237315e-06
+ 2.6e-08 7.05200096494527e-06
+ 2.8e-08 1.16923685617934e-05
+ 3e-08 2.13627302657815e-05
+ 3.2e-08 3.13256503442079e-05
+ 3.4e-08 2.11505799399261e-05
+ 3.6e-08 2.317724924817e-05
+ 3.8e-08 2.17490058816107e-05
+ 4e-08 2.16673466808725e-05
+ 4.2e-08 1.60698992520421e-05
+ 4.4e-08 2.96009114988955e-05
+ 4.6e-08 3.09714202922808e-05
+ 4.8e-08 3.22356670190774e-05
+ 5e-08 3.79878592452212e-05
+ 5.2e-08 5.1361849975285e-05
+ 5.4e-08 6.40733789585587e-05
+ 5.6e-08 7.40096034294421e-05
+ 5.8e-08 7.11255822521673e-05
+ 6e-08 9.1742314839033e-05
+ 6.2e-08 9.23543009405898e-05
+ 6.4e-08 9.30424470396749e-05
+ 6.6e-08 9.34233495936539e-05
+ 6.8e-08 0.000112962017561701
+ 7e-08 8.90301783482857e-05
+ 7.2e-08 9.40707778968808e-05
+ 7.4e-08 9.16026205059444e-05
+ 7.6e-08 6.74410676736112e-05
+ 7.8e-08 4.01667662206562e-05
+ 8e-08 3.88909381142594e-05
+ 8.2e-08 9.78463811327652e-06
+ 8.4e-08 2.71454372415988e-05
+ 8.6e-08 3.40717830121263e-05
+ 8.8e-08 3.03468028712108e-05
+ 9e-08 1.35117380293055e-05
+ 9.2e-08 4.24466450118782e-05
+ 9.4e-08 2.85936802310828e-05
+ 9.6e-08 6.51205189556239e-05
+ 9.8e-08 5.45485597212658e-05
+ 1e-07 3.76392730996358e-05
+ 1.02e-07 5.92170642916439e-05
+ 1.04e-07 8.10171081978569e-05
+ 1.06e-07 6.49609234092911e-05
+ 1.08e-07 0.000112843545429914
+ 1.1e-07 0.000139408158715935
+ 1.12e-07 0.000181046916931649
+ 1.14e-07 0.00020980913272527
+ 1.16e-07 0.000198617829453818
+ 1.18e-07 0.000158413429146064
+ 1.2e-07 0.000161589751349101
+ 1.22e-07 0.000196511081940254
+ 1.24e-07 0.000177176654799705
+ 1.26e-07 0.000168079482669994
+ 1.28e-07 0.000156882682329732
+ 1.3e-07 0.000156569350568869
+ 1.32e-07 0.000101333161165703
+ 1.34e-07 0.000103654474864329
+ 1.36e-07 0.000123775617776089
+ 1.38e-07 0.000116512284897053
+ 1.4e-07 0.000131934567596032
+ 1.42e-07 0.000142025240058853
+ 1.44e-07 0.000154422864741628
+ 1.46e-07 0.000197291812200129
+ 1.48e-07 0.000228379707652544
+ 1.5e-07 0.000257972972626983
+ 1.52e-07 0.000275204566224982
+ 1.54e-07 0.000292285132940516
+ 1.56e-07 0.000250450083751821
+ 1.58e-07 0.000245655765582537
+ 1.6e-07 0.000202602500075224
+ 1.62e-07 0.000216459036390141
+ 1.64e-07 0.000198958495078363
+ 1.66e-07 0.000227570423043215
+ 1.68e-07 0.000227304542614175
+ 1.7e-07 0.000238879971478782
+ 1.72e-07 0.000228417805429822
+ 1.74e-07 0.000232588445362124
+ 1.76e-07 0.000244885459252687
+ 1.78e-07 0.000252251915442203
+ 1.8e-07 0.000238094306086319
+ 1.82e-07 0.000167856966750919
+ 1.84e-07 0.000176242172728158
+ 1.86e-07 0.00013527778525133
+ 1.88e-07 5.61883834559295e-05
+ 1.9e-07 7.54758332155175e-05
+ 1.92e-07 5.6044484714096e-05
+ 1.94e-07 -1.5729794524566e-05
+ 1.96e-07 -7.39935844783808e-06
+ 1.98e-07 2.6220319697971e-05
+ 2e-07 2.88109916522497e-05
+ 2.02e-07 6.20597286712731e-05
+ 2.04e-07 -1.09983867028336e-05
+ 2.06e-07 -2.9254696802069e-05
+ 2.08e-07 -2.41785086129651e-05
+ 2.1e-07 -1.27065352789913e-05
+ 2.12e-07 -6.11646045737831e-05
+ 2.14e-07 -7.48854001713406e-05
+ 2.16e-07 -6.82039981664421e-05
+ 2.18e-07 -0.000119404542143553
+ 2.2e-07 -9.82510438134673e-05
+ 2.22e-07 -2.90217918302892e-05
+ 2.24e-07 2.37601554180125e-05
+ 2.26e-07 6.98153564835218e-05
+ 2.28e-07 5.35656059871328e-05
+ 2.3e-07 1.22016421562408e-05
+ 2.32e-07 8.09354351103925e-05
+ 2.34e-07 3.06866826177508e-05
+ 2.36e-07 3.5075422641405e-05
+ 2.38e-07 -4.86020651766021e-05
+ 2.4e-07 -5.35050881323561e-05
+ 2.42e-07 -7.59801726677936e-05
+ 2.44e-07 -6.38962292372805e-05
+ 2.46e-07 2.52279257785082e-05
+ 2.48e-07 -3.17745482061221e-05
+ 2.5e-07 -1.69376384872874e-05
+ 2.52e-07 6.20218671950771e-05
+ 2.54e-07 0.000125835672265585
+ 2.56e-07 0.000132388690064062
+ 2.58e-07 6.29525380154816e-05
+ 2.6e-07 4.06603860317501e-06
+ 2.62e-07 -3.50616557842399e-05
+ 2.64e-07 0.000141087681725915
+ 2.66e-07 0.000142456992388142
+ 2.68e-07 0.000220269589949592
+ 2.7e-07 0.000193980351844769
+ 2.72e-07 0.000219356437822014
+ 2.74e-07 0.000301529911838055
+ 2.76e-07 0.000238599769097034
+ 2.78e-07 0.000282831252554458
+ 2.8e-07 0.000342877749168176
+ 2.82e-07 0.000399492012080869
+ 2.84e-07 0.000377109999904955
+ 2.86e-07 0.000373955810362089
+ 2.88e-07 0.000296147090385609
+ 2.9e-07 0.000298759483461783
+ 2.92e-07 0.000280612280913803
+ 2.94e-07 0.000197835360292992
+ 2.96e-07 0.000218957888202172
+ 2.98e-07 0.000204062814793804
+ 3e-07 0.00025539505366099
+ 3.02e-07 0.000235941160707715
+ 3.04e-07 0.00024750615509063
+ 3.06e-07 0.000123109781615309
+ 3.08e-07 6.43143636041114e-05
+ 3.1e-07 0.000129701592813962
+ 3.12e-07 2.0823016982655e-05
+ 3.14e-07 -0.000134769642354419
+ 3.16e-07 -0.000149992756801161
+ 3.18e-07 -0.000172030450037641
+ 3.2e-07 -4.57987432651406e-05
+ 3.22e-07 -3.33427322607396e-05
+ 3.24e-07 8.62317677493119e-06
+ 3.26e-07 -4.99096659386284e-05
+ 3.28e-07 -0.000138309053946091
+ 3.3e-07 -0.000158346629819808
+ 3.32e-07 -8.87389113540596e-05
+ 3.34e-07 -0.000170211208845429
+ 3.36e-07 -0.000160216144214671
+ 3.38e-07 -0.000209009114800393
+ 3.4e-07 -0.000288584009323287
+ 3.42e-07 -0.000296978634191932
+ 3.44e-07 -0.00034206618310239
+ 3.46e-07 -0.000346151158229233
+ 3.48e-07 -0.000327614992284323
+ 3.5e-07 -0.000292905351123078
+ 3.52e-07 -0.000265222716178284
+ 3.54e-07 -0.000259707187220205
+ 3.56e-07 -0.000318116029634457
+ 3.58e-07 -0.000281342030748889
+ 3.6e-07 -0.000219572691727694
+ 3.62e-07 -0.000136855818822871
+ 3.64e-07 -8.86177615381088e-05
+ 3.66e-07 -9.52619420962666e-05
+ 3.68e-07 -4.67007064758855e-05
+ 3.7e-07 -1.97757548244124e-05
+ 3.72e-07 3.58393282251162e-05
+ 3.74e-07 2.53535509576387e-05
+ 3.76e-07 -2.16214756703418e-05
+ 3.78e-07 -6.28532780242025e-06
+ 3.8e-07 4.58044649438913e-05
+ 3.82e-07 4.75204911607982e-05
+ 3.84e-07 -4.12523766037443e-05
+ 3.86e-07 0.000104473309891725
+ 3.88e-07 0.00011607403646292
+ 3.9e-07 0.000278197947571742
+ 3.92e-07 0.000313309400766672
+ 3.94e-07 0.000328435629201655
+ 3.96e-07 0.000265643081801012
+ 3.98e-07 0.000334998749392521
+ 4e-07 0.000324840823324971
+ 4.02e-07 0.000268425093556361
+ 4.04e-07 0.000195770594414477
+ 4.06e-07 0.000202494978711283
+ 4.08e-07 0.000162391466660127
+ 4.1e-07 0.00019956564690785
+ 4.12e-07 2.36931245468839e-05
+ 4.14e-07 -7.94549983580394e-05
+ 4.16e-07 -5.67631028284294e-05
+ 4.18e-07 -2.08887494761845e-05
+ 4.2e-07 2.99247037739144e-06
+ 4.22e-07 -3.19321489017357e-05
+ 4.24e-07 1.57670407109069e-05
+ 4.26e-07 -5.82922797323958e-06
+ 4.28e-07 5.82296034241844e-05
+ 4.3e-07 6.68256852972415e-05
+ 4.32e-07 0.000128751027175782
+ 4.34e-07 0.000114288676264011
+ 4.36e-07 -0.00012405956765915
+ 4.38e-07 -0.000271890030741069
+ 4.4e-07 -0.000359335878427879
+ 4.42e-07 -0.000319965647273973
+ 4.44e-07 -0.000313133249371087
+ 4.46e-07 -0.000324784953132813
+ 4.48e-07 -0.000303840556767097
+ 4.5e-07 -0.000190569194096843
+ 4.52e-07 -0.000131653650121095
+ 4.54e-07 -4.9704454143511e-05
+ 4.56e-07 -6.79779011330277e-05
+ 4.58e-07 -8.66431498038431e-05
+ 4.6e-07 -6.75589495108463e-05
+ 4.62e-07 6.43429158087497e-05
+ 4.64e-07 3.58798144762322e-05
+ 4.66e-07 2.72124381919513e-05
+ 4.68e-07 -2.17174833776273e-05
+ 4.7e-07 -8.99271722783884e-05
+ 4.72e-07 1.43061918871918e-05
+ 4.74e-07 -7.74385614248685e-05
+ 4.76e-07 -8.37719252905234e-05
+ 4.78e-07 -1.76604611934117e-05
+ 4.8e-07 -0.000108555178088237
+ 4.82e-07 -0.000264540399883064
+ 4.84e-07 -0.000172969510200484
+ 4.86e-07 -0.000221179593109738
+ 4.88e-07 -0.000365284948027056
+ 4.9e-07 -0.000371748600850135
+ 4.92e-07 -0.000372307934125446
+ 4.94e-07 -0.000301501164612479
+ 4.96e-07 -0.000246708764994025
+ 4.98e-07 -0.000170378583212469
+ 5e-07 -6.62462436497021e-05
+ 5.02e-07 -6.10986189218201e-05
+ 5.04e-07 -9.3705398492857e-05
+ 5.06e-07 -0.000110614459817912
+ 5.08e-07 -0.000145262087763568
+ 5.1e-07 2.15034041542098e-05
+ 5.12e-07 4.50204589511415e-05
+ 5.14e-07 5.13759184363858e-05
+ 5.16e-07 7.82587021565193e-05
+ 5.18e-07 0.000204967371017404
+ 5.2e-07 0.000296491734137905
+ 5.22e-07 0.000272473980651716
+ 5.24e-07 0.00022966491574407
+ 5.26e-07 0.0002827558738872
+ 5.28e-07 0.000352178763957645
+ 5.3e-07 0.000463817202828071
+ 5.32e-07 0.000428086118198086
+ 5.34e-07 0.000473407585206781
+ 5.36e-07 0.000490901488818851
+ 5.38e-07 0.00037454865886595
+ 5.4e-07 0.000527450011676302
+ 5.42e-07 0.000379051184805904
+ 5.44e-07 0.000324776631312359
+ 5.46e-07 0.000354625312719685
+ 5.48e-07 0.000387395438921123
+ 5.5e-07 0.000362146811480954
+ 5.52e-07 0.000360049477322707
+ 5.54e-07 0.000230996950902736
+ 5.56e-07 0.000506956991227395
+ 5.58e-07 0.000596681006321254
+ 5.6e-07 0.000458058249709013
+ 5.62e-07 0.000527226776253134
+ 5.64e-07 0.000495366144462726
+ 5.66e-07 0.000260419811730863
+ 5.68e-07 0.00032409913393335
+ 5.7e-07 0.000256449370016451
+ 5.72e-07 0.000292046330511738
+ 5.74e-07 0.000328344374221323
+ 5.76e-07 0.000310414686543291
+ 5.78e-07 0.00026439844254295
+ 5.8e-07 0.000254998493692
+ 5.82e-07 0.000306597903044633
+ 5.84e-07 0.000467253780391759
+ 5.86e-07 0.000586230126089431
+ 5.88e-07 0.000596160170536895
+ 5.9e-07 0.000527827414049862
+ 5.92e-07 0.000528890786866276
+ 5.94e-07 0.000314082870108092
+ 5.96e-07 4.02290440212856e-05
+ 5.98e-07 -3.94913006180667e-06
+ 6e-07 -0.000116101170373255
+ 6.02e-07 8.56260693588647e-06
+ 6.04e-07 -9.04784270903033e-06
+ 6.06e-07 0.000187112550859912
+ 6.08e-07 5.4482879334442e-05
+ 6.1e-07 -0.000266466111599394
+ 6.12e-07 -0.000243283074723423
+ 6.14e-07 -0.000418189738385509
+ 6.16e-07 -0.00049781082039516
+ 6.18e-07 -0.000490747422232911
+ 6.2e-07 -0.000297500571294594
+ 6.22e-07 -0.000315600166468489
+ 6.24e-07 -0.00020755076083994
+ 6.26e-07 -0.000340533394655319
+ 6.28e-07 -0.0003429858947582
+ 6.3e-07 -0.000428656064526274
+ 6.32e-07 -0.000419534416696236
+ 6.34e-07 -0.00040741903193297
+ 6.36e-07 -0.000495156800630076
+ 6.38e-07 -0.000571205548161213
+ 6.4e-07 -0.000634598686814304
+ 6.42e-07 -0.000557671499880733
+ 6.44e-07 -0.000565435534969384
+ 6.46e-07 -0.00043671794589039
+ 6.48e-07 -0.000581003586110104
+ 6.5e-07 -0.000584042359889502
+ 6.52e-07 -0.000799014337459916
+ 6.54e-07 -0.000670635743713929
+ 6.56e-07 -0.000658540827402898
+ 6.58e-07 -0.000592314561445735
+ 6.6e-07 -0.000541574565725235
+ 6.62e-07 -0.000442262329160634
+ 6.64e-07 -0.000495998029087292
+ 6.66e-07 -0.000298348076995313
+ 6.68e-07 -0.000432433998782017
+ 6.7e-07 -0.000112943645764398
+ 6.72e-07 -9.60786115351084e-05
+ 6.74e-07 -1.14029262705858e-05
+ 6.76e-07 0.000165213348840765
+ 6.78e-07 0.000388086280114445
+ 6.8e-07 0.000615238111104157
+ 6.82e-07 0.000489225355467413
+ 6.84e-07 0.000578810876789096
+ 6.86e-07 0.000570810049296938
+ 6.88e-07 0.000596547970441624
+ 6.9e-07 0.000610632749552143
+ 6.92e-07 0.000606105580170758
+ 6.94e-07 0.000788906946259107
+ 6.96e-07 0.000700825983688461
+ 6.98e-07 0.000747983517918861
+ 7e-07 0.00057769383890868
+ 7.02e-07 0.000740175618992603
+ 7.04e-07 0.000788916883545091
+ 7.06e-07 0.000609523399357698
+ 7.08e-07 0.000615971904388934
+ 7.1e-07 0.00076006130017802
+ 7.12e-07 0.000863309909539397
+ 7.14e-07 0.000678470971615979
+ 7.16e-07 0.00061136924575727
+ 7.18e-07 0.000594892976792222
+ 7.2e-07 0.000969730813943744
+ 7.22e-07 0.000772035105969144
+ 7.24e-07 0.000674576864874315
+ 7.26e-07 0.000517552285880931
+ 7.28e-07 0.000448235554065436
+ 7.3e-07 0.000487018329868727
+ 7.32e-07 0.000549884655157802
+ 7.34e-07 0.000479201773179077
+ 7.36e-07 0.000219665381886089
+ 7.38e-07 0.000362873631494419
+ 7.4e-07 0.000337892640397717
+ 7.42e-07 0.000356956813479749
+ 7.44e-07 0.000354177798369337
+ 7.46e-07 0.000143994200464227
+ 7.48e-07 0.000180985385760654
+ 7.5e-07 0.000301260290855966
+ 7.52e-07 0.000171857244617384
+ 7.54e-07 0.000157087931361929
+ 7.56e-07 -0.000100550557481221
+ 7.58e-07 9.99017062886258e-05
+ 7.6e-07 -7.54763785371596e-06
+ 7.62e-07 0.000194975048200636
+ 7.64e-07 0.000107004317036128
+ 7.66e-07 0.000122703467942065
+ 7.68e-07 -9.25153260930306e-05
+ 7.7e-07 0.000228336758771259
+ 7.72e-07 -6.46897802358397e-05
+ 7.74e-07 -5.63718105467457e-05
+ 7.76e-07 9.0032198018778e-05
+ 7.78e-07 -9.42368516948073e-05
+ 7.8e-07 -0.000204670635385809
+ 7.82e-07 -0.000229313959205976
+ 7.84e-07 -4.23035435145356e-05
+ 7.86e-07 -6.6532200048294e-05
+ 7.88e-07 -1.46657952757154e-05
+ 7.9e-07 0.000219697764924253
+ 7.92e-07 0.000125425128180882
+ 7.94e-07 -5.50755553118416e-06
+ 7.96e-07 -5.53982292695449e-05
+ 7.98e-07 -0.000345557732671399
+ 8e-07 -0.000438919089080438
+ 8.02e-07 -0.000131559080678387
+ 8.04e-07 -0.000160331166400555
+ 8.06e-07 -3.81207124982604e-05
+ 8.08e-07 7.72310285865856e-05
+ 8.1e-07 -0.000285212442814975
+ 8.12e-07 -0.000309874126127968
+ 8.14e-07 -0.000309877949628246
+ 8.16e-07 -6.49022454078521e-05
+ 8.18e-07 0.000249065276158709
+ 8.2e-07 0.000365920845870697
+ 8.22e-07 0.000183369237280963
+ 8.24e-07 0.000109479387003161
+ 8.26e-07 5.81106508782716e-05
+ 8.28e-07 -7.85135043594421e-05
+ 8.3e-07 -6.80227406540991e-05
+ 8.32e-07 0.000158406312122436
+ 8.34e-07 0.000360551412022925
+ 8.36e-07 0.000353706881186184
+ 8.38e-07 0.000340491404495531
+ 8.4e-07 0.00074051965032927
+ 8.42e-07 0.000729744081581998
+ 8.44e-07 0.000728054260000807
+ 8.46e-07 0.000718759004212991
+ 8.48e-07 0.000701212159324933
+ 8.5e-07 0.000896342449884165
+ 8.52e-07 0.00117715866773326
+ 8.54e-07 0.00126454931278949
+ 8.56e-07 0.00106947463619665
+ 8.58e-07 0.000756681675750306
+ 8.6e-07 0.000688671661011273
+ 8.62e-07 0.000652796584817964
+ 8.64e-07 0.000540549086558161
+ 8.66e-07 0.000656622964669366
+ 8.68e-07 0.000733741529224441
+ 8.7e-07 0.000721340492154457
+ 8.72e-07 0.000924735967059821
+ 8.74e-07 0.00118947304690759
+ 8.76e-07 0.00116493523782134
+ 8.78e-07 0.00100721729101683
+ 8.8e-07 0.00139215847693881
+ 8.82e-07 0.00132611194655949
+ 8.84e-07 0.00116877760416664
+ 8.86e-07 0.0012408834254389
+ 8.88e-07 0.00110426380186354
+ 8.9e-07 0.00114358267533207
+ 8.92e-07 0.00121521610961793
+ 8.94e-07 0.000813716901889365
+ 8.96e-07 0.000847415740467531
+ 8.98e-07 0.000705739364671696
+ 9e-07 0.000518398702955892
+ 9.02e-07 0.000543615801502795
+ 9.04e-07 0.000584202071384225
+ 9.06e-07 0.000714899652877781
+ 9.08e-07 0.000721656712067304
+ 9.1e-07 0.000740690261773271
+ 9.12e-07 0.000979137618815684
+ 9.14e-07 0.000540008281314712
+ 9.16e-07 0.000516470189043712
+ 9.18e-07 0.000506699595493024
+ 9.2e-07 0.000292868614091557
+ 9.22e-07 7.30281426714764e-05
+ 9.24e-07 -1.18841108651953e-05
+ 9.26e-07 0.000171473279407002
+ 9.28e-07 0.00038407615956516
+ 9.3e-07 0.000416380346477918
+ 9.32e-07 0.000392348297930016
+ 9.34e-07 0.000438519799048834
+ 9.36e-07 0.000478474057437652
+ 9.38e-07 0.000383773951740747
+ 9.4e-07 0.000794509692855573
+ 9.42e-07 0.000628062021699112
+ 9.44e-07 0.000759766891693986
+ 9.46e-07 0.000824411287871276
+ 9.48e-07 0.000914183957481048
+ 9.5e-07 0.000657084435240634
+ 9.52e-07 0.000592717187595038
+ 9.54e-07 0.000757060664525519
+ 9.56e-07 0.000558162744348457
+ 9.58e-07 0.00041987967233487
+ 9.6e-07 0.000542753630849292
+ 9.62e-07 0.000322591156285265
+ 9.64e-07 0.000226703673735425
+ 9.66e-07 0.000330776985670341
+ 9.68e-07 0.000389375145334822
+ 9.7e-07 0.000278556779367229
+ 9.72e-07 0.000406056017370019
+ 9.74e-07 0.000218714915125401
+ 9.76e-07 0.000512675711697655
+ 9.78e-07 0.000236944009788706
+ 9.8e-07 0.000408140658865224
+ 9.82e-07 0.00020347017673952
+ 9.84e-07 0.000328581673493792
+ 9.86e-07 7.13909676211094e-05
+ 9.88e-07 0.000362011925290714
+ 9.9e-07 0.000440110778776321
+ 9.92e-07 0.000455882640153873
+ 9.94e-07 0.000270290157051226
+ 9.96e-07 -6.17188743460028e-05
+ 9.98e-07 -5.39042570732596e-05
+ 1e-06 0.00012318904134779
+ 1.002e-06 3.74202585693942e-07
+ 1.004e-06 -0.000205931677742841
+ 1.006e-06 -0.000113229806656012
+ 1.008e-06 -0.00021060238718521
+ 1.01e-06 -0.000184408152165205
+ 1.012e-06 0.000170481838624146
+ 1.014e-06 -0.000105700766713556
+ 1.016e-06 -0.000301446981508155
+ 1.018e-06 -7.37424823503876e-05
+ 1.02e-06 9.66541940639394e-05
+ 1.022e-06 -0.000330899305307826
+ 1.024e-06 -0.000428112140955754
+ 1.026e-06 2.81588973690411e-06
+ 1.028e-06 -0.000156630652158522
+ 1.03e-06 7.88085704480293e-05
+ 1.032e-06 0.000419403101344119
+ 1.034e-06 -3.51352204378189e-05
+ 1.036e-06 0.000177994733394978
+ 1.038e-06 0.000182138627003719
+ 1.04e-06 -7.12004530272697e-05
+ 1.042e-06 -0.000222308937395847
+ 1.044e-06 -0.000294334078390505
+ 1.046e-06 3.41933940052222e-05
+ 1.048e-06 -0.000214682368745082
+ 1.05e-06 -0.000438944378475158
+ 1.052e-06 3.62188630694144e-06
+ 1.054e-06 0.000138939177441477
+ 1.056e-06 -0.000221072048793905
+ 1.058e-06 -0.000304209100183076
+ 1.06e-06 -0.000679864267330054
+ 1.062e-06 -0.00057278849323597
+ 1.064e-06 -0.000455354396998585
+ 1.066e-06 -0.000382199959392262
+ 1.068e-06 -0.000469760595183032
+ 1.07e-06 -0.000438273595726915
+ 1.072e-06 -0.000368619461817998
+ 1.074e-06 -0.000116129299381956
+ 1.076e-06 -1.1259521339049e-05
+ 1.078e-06 -0.000105759318581374
+ 1.08e-06 -2.18179956621831e-05
+ 1.082e-06 -0.000392708112603719
+ 1.084e-06 7.38690271591684e-05
+ 1.086e-06 0.000269859554064422
+ 1.088e-06 0.000123814298081833
+ 1.09e-06 -6.57795676396279e-05
+ 1.092e-06 -0.000201502035763135
+ 1.094e-06 -9.62057466231272e-05
+ 1.096e-06 -0.000324630859082435
+ 1.098e-06 -0.000348045938507481
+ 1.1e-06 -0.000431958354873579
+ 1.102e-06 -0.00035463251191572
+ 1.104e-06 -0.000461709819838456
+ 1.106e-06 -0.000453379453622401
+ 1.108e-06 -0.000570696463426433
+ 1.11e-06 -0.000391555003654784
+ 1.112e-06 -0.000393392661081989
+ 1.114e-06 -2.88008466511862e-05
+ 1.116e-06 -0.000127696317252039
+ 1.118e-06 -0.000125052167864492
+ 1.12e-06 2.98688487036648e-05
+ 1.122e-06 0.000222958022728427
+ 1.124e-06 5.00372128214253e-05
+ 1.126e-06 0.000185839918724766
+ 1.128e-06 0.000119123861174711
+ 1.13e-06 0.00024276697869654
+ 1.132e-06 5.10429514851023e-05
+ 1.134e-06 0.000152373986856151
+ 1.136e-06 -0.000267752531947032
+ 1.138e-06 -0.000242901245392592
+ 1.14e-06 8.10998345328689e-05
+ 1.142e-06 7.11042910963016e-05
+ 1.144e-06 -0.000119342379018835
+ 1.146e-06 -0.000180218804109872
+ 1.148e-06 -0.000337375521173858
+ 1.15e-06 -0.000160637278848573
+ 1.152e-06 -0.000363614236708238
+ 1.154e-06 -0.000189226517400335
+ 1.156e-06 -0.000229604079075637
+ 1.158e-06 -1.17234944369966e-05
+ 1.16e-06 -0.00022611514616631
+ 1.162e-06 -9.65355748007652e-05
+ 1.164e-06 -0.000237003418105268
+ 1.166e-06 -4.01750694570692e-05
+ 1.168e-06 5.51439667498675e-05
+ 1.17e-06 -0.000175490571695357
+ 1.172e-06 9.66755627782165e-06
+ 1.174e-06 1.70929318348115e-05
+ 1.176e-06 -0.000191748179507437
+ 1.178e-06 -0.000220780507864475
+ 1.18e-06 -0.000146354357763726
+ 1.182e-06 -1.58809521155626e-05
+ 1.184e-06 0.000225849579100395
+ 1.186e-06 0.000415982754698388
+ 1.188e-06 0.000325766961224055
+ 1.19e-06 0.000387173227847625
+ 1.192e-06 0.000495133805540105
+ 1.194e-06 0.000373439882842545
+ 1.196e-06 0.000543812577339647
+ 1.198e-06 0.000688754603663113
+ 1.2e-06 0.000535555403379068
+ 1.202e-06 0.000923756483602098
+ 1.204e-06 0.000659290135146485
+ 1.206e-06 0.000640242471857086
+ 1.208e-06 0.000770885437947769
+ 1.21e-06 0.000485077605787408
+ 1.212e-06 0.000734396697017418
+ 1.214e-06 0.00105187899774543
+ 1.216e-06 0.000956671970609666
+ 1.218e-06 0.00113388017712364
+ 1.22e-06 0.00117123467483345
+ 1.222e-06 0.00123946042840845
+ 1.224e-06 0.00147308175006992
+ 1.226e-06 0.0011902371441313
+ 1.228e-06 0.00111414499594725
+ 1.23e-06 0.00101317365381166
+ 1.232e-06 0.00098567489778414
+ 1.234e-06 0.00098589229218717
+ 1.236e-06 0.00110681835491954
+ 1.238e-06 0.000988460173870755
+ 1.24e-06 0.00105562685239981
+ 1.242e-06 0.000899414355636531
+ 1.244e-06 0.000966484482279424
+ 1.246e-06 0.000588540604060323
+ 1.248e-06 0.000513156957274822
+ 1.25e-06 0.00050218857716269
+ 1.252e-06 0.000407587942121843
+ 1.254e-06 4.36926761713558e-05
+ 1.256e-06 0.000348812474427362
+ 1.258e-06 0.000415560647055416
+ 1.26e-06 0.000604327085498994
+ 1.262e-06 0.000968354951196079
+ 1.264e-06 0.000783227413783727
+ 1.266e-06 0.000761445695702799
+ 1.268e-06 0.000783788344004296
+ 1.27e-06 0.00090540822799014
+ 1.272e-06 0.000901891484666731
+ 1.274e-06 0.00127853008650555
+ 1.276e-06 0.00117754351666536
+ 1.278e-06 0.00143443210926372
+ 1.28e-06 0.00146223721592668
+ 1.282e-06 0.00148958433022074
+ 1.284e-06 0.00135631008956421
+ 1.286e-06 0.00108452955906453
+ 1.288e-06 0.000828463982287191
+ 1.29e-06 0.000946821155132814
+ 1.292e-06 0.000988994411400408
+ 1.294e-06 0.000706203019539417
+ 1.296e-06 0.000304083493396281
+ 1.298e-06 0.000452437260344371
+ 1.3e-06 0.000408199148908233
+ 1.302e-06 0.000197616620574754
+ 1.304e-06 2.02848165072822e-07
+ 1.306e-06 7.69891805717946e-06
+ 1.308e-06 0.000148911415582131
+ 1.31e-06 -6.54494761272055e-05
+ 1.312e-06 6.28878293874116e-05
+ 1.314e-06 7.38699791460854e-05
+ 1.316e-06 0.000160497029308382
+ 1.318e-06 -0.000291563440857112
+ 1.32e-06 -0.000106163402250346
+ 1.322e-06 0.000106070609429653
+ 1.324e-06 -0.000239118823749675
+ 1.326e-06 -0.000176669799947703
+ 1.328e-06 6.07159835564793e-05
+ 1.33e-06 0.000177856141164218
+ 1.332e-06 0.000287175592845299
+ 1.334e-06 4.09244488232462e-05
+ 1.336e-06 0.000141692460727542
+ 1.338e-06 7.23950469240639e-06
+ 1.34e-06 0.00040928086647994
+ 1.342e-06 7.58013904490273e-05
+ 1.344e-06 0.000128082939422472
+ 1.346e-06 0.000230538875084785
+ 1.348e-06 0.000329401188270723
+ 1.35e-06 0.000384788149542604
+ 1.352e-06 0.000669259216503596
+ 1.354e-06 0.000719919916169032
+ 1.356e-06 0.000782758803298392
+ 1.358e-06 0.000818774840727728
+ 1.36e-06 0.000802875727453637
+ 1.362e-06 0.000715356942977375
+ 1.364e-06 0.000842465856217417
+ 1.366e-06 0.00107178994039493
+ 1.368e-06 0.0010558380061184
+ 1.37e-06 0.000979175462947948
+ 1.372e-06 0.00092527974149174
+ 1.374e-06 0.00102453752975846
+ 1.376e-06 0.00126658186825461
+ 1.378e-06 0.00126885740885185
+ 1.38e-06 0.00122354349950247
+ 1.382e-06 0.00115665098128565
+ 1.384e-06 0.000702612445182492
+ 1.386e-06 0.000513426724255549
+ 1.388e-06 0.000689847354481457
+ 1.39e-06 0.000549946062138999
+ 1.392e-06 0.000407062463464976
+ 1.394e-06 0.000355827774976895
+ 1.396e-06 0.000280414380521611
+ 1.398e-06 -1.78412512167056e-05
+ 1.4e-06 0.000103374877745509
+ 1.402e-06 0.000144966839291029
+ 1.404e-06 0.000350165009982546
+ 1.406e-06 0.000462284546562419
+ 1.408e-06 0.000308936830574443
+ 1.41e-06 0.000357800625436558
+ 1.412e-06 0.000307047676193121
+ 1.414e-06 0.00044199158354048
+ 1.416e-06 0.000771463436557065
+ 1.418e-06 0.00072773353723244
+ 1.42e-06 0.000896724179939267
+ 1.422e-06 0.000896205312900317
+ 1.424e-06 0.00114206069748784
+ 1.426e-06 0.000959302926470012
+ 1.428e-06 0.00112559843915522
+ 1.43e-06 0.00116452534479136
+ 1.432e-06 0.00111043093062097
+ 1.434e-06 0.000933879506623767
+ 1.436e-06 0.000796332789954387
+ 1.438e-06 0.000911283061732213
+ 1.44e-06 0.00100719400195646
+ 1.442e-06 0.000863734158996143
+ 1.444e-06 0.000634412959742921
+ 1.446e-06 0.000424536326018211
+ 1.448e-06 0.000402891020472689
+ 1.45e-06 0.000245792144840183
+ 1.452e-06 0.0004834567617335
+ 1.454e-06 0.000602878657371342
+ 1.456e-06 0.000478862179919606
+ 1.458e-06 0.000543976130455458
+ 1.46e-06 0.000664885749920012
+ 1.462e-06 0.000481647194799357
+ 1.464e-06 0.000972718434040347
+ 1.466e-06 0.00110450190518201
+ 1.468e-06 0.000686781556775635
+ 1.47e-06 0.000462812867999597
+ 1.472e-06 0.00072452783022755
+ 1.474e-06 0.000473373738181289
+ 1.476e-06 0.000781495999956947
+ 1.478e-06 0.000684016531888628
+ 1.48e-06 0.00076110347253053
+ 1.482e-06 0.000815019358724766
+ 1.484e-06 0.000508497778130183
+ 1.486e-06 0.000516456224403758
+ 1.488e-06 0.000787825745276503
+ 1.49e-06 0.000638274465184343
+ 1.492e-06 0.000478902727226162
+ 1.494e-06 0.000722977799997096
+ 1.496e-06 0.00091913448884996
+ 1.498e-06 0.000477940046222418
+ 1.5e-06 0.000267278804823677
+ 1.502e-06 0.000554483961352913
+ 1.504e-06 0.000755348054198164
+ 1.506e-06 0.000845231511718491
+ 1.508e-06 0.000734012160450095
+ 1.51e-06 0.000555183314255469
+ 1.512e-06 0.000541813356390936
+ 1.514e-06 0.000588472101936815
+ 1.516e-06 0.000451940466799474
+ 1.518e-06 0.000189057370027643
+ 1.52e-06 0.000376743691594062
+ 1.522e-06 0.000514859871677046
+ 1.524e-06 0.000784343666721317
+ 1.526e-06 0.000789213739010784
+ 1.528e-06 0.000955378129296945
+ 1.53e-06 0.00105590480819354
+ 1.532e-06 0.000826000375512151
+ 1.534e-06 0.000838746394121146
+ 1.536e-06 0.000844082640803073
+ 1.538e-06 0.00107868005016378
+ 1.54e-06 0.00127679053318399
+ 1.542e-06 0.00147704526030526
+ 1.544e-06 0.00117853276047154
+ 1.546e-06 0.0013339996628794
+ 1.548e-06 0.0013944416540023
+ 1.55e-06 0.0013778327739167
+ 1.552e-06 0.00121945168319208
+ 1.554e-06 0.00081422056148227
+ 1.556e-06 0.000790953833346381
+ 1.558e-06 0.00108208992068855
+ 1.56e-06 0.00116465090568123
+ 1.562e-06 0.000939209362054683
+ 1.564e-06 0.00112884162043887
+ 1.566e-06 0.00107052581259588
+ 1.568e-06 0.00100835225410209
+ 1.57e-06 0.000638512587011805
+ 1.572e-06 0.000584507575032209
+ 1.574e-06 0.000911889771472216
+ 1.576e-06 0.000793199826935829
+ 1.578e-06 0.000750613257274237
+ 1.58e-06 0.000740968543033296
+ 1.582e-06 0.000851997264878961
+ 1.584e-06 0.000912760082442313
+ 1.586e-06 0.00101257713429437
+ 1.588e-06 0.000893243645396663
+ 1.59e-06 0.0012646204546584
+ 1.592e-06 0.00144242954419744
+ 1.594e-06 0.00123260219165111
+ 1.596e-06 0.00108272114137481
+ 1.598e-06 0.00146548354755345
+ 1.6e-06 0.00131624348885046
+ 1.602e-06 0.00155770842947674
+ 1.604e-06 0.00163740514278343
+ 1.606e-06 0.00151310176044481
+ 1.608e-06 0.00130138257190042
+ 1.61e-06 0.00139096062250275
+ 1.612e-06 0.00117878465984083
+ 1.614e-06 0.000997065950582
+ 1.616e-06 0.000733017703112957
+ 1.618e-06 0.000705443576309432
+ 1.62e-06 0.000796084730648141
+ 1.622e-06 0.000772745440977321
+ 1.624e-06 0.000763488556158765
+ 1.626e-06 0.000741827826481378
+ 1.628e-06 0.000661647904703954
+ 1.63e-06 0.000535000957856292
+ 1.632e-06 0.000740921349456745
+ 1.634e-06 0.000958890910185208
+ 1.636e-06 0.00107880819877384
+ 1.638e-06 0.00125190844048418
+ 1.64e-06 0.00102664862410005
+ 1.642e-06 0.00117528282968622
+ 1.644e-06 0.000895720676966225
+ 1.646e-06 0.00094403854143363
+ 1.648e-06 0.000801798090301536
+ 1.65e-06 0.000962026282692765
+ 1.652e-06 0.000883661219330379
+ 1.654e-06 0.000932687962214357
+ 1.656e-06 0.000987051140676743
+ 1.658e-06 0.000559374229258878
+ 1.66e-06 0.000557465356302864
+ 1.662e-06 0.000632145811034527
+ 1.664e-06 0.000610839284159256
+ 1.666e-06 0.000293932373631426
+ 1.668e-06 -3.27645767548434e-05
+ 1.67e-06 -0.000233218828115969
+ 1.672e-06 -0.000265383202189754
+ 1.674e-06 -0.000368427191187335
+ 1.676e-06 -0.000514483760720396
+ 1.678e-06 -0.000963008934667135
+ 1.68e-06 -0.000678082329832183
+ 1.682e-06 -0.000554612640357291
+ 1.684e-06 -0.000593224864320295
+ 1.686e-06 -0.000414003548141287
+ 1.688e-06 -0.000636793719199974
+ 1.69e-06 -0.0006853976330833
+ 1.692e-06 -0.000959724686266339
+ 1.694e-06 -0.000864839092376229
+ 1.696e-06 -0.000989583512827145
+ 1.698e-06 -0.00116951358605223
+ 1.7e-06 -0.00121258223737972
+ 1.702e-06 -0.00104743368298924
+ 1.704e-06 -0.000839501555037953
+ 1.706e-06 -0.000885287607891073
+ 1.708e-06 -0.000901999113601512
+ 1.71e-06 -0.000891720432509827
+ 1.712e-06 -0.00092283156511643
+ 1.714e-06 -0.00122544610435065
+ 1.716e-06 -0.00147971346303636
+ 1.718e-06 -0.0011041542778854
+ 1.72e-06 -0.00131651174649182
+ 1.722e-06 -0.00145704172747114
+ 1.724e-06 -0.00139480473579762
+ 1.726e-06 -0.00159804006486279
+ 1.728e-06 -0.00143596111641515
+ 1.73e-06 -0.00129778837835629
+ 1.732e-06 -0.00161025265375706
+ 1.734e-06 -0.00134164881822584
+ 1.736e-06 -0.00124133096322848
+ 1.738e-06 -0.000968376001047723
+ 1.74e-06 -0.00118225203826669
+ 1.742e-06 -0.00138217672689425
+ 1.744e-06 -0.00126542231560098
+ 1.746e-06 -0.00144131878069653
+ 1.748e-06 -0.00138988295493496
+ 1.75e-06 -0.00147885642137261
+ 1.752e-06 -0.00160387430401044
+ 1.754e-06 -0.00172219532665364
+ 1.756e-06 -0.00195847713293967
+ 1.758e-06 -0.00174823639801459
+ 1.76e-06 -0.00213276564960874
+ 1.762e-06 -0.00199871528170691
+ 1.764e-06 -0.0022553369868231
+ 1.766e-06 -0.00237206178414501
+ 1.768e-06 -0.00227902391470222
+ 1.77e-06 -0.00232702528931592
+ 1.772e-06 -0.00227760452068878
+ 1.774e-06 -0.00233171032338732
+ 1.776e-06 -0.00212899910399579
+ 1.778e-06 -0.00187482483777829
+ 1.78e-06 -0.00184958256943319
+ 1.782e-06 -0.00205343381419482
+ 1.784e-06 -0.00183338644093088
+ 1.786e-06 -0.00163054612870383
+ 1.788e-06 -0.00156149491622845
+ 1.79e-06 -0.00128123216768673
+ 1.792e-06 -0.00142108421854003
+ 1.794e-06 -0.00175390681737043
+ 1.796e-06 -0.00165054603015905
+ 1.798e-06 -0.00143651584711428
+ 1.8e-06 -0.00135063238412223
+ 1.802e-06 -0.00131190412081221
+ 1.804e-06 -0.00135346045257346
+ 1.806e-06 -0.00131771055934825
+ 1.808e-06 -0.00143328506163902
+ 1.81e-06 -0.00133639382529683
+ 1.812e-06 -0.00155931746887361
+ 1.814e-06 -0.00159016659008245
+ 1.816e-06 -0.00174945366310874
+ 1.818e-06 -0.0017576646999983
+ 1.82e-06 -0.00158284864190596
+ 1.822e-06 -0.00148212946051254
+ 1.824e-06 -0.00142733738535304
+ 1.826e-06 -0.00161780422985446
+ 1.828e-06 -0.0017008938740433
+ 1.83e-06 -0.00182063839744824
+ 1.832e-06 -0.00194870455542202
+ 1.834e-06 -0.00159863526901403
+ 1.836e-06 -0.00204876098645848
+ 1.838e-06 -0.00179945659767746
+ 1.84e-06 -0.00168804766731639
+ 1.842e-06 -0.00172963418321661
+ 1.844e-06 -0.00162594212503242
+ 1.846e-06 -0.00188798851262567
+ 1.848e-06 -0.00203434027417188
+ 1.85e-06 -0.0020064339546483
+ 1.852e-06 -0.00221846588509404
+ 1.854e-06 -0.00201990002854955
+ 1.856e-06 -0.00185338268619549
+ 1.858e-06 -0.00190540990022264
+ 1.86e-06 -0.00207866805145438
+ 1.862e-06 -0.00227470497958271
+ 1.864e-06 -0.00228768661811291
+ 1.866e-06 -0.00259821596336321
+ 1.868e-06 -0.00266000697238873
+ 1.87e-06 -0.00252010486948131
+ 1.872e-06 -0.00255973841993236
+ 1.874e-06 -0.00246510527831902
+ 1.876e-06 -0.00198556924400413
+ 1.878e-06 -0.00189554489262718
+ 1.88e-06 -0.0017252017571033
+ 1.882e-06 -0.001837915755521
+ 1.884e-06 -0.00181503380423902
+ 1.886e-06 -0.00192799390318825
+ 1.888e-06 -0.00209535576359566
+ 1.89e-06 -0.001595681070541
+ 1.892e-06 -0.00145981915758989
+ 1.894e-06 -0.00115827700433774
+ 1.896e-06 -0.00102175985168712
+ 1.898e-06 -0.00117186069469013
+ 1.9e-06 -0.00104336720779145
+ 1.902e-06 -0.00142270721090152
+ 1.904e-06 -0.00133392477175291
+ 1.906e-06 -0.00113170187592211
+ 1.908e-06 -0.000755639589280654
+ 1.91e-06 -0.00102163698198082
+ 1.912e-06 -0.00085988195529762
+ 1.914e-06 -0.000817221345512529
+ 1.916e-06 -0.000537714162158478
+ 1.918e-06 -0.00047509218775441
+ 1.92e-06 -0.000411303562864965
+ 1.922e-06 -0.000234737667153585
+ 1.924e-06 -0.000348885336294071
+ 1.926e-06 -0.000114335811496558
+ 1.928e-06 3.39911069919694e-05
+ 1.93e-06 -3.08583398903659e-05
+ 1.932e-06 7.18091899819689e-05
+ 1.934e-06 6.01135031398809e-05
+ 1.936e-06 -0.000131398479713695
+ 1.938e-06 -0.000205424779861615
+ 1.94e-06 -0.000234623210007376
+ 1.942e-06 -0.000461250876699316
+ 1.944e-06 -0.000556137812424899
+ 1.946e-06 -0.000693549696787157
+ 1.948e-06 -0.000468037433988417
+ 1.95e-06 -0.000241824361427559
+ 1.952e-06 5.50668331831262e-05
+ 1.954e-06 0.00029622782967585
+ 1.956e-06 0.000187219357074647
+ 1.958e-06 -1.0097802880896e-05
+ 1.96e-06 0.000253353320936792
+ 1.962e-06 0.000254492883250505
+ 1.964e-06 0.000342353226322549
+ 1.966e-06 7.05577139631228e-05
+ 1.968e-06 -0.000251260393566266
+ 1.97e-06 -0.00039037517867151
+ 1.972e-06 -0.000567622149149196
+ 1.974e-06 -0.000109014214898052
+ 1.976e-06 8.63715619938745e-05
+ 1.978e-06 0.000322235074868719
+ 1.98e-06 0.00030331487817184
+ 1.982e-06 0.000388859866422174
+ 1.984e-06 4.66163459713569e-05
+ 1.986e-06 4.55290235584105e-05
+ 1.988e-06 0.000180635079386467
+ 1.99e-06 -0.000244397803139238
+ 1.992e-06 -6.44218763234602e-05
+ 1.994e-06 0.000237542154556961
+ 1.996e-06 3.55392848476368e-05
+ 1.998e-06 0.000142983316885781
+ 2e-06 0.000298097196954766
+ 2.002e-06 0.000250968662006649
+ 2.004e-06 0.000108644041804661
+ 2.006e-06 0.000232411873989249
+ 2.008e-06 0.000561384941693133
+ 2.01e-06 0.000404441994501974
+ 2.012e-06 0.000539594910207715
+ 2.014e-06 0.000378971710250459
+ 2.016e-06 0.000387481118383969
+ 2.018e-06 0.000394126739601278
+ 2.02e-06 0.000216085020073993
+ 2.022e-06 0.000391323617422636
+ 2.024e-06 0.000381082857785731
+ 2.026e-06 0.000500895976702461
+ 2.028e-06 0.000643253289807503
+ 2.03e-06 0.000509299565571126
+ 2.032e-06 0.000901613697909141
+ 2.034e-06 0.000949455076891975
+ 2.036e-06 0.000897320204038521
+ 2.038e-06 0.000869387458460082
+ 2.04e-06 0.000879400303132251
+ 2.042e-06 0.00104398433245447
+ 2.044e-06 0.000922059376926156
+ 2.046e-06 0.000878819145980836
+ 2.048e-06 0.000840755150898648
+ 2.05e-06 0.00107270051727951
+ 2.052e-06 0.00104589682053493
+ 2.054e-06 0.00146780984701406
+ 2.056e-06 0.00136846428892378
+ 2.058e-06 0.00138754889871241
+ 2.06e-06 0.00138916677101632
+ 2.062e-06 0.0013279348243809
+ 2.064e-06 0.00148229274082993
+ 2.066e-06 0.00144378367540427
+ 2.068e-06 0.00133137998364029
+ 2.07e-06 0.00136112015175172
+ 2.072e-06 0.00105978908866117
+ 2.074e-06 0.000908642348501449
+ 2.076e-06 0.0010330525514443
+ 2.078e-06 0.00126250445422323
+ 2.08e-06 0.00121719638004203
+ 2.082e-06 0.00144701510181873
+ 2.084e-06 0.00101993174956706
+ 2.086e-06 0.00110599066190857
+ 2.088e-06 0.000915168267787767
+ 2.09e-06 0.000674585772212874
+ 2.092e-06 0.00106178363866839
+ 2.094e-06 0.00122033061530906
+ 2.096e-06 0.00130829490937835
+ 2.098e-06 0.00117997151026737
+ 2.1e-06 0.0013482228149677
+ 2.102e-06 0.00126283970249285
+ 2.104e-06 0.00125968312529591
+ 2.106e-06 0.000780378148018336
+ 2.108e-06 0.000937164211629984
+ 2.11e-06 0.000885765100320686
+ 2.112e-06 0.00103669138393838
+ 2.114e-06 0.000841398582098118
+ 2.116e-06 0.000887736588059006
+ 2.118e-06 0.000744813562107664
+ 2.12e-06 0.000438452367304192
+ 2.122e-06 0.000762417927751552
+ 2.124e-06 0.000407007267273158
+ 2.126e-06 0.000341671206451351
+ 2.128e-06 0.000391337159535959
+ 2.13e-06 0.00068910870849766
+ 2.132e-06 0.000633049003612968
+ 2.134e-06 0.000496679920563621
+ 2.136e-06 0.000590423660883673
+ 2.138e-06 0.000375306549552194
+ 2.14e-06 0.000263798314698704
+ 2.142e-06 -7.29795030192393e-05
+ 2.144e-06 -0.000195462527534884
+ 2.146e-06 -0.000396768957210444
+ 2.148e-06 -0.000382115885827674
+ 2.15e-06 -0.000616177443417622
+ 2.152e-06 -0.000350503835277144
+ 2.154e-06 -0.00066721379643445
+ 2.156e-06 -0.000397846197238215
+ 2.158e-06 -0.000526554750077678
+ 2.16e-06 -0.000477481769178019
+ 2.162e-06 -0.000673639675117008
+ 2.164e-06 -0.000752136161225264
+ 2.166e-06 -0.000682506401021421
+ 2.168e-06 -0.000704647722793068
+ 2.17e-06 -0.000788652070457706
+ 2.172e-06 -0.000922446664613065
+ 2.174e-06 -0.00115903695954157
+ 2.176e-06 -0.00118674887750555
+ 2.178e-06 -0.000878192777313251
+ 2.18e-06 -0.000637526703967937
+ 2.182e-06 -0.000461137935132282
+ 2.184e-06 -0.000251887733079352
+ 2.186e-06 -0.000502286627678151
+ 2.188e-06 -0.000520178638211293
+ 2.19e-06 -0.000411358158841571
+ 2.192e-06 -0.000291349299542846
+ 2.194e-06 -0.000162234985317721
+ 2.196e-06 -0.000288310823141556
+ 2.198e-06 -0.000376800462849764
+ 2.2e-06 -0.000302469690032273
+ 2.202e-06 -0.000193491037242626
+ 2.204e-06 7.24841947142216e-05
+ 2.206e-06 0.000113504719393945
+ 2.208e-06 1.38823586029202e-05
+ 2.21e-06 -0.000111425660142321
+ 2.212e-06 -1.96095105892671e-05
+ 2.214e-06 -5.84998448704904e-05
+ 2.216e-06 -0.00014510194432927
+ 2.218e-06 -0.000265606680573164
+ 2.22e-06 -0.000422663983033713
+ 2.222e-06 -0.000654664859557153
+ 2.224e-06 -0.000777310872115121
+ 2.226e-06 -0.000787287829814079
+ 2.228e-06 -0.000701116900396376
+ 2.23e-06 -0.000571160958503645
+ 2.232e-06 -0.000676420777516123
+ 2.234e-06 -0.000464555274774492
+ 2.236e-06 -0.00050617731916986
+ 2.238e-06 -0.000419344467939778
+ 2.24e-06 -0.000248153701928987
+ 2.242e-06 -0.00046707116054445
+ 2.244e-06 -2.39071984542475e-05
+ 2.246e-06 -0.000244837664620947
+ 2.248e-06 -8.73908292991738e-05
+ 2.25e-06 3.93824054082143e-05
+ 2.252e-06 4.76432668657711e-05
+ 2.254e-06 0.000136249434948244
+ 2.256e-06 0.000266583747217179
+ 2.258e-06 0.000367553954185042
+ 2.26e-06 0.000431786808822365
+ 2.262e-06 0.000263118731197578
+ 2.264e-06 0.000292506434989702
+ 2.266e-06 0.000272217057712197
+ 2.268e-06 8.26236923294532e-05
+ 2.27e-06 6.25721826476936e-05
+ 2.272e-06 0.000223216845646278
+ 2.274e-06 0.000453763368067138
+ 2.276e-06 0.000235503555772191
+ 2.278e-06 0.000274997967048581
+ 2.28e-06 0.000263140725814363
+ 2.282e-06 0.000198247873623979
+ 2.284e-06 0.000128407260022165
+ 2.286e-06 0.000176252368480024
+ 2.288e-06 -7.89455424080152e-05
+ 2.29e-06 -3.97713665909414e-05
+ 2.292e-06 -0.000189074014830133
+ 2.294e-06 -0.000221539354588716
+ 2.296e-06 -5.2587675820132e-05
+ 2.298e-06 -0.0003550678977501
+ 2.3e-06 -0.000399867621052921
+ 2.302e-06 -0.000127041542534779
+ 2.304e-06 -0.000293645329217046
+ 2.306e-06 -0.000610389805448687
+ 2.308e-06 -0.000731236627177934
+ 2.31e-06 -0.000854559491677006
+ 2.312e-06 -0.000766241125175239
+ 2.314e-06 -0.000724462148633437
+ 2.316e-06 -0.000462642950554923
+ 2.318e-06 -0.000459083212253336
+ 2.32e-06 -0.000112293855652843
+ 2.322e-06 -2.24046427645424e-05
+ 2.324e-06 0.000103049465234413
+ 2.326e-06 9.77308677959134e-05
+ 2.328e-06 9.76387197913067e-05
+ 2.33e-06 0.000240143351639387
+ 2.332e-06 8.33351195022058e-05
+ 2.334e-06 -0.000364589699397955
+ 2.336e-06 -0.000704074950320533
+ 2.338e-06 -0.000831230563980114
+ 2.34e-06 -0.00110353883448344
+ 2.342e-06 -0.0011158905575202
+ 2.344e-06 -0.000937286920978819
+ 2.346e-06 -0.000786643742584171
+ 2.348e-06 -0.000768490953467129
+ 2.35e-06 -0.00100825096746416
+ 2.352e-06 -0.000891713203179309
+ 2.354e-06 -0.000828356817556395
+ 2.356e-06 -0.000811776229225364
+ 2.358e-06 -0.000664116896085522
+ 2.36e-06 -0.000486022279965664
+ 2.362e-06 -0.000437936003784608
+ 2.364e-06 -0.000682111522995412
+ 2.366e-06 -0.000579617232688131
+ 2.368e-06 -0.000771781967524651
+ 2.37e-06 -0.000815679266880712
+ 2.372e-06 -0.000866118445124792
+ 2.374e-06 -0.00108884504596315
+ 2.376e-06 -0.00115500700426018
+ 2.378e-06 -0.00114157921625749
+ 2.38e-06 -0.00128243707030109
+ 2.382e-06 -0.000972895208214567
+ 2.384e-06 -0.00108611346221867
+ 2.386e-06 -0.00110446404509448
+ 2.388e-06 -0.0010133036035951
+ 2.39e-06 -0.00106438652227783
+ 2.392e-06 -0.00115013987114468
+ 2.394e-06 -0.000951222582662663
+ 2.396e-06 -0.000871194128998857
+ 2.398e-06 -0.000919864405618217
+ 2.4e-06 -0.000604540621266721
+ 2.402e-06 -0.000530072725830599
+ 2.404e-06 -0.000475610851848697
+ 2.406e-06 -0.000512649739985165
+ 2.408e-06 -0.000430450006909329
+ 2.41e-06 -0.000726420005451074
+ 2.412e-06 -0.000717192585731669
+ 2.414e-06 -0.000786560129119787
+ 2.416e-06 -0.000707807162335721
+ 2.418e-06 -0.000704487876483747
+ 2.42e-06 -0.000728758283945288
+ 2.422e-06 -0.000508837180353587
+ 2.424e-06 -0.000655210385490748
+ 2.426e-06 -0.000761456363918591
+ 2.428e-06 -0.0007244788985628
+ 2.43e-06 -0.000613451484594247
+ 2.432e-06 -0.000642994874684121
+ 2.434e-06 -0.000713415289722567
+ 2.436e-06 -0.000317842496202208
+ 2.438e-06 -0.000234657096329489
+ 2.44e-06 -0.000654759503606136
+ 2.442e-06 -0.000860029267986161
+ 2.444e-06 -0.00078107088360375
+ 2.446e-06 -0.000630623647595844
+ 2.448e-06 -0.000598029743478646
+ 2.45e-06 -0.000385537494643896
+ 2.452e-06 -0.00045146275460007
+ 2.454e-06 -0.000178213972516044
+ 2.456e-06 -8.40730219909891e-06
+ 2.458e-06 3.33909675672807e-05
+ 2.46e-06 -0.000596404427075361
+ 2.462e-06 -0.000793921676310605
+ 2.464e-06 -0.000703890966833698
+ 2.466e-06 -0.000576179249146572
+ 2.468e-06 -0.000861685545143373
+ 2.47e-06 -0.000874646521568766
+ 2.472e-06 -0.0009565729426355
+ 2.474e-06 -0.000452974758016388
+ 2.476e-06 -0.000443079926736446
+ 2.478e-06 -0.000162003851083884
+ 2.48e-06 -0.000248734952946931
+ 2.482e-06 -0.000416603065798169
+ 2.484e-06 -0.000402498321324628
+ 2.486e-06 -0.000406689689107098
+ 2.488e-06 -0.000324946737357125
+ 2.49e-06 -0.000174515155841162
+ 2.492e-06 -0.000241245497645911
+ 2.494e-06 -0.000548186098877962
+ 2.496e-06 -0.000709901400373388
+ 2.498e-06 -0.000601820934305088
+ 2.5e-06 -0.000762106679111262
+ 2.502e-06 -0.000635697302132839
+ 2.504e-06 -0.000287148876264973
+ 2.506e-06 -0.000285686702328255
+ 2.508e-06 -1.10473932743199e-05
+ 2.51e-06 0.000273248109736914
+ 2.512e-06 0.000293848825971875
+ 2.514e-06 -8.1218245120959e-05
+ 2.516e-06 -0.000319256696724433
+ 2.518e-06 -0.000340836250164087
+ 2.52e-06 -0.000163873781676697
+ 2.522e-06 -2.67060937072553e-05
+ 2.524e-06 -0.000285536346586154
+ 2.526e-06 -0.000223108699191958
+ 2.528e-06 -0.000332161628512882
+ 2.53e-06 -0.000561724827398982
+ 2.532e-06 -0.000495476856787855
+ 2.534e-06 -0.000497285562313172
+ 2.536e-06 -0.000595957378630119
+ 2.538e-06 -0.000636211044086353
+ 2.54e-06 -0.000578397600862371
+ 2.542e-06 -0.000174072134476214
+ 2.544e-06 -0.000602269779544688
+ 2.546e-06 -0.000803520285246101
+ 2.548e-06 -0.000983719407694789
+ 2.55e-06 -0.00083740073719666
+ 2.552e-06 -0.000681248896383259
+ 2.554e-06 -0.000927871716701393
+ 2.556e-06 -0.00132385134722949
+ 2.558e-06 -0.00126469677440772
+ 2.56e-06 -0.00132386287264506
+ 2.562e-06 -0.00138865814778914
+ 2.564e-06 -0.00100540190739158
+ 2.566e-06 -0.000641398157191595
+ 2.568e-06 -0.000718546933107081
+ 2.57e-06 -0.000765496883562194
+ 2.572e-06 -0.00114919760521059
+ 2.574e-06 -0.00136825007012725
+ 2.576e-06 -0.0012188500264641
+ 2.578e-06 -0.00109924360513857
+ 2.58e-06 -0.000931289041052436
+ 2.582e-06 -0.000933884536513302
+ 2.584e-06 -0.001053172526563
+ 2.586e-06 -0.000841335549205346
+ 2.588e-06 -0.00117026458773923
+ 2.59e-06 -0.00123632846835975
+ 2.592e-06 -0.00149220287177414
+ 2.594e-06 -0.00143374208084552
+ 2.596e-06 -0.00139267003984895
+ 2.598e-06 -0.00119219805514314
+ 2.6e-06 -0.00117705406469786
+ 2.602e-06 -0.00121435246969555
+ 2.604e-06 -0.00136058337679095
+ 2.606e-06 -0.00143758322475203
+ 2.608e-06 -0.00150958414842315
+ 2.61e-06 -0.00170964372058421
+ 2.612e-06 -0.00127752119272556
+ 2.614e-06 -0.00130590839463214
+ 2.616e-06 -0.000852562513031744
+ 2.618e-06 -0.000716517643048223
+ 2.62e-06 -0.00047920795890661
+ 2.622e-06 -0.000526053940953554
+ 2.624e-06 -0.000239753005296899
+ 2.626e-06 -0.000249380120934498
+ 2.628e-06 8.38906647809695e-06
+ 2.63e-06 -0.000166786600578772
+ 2.632e-06 -0.000396034748125978
+ 2.634e-06 -0.000501113456708875
+ 2.636e-06 -0.000558828837120094
+ 2.638e-06 -0.000231957371967685
+ 2.64e-06 -6.24843893921089e-05
+ 2.642e-06 -0.000154203406372787
+ 2.644e-06 -0.000438952707019784
+ 2.646e-06 -0.000526344624227989
+ 2.648e-06 -0.000262007194412542
+ 2.65e-06 -0.000249498828584646
+ 2.652e-06 -0.000381857500934149
+ 2.654e-06 -0.000556330463861247
+ 2.656e-06 -0.000454535842638106
+ 2.658e-06 -0.000479174171693439
+ 2.66e-06 -0.000297976790003886
+ 2.662e-06 -0.000247278568698668
+ 2.664e-06 -0.000364047060431041
+ 2.666e-06 -0.000431571831733505
+ 2.668e-06 -0.000331139690948309
+ 2.67e-06 -0.000414074935550058
+ 2.672e-06 -0.000420665762609738
+ 2.674e-06 -0.000451534453226754
+ 2.676e-06 -0.000232372952195349
+ 2.678e-06 -7.1644960445055e-05
+ 2.68e-06 0.00022782606994918
+ 2.682e-06 0.000313406199853841
+ 2.684e-06 0.000909916368780173
+ 2.686e-06 0.000971457380239396
+ 2.688e-06 0.00127430551281537
+ 2.69e-06 0.00114403853304222
+ 2.692e-06 0.00104359066124608
+ 2.694e-06 0.000910535294169984
+ 2.696e-06 0.0010833636420276
+ 2.698e-06 0.00112533991805524
+ 2.7e-06 0.00121777290820621
+ 2.702e-06 0.0015470351687323
+ 2.704e-06 0.00138971357457234
+ 2.706e-06 0.00132029364153408
+ 2.708e-06 0.00117348548803041
+ 2.71e-06 0.000920053128094492
+ 2.712e-06 0.000905648331868138
+ 2.714e-06 0.000762411834591437
+ 2.716e-06 0.000741887477538028
+ 2.718e-06 0.000475824062050856
+ 2.72e-06 0.00102179774981996
+ 2.722e-06 0.00120023216822271
+ 2.724e-06 0.00131870281935614
+ 2.726e-06 0.00114267418545172
+ 2.728e-06 0.00102031339679926
+ 2.73e-06 0.000915030025939281
+ 2.732e-06 0.000786892601092422
+ 2.734e-06 0.000846869569523934
+ 2.736e-06 0.000555143164803696
+ 2.738e-06 0.000228665540744873
+ 2.74e-06 0.000259264695864974
+ 2.742e-06 0.000317869718057965
+ 2.744e-06 0.000188382928203451
+ 2.746e-06 0.000277680461038386
+ 2.748e-06 0.000553942888602435
+ 2.75e-06 0.000319382209539542
+ 2.752e-06 0.000327343537728539
+ 2.754e-06 0.000789272782196572
+ 2.756e-06 0.00100776048265974
+ 2.758e-06 0.000859187250241048
+ 2.76e-06 0.000834071443793238
+ 2.762e-06 0.000786171720482122
+ 2.764e-06 0.000690349746638707
+ 2.766e-06 0.000797091942430506
+ 2.768e-06 0.000494180773201049
+ 2.77e-06 0.000517422982318121
+ 2.772e-06 0.00010287448279864
+ 2.774e-06 9.03419007947907e-05
+ 2.776e-06 -0.000420524481514692
+ 2.778e-06 -0.000419376666192169
+ 2.78e-06 -0.000292131904329519
+ 2.782e-06 -0.000318489909972151
+ 2.784e-06 -0.000307791798453334
+ 2.786e-06 7.81760946771459e-05
+ 2.788e-06 0.000255653798640379
+ 2.79e-06 0.000498500477839354
+ 2.792e-06 0.000655639658684208
+ 2.794e-06 0.000411158068049311
+ 2.796e-06 0.000797024958233159
+ 2.798e-06 0.000848059461016631
+ 2.8e-06 0.000515189825972544
+ 2.802e-06 0.000760672010413967
+ 2.804e-06 0.000599951801722736
+ 2.806e-06 0.000898442821351949
+ 2.808e-06 0.000890503685887012
+ 2.81e-06 0.00100071861900345
+ 2.812e-06 0.000969056611258711
+ 2.814e-06 0.00133142205019467
+ 2.816e-06 0.000889272374973239
+ 2.818e-06 0.00108642977370366
+ 2.82e-06 0.00108136870472148
+ 2.822e-06 0.000896525494870244
+ 2.824e-06 0.000741597259944587
+ 2.826e-06 0.000739658451332158
+ 2.828e-06 0.000840149876878723
+ 2.83e-06 0.000700854221426113
+ 2.832e-06 0.00036798628654348
+ 2.834e-06 0.000262067247353316
+ 2.836e-06 2.19850558292384e-06
+ 2.838e-06 -4.35311894120375e-05
+ 2.84e-06 2.17187600812375e-05
+ 2.842e-06 0.000285675640149359
+ 2.844e-06 0.000262441128793432
+ 2.846e-06 -0.000118111172471733
+ 2.848e-06 -0.000246576238257225
+ 2.85e-06 -6.3174714235383e-05
+ 2.852e-06 5.44817435988437e-05
+ 2.854e-06 -0.000184501863537734
+ 2.856e-06 -0.000118056653272411
+ 2.858e-06 -0.000508414569777825
+ 2.86e-06 -0.000505931691981707
+ 2.862e-06 -0.00058168595961918
+ 2.864e-06 -0.000656946257878211
+ 2.866e-06 -0.00100056638984076
+ 2.868e-06 -0.000845147078259956
+ 2.87e-06 -0.00104360352246313
+ 2.872e-06 -0.0011962342258616
+ 2.874e-06 -0.00133352781391707
+ 2.876e-06 -0.00163738519199936
+ 2.878e-06 -0.00165219658893888
+ 2.88e-06 -0.0016682389338838
+ 2.882e-06 -0.00166187530000366
+ 2.884e-06 -0.00133314471220166
+ 2.886e-06 -0.00128712113599507
+ 2.888e-06 -0.00115990083405574
+ 2.89e-06 -0.00105599035372973
+ 2.892e-06 -0.000685663189895655
+ 2.894e-06 -0.00105896118337132
+ 2.896e-06 -0.00121481554028116
+ 2.898e-06 -0.00135876554717388
+ 2.9e-06 -0.00146006976949598
+ 2.902e-06 -0.00125670179966115
+ 2.904e-06 -0.00137781100011456
+ 2.906e-06 -0.00135906604109856
+ 2.908e-06 -0.00115775075377182
+ 2.91e-06 -0.00108189099535137
+ 2.912e-06 -0.00104414173604891
+ 2.914e-06 -0.000706588423402163
+ 2.916e-06 -0.000820391338776445
+ 2.918e-06 -0.000675839983006555
+ 2.92e-06 -0.000540805786028849
+ 2.922e-06 -0.000764581932645032
+ 2.924e-06 -0.000490117324369997
+ 2.926e-06 -0.000340106950003748
+ 2.928e-06 -0.00023758247197815
+ 2.93e-06 -0.000159314208891311
+ 2.932e-06 -0.000431974393453441
+ 2.934e-06 -0.000353624188256553
+ 2.936e-06 -0.000260589427375615
+ 2.938e-06 -0.000332501121700111
+ 2.94e-06 -0.000256292012446315
+ 2.942e-06 -0.00026006500425124
+ 2.944e-06 -0.000269401334296156
+ 2.946e-06 -9.09501734337237e-05
+ 2.948e-06 0.000157289904954018
+ 2.95e-06 0.000404354775576594
+ 2.952e-06 0.000446127023914008
+ 2.954e-06 0.000185038511002309
+ 2.956e-06 0.000229950786172924
+ 2.958e-06 4.04123048100194e-05
+ 2.96e-06 -1.10392017636909e-05
+ 2.962e-06 4.65297653232475e-05
+ 2.964e-06 -0.000338523414391524
+ 2.966e-06 -0.000441657474139935
+ 2.968e-06 -0.00067511917138468
+ 2.97e-06 -0.000644707791386655
+ 2.972e-06 -0.000355320023834069
+ 2.974e-06 -0.00067320871183145
+ 2.976e-06 -0.00042898814757294
+ 2.978e-06 -0.000212466523090748
+ 2.98e-06 -0.000336556172150182
+ 2.982e-06 -0.000476326750355521
+ 2.984e-06 -0.000415339307153843
+ 2.986e-06 -0.000186657477230496
+ 2.988e-06 -5.34511928642383e-05
+ 2.99e-06 -0.000143779521476077
+ 2.992e-06 -0.0002074953483795
+ 2.994e-06 -0.000338601918160273
+ 2.996e-06 -0.000487014938515392
+ 2.998e-06 -0.000539941688603317
+ 3e-06 -0.00042704305407897
+ 3.002e-06 -0.000677934527593633
+ 3.004e-06 -0.000619197875202124
+ 3.006e-06 -0.000362155161043185
+ 3.008e-06 -0.000120196996917762
+ 3.01e-06 -4.80553197900835e-05
+ 3.012e-06 0.000343214496646192
+ 3.014e-06 0.000370165152931406
+ 3.016e-06 0.000362486133167333
+ 3.018e-06 0.000517580212014247
+ 3.02e-06 0.000382444332319121
+ 3.022e-06 0.000621651725794204
+ 3.024e-06 0.000742387003198263
+ 3.026e-06 0.000968016562835669
+ 3.028e-06 0.000923545613089966
+ 3.03e-06 0.00117335193514524
+ 3.032e-06 0.00128949766976525
+ 3.034e-06 0.000876632986988308
+ 3.036e-06 0.00118978995340461
+ 3.038e-06 0.00142935669839877
+ 3.04e-06 0.00125260371162361
+ 3.042e-06 0.00129293508691017
+ 3.044e-06 0.00116939132362785
+ 3.046e-06 0.00137054113072378
+ 3.048e-06 0.0014039237695746
+ 3.05e-06 0.00119764209333364
+ 3.052e-06 0.00117081532796387
+ 3.054e-06 0.000891598784717573
+ 3.056e-06 0.000498408177321539
+ 3.058e-06 0.000776370768041926
+ 3.06e-06 0.000773867706168175
+ 3.062e-06 0.000629679597761934
+ 3.064e-06 0.000704395248451179
+ 3.066e-06 0.000414194370414017
+ 3.068e-06 0.000662975317015129
+ 3.07e-06 0.00092684175269217
+ 3.072e-06 0.000950939306721102
+ 3.074e-06 0.00105803433566753
+ 3.076e-06 0.00149500348720944
+ 3.078e-06 0.00103893915018842
+ 3.08e-06 0.00113860361859768
+ 3.082e-06 0.00117972008839501
+ 3.084e-06 0.00106500316709989
+ 3.086e-06 0.00113117187665321
+ 3.088e-06 0.00118005165283611
+ 3.09e-06 0.00101054974279131
+ 3.092e-06 0.000940761025613475
+ 3.094e-06 0.000750605633100621
+ 3.096e-06 0.000738130969742754
+ 3.098e-06 0.000765670842192994
+ 3.1e-06 0.000697364370386375
+ 3.102e-06 0.000721059915196959
+ 3.104e-06 0.000537530422259723
+ 3.106e-06 0.000432471204581028
+ 3.108e-06 0.000295657476283075
+ 3.11e-06 0.000592465207994164
+ 3.112e-06 0.000600597797555323
+ 3.114e-06 0.000365791131604319
+ 3.116e-06 0.000643306169547333
+ 3.118e-06 0.000680082978134609
+ 3.12e-06 0.00109084310021523
+ 3.122e-06 0.00138543957356017
+ 3.124e-06 0.00122006935993895
+ 3.126e-06 0.00121891564778828
+ 3.128e-06 0.00120598334325431
+ 3.13e-06 0.00119570111965076
+ 3.132e-06 0.00100342205967442
+ 3.134e-06 0.00103203414391466
+ 3.136e-06 0.00086969793726824
+ 3.138e-06 0.000796501325656669
+ 3.14e-06 0.000940778624381247
+ 3.142e-06 0.00104302048329831
+ 3.144e-06 0.00103590975107254
+ 3.146e-06 0.000784837619268379
+ 3.148e-06 0.00119958284598661
+ 3.15e-06 0.00123128106252816
+ 3.152e-06 0.0008528476935123
+ 3.154e-06 0.00091923854679561
+ 3.156e-06 0.000889788886893101
+ 3.158e-06 0.000869181206702921
+ 3.16e-06 0.000832846497737836
+ 3.162e-06 0.000347817163155143
+ 3.164e-06 0.000327217930334697
+ 3.166e-06 -0.000146453504387416
+ 3.168e-06 4.85868375881026e-05
+ 3.17e-06 0.000216964896015785
+ 3.172e-06 0.000826298018746092
+ 3.174e-06 0.00103210684277919
+ 3.176e-06 0.000804671294243328
+ 3.178e-06 0.000482715687016944
+ 3.18e-06 0.000505541518630648
+ 3.182e-06 0.000829754790772034
+ 3.184e-06 0.000746615807958305
+ 3.186e-06 0.00100868290535031
+ 3.188e-06 0.000823285756446918
+ 3.19e-06 0.000779418848510457
+ 3.192e-06 0.00108741812330725
+ 3.194e-06 0.000994599577340184
+ 3.196e-06 0.00114412812078781
+ 3.198e-06 0.00111797907260706
+ 3.2e-06 0.00109973993591412
+ 3.202e-06 0.00109523629354876
+ 3.204e-06 0.00110805663181311
+ 3.206e-06 0.000986736557088496
+ 3.208e-06 0.00119888792266604
+ 3.21e-06 0.00123667052452886
+ 3.212e-06 0.000969021336220168
+ 3.214e-06 0.00115057015295324
+ 3.216e-06 0.00105748470405126
+ 3.218e-06 0.000886979211523056
+ 3.22e-06 0.000820640017352404
+ 3.222e-06 0.000778871438083367
+ 3.224e-06 0.00126372332615186
+ 3.226e-06 0.00132923334816882
+ 3.228e-06 0.00114525698504522
+ 3.23e-06 0.0012580769210923
+ 3.232e-06 0.000965199670326681
+ 3.234e-06 0.00083841892456107
+ 3.236e-06 0.00126480219817102
+ 3.238e-06 0.00137245848695939
+ 3.24e-06 0.000848098001147379
+ 3.242e-06 0.000872323516441399
+ 3.244e-06 0.000887338892697312
+ 3.246e-06 0.000696010822635151
+ 3.248e-06 0.000508545960918816
+ 3.25e-06 0.000398384608607426
+ 3.252e-06 0.000195244152915749
+ 3.254e-06 1.19638597836375e-05
+ 3.256e-06 -4.98047542709223e-06
+ 3.258e-06 0.000178879067180315
+ 3.26e-06 0.000226596666744827
+ 3.262e-06 0.000163697185599055
+ 3.264e-06 -1.66667434929264e-05
+ 3.266e-06 -5.72248251207669e-05
+ 3.268e-06 -0.000386156441621813
+ 3.27e-06 -0.000541615870770416
+ 3.272e-06 -0.000406141140601943
+ 3.274e-06 -0.000478454031897454
+ 3.276e-06 -0.000490579393343795
+ 3.278e-06 -0.000195330134469001
+ 3.28e-06 -0.000249756407041383
+ 3.282e-06 -0.000254188851569852
+ 3.284e-06 3.49543708389729e-05
+ 3.286e-06 -0.000179005164682621
+ 3.288e-06 2.55410402900422e-06
+ 3.29e-06 -5.01757673476978e-05
+ 3.292e-06 -0.000337706160149632
+ 3.294e-06 -0.000277453386108361
+ 3.296e-06 -0.000501949947183093
+ 3.298e-06 -0.00044820531702077
+ 3.3e-06 -0.000686489811949807
+ 3.302e-06 -0.000577077284679803
+ 3.304e-06 -0.000545561278910757
+ 3.306e-06 -0.000906488312904836
+ 3.308e-06 -0.00101846883648768
+ 3.31e-06 -0.00109571764127157
+ 3.312e-06 -0.000916388747634369
+ 3.314e-06 -0.00115680015641462
+ 3.316e-06 -0.00107336052957821
+ 3.318e-06 -0.0012530041576415
+ 3.32e-06 -0.00111413841768807
+ 3.322e-06 -0.00111986219456292
+ 3.324e-06 -0.000835923824847059
+ 3.326e-06 -0.00104327775845224
+ 3.328e-06 -0.000757067482091804
+ 3.33e-06 -0.000459331378347528
+ 3.332e-06 -0.000637042907890813
+ 3.334e-06 -0.000801178400966235
+ 3.336e-06 -0.000903756116306025
+ 3.338e-06 -0.0011324668253072
+ 3.34e-06 -0.00103036606819237
+ 3.342e-06 -0.000910139811649369
+ 3.344e-06 -0.00101836503059149
+ 3.346e-06 -0.00127741280544457
+ 3.348e-06 -0.00134342784315795
+ 3.35e-06 -0.00165401873492428
+ 3.352e-06 -0.00155826471488649
+ 3.354e-06 -0.0015078493367455
+ 3.356e-06 -0.00129271044033423
+ 3.358e-06 -0.00172420236430703
+ 3.36e-06 -0.00170788316258368
+ 3.362e-06 -0.00175671464899934
+ 3.364e-06 -0.00145038067047884
+ 3.366e-06 -0.00144158597730623
+ 3.368e-06 -0.00168324332829636
+ 3.37e-06 -0.00145812193773671
+ 3.372e-06 -0.00167510573609147
+ 3.374e-06 -0.00149435528240481
+ 3.376e-06 -0.00157141720148329
+ 3.378e-06 -0.00128052901758768
+ 3.38e-06 -0.00143337043226933
+ 3.382e-06 -0.00118548548530228
+ 3.384e-06 -0.000995034685387022
+ 3.386e-06 -0.00121947571718666
+ 3.388e-06 -0.00107473504563525
+ 3.39e-06 -0.000966022276757844
+ 3.392e-06 -0.000826729318370673
+ 3.394e-06 -0.000474180804950551
+ 3.396e-06 -0.000769877867983225
+ 3.398e-06 -0.000785424425433602
+ 3.4e-06 -0.000854200357760401
+ 3.402e-06 -0.000465811465373056
+ 3.404e-06 -0.000328719369818553
+ 3.406e-06 -0.000328457825545381
+ 3.408e-06 -7.74855078475226e-05
+ 3.41e-06 -0.000120345059629551
+ 3.412e-06 0.000339797485541111
+ 3.414e-06 0.000266958036615948
+ 3.416e-06 0.000171758019131654
+ 3.418e-06 0.000325584238389617
+ 3.42e-06 0.000275633180746667
+ 3.422e-06 0.000591707986937621
+ 3.424e-06 0.000798896004855987
+ 3.426e-06 0.000656768489169768
+ 3.428e-06 0.000474038999232635
+ 3.43e-06 0.000740214523069408
+ 3.432e-06 0.000719295037009494
+ 3.434e-06 0.000657047773704232
+ 3.436e-06 0.000387272342738948
+ 3.438e-06 0.000383008932378702
+ 3.44e-06 0.000285994741099399
+ 3.442e-06 0.000303403592498732
+ 3.444e-06 3.92236864234119e-07
+ 3.446e-06 -0.000431412457650798
+ 3.448e-06 -0.00038634219294115
+ 3.45e-06 -0.000365298493179028
+ 3.452e-06 6.18066663308104e-05
+ 3.454e-06 -0.000191231788740951
+ 3.456e-06 -1.09303452622102e-05
+ 3.458e-06 -4.41735424820712e-05
+ 3.46e-06 -4.17961210997083e-05
+ 3.462e-06 -0.000526750158162151
+ 3.464e-06 -0.000566979050559032
+ 3.466e-06 -0.000651282010470392
+ 3.468e-06 -0.000657845865348169
+ 3.47e-06 -0.000491655848164768
+ 3.472e-06 -0.000761075506968146
+ 3.474e-06 -0.000976314841438692
+ 3.476e-06 -0.000966063324709825
+ 3.478e-06 -0.000792424699244056
+ 3.48e-06 -0.000216421923374361
+ 3.482e-06 -0.000400403794352174
+ 3.484e-06 -0.000297835585557171
+ 3.486e-06 -9.63970012623815e-05
+ 3.488e-06 -0.000153192731109306
+ 3.49e-06 -0.000361461292464361
+ 3.492e-06 -0.000223847031611271
+ 3.494e-06 -0.000366656769789731
+ 3.496e-06 -0.000284585377115712
+ 3.498e-06 0.000100122827249132
+ 3.5e-06 -0.000112086403581393
+ 3.502e-06 6.13255669929251e-05
+ 3.504e-06 0.00016238045314765
+ 3.506e-06 0.000271219282311029
+ 3.508e-06 -3.61259386344175e-05
+ 3.51e-06 -6.572059607826e-05
+ 3.512e-06 -0.00038735292073654
+ 3.514e-06 -0.000598206911561803
+ 3.516e-06 -0.000813498531668816
+ 3.518e-06 -0.00109061736025713
+ 3.52e-06 -0.000934107502269753
+ 3.522e-06 -0.00117665192953614
+ 3.524e-06 -0.000873786287932017
+ 3.526e-06 -0.000824435088694254
+ 3.528e-06 -0.000872368520931445
+ 3.53e-06 -0.000969603368842889
+ 3.532e-06 -0.00100412820600222
+ 3.534e-06 -0.000877148609302736
+ 3.536e-06 -0.00137173966251797
+ 3.538e-06 -0.00162314367648315
+ 3.54e-06 -0.00153362653167954
+ 3.542e-06 -0.00129410478558374
+ 3.544e-06 -0.00128975641096622
+ 3.546e-06 -0.00122898675279401
+ 3.548e-06 -0.000770949844826532
+ 3.55e-06 -0.000634199667443333
+ 3.552e-06 -0.000513181349813977
+ 3.554e-06 -0.000423111756469045
+ 3.556e-06 -0.000665459305195525
+ 3.558e-06 -0.000568540736387206
+ 3.56e-06 -0.000648403693937086
+ 3.562e-06 -0.000591657719974512
+ 3.564e-06 -0.000478283908810776
+ 3.566e-06 -0.000544711797658436
+ 3.568e-06 -0.000393278961957812
+ 3.57e-06 -0.000207061992037442
+ 3.572e-06 -0.000202891280118388
+ 3.574e-06 -0.000297910324376552
+ 3.576e-06 -0.000178757484013175
+ 3.578e-06 -0.000173983880664506
+ 3.58e-06 -0.000209334094079467
+ 3.582e-06 -0.000146641067797302
+ 3.584e-06 0.000162807146326556
+ 3.586e-06 0.000287018878950768
+ 3.588e-06 3.76565623272112e-05
+ 3.59e-06 -7.61281662059615e-05
+ 3.592e-06 -0.000164970625960375
+ 3.594e-06 -0.000453179980540341
+ 3.596e-06 -0.00017644960986469
+ 3.598e-06 -0.000151075450025176
+ 3.6e-06 -0.000120995202077214
+ 3.602e-06 0.000116328851029753
+ 3.604e-06 -5.29711155610558e-05
+ 3.606e-06 -0.000218115250183714
+ 3.608e-06 -0.000212395454033341
+ 3.61e-06 -0.000349081254029311
+ 3.612e-06 -0.000304775818659118
+ 3.614e-06 -0.000453717561152859
+ 3.616e-06 -0.000631685232302952
+ 3.618e-06 -0.000498013760105902
+ 3.62e-06 -0.000350484120005887
+ 3.622e-06 -0.000602816753521958
+ 3.624e-06 -0.000609791209199476
+ 3.626e-06 -0.000515493274719327
+ 3.628e-06 -0.000441408355642659
+ 3.63e-06 -0.000139731350948735
+ 3.632e-06 -0.000441864126132973
+ 3.634e-06 -0.000524258798318761
+ 3.636e-06 -0.000526513204876275
+ 3.638e-06 -0.000545039560007629
+ 3.64e-06 -0.000534165513882246
+ 3.642e-06 -0.000582753164629964
+ 3.644e-06 -0.000498802918875731
+ 3.646e-06 -0.000529572806808137
+ 3.648e-06 -0.000718636731661997
+ 3.65e-06 -0.000725336150288205
+ 3.652e-06 -0.000471215920317215
+ 3.654e-06 -0.000279268868906239
+ 3.656e-06 -0.00014736994141624
+ 3.658e-06 -0.000263564338065081
+ 3.66e-06 -0.000265760152074449
+ 3.662e-06 -0.000261069507682019
+ 3.664e-06 -0.000671098866883886
+ 3.666e-06 -0.000535507093163882
+ 3.668e-06 -0.000322822387633557
+ 3.67e-06 0.000117197991608806
+ 3.672e-06 0.000138737154038296
+ 3.674e-06 0.00023947370203603
+ 3.676e-06 0.000195390168017663
+ 3.678e-06 -2.06215493204256e-05
+ 3.68e-06 0.000249473127484138
+ 3.682e-06 -0.000260679857973972
+ 3.684e-06 -0.000256746543579003
+ 3.686e-06 -0.000533830819770845
+ 3.688e-06 -0.000272816909318987
+ 3.69e-06 -9.2699877020817e-05
+ 3.692e-06 0.000136440999703488
+ 3.694e-06 0.000160887273686761
+ 3.696e-06 -3.0392997989121e-05
+ 3.698e-06 -0.000116254012070941
+ 3.7e-06 -0.000453913149593287
+ 3.702e-06 -0.000354779029370436
+ 3.704e-06 -0.000156124878288265
+ 3.706e-06 -0.000305739721660594
+ 3.708e-06 1.04150485500953e-06
+ 3.71e-06 4.80489196016576e-05
+ 3.712e-06 0.000513715292322991
+ 3.714e-06 0.000800752109137094
+ 3.716e-06 0.000712559487025304
+ 3.718e-06 0.000707658437817233
+ 3.72e-06 0.000810404584561695
+ 3.722e-06 0.000878029611354593
+ 3.724e-06 0.000971898369269628
+ 3.726e-06 0.00111424583125246
+ 3.728e-06 0.00106371399688695
+ 3.73e-06 0.000332498354592272
+ 3.732e-06 0.000376490936867341
+ 3.734e-06 0.00040066663578497
+ 3.736e-06 0.000185666259120982
+ 3.738e-06 -0.000198043307055528
+ 3.74e-06 -0.000557497984154157
+ 3.742e-06 -0.000416305491288201
+ 3.744e-06 -0.00051594538243169
+ 3.746e-06 -0.000363786470397463
+ 3.748e-06 -0.000415238119011938
+ 3.75e-06 -0.000464107087683631
+ 3.752e-06 -0.000710746958095217
+ 3.754e-06 -0.000650246667593071
+ 3.756e-06 -0.000809742634081711
+ 3.758e-06 -0.0006790022720779
+ 3.76e-06 -0.000529590191272417
+ 3.762e-06 -0.000323220988641223
+ 3.764e-06 -0.00040894615471817
+ 3.766e-06 -0.000584423511999694
+ 3.768e-06 -0.000392088007835815
+ 3.77e-06 -0.000319743787589165
+ 3.772e-06 -0.00020448652685488
+ 3.774e-06 -0.000576129071026503
+ 3.776e-06 -0.000548499257467122
+ 3.778e-06 -0.000799551922857721
+ 3.78e-06 -0.000762286069440705
+ 3.782e-06 -0.000929800843181116
+ 3.784e-06 -0.00125012575428949
+ 3.786e-06 -0.00133212391232231
+ 3.788e-06 -0.00151929666189022
+ 3.79e-06 -0.00143500385069981
+ 3.792e-06 -0.00168970179384907
+ 3.794e-06 -0.0012227386464773
+ 3.796e-06 -0.00147828287469017
+ 3.798e-06 -0.000946206951543723
+ 3.8e-06 -0.000953473776191116
+ 3.802e-06 -0.000914399197938349
+ 3.804e-06 -0.00111857482692501
+ 3.806e-06 -0.000907118012804475
+ 3.808e-06 -0.000786142807972192
+ 3.81e-06 -0.000936061586917177
+ 3.812e-06 -0.000964081010330953
+ 3.814e-06 -0.000956848077752876
+ 3.816e-06 -0.000955217824265341
+ 3.818e-06 -0.000905434161748608
+ 3.82e-06 -0.00113792599504743
+ 3.822e-06 -0.00124512418233542
+ 3.824e-06 -0.00101850528236101
+ 3.826e-06 -0.00128270521001141
+ 3.828e-06 -0.00141269172202101
+ 3.83e-06 -0.00121886559757532
+ 3.832e-06 -0.00134194935449853
+ 3.834e-06 -0.0012286064806203
+ 3.836e-06 -0.00117770364864544
+ 3.838e-06 -0.00116012932881846
+ 3.84e-06 -0.00137578287328768
+ 3.842e-06 -0.0015572769708189
+ 3.844e-06 -0.00140345624461764
+ 3.846e-06 -0.0015264905592194
+ 3.848e-06 -0.0015408503597524
+ 3.85e-06 -0.00127660011389426
+ 3.852e-06 -0.00110536049786763
+ 3.854e-06 -0.00101652139391972
+ 3.856e-06 -0.00135385673866216
+ 3.858e-06 -0.00125029140873292
+ 3.86e-06 -0.00115239544405941
+ 3.862e-06 -0.00106168466450569
+ 3.864e-06 -0.000638676834393213
+ 3.866e-06 -0.00088691204055329
+ 3.868e-06 -0.000960650030781588
+ 3.87e-06 -0.00100481526056881
+ 3.872e-06 -0.00121158212690563
+ 3.874e-06 -0.0014667909543906
+ 3.876e-06 -0.001176633829088
+ 3.878e-06 -0.00115389874535477
+ 3.88e-06 -0.00135469454049506
+ 3.882e-06 -0.00127505111558312
+ 3.884e-06 -0.00145267535664511
+ 3.886e-06 -0.0015343763217757
+ 3.888e-06 -0.001728349972217
+ 3.89e-06 -0.00183376856117401
+ 3.892e-06 -0.00158668126379116
+ 3.894e-06 -0.00125920783447636
+ 3.896e-06 -0.00153489929953548
+ 3.898e-06 -0.00169340808935873
+ 3.9e-06 -0.00192549747400975
+ 3.902e-06 -0.00187322078023568
+ 3.904e-06 -0.0018473010621521
+ 3.906e-06 -0.00182028022664072
+ 3.908e-06 -0.00171569834994976
+ 3.91e-06 -0.00175872319296066
+ 3.912e-06 -0.00174044336199978
+ 3.914e-06 -0.00187869813702972
+ 3.916e-06 -0.00200341647179723
+ 3.918e-06 -0.00212334556517462
+ 3.92e-06 -0.00227236081932376
+ 3.922e-06 -0.00241982616987878
+ 3.924e-06 -0.00234235069821931
+ 3.926e-06 -0.00222639249720435
+ 3.928e-06 -0.0017602936420789
+ 3.93e-06 -0.001735512283969
+ 3.932e-06 -0.00164499871537872
+ 3.934e-06 -0.00153136818395481
+ 3.936e-06 -0.00177012089283625
+ 3.938e-06 -0.0013667720959203
+ 3.94e-06 -0.00143646899556874
+ 3.942e-06 -0.00160917412654488
+ 3.944e-06 -0.00138026794350857
+ 3.946e-06 -0.00153785329979614
+ 3.948e-06 -0.00142324700330317
+ 3.95e-06 -0.00141799654341677
+ 3.952e-06 -0.00139227473553925
+ 3.954e-06 -0.00136750257540898
+ 3.956e-06 -0.00116432746961003
+ 3.958e-06 -0.00136222877657553
+ 3.96e-06 -0.00117910257906426
+ 3.962e-06 -0.00142146878326033
+ 3.964e-06 -0.00142012393086605
+ 3.966e-06 -0.0013099801914372
+ 3.968e-06 -0.00106206623416143
+ 3.97e-06 -0.000887876800604113
+ 3.972e-06 -0.000945262929681025
+ 3.974e-06 -0.000803039736239491
+ 3.976e-06 -0.000850811817810889
+ 3.978e-06 -0.000745347626536461
+ 3.98e-06 -0.000745072866629578
+ 3.982e-06 -0.000733685343436234
+ 3.984e-06 -0.00109026147351488
+ 3.986e-06 -0.00109438620567075
+ 3.988e-06 -0.00119511996585886
+ 3.99e-06 -0.00125802857480767
+ 3.992e-06 -0.00115079330628281
+ 3.994e-06 -0.00117072053551122
+ 3.996e-06 -0.00122336084846807
+ 3.998e-06 -0.00140917245457766
+ 4e-06 -0.000951354974165572
+ 4.002e-06 -0.000850277632566806
+ 4.004e-06 -0.000646348073646181
+ 4.006e-06 -0.000641579369687258
+ 4.008e-06 -0.000630482900955303
+ 4.01e-06 -0.000392537624678502
+ 4.012e-06 3.0007882555363e-05
+ 4.014e-06 -5.01077909999901e-05
+ 4.016e-06 -0.00018082320348414
+ 4.018e-06 -0.000248107354702125
+ 4.02e-06 -0.000311556882827403
+ 4.022e-06 -0.000532806758408049
+ 4.024e-06 -0.000836292995675061
+ 4.026e-06 -0.000530230613129486
+ 4.028e-06 -0.000806275638197623
+ 4.03e-06 -0.000775171721272934
+ 4.032e-06 -0.00059832235521898
+ 4.034e-06 -0.000372093259956955
+ 4.036e-06 -0.00055419049697661
+ 4.038e-06 -0.000458147294803052
+ 4.04e-06 -0.000413421241723395
+ 4.042e-06 -0.000601683031448088
+ 4.044e-06 -0.000321380726982709
+ 4.046e-06 -0.000412050019397871
+ 4.048e-06 -0.000136476705553455
+ 4.05e-06 -0.000344730708461765
+ 4.052e-06 -0.000471582413473177
+ 4.054e-06 -0.000571760367678287
+ 4.056e-06 -0.00075543884296452
+ 4.058e-06 -0.000633940710262107
+ 4.06e-06 -0.000440920312443389
+ 4.062e-06 -0.000455300671137232
+ 4.064e-06 -0.00041131827369729
+ 4.066e-06 -0.000479238216278125
+ 4.068e-06 -0.000349137140552529
+ 4.07e-06 -0.000249205599998478
+ 4.072e-06 -0.000761756044864765
+ 4.074e-06 -0.000951751014097469
+ 4.076e-06 -0.000974742561987869
+ 4.078e-06 -0.00103392651283414
+ 4.08e-06 -0.00106744517488233
+ 4.082e-06 -0.000912255444500542
+ 4.084e-06 -0.000870782127773825
+ 4.086e-06 -0.000814485680311951
+ 4.088e-06 -0.000719798953850682
+ 4.09e-06 -0.000907672404418191
+ 4.092e-06 -0.000885299344086521
+ 4.094e-06 -0.000971700593399185
+ 4.096e-06 -0.000897867025506198
+ 4.098e-06 -0.00062645963259953
+ 4.1e-06 -0.000727661031720568
+ 4.102e-06 -0.000694517946764104
+ 4.104e-06 -0.000628581137330269
+ 4.106e-06 -0.000757128684546497
+ 4.108e-06 -0.000457408868509216
+ 4.11e-06 -0.000823504503995485
+ 4.112e-06 -0.000549244131562872
+ 4.114e-06 -0.000459159948411636
+ 4.116e-06 -0.000725032391527783
+ 4.118e-06 -0.000645909045953955
+ 4.12e-06 -0.000766062874780096
+ 4.122e-06 -0.000642326900084661
+ 4.124e-06 -0.000569193858358512
+ 4.126e-06 -0.000503756933927146
+ 4.128e-06 -0.000568018029413317
+ 4.13e-06 -0.000322706910374961
+ 4.132e-06 -0.00060474561581048
+ 4.134e-06 -0.000735492842156492
+ 4.136e-06 -0.000792853163673001
+ 4.138e-06 -0.000676128227525516
+ 4.14e-06 -0.0008596151145579
+ 4.142e-06 -0.00100345182016107
+ 4.144e-06 -0.00127110608114496
+ 4.146e-06 -0.00136303123254255
+ 4.148e-06 -0.00107218412742974
+ 4.15e-06 -0.00117348123526793
+ 4.152e-06 -0.00121670056329086
+ 4.154e-06 -0.000905124319048693
+ 4.156e-06 -0.000990821101181875
+ 4.158e-06 -0.00123192883389243
+ 4.16e-06 -0.00123187957168303
+ 4.162e-06 -0.00141875216155918
+ 4.164e-06 -0.00129956232665382
+ 4.166e-06 -0.000947061457175667
+ 4.168e-06 -0.00103813124569124
+ 4.17e-06 -0.000995673252713354
+ 4.172e-06 -0.00089084271335008
+ 4.174e-06 -0.00064093135443248
+ 4.176e-06 -0.000407741623048467
+ 4.178e-06 -0.000152511278915702
+ 4.18e-06 -0.0001047912496195
+ 4.182e-06 -0.000276657614505829
+ 4.184e-06 -0.000403348036733269
+ 4.186e-06 -0.000566684092153042
+ 4.188e-06 -0.000798149099143869
+ 4.19e-06 -0.00138060750950508
+ 4.192e-06 -0.00105602679772616
+ 4.194e-06 -0.000936242408114752
+ 4.196e-06 -0.000848004232347918
+ 4.198e-06 -0.00114332538179991
+ 4.2e-06 -0.00103519345735412
+ 4.202e-06 -0.00122849574231108
+ 4.204e-06 -0.00101599060460557
+ 4.206e-06 -0.00116297109473675
+ 4.208e-06 -0.00123345237428692
+ 4.21e-06 -0.000873604290194587
+ 4.212e-06 -0.000685295442353888
+ 4.214e-06 -0.000262037097356188
+ 4.216e-06 -0.000285005187573887
+ 4.218e-06 -0.000474683668761675
+ 4.22e-06 -0.000519279469329425
+ 4.222e-06 -0.000524705183298451
+ 4.224e-06 -0.000245220342157495
+ 4.226e-06 9.82048076353386e-05
+ 4.228e-06 2.35493629177275e-05
+ 4.23e-06 -3.440188975844e-05
+ 4.232e-06 -1.60100200819073e-05
+ 4.234e-06 0.000128881816645646
+ 4.236e-06 2.85389743624361e-05
+ 4.238e-06 3.60266572522332e-05
+ 4.24e-06 -8.20135102175522e-05
+ 4.242e-06 -7.40279843265142e-05
+ 4.244e-06 -0.00036142944914946
+ 4.246e-06 -0.000433550826759888
+ 4.248e-06 0.000103887459682299
+ 4.25e-06 8.80088470290364e-05
+ 4.252e-06 4.55794485300649e-05
+ 4.254e-06 -0.000356666496408885
+ 4.256e-06 -7.12978752332565e-05
+ 4.258e-06 -0.000212980689426778
+ 4.26e-06 -7.77626987063996e-05
+ 4.262e-06 -0.000227724956555205
+ 4.264e-06 -4.82067531471764e-05
+ 4.266e-06 -0.000187685525438639
+ 4.268e-06 -0.00011235459532326
+ 4.27e-06 0.000124253244211632
+ 4.272e-06 0.000300630689057315
+ 4.274e-06 0.000213732718955547
+ 4.276e-06 0.000398081425608082
+ 4.278e-06 0.000189561906378557
+ 4.28e-06 0.000191523627972463
+ 4.282e-06 6.61115052109809e-05
+ 4.284e-06 0.000297098897344178
+ 4.286e-06 0.00019967516689503
+ 4.288e-06 0.000261498592987067
+ 4.29e-06 3.16738905185115e-05
+ 4.292e-06 -0.000229727792543121
+ 4.294e-06 -4.84903661932676e-05
+ 4.296e-06 -8.00457457676324e-05
+ 4.298e-06 -0.000176265503086183
+ 4.3e-06 -0.000608603928461781
+ 4.302e-06 -0.000929448340453642
+ 4.304e-06 -0.000977593210150821
+ 4.306e-06 -0.000888910119525627
+ 4.308e-06 -0.000836865435218213
+ 4.31e-06 -0.00108398681062173
+ 4.312e-06 -0.00102710700201979
+ 4.314e-06 -0.000619403837346627
+ 4.316e-06 -0.000768080020989049
+ 4.318e-06 -0.00078024486111726
+ 4.32e-06 -0.000419868141236335
+ 4.322e-06 -0.000903468495137397
+ 4.324e-06 -0.000644154147927968
+ 4.326e-06 -0.000689536174767201
+ 4.328e-06 -0.000836625598236933
+ 4.33e-06 -0.000930553583128609
+ 4.332e-06 -0.000775470125307557
+ 4.334e-06 -0.000689580241539459
+ 4.336e-06 -0.000832800099634198
+ 4.338e-06 -0.000738709084493152
+ 4.34e-06 -0.000771633905141758
+ 4.342e-06 -0.000838073064030677
+ 4.344e-06 -0.000437416300576413
+ 4.346e-06 -0.000164534920054513
+ 4.348e-06 0.00021660433166294
+ 4.35e-06 0.000423657470705294
+ 4.352e-06 0.000227430805590637
+ 4.354e-06 0.000217102248907499
+ 4.356e-06 0.000250376005329989
+ 4.358e-06 0.000278192419929341
+ 4.36e-06 0.00048205454318856
+ 4.362e-06 0.000204971194680423
+ 4.364e-06 0.000549995863932296
+ 4.366e-06 0.000508857111730426
+ 4.368e-06 0.000247423625068635
+ 4.37e-06 0.000265352642954613
+ 4.372e-06 1.77661568971177e-06
+ 4.374e-06 0.000261383726362542
+ 4.376e-06 0.000315794731566788
+ 4.378e-06 0.000568182699873666
+ 4.38e-06 0.000801438002164701
+ 4.382e-06 0.000862336570040366
+ 4.384e-06 0.00097184883354153
+ 4.386e-06 0.00110472032646498
+ 4.388e-06 0.00157285264190287
+ 4.39e-06 0.00172456250517908
+ 4.392e-06 0.00178634078793646
+ 4.394e-06 0.00167310337015316
+ 4.396e-06 0.00171307773219599
+ 4.398e-06 0.00174650750923976
+ 4.4e-06 0.00182068469683806
+ 4.402e-06 0.00208084949003034
+ 4.404e-06 0.0018064007234266
+ 4.406e-06 0.00189851220933492
+ 4.408e-06 0.00156740154148609
+ 4.41e-06 0.00167664991181171
+ 4.412e-06 0.0012835680454085
+ 4.414e-06 0.0012871694046878
+ 4.416e-06 0.00124993031230941
+ 4.418e-06 0.00111390461115046
+ 4.42e-06 0.000968721374932026
+ 4.422e-06 0.000792257849601079
+ 4.424e-06 0.000761256589762322
+ 4.426e-06 0.000544682179519141
+ 4.428e-06 0.000320519345576761
+ 4.43e-06 0.000336549061087112
+ 4.432e-06 0.000534328389787264
+ 4.434e-06 0.000393047763611873
+ 4.436e-06 0.000545838317285582
+ 4.438e-06 0.000162647790700531
+ 4.44e-06 0.00026781851266286
+ 4.442e-06 0.000328011031548334
+ 4.444e-06 -6.51227803322929e-06
+ 4.446e-06 0.000184301333654099
+ 4.448e-06 0.000433358282546332
+ 4.45e-06 -6.36794998229243e-05
+ 4.452e-06 -5.67752994182322e-05
+ 4.454e-06 0.000174149589092982
+ 4.456e-06 0.000336328218699835
+ 4.458e-06 -9.44844578823255e-05
+ 4.46e-06 -0.000358471268294733
+ 4.462e-06 -0.000416837821029608
+ 4.464e-06 -0.000528978911747893
+ 4.466e-06 -0.00066150895119007
+ 4.468e-06 -0.000372716458872871
+ 4.47e-06 -0.000343480021396583
+ 4.472e-06 -0.000262057875295751
+ 4.474e-06 -0.00023051406173823
+ 4.476e-06 -0.000160722557862292
+ 4.478e-06 -1.35977427598832e-05
+ 4.48e-06 8.50150213706142e-05
+ 4.482e-06 9.72539532098845e-05
+ 4.484e-06 -0.000359473874177345
+ 4.486e-06 -0.000537394504290719
+ 4.488e-06 -0.000651546387412962
+ 4.49e-06 -0.000653198732172048
+ 4.492e-06 -0.000653468290007459
+ 4.494e-06 -0.000855529255853224
+ 4.496e-06 -0.000856723901444067
+ 4.498e-06 -0.000505518853105269
+ 4.5e-06 -0.000315731755984132
+ 4.502e-06 8.83940779754193e-05
+ 4.504e-06 0.000406907542409486
+ 4.506e-06 0.000261833381335193
+ 4.508e-06 0.000153676833936044
+ 4.51e-06 0.000298943445073926
+ 4.512e-06 0.000150135687129204
+ 4.514e-06 -0.00016172469267882
+ 4.516e-06 5.21790673333175e-05
+ 4.518e-06 -2.38322792422105e-05
+ 4.52e-06 -9.19082855256503e-05
+ 4.522e-06 -0.000158112444752257
+ 4.524e-06 -6.1931644140155e-05
+ 4.526e-06 -3.23731289043854e-05
+ 4.528e-06 -0.00047361793659009
+ 4.53e-06 -0.000113725782129374
+ 4.532e-06 -0.000242093560881279
+ 4.534e-06 -0.000585230122390922
+ 4.536e-06 -0.000445137548079779
+ 4.538e-06 -0.000231166745227684
+ 4.54e-06 -0.000261174831957968
+ 4.542e-06 -0.000148848668535937
+ 4.544e-06 -0.000231584455972668
+ 4.546e-06 -0.000129770904910784
+ 4.548e-06 -0.0001143794130997
+ 4.55e-06 -0.000285080233515637
+ 4.552e-06 -0.000514982406097619
+ 4.554e-06 -0.000683888072919031
+ 4.556e-06 -0.000665844381317294
+ 4.558e-06 -0.000921781287606666
+ 4.56e-06 -0.00109780888449549
+ 4.562e-06 -0.0011208983150073
+ 4.564e-06 -0.000756796764311935
+ 4.566e-06 -0.000647518523231088
+ 4.568e-06 -0.000850212213530018
+ 4.57e-06 -0.000973300269693114
+ 4.572e-06 -0.000925393214569819
+ 4.574e-06 -0.000855771073405778
+ 4.576e-06 -0.000881751084239054
+ 4.578e-06 -0.000857107252165177
+ 4.58e-06 -0.000880591356678224
+ 4.582e-06 -0.00103263546935648
+ 4.584e-06 -0.00120392744482533
+ 4.586e-06 -0.00115229627073805
+ 4.588e-06 -0.000993436987380618
+ 4.59e-06 -0.000892486137506517
+ 4.592e-06 -0.00107688334010808
+ 4.594e-06 -0.0010569640861056
+ 4.596e-06 -0.000939597670597452
+ 4.598e-06 -0.000830964104635481
+ 4.6e-06 -0.000988891566321569
+ 4.602e-06 -0.00108954540218665
+ 4.604e-06 -0.00122525670133794
+ 4.606e-06 -0.00107349160136489
+ 4.608e-06 -0.00150428354036008
+ 4.61e-06 -0.0017379560562718
+ 4.612e-06 -0.00187012098016843
+ 4.614e-06 -0.00193755087856301
+ 4.616e-06 -0.00216183674834375
+ 4.618e-06 -0.00261599371684224
+ 4.62e-06 -0.002070382463852
+ 4.622e-06 -0.00194470897655652
+ 4.624e-06 -0.00176415269420364
+ 4.626e-06 -0.00163602381918239
+ 4.628e-06 -0.00195890800935666
+ 4.63e-06 -0.00177168632255998
+ 4.632e-06 -0.0017636367670816
+ 4.634e-06 -0.00163124380209945
+ 4.636e-06 -0.00157976876523219
+ 4.638e-06 -0.00141081853147805
+ 4.64e-06 -0.00204466280767015
+ 4.642e-06 -0.00209741015680956
+ 4.644e-06 -0.00227476806202591
+ 4.646e-06 -0.00210790918517023
+ 4.648e-06 -0.00213261578409146
+ 4.65e-06 -0.00196984978295581
+ 4.652e-06 -0.00188623761921374
+ 4.654e-06 -0.00176030747344847
+ 4.656e-06 -0.00165753973336338
+ 4.658e-06 -0.00151089817963438
+ 4.66e-06 -0.00120785355625012
+ 4.662e-06 -0.00119492560836653
+ 4.664e-06 -0.00114781196815791
+ 4.666e-06 -0.00108592100334442
+ 4.668e-06 -0.000578353457158929
+ 4.67e-06 -0.00052591104488974
+ 4.672e-06 -0.000563769865983812
+ 4.674e-06 -0.000678760004599826
+ 4.676e-06 -0.000734142030612553
+ 4.678e-06 -0.000992533287037821
+ 4.68e-06 -0.00133089418700208
+ 4.682e-06 -0.00142660315225755
+ 4.684e-06 -0.00138723029823198
+ 4.686e-06 -0.0012151615757054
+ 4.688e-06 -0.00128995293088926
+ 4.69e-06 -0.00126311263503231
+ 4.692e-06 -0.0011653101406868
+ 4.694e-06 -0.00135487292998422
+ 4.696e-06 -0.000988097557574584
+ 4.698e-06 -0.000908962323384632
+ 4.7e-06 -0.00101882622986982
+ 4.702e-06 -0.000765837620098882
+ 4.704e-06 -0.000865007847697751
+ 4.706e-06 -0.000674047303274076
+ 4.708e-06 -0.000758898899932643
+ 4.71e-06 -0.000585193789108384
+ 4.712e-06 -0.000675805501361272
+ 4.714e-06 -0.000856199651533874
+ 4.716e-06 -0.000884047065739639
+ 4.718e-06 -0.000895333058765397
+ 4.72e-06 -0.00104445959710122
+ 4.722e-06 -0.000904855564784068
+ 4.724e-06 -0.000968701663055179
+ 4.726e-06 -0.00115007088508812
+ 4.728e-06 -0.00129842523664899
+ 4.73e-06 -0.00129185753323278
+ 4.732e-06 -0.00125544128007501
+ 4.734e-06 -0.00124640799903947
+ 4.736e-06 -0.00137222307525088
+ 4.738e-06 -0.0011373233934309
+ 4.74e-06 -0.0011532778328087
+ 4.742e-06 -0.00106367110225799
+ 4.744e-06 -0.000912981039926056
+ 4.746e-06 -0.000694040754829519
+ 4.748e-06 -0.000276065238623332
+ 4.75e-06 -0.000200896673644638
+ 4.752e-06 -0.00044723447874037
+ 4.754e-06 -0.000720044680936612
+ 4.756e-06 -0.000897673035333969
+ 4.758e-06 -0.00100622805443662
+ 4.76e-06 -0.000669089355617269
+ 4.762e-06 -0.00092164610834933
+ 4.764e-06 -0.00106306983699481
+ 4.766e-06 -0.00104352185123255
+ 4.768e-06 -0.00131588820861864
+ 4.77e-06 -0.00133270235071396
+ 4.772e-06 -0.0012117741388303
+ 4.774e-06 -0.000963764722701516
+ 4.776e-06 -0.000446759157940729
+ 4.778e-06 -0.000687316304239752
+ 4.78e-06 -0.000182759992531086
+ 4.782e-06 -0.000403876313025541
+ 4.784e-06 -0.000361553888634255
+ 4.786e-06 -0.000109987164124425
+ 4.788e-06 -0.000186834787286347
+ 4.79e-06 -0.000368031115119696
+ 4.792e-06 -0.000348687026141389
+ 4.794e-06 -0.00019382815894566
+ 4.796e-06 -8.8092334329544e-05
+ 4.798e-06 1.11064446411265e-05
+ 4.8e-06 -0.000160059827867586
+ 4.802e-06 6.98944791736587e-05
+ 4.804e-06 0.000163497160874919
+ 4.806e-06 0.000125347650086407
+ 4.808e-06 -0.000195433369310905
+ 4.81e-06 -0.000292743695527023
+ 4.812e-06 1.25548111601235e-05
+ 4.814e-06 0.000128704897496293
+ 4.816e-06 -0.000111725261295154
+ 4.818e-06 7.11047050281492e-05
+ 4.82e-06 5.59656638492291e-05
+ 4.822e-06 4.33970686661463e-05
+ 4.824e-06 0.000162114730217042
+ 4.826e-06 0.000238898128508037
+ 4.828e-06 0.000237968165581179
+ 4.83e-06 0.000378873634536187
+ 4.832e-06 0.000455646533476217
+ 4.834e-06 0.00035964626534714
+ 4.836e-06 0.000327386569032691
+ 4.838e-06 0.000299037462193465
+ 4.84e-06 0.000252268341488473
+ 4.842e-06 0.000322689646039954
+ 4.844e-06 0.000335935172337326
+ 4.846e-06 0.000210860313549158
+ 4.848e-06 0.00038953538363141
+ 4.85e-06 0.000230490812932666
+ 4.852e-06 0.000336368711473246
+ 4.854e-06 -0.000208805818983982
+ 4.856e-06 0.000238081317782359
+ 4.858e-06 5.44284800657352e-07
+ 4.86e-06 -0.00018316168862572
+ 4.862e-06 -0.000460060720730715
+ 4.864e-06 -0.000462556674650081
+ 4.866e-06 -0.000691597380678701
+ 4.868e-06 -0.00105980778482543
+ 4.87e-06 -0.00105288932682021
+ 4.872e-06 -0.00113495680309614
+ 4.874e-06 -0.00133093666456403
+ 4.876e-06 -0.0013536717869368
+ 4.878e-06 -0.00161511624536408
+ 4.88e-06 -0.00157845630093081
+ 4.882e-06 -0.0016260745001074
+ 4.884e-06 -0.00155776522948173
+ 4.886e-06 -0.00143247833932939
+ 4.888e-06 -0.000999993169255004
+ 4.89e-06 -0.000854650458202154
+ 4.892e-06 -0.000913409560924476
+ 4.894e-06 -0.00125181162488144
+ 4.896e-06 -0.00135173413686297
+ 4.898e-06 -0.00117779727776688
+ 4.9e-06 -0.000838801486522336
+ 4.902e-06 -0.000520691341982309
+ 4.904e-06 -0.000243886118022902
+ 4.906e-06 -0.000498156829817586
+ 4.908e-06 -0.000312778241472085
+ 4.91e-06 -8.49614357438111e-06
+ 4.912e-06 9.89186719598319e-05
+ 4.914e-06 7.85167607317778e-05
+ 4.916e-06 -9.40254858292973e-05
+ 4.918e-06 0.000184176266404809
+ 4.92e-06 0.000293503180546168
+ 4.922e-06 0.000130154784159686
+ 4.924e-06 0.000293758188902889
+ 4.926e-06 4.99611001909511e-05
+ 4.928e-06 0.000288270332990501
+ 4.93e-06 -7.2726377005954e-05
+ 4.932e-06 7.86098216250321e-05
+ 4.934e-06 0.000392987082753154
+ 4.936e-06 0.000381462494645004
+ 4.938e-06 0.000600430215244193
+ 4.94e-06 0.000763204848309437
+ 4.942e-06 0.00103426029232861
+ 4.944e-06 0.00120861637282653
+ 4.946e-06 0.00088784425963372
+ 4.948e-06 0.000872435238662845
+ 4.95e-06 0.000765795113835622
+ 4.952e-06 0.000711847243608648
+ 4.954e-06 0.000594795288403693
+ 4.956e-06 0.00057394107537799
+ 4.958e-06 0.000742675467327653
+ 4.96e-06 0.000571472761653219
+ 4.962e-06 0.000366278313551926
+ 4.964e-06 0.000687663157937126
+ 4.966e-06 0.000823856773513036
+ 4.968e-06 0.000619635174412759
+ 4.97e-06 0.000835709296702541
+ 4.972e-06 0.00105376149598342
+ 4.974e-06 0.00113497880117987
+ 4.976e-06 0.00116588698424788
+ 4.978e-06 0.00102692102098331
+ 4.98e-06 0.000707528684595389
+ 4.982e-06 0.000899234625767959
+ 4.984e-06 0.00116776994082839
+ 4.986e-06 0.00132909387833505
+ 4.988e-06 0.000875315281244479
+ 4.99e-06 0.00084267797692086
+ 4.992e-06 0.000670194625128066
+ 4.994e-06 0.000657795200302723
+ 4.996e-06 0.000766599050123383
+ 4.998e-06 0.00093086286002556
+ 5e-06 0.0012152885533716
+ 5.002e-06 0.00122537980222849
+ 5.004e-06 0.00099993151994854
+ 5.006e-06 0.000976210466532639
+ 5.008e-06 0.000560802605087871
+ 5.01e-06 0.000661450901329555
+ 5.012e-06 0.000442807386438444
+ 5.014e-06 0.000348755508368014
+ 5.016e-06 0.000297582985333197
+ 5.018e-06 0.000298974919828013
+ 5.02e-06 -0.000127637647671877
+ 5.022e-06 -0.000122789304291192
+ 5.024e-06 8.28296607653156e-05
+ 5.026e-06 -0.000206654368267196
+ 5.028e-06 -0.000404081966945115
+ 5.03e-06 -0.000911173232943425
+ 5.032e-06 -0.000984193885909794
+ 5.034e-06 -0.000958369049549879
+ 5.036e-06 -0.00115333092313634
+ 5.038e-06 -0.00128640072318303
+ 5.04e-06 -0.00136661073700745
+ 5.042e-06 -0.0012230087820895
+ 5.044e-06 -0.00160908553709956
+ 5.046e-06 -0.00149532916442175
+ 5.048e-06 -0.00116518592966259
+ 5.05e-06 -0.000782651319569182
+ 5.052e-06 -0.00113387050564138
+ 5.054e-06 -0.00148967897484816
+ 5.056e-06 -0.00148514594236944
+ 5.058e-06 -0.00158963459692383
+ 5.06e-06 -0.00152535434323283
+ 5.062e-06 -0.00163544909732716
+ 5.064e-06 -0.00169987726090519
+ 5.066e-06 -0.00178640925555597
+ 5.068e-06 -0.00176874321162158
+ 5.07e-06 -0.00195447691209286
+ 5.072e-06 -0.00196616599571944
+ 5.074e-06 -0.00173522280942201
+ 5.076e-06 -0.001614940176669
+ 5.078e-06 -0.00147742019453658
+ 5.08e-06 -0.00144169062804937
+ 5.082e-06 -0.00149536018837758
+ 5.084e-06 -0.0016390412575663
+ 5.086e-06 -0.0019278877346305
+ 5.088e-06 -0.00154196977215786
+ 5.09e-06 -0.00166161693438909
+ 5.092e-06 -0.00203608251330849
+ 5.094e-06 -0.00220379231411278
+ 5.096e-06 -0.00217897343585528
+ 5.098e-06 -0.00200131602076182
+ 5.1e-06 -0.00248489116994016
+ 5.102e-06 -0.00227284895106417
+ 5.104e-06 -0.00242944527902127
+ 5.106e-06 -0.00239790424402567
+ 5.108e-06 -0.0024531314151925
+ 5.11e-06 -0.00201731879841531
+ 5.112e-06 -0.00241314828170431
+ 5.114e-06 -0.00213070422021511
+ 5.116e-06 -0.00173158993907968
+ 5.118e-06 -0.0019751358653182
+ 5.12e-06 -0.0020009364384422
+ 5.122e-06 -0.00248015377595565
+ 5.124e-06 -0.00267335595907411
+ 5.126e-06 -0.00255314441482921
+ 5.128e-06 -0.00242109326995936
+ 5.13e-06 -0.00246397841514679
+ 5.132e-06 -0.00230759041366857
+ 5.134e-06 -0.00234298598538642
+ 5.136e-06 -0.00238932128535699
+ 5.138e-06 -0.00243368196623862
+ 5.14e-06 -0.00270847839637351
+ 5.142e-06 -0.0025812603412903
+ 5.144e-06 -0.00247930146756319
+ 5.146e-06 -0.00252973421528384
+ 5.148e-06 -0.00210023671660964
+ 5.15e-06 -0.00166897111013046
+ 5.152e-06 -0.00157209866034066
+ 5.154e-06 -0.00107614500558898
+ 5.156e-06 -0.000852022293572619
+ 5.158e-06 -0.000603957541720685
+ 5.16e-06 -0.000761389390819784
+ 5.162e-06 -0.000783092242573172
+ 5.164e-06 -0.000426493797817053
+ 5.166e-06 -0.00035006421906703
+ 5.168e-06 -0.000402431007784361
+ 5.17e-06 -0.00051320508959992
+ 5.172e-06 -0.000527960560404666
+ 5.174e-06 -0.000875748293872836
+ 5.176e-06 -0.00098258014376012
+ 5.178e-06 -0.000948211415428022
+ 5.18e-06 -0.000900980899094736
+ 5.182e-06 -0.000390116451791439
+ 5.184e-06 -0.000568246603481547
+ 5.186e-06 -0.000568451804078353
+ 5.188e-06 -0.000527870724836826
+ 5.19e-06 -0.000643072827782757
+ 5.192e-06 -0.00103772711917984
+ 5.194e-06 -0.000909216505624542
+ 5.196e-06 -0.00112337182072175
+ 5.198e-06 -0.000775035748371294
+ 5.2e-06 -0.000739727624097012
+ 5.202e-06 -0.000563649615419625
+ 5.204e-06 -0.000563060520072218
+ 5.206e-06 -0.000688975574489757
+ 5.208e-06 -0.000543470744972451
+ 5.21e-06 7.13406822378733e-05
+ 5.212e-06 0.000500853210615622
+ 5.214e-06 0.000685287497645962
+ 5.216e-06 0.000611979095415276
+ 5.218e-06 0.000596907991463573
+ 5.22e-06 0.000771439842890065
+ 5.222e-06 0.000790115912622866
+ 5.224e-06 0.000472686782272675
+ 5.226e-06 0.000678257310744608
+ 5.228e-06 0.00045848406962422
+ 5.23e-06 0.000161262242638795
+ 5.232e-06 -9.70146729589881e-05
+ 5.234e-06 -0.000176143769129072
+ 5.236e-06 0.000269017537617832
+ 5.238e-06 0.000297158354116133
+ 5.24e-06 0.000261534538893719
+ 5.242e-06 0.000215774963880759
+ 5.244e-06 0.000185754603881593
+ 5.246e-06 0.000310771601641456
+ 5.248e-06 0.000333066982268798
+ 5.25e-06 0.000145782712017293
+ 5.252e-06 0.000266022316531813
+ 5.254e-06 0.00046767020731208
+ 5.256e-06 0.000337417635444941
+ 5.258e-06 0.000481278959729839
+ 5.26e-06 0.000652629317468947
+ 5.262e-06 0.000711116081247169
+ 5.264e-06 0.00105651142851799
+ 5.266e-06 0.00114889200870698
+ 5.268e-06 0.00135735572937216
+ 5.27e-06 0.00111438906515311
+ 5.272e-06 0.00101163285072325
+ 5.274e-06 0.000790152813654019
+ 5.276e-06 0.00078370620800375
+ 5.278e-06 0.00074664164087041
+ 5.28e-06 0.000912387558294006
+ 5.282e-06 0.00103028953343109
+ 5.284e-06 0.00118913919746684
+ 5.286e-06 0.00115507205457122
+ 5.288e-06 0.00101146795555217
+ 5.29e-06 0.00105934019390589
+ 5.292e-06 0.00116392201204526
+ 5.294e-06 0.000904268068821782
+ 5.296e-06 0.000833021832772862
+ 5.298e-06 0.000589054532616362
+ 5.3e-06 0.000557959756496196
+ 5.302e-06 0.00018698634995421
+ 5.304e-06 -0.000123118982024105
+ 5.306e-06 -0.000124756136404637
+ 5.308e-06 -0.000220451635839417
+ 5.31e-06 -0.000199956040656443
+ 5.312e-06 -0.000120934059511327
+ 5.314e-06 2.4523171338058e-05
+ 5.316e-06 0.000121722983156004
+ 5.318e-06 0.000310827842679195
+ 5.32e-06 0.000338436549461674
+ 5.322e-06 0.000319545816526691
+ 5.324e-06 9.36905822077256e-05
+ 5.326e-06 0.000318378969648602
+ 5.328e-06 0.000408696423470247
+ 5.33e-06 0.000288145314666438
+ 5.332e-06 0.000479449646832383
+ 5.334e-06 0.000305551606175607
+ 5.336e-06 0.000214151098866819
+ 5.338e-06 -5.76253084248421e-05
+ 5.34e-06 0.000192728839470241
+ 5.342e-06 -0.000210223976866917
+ 5.344e-06 -0.000377952592377089
+ 5.346e-06 -0.000589119786421241
+ 5.348e-06 -0.000566334288418426
+ 5.35e-06 -0.0005523800624181
+ 5.352e-06 -0.000239220418639685
+ 5.354e-06 -0.000179494367962181
+ 5.356e-06 -0.000103424768561429
+ 5.358e-06 -0.000201171448408843
+ 5.36e-06 -0.000285389989547666
+ 5.362e-06 -0.000159637892367115
+ 5.364e-06 -0.000391080119466713
+ 5.366e-06 1.12447851424936e-05
+ 5.368e-06 0.000253145070415765
+ 5.37e-06 0.000215589924307734
+ 5.372e-06 0.000536057638659962
+ 5.374e-06 -1.37215394144341e-06
+ 5.376e-06 -4.6740607308298e-05
+ 5.378e-06 -8.02749597717536e-05
+ 5.38e-06 -0.000249530202598868
+ 5.382e-06 -0.000160588554311358
+ 5.384e-06 1.66552459888821e-05
+ 5.386e-06 0.000191058344559479
+ 5.388e-06 0.00026205143937686
+ 5.39e-06 0.000415115644750557
+ 5.392e-06 0.000359411498211886
+ 5.394e-06 0.000287491330655045
+ 5.396e-06 0.000331951018091356
+ 5.398e-06 0.000555106500264204
+ 5.4e-06 0.000751358202595493
+ 5.402e-06 0.000828809001485671
+ 5.404e-06 0.00108170402617612
+ 5.406e-06 0.00127513433424996
+ 5.408e-06 0.00116600055002226
+ 5.41e-06 0.00142225940888782
+ 5.412e-06 0.0011507794763423
+ 5.414e-06 0.00120406174633989
+ 5.416e-06 0.00106359363223592
+ 5.418e-06 0.000936724832291724
+ 5.42e-06 0.00152004317056591
+ 5.422e-06 0.00211318785002259
+ 5.424e-06 0.00206197452996587
+ 5.426e-06 0.00223063529925859
+ 5.428e-06 0.00205608862315603
+ 5.43e-06 0.00244181508238445
+ 5.432e-06 0.00230518432412739
+ 5.434e-06 0.00208896224817146
+ 5.436e-06 0.0022622881408743
+ 5.438e-06 0.00196406919813105
+ 5.44e-06 0.00220007172646659
+ 5.442e-06 0.00208047399258019
+ 5.444e-06 0.00218098140486006
+ 5.446e-06 0.00198570014430613
+ 5.448e-06 0.00183024308304717
+ 5.45e-06 0.00176635039975263
+ 5.452e-06 0.00165884594637457
+ 5.454e-06 0.00144480033229704
+ 5.456e-06 0.00125179958013891
+ 5.458e-06 0.00125657443211494
+ 5.46e-06 0.00135014045115495
+ 5.462e-06 0.00128836949811262
+ 5.464e-06 0.00121298859106865
+ 5.466e-06 0.000939495487214199
+ 5.468e-06 0.00121212218023796
+ 5.47e-06 0.00135201455418569
+ 5.472e-06 0.00124465367378391
+ 5.474e-06 0.00101880760463144
+ 5.476e-06 0.00117461888039906
+ 5.478e-06 0.00131704817615313
+ 5.48e-06 0.000975915237051698
+ 5.482e-06 0.000617028435356308
+ 5.484e-06 0.000303031494038007
+ 5.486e-06 0.000549419449690759
+ 5.488e-06 0.000345630170849406
+ 5.49e-06 0.000335842566408111
+ 5.492e-06 0.000503264643435818
+ 5.494e-06 0.000341610959591496
+ 5.496e-06 6.76754778433621e-05
+ 5.498e-06 0.000329417979232334
+ 5.5e-06 0.000320598605061588
+ 5.502e-06 0.000195946361698181
+ 5.504e-06 6.36812470433073e-05
+ 5.506e-06 9.43455583578519e-05
+ 5.508e-06 4.19981556915477e-06
+ 5.51e-06 0.000383374560541414
+ 5.512e-06 0.000584149445319135
+ 5.514e-06 0.000553860758191431
+ 5.516e-06 0.000471226776725188
+ 5.518e-06 0.000285608418231309
+ 5.52e-06 0.000285444101743818
+ 5.522e-06 0.000428645892399683
+ 5.524e-06 0.000622266366368818
+ 5.526e-06 0.000647515573776899
+ 5.528e-06 0.00084383287171451
+ 5.53e-06 0.00105298133153884
+ 5.532e-06 0.000739593163566131
+ 5.534e-06 0.000775032952370814
+ 5.536e-06 0.00107284378332879
+ 5.538e-06 0.001030348146211
+ 5.54e-06 0.00106573498412694
+ 5.542e-06 0.00106365575909414
+ 5.544e-06 0.00115309572665075
+ 5.546e-06 0.00111159884264626
+ 5.548e-06 0.000941822108933581
+ 5.55e-06 0.000668340149617727
+ 5.552e-06 0.000439713764403009
+ 5.554e-06 0.000190327927385381
+ 5.556e-06 2.98103949283202e-06
+ 5.558e-06 0.000252996387831799
+ 5.56e-06 0.000421637176388683
+ 5.562e-06 0.000352155739939526
+ 5.564e-06 0.00088551883408485
+ 5.566e-06 0.00109864677777881
+ 5.568e-06 0.00100671809943868
+ 5.57e-06 0.000730846445493271
+ 5.572e-06 0.000478212413780775
+ 5.574e-06 0.000421010087014669
+ 5.576e-06 0.000408778499054142
+ 5.578e-06 0.000381715441796546
+ 5.58e-06 0.00012019645445596
+ 5.582e-06 0.00010479213881741
+ 5.584e-06 0.000342387837756992
+ 5.586e-06 0.000328235134243135
+ 5.588e-06 0.000478975521549592
+ 5.59e-06 0.00048208012939694
+ 5.592e-06 0.000488855697233762
+ 5.594e-06 0.000262446979966418
+ 5.596e-06 0.000346872519894551
+ 5.598e-06 0.000391374411353509
+ 5.6e-06 0.000214632981741414
+ 5.602e-06 7.11408111420661e-05
+ 5.604e-06 0.000145100429557976
+ 5.606e-06 0.000160686126944272
+ 5.608e-06 0.000113575604528602
+ 5.61e-06 6.05970280020816e-05
+ 5.612e-06 0.000162271405578717
+ 5.614e-06 0.000344888804294037
+ 5.616e-06 0.000492791840346751
+ 5.618e-06 0.000823945746947457
+ 5.62e-06 0.000857573751745825
+ 5.622e-06 0.000980399561482744
+ 5.624e-06 0.000756917756564328
+ 5.626e-06 0.000876535135101367
+ 5.628e-06 0.0011235748334905
+ 5.63e-06 0.000905860514184963
+ 5.632e-06 0.000609821112640652
+ 5.634e-06 0.000529535620023862
+ 5.636e-06 0.000366682777227388
+ 5.638e-06 0.000508695389235171
+ 5.64e-06 0.000848131803679642
+ 5.642e-06 0.000829964836330138
+ 5.644e-06 0.00095638401135195
+ 5.646e-06 0.000817386897462993
+ 5.648e-06 0.000895082708232003
+ 5.65e-06 0.000834825294089946
+ 5.652e-06 0.000853137050105456
+ 5.654e-06 0.000852689765834663
+ 5.656e-06 0.000719477204975647
+ 5.658e-06 0.000823307320266275
+ 5.66e-06 0.000703119660043153
+ 5.662e-06 0.000958328928212287
+ 5.664e-06 0.00089598872761024
+ 5.666e-06 0.000664185217750367
+ 5.668e-06 0.000774851600000078
+ 5.67e-06 0.000834412031566239
+ 5.672e-06 0.000909572097410507
+ 5.674e-06 0.00091689802629604
+ 5.676e-06 0.000819645454644946
+ 5.678e-06 0.000670700619229408
+ 5.68e-06 0.000846527360574429
+ 5.682e-06 0.00102197148731951
+ 5.684e-06 0.000767668841974218
+ 5.686e-06 0.000809463477567227
+ 5.688e-06 0.00119560372428347
+ 5.69e-06 0.00139974978433229
+ 5.692e-06 0.000994555750832851
+ 5.694e-06 0.000983232783432572
+ 5.696e-06 0.000888947747298003
+ 5.698e-06 0.00107166199189857
+ 5.7e-06 0.00132040034763595
+ 5.702e-06 0.00148910967693367
+ 5.704e-06 0.0016076361936716
+ 5.706e-06 0.00165451591550398
+ 5.708e-06 0.00158500081025904
+ 5.71e-06 0.00137994704604101
+ 5.712e-06 0.00106885204462103
+ 5.714e-06 0.00126833988847247
+ 5.716e-06 0.00124452574745914
+ 5.718e-06 0.000981264612306357
+ 5.72e-06 0.000731513071654397
+ 5.722e-06 0.00044199049134694
+ 5.724e-06 0.000313742799966704
+ 5.726e-06 0.000554406084706922
+ 5.728e-06 0.000574874020149349
+ 5.73e-06 0.000283223229363247
+ 5.732e-06 0.00027779916327942
+ 5.734e-06 0.000613721051847183
+ 5.736e-06 0.000739223578592297
+ 5.738e-06 0.00057117761917913
+ 5.74e-06 0.000668473537399839
+ 5.742e-06 0.000743386362860201
+ 5.744e-06 0.000753127601142881
+ 5.746e-06 0.000819399006749704
+ 5.748e-06 0.000779974289560887
+ 5.75e-06 0.000960278802570071
+ 5.752e-06 0.00092471093428721
+ 5.754e-06 0.000682005971229948
+ 5.756e-06 0.000730672896761669
+ 5.758e-06 0.000714769813622863
+ 5.76e-06 0.000632515349509002
+ 5.762e-06 0.000471954241011072
+ 5.764e-06 0.000708403089291481
+ 5.766e-06 0.000430819785469857
+ 5.768e-06 0.000308015487740993
+ 5.77e-06 0.000545019824146422
+ 5.772e-06 0.000516542268125691
+ 5.774e-06 0.000304059077819899
+ 5.776e-06 0.000137254012088583
+ 5.778e-06 0.000232282851951062
+ 5.78e-06 0.000324614507138904
+ 5.782e-06 0.000120639979606167
+ 5.784e-06 4.46328906723185e-05
+ 5.786e-06 -0.000243477838938455
+ 5.788e-06 -0.000481524014301432
+ 5.79e-06 -0.000704987487772145
+ 5.792e-06 -0.000441856025791248
+ 5.794e-06 -0.000412402309463153
+ 5.796e-06 -0.000622601952656177
+ 5.798e-06 -0.000716214537108343
+ 5.8e-06 -0.000858035669611924
+ 5.802e-06 -0.000744101519860906
+ 5.804e-06 -0.000526980129759774
+ 5.806e-06 -0.000677536378595179
+ 5.808e-06 -0.000613183294328468
+ 5.81e-06 -0.000546903179501455
+ 5.812e-06 -0.000370853804226004
+ 5.814e-06 -0.000650710363609985
+ 5.816e-06 -0.000727347429130739
+ 5.818e-06 -0.000442105217641011
+ 5.82e-06 -0.000403621826465223
+ 5.822e-06 -0.000668664202439052
+ 5.824e-06 -0.00040350506972078
+ 5.826e-06 -0.000516588968619645
+ 5.828e-06 -0.000396501659221423
+ 5.83e-06 -0.000385198609550745
+ 5.832e-06 -0.000541017595802381
+ 5.834e-06 -0.000384942119601846
+ 5.836e-06 0.000150762918369961
+ 5.838e-06 -0.000185799718159231
+ 5.84e-06 -0.000150416534495795
+ 5.842e-06 -0.000285777610877612
+ 5.844e-06 -0.000348301565969506
+ 5.846e-06 -0.000156337595747319
+ 5.848e-06 -0.000528720309985192
+ 5.85e-06 -0.000338360205871722
+ 5.852e-06 -0.000388665945087307
+ 5.854e-06 -5.06756458183352e-05
+ 5.856e-06 -5.99028789485645e-05
+ 5.858e-06 0.000160047645211456
+ 5.86e-06 0.000537625329623747
+ 5.862e-06 0.000668917315358964
+ 5.864e-06 0.000731344903307139
+ 5.866e-06 0.000593744769626146
+ 5.868e-06 0.000137289907057412
+ 5.87e-06 0.000253201910824124
+ 5.872e-06 0.000386743063207498
+ 5.874e-06 0.00038052801529454
+ 5.876e-06 0.000425433689469372
+ 5.878e-06 0.000180255386062553
+ 5.88e-06 0.000403383228351705
+ 5.882e-06 0.000639164572881276
+ 5.884e-06 0.000544441838365533
+ 5.886e-06 0.000700817762139176
+ 5.888e-06 0.000632719121559563
+ 5.89e-06 0.000679551598243273
+ 5.892e-06 0.000562966160782952
+ 5.894e-06 0.000336823110814915
+ 5.896e-06 0.000431173266626426
+ 5.898e-06 0.00052509456695336
+ 5.9e-06 0.00049926555319141
+ 5.902e-06 0.000341924613793378
+ 5.904e-06 0.000541115382414294
+ 5.906e-06 0.000620190359565411
+ 5.908e-06 0.000408244091693211
+ 5.91e-06 0.000754974168573156
+ 5.912e-06 0.000988719456755642
+ 5.914e-06 0.000934266253430182
+ 5.916e-06 0.000844974658785844
+ 5.918e-06 0.000678122012135099
+ 5.92e-06 0.000464667249411226
+ 5.922e-06 0.000724422611649169
+ 5.924e-06 0.000856787032415308
+ 5.926e-06 0.000962461558077006
+ 5.928e-06 0.000480312980140481
+ 5.93e-06 0.000488394230787686
+ 5.932e-06 0.000293675793503299
+ 5.934e-06 0.000345626092003076
+ 5.936e-06 0.000126559950745432
+ 5.938e-06 -0.000117277386915399
+ 5.94e-06 -0.000400431621609631
+ 5.942e-06 -0.000503642407143991
+ 5.944e-06 -0.00066371956110158
+ 5.946e-06 -0.000507424958527942
+ 5.948e-06 -0.000622900450955712
+ 5.95e-06 -0.000788937436570778
+ 5.952e-06 -0.000903751117419227
+ 5.954e-06 -0.000937786502782467
+ 5.956e-06 -0.000826223565311853
+ 5.958e-06 -0.000854749462769019
+ 5.96e-06 -0.000846259427133149
+ 5.962e-06 -0.000925164161094898
+ 5.964e-06 -0.000742639358669615
+ 5.966e-06 -0.000855603823426687
+ 5.968e-06 -0.00073335015229169
+ 5.97e-06 -0.00065853300302284
+ 5.972e-06 -0.000699157945414334
+ 5.974e-06 -0.000683751738196473
+ 5.976e-06 -0.000990219895644362
+ 5.978e-06 -0.000953898983882554
+ 5.98e-06 -0.00115132450907711
+ 5.982e-06 -0.00130435479935541
+ 5.984e-06 -0.00117369647112796
+ 5.986e-06 -0.000997838360531674
+ 5.988e-06 -0.000962155951617851
+ 5.99e-06 -0.00108451579263522
+ 5.992e-06 -0.00122623292334909
+ 5.994e-06 -0.000957841413185047
+ 5.996e-06 -0.000710033710430901
+ 5.998e-06 -0.000910265532992247
+ 6e-06 -0.000791595679463209
+ 6.002e-06 -0.000456030217641604
+ 6.004e-06 -0.000385376551839443
+ 6.006e-06 -0.00046575153329526
+ 6.008e-06 -5.94441107039205e-05
+ 6.01e-06 0.000354478345249571
+ 6.012e-06 0.000263457005174865
+ 6.014e-06 0.000107016733805168
+ 6.016e-06 -3.30064194758569e-05
+ 6.018e-06 3.76896867861297e-05
+ 6.02e-06 5.1148771153653e-05
+ 6.022e-06 5.33487259462987e-05
+ 6.024e-06 8.49270869505854e-06
+ 6.026e-06 -5.76973454963899e-05
+ 6.028e-06 0.000169452045096712
+ 6.03e-06 -0.000199835602333566
+ 6.032e-06 -0.000328698658127537
+ 6.034e-06 -5.5326737039174e-05
+ 6.036e-06 0.000255549669088234
+ 6.038e-06 0.000141003920279794
+ 6.04e-06 -7.4192000090966e-06
+ 6.042e-06 -7.59096434151869e-05
+ 6.044e-06 0.000191728677819288
+ 6.046e-06 6.49139416259714e-05
+ 6.048e-06 4.50448455821435e-05
+ 6.05e-06 -0.000193601244076182
+ 6.052e-06 -0.000324579379863096
+ 6.054e-06 -9.29206510162556e-05
+ 6.056e-06 -7.27265051849234e-05
+ 6.058e-06 -0.00027717608962823
+ 6.06e-06 -8.23095984050878e-05
+ 6.062e-06 -0.000498248220806744
+ 6.064e-06 -0.000543985793418472
+ 6.066e-06 -0.000697747519367221
+ 6.068e-06 -0.000644443506905037
+ 6.07e-06 -0.000667396585047676
+ 6.072e-06 -0.000499795036635331
+ 6.074e-06 -0.000172805981356738
+ 6.076e-06 -0.000393728975521902
+ 6.078e-06 -0.000392377985997147
+ 6.08e-06 -0.000502562324323084
+ 6.082e-06 -0.0003613985158196
+ 6.084e-06 -0.000482554790037336
+ 6.086e-06 -0.000413463589017069
+ 6.088e-06 -7.78500258528157e-05
+ 6.09e-06 -0.000193646935163801
+ 6.092e-06 5.40483078256449e-05
+ 6.094e-06 -0.000246899417285117
+ 6.096e-06 -0.000560266202739653
+ 6.098e-06 -0.000491023107026673
+ 6.1e-06 -0.000448233528477158
+ 6.102e-06 -0.000217933521847688
+ 6.104e-06 -0.000214228921260607
+ 6.106e-06 4.36275196105647e-05
+ 6.108e-06 6.33878316356891e-05
+ 6.11e-06 -3.03796667339767e-05
+ 6.112e-06 6.71942085748042e-05
+ 6.114e-06 8.15072245623171e-05
+ 6.116e-06 6.43821436414315e-05
+ 6.118e-06 2.12495125922671e-06
+ 6.12e-06 -6.57945253924135e-05
+ 6.122e-06 -0.000161031166612832
+ 6.124e-06 -0.000308037588242459
+ 6.126e-06 -0.000332545325120306
+ 6.128e-06 -0.000422893600120684
+ 6.13e-06 -0.00092560015170862
+ 6.132e-06 -0.000867639233362822
+ 6.134e-06 -0.000864577276188578
+ 6.136e-06 -0.00108448223834142
+ 6.138e-06 -0.00102577405881558
+ 6.14e-06 -0.00100009717897294
+ 6.142e-06 -0.000809380015582223
+ 6.144e-06 -0.00100825302245886
+ 6.146e-06 -0.000885275777067174
+ 6.148e-06 -0.000752008863273745
+ 6.15e-06 -0.00121847416458534
+ 6.152e-06 -0.0012413362440721
+ 6.154e-06 -0.000949735012416225
+ 6.156e-06 -0.000931680193890061
+ 6.158e-06 -0.000649215267629714
+ 6.16e-06 -0.000698394175763472
+ 6.162e-06 -0.000482716949452335
+ 6.164e-06 -0.000179747219781838
+ 6.166e-06 -0.000160231868237722
+ 6.168e-06 -0.00021026330117648
+ 6.17e-06 -0.000186829070307272
+ 6.172e-06 -0.000139914132219601
+ 6.174e-06 -0.000347655095905652
+ 6.176e-06 -0.000792898584484297
+ 6.178e-06 -0.00104092718817833
+ 6.18e-06 -0.000800837943400619
+ 6.182e-06 -0.000839386316013246
+ 6.184e-06 -0.00098456763860561
+ 6.186e-06 -0.000963041651208422
+ 6.188e-06 -0.000997162213843169
+ 6.19e-06 -0.000818732386654779
+ 6.192e-06 -0.00093174256830352
+ 6.194e-06 -0.000565777936060373
+ 6.196e-06 -0.000263334190418534
+ 6.198e-06 -0.000279784671243498
+ 6.2e-06 -0.000214891691278194
+ 6.202e-06 -0.000240713071529775
+ 6.204e-06 8.83477745024616e-05
+ 6.206e-06 9.98298719214744e-05
+ 6.208e-06 0.000177033154105571
+ 6.21e-06 5.05915869890136e-05
+ 6.212e-06 -1.08017916842143e-05
+ 6.214e-06 -0.000137672773937643
+ 6.216e-06 -0.000243703060193228
+ 6.218e-06 -0.000241688393391388
+ 6.22e-06 -0.00033299365123556
+ 6.222e-06 -5.15117354607648e-05
+ 6.224e-06 -6.58047045142253e-05
+ 6.226e-06 -0.000125950445921586
+ 6.228e-06 -0.000167483302331578
+ 6.23e-06 -0.000270403007954047
+ 6.232e-06 -0.000728416567735876
+ 6.234e-06 -0.000959752538292091
+ 6.236e-06 -0.00119327788655574
+ 6.238e-06 -0.00108738871881492
+ 6.24e-06 -0.000921246442219528
+ 6.242e-06 -0.000747138186005771
+ 6.244e-06 -0.000797103910786728
+ 6.246e-06 -0.000867271782710591
+ 6.248e-06 -0.000845201054679127
+ 6.25e-06 -0.00101672963034853
+ 6.252e-06 -0.000970695147412758
+ 6.254e-06 -0.00089795127787397
+ 6.256e-06 -0.000871550643788492
+ 6.258e-06 -0.000935823882157301
+ 6.26e-06 -0.000760790616966839
+ 6.262e-06 -0.00063483498586412
+ 6.264e-06 -0.000352589813445726
+ 6.266e-06 8.15032708557734e-05
+ 6.268e-06 -7.01330729138874e-05
+ 6.27e-06 -0.000340122272598107
+ 6.272e-06 -0.000707261114549806
+ 6.274e-06 -0.000995470607834832
+ 6.276e-06 -0.000812299739865163
+ 6.278e-06 -0.000649644836621604
+ 6.28e-06 -0.000782316385479551
+ 6.282e-06 -0.000672852922818255
+ 6.284e-06 -0.000557672128080069
+ 6.286e-06 -0.000422852443318344
+ 6.288e-06 -0.000417500176770501
+ 6.29e-06 -0.000724319183564081
+ 6.292e-06 -0.000750858034227903
+ 6.294e-06 -0.000612231740557869
+ 6.296e-06 -0.000826432191227202
+ 6.298e-06 -0.000767517623222548
+ 6.3e-06 -0.00063419585488209
+ 6.302e-06 -0.00065743323166207
+ 6.304e-06 -0.000863473447975383
+ 6.306e-06 -0.000954252603013223
+ 6.308e-06 -0.000911633899397707
+ 6.31e-06 -0.00138364695031059
+ 6.312e-06 -0.00121461229662994
+ 6.314e-06 -0.000885169060077745
+ 6.316e-06 -0.0010209583223777
+ 6.318e-06 -0.00113860728851255
+ 6.32e-06 -0.00106925372300481
+ 6.322e-06 -0.00104310108604649
+ 6.324e-06 -0.000928967325374776
+ 6.326e-06 -0.0012298432398755
+ 6.328e-06 -0.00124117047903448
+ 6.33e-06 -0.000754989272860941
+ 6.332e-06 -0.000834139935595054
+ 6.334e-06 -0.000941405559366723
+ 6.336e-06 -0.00107727300859931
+ 6.338e-06 -0.000828454207957583
+ 6.34e-06 -0.000629745853622342
+ 6.342e-06 -0.000880799373974974
+ 6.344e-06 -0.000876382736093284
+ 6.346e-06 -0.000917098811372822
+ 6.348e-06 -0.000881544974275828
+ 6.35e-06 -0.00130101089372997
+ 6.352e-06 -0.00156992747867404
+ 6.354e-06 -0.00107755069148042
+ 6.356e-06 -0.00114156527127731
+ 6.358e-06 -0.00140817402192078
+ 6.36e-06 -0.00130527949285234
+ 6.362e-06 -0.00125585544284471
+ 6.364e-06 -0.00165062937090592
+ 6.366e-06 -0.00155498746658671
+ 6.368e-06 -0.00153687545091419
+ 6.37e-06 -0.00144061615978181
+ 6.372e-06 -0.00124672341425498
+ 6.374e-06 -0.00108180914600219
+ 6.376e-06 -0.00093702097262032
+ 6.378e-06 -0.000897808771910704
+ 6.38e-06 -0.00105219798294265
+ 6.382e-06 -0.00106146562429486
+ 6.384e-06 -0.0010068461605225
+ 6.386e-06 -0.000883369625547568
+ 6.388e-06 -0.00104080115591385
+ 6.39e-06 -0.000633012350542351
+ 6.392e-06 -0.000362094362666497
+ 6.394e-06 -0.000512774439797051
+ 6.396e-06 -0.000793586785391369
+ 6.398e-06 -0.000650198261571165
+ 6.4e-06 -0.000673612402234599
+ 6.402e-06 -0.000645062743282821
+ 6.404e-06 -0.000854488434402558
+ 6.406e-06 -0.000475046349008014
+ 6.408e-06 -0.00030270473841113
+ 6.41e-06 -0.000560882420431051
+ 6.412e-06 -0.000799879859978255
+ 6.414e-06 -0.000819505612072869
+ 6.416e-06 -0.0007960972663468
+ 6.418e-06 -0.00057327704738599
+ 6.42e-06 -0.000666141659721656
+ 6.422e-06 -0.000434760957865954
+ 6.424e-06 -6.31498612482017e-05
+ 6.426e-06 -0.000277131059407694
+ 6.428e-06 -0.000147651282215018
+ 6.43e-06 -0.000474693628252149
+ 6.432e-06 -0.000605649044785325
+ 6.434e-06 -0.000623479266897167
+ 6.436e-06 -0.000554185547825895
+ 6.438e-06 -0.000404824199885224
+ 6.44e-06 -0.00050483002692943
+ 6.442e-06 -0.000694642896369098
+ 6.444e-06 -0.000857461876855141
+ 6.446e-06 -0.000924251292287373
+ 6.448e-06 -0.000758136651397801
+ 6.45e-06 -0.000965970349748056
+ 6.452e-06 -0.000870565266691021
+ 6.454e-06 -0.00076418982496925
+ 6.456e-06 -0.000846753434859984
+ 6.458e-06 -0.00054157801692333
+ 6.46e-06 -0.000639493946337363
+ 6.462e-06 -0.000489220086560467
+ 6.464e-06 -0.000405934617942859
+ 6.466e-06 -0.000549423373763565
+ 6.468e-06 -0.000441338509224085
+ 6.47e-06 -0.000351013971463813
+ 6.472e-06 -9.60280198203897e-05
+ 6.474e-06 -0.000123036273652581
+ 6.476e-06 -7.18810890175606e-05
+ 6.478e-06 0.000105872167074936
+ 6.48e-06 -5.15879869369049e-05
+ 6.482e-06 -9.61351309379098e-05
+ 6.484e-06 -0.00010614530877843
+ 6.486e-06 -8.72139410429499e-05
+ 6.488e-06 -0.000117749923330147
+ 6.49e-06 -0.000262407942929738
+ 6.492e-06 -0.0001903183204118
+ 6.494e-06 -0.000410615659162547
+ 6.496e-06 -0.000427268983690244
+ 6.498e-06 -0.000126690368266206
+ 6.5e-06 0.000146452335530858
+ 6.502e-06 0.000228605151465899
+ 6.504e-06 1.12079354621057e-05
+ 6.506e-06 -0.000172967662438355
+ 6.508e-06 -0.000133295503565265
+ 6.51e-06 -0.000128294948193981
+ 6.512e-06 -0.000159286775953287
+ 6.514e-06 3.25760457182115e-05
+ 6.516e-06 -7.53598255678494e-05
+ 6.518e-06 0.000294886429530131
+ 6.52e-06 0.000470716274140213
+ 6.522e-06 0.00050522580830184
+ 6.524e-06 0.000427859369637304
+ 6.526e-06 0.000214456732961617
+ 6.528e-06 0.000499961767820681
+ 6.53e-06 0.000684601267262218
+ 6.532e-06 0.000803757700608486
+ 6.534e-06 0.000773118861117318
+ 6.536e-06 0.000539876229140454
+ 6.538e-06 7.56063979524342e-05
+ 6.54e-06 0.000323990921943233
+ 6.542e-06 3.56915232029311e-05
+ 6.544e-06 2.51670297604332e-06
+ 6.546e-06 -0.000137224782264333
+ 6.548e-06 0.000167679421426687
+ 6.55e-06 -0.000247445424348727
+ 6.552e-06 -0.000260460452131636
+ 6.554e-06 -3.96621450709877e-05
+ 6.556e-06 8.68055001601157e-05
+ 6.558e-06 -9.75046730790876e-05
+ 6.56e-06 -2.39556460712529e-05
+ 6.562e-06 0.000121610791704882
+ 6.564e-06 7.79760032742786e-06
+ 6.566e-06 0.000164128946602272
+ 6.568e-06 0.000287880038991621
+ 6.57e-06 0.000185211172491694
+ 6.572e-06 0.000184056209304607
+ 6.574e-06 -0.000150337618985524
+ 6.576e-06 -0.00031245519014261
+ 6.578e-06 -0.000629359337514404
+ 6.58e-06 -0.000366339208112956
+ 6.582e-06 -0.000542181038100282
+ 6.584e-06 -0.000858540392415043
+ 6.586e-06 -0.000683231371455415
+ 6.588e-06 -0.000384520763491114
+ 6.59e-06 -0.000260827149117981
+ 6.592e-06 -0.000260215763870762
+ 6.594e-06 -0.000122563285519526
+ 6.596e-06 -0.000248332020014949
+ 6.598e-06 -8.57334687273867e-05
+ 6.6e-06 -0.000155464454622493
+ 6.602e-06 -0.000129392945323502
+ 6.604e-06 8.44592217338191e-05
+ 6.606e-06 0.000157431642417434
+ 6.608e-06 0.000156722021479482
+ 6.61e-06 0.000288998668665225
+ 6.612e-06 0.00042228020114469
+ 6.614e-06 0.000562612718745269
+ 6.616e-06 0.000411780876931932
+ 6.618e-06 0.000329451752315679
+ 6.62e-06 0.00040562927817323
+ 6.622e-06 0.000535605482793873
+ 6.624e-06 0.000326282993002667
+ 6.626e-06 0.00014853113414172
+ 6.628e-06 0.000347867833967451
+ 6.63e-06 1.31559815552414e-05
+ 6.632e-06 0.000267768380758392
+ 6.634e-06 0.000451239776889369
+ 6.636e-06 0.000335521826611537
+ 6.638e-06 0.000328077189286151
+ 6.64e-06 0.000214300326980542
+ 6.642e-06 -0.000181223317465355
+ 6.644e-06 -0.000443705109401345
+ 6.646e-06 -0.000467718611661481
+ 6.648e-06 -0.000510165187333189
+ 6.65e-06 -0.000547590231169228
+ 6.652e-06 -0.000591606074653137
+ 6.654e-06 -0.000790249762170669
+ 6.656e-06 -0.000677025452622091
+ 6.658e-06 -0.000675449923519066
+ 6.66e-06 -0.00110983747219077
+ 6.662e-06 -0.00095669268526232
+ 6.664e-06 -0.000940743679917248
+ 6.666e-06 -0.0012527551766047
+ 6.668e-06 -0.00101085395521771
+ 6.67e-06 -0.00118837285300461
+ 6.672e-06 -0.00135896302305865
+ 6.674e-06 -0.00109639807749546
+ 6.676e-06 -0.000857547592141756
+ 6.678e-06 -0.00067036996312257
+ 6.68e-06 -0.000703764519401217
+ 6.682e-06 -0.000214903718006613
+ 6.684e-06 -0.000399636530223369
+ 6.686e-06 -0.000165672923667185
+ 6.688e-06 -0.00038282021464725
+ 6.69e-06 -0.000420706823213218
+ 6.692e-06 -0.0001025418599539
+ 6.694e-06 -0.000161312093411981
+ 6.696e-06 -0.000215458556781272
+ 6.698e-06 -0.000550703214562344
+ 6.7e-06 -0.000581798084184903
+ 6.702e-06 -0.000602327317454086
+ 6.704e-06 -0.000846014994333987
+ 6.706e-06 -0.000770769473396783
+ 6.708e-06 -0.000749416810964986
+ 6.71e-06 -0.000709762843845122
+ 6.712e-06 -0.00072612495862597
+ 6.714e-06 -0.000553971336478735
+ 6.716e-06 -0.000829021648092623
+ 6.718e-06 -0.00105967130468229
+ 6.72e-06 -0.000804333784073574
+ 6.722e-06 -0.000570071575684042
+ 6.724e-06 -0.000534339460940598
+ 6.726e-06 -0.000422455006015833
+ 6.728e-06 -0.000431249016010307
+ 6.73e-06 -0.000325648004158566
+ 6.732e-06 -0.00018848458037094
+ 6.734e-06 -9.72636565394074e-05
+ 6.736e-06 -0.000321096080272432
+ 6.738e-06 -0.000615489578032159
+ 6.74e-06 -0.000714456015675553
+ 6.742e-06 -0.000569537459758038
+ 6.744e-06 -0.000762291676222027
+ 6.746e-06 -0.000467571094181255
+ 6.748e-06 -0.000535275128868638
+ 6.75e-06 -0.000318471219461512
+ 6.752e-06 -0.000230435239728156
+ 6.754e-06 -0.000124270470435311
+ 6.756e-06 -9.14552278110576e-05
+ 6.758e-06 -0.000137691721570354
+ 6.76e-06 -0.000453419867057053
+ 6.762e-06 -0.000480200431057413
+ 6.764e-06 -0.000643420867032
+ 6.766e-06 -0.000682451082192778
+ 6.768e-06 -0.000617653505116205
+ 6.77e-06 -0.000831024621918473
+ 6.772e-06 -0.00103365557917243
+ 6.774e-06 -0.000641468030331353
+ 6.776e-06 -0.000742358452235776
+ 6.778e-06 -0.00103956262599492
+ 6.78e-06 -0.00111102030739295
+ 6.782e-06 -0.00121966381670841
+ 6.784e-06 -0.00122364120393633
+ 6.786e-06 -0.00133676478696192
+ 6.788e-06 -0.00130673232162403
+ 6.79e-06 -0.00164471151525533
+ 6.792e-06 -0.00140716969503261
+ 6.794e-06 -0.00106409615852887
+ 6.796e-06 -0.000849980571518078
+ 6.798e-06 -0.00103759063946796
+ 6.8e-06 -0.000782658382951965
+ 6.802e-06 -0.000870739513840276
+ 6.804e-06 -0.000958781636493722
+ 6.806e-06 -0.00093900671403717
+ 6.808e-06 -0.00106080420986828
+ 6.81e-06 -0.00111003487373852
+ 6.812e-06 -0.000862485011556313
+ 6.814e-06 -0.000594811722025515
+ 6.816e-06 -0.000934526313986195
+ 6.818e-06 -0.000928232762493679
+ 6.82e-06 -0.000871359316774149
+ 6.822e-06 -0.00089796913420018
+ 6.824e-06 -0.000763210613501164
+ 6.826e-06 -0.000440885093981346
+ 6.828e-06 -0.000438298597002618
+ 6.83e-06 -0.000843814841110543
+ 6.832e-06 -0.00104006168144838
+ 6.834e-06 -0.000969772784429217
+ 6.836e-06 -0.00103619438171311
+ 6.838e-06 -0.000996666599347958
+ 6.84e-06 -0.00103569136041322
+ 6.842e-06 -0.000957675702169831
+ 6.844e-06 -0.00103454518044151
+ 6.846e-06 -0.00105204611687119
+ 6.848e-06 -0.000700678098408249
+ 6.85e-06 -0.00066658297108025
+ 6.852e-06 -0.000840997572621246
+ 6.854e-06 -0.00074430528481025
+ 6.856e-06 -0.000442615907762055
+ 6.858e-06 -0.000576311936574384
+ 6.86e-06 -0.000451188097657645
+ 6.862e-06 -0.000514332887320913
+ 6.864e-06 -0.0003294075377093
+ 6.866e-06 -0.00028662642307765
+ 6.868e-06 -0.000479004142123721
+ 6.87e-06 -0.000304580732770061
+ 6.872e-06 -0.000458788866219045
+ 6.874e-06 -0.000603890102240532
+ 6.876e-06 -0.000625189866581589
+ 6.878e-06 -0.000591818354148031
+ 6.88e-06 -0.000702226822904515
+ 6.882e-06 -0.000222227897349682
+ 6.884e-06 -0.000341840943977152
+ 6.886e-06 -0.000457464195007759
+ 6.888e-06 -0.000280958814572068
+ 6.89e-06 -4.32209130450478e-05
+ 6.892e-06 -0.000121415885787009
+ 6.894e-06 -9.22304801557875e-05
+ 6.896e-06 -0.000247722879237052
+ 6.898e-06 -0.00027383305392007
+ 6.9e-06 -0.000108161340329705
+ 6.902e-06 -0.000165798437441414
+ 6.904e-06 -0.000552923212453025
+ 6.906e-06 -0.000317897206029517
+ 6.908e-06 -0.000423137503455489
+ 6.91e-06 -0.000443303538479349
+ 6.912e-06 5.39673011183159e-05
+ 6.914e-06 0.000420154477081005
+ 6.916e-06 0.000455215714874289
+ 6.918e-06 0.000593841052520329
+ 6.92e-06 0.000620944370928225
+ 6.922e-06 0.000533881479531103
+ 6.924e-06 0.000662853650804832
+ 6.926e-06 0.000947211983848381
+ 6.928e-06 0.000999565704936485
+ 6.93e-06 0.000942021724793896
+ 6.932e-06 0.000876381789430935
+ 6.934e-06 0.000829156059979479
+ 6.936e-06 0.000576092359108687
+ 6.938e-06 0.000603643728915043
+ 6.94e-06 0.000617938672979689
+ 6.942e-06 0.000574132612915084
+ 6.944e-06 0.00035032766313279
+ 6.946e-06 0.00035360943839365
+ 6.948e-06 0.000150138507320842
+ 6.95e-06 0.000471537354504322
+ 6.952e-06 0.000438819230429294
+ 6.954e-06 0.000554742394379931
+ 6.956e-06 0.000305744663987366
+ 6.958e-06 0.000327994950831021
+ 6.96e-06 0.000211563079986878
+ 6.962e-06 0.000193685436375899
+ 6.964e-06 0.000532982832216386
+ 6.966e-06 0.000873608444183068
+ 6.968e-06 0.000906208261704465
+ 6.97e-06 0.000809446322449389
+ 6.972e-06 0.000982198338360302
+ 6.974e-06 0.00108774182710092
+ 6.976e-06 0.00111274656923784
+ 6.978e-06 0.0013572799028488
+ 6.98e-06 0.00136187645602255
+ 6.982e-06 0.00145617723254893
+ 6.984e-06 0.00174063321618012
+ 6.986e-06 0.00151417647667844
+ 6.988e-06 0.00170880800270785
+ 6.99e-06 0.00142205340909983
+ 6.992e-06 0.00139800610855454
+ 6.994e-06 0.00144836705819859
+ 6.996e-06 0.00114814816624228
+ 6.998e-06 0.00119586472299873
+ 7e-06 0.00110054091610077
+ 7.002e-06 0.000898902060447025
+ 7.004e-06 0.000778186971821466
+ 7.006e-06 0.000487826436851818
+ 7.008e-06 0.000203803745099712
+ 7.01e-06 0.000146249571248193
+ 7.012e-06 0.000364840801432417
+ 7.014e-06 0.000194073824643334
+ 7.016e-06 3.53297094387056e-05
+ 7.018e-06 0.000206394837510809
+ 7.02e-06 -2.17605363523381e-05
+ 7.022e-06 0.000103063365334968
+ 7.024e-06 0.000160258633636417
+ 7.026e-06 0.000346526294580873
+ 7.028e-06 0.000399910557978394
+ 7.03e-06 0.000488007619370466
+ 7.032e-06 0.000251652746610527
+ 7.034e-06 -2.56092727882012e-05
+ 7.036e-06 -0.000180924961963891
+ 7.038e-06 -0.000168196098995352
+ 7.04e-06 0.000175841799238308
+ 7.042e-06 0.000220283216275243
+ 7.044e-06 0.000171847454998596
+ 7.046e-06 9.802429206211e-05
+ 7.048e-06 0.000280761989965342
+ 7.05e-06 0.000408594783476752
+ 7.052e-06 0.000677977082967654
+ 7.054e-06 0.000531442493919601
+ 7.056e-06 0.000632138385420717
+ 7.058e-06 0.000567986822561301
+ 7.06e-06 0.00013461205525611
+ 7.062e-06 -8.87140228484115e-05
+ 7.064e-06 -0.000209460355694764
+ 7.066e-06 -0.000487443782107636
+ 7.068e-06 -0.000718583741089977
+ 7.07e-06 -0.000794742774126276
+ 7.072e-06 -0.000876721256732295
+ 7.074e-06 -0.00101454850566365
+ 7.076e-06 -0.0011608837075749
+ 7.078e-06 -0.00147363579542965
+ 7.08e-06 -0.00161229843678855
+ 7.082e-06 -0.00195356138101131
+ 7.084e-06 -0.00191248702916359
+ 7.086e-06 -0.00212094915214752
+ 7.088e-06 -0.00184574307254406
+ 7.09e-06 -0.00198900930380833
+ 7.092e-06 -0.00175413733153345
+ 7.094e-06 -0.00145342313340187
+ 7.096e-06 -0.00143965953920452
+ 7.098e-06 -0.00159235879880291
+ 7.1e-06 -0.00136786521195834
+ 7.102e-06 -0.00147296823240986
+ 7.104e-06 -0.00181359840329727
+ 7.106e-06 -0.00186141179558984
+ 7.108e-06 -0.00167942763213224
+ 7.11e-06 -0.00142501072084662
+ 7.112e-06 -0.00130284056221386
+ 7.114e-06 -0.00101621379797169
+ 7.116e-06 -0.0010670752041504
+ 7.118e-06 -0.00127383781711026
+ 7.12e-06 -0.00137578070142793
+ 7.122e-06 -0.00133725049507286
+ 7.124e-06 -0.00132321265367407
+ 7.126e-06 -0.00130492933958749
+ 7.128e-06 -0.001418020749009
+ 7.13e-06 -0.00153856691661422
+ 7.132e-06 -0.00154196395316219
+ 7.134e-06 -0.00122777465921952
+ 7.136e-06 -0.000914086460178967
+ 7.138e-06 -0.000696485286312047
+ 7.14e-06 -0.00086872266598444
+ 7.142e-06 -0.000694704013833003
+ 7.144e-06 -0.000699455106940845
+ 7.146e-06 -0.000467572230863496
+ 7.148e-06 -0.000716270783658492
+ 7.15e-06 -0.000638270531800978
+ 7.152e-06 -0.00085229107684812
+ 7.154e-06 -0.000741711154381007
+ 7.156e-06 -0.000486281844241805
+ 7.158e-06 -0.000419362866989975
+ 7.16e-06 -0.000445099613562513
+ 7.162e-06 -0.000716803081952072
+ 7.164e-06 -0.000461976705317805
+ 7.166e-06 -0.000640282519345418
+ 7.168e-06 -0.000649942323746996
+ 7.17e-06 -0.000517424879684631
+ 7.172e-06 -0.000432042296323041
+ 7.174e-06 -0.000948978754328291
+ 7.176e-06 -0.00105066761119581
+ 7.178e-06 -0.00103191790901621
+ 7.18e-06 -0.000682625995058535
+ 7.182e-06 -0.000913013595152005
+ 7.184e-06 -0.000554939136628085
+ 7.186e-06 -0.000780901338622529
+ 7.188e-06 -0.000469659456055471
+ 7.19e-06 -0.000420373760268002
+ 7.192e-06 2.68097080159457e-07
+ 7.194e-06 -0.00031910226430857
+ 7.196e-06 -7.03271851937316e-05
+ 7.198e-06 -0.000259808018713311
+ 7.2e-06 -0.000319420033134333
+ 7.202e-06 -0.000364298549271465
+ 7.204e-06 -0.000228789136683409
+ 7.206e-06 -0.000354166833224821
+ 7.208e-06 -0.000120047083373513
+ 7.21e-06 -0.000457171442654636
+ 7.212e-06 -0.00064025043258515
+ 7.214e-06 -0.000652395819442672
+ 7.216e-06 -0.000588070261274099
+ 7.218e-06 -0.000244430104142052
+ 7.22e-06 -0.000548671832204233
+ 7.222e-06 -0.000754654087232388
+ 7.224e-06 -0.000543075228217462
+ 7.226e-06 -0.000381114828962123
+ 7.228e-06 -4.67053935395028e-05
+ 7.23e-06 0.000356903954633826
+ 7.232e-06 0.000488585767148897
+ 7.234e-06 0.000630623755452067
+ 7.236e-06 0.000395593065880515
+ 7.238e-06 0.00047196595834008
+ 7.24e-06 0.000529654574345036
+ 7.242e-06 0.0003846358715313
+ 7.244e-06 0.000566115355798373
+ 7.246e-06 0.000787148800335832
+ 7.248e-06 0.000642523207029359
+ 7.25e-06 0.000472133042506033
+ 7.252e-06 0.000364379663024847
+ 7.254e-06 0.000272288401637508
+ 7.256e-06 0.000470249927112232
+ 7.258e-06 0.000517177789048862
+ 7.26e-06 0.000703356269993958
+ 7.262e-06 0.000919005980969916
+ 7.264e-06 0.000804766882893447
+ 7.266e-06 0.000892982978635343
+ 7.268e-06 0.000837290503694928
+ 7.27e-06 0.000786238968321866
+ 7.272e-06 0.000444836342194694
+ 7.274e-06 0.000606041753228755
+ 7.276e-06 0.000559946708297653
+ 7.278e-06 0.000624937916355333
+ 7.28e-06 0.000584893861837975
+ 7.282e-06 0.000424953431451693
+ 7.284e-06 0.000400912876607543
+ 7.286e-06 0.000354524615679518
+ 7.288e-06 0.000344482902167674
+ 7.29e-06 0.000416901163558487
+ 7.292e-06 0.000154475272004848
+ 7.294e-06 -0.000195117200018738
+ 7.296e-06 1.37459319156854e-05
+ 7.298e-06 0.000169346939868913
+ 7.3e-06 0.00034187439349814
+ 7.302e-06 0.000604351391354591
+ 7.304e-06 0.000587363795687169
+ 7.306e-06 0.00067236911774058
+ 7.308e-06 0.000679748147754539
+ 7.31e-06 0.000485688537521822
+ 7.312e-06 0.000312249230883319
+ 7.314e-06 0.000260158659336342
+ 7.316e-06 0.000314405998272674
+ 7.318e-06 0.000362376330470447
+ 7.32e-06 0.000233669169033415
+ 7.322e-06 0.000132122225108059
+ 7.324e-06 0.000203768411797669
+ 7.326e-06 0.000167740468297667
+ 7.328e-06 0.00024349022261504
+ 7.33e-06 0.00041914431315643
+ 7.332e-06 0.000556224575661416
+ 7.334e-06 0.000276389686463547
+ 7.336e-06 0.000549346060877852
+ 7.338e-06 0.000480282801051282
+ 7.34e-06 0.000358566925375768
+ 7.342e-06 4.66257634390401e-05
+ 7.344e-06 -3.21388734937062e-05
+ 7.346e-06 0.000146635696631572
+ 7.348e-06 0.000150392645572068
+ 7.35e-06 -0.000154550748701782
+ 7.352e-06 -0.000184171205702108
+ 7.354e-06 -0.000574192072500992
+ 7.356e-06 -0.00051862583461134
+ 7.358e-06 -0.000820665276332888
+ 7.36e-06 -0.000910204423857359
+ 7.362e-06 -0.00100798115739643
+ 7.364e-06 -0.00102531774300394
+ 7.366e-06 -0.00132229731604046
+ 7.368e-06 -0.00131875946922581
+ 7.37e-06 -0.00147148730986987
+ 7.372e-06 -0.00152268488146608
+ 7.374e-06 -0.00144956139963002
+ 7.376e-06 -0.00164206150955944
+ 7.378e-06 -0.00154184097358573
+ 7.38e-06 -0.00137226291189098
+ 7.382e-06 -0.00134586759602037
+ 7.384e-06 -0.00141863222683521
+ 7.386e-06 -0.00186997906797744
+ 7.388e-06 -0.00179313342217902
+ 7.39e-06 -0.00174494212123157
+ 7.392e-06 -0.00169632279301378
+ 7.394e-06 -0.00165140680484258
+ 7.396e-06 -0.00169699631066499
+ 7.398e-06 -0.00166639523550166
+ 7.4e-06 -0.00158208353402887
+ 7.402e-06 -0.00145028601762988
+ 7.404e-06 -0.00162817934053257
+ 7.406e-06 -0.00123323271786751
+ 7.408e-06 -0.000806811919483942
+ 7.41e-06 -0.000945323482375504
+ 7.412e-06 -0.000864762951738749
+ 7.414e-06 -0.000716296685251604
+ 7.416e-06 -0.000636999895516726
+ 7.418e-06 -0.0008445309884375
+ 7.42e-06 -0.000927584952408858
+ 7.422e-06 -0.000653427740862114
+ 7.424e-06 -0.000725790536944277
+ 7.426e-06 -0.000884894926034657
+ 7.428e-06 -0.000640752531579426
+ 7.43e-06 -0.00037844152610718
+ 7.432e-06 -0.000765641892417852
+ 7.434e-06 -0.000552178193802347
+ 7.436e-06 -0.000802615314023469
+ 7.438e-06 -0.000829406663095903
+ 7.44e-06 -0.00112208913201044
+ 7.442e-06 -0.00151804104976186
+ 7.444e-06 -0.00160309728575007
+ 7.446e-06 -0.00160074861674511
+ 7.448e-06 -0.00138269341018404
+ 7.45e-06 -0.00141342967137281
+ 7.452e-06 -0.00151982094246785
+ 7.454e-06 -0.00146069197804375
+ 7.456e-06 -0.00130108804977133
+ 7.458e-06 -0.00129484213114839
+ 7.46e-06 -0.00117665633113906
+ 7.462e-06 -0.00121225164877456
+ 7.464e-06 -0.00145065788146534
+ 7.466e-06 -0.00119987057294966
+ 7.468e-06 -0.000962346357433031
+ 7.47e-06 -0.00109140278245837
+ 7.472e-06 -0.00126230843677847
+ 7.474e-06 -0.000762212903014767
+ 7.476e-06 -0.00100854514043024
+ 7.478e-06 -0.00101222226757602
+ 7.48e-06 -0.00103897007509671
+ 7.482e-06 -0.000860725959686508
+ 7.484e-06 -0.00104435105029885
+ 7.486e-06 -0.000955696695623436
+ 7.488e-06 -0.00109276635431492
+ 7.49e-06 -0.000914878888673189
+ 7.492e-06 -0.000982235314505072
+ 7.494e-06 -0.00111974518888986
+ 7.496e-06 -0.00125868557472157
+ 7.498e-06 -0.00112449983439021
+ 7.5e-06 -0.00125748301164694
+ 7.502e-06 -0.00129487304667221
+ 7.504e-06 -0.00130376183759833
+ 7.506e-06 -0.00130582728021295
+ 7.508e-06 -0.00114383853222659
+ 7.51e-06 -0.000971691430349586
+ 7.512e-06 -0.000791431010355341
+ 7.514e-06 -0.000809581140889594
+ 7.516e-06 -0.000596019201498265
+ 7.518e-06 -0.000559168741624334
+ 7.52e-06 -0.000888982341961927
+ 7.522e-06 -0.00106720642869056
+ 7.524e-06 -0.00128139704384461
+ 7.526e-06 -0.0015848341349871
+ 7.528e-06 -0.00145881801406566
+ 7.53e-06 -0.00149630959202572
+ 7.532e-06 -0.00124113713591927
+ 7.534e-06 -0.00121266289698722
+ 7.536e-06 -0.00125605628359838
+ 7.538e-06 -0.001105592316199
+ 7.54e-06 -0.000865133038397514
+ 7.542e-06 -0.00104836035289164
+ 7.544e-06 -0.00108073424950528
+ 7.546e-06 -0.00106183400984146
+ 7.548e-06 -0.000720344656735749
+ 7.55e-06 -0.000722942201106821
+ 7.552e-06 -0.00079754002902741
+ 7.554e-06 -0.000878415064971454
+ 7.556e-06 -0.000859203344855653
+ 7.558e-06 -0.000857069172574389
+ 7.56e-06 -0.0010887442880358
+ 7.562e-06 -0.000883555213577816
+ 7.564e-06 -0.000756959918353104
+ 7.566e-06 -0.00120671166614715
+ 7.568e-06 -0.000993042108851679
+ 7.57e-06 -0.000693442281065935
+ 7.572e-06 -0.000413144173497193
+ 7.574e-06 -0.000700887336843165
+ 7.576e-06 -0.000821493466619592
+ 7.578e-06 -0.000535892911148234
+ 7.58e-06 -0.000593728304026882
+ 7.582e-06 -0.000778977140520095
+ 7.584e-06 -0.000379303157215931
+ 7.586e-06 -0.000341089029182036
+ 7.588e-06 -0.00030213548866259
+ 7.59e-06 -0.000292760871493514
+ 7.592e-06 -0.000147930640629618
+ 7.594e-06 -0.000407205494228709
+ 7.596e-06 -3.92763511165304e-05
+ 7.598e-06 -6.50651687379484e-06
+ 7.6e-06 -0.000110921079999126
+ 7.602e-06 -4.2693922497315e-05
+ 7.604e-06 0.000143416545171304
+ 7.606e-06 0.00011898995955637
+ 7.608e-06 0.000137491111183154
+ 7.61e-06 -4.42958427794e-05
+ 7.612e-06 -0.000213666977934545
+ 7.614e-06 -0.000380025040056067
+ 7.616e-06 -0.000632300075413969
+ 7.618e-06 -0.000619474252009493
+ 7.62e-06 -0.000639180421391995
+ 7.622e-06 -0.000438627867409592
+ 7.624e-06 -0.000452788270124101
+ 7.626e-06 -0.000163704174886508
+ 7.628e-06 -0.000193740457863486
+ 7.63e-06 -0.000386048087503071
+ 7.632e-06 2.14026779276877e-06
+ 7.634e-06 -8.6977964405793e-05
+ 7.636e-06 -3.4382949265385e-05
+ 7.638e-06 0.000183162259768796
+ 7.64e-06 0.000446928858001851
+ 7.642e-06 0.000314632859024414
+ 7.644e-06 0.000437905230722681
+ 7.646e-06 0.000441620779122071
+ 7.648e-06 0.00051839545638547
+ 7.65e-06 0.000493341901029596
+ 7.652e-06 0.000520034160705114
+ 7.654e-06 0.000894013508669323
+ 7.656e-06 0.000815088890712926
+ 7.658e-06 0.000942047340474114
+ 7.66e-06 0.000999966758515516
+ 7.662e-06 0.000982166540415878
+ 7.664e-06 0.00124247741889779
+ 7.666e-06 0.00125421476414389
+ 7.668e-06 0.00105037802496605
+ 7.67e-06 0.000994092010156989
+ 7.672e-06 0.000990322384285615
+ 7.674e-06 0.00122480754554236
+ 7.676e-06 0.00133522139689449
+ 7.678e-06 0.00139812878013604
+ 7.68e-06 0.00120924302043006
+ 7.682e-06 0.00126176479031273
+ 7.684e-06 0.00123472609709292
+ 7.686e-06 0.00127377030967722
+ 7.688e-06 0.00148745641611987
+ 7.69e-06 0.0017134329246375
+ 7.692e-06 0.0017706339575919
+ 7.694e-06 0.00178775917234477
+ 7.696e-06 0.00206854455589623
+ 7.698e-06 0.00172479053774988
+ 7.7e-06 0.00193317997104185
+ 7.702e-06 0.00185650689810585
+ 7.704e-06 0.00161978565297641
+ 7.706e-06 0.00166215956824359
+ 7.708e-06 0.00163538582532566
+ 7.71e-06 0.00145726504568995
+ 7.712e-06 0.00161787495247535
+ 7.714e-06 0.00135069653802182
+ 7.716e-06 0.00108018509867046
+ 7.718e-06 0.000805322677367808
+ 7.72e-06 0.000579839470791144
+ 7.722e-06 0.000182379763403767
+ 7.724e-06 0.000199192849267965
+ 7.726e-06 9.89392553898963e-06
+ 7.728e-06 5.15133342251153e-06
+ 7.73e-06 0.00037024018277203
+ 7.732e-06 0.000178989372733422
+ 7.734e-06 -2.00530763843728e-05
+ 7.736e-06 0.00022840337655293
+ 7.738e-06 0.00047958754724493
+ 7.74e-06 0.000656960629571036
+ 7.742e-06 0.000592723905390889
+ 7.744e-06 0.00030555418734589
+ 7.746e-06 0.000296465119424737
+ 7.748e-06 0.000365623654026525
+ 7.75e-06 0.000474066605265565
+ 7.752e-06 0.000298693227762982
+ 7.754e-06 0.000483951498745657
+ 7.756e-06 0.000700838751946899
+ 7.758e-06 0.000979734361345695
+ 7.76e-06 0.0010031115853602
+ 7.762e-06 0.000875587982972375
+ 7.764e-06 0.00104183380759675
+ 7.766e-06 0.0005147708610457
+ 7.768e-06 0.000832367430444883
+ 7.77e-06 0.00082391631244085
+ 7.772e-06 0.000830989316991727
+ 7.774e-06 0.000871414886948945
+ 7.776e-06 0.00111063008980207
+ 7.778e-06 0.000932473190947928
+ 7.78e-06 0.000793720329806551
+ 7.782e-06 0.00105895267488589
+ 7.784e-06 0.00113110523185285
+ 7.786e-06 0.000967972364937356
+ 7.788e-06 0.000896025527526655
+ 7.79e-06 0.000966280421686959
+ 7.792e-06 0.000629586286538055
+ 7.794e-06 0.000680067696993268
+ 7.796e-06 0.000817807872703879
+ 7.798e-06 0.00102080295497787
+ 7.8e-06 0.000905872349190777
+ 7.802e-06 0.000785842745473384
+ 7.804e-06 0.000929313391660515
+ 7.806e-06 0.00057641751673823
+ 7.808e-06 0.000699257116010683
+ 7.81e-06 0.000813306419173064
+ 7.812e-06 0.00114642899722478
+ 7.814e-06 0.00119518724576739
+ 7.816e-06 0.00122260303092125
+ 7.818e-06 0.00105030979139237
+ 7.82e-06 0.00144234533439345
+ 7.822e-06 0.00145710632621049
+ 7.824e-06 0.00140124779594861
+ 7.826e-06 0.00139738503685228
+ 7.828e-06 0.00147227170658197
+ 7.83e-06 0.00126677417500847
+ 7.832e-06 0.00111419378252137
+ 7.834e-06 0.00099190096480223
+ 7.836e-06 0.00100539434284086
+ 7.838e-06 0.000900480890200904
+ 7.84e-06 0.000870140455600177
+ 7.842e-06 0.000831161617281954
+ 7.844e-06 0.000733272992373798
+ 7.846e-06 0.000575903241017635
+ 7.848e-06 0.000103160330681768
+ 7.85e-06 0.000173853832942387
+ 7.852e-06 0.000292025879760567
+ 7.854e-06 0.000558125178112539
+ 7.856e-06 0.000460976801596571
+ 7.858e-06 0.000281791910249881
+ 7.86e-06 0.000294276466880259
+ 7.862e-06 0.000136739308346681
+ 7.864e-06 8.95361036157421e-05
+ 7.866e-06 7.33563622865421e-05
+ 7.868e-06 0.000302114470675299
+ 7.87e-06 0.000230839531135071
+ 7.872e-06 -8.22776704648364e-05
+ 7.874e-06 -8.56436681851168e-06
+ 7.876e-06 0.000452720444654531
+ 7.878e-06 0.000659106456857234
+ 7.88e-06 0.000331058841009707
+ 7.882e-06 0.000218313680190485
+ 7.884e-06 0.000521445739925039
+ 7.886e-06 0.000760567695983356
+ 7.888e-06 0.000845482586474863
+ 7.89e-06 0.000943953403176005
+ 7.892e-06 0.00107534146316928
+ 7.894e-06 0.000827451962974757
+ 7.896e-06 0.000805971346279803
+ 7.898e-06 0.000963919114770486
+ 7.9e-06 0.000786495838070861
+ 7.902e-06 0.000531381456185298
+ 7.904e-06 0.000812767229266877
+ 7.906e-06 0.000697839550097475
+ 7.908e-06 0.000582201359701204
+ 7.91e-06 0.000609386384034042
+ 7.912e-06 0.000639766999307029
+ 7.914e-06 0.000686740878975747
+ 7.916e-06 0.000942980296451963
+ 7.918e-06 0.000982290606208447
+ 7.92e-06 0.00136775741918266
+ 7.922e-06 0.00130254142975287
+ 7.924e-06 0.00160340417581205
+ 7.926e-06 0.00172138468441251
+ 7.928e-06 0.00181821366844946
+ 7.93e-06 0.00171083788015166
+ 7.932e-06 0.00192808171475228
+ 7.934e-06 0.0017327116452454
+ 7.936e-06 0.00132757345030306
+ 7.938e-06 0.00157110310010655
+ 7.94e-06 0.00173796755749171
+ 7.942e-06 0.00139621590839004
+ 7.944e-06 0.00160871058516239
+ 7.946e-06 0.00138478507657255
+ 7.948e-06 0.00134298670735313
+ 7.95e-06 0.00155184170800089
+ 7.952e-06 0.00181420756797977
+ 7.954e-06 0.0014391557136943
+ 7.956e-06 0.00138734623986099
+ 7.958e-06 0.00134839881024587
+ 7.96e-06 0.00115214165051409
+ 7.962e-06 0.000961678789164356
+ 7.964e-06 0.000970831402131403
+ 7.966e-06 0.000968220047986226
+ 7.968e-06 0.00113452695251037
+ 7.97e-06 0.000976036121918138
+ 7.972e-06 0.000727362578011435
+ 7.974e-06 0.000778965842169878
+ 7.976e-06 0.000661935528517474
+ 7.978e-06 0.000739769943214994
+ 7.98e-06 0.000674670372425966
+ 7.982e-06 0.000565734160128269
+ 7.984e-06 0.000399305371942505
+ 7.986e-06 0.000138080600448308
+ 7.988e-06 -3.19692245920898e-05
+ 7.99e-06 -0.000383142977043311
+ 7.992e-06 -0.000542367319026875
+ 7.994e-06 -0.000522259988180922
+ 7.996e-06 -0.00070951564400033
+ 7.998e-06 -0.00082885071055904
+ 8e-06 -0.000568067507910581
+ 8.002e-06 -0.000572141812522017
+ 8.004e-06 -0.000474351892356502
+ 8.006e-06 -0.000414119379253995
+ 8.008e-06 -0.000436874324553741
+ 8.01e-06 -0.000367274554820891
+ 8.012e-06 -0.000369791234489523
+ 8.014e-06 -0.000444286201281475
+ 8.016e-06 -0.000261188906741951
+ 8.018e-06 -0.000408819013464352
+ 8.02e-06 -0.000484066566157591
+ 8.022e-06 -0.000487363406696757
+ 8.024e-06 -0.000190034299614235
+ 8.026e-06 -0.000152753933134511
+ 8.028e-06 -0.000308571453339744
+ 8.03e-06 -0.00075263817685471
+ 8.032e-06 -0.000543746474257779
+ 8.034e-06 -0.000522873622601965
+ 8.036e-06 -0.000889133172946862
+ 8.038e-06 -0.00101911175496369
+ 8.04e-06 -0.00088402556375473
+ 8.042e-06 -0.000812143596631692
+ 8.044e-06 -0.000927619121264018
+ 8.046e-06 -0.000654106476169723
+ 8.048e-06 8.14637243623768e-05
+ 8.05e-06 0.000629957229075051
+ 8.052e-06 0.000879384898349575
+ 8.054e-06 0.000992424511549011
+ 8.056e-06 0.00153748889935738
+ 8.058e-06 0.00148567541948793
+ 8.06e-06 0.00137958647630264
+ 8.062e-06 0.00143734479160345
+ 8.064e-06 0.00121485703078981
+ 8.066e-06 0.00119211760649411
+ 8.068e-06 0.00104092427191409
+ 8.07e-06 0.00108856625795455
+ 8.072e-06 0.00116839773134159
+ 8.074e-06 0.000907702896641812
+ 8.076e-06 0.000721545082249977
+ 8.078e-06 0.000637725994474986
+ 8.08e-06 0.00118659274502845
+ 8.082e-06 0.00103919648019018
+ 8.084e-06 0.00124560980922717
+ 8.086e-06 0.0014802338466203
+ 8.088e-06 0.00120150979178987
+ 8.09e-06 0.00131959859503243
+ 8.092e-06 0.00110749736789726
+ 8.094e-06 0.000930312291293306
+ 8.096e-06 0.0012608138670289
+ 8.098e-06 0.00174491689484123
+ 8.1e-06 0.00191857312702596
+ 8.102e-06 0.00192644139008555
+ 8.104e-06 0.00171445965719656
+ 8.106e-06 0.00182147135938496
+ 8.108e-06 0.0015350693137071
+ 8.11e-06 0.00147290011651012
+ 8.112e-06 0.00176588525550781
+ 8.114e-06 0.00172914591685667
+ 8.116e-06 0.00143498449589037
+ 8.118e-06 0.00112359265686389
+ 8.12e-06 0.00105787750371547
+ 8.122e-06 0.00117775094147534
+ 8.124e-06 0.00116242659917677
+ 8.126e-06 0.00127917404555882
+ 8.128e-06 0.00120381378851426
+ 8.13e-06 0.00108762696771905
+ 8.132e-06 0.000847789356792052
+ 8.134e-06 0.000837551796703147
+ 8.136e-06 0.000880211917698253
+ 8.138e-06 0.00103644497320275
+ 8.14e-06 0.000776503384840837
+ 8.142e-06 0.00111270246982362
+ 8.144e-06 0.00096835803760725
+ 8.146e-06 0.0010477105183512
+ 8.148e-06 0.000750042562815289
+ 8.15e-06 0.000714423973675444
+ 8.152e-06 0.000609225220530571
+ 8.154e-06 0.000848892917537138
+ 8.156e-06 0.000790722125357507
+ 8.158e-06 0.00081822521454898
+ 8.16e-06 0.000816894471378201
+ 8.162e-06 0.000774271778271406
+ 8.164e-06 0.000826592791506277
+ 8.166e-06 0.000965785588465468
+ 8.168e-06 0.000865967098482126
+ 8.17e-06 0.00037523817151601
+ 8.172e-06 0.000365174749580414
+ 8.174e-06 0.000216771678780948
+ 8.176e-06 0.000340961888944498
+ 8.178e-06 0.000722051636340921
+ 8.18e-06 0.000526212047939834
+ 8.182e-06 0.000591938961003765
+ 8.184e-06 0.000771262186133414
+ 8.186e-06 0.00103618668959277
+ 8.188e-06 0.000886979552282542
+ 8.19e-06 0.00134553137667955
+ 8.192e-06 0.00101525088817784
+ 8.194e-06 0.00102254569951065
+ 8.196e-06 0.000818307405631444
+ 8.198e-06 0.000734978105846741
+ 8.2e-06 0.00061790332822146
+ 8.202e-06 0.000736558187042202
+ 8.204e-06 0.000963227608547677
+ 8.206e-06 0.000923339556739499
+ 8.208e-06 0.000591547441877655
+ 8.21e-06 0.000797944454310089
+ 8.212e-06 0.000802292912844264
+ 8.214e-06 0.000941875051527196
+ 8.216e-06 0.000718171625965382
+ 8.218e-06 0.000519742220902492
+ 8.22e-06 0.000938599837607645
+ 8.222e-06 0.00103779509049843
+ 8.224e-06 0.000992356571623558
+ 8.226e-06 0.00102712347098198
+ 8.228e-06 0.000941436408676698
+ 8.23e-06 0.000919128736376807
+ 8.232e-06 0.000968702326145368
+ 8.234e-06 0.00122524441532576
+ 8.236e-06 0.00133016394297108
+ 8.238e-06 0.00144200934912535
+ 8.24e-06 0.00148587309502126
+ 8.242e-06 0.00138699977790186
+ 8.244e-06 0.00101491038644967
+ 8.246e-06 0.00121189842535461
+ 8.248e-06 0.00165154774175096
+ 8.25e-06 0.00142327204226879
+ 8.252e-06 0.00152258569145846
+ 8.254e-06 0.00157894076745682
+ 8.256e-06 0.00147321172833549
+ 8.258e-06 0.00166677968965644
+ 8.26e-06 0.00154159561078082
+ 8.262e-06 0.00151461675912936
+ 8.264e-06 0.00143239902117403
+ 8.266e-06 0.00138583208495621
+ 8.268e-06 0.00154171530767407
+ 8.27e-06 0.00127703779958885
+ 8.272e-06 0.000929537061161635
+ 8.274e-06 0.000571173307748198
+ 8.276e-06 0.000616394535586358
+ 8.278e-06 0.000571635897259849
+ 8.28e-06 0.000548377235562655
+ 8.282e-06 0.000179006414887765
+ 8.284e-06 0.000258803609290007
+ 8.286e-06 0.000499116746707053
+ 8.288e-06 0.000790684978301829
+ 8.29e-06 0.000925865662920468
+ 8.292e-06 0.000722502181630123
+ 8.294e-06 0.000843028520165919
+ 8.296e-06 0.000496645853037143
+ 8.298e-06 0.000683711053323803
+ 8.3e-06 0.000683972921887058
+ 8.302e-06 0.000498790975884077
+ 8.304e-06 0.000287376302716223
+ 8.306e-06 0.000421964844279072
+ 8.308e-06 2.64809009333898e-05
+ 8.31e-06 0.000214383566942354
+ 8.312e-06 0.000210874450330821
+ 8.314e-06 0.000227835922609348
+ 8.316e-06 -0.00019871123821933
+ 8.318e-06 -0.000282019889567518
+ 8.32e-06 0.000137507246052416
+ 8.322e-06 1.51736395896522e-05
+ 8.324e-06 0.000143281749633729
+ 8.326e-06 -8.42394652135704e-05
+ 8.328e-06 0.000159072618663073
+ 8.33e-06 0.000203798487456426
+ 8.332e-06 0.000518365626879921
+ 8.334e-06 0.000521085774933521
+ 8.336e-06 0.000407362782444977
+ 8.338e-06 0.000642603195226814
+ 8.34e-06 0.000897166161180436
+ 8.342e-06 0.00104363803781687
+ 8.344e-06 0.000992357779418292
+ 8.346e-06 0.000897805204824878
+ 8.348e-06 0.00110033770572967
+ 8.35e-06 0.000853746298729688
+ 8.352e-06 0.000719614348102051
+ 8.354e-06 0.0006414061438299
+ 8.356e-06 0.000610181258923373
+ 8.358e-06 0.000875908906493257
+ 8.36e-06 0.000807762899824525
+ 8.362e-06 0.000718826518185834
+ 8.364e-06 0.000989253070771963
+ 8.366e-06 0.000844413945553598
+ 8.368e-06 0.001135072854046
+ 8.37e-06 0.00106383096737874
+ 8.372e-06 0.000748304433162501
+ 8.374e-06 0.000518197385086741
+ 8.376e-06 7.27922608377002e-05
+ 8.378e-06 5.70886913076007e-05
+ 8.38e-06 -0.000262059761304987
+ 8.382e-06 -0.000119004016213521
+ 8.384e-06 0.0001441516230095
+ 8.386e-06 0.000163661688117066
+ 8.388e-06 0.0005547203227674
+ 8.39e-06 0.00084880797038593
+ 8.392e-06 0.00063802674786568
+ 8.394e-06 0.000643396587472842
+ 8.396e-06 0.00042793160680614
+ 8.398e-06 0.000243349607922297
+ 8.4e-06 0.000149816817753758
+ 8.402e-06 0.000454348137881337
+ 8.404e-06 0.000568556466054489
+ 8.406e-06 0.000625925309346868
+ 8.408e-06 0.000580014889915475
+ 8.41e-06 0.00107506489544506
+ 8.412e-06 0.000877500921531327
+ 8.414e-06 0.000777852936144321
+ 8.416e-06 0.00050484701700656
+ 8.418e-06 0.000408467297379864
+ 8.42e-06 0.000286763362825151
+ 8.422e-06 0.000371163571182314
+ 8.424e-06 0.000670354241389806
+ 8.426e-06 0.0007168536535662
+ 8.428e-06 0.000585666506218632
+ 8.43e-06 0.000696572767426168
+ 8.432e-06 0.00115235243153985
+ 8.434e-06 0.00110852754614097
+ 8.436e-06 0.000700754555915254
+ 8.438e-06 0.000682401788643912
+ 8.44e-06 0.000325953989485578
+ 8.442e-06 0.000354989602062677
+ 8.444e-06 5.96324327550637e-05
+ 8.446e-06 -0.000100799107073993
+ 8.448e-06 -0.000185731101406835
+ 8.45e-06 -0.000296479016792847
+ 8.452e-06 -0.000233784518868088
+ 8.454e-06 -0.000465129116678846
+ 8.456e-06 -0.000960109326437687
+ 8.458e-06 -0.000698124745014632
+ 8.46e-06 -0.000831471620728412
+ 8.462e-06 -0.000526086205701432
+ 8.464e-06 -0.000497396514073296
+ 8.466e-06 -0.000557619529406061
+ 8.468e-06 -0.000257955415287667
+ 8.47e-06 -0.000218362335772613
+ 8.472e-06 -5.32140852053765e-05
+ 8.474e-06 0.000108475173425128
+ 8.476e-06 0.000254605410701762
+ 8.478e-06 -9.35897103719581e-05
+ 8.48e-06 -0.00021431466085129
+ 8.482e-06 -0.00032482456649188
+ 8.484e-06 -0.000466583919564337
+ 8.486e-06 -0.0009333610090537
+ 8.488e-06 -0.000846110962572529
+ 8.49e-06 -0.000837412504440233
+ 8.492e-06 -0.000818169568687719
+ 8.494e-06 -0.000678318985258734
+ 8.496e-06 -0.000867627682456245
+ 8.498e-06 -0.000770368077044078
+ 8.5e-06 -0.000704822126282349
+ 8.502e-06 -0.000417515194768111
+ 8.504e-06 -0.000298806939500261
+ 8.506e-06 -0.000339235112421178
+ 8.508e-06 -0.000458144328152838
+ 8.51e-06 -0.000246436005128926
+ 8.512e-06 -0.000126516091511481
+ 8.514e-06 -0.000443421414613101
+ 8.516e-06 -0.000794622428929933
+ 8.518e-06 -0.000991656647166854
+ 8.52e-06 -0.000990032953834851
+ 8.522e-06 -0.00120175798127607
+ 8.524e-06 -0.00152014504024735
+ 8.526e-06 -0.00158719822923473
+ 8.528e-06 -0.00180035283735643
+ 8.53e-06 -0.00187324422964034
+ 8.532e-06 -0.00179654713165533
+ 8.534e-06 -0.0019060575988272
+ 8.536e-06 -0.00209962309833045
+ 8.538e-06 -0.00255470394594217
+ 8.54e-06 -0.00210007276493654
+ 8.542e-06 -0.00187719024236647
+ 8.544e-06 -0.00205163268601242
+ 8.546e-06 -0.00183781175469704
+ 8.548e-06 -0.0016684865599648
+ 8.55e-06 -0.001424363161647
+ 8.552e-06 -0.00150637632758788
+ 8.554e-06 -0.00175952147859784
+ 8.556e-06 -0.00163353559493615
+ 8.558e-06 -0.00115144770565834
+ 8.56e-06 -0.00109444927574242
+ 8.562e-06 -0.00132594171312803
+ 8.564e-06 -0.00152344282405435
+ 8.566e-06 -0.00147849534928222
+ 8.568e-06 -0.00143866689346391
+ 8.57e-06 -0.0013929918031328
+ 8.572e-06 -0.0013038116540093
+ 8.574e-06 -0.00106688552390778
+ 8.576e-06 -0.000831301261962537
+ 8.578e-06 -0.000548373887139612
+ 8.58e-06 -0.000408907360248697
+ 8.582e-06 -0.000621099410506391
+ 8.584e-06 -0.000718221282536531
+ 8.586e-06 -0.000936299030257916
+ 8.588e-06 -0.00106601731143613
+ 8.59e-06 -0.000710072651956001
+ 8.592e-06 -0.000546662546771204
+ 8.594e-06 -0.000664167166609606
+ 8.596e-06 -0.000823246893091523
+ 8.598e-06 -0.000916923848724564
+ 8.6e-06 -0.00103264264806948
+ 8.602e-06 -0.000989490064110091
+ 8.604e-06 -0.00113372577982217
+ 8.606e-06 -0.00101886655160423
+ 8.608e-06 -0.000923840980202003
+ 8.61e-06 -0.00111673662147011
+ 8.612e-06 -0.00099619158288349
+ 8.614e-06 -0.00117636032931429
+ 8.616e-06 -0.00110253901664289
+ 8.618e-06 -0.00127484694380218
+ 8.62e-06 -0.00154481931248819
+ 8.622e-06 -0.00132957557586306
+ 8.624e-06 -0.001643075814747
+ 8.626e-06 -0.00142346296329064
+ 8.628e-06 -0.00147943237770475
+ 8.63e-06 -0.00145307404168359
+ 8.632e-06 -0.0012259389914313
+ 8.634e-06 -0.00108019944202554
+ 8.636e-06 -0.000827855603150064
+ 8.638e-06 -0.000731215099797568
+ 8.64e-06 -0.000765947486386596
+ 8.642e-06 -0.000905465736751471
+ 8.644e-06 -0.00106792556553767
+ 8.646e-06 -0.000887711345948507
+ 8.648e-06 -0.000618960972951899
+ 8.65e-06 -0.000921371856331948
+ 8.652e-06 -0.00102155836854151
+ 8.654e-06 -0.000930786760224532
+ 8.656e-06 -0.000847139323141952
+ 8.658e-06 -0.000620431946427437
+ 8.66e-06 -0.000524834336806852
+ 8.662e-06 -0.000482214421012041
+ 8.664e-06 -0.000691913031680982
+ 8.666e-06 -0.000703209931016768
+ 8.668e-06 -0.000786714254356606
+ 8.67e-06 -0.00102525805084899
+ 8.672e-06 -0.000841217539783088
+ 8.674e-06 -0.000898874355164721
+ 8.676e-06 -0.000769493210267242
+ 8.678e-06 -0.000831697331209166
+ 8.68e-06 -0.00090778276226445
+ 8.682e-06 -0.00116944016474595
+ 8.684e-06 -0.00107242394615855
+ 8.686e-06 -0.00131031830859967
+ 8.688e-06 -0.00140868539422458
+ 8.69e-06 -0.00125054513093792
+ 8.692e-06 -0.00113939053372091
+ 8.694e-06 -0.00140074481307368
+ 8.696e-06 -0.00164479238184062
+ 8.698e-06 -0.00178693872975534
+ 8.7e-06 -0.00156552683055445
+ 8.702e-06 -0.00146204827555979
+ 8.704e-06 -0.00144302966365454
+ 8.706e-06 -0.00137297060879753
+ 8.708e-06 -0.0015527208233269
+ 8.71e-06 -0.00192116067853707
+ 8.712e-06 -0.00170737142714019
+ 8.714e-06 -0.00163008171312226
+ 8.716e-06 -0.00141631257043273
+ 8.718e-06 -0.00131532482362446
+ 8.72e-06 -0.00134099056982627
+ 8.722e-06 -0.0013793548963989
+ 8.724e-06 -0.00131778714390616
+ 8.726e-06 -0.00109543767756648
+ 8.728e-06 -0.000867623980517946
+ 8.73e-06 -0.000468936842189821
+ 8.732e-06 -0.000211628338856131
+ 8.734e-06 1.19114541009717e-05
+ 8.736e-06 -0.00021480718606248
+ 8.738e-06 0.000263039063940921
+ 8.74e-06 0.000142975351491389
+ 8.742e-06 -2.86286115171072e-05
+ 8.744e-06 9.24633467425042e-05
+ 8.746e-06 -8.58369679770613e-05
+ 8.748e-06 9.6216469814297e-05
+ 8.75e-06 -0.00019251192804092
+ 8.752e-06 -5.07311053524146e-05
+ 8.754e-06 -0.000132350737337886
+ 8.756e-06 -0.000286121741933916
+ 8.758e-06 -0.000395700219323898
+ 8.76e-06 -0.000374071159352821
+ 8.762e-06 -0.000136950967014978
+ 8.764e-06 -5.88179713259278e-05
+ 8.766e-06 0.000125116427184788
+ 8.768e-06 0.000274382513073116
+ 8.77e-06 0.000168490695185012
+ 8.772e-06 0.00013313483138278
+ 8.774e-06 4.63731722436165e-05
+ 8.776e-06 8.42781456098629e-05
+ 8.778e-06 0.000146856091158303
+ 8.78e-06 0.000122809865414344
+ 8.782e-06 -5.93891797444654e-05
+ 8.784e-06 0.000343042645598806
+ 8.786e-06 0.000132361928589034
+ 8.788e-06 0.000159505371631575
+ 8.79e-06 0.000344035929775733
+ 8.792e-06 0.000389161424201088
+ 8.794e-06 0.000599850681972228
+ 8.796e-06 0.000357404306249281
+ 8.798e-06 0.000126136250941766
+ 8.8e-06 -0.000430044527673016
+ 8.802e-06 -0.000211302500507083
+ 8.804e-06 4.10781375666682e-05
+ 8.806e-06 -0.000225837442584792
+ 8.808e-06 -0.000372392745923532
+ 8.81e-06 -0.000446621157867002
+ 8.812e-06 -0.000574216691087103
+ 8.814e-06 -0.000816322325121712
+ 8.816e-06 -0.000595588651601487
+ 8.818e-06 -0.00043950757798634
+ 8.82e-06 -0.000678752603911702
+ 8.822e-06 -0.00063161659223563
+ 8.824e-06 -0.000249697733305082
+ 8.826e-06 8.53297546280298e-05
+ 8.828e-06 -3.78474885782431e-05
+ 8.83e-06 -1.19774829255612e-05
+ 8.832e-06 0.000124468417315244
+ 8.834e-06 7.84992393847028e-05
+ 8.836e-06 -0.000139205358448216
+ 8.838e-06 -3.22911588544912e-05
+ 8.84e-06 -0.000469721821546482
+ 8.842e-06 -0.000406369080293335
+ 8.844e-06 -0.000755819177976611
+ 8.846e-06 -0.000516717674518167
+ 8.848e-06 -0.000709540813882769
+ 8.85e-06 -0.000680442673036327
+ 8.852e-06 -0.000794895033209249
+ 8.854e-06 -0.000824154312628386
+ 8.856e-06 -0.000744507218702461
+ 8.858e-06 -0.000952415096699339
+ 8.86e-06 -0.000681874844661313
+ 8.862e-06 -0.000709358817686759
+ 8.864e-06 -0.0010250249919005
+ 8.866e-06 -0.000983204718941136
+ 8.868e-06 -0.00148597106672697
+ 8.87e-06 -0.00155836326814661
+ 8.872e-06 -0.00146551749283992
+ 8.874e-06 -0.00134930250994639
+ 8.876e-06 -0.00134221224278489
+ 8.878e-06 -0.001362557592898
+ 8.88e-06 -0.00078585418734994
+ 8.882e-06 -0.000950658477821096
+ 8.884e-06 -0.000965567178799875
+ 8.886e-06 -0.00113872141774262
+ 8.888e-06 -0.00110886701033661
+ 8.89e-06 -0.000985375390083159
+ 8.892e-06 -0.000826228986699822
+ 8.894e-06 -0.000757538109052177
+ 8.896e-06 -0.000670657058666268
+ 8.898e-06 -0.000820969811270422
+ 8.9e-06 -0.000641457393203922
+ 8.902e-06 -0.000918100252598359
+ 8.904e-06 -0.00112000001323837
+ 8.906e-06 -0.0012003563977954
+ 8.908e-06 -0.00127082133375528
+ 8.91e-06 -0.00119866888564159
+ 8.912e-06 -0.00115837096063151
+ 8.914e-06 -0.00052201155064071
+ 8.916e-06 -0.000877107727401526
+ 8.918e-06 -0.00117792020247138
+ 8.92e-06 -0.001022974293828
+ 8.922e-06 -0.00131219218960787
+ 8.924e-06 -0.00135326372393228
+ 8.926e-06 -0.00148235960384026
+ 8.928e-06 -0.00194056472880625
+ 8.93e-06 -0.00160771634914192
+ 8.932e-06 -0.0017213144238361
+ 8.934e-06 -0.00163654067192659
+ 8.936e-06 -0.00178778476092371
+ 8.938e-06 -0.00189237704395752
+ 8.94e-06 -0.00203859895220681
+ 8.942e-06 -0.00187795864762074
+ 8.944e-06 -0.00186168774708283
+ 8.946e-06 -0.00173216299745382
+ 8.948e-06 -0.00198353707577395
+ 8.95e-06 -0.00176768262778853
+ 8.952e-06 -0.00134681204673958
+ 8.954e-06 -0.00149395236785416
+ 8.956e-06 -0.00133655675976524
+ 8.958e-06 -0.00100394544713374
+ 8.96e-06 -0.000846851917032843
+ 8.962e-06 -0.000890451283907297
+ 8.964e-06 -0.00126341782908137
+ 8.966e-06 -0.00100218790396779
+ 8.968e-06 -0.00098213209573822
+ 8.97e-06 -0.000804816295409689
+ 8.972e-06 -0.000393212109051811
+ 8.974e-06 -0.000616731318729382
+ 8.976e-06 -0.000395845276565488
+ 8.978e-06 -0.000745230834752655
+ 8.98e-06 -0.00097925751858858
+ 8.982e-06 -0.00087518161225961
+ 8.984e-06 -0.000664569657475906
+ 8.986e-06 -0.000468428009065729
+ 8.988e-06 -0.000482151998620022
+ 8.99e-06 -0.000505951062800268
+ 8.992e-06 -0.000766098893982184
+ 8.994e-06 -0.000575893005153812
+ 8.996e-06 -1.86200759098434e-05
+ 8.998e-06 0.000330386337528067
+ 9e-06 0.00011242418036739
+ 9.002e-06 1.46419233422219e-05
+ 9.004e-06 7.85946947563334e-05
+ 9.006e-06 -9.21735569105953e-05
+ 9.008e-06 0.000209219917441911
+ 9.01e-06 0.000376691996761228
+ 9.012e-06 0.000624739845341024
+ 9.014e-06 0.000507254805106567
+ 9.016e-06 0.000373154146583276
+ 9.018e-06 0.00056545423319911
+ 9.02e-06 0.000669410093901805
+ 9.022e-06 0.000631146899600527
+ 9.024e-06 0.00063414964973068
+ 9.026e-06 0.000721458980538063
+ 9.028e-06 0.000803764957421759
+ 9.03e-06 0.000967951771661866
+ 9.032e-06 0.00100173312846601
+ 9.034e-06 0.00115524731708012
+ 9.036e-06 0.00133561498050793
+ 9.038e-06 0.00148096409806846
+ 9.04e-06 0.00110358064588469
+ 9.042e-06 0.000880662221766616
+ 9.044e-06 0.000614331098885692
+ 9.046e-06 0.000391243304247338
+ 9.048e-06 0.000503067242325318
+ 9.05e-06 0.000362152500998042
+ 9.052e-06 0.000506322780697241
+ 9.054e-06 0.00065936247437981
+ 9.056e-06 0.000599713819234342
+ 9.058e-06 0.000948257366793216
+ 9.06e-06 0.000541508306244636
+ 9.062e-06 0.000782458545608755
+ 9.064e-06 0.000523271221254101
+ 9.066e-06 0.000565263201144127
+ 9.068e-06 0.000512027473125407
+ 9.07e-06 0.00057477066210602
+ 9.072e-06 0.000340673583743164
+ 9.074e-06 0.000446881495976058
+ 9.076e-06 0.000344321038896417
+ 9.078e-06 0.000421183843126768
+ 9.08e-06 0.000416131944167832
+ 9.082e-06 0.000263327383710505
+ 9.084e-06 0.000216318519150572
+ 9.086e-06 -3.38232029013479e-05
+ 9.088e-06 -3.94222993130815e-05
+ 9.09e-06 -6.04624078111953e-05
+ 9.092e-06 -0.000149728449900765
+ 9.094e-06 -0.00014086474086807
+ 9.096e-06 -0.000275872400751257
+ 9.098e-06 -0.000477649989960917
+ 9.1e-06 -0.000606628327775459
+ 9.102e-06 -0.000469766648422009
+ 9.104e-06 -0.000468400557736106
+ 9.106e-06 -0.000588193085657858
+ 9.108e-06 -0.000610403553406611
+ 9.11e-06 -0.000341737999482177
+ 9.112e-06 -0.000211099338785785
+ 9.114e-06 0.000144522100824076
+ 9.116e-06 1.86485292392389e-05
+ 9.118e-06 -0.000383303599838154
+ 9.12e-06 -0.000324952445105961
+ 9.122e-06 -0.000187579278987327
+ 9.124e-06 -0.000349151157105975
+ 9.126e-06 -0.00041028679891469
+ 9.128e-06 0.000144503654142923
+ 9.13e-06 0.00037040394266774
+ 9.132e-06 0.000431967900750752
+ 9.134e-06 0.000339993743714689
+ 9.136e-06 0.00042679868585989
+ 9.138e-06 0.000640687946012049
+ 9.14e-06 0.000293124491390507
+ 9.142e-06 0.000423936609127027
+ 9.144e-06 0.000370040689998119
+ 9.146e-06 0.000256552773233731
+ 9.148e-06 0.000463320879079536
+ 9.15e-06 0.000788375253251925
+ 9.152e-06 0.000506418951873182
+ 9.154e-06 0.000460920584376349
+ 9.156e-06 0.000483158507268102
+ 9.158e-06 0.000592525010239274
+ 9.16e-06 0.000559682420203399
+ 9.162e-06 0.000427735592911438
+ 9.164e-06 0.000330650188821375
+ 9.166e-06 0.000437237196717709
+ 9.168e-06 0.000259478990654536
+ 9.17e-06 0.000158151987313698
+ 9.172e-06 0.000296580254231835
+ 9.174e-06 0.000213790617976289
+ 9.176e-06 0.000567464980160291
+ 9.178e-06 0.000526886116737033
+ 9.18e-06 0.000438537884771588
+ 9.182e-06 0.000485129736957129
+ 9.184e-06 6.77601259474833e-05
+ 9.186e-06 -0.000414259578920745
+ 9.188e-06 -0.000268400824898857
+ 9.19e-06 -0.000466816991820034
+ 9.192e-06 -0.000356199815281703
+ 9.194e-06 -0.00024703493210189
+ 9.196e-06 -0.000289468826380355
+ 9.198e-06 -0.000496587874201845
+ 9.2e-06 -0.000577530382835752
+ 9.202e-06 -0.000536957719253006
+ 9.204e-06 -0.000390642042080508
+ 9.206e-06 -0.000587643796218931
+ 9.208e-06 -0.000413040349776826
+ 9.21e-06 -0.000161710782598625
+ 9.212e-06 -0.000426209274129462
+ 9.214e-06 -0.0003559555370981
+ 9.216e-06 -9.94001437725163e-05
+ 9.218e-06 -9.36588565284206e-05
+ 9.22e-06 -0.00026005985712411
+ 9.222e-06 -0.000361147045197261
+ 9.224e-06 -0.000350583049303518
+ 9.226e-06 -0.000160680802175436
+ 9.228e-06 8.49587631690126e-05
+ 9.23e-06 0.000283973932230052
+ 9.232e-06 0.00030861079533097
+ 9.234e-06 0.000300905725717505
+ 9.236e-06 0.000754714478413271
+ 9.238e-06 0.000830783256179733
+ 9.24e-06 0.00101449037009007
+ 9.242e-06 0.000933762620707857
+ 9.244e-06 0.000734644619299761
+ 9.246e-06 0.000919331819857234
+ 9.248e-06 0.000957831369801268
+ 9.25e-06 0.000784020668498805
+ 9.252e-06 0.000356079423158325
+ 9.254e-06 0.000229070497465155
+ 9.256e-06 0.000203436526466542
+ 9.258e-06 6.17388844821571e-05
+ 9.26e-06 0.000307979558316136
+ 9.262e-06 0.000512036065643846
+ 9.264e-06 0.000506135624644013
+ 9.266e-06 0.000676087993232022
+ 9.268e-06 0.000300120591707504
+ 9.27e-06 0.000195377131437734
+ 9.272e-06 0.000119865912416778
+ 9.274e-06 0.000317826438791867
+ 9.276e-06 6.30000070897144e-05
+ 9.278e-06 -2.23002500901287e-05
+ 9.28e-06 8.18669430359546e-05
+ 9.282e-06 -0.000248213121431758
+ 9.284e-06 -0.000313303114016962
+ 9.286e-06 4.76058195725899e-05
+ 9.288e-06 0.0002172248615171
+ 9.29e-06 5.40025679351833e-05
+ 9.292e-06 0.000308065358041622
+ 9.294e-06 0.000323536414348861
+ 9.296e-06 0.000382173893116636
+ 9.298e-06 0.000391515429873336
+ 9.3e-06 0.000282691304060089
+ 9.302e-06 0.000156152626395198
+ 9.304e-06 -0.000113992454154565
+ 9.306e-06 -7.64334625824144e-05
+ 9.308e-06 -0.00043748937228419
+ 9.31e-06 -0.000560251942840254
+ 9.312e-06 -0.000558582606372762
+ 9.314e-06 -0.000642469769674188
+ 9.316e-06 -0.000703355784715506
+ 9.318e-06 -0.000821262524817866
+ 9.32e-06 -0.000996220534813121
+ 9.322e-06 -0.00130110867328794
+ 9.324e-06 -0.00149904921982623
+ 9.326e-06 -0.00116899554974015
+ 9.328e-06 -0.00109168326660324
+ 9.33e-06 -0.00099273855887411
+ 9.332e-06 -0.00108325127943827
+ 9.334e-06 -0.00112887956260797
+ 9.336e-06 -0.00131694528557189
+ 9.338e-06 -0.00122277999498221
+ 9.34e-06 -0.0010230102987156
+ 9.342e-06 -0.000947169725521141
+ 9.344e-06 -0.000850249151380897
+ 9.346e-06 -0.000918369254181737
+ 9.348e-06 -0.000850866354940145
+ 9.35e-06 -0.000713867221762191
+ 9.352e-06 -0.00102179923781199
+ 9.354e-06 -0.000765148520404893
+ 9.356e-06 -0.0004850582900927
+ 9.358e-06 -0.000104266917312578
+ 9.36e-06 -2.10224333237051e-05
+ 9.362e-06 -0.000499128835585155
+ 9.364e-06 -0.000183631209570141
+ 9.366e-06 -0.000160076289895492
+ 9.368e-06 -4.06786506761543e-05
+ 9.37e-06 -0.00015203464316398
+ 9.372e-06 -0.000161041325789248
+ 9.374e-06 1.06514338603518e-05
+ 9.376e-06 -0.00012227308542452
+ 9.378e-06 -0.000195703227278537
+ 9.38e-06 -0.000126905813859907
+ 9.382e-06 0.000108758245796918
+ 9.384e-06 0.000249950007104825
+ 9.386e-06 0.000258677832233105
+ 9.388e-06 -0.000107968950474547
+ 9.39e-06 -6.35105213142324e-05
+ 9.392e-06 -7.42249418143822e-05
+ 9.394e-06 3.72974446466264e-05
+ 9.396e-06 0.000244614413866081
+ 9.398e-06 3.95533377681375e-05
+ 9.4e-06 0.000109116041388373
+ 9.402e-06 -0.000158897296384688
+ 9.404e-06 -0.000143347383751482
+ 9.406e-06 -0.000226926078404837
+ 9.408e-06 -0.000462865832972781
+ 9.41e-06 -0.000597565150308131
+ 9.412e-06 -0.00104782533384152
+ 9.414e-06 -0.00095165229241908
+ 9.416e-06 -0.000708197711540519
+ 9.418e-06 -0.00090956971341861
+ 9.42e-06 -0.000990952689319979
+ 9.422e-06 -0.00086775919790271
+ 9.424e-06 -0.00084850039547692
+ 9.426e-06 -0.000883043797622607
+ 9.428e-06 -0.00105822600090213
+ 9.43e-06 -0.000658853056842986
+ 9.432e-06 -0.000641923192055575
+ 9.434e-06 -0.000688116739591977
+ 9.436e-06 -0.000549367189653509
+ 9.438e-06 -0.000572273961328922
+ 9.44e-06 -0.000446835686752572
+ 9.442e-06 -0.000893015963047926
+ 9.444e-06 -0.000598242249668948
+ 9.446e-06 -0.000632925753196559
+ 9.448e-06 -0.000632247270428118
+ 9.45e-06 -0.000451719753037815
+ 9.452e-06 -0.000685049187742445
+ 9.454e-06 -0.000581696666859144
+ 9.456e-06 -0.000702370444808151
+ 9.458e-06 -0.000897953119305416
+ 9.46e-06 -0.000970069028567203
+ 9.462e-06 -0.0010321703314878
+ 9.464e-06 -0.000883576383454613
+ 9.466e-06 -0.000525642361796144
+ 9.468e-06 -0.000454042483855453
+ 9.47e-06 -0.000303221625550601
+ 9.472e-06 -0.000344008113992928
+ 9.474e-06 -0.000400241451670979
+ 9.476e-06 -0.000166670550533738
+ 9.478e-06 -8.41971584708305e-05
+ 9.48e-06 -0.000158184556676835
+ 9.482e-06 -0.000111418794144142
+ 9.484e-06 4.56086509727756e-05
+ 9.486e-06 -9.35575601398886e-05
+ 9.488e-06 0.000226015776338379
+ 9.49e-06 0.000355088180237698
+ 9.492e-06 0.000590527572597156
+ 9.494e-06 0.000660015612650633
+ 9.496e-06 0.000646896209169402
+ 9.498e-06 0.000791093560769653
+ 9.5e-06 0.000678498093389798
+ 9.502e-06 0.000782845966381317
+ 9.504e-06 0.000687557543064723
+ 9.506e-06 0.000426325755695478
+ 9.508e-06 0.00012514071776147
+ 9.51e-06 -0.000110473623861673
+ 9.512e-06 -6.33922204980227e-05
+ 9.514e-06 -2.93972248948254e-07
+ 9.516e-06 -0.000161186011290505
+ 9.518e-06 -0.000307053420223421
+ 9.52e-06 -0.000244533457907496
+ 9.522e-06 -0.000335784659892543
+ 9.524e-06 -6.07070841157226e-05
+ 9.526e-06 0.000146377489702201
+ 9.528e-06 1.64906247378601e-05
+ 9.53e-06 -0.000261720771926963
+ 9.532e-06 -0.000103462519375111
+ 9.534e-06 -0.00026720333625693
+ 9.536e-06 -0.000128506174173214
+ 9.538e-06 2.3252273474797e-05
+ 9.54e-06 -0.00014358740570488
+ 9.542e-06 -0.000320541328806076
+ 9.544e-06 -0.00038787450483723
+ 9.546e-06 -0.000247001873134235
+ 9.548e-06 -0.000129621461312882
+ 9.55e-06 -6.55911201746454e-05
+ 9.552e-06 0.000275462113380591
+ 9.554e-06 0.000246796392469425
+ 9.556e-06 0.000252566511719098
+ 9.558e-06 0.000633321293778781
+ 9.56e-06 0.000605253130947549
+ 9.562e-06 0.000315413138036409
+ 9.564e-06 0.000272902816613259
+ 9.566e-06 0.000546912541886387
+ 9.568e-06 0.000525642370621904
+ 9.57e-06 0.000483613981386174
+ 9.572e-06 0.000898148263658525
+ 9.574e-06 0.000837910288494866
+ 9.576e-06 0.0010753667517308
+ 9.578e-06 0.0010207645868226
+ 9.58e-06 0.000818992557754569
+ 9.582e-06 0.00104103186435425
+ 9.584e-06 0.00109479215403566
+ 9.586e-06 0.000977761108259411
+ 9.588e-06 0.000712157953434767
+ 9.59e-06 0.000645180702857387
+ 9.592e-06 0.000731291349002267
+ 9.594e-06 0.00107345016266418
+ 9.596e-06 0.00117964408623289
+ 9.598e-06 0.00122456838923163
+ 9.6e-06 0.00128269736713936
+ 9.602e-06 0.00146373206443111
+ 9.604e-06 0.0013424676205458
+ 9.606e-06 0.00138820561804698
+ 9.608e-06 0.00150768398679835
+ 9.61e-06 0.00157272921399574
+ 9.612e-06 0.00170161470050335
+ 9.614e-06 0.00147557446730779
+ 9.616e-06 0.00145771887286894
+ 9.618e-06 0.00126519199469012
+ 9.62e-06 0.00144109040749373
+ 9.622e-06 0.00133782393496023
+ 9.624e-06 0.00112675610117823
+ 9.626e-06 0.00121111474264378
+ 9.628e-06 0.00100822469519394
+ 9.63e-06 0.00116806506659665
+ 9.632e-06 0.00131014965171518
+ 9.634e-06 0.00127618567883482
+ 9.636e-06 0.00119937967868993
+ 9.638e-06 0.00114290378210848
+ 9.64e-06 0.000839006963192415
+ 9.642e-06 0.000829822004820846
+ 9.644e-06 0.000916331251612265
+ 9.646e-06 0.0011674388382104
+ 9.648e-06 0.00100506352534993
+ 9.65e-06 0.000911575148818986
+ 9.652e-06 0.000992268983383388
+ 9.654e-06 0.00108979022702473
+ 9.656e-06 0.00121828190268376
+ 9.658e-06 0.00127945668374465
+ 9.66e-06 0.00139025582084998
+ 9.662e-06 0.00146719470301634
+ 9.664e-06 0.0012692524845712
+ 9.666e-06 0.000961007347666052
+ 9.668e-06 0.000893111684012592
+ 9.67e-06 0.000888813979383923
+ 9.672e-06 0.000526938484044968
+ 9.674e-06 0.00038431032106911
+ 9.676e-06 0.000599084713839338
+ 9.678e-06 0.000466990372914016
+ 9.68e-06 0.000538426955826467
+ 9.682e-06 0.000456754418141407
+ 9.684e-06 0.000242858562145939
+ 9.686e-06 3.46701490954443e-05
+ 9.688e-06 -0.00023402598999893
+ 9.69e-06 -0.000365901374769161
+ 9.692e-06 -4.18011255133563e-05
+ 9.694e-06 9.83497789188357e-05
+ 9.696e-06 1.54959395330914e-05
+ 9.698e-06 2.3701735891644e-05
+ 9.7e-06 -3.44544265593969e-05
+ 9.702e-06 0.000168367005605901
+ 9.704e-06 0.00024851900700037
+ 9.706e-06 5.85759110623525e-05
+ 9.708e-06 -0.000126878445341949
+ 9.71e-06 -0.000448706286490699
+ 9.712e-06 -0.000605152875554765
+ 9.714e-06 -0.000504778165482435
+ 9.716e-06 -0.000887113454085242
+ 9.718e-06 -0.0010714422693524
+ 9.72e-06 -0.000788874475491894
+ 9.722e-06 -0.000623384502203088
+ 9.724e-06 -0.000969541863926232
+ 9.726e-06 -0.000892430445411452
+ 9.728e-06 -0.000895709713586689
+ 9.73e-06 -0.000697535254437006
+ 9.732e-06 -0.000634435430469012
+ 9.734e-06 -0.000664160490839234
+ 9.736e-06 -0.000314890904272418
+ 9.738e-06 -0.000680246784913941
+ 9.74e-06 -0.000840501263402993
+ 9.742e-06 -0.00106170283915766
+ 9.744e-06 -0.00123429406040599
+ 9.746e-06 -0.00117537683132845
+ 9.748e-06 -0.00112574803729088
+ 9.75e-06 -0.00121318871668159
+ 9.752e-06 -0.000986015785834912
+ 9.754e-06 -0.000817758239556673
+ 9.756e-06 -0.000695057376866534
+ 9.758e-06 -0.000744996942635928
+ 9.76e-06 -0.0012197615360469
+ 9.762e-06 -0.00123342763185384
+ 9.764e-06 -0.00126492061248588
+ 9.766e-06 -0.00123310175655311
+ 9.768e-06 -0.00117741499986348
+ 9.77e-06 -0.000738637906930369
+ 9.772e-06 -0.000536666720847297
+ 9.774e-06 -0.000550572097890915
+ 9.776e-06 -0.000313500409636788
+ 9.778e-06 -0.000102200980786624
+ 9.78e-06 -0.000214408143194231
+ 9.782e-06 -0.000106704189501626
+ 9.784e-06 2.58899143344102e-06
+ 9.786e-06 -2.29670998648567e-05
+ 9.788e-06 -0.000119980761717891
+ 9.79e-06 -1.27062032087967e-06
+ 9.792e-06 -3.85170894691401e-05
+ 9.794e-06 -0.000129947963089958
+ 9.796e-06 -0.000279171247600759
+ 9.798e-06 0.000180563356041462
+ 9.8e-06 0.000337913910065653
+ 9.802e-06 0.000665465628661845
+ 9.804e-06 0.000738793105967036
+ 9.806e-06 0.000968900202751177
+ 9.808e-06 0.00137673530695983
+ 9.81e-06 0.00168260247750731
+ 9.812e-06 0.00139313023417202
+ 9.814e-06 0.00139874803919918
+ 9.816e-06 0.00143031265621335
+ 9.818e-06 0.0012929144304849
+ 9.82e-06 0.00142584670092403
+ 9.822e-06 0.00163825914430405
+ 9.824e-06 0.00184270783047198
+ 9.826e-06 0.00184335207067076
+ 9.828e-06 0.00159674229956202
+ 9.83e-06 0.00149043658450278
+ 9.832e-06 0.00158766200270743
+ 9.834e-06 0.00117331743851072
+ 9.836e-06 0.00105117392887129
+ 9.838e-06 0.00123731288402381
+ 9.84e-06 0.000959556731988104
+ 9.842e-06 0.00064661670623793
+ 9.844e-06 0.00041622393061229
+ 9.846e-06 0.000518527749074833
+ 9.848e-06 0.000373098903992296
+ 9.85e-06 0.000457274106066958
+ 9.852e-06 0.00060807175598502
+ 9.854e-06 0.000765587965550452
+ 9.856e-06 0.000619681584186085
+ 9.858e-06 0.000487577899721972
+ 9.86e-06 0.000677822686578618
+ 9.862e-06 0.000847988967741329
+ 9.864e-06 0.000799407508628417
+ 9.866e-06 0.000797411740809965
+ 9.868e-06 0.000688086417607278
+ 9.87e-06 0.000672560201602177
+ 9.872e-06 0.000711741288423067
+ 9.874e-06 0.000427682421554247
+ 9.876e-06 0.000321841172457148
+ 9.878e-06 0.000677275613567452
+ 9.88e-06 0.000470313162924762
+ 9.882e-06 0.000370261858073945
+ 9.884e-06 0.000263204511180153
+ 9.886e-06 -5.08790802776725e-05
+ 9.888e-06 0.000245741307623146
+ 9.89e-06 -5.83902917771146e-05
+ 9.892e-06 9.71033972665995e-05
+ 9.894e-06 0.000124347178943871
+ 9.896e-06 4.99461291746043e-05
+ 9.898e-06 -8.77852010061055e-05
+ 9.9e-06 -0.000327687931479836
+ 9.902e-06 -0.000428151784925998
+ 9.904e-06 -0.000329902006927453
+ 9.906e-06 -0.000445448302473787
+ 9.908e-06 -0.000904219786875285
+ 9.91e-06 -0.000733825844047908
+ 9.912e-06 -0.0010375262253641
+ 9.914e-06 -0.000889774821345402
+ 9.916e-06 -0.00107177826196125
+ 9.918e-06 -0.0010929982807006
+ 9.92e-06 -0.000800747312253138
+ 9.922e-06 -0.000436147460606356
+ 9.924e-06 9.36246495474959e-05
+ 9.926e-06 0.000151390547030879
+ 9.928e-06 1.91697199953718e-05
+ 9.93e-06 0.000193518005810569
+ 9.932e-06 -3.59779078823969e-05
+ 9.934e-06 0.000333680601329754
+ 9.936e-06 -2.02006787442234e-05
+ 9.938e-06 -7.06484546645e-07
+ 9.94e-06 -0.000215252138636559
+ 9.942e-06 0.000101841288313518
+ 9.944e-06 0.000267382547241858
+ 9.946e-06 0.000192581392807909
+ 9.948e-06 0.000462613825361976
+ 9.95e-06 0.000463737436796809
+ 9.952e-06 0.000373486475678029
+ 9.954e-06 9.76928825500137e-05
+ 9.956e-06 -0.000198748186978661
+ 9.958e-06 -0.00036085598028506
+ 9.96e-06 0.000123264059242954
+ 9.962e-06 0.000215786138364778
+ 9.964e-06 0.000227429394483131
+ 9.966e-06 0.000259354935557372
+ 9.968e-06 -4.98867944979025e-05
+ 9.97e-06 0.000115231957536349
+ 9.972e-06 -1.76084967475263e-05
+ 9.974e-06 0.000180954820305525
+ 9.976e-06 0.00021259069101364
+ 9.978e-06 0.000247235881663918
+ 9.98e-06 0.000355688814418871
+ 9.982e-06 0.000388383256265439
+ 9.984e-06 0.00026348977600834
+ 9.986e-06 4.4158903241553e-05
+ 9.988e-06 4.22641637040151e-05
+ 9.99e-06 -0.000141417720587199
+ 9.992e-06 -0.00051944896000683
+ 9.994e-06 -0.000673668516003927
+ 9.996e-06 -0.000988895608501435
+ 9.998e-06 -0.00093443813154463
+ 1e-05 -0.00105537046140759
+ 1.0002e-05 -0.000670415330204751
+ 1.0004e-05 -0.000793105337101039
+ 1.0006e-05 -0.000537293930125077
+ 1.0008e-05 -0.000890670545463546
+ 1.001e-05 -0.000694003793861559
+ 1.0012e-05 -0.000321242863868632
+ 1.0014e-05 -0.000268308132222304
+ 1.0016e-05 -0.000183333809531108
+ 1.0018e-05 -0.000437125661177649
+ 1.002e-05 -0.000655730444196959
+ 1.0022e-05 -0.000818107746991576
+ 1.0024e-05 -0.00082269508183434
+ 1.0026e-05 -0.000864515063173367
+ 1.0028e-05 -0.000910635666725647
+ 1.003e-05 -0.000558394508026272
+ 1.0032e-05 -0.000525899023633634
+ 1.0034e-05 -0.000633345688429721
+ 1.0036e-05 -0.000702968868448313
+ 1.0038e-05 -0.000827469809375436
+ 1.004e-05 -0.000774983185801687
+ 1.0042e-05 -0.000679159710213685
+ 1.0044e-05 -0.000981255058346374
+ 1.0046e-05 -0.00101582894611809
+ 1.0048e-05 -0.0010054068133224
+ 1.005e-05 -0.00126603158678023
+ 1.0052e-05 -0.00131324389260004
+ 1.0054e-05 -0.00123813207457124
+ 1.0056e-05 -0.00114872659446432
+ 1.0058e-05 -0.000822323737888695
+ 1.006e-05 -0.000785132845026576
+ 1.0062e-05 -0.000622417160902203
+ 1.0064e-05 -0.000871483311053852
+ 1.0066e-05 -0.000659789139491499
+ 1.0068e-05 -0.00083909818758273
+ 1.007e-05 -0.000878490637580283
+ 1.0072e-05 -0.00101054383067738
+ 1.0074e-05 -0.0011431332022496
+ 1.0076e-05 -0.00098576977812021
+ 1.0078e-05 -0.00119871112480285
+ 1.008e-05 -0.00107878082143541
+ 1.0082e-05 -0.00118714973024946
+ 1.0084e-05 -0.000874231234409832
+ 1.0086e-05 -0.000731064455343937
+ 1.0088e-05 -0.000262528457704876
+ 1.009e-05 -0.000108301412651464
+ 1.0092e-05 3.20234819437059e-05
+ 1.0094e-05 0.000292575924903917
+ 1.0096e-05 0.000149690201695048
+ 1.0098e-05 -3.26159389367161e-05
+ 1.01e-05 4.29342114983816e-05
+ 1.0102e-05 -0.000191362609102373
+ 1.0104e-05 -0.000375010058663857
+ 1.0106e-05 -0.000412324985288638
+ 1.0108e-05 -0.000233124915207288
+ 1.011e-05 -0.000423338771081894
+ 1.0112e-05 -0.000239374815431047
+ 1.0114e-05 -0.000452165270123609
+ 1.0116e-05 -0.000557562839258006
+ 1.0118e-05 -0.000404126840482616
+ 1.012e-05 -0.000258861455052647
+ 1.0122e-05 -0.000244687263309614
+ 1.0124e-05 -0.000504369078406901
+ 1.0126e-05 -0.000219899523383375
+ 1.0128e-05 -8.09935444801934e-05
+ 1.013e-05 -0.000245204693109329
+ 1.0132e-05 -0.000438218116182745
+ 1.0134e-05 -0.000523782211174161
+ 1.0136e-05 -0.000390023201808611
+ 1.0138e-05 -0.000320578441431172
+ 1.014e-05 -0.000162018559551471
+ 1.0142e-05 -0.000221333606176002
+ 1.0144e-05 -0.000228232835950178
+ 1.0146e-05 -2.71579687737231e-06
+ 1.0148e-05 -4.63883180484835e-05
+ 1.015e-05 -0.000221956313591631
+ 1.0152e-05 -0.000328472163630864
+ 1.0154e-05 -0.000192454546695092
+ 1.0156e-05 0.000421913604001841
+ 1.0158e-05 0.000406668072907843
+ 1.016e-05 0.000474564833986193
+ 1.0162e-05 0.000434970459835945
+ 1.0164e-05 0.000284825803554374
+ 1.0166e-05 0.000757532568261648
+ 1.0168e-05 0.000785294483834522
+ 1.017e-05 0.000191616733055346
+ 1.0172e-05 9.86317071257051e-05
+ 1.0174e-05 0.000221788287588637
+ 1.0176e-05 0.000152192171977575
+ 1.0178e-05 9.18737933714549e-05
+ 1.018e-05 -0.000103450333449386
+ 1.0182e-05 -0.000178267593469993
+ 1.0184e-05 -0.00041287787235929
+ 1.0186e-05 -0.000486007213755174
+ 1.0188e-05 -0.000360111616770324
+ 1.019e-05 -0.00042722883435839
+ 1.0192e-05 -0.000497971649694837
+ 1.0194e-05 -0.000510259627779542
+ 1.0196e-05 -0.000486417798588665
+ 1.0198e-05 -0.00060560590339695
+ 1.02e-05 -0.000703307227361441
+ 1.0202e-05 -0.000646823952679433
+ 1.0204e-05 -0.000827467329599103
+ 1.0206e-05 -0.000889119271040649
+ 1.0208e-05 -0.00120393309801093
+ 1.021e-05 -0.00129230754651889
+ 1.0212e-05 -0.00145687623675411
+ 1.0214e-05 -0.00134599840073167
+ 1.0216e-05 -0.00158111189520036
+ 1.0218e-05 -0.00174160176349042
+ 1.022e-05 -0.00185497653068119
+ 1.0222e-05 -0.00178867266834443
+ 1.0224e-05 -0.0016575565054861
+ 1.0226e-05 -0.00141895124893696
+ 1.0228e-05 -0.00102786319396138
+ 1.023e-05 -0.000924414803667982
+ 1.0232e-05 -0.00109177530711898
+ 1.0234e-05 -0.000866125627097194
+ 1.0236e-05 -0.000960963317042628
+ 1.0238e-05 -0.00108841229032626
+ 1.024e-05 -0.00122649416327069
+ 1.0242e-05 -0.00134500896697863
+ 1.0244e-05 -0.00146195893803789
+ 1.0246e-05 -0.00149976525106871
+ 1.0248e-05 -0.00112621921528427
+ 1.025e-05 -0.0010780858516444
+ 1.0252e-05 -0.00118366892565585
+ 1.0254e-05 -0.00125448602136921
+ 1.0256e-05 -0.0014022892675667
+ 1.0258e-05 -0.00158754244173616
+ 1.026e-05 -0.00170611847031126
+ 1.0262e-05 -0.00179130395243122
+ 1.0264e-05 -0.00187992111265686
+ 1.0266e-05 -0.00187260472922858
+ 1.0268e-05 -0.00200133786380193
+ 1.027e-05 -0.00192458530060201
+ 1.0272e-05 -0.00192292335401945
+ 1.0274e-05 -0.00219054339376823
+ 1.0276e-05 -0.0022026059682923
+ 1.0278e-05 -0.00206510714099304
+ 1.028e-05 -0.00219906873751117
+ 1.0282e-05 -0.00189381413312768
+ 1.0284e-05 -0.00200139789292281
+ 1.0286e-05 -0.00199340103686702
+ 1.0288e-05 -0.00176159149100728
+ 1.029e-05 -0.00201099691549119
+ 1.0292e-05 -0.00212021628123353
+ 1.0294e-05 -0.00196208661209215
+ 1.0296e-05 -0.00231459918239341
+ 1.0298e-05 -0.00219109655664025
+ 1.03e-05 -0.00235111901991163
+ 1.0302e-05 -0.00264130679732155
+ 1.0304e-05 -0.00294703480654156
+ 1.0306e-05 -0.00260954121627995
+ 1.0308e-05 -0.00246692669305475
+ 1.031e-05 -0.00246056851349899
+ 1.0312e-05 -0.00217505146750573
+ 1.0314e-05 -0.00210358890000822
+ 1.0316e-05 -0.00200560721526673
+ 1.0318e-05 -0.00190631741661386
+ 1.032e-05 -0.00118514110617954
+ 1.0322e-05 -0.00143191755994665
+ 1.0324e-05 -0.00120552863337372
+ 1.0326e-05 -0.00154996872328782
+ 1.0328e-05 -0.00172232313836727
+ 1.033e-05 -0.00155207024420262
+ 1.0332e-05 -0.00150424547704941
+ 1.0334e-05 -0.00143724252175907
+ 1.0336e-05 -0.00109909945679537
+ 1.0338e-05 -0.00114155027455904
+ 1.034e-05 -0.00135894383310919
+ 1.0342e-05 -0.000946057246082677
+ 1.0344e-05 -0.000738769096660018
+ 1.0346e-05 -0.000760817478199383
+ 1.0348e-05 -0.000649105639511439
+ 1.035e-05 -0.000423185567879177
+ 1.0352e-05 -0.000503793333884762
+ 1.0354e-05 -0.000119763526225339
+ 1.0356e-05 6.5355864827923e-05
+ 1.0358e-05 0.000175662354488227
+ 1.036e-05 2.49559104719318e-05
+ 1.0362e-05 -0.000108315071118205
+ 1.0364e-05 0.000321853013089389
+ 1.0366e-05 3.64382966333002e-05
+ 1.0368e-05 -0.000239527175572749
+ 1.037e-05 -0.000145216984448634
+ 1.0372e-05 0.000221653105271627
+ 1.0374e-05 0.000190370204664555
+ 1.0376e-05 0.000370413150631392
+ 1.0378e-05 0.000351106645961006
+ 1.038e-05 0.000432643997185325
+ 1.0382e-05 0.000104363398081032
+ 1.0384e-05 -0.000231565709669865
+ 1.0386e-05 -0.000131515123524046
+ 1.0388e-05 0.000209786462796776
+ 1.039e-05 -0.000104750609667632
+ 1.0392e-05 5.19727630827929e-05
+ 1.0394e-05 0.000155557537336823
+ 1.0396e-05 -1.65721774425265e-05
+ 1.0398e-05 -0.000131854524613705
+ 1.04e-05 -0.000360838166486694
+ 1.0402e-05 -0.000647638341771458
+ 1.0404e-05 -0.000918332308639224
+ 1.0406e-05 -0.000781579251191127
+ 1.0408e-05 -0.000820798532981523
+ 1.041e-05 -0.00103432516424232
+ 1.0412e-05 -0.00119546639108328
+ 1.0414e-05 -0.00115933785969532
+ 1.0416e-05 -0.00118433060272635
+ 1.0418e-05 -0.00121962156031914
+ 1.042e-05 -0.00134056955674013
+ 1.0422e-05 -0.00104135547012746
+ 1.0424e-05 -0.00110108088675109
+ 1.0426e-05 -0.000736599550592351
+ 1.0428e-05 -0.000786744322906469
+ 1.043e-05 -0.000835314425807389
+ 1.0432e-05 -0.000779424572088137
+ 1.0434e-05 -0.000595380280582448
+ 1.0436e-05 -0.000539556518373073
+ 1.0438e-05 -0.000438387516967879
+ 1.044e-05 -0.000507752373469335
+ 1.0442e-05 -0.000533248074279946
+ 1.0444e-05 -0.000397090754811847
+ 1.0446e-05 -0.000702667793447947
+ 1.0448e-05 -0.00046082997058504
+ 1.045e-05 -0.000427389325985748
+ 1.0452e-05 -0.000404321540911697
+ 1.0454e-05 -0.000589079470035112
+ 1.0456e-05 -0.000422058690983762
+ 1.0458e-05 -0.000447957208813772
+ 1.046e-05 -0.000771195449097383
+ 1.0462e-05 -0.000773281190896591
+ 1.0464e-05 -0.000855844030730799
+ 1.0466e-05 -0.00103088087750849
+ 1.0468e-05 -0.000922506435975975
+ 1.047e-05 -0.000682226077216613
+ 1.0472e-05 -0.000363597616576729
+ 1.0474e-05 -0.000329514643088328
+ 1.0476e-05 -0.000510793152896115
+ 1.0478e-05 -0.000573862589486644
+ 1.048e-05 -0.000550251453745723
+ 1.0482e-05 -0.000481119550795903
+ 1.0484e-05 -0.000274530858458148
+ 1.0486e-05 -0.000344253655035905
+ 1.0488e-05 -0.000168455292079584
+ 1.049e-05 -0.000136417646010856
+ 1.0492e-05 -0.000354576546308573
+ 1.0494e-05 -7.10005943545995e-05
+ 1.0496e-05 0.000331210235069082
+ 1.0498e-05 0.000330701621813187
+ 1.05e-05 0.00059369461479953
+ 1.0502e-05 0.000443843810151096
+ 1.0504e-05 0.000444480620780428
+ 1.0506e-05 0.00026926171328645
+ 1.0508e-05 0.000285978095373873
+ 1.051e-05 0.000167595738058187
+ 1.0512e-05 0.000103971151989311
+ 1.0514e-05 0.000168009857519455
+ 1.0516e-05 0.000277717769217887
+ 1.0518e-05 0.000108262727999621
+ 1.052e-05 0.000213161678769606
+ 1.0522e-05 0.00022691845626788
+ 1.0524e-05 0.000194081225440329
+ 1.0526e-05 1.44877152852103e-05
+ 1.0528e-05 7.56170916504136e-05
+ 1.053e-05 0.000184014866552566
+ 1.0532e-05 0.000308939296093104
+ 1.0534e-05 0.000288361093940431
+ 1.0536e-05 -8.73388072894827e-05
+ 1.0538e-05 -0.000291717102871596
+ 1.054e-05 -0.000500032080638229
+ 1.0542e-05 -0.000472176452736046
+ 1.0544e-05 -0.000748475643146881
+ 1.0546e-05 -0.000718456381921993
+ 1.0548e-05 -0.000875357554235189
+ 1.055e-05 -0.000631857884105921
+ 1.0552e-05 -0.000484876550559474
+ 1.0554e-05 -0.00048841590807941
+ 1.0556e-05 -0.000355768206347442
+ 1.0558e-05 -0.000667913208750495
+ 1.056e-05 -0.000707952587180606
+ 1.0562e-05 -0.000858769900301674
+ 1.0564e-05 -0.00105425655113956
+ 1.0566e-05 -0.00113244392068256
+ 1.0568e-05 -0.000862951351245448
+ 1.057e-05 -0.000854051431784819
+ 1.0572e-05 -0.000783580240357985
+ 1.0574e-05 -0.00128233501452986
+ 1.0576e-05 -0.00114747735788042
+ 1.0578e-05 -0.00127880717358903
+ 1.058e-05 -0.00141870791642734
+ 1.0582e-05 -0.00123055092916577
+ 1.0584e-05 -0.00132685559731975
+ 1.0586e-05 -0.00137122622131269
+ 1.0588e-05 -0.0018904693591491
+ 1.059e-05 -0.00207971042095818
+ 1.0592e-05 -0.00212236125379177
+ 1.0594e-05 -0.00201207298339495
+ 1.0596e-05 -0.00209286551704216
+ 1.0598e-05 -0.00180411223027748
+ 1.06e-05 -0.00167324596671715
+ 1.0602e-05 -0.00160925586419621
+ 1.0604e-05 -0.00152058022524289
+ 1.0606e-05 -0.00128063241056194
+ 1.0608e-05 -0.000859348466029788
+ 1.061e-05 -0.000737655569480185
+ 1.0612e-05 -0.000614716095907021
+ 1.0614e-05 -0.000871951367639221
+ 1.0616e-05 -0.000634752423002081
+ 1.0618e-05 -0.000617295513206803
+ 1.062e-05 -0.000444172691382777
+ 1.0622e-05 -0.000701104031003172
+ 1.0624e-05 -0.000735122290147718
+ 1.0626e-05 -0.000452011444241544
+ 1.0628e-05 -0.000657889298214008
+ 1.063e-05 -0.000523348907180094
+ 1.0632e-05 -0.000726422963766735
+ 1.0634e-05 -0.000851085480929662
+ 1.0636e-05 -0.00090249566784116
+ 1.0638e-05 -0.000861975213824719
+ 1.064e-05 -0.000783634607275358
+ 1.0642e-05 -0.000935868999784123
+ 1.0644e-05 -0.000845846429964471
+ 1.0646e-05 -0.00105220569959612
+ 1.0648e-05 -0.000811418885720399
+ 1.065e-05 -0.00109394825723325
+ 1.0652e-05 -0.000844539966174718
+ 1.0654e-05 -0.00117459052207947
+ 1.0656e-05 -0.00123063887576465
+ 1.0658e-05 -0.0012396974735698
+ 1.066e-05 -0.00105068338717089
+ 1.0662e-05 -0.00114720216652594
+ 1.0664e-05 -0.00144479081288152
+ 1.0666e-05 -0.00130745229004319
+ 1.0668e-05 -0.00128967516301935
+ 1.067e-05 -0.00112489592945978
+ 1.0672e-05 -0.00140159268551295
+ 1.0674e-05 -0.00147354949281458
+ 1.0676e-05 -0.00162113961538624
+ 1.0678e-05 -0.0017989551148254
+ 1.068e-05 -0.00179994448000498
+ 1.0682e-05 -0.00174621315436545
+ 1.0684e-05 -0.00178223812402088
+ 1.0686e-05 -0.00188191228071855
+ 1.0688e-05 -0.00168129010799238
+ 1.069e-05 -0.00151472945956139
+ 1.0692e-05 -0.00160807770170345
+ 1.0694e-05 -0.00154865029721464
+ 1.0696e-05 -0.00179466781243518
+ 1.0698e-05 -0.00158114051943789
+ 1.07e-05 -0.00132654143201085
+ 1.0702e-05 -0.00153320628706181
+ 1.0704e-05 -0.00145153546438109
+ 1.0706e-05 -0.00106829664416176
+ 1.0708e-05 -0.00105990284186449
+ 1.071e-05 -0.00107575513634057
+ 1.0712e-05 -0.00141835194545462
+ 1.0714e-05 -0.00140134256267641
+ 1.0716e-05 -0.00137341338330095
+ 1.0718e-05 -0.00153622756566496
+ 1.072e-05 -0.00152663665530068
+ 1.0722e-05 -0.00175889805264421
+ 1.0724e-05 -0.00175853622811863
+ 1.0726e-05 -0.00170169171799208
+ 1.0728e-05 -0.00201957366566821
+ 1.073e-05 -0.00217503925846327
+ 1.0732e-05 -0.00237617875636294
+ 1.0734e-05 -0.00258734647857991
+ 1.0736e-05 -0.00255323368146115
+ 1.0738e-05 -0.00273654239175544
+ 1.074e-05 -0.0027612571673078
+ 1.0742e-05 -0.00321519561349452
+ 1.0744e-05 -0.00335472259165617
+ 1.0746e-05 -0.00355777457593621
+ 1.0748e-05 -0.00377991359071484
+ 1.075e-05 -0.00357652479934742
+ 1.0752e-05 -0.00351466063629043
+ 1.0754e-05 -0.0034224447962739
+ 1.0756e-05 -0.00326612979076565
+ 1.0758e-05 -0.00365060194123705
+ 1.076e-05 -0.00361121797571041
+ 1.0762e-05 -0.00362874672126007
+ 1.0764e-05 -0.00375861693034272
+ 1.0766e-05 -0.00347375611145524
+ 1.0768e-05 -0.0032297463865645
+ 1.077e-05 -0.00326544615245939
+ 1.0772e-05 -0.00352266741072471
+ 1.0774e-05 -0.00387698702486767
+ 1.0776e-05 -0.00381850587040554
+ 1.0778e-05 -0.00407229291033134
+ 1.078e-05 -0.00387762014990149
+ 1.0782e-05 -0.00398329287011981
+ 1.0784e-05 -0.00388151818958429
+ 1.0786e-05 -0.00357478949108745
+ 1.0788e-05 -0.00330666803582654
+ 1.079e-05 -0.00333876215206838
+ 1.0792e-05 -0.00333861632090416
+ 1.0794e-05 -0.00352528123501835
+ 1.0796e-05 -0.00311862331593771
+ 1.0798e-05 -0.00285114967538758
+ 1.08e-05 -0.00282865112462411
+ 1.0802e-05 -0.00285730360556735
+ 1.0804e-05 -0.00282277554016809
+ 1.0806e-05 -0.002478107033475
+ 1.0808e-05 -0.00259588243533372
+ 1.081e-05 -0.00270640469271893
+ 1.0812e-05 -0.00273219118956663
+ 1.0814e-05 -0.00260976905150954
+ 1.0816e-05 -0.00260411397230254
+ 1.0818e-05 -0.00228371444793963
+ 1.082e-05 -0.00242812788870445
+ 1.0822e-05 -0.0024148787405494
+ 1.0824e-05 -0.00231004795139266
+ 1.0826e-05 -0.00203439325659183
+ 1.0828e-05 -0.00196309524523339
+ 1.083e-05 -0.00185009576204671
+ 1.0832e-05 -0.00169305739614823
+ 1.0834e-05 -0.00126119630918325
+ 1.0836e-05 -0.000863881861104979
+ 1.0838e-05 -0.000687832086198809
+ 1.084e-05 -0.000199341123825648
+ 1.0842e-05 -0.000509978240453106
+ 1.0844e-05 -0.000268127897682897
+ 1.0846e-05 -9.35537279370582e-05
+ 1.0848e-05 -0.00028700655190944
+ 1.085e-05 -0.000441668265810301
+ 1.0852e-05 -0.000665404188481338
+ 1.0854e-05 -0.000741784771406994
+ 1.0856e-05 -0.000676621280824332
+ 1.0858e-05 -0.00015480933405455
+ 1.086e-05 0.000326930152904364
+ 1.0862e-05 0.00051606906771484
+ 1.0864e-05 0.00101108685528609
+ 1.0866e-05 0.000956308220759817
+ 1.0868e-05 0.000978367033632746
+ 1.087e-05 0.00102900671211709
+ 1.0872e-05 0.00091009428338512
+ 1.0874e-05 0.000717336033943997
+ 1.0876e-05 0.000431787096328842
+ 1.0878e-05 0.000333805671258941
+ 1.088e-05 0.000338564009081122
+ 1.0882e-05 0.00075453167044208
+ 1.0884e-05 0.000701439343084347
+ 1.0886e-05 0.000680674037332115
+ 1.0888e-05 0.000715164628886728
+ 1.089e-05 0.0010417835244517
+ 1.0892e-05 0.00115203960090044
+ 1.0894e-05 0.00114853517445165
+ 1.0896e-05 0.00122518449888954
+ 1.0898e-05 0.00116530421243897
+ 1.09e-05 0.00104144777222984
+ 1.0902e-05 0.00107258049936406
+ 1.0904e-05 0.000469848565480556
+ 1.0906e-05 0.000370236112238393
+ 1.0908e-05 0.000445275383573548
+ 1.091e-05 0.000609136832931629
+ 1.0912e-05 0.000594679996645197
+ 1.0914e-05 0.000938640847340197
+ 1.0916e-05 0.0012456555409572
+ 1.0918e-05 0.00100836849689696
+ 1.092e-05 0.00137778776902791
+ 1.0922e-05 0.00156749168134482
+ 1.0924e-05 0.00130577252921775
+ 1.0926e-05 0.00150247933665201
+ 1.0928e-05 0.00128558960282253
+ 1.093e-05 0.00138558351100093
+ 1.0932e-05 0.00152902388017905
+ 1.0934e-05 0.00142452967467979
+ 1.0936e-05 0.00208625146946182
+ 1.0938e-05 0.00179444460081162
+ 1.094e-05 0.00140524862132584
+ 1.0942e-05 0.00145333475053665
+ 1.0944e-05 0.0014221684212557
+ 1.0946e-05 0.00111427671142107
+ 1.0948e-05 0.00112314536038984
+ 1.095e-05 0.000770346879373679
+ 1.0952e-05 0.000627002462375409
+ 1.0954e-05 0.00070730861277221
+ 1.0956e-05 0.000404574997808889
+ 1.0958e-05 0.000181621547091602
+ 1.096e-05 -9.87265224049282e-05
+ 1.0962e-05 -5.44925109646745e-05
+ 1.0964e-05 -0.0001110945486231
+ 1.0966e-05 -1.79255009811607e-05
+ 1.0968e-05 1.93354710369197e-05
+ 1.097e-05 -0.000211996614863618
+ 1.0972e-05 -7.97028958509732e-05
+ 1.0974e-05 -2.52344682573697e-05
+ 1.0976e-05 6.80605263226794e-05
+ 1.0978e-05 0.000423281411062034
+ 1.098e-05 0.000297609446196287
+ 1.0982e-05 0.000385981440982099
+ 1.0984e-05 0.000359351551524451
+ 1.0986e-05 -2.23962931781724e-06
+ 1.0988e-05 0.000311819988779823
+ 1.099e-05 0.00051415797623867
+ 1.0992e-05 0.000465259250603647
+ 1.0994e-05 0.000651764134312268
+ 1.0996e-05 0.000560151673592229
+ 1.0998e-05 0.000526763924811971
+ 1.1e-05 0.000224637668487195
+ 1.1002e-05 -3.28380643182571e-06
+ 1.1004e-05 0.000155078364155047
+ 1.1006e-05 -7.47694306161098e-06
+ 1.1008e-05 -2.9573105438076e-05
+ 1.101e-05 -0.000452180836120465
+ 1.1012e-05 -0.000613420676140495
+ 1.1014e-05 -0.000640235295346917
+ 1.1016e-05 -0.000521044941541062
+ 1.1018e-05 -0.000583666166605145
+ 1.102e-05 -0.000926550151178191
+ 1.1022e-05 -0.000799236702938818
+ 1.1024e-05 -0.000773615838311931
+ 1.1026e-05 -0.000593993748704747
+ 1.1028e-05 -0.000614759890378639
+ 1.103e-05 -0.00068552032165444
+ 1.1032e-05 -0.000441105122732995
+ 1.1034e-05 -0.000723922778001794
+ 1.1036e-05 -0.000473519557644082
+ 1.1038e-05 -0.00051974330830167
+ 1.104e-05 -0.000504346151498441
+ 1.1042e-05 -0.000217576834311469
+ 1.1044e-05 -0.000260415892418694
+ 1.1046e-05 -2.45044764264654e-05
+ 1.1048e-05 -5.12378040705307e-05
+ 1.105e-05 -0.00056999882946402
+ 1.1052e-05 -0.000657651642466179
+ 1.1054e-05 -0.000142417150314637
+ 1.1056e-05 -5.59647953702061e-05
+ 1.1058e-05 0.000391264245967576
+ 1.106e-05 0.000363715429967258
+ 1.1062e-05 0.000228575713137614
+ 1.1064e-05 0.000418005762797354
+ 1.1066e-05 3.79358770995675e-05
+ 1.1068e-05 -2.87871945654587e-05
+ 1.107e-05 -0.000182455604658873
+ 1.1072e-05 -0.000179351387911746
+ 1.1074e-05 -0.000174326158526879
+ 1.1076e-05 0.0001961456223961
+ 1.1078e-05 0.000119934373779579
+ 1.108e-05 0.000402138874732555
+ 1.1082e-05 0.00059031419913253
+ 1.1084e-05 0.000663815698666566
+ 1.1086e-05 0.000822836090820407
+ 1.1088e-05 0.000772951729197941
+ 1.109e-05 0.000372316712002669
+ 1.1092e-05 3.97393205515664e-05
+ 1.1094e-05 -0.000202066242080334
+ 1.1096e-05 -0.000197406018009195
+ 1.1098e-05 7.7774100690112e-05
+ 1.11e-05 0.000365538255740116
+ 1.1102e-05 0.000201992072291715
+ 1.1104e-05 0.000470392754804919
+ 1.1106e-05 0.000547340271487312
+ 1.1108e-05 0.000235574601975256
+ 1.111e-05 -0.000143836143107507
+ 1.1112e-05 -0.000211819628226733
+ 1.1114e-05 -0.000393114800047306
+ 1.1116e-05 -0.000737112758155549
+ 1.1118e-05 -0.000398532934983859
+ 1.112e-05 -0.000254573309295847
+ 1.1122e-05 -1.25256843468487e-05
+ 1.1124e-05 5.49723252020593e-05
+ 1.1126e-05 -0.000123567869255093
+ 1.1128e-05 -0.00018603937104106
+ 1.113e-05 -0.000196761662126429
+ 1.1132e-05 -0.000383885839551185
+ 1.1134e-05 -0.000317521572421759
+ 1.1136e-05 -0.000197563310959961
+ 1.1138e-05 5.719943680334e-05
+ 1.114e-05 0.000244399761719652
+ 1.1142e-05 0.000264930555573116
+ 1.1144e-05 0.000211682675561393
+ 1.1146e-05 5.58376171490685e-06
+ 1.1148e-05 -9.34621743754545e-05
+ 1.115e-05 -0.000113794600445486
+ 1.1152e-05 -0.000179011615271882
+ 1.1154e-05 -0.000137107097614275
+ 1.1156e-05 -0.000131771653806909
+ 1.1158e-05 0.00022978911282174
+ 1.116e-05 0.000447217306219126
+ 1.1162e-05 0.000856595838259711
+ 1.1164e-05 0.000854820174385846
+ 1.1166e-05 0.00110321967243928
+ 1.1168e-05 0.000747267289997644
+ 1.117e-05 0.000699824183477837
+ 1.1172e-05 0.000661837352390447
+ 1.1174e-05 0.000943259572276257
+ 1.1176e-05 0.000966308353910259
+ 1.1178e-05 0.000914682524825858
+ 1.118e-05 0.000968244738733547
+ 1.1182e-05 0.00065409539908996
+ 1.1184e-05 0.000649644170012718
+ 1.1186e-05 0.000691272708958938
+ 1.1188e-05 0.000723082749102523
+ 1.119e-05 0.000575538852681047
+ 1.1192e-05 0.000471219981698343
+ 1.1194e-05 0.000314345597580821
+ 1.1196e-05 0.000429177466611009
+ 1.1198e-05 0.000336662969248937
+ 1.12e-05 -4.80097299859031e-05
+ 1.1202e-05 0.000105610019916208
+ 1.1204e-05 6.12723099824259e-05
+ 1.1206e-05 9.35637199949984e-05
+ 1.1208e-05 0.000160808702068935
+ 1.121e-05 0.00026233165886252
+ 1.1212e-05 0.000109062162776873
+ 1.1214e-05 -0.000156700255745073
+ 1.1216e-05 -0.000462453076850502
+ 1.1218e-05 -0.00036790157679625
+ 1.122e-05 -0.000526890218877922
+ 1.1222e-05 -0.000549209705038378
+ 1.1224e-05 -0.000391410214909546
+ 1.1226e-05 -0.000546333278323438
+ 1.1228e-05 -0.000503417939225739
+ 1.123e-05 -0.000648340520268584
+ 1.1232e-05 -0.000657891469195516
+ 1.1234e-05 -0.000264886798551068
+ 1.1236e-05 -0.000268063388486655
+ 1.1238e-05 -0.000363933748316863
+ 1.124e-05 -0.000388344628139454
+ 1.1242e-05 -0.000409594109929108
+ 1.1244e-05 -0.000186270143459721
+ 1.1246e-05 -0.000151126388652742
+ 1.1248e-05 -0.000237173600190816
+ 1.125e-05 -0.000261108327779827
+ 1.1252e-05 2.62910520743172e-05
+ 1.1254e-05 -0.000360807796933098
+ 1.1256e-05 -0.00049889187798148
+ 1.1258e-05 -0.000519300384125958
+ 1.126e-05 -0.000136410205728088
+ 1.1262e-05 -0.000138580284256875
+ 1.1264e-05 -0.000169952405203937
+ 1.1266e-05 -0.000372063087126338
+ 1.1268e-05 -0.000555325363859654
+ 1.127e-05 -0.000575788547981874
+ 1.1272e-05 -0.000325190173597333
+ 1.1274e-05 -0.000563622996256354
+ 1.1276e-05 -0.00028980935617453
+ 1.1278e-05 -0.000231859835069678
+ 1.128e-05 -0.000777693372383955
+ 1.1282e-05 -0.000402877989988456
+ 1.1284e-05 -0.000262198817172076
+ 1.1286e-05 -0.000126601227474272
+ 1.1288e-05 -7.68297474503424e-05
+ 1.129e-05 -0.000228276123976572
+ 1.1292e-05 0.000216158132277525
+ 1.1294e-05 0.000379679540944502
+ 1.1296e-05 0.000425870794962189
+ 1.1298e-05 -0.000129666703758316
+ 1.13e-05 -0.00017358512162272
+ 1.1302e-05 0.000147022468859953
+ 1.1304e-05 0.000136925413381139
+ 1.1306e-05 5.68952697154608e-05
+ 1.1308e-05 -5.30455115619136e-05
+ 1.131e-05 -8.67673115355737e-05
+ 1.1312e-05 -0.00023899155665485
+ 1.1314e-05 -0.000622363841736506
+ 1.1316e-05 -0.000678915572129808
+ 1.1318e-05 -0.000830273916615484
+ 1.132e-05 -0.000563485152715569
+ 1.1322e-05 -0.000292461200067462
+ 1.1324e-05 -0.000232551084263923
+ 1.1326e-05 -0.000380824195964544
+ 1.1328e-05 -0.000209105495375838
+ 1.133e-05 2.66329814388699e-06
+ 1.1332e-05 0.000329907571712531
+ 1.1334e-05 1.94595123151455e-05
+ 1.1336e-05 0.000211421033924931
+ 1.1338e-05 -3.43828149894582e-05
+ 1.134e-05 -1.21276459154636e-05
+ 1.1342e-05 9.30222987877834e-05
+ 1.1344e-05 0.000183418832639344
+ 1.1346e-05 0.000438863294915633
+ 1.1348e-05 0.000685446432755713
+ 1.135e-05 0.000496108880480848
+ 1.1352e-05 0.000584375816867683
+ 1.1354e-05 0.000839974746161604
+ 1.1356e-05 0.000947326885638307
+ 1.1358e-05 0.000635728896064394
+ 1.136e-05 0.00058264135082215
+ 1.1362e-05 3.43864880458227e-05
+ 1.1364e-05 0.000114793854891478
+ 1.1366e-05 4.64177570850325e-05
+ 1.1368e-05 -0.000297466184936219
+ 1.137e-05 -0.000492020457581972
+ 1.1372e-05 -0.000817870011445091
+ 1.1374e-05 -0.000943627107875572
+ 1.1376e-05 -0.00110675045167055
+ 1.1378e-05 -0.00102098942818361
+ 1.138e-05 -0.000859153629527265
+ 1.1382e-05 -0.000629712996177775
+ 1.1384e-05 -0.000864483938503432
+ 1.1386e-05 -0.000704304749730835
+ 1.1388e-05 -0.000727155931676044
+ 1.139e-05 -0.000296290539040483
+ 1.1392e-05 -0.000199893087674666
+ 1.1394e-05 -0.000500554704569279
+ 1.1396e-05 -0.000789500055998585
+ 1.1398e-05 -0.000600699275155936
+ 1.14e-05 -0.000996863898705928
+ 1.1402e-05 -0.000828561960247522
+ 1.1404e-05 -0.000631287381171765
+ 1.1406e-05 -0.000460396697948064
+ 1.1408e-05 -0.000532382339665847
+ 1.141e-05 -0.000863425251471868
+ 1.1412e-05 -0.000584742778057922
+ 1.1414e-05 -0.00054411205050024
+ 1.1416e-05 -0.000329187222047499
+ 1.1418e-05 -0.000494313946096612
+ 1.142e-05 -0.000243070414465917
+ 1.1422e-05 -0.000205693267573541
+ 1.1424e-05 -0.000716024767243564
+ 1.1426e-05 -0.000507571075811161
+ 1.1428e-05 -0.000508599169697691
+ 1.143e-05 -0.000285123710172968
+ 1.1432e-05 -0.000339741066821943
+ 1.1434e-05 -0.00038930140276889
+ 1.1436e-05 4.72394352545008e-05
+ 1.1438e-05 0.000240432581032871
+ 1.144e-05 -9.56948110356849e-05
+ 1.1442e-05 -0.000366045051650835
+ 1.1444e-05 -0.000170744227142552
+ 1.1446e-05 0.000127620366360681
+ 1.1448e-05 0.000358212506047544
+ 1.145e-05 0.000437075762613028
+ 1.1452e-05 -0.000224335985656126
+ 1.1454e-05 -0.000180065168178904
+ 1.1456e-05 -0.000306210554831643
+ 1.1458e-05 -0.000650284594384412
+ 1.146e-05 -0.000414742163666151
+ 1.1462e-05 -0.000405230681043735
+ 1.1464e-05 -0.000411130554066416
+ 1.1466e-05 -0.00058773735232579
+ 1.1468e-05 -0.000663057262062416
+ 1.147e-05 -0.000693874433666112
+ 1.1472e-05 -0.000862676763089762
+ 1.1474e-05 -0.000490906175478949
+ 1.1476e-05 -0.00061739959041666
+ 1.1478e-05 -0.000666843649094613
+ 1.148e-05 -0.000452287938438369
+ 1.1482e-05 -0.000531888995558319
+ 1.1484e-05 -0.000605795478138801
+ 1.1486e-05 -0.000520594571399444
+ 1.1488e-05 -0.000542821773333786
+ 1.149e-05 -0.00052589769727566
+ 1.1492e-05 -0.000490011059921783
+ 1.1494e-05 -0.000377181444907645
+ 1.1496e-05 -0.000526771093794786
+ 1.1498e-05 -0.000453936185559362
+ 1.15e-05 -0.000501353471984929
+ 1.1502e-05 -0.000596891549499937
+ 1.1504e-05 -0.000971583058965788
+ 1.1506e-05 -0.0011044200212738
+ 1.1508e-05 -0.00126195773092898
+ 1.151e-05 -0.00147035447418878
+ 1.1512e-05 -0.00139090607104484
+ 1.1514e-05 -0.00111098524415041
+ 1.1516e-05 -0.00121516602295704
+ 1.1518e-05 -0.00128406230751059
+ 1.152e-05 -0.00135789671678882
+ 1.1522e-05 -0.00109996509875711
+ 1.1524e-05 -0.00115500347462417
+ 1.1526e-05 -0.00126136320016057
+ 1.1528e-05 -0.00120250862646403
+ 1.153e-05 -0.00141058839518462
+ 1.1532e-05 -0.0014326465545046
+ 1.1534e-05 -0.00102274336662097
+ 1.1536e-05 -0.00107798770444118
+ 1.1538e-05 -0.00105644167751785
+ 1.154e-05 -0.00100333607530969
+ 1.1542e-05 -0.000931072324415563
+ 1.1544e-05 -0.00113446188969132
+ 1.1546e-05 -0.00111642062025348
+ 1.1548e-05 -0.00129585719716836
+ 1.155e-05 -0.00146730058289001
+ 1.1552e-05 -0.00103536151105627
+ 1.1554e-05 -0.000835432135971868
+ 1.1556e-05 -0.000681763120146613
+ 1.1558e-05 -0.000424750447093523
+ 1.156e-05 -0.000591727308618046
+ 1.1562e-05 -0.000258986295914297
+ 1.1564e-05 -0.000304756266809475
+ 1.1566e-05 -0.00020479473209503
+ 1.1568e-05 -0.000293414022115685
+ 1.157e-05 -0.00040716832659994
+ 1.1572e-05 -0.000145592924565615
+ 1.1574e-05 -0.000501611415006704
+ 1.1576e-05 -0.00058322293394294
+ 1.1578e-05 -0.000525327801820149
+ 1.158e-05 -0.000181741482035151
+ 1.1582e-05 9.50513760203218e-05
+ 1.1584e-05 0.000203353878643802
+ 1.1586e-05 0.000391898158227932
+ 1.1588e-05 0.000354626582380642
+ 1.159e-05 0.000271784893846133
+ 1.1592e-05 0.000234401255770365
+ 1.1594e-05 0.000231575502207325
+ 1.1596e-05 -4.14899620186523e-05
+ 1.1598e-05 -6.67104705232233e-05
+ 1.16e-05 -0.000118067820321487
+ 1.1602e-05 -0.000315734764564702
+ 1.1604e-05 -0.000459395988194204
+ 1.1606e-05 -0.000695339517512336
+ 1.1608e-05 -0.00063062826557114
+ 1.161e-05 -0.000458800459326629
+ 1.1612e-05 -0.000497598897682311
+ 1.1614e-05 -0.000247732254598189
+ 1.1616e-05 -0.000350733256665678
+ 1.1618e-05 -0.000224104590037077
+ 1.162e-05 -0.000172110263183562
+ 1.1622e-05 0.000143888015549493
+ 1.1624e-05 0.000216593588821766
+ 1.1626e-05 0.000113150412359792
+ 1.1628e-05 0.00013715548256551
+ 1.163e-05 0.000354083343589058
+ 1.1632e-05 0.00025121937432433
+ 1.1634e-05 0.000211414549038802
+ 1.1636e-05 0.000182664839566381
+ 1.1638e-05 6.30416812740531e-05
+ 1.164e-05 0.000187280865614721
+ 1.1642e-05 2.90215663635766e-05
+ 1.1644e-05 -0.000283135614165782
+ 1.1646e-05 -0.0003809774666485
+ 1.1648e-05 -0.000347063669021384
+ 1.165e-05 -0.000440107304594616
+ 1.1652e-05 -0.000364846646727067
+ 1.1654e-05 -0.000306615777936624
+ 1.1656e-05 -0.000381566710681255
+ 1.1658e-05 -0.000390560138542745
+ 1.166e-05 -0.000286338453342192
+ 1.1662e-05 -0.000122903207783295
+ 1.1664e-05 -0.000193367636550778
+ 1.1666e-05 9.93924574846559e-05
+ 1.1668e-05 5.75296545663449e-05
+ 1.167e-05 0.000151526752967961
+ 1.1672e-05 0.000263997438822526
+ 1.1674e-05 -6.78198110491575e-05
+ 1.1676e-05 -0.000644158146637258
+ 1.1678e-05 -0.000303076420521122
+ 1.168e-05 -0.0004214735837893
+ 1.1682e-05 -0.000710458761668653
+ 1.1684e-05 -0.000479219019392446
+ 1.1686e-05 -0.00068901030533119
+ 1.1688e-05 -0.000452212004303638
+ 1.169e-05 -0.000404081881075015
+ 1.1692e-05 -0.000284966214053055
+ 1.1694e-05 -0.000190151543005642
+ 1.1696e-05 -0.000239468658139279
+ 1.1698e-05 -0.0003691578604892
+ 1.17e-05 -0.000376510740230441
+ 1.1702e-05 -0.000634351969392814
+ 1.1704e-05 -0.000604096375902986
+ 1.1706e-05 -0.000540378257318303
+ 1.1708e-05 -0.000191322673009647
+ 1.171e-05 -0.000442699287802527
+ 1.1712e-05 -0.000732369831626493
+ 1.1714e-05 -0.000847785685922403
+ 1.1716e-05 -0.000840800809045563
+ 1.1718e-05 -0.000480880422598476
+ 1.172e-05 -0.000324318527382538
+ 1.1722e-05 -0.000122360245313335
+ 1.1724e-05 -0.000111210067401903
+ 1.1726e-05 7.48294262883764e-05
+ 1.1728e-05 0.000325093149443768
+ 1.173e-05 0.00050704299276966
+ 1.1732e-05 0.000408527599645647
+ 1.1734e-05 4.72213925207297e-05
+ 1.1736e-05 9.27267041769287e-05
+ 1.1738e-05 9.31533882263264e-05
+ 1.174e-05 -1.48387333391685e-05
+ 1.1742e-05 0.00030460986963135
+ 1.1744e-05 5.18117358773357e-05
+ 1.1746e-05 0.000320505296896591
+ 1.1748e-05 0.000331333627992789
+ 1.175e-05 9.0593121062829e-05
+ 1.1752e-05 0.000366436542713514
+ 1.1754e-05 0.000410290342917171
+ 1.1756e-05 0.000322283332111492
+ 1.1758e-05 0.000234421243954898
+ 1.176e-05 -4.71045687654015e-05
+ 1.1762e-05 1.97945568332387e-05
+ 1.1764e-05 0.000145618798412764
+ 1.1766e-05 1.13027913098006e-05
+ 1.1768e-05 -3.02455625120164e-05
+ 1.177e-05 -0.00019312321232255
+ 1.1772e-05 -0.00053131304065494
+ 1.1774e-05 -0.000331267481443523
+ 1.1776e-05 -0.000287972919338349
+ 1.1778e-05 -0.000260573966927017
+ 1.178e-05 -0.000261701454129566
+ 1.1782e-05 -0.000144700378676717
+ 1.1784e-05 -0.000247361128697635
+ 1.1786e-05 -0.000221180761317608
+ 1.1788e-05 -0.000578702103776609
+ 1.179e-05 -0.000630453728973448
+ 1.1792e-05 -0.000724189985486345
+ 1.1794e-05 -0.00109929067327638
+ 1.1796e-05 -0.00130547890239916
+ 1.1798e-05 -0.00166335416832929
+ 1.18e-05 -0.00156265900746956
+ 1.1802e-05 -0.00172613615660507
+ 1.1804e-05 -0.001714772632965
+ 1.1806e-05 -0.00162796250122709
+ 1.1808e-05 -0.00171314243505303
+ 1.181e-05 -0.00167224068476978
+ 1.1812e-05 -0.0013864900858269
+ 1.1814e-05 -0.00151789192866732
+ 1.1816e-05 -0.00170162517145575
+ 1.1818e-05 -0.00171364990108186
+ 1.182e-05 -0.00147928566596659
+ 1.1822e-05 -0.00149067739301153
+ 1.1824e-05 -0.00154018232630585
+ 1.1826e-05 -0.00173926789007288
+ 1.1828e-05 -0.00179712387578905
+ 1.183e-05 -0.00182900957928667
+ 1.1832e-05 -0.00171602931638214
+ 1.1834e-05 -0.00163338794744936
+ 1.1836e-05 -0.00197717473175481
+ 1.1838e-05 -0.00181057191885422
+ 1.184e-05 -0.00189309932118906
+ 1.1842e-05 -0.00222449978338541
+ 1.1844e-05 -0.00222404046254223
+ 1.1846e-05 -0.002347315895138
+ 1.1848e-05 -0.0025381704736154
+ 1.185e-05 -0.00248974226627296
+ 1.1852e-05 -0.00249324560440995
+ 1.1854e-05 -0.00224151429637768
+ 1.1856e-05 -0.00257074091156916
+ 1.1858e-05 -0.00264054886951012
+ 1.186e-05 -0.00248217664489949
+ 1.1862e-05 -0.00232115236900169
+ 1.1864e-05 -0.00223912121871253
+ 1.1866e-05 -0.00217018703156904
+ 1.1868e-05 -0.00194940719922565
+ 1.187e-05 -0.00148952400133107
+ 1.1872e-05 -0.00152194663104147
+ 1.1874e-05 -0.00189858490563675
+ 1.1876e-05 -0.00169358010473899
+ 1.1878e-05 -0.00180513614297384
+ 1.188e-05 -0.00154305459376163
+ 1.1882e-05 -0.00130572620927443
+ 1.1884e-05 -0.00128647984501305
+ 1.1886e-05 -0.000984891112354168
+ 1.1888e-05 -0.000959400532987092
+ 1.189e-05 -0.000982047439339972
+ 1.1892e-05 -0.00127980537330918
+ 1.1894e-05 -0.00144469734434427
+ 1.1896e-05 -0.0010793895832631
+ 1.1898e-05 -0.00137275678649685
+ 1.19e-05 -0.00173611748104051
+ 1.1902e-05 -0.0020141891180213
+ 1.1904e-05 -0.00163148484185181
+ 1.1906e-05 -0.00153065329708273
+ 1.1908e-05 -0.001559395187217
+ 1.191e-05 -0.00137621209148795
+ 1.1912e-05 -0.00125854715060697
+ 1.1914e-05 -0.00136776347940593
+ 1.1916e-05 -0.00114573888435764
+ 1.1918e-05 -0.00123725889129977
+ 1.192e-05 -0.000920847035725082
+ 1.1922e-05 -0.000843467520029504
+ 1.1924e-05 -0.000894357156586467
+ 1.1926e-05 -0.000962331275537625
+ 1.1928e-05 -0.000957870702084609
+ 1.193e-05 -0.000708179874930684
+ 1.1932e-05 -0.000800984975243872
+ 1.1934e-05 -0.000971268252318048
+ 1.1936e-05 -0.00126274100551957
+ 1.1938e-05 -0.0012346029503043
+ 1.194e-05 -0.00112716399786685
+ 1.1942e-05 -0.000772751430053139
+ 1.1944e-05 -0.000141776158248071
+ 1.1946e-05 9.53683407976927e-05
+ 1.1948e-05 -0.000106961730235533
+ 1.195e-05 0.000115468000915277
+ 1.1952e-05 0.000354522777723291
+ 1.1954e-05 0.000498948078898392
+ 1.1956e-05 0.000549114890541035
+ 1.1958e-05 0.000276218752901882
+ 1.196e-05 0.000348283773635749
+ 1.1962e-05 9.64566920667232e-05
+ 1.1964e-05 0.00025881621064009
+ 1.1966e-05 0.000348349522800979
+ 1.1968e-05 -7.29212377273641e-06
+ 1.197e-05 -8.78011705718601e-05
+ 1.1972e-05 -0.000250066592912023
+ 1.1974e-05 -0.000117032094411525
+ 1.1976e-05 -0.00035231188509798
+ 1.1978e-05 -0.000341645450873958
+ 1.198e-05 -0.000246421269358589
+ 1.1982e-05 -5.45710042103091e-05
+ 1.1984e-05 0.000140181255956489
+ 1.1986e-05 0.00020323409987034
+ 1.1988e-05 0.000241916291201346
+ 1.199e-05 0.00022040597656582
+ 1.1992e-05 -1.62447213260364e-05
+ 1.1994e-05 -7.90328539211218e-05
+ 1.1996e-05 2.31570024686992e-05
+ 1.1998e-05 0.000170838612364694
+ 1.2e-05 0.000416032767055236
+ 1.2002e-05 0.000501570371206825
+ 1.2004e-05 0.000369075808326814
+ 1.2006e-05 0.000505543580700206
+ 1.2008e-05 0.000763334471822261
+ 1.201e-05 0.00085733659938216
+ 1.2012e-05 0.000919013898496289
+ 1.2014e-05 0.00104662663137246
+ 1.2016e-05 0.00110471184668283
+ 1.2018e-05 0.000815369506700168
+ 1.202e-05 0.000507720189544812
+ 1.2022e-05 0.000532085057199296
+ 1.2024e-05 0.000675231609286348
+ 1.2026e-05 0.000870158501503884
+ 1.2028e-05 0.000957752827094872
+ 1.203e-05 0.000907159650288779
+ 1.2032e-05 0.000832922748113049
+ 1.2034e-05 0.000562533174935109
+ 1.2036e-05 0.000462127874493268
+ 1.2038e-05 0.000276005782163979
+ 1.204e-05 0.000664056840058216
+ 1.2042e-05 -3.95027031173475e-05
+ 1.2044e-05 0.000244528604360393
+ 1.2046e-05 0.000644595765041783
+ 1.2048e-05 0.000610800994706904
+ 1.205e-05 0.000577360467746034
+ 1.2052e-05 0.000701521628446963
+ 1.2054e-05 0.000565902189233539
+ 1.2056e-05 0.000208830965328074
+ 1.2058e-05 9.2521080417795e-05
+ 1.206e-05 0.000234806748809042
+ 1.2062e-05 0.000335183090864304
+ 1.2064e-05 0.000522956665188439
+ 1.2066e-05 0.00071703020972321
+ 1.2068e-05 0.000653895967176272
+ 1.207e-05 0.000513358767075384
+ 1.2072e-05 0.000617855586816243
+ 1.2074e-05 0.000700924636258227
+ 1.2076e-05 0.000892408811511257
+ 1.2078e-05 0.000836476827696798
+ 1.208e-05 0.000811248866204509
+ 1.2082e-05 0.000876037064029903
+ 1.2084e-05 0.001143892510844
+ 1.2086e-05 0.000970235289588006
+ 1.2088e-05 0.00081893608630002
+ 1.209e-05 0.00104263673039336
+ 1.2092e-05 0.00106739988192371
+ 1.2094e-05 0.00114564970930558
+ 1.2096e-05 0.00101100345077536
+ 1.2098e-05 0.00135758326134658
+ 1.21e-05 0.00139003767659401
+ 1.2102e-05 0.00140919947887195
+ 1.2104e-05 0.00127290770496341
+ 1.2106e-05 0.000945139868895845
+ 1.2108e-05 0.000854220590435457
+ 1.211e-05 0.000639112713167915
+ 1.2112e-05 0.000539406365607202
+ 1.2114e-05 0.000697331406271002
+ 1.2116e-05 0.000778357335847686
+ 1.2118e-05 0.00057386801013385
+ 1.212e-05 0.000367445513862284
+ 1.2122e-05 6.28223413242241e-05
+ 1.2124e-05 3.79862682960328e-05
+ 1.2126e-05 0.00040483792802003
+ 1.2128e-05 0.000244044277112578
+ 1.213e-05 0.000379264486573718
+ 1.2132e-05 0.000151519971548017
+ 1.2134e-05 5.38657598534906e-05
+ 1.2136e-05 0.000240584719500599
+ 1.2138e-05 0.000253402272683793
+ 1.214e-05 0.000232851975827124
+ 1.2142e-05 0.000505109569945399
+ 1.2144e-05 0.000359712646430805
+ 1.2146e-05 2.05002195997517e-05
+ 1.2148e-05 0.00017755427434654
+ 1.215e-05 0.000329101213208037
+ 1.2152e-05 0.000375875173139802
+ 1.2154e-05 0.000514018155449337
+ 1.2156e-05 0.000351663003077427
+ 1.2158e-05 0.000438217640974857
+ 1.216e-05 0.000334045086519103
+ 1.2162e-05 0.000433750564619203
+ 1.2164e-05 0.000468107046573346
+ 1.2166e-05 0.000121730429864447
+ 1.2168e-05 0.000307617019234955
+ 1.217e-05 0.000346998354556928
+ 1.2172e-05 0.000559746265087332
+ 1.2174e-05 0.000590447383914725
+ 1.2176e-05 0.000772397089089579
+ 1.2178e-05 0.000846771777392279
+ 1.218e-05 0.000667954243529434
+ 1.2182e-05 0.000501791071432631
+ 1.2184e-05 0.000373475899022939
+ 1.2186e-05 0.000373198094988887
+ 1.2188e-05 0.000309670113279855
+ 1.219e-05 0.000539311017223574
+ 1.2192e-05 0.000346477097864771
+ 1.2194e-05 0.000147346307007002
+ 1.2196e-05 -0.000145355713287169
+ 1.2198e-05 -0.000466029340504369
+ 1.22e-05 -0.000762601253873978
+ 1.2202e-05 -0.00071803089212195
+ 1.2204e-05 -0.000551310516184491
+ 1.2206e-05 -0.000460231037680426
+ 1.2208e-05 -0.000648447882988771
+ 1.221e-05 -0.000475231433997855
+ 1.2212e-05 -0.000588358506357922
+ 1.2214e-05 -0.000564715864112102
+ 1.2216e-05 -0.000313001048733354
+ 1.2218e-05 -0.000428325886654628
+ 1.222e-05 -0.000129938568851617
+ 1.2222e-05 3.9799154185303e-05
+ 1.2224e-05 -0.000247848650039219
+ 1.2226e-05 0.000115592062862758
+ 1.2228e-05 0.000223953627173252
+ 1.223e-05 0.000181048137162456
+ 1.2232e-05 0.00030795395925157
+ 1.2234e-05 0.000438173595462752
+ 1.2236e-05 0.00031326464403233
+ 1.2238e-05 0.000529735071144788
+ 1.224e-05 0.000812527815888641
+ 1.2242e-05 0.0013695909936823
+ 1.2244e-05 0.00105780072980914
+ 1.2246e-05 0.000710768148378364
+ 1.2248e-05 0.000897127317831395
+ 1.225e-05 0.00097355115235651
+ 1.2252e-05 0.000836213304504679
+ 1.2254e-05 0.00117246675767603
+ 1.2256e-05 0.00121645028299231
+ 1.2258e-05 0.00140853958890615
+ 1.226e-05 0.00120350202509376
+ 1.2262e-05 0.000896731708601462
+ 1.2264e-05 0.0014833784584633
+ 1.2266e-05 0.0015002681462319
+ 1.2268e-05 0.00135113415633068
+ 1.227e-05 0.0010013036961669
+ 1.2272e-05 0.000827184681676902
+ 1.2274e-05 0.000902854704290226
+ 1.2276e-05 0.00083360245615994
+ 1.2278e-05 0.0009737440819043
+ 1.228e-05 0.000948398320823648
+ 1.2282e-05 0.0013310170557428
+ 1.2284e-05 0.00124753217256128
+ 1.2286e-05 0.000489996369727676
+ 1.2288e-05 0.000482145036720145
+ 1.229e-05 0.000354665829274572
+ 1.2292e-05 0.000533697023847339
+ 1.2294e-05 0.000357733031053551
+ 1.2296e-05 0.000310905749020363
+ 1.2298e-05 0.000231456818741084
+ 1.23e-05 7.42371388270655e-05
+ 1.2302e-05 0.000156461794201215
+ 1.2304e-05 7.29310143954382e-05
+ 1.2306e-05 0.000274333561136839
+ 1.2308e-05 0.000125098611581995
+ 1.231e-05 6.15220754026991e-05
+ 1.2312e-05 -5.96381972212828e-05
+ 1.2314e-05 -0.000253241259547811
+ 1.2316e-05 -0.000711715214848984
+ 1.2318e-05 -0.000640209730506258
+ 1.232e-05 -0.000500309646288135
+ 1.2322e-05 -0.000482643755393755
+ 1.2324e-05 -0.000540983479196698
+ 1.2326e-05 -0.000549733204043408
+ 1.2328e-05 -0.000140646114250892
+ 1.233e-05 -0.0001771902134307
+ 1.2332e-05 -0.000191447605919933
+ 1.2334e-05 -0.000479191379595716
+ 1.2336e-05 -0.000596546855908944
+ 1.2338e-05 -0.000361662695946016
+ 1.234e-05 -0.000786814435686303
+ 1.2342e-05 -0.000669631449717733
+ 1.2344e-05 -0.000646606882175863
+ 1.2346e-05 -0.000539847798130023
+ 1.2348e-05 -0.000829084032621217
+ 1.235e-05 -0.000863026554049834
+ 1.2352e-05 -0.000900068853477282
+ 1.2354e-05 -0.000802844832194813
+ 1.2356e-05 -0.000988336994327002
+ 1.2358e-05 -0.00110057185364875
+ 1.236e-05 -0.00124299210265682
+ 1.2362e-05 -0.00126490455614634
+ 1.2364e-05 -0.00139367544574077
+ 1.2366e-05 -0.0012415084638969
+ 1.2368e-05 -0.00135631195799472
+ 1.237e-05 -0.0011804844402276
+ 1.2372e-05 -0.00135227541525577
+ 1.2374e-05 -0.00126264188562603
+ 1.2376e-05 -0.00155430002368739
+ 1.2378e-05 -0.00131335013910925
+ 1.238e-05 -0.00104119457590523
+ 1.2382e-05 -0.00109936560170489
+ 1.2384e-05 -0.000877358453932718
+ 1.2386e-05 -0.000957721291523739
+ 1.2388e-05 -0.00107924489108945
+ 1.239e-05 -0.0011749162806389
+ 1.2392e-05 -0.00110909361148347
+ 1.2394e-05 -0.00125424943015192
+ 1.2396e-05 -0.0013471994163785
+ 1.2398e-05 -0.00105485103975636
+ 1.24e-05 -0.00154376670520419
+ 1.2402e-05 -0.00134217158914009
+ 1.2404e-05 -0.00129828404962812
+ 1.2406e-05 -0.00112232491325566
+ 1.2408e-05 -0.00109640648457354
+ 1.241e-05 -0.00142671178995247
+ 1.2412e-05 -0.00144128336761845
+ 1.2414e-05 -0.00152192251587658
+ 1.2416e-05 -0.0014865172396306
+ 1.2418e-05 -0.00149697122304167
+ 1.242e-05 -0.00152959688502643
+ 1.2422e-05 -0.0013916218975056
+ 1.2424e-05 -0.00179755294485201
+ 1.2426e-05 -0.00175670341059475
+ 1.2428e-05 -0.00186845398206394
+ 1.243e-05 -0.00159955992104532
+ 1.2432e-05 -0.00168771024635916
+ 1.2434e-05 -0.0013879131520614
+ 1.2436e-05 -0.00132157251012955
+ 1.2438e-05 -0.0016064682845152
+ 1.244e-05 -0.00143002765251391
+ 1.2442e-05 -0.00108659224827864
+ 1.2444e-05 -0.0011098306935517
+ 1.2446e-05 -0.00122940641466028
+ 1.2448e-05 -0.00107504556019726
+ 1.245e-05 -0.000790555196415672
+ 1.2452e-05 -0.000704400176156687
+ 1.2454e-05 -0.000726608750734038
+ 1.2456e-05 -0.000734329106984713
+ 1.2458e-05 -0.000864730477299336
+ 1.246e-05 -0.000777372676582491
+ 1.2462e-05 -0.000925707154181822
+ 1.2464e-05 -0.000796717907995424
+ 1.2466e-05 -0.000954894957587662
+ 1.2468e-05 -0.000807540188938035
+ 1.247e-05 -0.000868031050155565
+ 1.2472e-05 -0.000834627572585657
+ 1.2474e-05 -0.00100298272033661
+ 1.2476e-05 -0.00104968363146268
+ 1.2478e-05 -0.00109791867753444
+ 1.248e-05 -0.00103236012290008
+ 1.2482e-05 -0.00108873023428722
+ 1.2484e-05 -0.000618454028280522
+ 1.2486e-05 -0.000597993850064092
+ 1.2488e-05 -0.000462077882674181
+ 1.249e-05 -0.000325980735310256
+ 1.2492e-05 -0.000100157493717523
+ 1.2494e-05 -6.59806707603765e-05
+ 1.2496e-05 -8.03520688695906e-05
+ 1.2498e-05 0.000260314373206255
+ 1.25e-05 0.000417219071836432
+ 1.2502e-05 0.000555813196989272
+ 1.2504e-05 0.000943276748581906
+ 1.2506e-05 0.0012839678677432
+ 1.2508e-05 0.00142482167409156
+ 1.251e-05 0.00150875222978184
+ 1.2512e-05 0.00150400679358307
+ 1.2514e-05 0.00139655435343272
+ 1.2516e-05 0.00158854754485472
+ 1.2518e-05 0.00170160639044385
+ 1.252e-05 0.00188958641084013
+ 1.2522e-05 0.00203297393075969
+ 1.2524e-05 0.00208229624182678
+ 1.2526e-05 0.00197937985708773
+ 1.2528e-05 0.00202619618638252
+ 1.253e-05 0.00229092952777379
+ 1.2532e-05 0.00235247141061668
+ 1.2534e-05 0.00235783914936601
+ 1.2536e-05 0.00218067883598957
+ 1.2538e-05 0.00194545466565502
+ 1.254e-05 0.00195161210992185
+ 1.2542e-05 0.00177107887066037
+ 1.2544e-05 0.00185375244071635
+ 1.2546e-05 0.00150334918827375
+ 1.2548e-05 0.00134637562786153
+ 1.255e-05 0.00152540425502895
+ 1.2552e-05 0.00155541911933362
+ 1.2554e-05 0.00150730440729391
+ 1.2556e-05 0.0015898745298479
+ 1.2558e-05 0.0016596676750496
+ 1.256e-05 0.0015413699819267
+ 1.2562e-05 0.00157640029207296
+ 1.2564e-05 0.00156711047977093
+ 1.2566e-05 0.00158853238159945
+ 1.2568e-05 0.00178031177384409
+ 1.257e-05 0.00183501755168611
+ 1.2572e-05 0.00199448229225671
+ 1.2574e-05 0.00143479507163769
+ 1.2576e-05 0.00133634392314739
+ 1.2578e-05 0.00148167386131374
+ 1.258e-05 0.00154884176884421
+ 1.2582e-05 0.00119200796759448
+ 1.2584e-05 0.00121884778413952
+ 1.2586e-05 0.0015721579279051
+ 1.2588e-05 0.00114948658912315
+ 1.259e-05 0.0011650418490141
+ 1.2592e-05 0.00083650675312132
+ 1.2594e-05 0.000934878455773143
+ 1.2596e-05 0.000896365488901752
+ 1.2598e-05 0.00084363901593126
+ 1.26e-05 0.000657234133153553
+ 1.2602e-05 0.000561561033421064
+ 1.2604e-05 0.000523278334672444
+ 1.2606e-05 0.000541915411237877
+ 1.2608e-05 0.000568654395340179
+ 1.261e-05 0.000546209072861646
+ 1.2612e-05 0.000554616071782802
+ 1.2614e-05 0.000326966950357616
+ 1.2616e-05 0.000557337051677239
+ 1.2618e-05 0.000307688131972932
+ 1.262e-05 7.03863119417531e-05
+ 1.2622e-05 0.000456319396959382
+ 1.2624e-05 0.00055902053405318
+ 1.2626e-05 0.000809022650240633
+ 1.2628e-05 0.000895497246407157
+ 1.263e-05 0.000892875852437168
+ 1.2632e-05 0.000878802487114949
+ 1.2634e-05 0.000784995794079656
+ 1.2636e-05 0.000786878064599419
+ 1.2638e-05 0.000731783414645162
+ 1.264e-05 0.000947749648112085
+ 1.2642e-05 0.000813378440541412
+ 1.2644e-05 0.000994723840910069
+ 1.2646e-05 0.000773608032710742
+ 1.2648e-05 0.000704894684135673
+ 1.265e-05 0.000482144042038083
+ 1.2652e-05 0.000479909944824379
+ 1.2654e-05 0.000644721927009338
+ 1.2656e-05 0.000571348150834516
+ 1.2658e-05 0.000514286952367797
+ 1.266e-05 0.000493313280459516
+ 1.2662e-05 0.000180959433995544
+ 1.2664e-05 0.000111494350833337
+ 1.2666e-05 0.000289292013501557
+ 1.2668e-05 2.60237386446936e-05
+ 1.267e-05 0.000318762293546505
+ 1.2672e-05 0.000439982056453275
+ 1.2674e-05 0.000231138206182581
+ 1.2676e-05 2.85986312365024e-05
+ 1.2678e-05 0.000168486432669984
+ 1.268e-05 0.000351287651898738
+ 1.2682e-05 0.000909431719088579
+ 1.2684e-05 0.00110267176483063
+ 1.2686e-05 0.000946241738083049
+ 1.2688e-05 0.000910606488044457
+ 1.269e-05 0.00127071402632577
+ 1.2692e-05 0.00118839081989944
+ 1.2694e-05 0.00101766954669705
+ 1.2696e-05 0.00124166089804682
+ 1.2698e-05 0.000829910368469436
+ 1.27e-05 0.00086949097316841
+ 1.2702e-05 0.000716190380929695
+ 1.2704e-05 0.000574739379959475
+ 1.2706e-05 0.000536217316832734
+ 1.2708e-05 0.000178214664229708
+ 1.271e-05 0.000219894984382171
+ 1.2712e-05 0.000252391676446628
+ 1.2714e-05 0.000223388828755713
+ 1.2716e-05 0.000677611994484108
+ 1.2718e-05 0.000817627736212532
+ 1.272e-05 0.000805570254345262
+ 1.2722e-05 0.000606145620203494
+ 1.2724e-05 0.000779689517015778
+ 1.2726e-05 0.0007469509449701
+ 1.2728e-05 0.000788323964445883
+ 1.273e-05 0.000606398557297219
+ 1.2732e-05 0.000817567753895838
+ 1.2734e-05 0.000675225755452902
+ 1.2736e-05 0.000449475095941168
+ 1.2738e-05 0.000529980232549332
+ 1.274e-05 0.000727800774043152
+ 1.2742e-05 0.000532045436200712
+ 1.2744e-05 0.000668460550185297
+ 1.2746e-05 0.000977767672954444
+ 1.2748e-05 0.00099978769459815
+ 1.275e-05 0.00124299321267382
+ 1.2752e-05 0.0013175867541444
+ 1.2754e-05 0.00104410163787218
+ 1.2756e-05 0.0007949089927878
+ 1.2758e-05 0.00076216363185548
+ 1.276e-05 0.000469689478898325
+ 1.2762e-05 0.000514701278915145
+ 1.2764e-05 0.000559190889090681
+ 1.2766e-05 0.000564729642431069
+ 1.2768e-05 0.000409692991903331
+ 1.277e-05 0.000469502067605728
+ 1.2772e-05 0.00033596465441463
+ 1.2774e-05 0.000799047887792308
+ 1.2776e-05 0.000724340537124669
+ 1.2778e-05 0.000733372205621146
+ 1.278e-05 0.000443075600198858
+ 1.2782e-05 0.000130909570617159
+ 1.2784e-05 -0.000180548307795133
+ 1.2786e-05 -0.000461695612837779
+ 1.2788e-05 -0.000746988207890369
+ 1.279e-05 -0.000845010953756234
+ 1.2792e-05 -0.000668520641239174
+ 1.2794e-05 -0.000621855861011604
+ 1.2796e-05 -0.000658599711092026
+ 1.2798e-05 -0.000263428168373961
+ 1.28e-05 9.94105842620248e-05
+ 1.2802e-05 9.55877330221252e-05
+ 1.2804e-05 9.09727724463285e-05
+ 1.2806e-05 -0.000256932842464857
+ 1.2808e-05 -2.1946264511146e-05
+ 1.281e-05 0.000301509327143477
+ 1.2812e-05 0.000474618971908475
+ 1.2814e-05 0.000511731453312119
+ 1.2816e-05 0.000787979777656806
+ 1.2818e-05 0.00101215167906113
+ 1.282e-05 0.0011235250830405
+ 1.2822e-05 0.00125635159983077
+ 1.2824e-05 0.00114635381666489
+ 1.2826e-05 0.00101105992949752
+ 1.2828e-05 0.000868052098023588
+ 1.283e-05 0.000810199409530909
+ 1.2832e-05 0.000529165223759218
+ 1.2834e-05 0.000472757202027856
+ 1.2836e-05 0.000698200617192616
+ 1.2838e-05 0.000523618115009059
+ 1.284e-05 0.000971544846791558
+ 1.2842e-05 0.000968789018682098
+ 1.2844e-05 0.00103234597420629
+ 1.2846e-05 0.00119120724286408
+ 1.2848e-05 0.0011575177919088
+ 1.285e-05 0.000956354718685284
+ 1.2852e-05 0.000737637903960531
+ 1.2854e-05 0.000460341853939907
+ 1.2856e-05 0.000488607647510391
+ 1.2858e-05 0.000377861463272413
+ 1.286e-05 0.000443624114353998
+ 1.2862e-05 0.000541429485896854
+ 1.2864e-05 0.000303078914110582
+ 1.2866e-05 0.000249172981321544
+ 1.2868e-05 -0.000118248167291469
+ 1.287e-05 0.000168419065447226
+ 1.2872e-05 0.000321286545412637
+ 1.2874e-05 0.00021020771722645
+ 1.2876e-05 0.000395824797001289
+ 1.2878e-05 0.000165284550739873
+ 1.288e-05 0.000233493026301886
+ 1.2882e-05 0.000362974436877993
+ 1.2884e-05 0.00034517133155576
+ 1.2886e-05 0.000587218343962411
+ 1.2888e-05 0.000377517833334474
+ 1.289e-05 0.000715032642846462
+ 1.2892e-05 0.000663766870388349
+ 1.2894e-05 0.000534870773393806
+ 1.2896e-05 0.000405959614315885
+ 1.2898e-05 0.000375328780708041
+ 1.29e-05 0.000496981355637686
+ 1.2902e-05 0.000397303625690701
+ 1.2904e-05 0.000380750630593577
+ 1.2906e-05 0.000226000743141673
+ 1.2908e-05 -0.000268420760296025
+ 1.291e-05 -0.000139417668973956
+ 1.2912e-05 -0.00014929159411031
+ 1.2914e-05 -9.45737719758852e-05
+ 1.2916e-05 -0.000108812431978259
+ 1.2918e-05 -0.000198705012400874
+ 1.292e-05 -0.000354383302569181
+ 1.2922e-05 -4.77497729989119e-05
+ 1.2924e-05 -0.000112851044216955
+ 1.2926e-05 -8.87565670670956e-05
+ 1.2928e-05 -0.000113766667789907
+ 1.293e-05 -7.29820140672773e-05
+ 1.2932e-05 -2.1769945041631e-05
+ 1.2934e-05 0.000129834601119539
+ 1.2936e-05 0.000217798040341803
+ 1.2938e-05 0.000336277738463657
+ 1.294e-05 0.000885022638452935
+ 1.2942e-05 0.000759550494883564
+ 1.2944e-05 0.000946213513574962
+ 1.2946e-05 0.000672458877832814
+ 1.2948e-05 0.000613804698456624
+ 1.295e-05 0.00044900983596918
+ 1.2952e-05 0.000199108920925418
+ 1.2954e-05 -0.000273610381474013
+ 1.2956e-05 -0.000410734515513388
+ 1.2958e-05 -0.000213132030028321
+ 1.296e-05 -0.000244562913647486
+ 1.2962e-05 -0.000629629875100836
+ 1.2964e-05 -0.00099561684585103
+ 1.2966e-05 -0.00106888591839728
+ 1.2968e-05 -0.000949942990240046
+ 1.297e-05 -0.00109134043083836
+ 1.2972e-05 -0.000511866395472921
+ 1.2974e-05 -0.000540850890472711
+ 1.2976e-05 -0.000535154301353052
+ 1.2978e-05 -0.00106098868530585
+ 1.298e-05 -0.000964003245339901
+ 1.2982e-05 -0.000999309002690439
+ 1.2984e-05 -0.00142272186058397
+ 1.2986e-05 -0.00133082317047293
+ 1.2988e-05 -0.00140742923443552
+ 1.299e-05 -0.00142044122056066
+ 1.2992e-05 -0.00118555696221865
+ 1.2994e-05 -0.00116955445514219
+ 1.2996e-05 -0.000939108676165403
+ 1.2998e-05 -0.000895508236256917
+ 1.3e-05 -0.000995174011033927
+ 1.3002e-05 -0.00108600079329112
+ 1.3004e-05 -0.000720544649987602
+ 1.3006e-05 -0.000434536165450333
+ 1.3008e-05 -0.000683985571972357
+ 1.301e-05 -0.0011749126481238
+ 1.3012e-05 -0.00119341043063459
+ 1.3014e-05 -0.00106209035318294
+ 1.3016e-05 -0.00107873082450112
+ 1.3018e-05 -0.00112767847102446
+ 1.302e-05 -0.0010057933487413
+ 1.3022e-05 -0.00131245410201645
+ 1.3024e-05 -0.0013893257385106
+ 1.3026e-05 -0.00150360572461092
+ 1.3028e-05 -0.00185238092576967
+ 1.303e-05 -0.001758896101221
+ 1.3032e-05 -0.00160778975760959
+ 1.3034e-05 -0.00139244589673047
+ 1.3036e-05 -0.0015357048902903
+ 1.3038e-05 -0.00168683551567696
+ 1.304e-05 -0.00170869169549287
+ 1.3042e-05 -0.00107328328141852
+ 1.3044e-05 -0.00113739451191539
+ 1.3046e-05 -0.00110998864350441
+ 1.3048e-05 -0.00128504845308266
+ 1.305e-05 -0.00114455664922082
+ 1.3052e-05 -0.00134832445977867
+ 1.3054e-05 -0.000812698738217989
+ 1.3056e-05 -0.000893942264627012
+ 1.3058e-05 -0.000580757934439298
+ 1.306e-05 -0.000380353013223699
+ 1.3062e-05 -0.000119055541554096
+ 1.3064e-05 0.000141614855025232
+ 1.3066e-05 0.000113783084551794
+ 1.3068e-05 -5.54320098227583e-05
+ 1.307e-05 -0.000174857722911046
+ 1.3072e-05 -0.000299813546308699
+ 1.3074e-05 -0.000464526065141864
+ 1.3076e-05 -0.000664102752632008
+ 1.3078e-05 -0.000685254183853091
+ 1.308e-05 -0.000560254189392573
+ 1.3082e-05 -0.000899143914402
+ 1.3084e-05 -0.000662869528654168
+ 1.3086e-05 -0.000580101131468201
+ 1.3088e-05 -0.000601313694394853
+ 1.309e-05 -0.000855582703217476
+ 1.3092e-05 -0.000836082572189442
+ 1.3094e-05 -0.000652890777967642
+ 1.3096e-05 -0.000685536419728918
+ 1.3098e-05 -0.000654085472922419
+ 1.31e-05 -0.000713129128239177
+ 1.3102e-05 -0.000697837996886686
+ 1.3104e-05 -0.00106685441820509
+ 1.3106e-05 -0.00101102485319567
+ 1.3108e-05 -0.00096572872558309
+ 1.311e-05 -0.00078372251893667
+ 1.3112e-05 -0.000604182729440871
+ 1.3114e-05 -0.000685671369359499
+ 1.3116e-05 -0.000712388289256115
+ 1.3118e-05 -0.000982862311367348
+ 1.312e-05 -0.00129669412295107
+ 1.3122e-05 -0.00113400284377815
+ 1.3124e-05 -0.000832298208334526
+ 1.3126e-05 -0.000836147288882942
+ 1.3128e-05 -0.000758694115612977
+ 1.313e-05 -0.000987111565985279
+ 1.3132e-05 -0.000842547327946134
+ 1.3134e-05 -0.000569297280519247
+ 1.3136e-05 -0.000638323720771864
+ 1.3138e-05 -0.000607276044713882
+ 1.314e-05 -0.000385169503632328
+ 1.3142e-05 -0.000705966934418984
+ 1.3144e-05 -0.000662630531120421
+ 1.3146e-05 -0.00053152446081414
+ 1.3148e-05 -0.000398130457544634
+ 1.315e-05 -0.000103166804053939
+ 1.3152e-05 0.000113472118285806
+ 1.3154e-05 -0.000105077359402101
+ 1.3156e-05 -0.00022079938448144
+ 1.3158e-05 -0.000308319484230632
+ 1.316e-05 -0.000108484974573391
+ 1.3162e-05 0.000135311441244243
+ 1.3164e-05 3.52908205349503e-05
+ 1.3166e-05 0.000368656003025037
+ 1.3168e-05 0.000239461020572547
+ 1.317e-05 -0.000113886773420228
+ 1.3172e-05 -0.000334033410662389
+ 1.3174e-05 -0.000260126230164753
+ 1.3176e-05 -8.4670163958032e-05
+ 1.3178e-05 0.000234866605898846
+ 1.318e-05 4.61400496189562e-05
+ 1.3182e-05 0.000122761762970545
+ 1.3184e-05 0.000170966987174774
+ 1.3186e-05 1.83754076190323e-05
+ 1.3188e-05 -9.80774971206727e-05
+ 1.319e-05 -4.25184854309023e-05
+ 1.3192e-05 0.000390851180078468
+ 1.3194e-05 0.000292821475775889
+ 1.3196e-05 0.000476013734046918
+ 1.3198e-05 0.000434093758218768
+ 1.32e-05 0.000438698310741015
+ 1.3202e-05 0.000878497828682332
+ 1.3204e-05 0.000857565304821092
+ 1.3206e-05 0.000987948266007486
+ 1.3208e-05 0.00132383811496067
+ 1.321e-05 0.00143024270086359
+ 1.3212e-05 0.00156071647848099
+ 1.3214e-05 0.0017654014611712
+ 1.3216e-05 0.00195829651124202
+ 1.3218e-05 0.00181928081731177
+ 1.322e-05 0.00172308104174879
+ 1.3222e-05 0.0017368194295424
+ 1.3224e-05 0.00204322121942233
+ 1.3226e-05 0.00189420359046648
+ 1.3228e-05 0.00206941336601924
+ 1.323e-05 0.00214736599498393
+ 1.3232e-05 0.00187234534084158
+ 1.3234e-05 0.00174922469305555
+ 1.3236e-05 0.00165445761591312
+ 1.3238e-05 0.00173506716599233
+ 1.324e-05 0.00172148230198943
+ 1.3242e-05 0.00167667834805079
+ 1.3244e-05 0.0011680598155151
+ 1.3246e-05 0.000797141751647548
+ 1.3248e-05 0.000745987386676924
+ 1.325e-05 0.000363272784916808
+ 1.3252e-05 0.000475021975103323
+ 1.3254e-05 0.000614055589904932
+ 1.3256e-05 0.000225374038743423
+ 1.3258e-05 0.000181675495350919
+ 1.326e-05 0.000354113797480776
+ 1.3262e-05 0.00018899435253775
+ 1.3264e-05 9.09747915664087e-05
+ 1.3266e-05 0.000301754467077717
+ 1.3268e-05 0.000317011369047016
+ 1.327e-05 9.58219250882167e-05
+ 1.3272e-05 0.000418996237895555
+ 1.3274e-05 0.000500838325316409
+ 1.3276e-05 0.000388828933542598
+ 1.3278e-05 0.000616704236554731
+ 1.328e-05 0.000597609060161672
+ 1.3282e-05 0.000553386629701591
+ 1.3284e-05 0.000375718677509657
+ 1.3286e-05 0.000536913556912557
+ 1.3288e-05 0.000459273816244166
+ 1.329e-05 0.00035382338485267
+ 1.3292e-05 0.000410881799480584
+ 1.3294e-05 0.000364669758903349
+ 1.3296e-05 0.000192428189806873
+ 1.3298e-05 0.000459756589018137
+ 1.33e-05 0.000380519197063433
+ 1.3302e-05 0.000509635524774854
+ 1.3304e-05 0.000380078243926509
+ 1.3306e-05 0.000567929098738729
+ 1.3308e-05 0.000708896545137441
+ 1.331e-05 0.000860825949508589
+ 1.3312e-05 0.000817105577079817
+ 1.3314e-05 0.00105904277228984
+ 1.3316e-05 0.00106611529648621
+ 1.3318e-05 0.00110586680793211
+ 1.332e-05 0.00104484487432123
+ 1.3322e-05 0.0011410531493068
+ 1.3324e-05 0.00122279576920358
+ 1.3326e-05 0.00128077880090621
+ 1.3328e-05 0.00108736360380934
+ 1.333e-05 0.000996453526959177
+ 1.3332e-05 0.00117416288520574
+ 1.3334e-05 0.00103504743634053
+ 1.3336e-05 0.000909563365559593
+ 1.3338e-05 0.00108311801073428
+ 1.334e-05 0.00128246444709878
+ 1.3342e-05 0.0011823092299939
+ 1.3344e-05 0.000994384221843098
+ 1.3346e-05 0.000862211354343914
+ 1.3348e-05 0.00107019563848102
+ 1.335e-05 0.00127948026989001
+ 1.3352e-05 0.00165259747410203
+ 1.3354e-05 0.00162681349201151
+ 1.3356e-05 0.00144402789176164
+ 1.3358e-05 0.0011272332679786
+ 1.336e-05 0.000929192575190248
+ 1.3362e-05 0.000645060739167188
+ 1.3364e-05 0.00100953235404832
+ 1.3366e-05 0.000784226497950691
+ 1.3368e-05 0.0007324285804008
+ 1.337e-05 0.000640456228959503
+ 1.3372e-05 0.000301214561183382
+ 1.3374e-05 0.000328299432388378
+ 1.3376e-05 0.000135143141256138
+ 1.3378e-05 0.000244982525809635
+ 1.338e-05 4.03824300328723e-05
+ 1.3382e-05 0.000249741718145808
+ 1.3384e-05 0.000319725876163225
+ 1.3386e-05 0.000223111974178911
+ 1.3388e-05 0.000449376241600082
+ 1.339e-05 9.07231581208162e-05
+ 1.3392e-05 0.000251862985451012
+ 1.3394e-05 0.000217614387707482
+ 1.3396e-05 0.000278118977991827
+ 1.3398e-05 0.000402620054473806
+ 1.34e-05 0.000284276238734485
+ 1.3402e-05 8.45128405044707e-05
+ 1.3404e-05 -0.000133714646780281
+ 1.3406e-05 -0.000213132360131142
+ 1.3408e-05 -8.90688178541813e-05
+ 1.341e-05 -4.64365449934168e-05
+ 1.3412e-05 -0.000154244756655485
+ 1.3414e-05 -0.000445923736665762
+ 1.3416e-05 -0.000686396030391279
+ 1.3418e-05 -0.00044098931379546
+ 1.342e-05 -0.000204276804106284
+ 1.3422e-05 -0.000190458440499864
+ 1.3424e-05 -0.000754039147943584
+ 1.3426e-05 -0.000696690749602401
+ 1.3428e-05 -0.0006329443819688
+ 1.343e-05 -0.00058485716333839
+ 1.3432e-05 -0.000442246688587849
+ 1.3434e-05 -0.000453389631761817
+ 1.3436e-05 -0.000367323703667964
+ 1.3438e-05 -0.000666949315235194
+ 1.344e-05 -0.000570605992273084
+ 1.3442e-05 -0.000315246057426154
+ 1.3444e-05 -0.00016820970731411
+ 1.3446e-05 -9.6282531759032e-05
+ 1.3448e-05 -0.000289778369691051
+ 1.345e-05 -0.000454535965710238
+ 1.3452e-05 -0.000271802899095159
+ 1.3454e-05 -0.000306770832604197
+ 1.3456e-05 4.41063582804697e-05
+ 1.3458e-05 -5.74673897950111e-06
+ 1.346e-05 -0.000228454357751293
+ 1.3462e-05 -0.00024539779843417
+ 1.3464e-05 -0.000517567137511477
+ 1.3466e-05 -0.000672608891712886
+ 1.3468e-05 -0.000656526960021774
+ 1.347e-05 -0.000962371790674748
+ 1.3472e-05 -0.000811189569725366
+ 1.3474e-05 -0.000914785633320789
+ 1.3476e-05 -0.000757092287630161
+ 1.3478e-05 -0.00103496612934252
+ 1.348e-05 -0.00101907280369987
+ 1.3482e-05 -0.000400897279138283
+ 1.3484e-05 -0.000514834059952016
+ 1.3486e-05 -0.000450765397552147
+ 1.3488e-05 -0.000146399080899455
+ 1.349e-05 -0.000314860201460677
+ 1.3492e-05 4.68573746835202e-05
+ 1.3494e-05 3.38978990019636e-05
+ 1.3496e-05 -0.000175348780154699
+ 1.3498e-05 -0.000650154551278596
+ 1.35e-05 -0.000467917523988521
+ 1.3502e-05 -0.000419372081765756
+ 1.3504e-05 -0.000218974805344418
+ 1.3506e-05 -0.00019286426436149
+ 1.3508e-05 -1.76187296991664e-05
+ 1.351e-05 9.44308756159038e-05
+ 1.3512e-05 0.00030853405205347
+ 1.3514e-05 8.03741008133042e-05
+ 1.3516e-05 0.000263986947099112
+ 1.3518e-05 0.000175297792013644
+ 1.352e-05 0.000380430077791299
+ 1.3522e-05 0.000680249322754644
+ 1.3524e-05 0.000567627079593082
+ 1.3526e-05 0.000877290621441515
+ 1.3528e-05 0.000982558057445798
+ 1.353e-05 0.00121875615225816
+ 1.3532e-05 0.00155741263708795
+ 1.3534e-05 0.00151640445305996
+ 1.3536e-05 0.00166470199649125
+ 1.3538e-05 0.00174399036464747
+ 1.354e-05 0.0016093061244945
+ 1.3542e-05 0.00159531833874832
+ 1.3544e-05 0.00126541873432566
+ 1.3546e-05 0.00145679406267123
+ 1.3548e-05 0.00158675990868492
+ 1.355e-05 0.00131660547344184
+ 1.3552e-05 0.000846143829538849
+ 1.3554e-05 0.00103603341066939
+ 1.3556e-05 0.00114634663557653
+ 1.3558e-05 0.0011801750437679
+ 1.356e-05 0.00105726579193435
+ 1.3562e-05 0.000814446760280667
+ 1.3564e-05 0.00104789371812074
+ 1.3566e-05 0.000598401601990286
+ 1.3568e-05 0.00079235261285192
+ 1.357e-05 0.000614286608424144
+ 1.3572e-05 0.000735632629329006
+ 1.3574e-05 0.000534969042922275
+ 1.3576e-05 0.000485508628934517
+ 1.3578e-05 0.000121572641383333
+ 1.358e-05 0.000108438067827056
+ 1.3582e-05 -0.000265453755119411
+ 1.3584e-05 -0.000360948266293075
+ 1.3586e-05 -0.000640233038454572
+ 1.3588e-05 -0.000690155866449065
+ 1.359e-05 -0.00066585926926472
+ 1.3592e-05 -0.000948825430562578
+ 1.3594e-05 -0.00111181199739021
+ 1.3596e-05 -0.00109783303662777
+ 1.3598e-05 -0.00114087121718854
+ 1.36e-05 -0.000956132587616511
+ 1.3602e-05 -0.00111810275217297
+ 1.3604e-05 -0.00124622565056606
+ 1.3606e-05 -0.00119098200946927
+ 1.3608e-05 -0.000855343081425779
+ 1.361e-05 -0.000937968118511166
+ 1.3612e-05 -0.00115657528356199
+ 1.3614e-05 -0.00132993096690623
+ 1.3616e-05 -0.0013777050811117
+ 1.3618e-05 -0.00144988168877769
+ 1.362e-05 -0.00123120712599813
+ 1.3622e-05 -0.000937765297923836
+ 1.3624e-05 -0.000910339003088448
+ 1.3626e-05 -0.000709710775811615
+ 1.3628e-05 -0.000758172196913622
+ 1.363e-05 -0.000756223119355348
+ 1.3632e-05 -0.000743661012252917
+ 1.3634e-05 -0.000995839423737406
+ 1.3636e-05 -0.00109262818860588
+ 1.3638e-05 -0.00104225125069898
+ 1.364e-05 -0.000993966978336777
+ 1.3642e-05 -0.000958788874458954
+ 1.3644e-05 -0.000948807791910315
+ 1.3646e-05 -0.000782486069560677
+ 1.3648e-05 -0.000464923458799507
+ 1.365e-05 1.39646909616328e-05
+ 1.3652e-05 -0.000137260281267716
+ 1.3654e-05 -0.000125595078858765
+ 1.3656e-05 -0.000351561149793902
+ 1.3658e-05 -0.000450007440742995
+ 1.366e-05 -0.000505914928274785
+ 1.3662e-05 -0.000500299961932836
+ 1.3664e-05 -0.000639399923855128
+ 1.3666e-05 -0.000452271900389915
+ 1.3668e-05 -0.000455503466843991
+ 1.367e-05 -0.000482191290488642
+ 1.3672e-05 -0.000101394605207758
+ 1.3674e-05 -0.000202349531512855
+ 1.3676e-05 -0.000668823413539952
+ 1.3678e-05 -0.00035239863739178
+ 1.368e-05 3.7115430002503e-05
+ 1.3682e-05 0.000345343094517544
+ 1.3684e-05 0.000385719125265211
+ 1.3686e-05 0.00030347305400312
+ 1.3688e-05 0.000100591403057575
+ 1.369e-05 0.000114759105324994
+ 1.3692e-05 0.000195304799828033
+ 1.3694e-05 0.000242501121966231
+ 1.3696e-05 9.2793843774737e-05
+ 1.3698e-05 0.000141738064309578
+ 1.37e-05 -5.00210998507607e-05
+ 1.3702e-05 0.000142199741829564
+ 1.3704e-05 0.00011377226044527
+ 1.3706e-05 -5.15527388229482e-05
+ 1.3708e-05 0.0001685277975169
+ 1.371e-05 0.000537228125191065
+ 1.3712e-05 0.000642547504685195
+ 1.3714e-05 0.000452873905817071
+ 1.3716e-05 0.000418266209410671
+ 1.3718e-05 0.000734724558415101
+ 1.372e-05 0.00107872263654786
+ 1.3722e-05 0.000965282930910662
+ 1.3724e-05 0.000978448501004989
+ 1.3726e-05 0.000775966842873914
+ 1.3728e-05 0.000714943828765256
+ 1.373e-05 0.000535405628948996
+ 1.3732e-05 0.000444997962732394
+ 1.3734e-05 5.80294711275602e-05
+ 1.3736e-05 0.000156863382381687
+ 1.3738e-05 0.00018751339657627
+ 1.374e-05 -8.39612878405926e-05
+ 1.3742e-05 -0.000155987542993729
+ 1.3744e-05 -6.4541262456886e-05
+ 1.3746e-05 -0.000401035610029157
+ 1.3748e-05 -0.000638860984499571
+ 1.375e-05 -0.000506221024715396
+ 1.3752e-05 -0.000407404301771475
+ 1.3754e-05 -0.000473204297592176
+ 1.3756e-05 -0.000312398206374558
+ 1.3758e-05 -0.000171819211570868
+ 1.376e-05 -8.26106330985719e-05
+ 1.3762e-05 -0.000105718572488728
+ 1.3764e-05 -7.22716376680851e-05
+ 1.3766e-05 -0.000182343600975484
+ 1.3768e-05 -0.000229084095398698
+ 1.377e-05 -0.000351646852185178
+ 1.3772e-05 -6.84540023841854e-05
+ 1.3774e-05 8.58804900160714e-05
+ 1.3776e-05 0.000289940980449851
+ 1.3778e-05 0.000556681806739985
+ 1.378e-05 0.000664726767381703
+ 1.3782e-05 0.000645786161987595
+ 1.3784e-05 0.000601080852327067
+ 1.3786e-05 0.000573243569345937
+ 1.3788e-05 0.000515045793173546
+ 1.379e-05 0.00022232971297224
+ 1.3792e-05 0.000498905362857996
+ 1.3794e-05 0.000495225727573651
+ 1.3796e-05 0.000465647045101446
+ 1.3798e-05 0.00035021262193863
+ 1.38e-05 0.000143155050772913
+ 1.3802e-05 -0.000270075053624257
+ 1.3804e-05 -0.000425279802202832
+ 1.3806e-05 -0.000176299395866414
+ 1.3808e-05 -0.000162524982395362
+ 1.381e-05 8.99604551193824e-05
+ 1.3812e-05 0.000205262920607072
+ 1.3814e-05 0.000524861714055185
+ 1.3816e-05 0.000237806294864729
+ 1.3818e-05 0.000186623741137614
+ 1.382e-05 0.00032402908818781
+ 1.3822e-05 0.000607246774278239
+ 1.3824e-05 0.00075819555190249
+ 1.3826e-05 0.000876649836834632
+ 1.3828e-05 0.000793773134069339
+ 1.383e-05 0.000795524925259007
+ 1.3832e-05 0.000526507784811003
+ 1.3834e-05 0.000469682696759568
+ 1.3836e-05 0.000313441379381898
+ 1.3838e-05 0.000275197039718285
+ 1.384e-05 0.000424042958247968
+ 1.3842e-05 0.00038210174263772
+ 1.3844e-05 0.000350059919119158
+ 1.3846e-05 6.55099169848128e-07
+ 1.3848e-05 5.11363963887019e-05
+ 1.385e-05 0.000189024911286182
+ 1.3852e-05 0.0002028630874446
+ 1.3854e-05 0.00013148905455719
+ 1.3856e-05 0.000500484459402423
+ 1.3858e-05 0.000687197060986846
+ 1.386e-05 0.000772692938274089
+ 1.3862e-05 0.00107445296864053
+ 1.3864e-05 0.00108740210495192
+ 1.3866e-05 0.00119004959866358
+ 1.3868e-05 0.00112260190982125
+ 1.387e-05 0.00118963887713845
+ 1.3872e-05 0.000687904314176963
+ 1.3874e-05 0.00064863291775572
+ 1.3876e-05 0.000574508769850312
+ 1.3878e-05 0.000371167385339049
+ 1.388e-05 9.50489581656169e-05
+ 1.3882e-05 0.000132086340134559
+ 1.3884e-05 0.000141052941099088
+ 1.3886e-05 0.000348916836331539
+ 1.3888e-05 0.000202239924368
+ 1.389e-05 0.000503932548253719
+ 1.3892e-05 0.00033586984231804
+ 1.3894e-05 0.00028363602913338
+ 1.3896e-05 0.000546730704498982
+ 1.3898e-05 0.000653188798206731
+ 1.39e-05 0.000662168791177855
+ 1.3902e-05 0.000596396579062294
+ 1.3904e-05 0.000418020944955501
+ 1.3906e-05 0.000317814411071103
+ 1.3908e-05 0.000214566640695393
+ 1.391e-05 0.000448780745047278
+ 1.3912e-05 0.00048973499792074
+ 1.3914e-05 0.000508804646638475
+ 1.3916e-05 0.000411481807496531
+ 1.3918e-05 0.000205148665854977
+ 1.392e-05 0.000258412773913893
+ 1.3922e-05 0.000379899225546533
+ 1.3924e-05 5.95124528374183e-05
+ 1.3926e-05 -0.000127842267475705
+ 1.3928e-05 -0.00034097285659092
+ 1.393e-05 -0.00019262172718413
+ 1.3932e-05 -0.000220010136005647
+ 1.3934e-05 -0.00034962220123512
+ 1.3936e-05 -0.000392819573105385
+ 1.3938e-05 -0.000467600187239106
+ 1.394e-05 -0.000490483543094435
+ 1.3942e-05 -0.000853389258420826
+ 1.3944e-05 -0.00111194118493728
+ 1.3946e-05 -0.00146364510976675
+ 1.3948e-05 -0.00121524471504972
+ 1.395e-05 -0.00101183990544003
+ 1.3952e-05 -0.000940168460629282
+ 1.3954e-05 -0.00106058223145361
+ 1.3956e-05 -0.00110245288790729
+ 1.3958e-05 -0.000880519506824921
+ 1.396e-05 -0.000956803061921857
+ 1.3962e-05 -0.000652932226962727
+ 1.3964e-05 -0.000612591503819857
+ 1.3966e-05 -0.00125668569456421
+ 1.3968e-05 -0.00135038667392854
+ 1.397e-05 -0.00140487459419503
+ 1.3972e-05 -0.00127169152672823
+ 1.3974e-05 -0.0012210102933693
+ 1.3976e-05 -0.00145964163363285
+ 1.3978e-05 -0.00123189331510269
+ 1.398e-05 -0.00132185360667478
+ 1.3982e-05 -0.00161246829462281
+ 1.3984e-05 -0.00132870335801793
+ 1.3986e-05 -0.00130902987085284
+ 1.3988e-05 -0.000964745356946726
+ 1.399e-05 -0.00107705645964322
+ 1.3992e-05 -0.00100005579513134
+ 1.3994e-05 -0.000742599686544181
+ 1.3996e-05 -0.00114154832543666
+ 1.3998e-05 -0.0013004465662415
+ 1.4e-05 -0.00142544411006834
+ 1.4002e-05 -0.00125745977855683
+ 1.4004e-05 -0.00121474691201368
+ 1.4006e-05 -0.00121752370799529
+ 1.4008e-05 -0.0012217687529842
+ 1.401e-05 -0.00113912151186403
+ 1.4012e-05 -0.000996204248267592
+ 1.4014e-05 -0.00105936671147563
+ 1.4016e-05 -0.0010284592036745
+ 1.4018e-05 -0.000681911454544114
+ 1.402e-05 -0.00083413449801719
+ 1.4022e-05 -0.000589855975119083
+ 1.4024e-05 -0.000595303918095857
+ 1.4026e-05 -0.000475494758323343
+ 1.4028e-05 -0.0004663608243507
+ 1.403e-05 -0.000965414878572186
+ 1.4032e-05 -0.000941137224100615
+ 1.4034e-05 -0.00139195286711707
+ 1.4036e-05 -0.0014150666740464
+ 1.4038e-05 -0.0015731013079
+ 1.404e-05 -0.00151374071273879
+ 1.4042e-05 -0.00133149817640967
+ 1.4044e-05 -0.0011826093294389
+ 1.4046e-05 -0.00142779769722046
+ 1.4048e-05 -0.00146280964936146
+ 1.405e-05 -0.00162553286450902
+ 1.4052e-05 -0.00201349019129516
+ 1.4054e-05 -0.00190647453656284
+ 1.4056e-05 -0.00172705017817341
+ 1.4058e-05 -0.00199693908792319
+ 1.406e-05 -0.00188927564755957
+ 1.4062e-05 -0.00201629267500235
+ 1.4064e-05 -0.00167940536287242
+ 1.4066e-05 -0.00141478268975204
+ 1.4068e-05 -0.00125638125864007
+ 1.407e-05 -0.00111455596543255
+ 1.4072e-05 -0.0009820055138135
+ 1.4074e-05 -0.00113748202171855
+ 1.4076e-05 -0.00137280699326555
+ 1.4078e-05 -0.00156980585245323
+ 1.408e-05 -0.00177790545340198
+ 1.4082e-05 -0.0017487540941416
+ 1.4084e-05 -0.00170545361604884
+ 1.4086e-05 -0.00178419755060347
+ 1.4088e-05 -0.00187784787086289
+ 1.409e-05 -0.00216536666899437
+ 1.4092e-05 -0.00188809293995878
+ 1.4094e-05 -0.00206844283335831
+ 1.4096e-05 -0.00210974630699455
+ 1.4098e-05 -0.00231589825412932
+ 1.41e-05 -0.00233513432046506
+ 1.4102e-05 -0.00226186592516185
+ 1.4104e-05 -0.00224772391700291
+ 1.4106e-05 -0.00228404344286309
+ 1.4108e-05 -0.00185807090626301
+ 1.411e-05 -0.00191710698197291
+ 1.4112e-05 -0.00185260802071027
+ 1.4114e-05 -0.00212162228169194
+ 1.4116e-05 -0.00223057797770818
+ 1.4118e-05 -0.00212056730406075
+ 1.412e-05 -0.00220340530309478
+ 1.4122e-05 -0.00216387467544273
+ 1.4124e-05 -0.00213060561303254
+ 1.4126e-05 -0.00225644736587159
+ 1.4128e-05 -0.00220537261602441
+ 1.413e-05 -0.00240015621412278
+ 1.4132e-05 -0.00252050728712325
+ 1.4134e-05 -0.00247127471619974
+ 1.4136e-05 -0.00262859770145568
+ 1.4138e-05 -0.00255657372005998
+ 1.414e-05 -0.00244566017252026
+ 1.4142e-05 -0.00227106390336861
+ 1.4144e-05 -0.00247734023144184
+ 1.4146e-05 -0.00250959694505084
+ 1.4148e-05 -0.00238582432271148
+ 1.415e-05 -0.00274561649164929
+ 1.4152e-05 -0.00260684331372338
+ 1.4154e-05 -0.00237614813456075
+ 1.4156e-05 -0.00247278258934659
+ 1.4158e-05 -0.00253515033374023
+ 1.416e-05 -0.00273200554128893
+ 1.4162e-05 -0.00257731407351209
+ 1.4164e-05 -0.00263353822152195
+ 1.4166e-05 -0.0029248944335622
+ 1.4168e-05 -0.00307749508301073
+ 1.417e-05 -0.00299208272334131
+ 1.4172e-05 -0.00306565479796065
+ 1.4174e-05 -0.00317000226378109
+ 1.4176e-05 -0.00282604764142399
+ 1.4178e-05 -0.00276861434341733
+ 1.418e-05 -0.00260867595803958
+ 1.4182e-05 -0.00240427262235998
+ 1.4184e-05 -0.00219720727242353
+ 1.4186e-05 -0.00211759242682627
+ 1.4188e-05 -0.00225657591336149
+ 1.419e-05 -0.00194806263416214
+ 1.4192e-05 -0.00213011291051572
+ 1.4194e-05 -0.00183376766282533
+ 1.4196e-05 -0.00150975454578936
+ 1.4198e-05 -0.00180579531428232
+ 1.42e-05 -0.00184855736977544
+ 1.4202e-05 -0.00169094937145184
+ 1.4204e-05 -0.00148771272988827
+ 1.4206e-05 -0.00112769865526795
+ 1.4208e-05 -0.00116862834468858
+ 1.421e-05 -0.00115028607518265
+ 1.4212e-05 -0.000971454356649125
+ 1.4214e-05 -0.000664423042760975
+ 1.4216e-05 -0.000895122077499189
+ 1.4218e-05 -0.000715291023787069
+ 1.422e-05 -0.000548263693454164
+ 1.4222e-05 -0.000671567869279688
+ 1.4224e-05 -0.000461144991173184
+ 1.4226e-05 -0.0006148735960667
+ 1.4228e-05 -0.000950529806230507
+ 1.423e-05 -0.00122509264925677
+ 1.4232e-05 -0.00115380303864822
+ 1.4234e-05 -0.000991560624314391
+ 1.4236e-05 -0.000779662420509644
+ 1.4238e-05 -0.000680056817703569
+ 1.424e-05 -0.000654388160448194
+ 1.4242e-05 -0.000676657521806172
+ 1.4244e-05 -0.000676937806903508
+ 1.4246e-05 -0.000612755427693009
+ 1.4248e-05 -0.000703102703964968
+ 1.425e-05 -0.000696695074333942
+ 1.4252e-05 -0.000783059945888614
+ 1.4254e-05 -0.000595034784090615
+ 1.4256e-05 -0.000652026942239464
+ 1.4258e-05 -0.000496878554496732
+ 1.426e-05 -0.000178749293172167
+ 1.4262e-05 -0.000360293508046401
+ 1.4264e-05 -0.000337870482509631
+ 1.4266e-05 -9.37877046461472e-05
+ 1.4268e-05 -0.000551449474708908
+ 1.427e-05 -0.000871145176987535
+ 1.4272e-05 -0.000715208971349339
+ 1.4274e-05 -0.00071419857477667
+ 1.4276e-05 -0.000832434129704758
+ 1.4278e-05 -0.00051392707540671
+ 1.428e-05 -0.000264447530699127
+ 1.4282e-05 -0.000359975034939218
+ 1.4284e-05 -0.00015206661755806
+ 1.4286e-05 -0.000257244485716376
+ 1.4288e-05 -0.000123526339317443
+ 1.429e-05 -0.000100932362810762
+ 1.4292e-05 -0.000305725425945367
+ 1.4294e-05 -0.000534550321366054
+ 1.4296e-05 -0.000318132920613307
+ 1.4298e-05 -0.000121042510863697
+ 1.43e-05 -0.000210807675281001
+ 1.4302e-05 -0.000399877895493311
+ 1.4304e-05 -0.000577483382715487
+ 1.4306e-05 -0.00060498042347007
+ 1.4308e-05 -0.00067445603026438
+ 1.431e-05 -0.000600429435497048
+ 1.4312e-05 -0.000533108161641805
+ 1.4314e-05 -0.000424932487405485
+ 1.4316e-05 -0.000677665008162992
+ 1.4318e-05 -0.000348287319557156
+ 1.432e-05 -0.000588144045542554
+ 1.4322e-05 -0.000686037389487947
+ 1.4324e-05 -0.000874268096936193
+ 1.4326e-05 -0.0010524835252304
+ 1.4328e-05 -0.0010086802222519
+ 1.433e-05 -0.000868284868714268
+ 1.4332e-05 -0.000972568982525566
+ 1.4334e-05 -0.00131488353092792
+ 1.4336e-05 -0.00147129653295254
+ 1.4338e-05 -0.00158804666366747
+ 1.434e-05 -0.00177294680662752
+ 1.4342e-05 -0.00180403433776452
+ 1.4344e-05 -0.00155038310455533
+ 1.4346e-05 -0.00165597706626159
+ 1.4348e-05 -0.00155980880699651
+ 1.435e-05 -0.00156984496718197
+ 1.4352e-05 -0.00155858991888189
+ 1.4354e-05 -0.00175540753179903
+ 1.4356e-05 -0.00168733638227632
+ 1.4358e-05 -0.00183154288214113
+ 1.436e-05 -0.00194676932042262
+ 1.4362e-05 -0.00193819171235756
+ 1.4364e-05 -0.00191387195969652
+ 1.4366e-05 -0.00182689134781509
+ 1.4368e-05 -0.00206378067367799
+ 1.437e-05 -0.00231071305803771
+ 1.4372e-05 -0.00213345693411005
+ 1.4374e-05 -0.00217100104232738
+ 1.4376e-05 -0.00220294668886924
+ 1.4378e-05 -0.00215304512782332
+ 1.438e-05 -0.0022869234395703
+ 1.4382e-05 -0.00196416148156601
+ 1.4384e-05 -0.00180159590089611
+ 1.4386e-05 -0.00170952350516556
+ 1.4388e-05 -0.0014669521576484
+ 1.439e-05 -0.0013260353345881
+ 1.4392e-05 -0.001004486803874
+ 1.4394e-05 -0.00100429937425342
+ 1.4396e-05 -0.000924164105681901
+ 1.4398e-05 -0.000678043704791311
+ 1.44e-05 -0.000648649914475077
+ 1.4402e-05 -0.000372093299795784
+ 1.4404e-05 -0.000288043191276512
+ 1.4406e-05 -9.76748139102271e-05
+ 1.4408e-05 -0.000251932022960695
+ 1.441e-05 3.6916920095732e-05
+ 1.4412e-05 3.64019297005921e-05
+ 1.4414e-05 0.000332002893549721
+ 1.4416e-05 0.000449574572619603
+ 1.4418e-05 0.000546417018065777
+ 1.442e-05 0.000995986168200329
+ 1.4422e-05 0.0010034226148211
+ 1.4424e-05 0.000917344496762828
+ 1.4426e-05 0.000800818414271918
+ 1.4428e-05 0.000701958037035599
+ 1.443e-05 0.00100209908316042
+ 1.4432e-05 0.000967705030520798
+ 1.4434e-05 0.000804675022885096
+ 1.4436e-05 0.000870682605928537
+ 1.4438e-05 0.000754731424975709
+ 1.444e-05 0.000392337252981959
+ 1.4442e-05 0.00031493249407034
+ 1.4444e-05 0.00048755772270456
+ 1.4446e-05 0.000657449220818813
+ 1.4448e-05 0.000797556916083679
+ 1.445e-05 0.000481902108868355
+ 1.4452e-05 0.000403212229395598
+ 1.4454e-05 0.000414786188149279
+ 1.4456e-05 0.000629113529562607
+ 1.4458e-05 0.000523032308556173
+ 1.446e-05 0.00061088577929893
+ 1.4462e-05 0.000926977960119199
+ 1.4464e-05 0.00103769806778897
+ 1.4466e-05 0.00122428688095803
+ 1.4468e-05 0.00110459519327335
+ 1.447e-05 0.00139240518605779
+ 1.4472e-05 0.0016571426194417
+ 1.4474e-05 0.0013367803704886
+ 1.4476e-05 0.001136281295061
+ 1.4478e-05 0.00101272276465451
+ 1.448e-05 0.000980936698399119
+ 1.4482e-05 0.000881231823461202
+ 1.4484e-05 0.000897284883231288
+ 1.4486e-05 0.000993977485906122
+ 1.4488e-05 0.000712889578349105
+ 1.449e-05 0.000990084178461316
+ 1.4492e-05 0.000669529536930827
+ 1.4494e-05 0.000678421429256158
+ 1.4496e-05 0.000601334787583303
+ 1.4498e-05 0.000330988815194979
+ 1.45e-05 0.000363496111546047
+ 1.4502e-05 0.000457979207414593
+ 1.4504e-05 0.000379657106456011
+ 1.4506e-05 0.00036169939879607
+ 1.4508e-05 0.000269383724750818
+ 1.451e-05 0.00069226211363
+ 1.4512e-05 0.00078284786242295
+ 1.4514e-05 0.000483540868507261
+ 1.4516e-05 0.000344072090802863
+ 1.4518e-05 0.000326346433428835
+ 1.452e-05 0.000225905741007025
+ 1.4522e-05 0.000120792762999363
+ 1.4524e-05 9.88642375734925e-05
+ 1.4526e-05 -8.66826588165794e-05
+ 1.4528e-05 -7.66854209797684e-06
+ 1.453e-05 -0.000239355967913411
+ 1.4532e-05 -0.000386868818169352
+ 1.4534e-05 -0.000502065516128458
+ 1.4536e-05 -0.000548475937411445
+ 1.4538e-05 -0.000757375422201396
+ 1.454e-05 -0.000656117907405345
+ 1.4542e-05 -0.000832170985608524
+ 1.4544e-05 -0.000957119949519345
+ 1.4546e-05 -0.000928566451184385
+ 1.4548e-05 -0.000964264401833846
+ 1.455e-05 -0.00103121944244641
+ 1.4552e-05 -0.00112556282851835
+ 1.4554e-05 -0.00136373497741102
+ 1.4556e-05 -0.00179688048317134
+ 1.4558e-05 -0.00161358270933068
+ 1.456e-05 -0.001784002008485
+ 1.4562e-05 -0.00162417518228456
+ 1.4564e-05 -0.00179420290270397
+ 1.4566e-05 -0.00197915340172171
+ 1.4568e-05 -0.00217899991051171
+ 1.457e-05 -0.00193008847545667
+ 1.4572e-05 -0.00160044209176158
+ 1.4574e-05 -0.00158489675877266
+ 1.4576e-05 -0.00133980429508148
+ 1.4578e-05 -0.00104719794275323
+ 1.458e-05 -0.00120011342515896
+ 1.4582e-05 -0.00144768236526759
+ 1.4584e-05 -0.00131725689568722
+ 1.4586e-05 -0.00117678891228495
+ 1.4588e-05 -0.00113524909974598
+ 1.459e-05 -0.00116303448517873
+ 1.4592e-05 -0.00131093340228749
+ 1.4594e-05 -0.00128978507208219
+ 1.4596e-05 -0.00136689331471175
+ 1.4598e-05 -0.00125312674330054
+ 1.46e-05 -0.00129131472585385
+ 1.4602e-05 -0.00137205962241567
+ 1.4604e-05 -0.00144199611529559
+ 1.4606e-05 -0.0014940607366168
+ 1.4608e-05 -0.0013978064511668
+ 1.461e-05 -0.000741434964816033
+ 1.4612e-05 -0.000511108733449931
+ 1.4614e-05 -0.000350942629343593
+ 1.4616e-05 -0.000564265692270377
+ 1.4618e-05 -0.000245322800197966
+ 1.462e-05 -0.000782332715761131
+ 1.4622e-05 -0.000949688753518849
+ 1.4624e-05 -0.000982020399679044
+ 1.4626e-05 -0.000877257880970396
+ 1.4628e-05 -0.000666976647425357
+ 1.463e-05 -0.00074363522190432
+ 1.4632e-05 -0.000995974723627437
+ 1.4634e-05 -0.000808469090800791
+ 1.4636e-05 -0.000998629516271018
+ 1.4638e-05 -0.00090152248287895
+ 1.464e-05 -0.00088727558972626
+ 1.4642e-05 -0.000853405458043602
+ 1.4644e-05 -0.000843730370839639
+ 1.4646e-05 -0.000668106553834139
+ 1.4648e-05 -0.000619007773407677
+ 1.465e-05 -0.000455849986066987
+ 1.4652e-05 -0.000710737249473284
+ 1.4654e-05 -0.000955213007644825
+ 1.4656e-05 -0.000968536466504226
+ 1.4658e-05 -0.000590277130113446
+ 1.466e-05 -0.000721722028608338
+ 1.4662e-05 -0.000638131777229899
+ 1.4664e-05 -0.000466151070168133
+ 1.4666e-05 -0.000379191897834899
+ 1.4668e-05 -0.000641926209851377
+ 1.467e-05 -0.000114084959382614
+ 1.4672e-05 6.73397763069924e-05
+ 1.4674e-05 0.000114817299836318
+ 1.4676e-05 0.000360903623692752
+ 1.4678e-05 0.000406243043489953
+ 1.468e-05 0.000353694762610985
+ 1.4682e-05 0.000338531219700438
+ 1.4684e-05 0.00021184807464731
+ 1.4686e-05 0.000251183269858821
+ 1.4688e-05 0.000357754123048167
+ 1.469e-05 0.000256832741777272
+ 1.4692e-05 -8.61120720219062e-05
+ 1.4694e-05 -0.000104417137001381
+ 1.4696e-05 -0.000308016543492768
+ 1.4698e-05 -0.000434840862568656
+ 1.47e-05 -0.000676792110283351
+ 1.4702e-05 -0.000863508748285276
+ 1.4704e-05 -0.000654559569351742
+ 1.4706e-05 -0.000709650270089658
+ 1.4708e-05 -0.000968961002687524
+ 1.471e-05 -0.00109335753560387
+ 1.4712e-05 -0.00100387059904893
+ 1.4714e-05 -0.000729697119106379
+ 1.4716e-05 -0.000685076502690786
+ 1.4718e-05 -0.00052894231839008
+ 1.472e-05 -0.000666668492074966
+ 1.4722e-05 -0.000526457624951608
+ 1.4724e-05 -0.000782319691037718
+ 1.4726e-05 -0.000165049259106076
+ 1.4728e-05 -6.06083729771331e-05
+ 1.473e-05 0.000295891296325607
+ 1.4732e-05 0.000459414126356152
+ 1.4734e-05 0.000540739970343557
+ 1.4736e-05 0.00064960516238068
+ 1.4738e-05 0.000475784194028748
+ 1.474e-05 0.000581093113482723
+ 1.4742e-05 0.000692545905006515
+ 1.4744e-05 0.00070908310907644
+ 1.4746e-05 0.000660598428417746
+ 1.4748e-05 0.000503069222731208
+ 1.475e-05 0.000439639213493752
+ 1.4752e-05 8.7876381646536e-05
+ 1.4754e-05 5.47502033504173e-06
+ 1.4756e-05 0.000111007546363626
+ 1.4758e-05 -3.60615525884813e-05
+ 1.476e-05 -0.000213480123159788
+ 1.4762e-05 -3.28666179835826e-05
+ 1.4764e-05 -8.624767928065e-05
+ 1.4766e-05 -1.46542838122021e-05
+ 1.4768e-05 -0.000330356610720799
+ 1.477e-05 -0.000407478483008198
+ 1.4772e-05 -0.000469598709521479
+ 1.4774e-05 -0.000419015732665445
+ 1.4776e-05 -0.000491041113881297
+ 1.4778e-05 -0.000654426221454976
+ 1.478e-05 -0.00109232562925916
+ 1.4782e-05 -0.000918001136893708
+ 1.4784e-05 -0.00116076295849058
+ 1.4786e-05 -0.00115576849974099
+ 1.4788e-05 -0.00123092692489793
+ 1.479e-05 -0.00142247859192266
+ 1.4792e-05 -0.00152633115313545
+ 1.4794e-05 -0.00167679221914306
+ 1.4796e-05 -0.0013551764859762
+ 1.4798e-05 -0.00145096050943568
+ 1.48e-05 -0.00123638596478976
+ 1.4802e-05 -0.00134303369519838
+ 1.4804e-05 -0.00111058114847818
+ 1.4806e-05 -0.00125797294667519
+ 1.4808e-05 -0.0014030489396106
+ 1.481e-05 -0.00123155281161615
+ 1.4812e-05 -0.000814637979185626
+ 1.4814e-05 -0.000798737642963959
+ 1.4816e-05 -0.000837201104350699
+ 1.4818e-05 -0.00119891348778505
+ 1.482e-05 -0.00119559478454152
+ 1.4822e-05 -0.00110436796005192
+ 1.4824e-05 -0.00115256249711695
+ 1.4826e-05 -0.00118987764762205
+ 1.4828e-05 -0.00121400312797992
+ 1.483e-05 -0.00134901602451822
+ 1.4832e-05 -0.00119436340238029
+ 1.4834e-05 -0.000892319227491588
+ 1.4836e-05 -0.000888997751851385
+ 1.4838e-05 -0.000653874906922497
+ 1.484e-05 -0.000468055814446569
+ 1.4842e-05 -0.000311608781403431
+ 1.4844e-05 -0.000430830199120452
+ 1.4846e-05 -0.000264765358056163
+ 1.4848e-05 -0.000117632764096497
+ 1.485e-05 -0.000203989398983523
+ 1.4852e-05 -0.000320878390232765
+ 1.4854e-05 -0.000305608849020679
+ 1.4856e-05 -0.000452568462664801
+ 1.4858e-05 -0.000155655899448604
+ 1.486e-05 -0.000182563024790123
+ 1.4862e-05 2.81090331046498e-05
+ 1.4864e-05 0.000316302563902634
+ 1.4866e-05 0.000279669812875921
+ 1.4868e-05 7.72832343659757e-05
+ 1.487e-05 0.000100827455049715
+ 1.4872e-05 -0.000221956472925433
+ 1.4874e-05 -0.000369715178265789
+ 1.4876e-05 -0.000233887154191223
+ 1.4878e-05 9.09092064015765e-07
+ 1.488e-05 -7.96275414741902e-05
+ 1.4882e-05 -0.000174425096029978
+ 1.4884e-05 -0.000130555734695893
+ 1.4886e-05 0.000101884244581778
+ 1.4888e-05 5.60670470092119e-05
+ 1.489e-05 -4.37870735465483e-05
+ 1.4892e-05 4.84774679846589e-05
+ 1.4894e-05 -0.000383304641590381
+ 1.4896e-05 -0.000403210090272258
+ 1.4898e-05 -0.00046726534992749
+ 1.49e-05 -0.000431198537626383
+ 1.4902e-05 -0.000555643980262203
+ 1.4904e-05 -0.000131339279620329
+ 1.4906e-05 0.000225293026803701
+ 1.4908e-05 0.000119694011118518
+ 1.491e-05 0.000207920351489019
+ 1.4912e-05 0.000294238666583506
+ 1.4914e-05 0.000380624925714888
+ 1.4916e-05 0.000642538092860729
+ 1.4918e-05 0.000357328445374318
+ 1.492e-05 0.000434507093401383
+ 1.4922e-05 0.000463924759949938
+ 1.4924e-05 0.000523388447332473
+ 1.4926e-05 0.000473357568304739
+ 1.4928e-05 0.00064199700588347
+ 1.493e-05 0.000313472140125554
+ 1.4932e-05 0.00013901869729855
+ 1.4934e-05 0.000358027658622458
+ 1.4936e-05 0.000157688814531803
+ 1.4938e-05 0.000258865624774351
+ 1.494e-05 0.000188538062284964
+ 1.4942e-05 0.000474399749270334
+ 1.4944e-05 0.000532316705737197
+ 1.4946e-05 0.000391651975726285
+ 1.4948e-05 0.000474419758945742
+ 1.495e-05 0.000571976385859445
+ 1.4952e-05 0.000624756374596375
+ 1.4954e-05 0.000725453539624133
+ 1.4956e-05 0.000776009453828056
+ 1.4958e-05 0.000688201325585461
+ 1.496e-05 0.000893316955356022
+ 1.4962e-05 0.000579431313987827
+ 1.4964e-05 0.000661635263655273
+ 1.4966e-05 0.000299536337727619
+ 1.4968e-05 0.000250846025882261
+ 1.497e-05 0.000372905232624928
+ 1.4972e-05 0.0008129662059243
+ 1.4974e-05 0.00082027968566542
+ 1.4976e-05 0.000554346608073313
+ 1.4978e-05 0.000528605359475406
+ 1.498e-05 0.000305890114120073
+ 1.4982e-05 0.000184927386872851
+ 1.4984e-05 3.07617160544443e-05
+ 1.4986e-05 0.000171431512312148
+ 1.4988e-05 0.000102696194668891
+ 1.499e-05 0.000257210853314047
+ 1.4992e-05 0.000198494592861676
+ 1.4994e-05 0.000288556896888558
+ 1.4996e-05 8.61861316564567e-05
+ 1.4998e-05 -4.0713845853551e-05
+ 1.5e-05 -0.000339431113045209
+ 1.5002e-05 -0.000337985013060792
+ 1.5004e-05 -7.81629436487897e-05
+ 1.5006e-05 -0.000223730723758339
+ 1.5008e-05 -0.00031124439442827
+ 1.501e-05 -0.00052871377832165
+ 1.5012e-05 -0.000188446063078104
+ 1.5014e-05 -0.000100228444707176
+ 1.5016e-05 1.43005687872074e-05
+ 1.5018e-05 0.000128301627333431
+ 1.502e-05 2.52251069211004e-05
+ 1.5022e-05 1.62556106340673e-05
+ 1.5024e-05 0.000228972535472156
+ 1.5026e-05 7.04785870093987e-05
+ 1.5028e-05 0.000636179425160188
+ 1.503e-05 0.000804353709974665
+ 1.5032e-05 0.000575241444561019
+ 1.5034e-05 0.000645474202165042
+ 1.5036e-05 0.000516734882065376
+ 1.5038e-05 0.000593932731970493
+ 1.504e-05 0.000640081342353482
+ 1.5042e-05 0.000606036858899408
+ 1.5044e-05 0.00026096665546335
+ 1.5046e-05 0.000158419593882024
+ 1.5048e-05 -0.000162697529166276
+ 1.505e-05 -0.000190685375081827
+ 1.5052e-05 -0.000174204818633999
+ 1.5054e-05 -8.6070895856276e-05
+ 1.5056e-05 -0.000275022696167058
+ 1.5058e-05 -0.000138849878522358
+ 1.506e-05 -4.24143859370204e-05
+ 1.5062e-05 3.23507691195796e-05
+ 1.5064e-05 6.46055234546625e-05
+ 1.5066e-05 0.000232820307312436
+ 1.5068e-05 -9.95838847673543e-05
+ 1.507e-05 -0.000119570596029476
+ 1.5072e-05 -6.8395597312404e-05
+ 1.5074e-05 1.57570915706175e-05
+ 1.5076e-05 -9.87410628011512e-05
+ 1.5078e-05 -0.000224083718129148
+ 1.508e-05 -0.000404544637755895
+ 1.5082e-05 -0.000593283912189568
+ 1.5084e-05 -0.000354661180858638
+ 1.5086e-05 -0.000140062270164969
+ 1.5088e-05 -3.71557839565432e-05
+ 1.509e-05 -0.000333964472431146
+ 1.5092e-05 -0.000637484523321607
+ 1.5094e-05 -0.000913934466282815
+ 1.5096e-05 -0.00146210570055334
+ 1.5098e-05 -0.00132411754228559
+ 1.51e-05 -0.00155949261075376
+ 1.5102e-05 -0.00173658393460695
+ 1.5104e-05 -0.00170784941534714
+ 1.5106e-05 -0.00172235423422863
+ 1.5108e-05 -0.00165763170445379
+ 1.511e-05 -0.00167243927539706
+ 1.5112e-05 -0.00165475140507001
+ 1.5114e-05 -0.00175026779596562
+ 1.5116e-05 -0.00167845459063093
+ 1.5118e-05 -0.00177225599396396
+ 1.512e-05 -0.00149035223400441
+ 1.5122e-05 -0.00159820186761424
+ 1.5124e-05 -0.00180107089402952
+ 1.5126e-05 -0.00189894916943832
+ 1.5128e-05 -0.00193935286407407
+ 1.513e-05 -0.00176163298736561
+ 1.5132e-05 -0.0015133822869498
+ 1.5134e-05 -0.00175639830683473
+ 1.5136e-05 -0.00206196132574329
+ 1.5138e-05 -0.00222034336123001
+ 1.514e-05 -0.00232275391035892
+ 1.5142e-05 -0.00228628273833318
+ 1.5144e-05 -0.00232935133103403
+ 1.5146e-05 -0.00239251132809658
+ 1.5148e-05 -0.00235491503670382
+ 1.515e-05 -0.00253215469688862
+ 1.5152e-05 -0.00273383089367877
+ 1.5154e-05 -0.00243120224656409
+ 1.5156e-05 -0.00224294483002525
+ 1.5158e-05 -0.00170845963056684
+ 1.516e-05 -0.00136459590404605
+ 1.5162e-05 -0.00128022821065045
+ 1.5164e-05 -0.00147675489776287
+ 1.5166e-05 -0.0013662982227782
+ 1.5168e-05 -0.00137669590933684
+ 1.517e-05 -0.000988229618599902
+ 1.5172e-05 -0.000790621411890741
+ 1.5174e-05 -0.000851932545245299
+ 1.5176e-05 -0.00140567886589895
+ 1.5178e-05 -0.00113848929986994
+ 1.518e-05 -0.00110139798942969
+ 1.5182e-05 -0.000798307903067057
+ 1.5184e-05 -0.000782335176998709
+ 1.5186e-05 -0.000596053180920284
+ 1.5188e-05 -0.000413663710152954
+ 1.519e-05 -0.000481085710679489
+ 1.5192e-05 -0.000598409990021104
+ 1.5194e-05 -0.000406153589023449
+ 1.5196e-05 -0.000262073565334593
+ 1.5198e-05 -0.00049277422967104
+ 1.52e-05 -0.000622899000163201
+ 1.5202e-05 -0.000371592694190199
+ 1.5204e-05 -0.000276759774588231
+ 1.5206e-05 0.000166292012883542
+ 1.5208e-05 0.00016409405225199
+ 1.521e-05 0.000230740375244904
+ 1.5212e-05 -0.000218205734964647
+ 1.5214e-05 -0.000235762808262766
+ 1.5216e-05 -0.000253433503999159
+ 1.5218e-05 -0.000205521819483273
+ 1.522e-05 -0.000220071831411733
+ 1.5222e-05 -5.96848848188022e-05
+ 1.5224e-05 -7.14248009925777e-05
+ 1.5226e-05 -0.000124202791684267
+ 1.5228e-05 -0.000145634830730877
+ 1.523e-05 8.80995069115307e-05
+ 1.5232e-05 9.57247070263519e-05
+ 1.5234e-05 0.000445550469493599
+ 1.5236e-05 2.24743304459183e-05
+ 1.5238e-05 0.00010252704361089
+ 1.524e-05 -8.70073863951794e-05
+ 1.5242e-05 -0.000523374374772555
+ 1.5244e-05 -0.00072289080952661
+ 1.5246e-05 -0.000800043300589495
+ 1.5248e-05 -0.000486299332460929
+ 1.525e-05 -0.000142873805316464
+ 1.5252e-05 -0.000305307649321434
+ 1.5254e-05 -0.000173850187251672
+ 1.5256e-05 -0.000367605135570352
+ 1.5258e-05 -0.000610081129330377
+ 1.526e-05 -0.000652056903580984
+ 1.5262e-05 -0.0003444089104932
+ 1.5264e-05 -0.000223032406967731
+ 1.5266e-05 -0.000185494785602405
+ 1.5268e-05 -4.90957201491975e-05
+ 1.527e-05 -8.25115993548988e-06
+ 1.5272e-05 -0.000128712896449322
+ 1.5274e-05 -7.08070704586495e-05
+ 1.5276e-05 -0.000121757903898308
+ 1.5278e-05 -8.73294270239848e-05
+ 1.528e-05 -0.000259111744924785
+ 1.5282e-05 -4.18535985410384e-06
+ 1.5284e-05 0.000166367252395723
+ 1.5286e-05 0.000325295657448965
+ 1.5288e-05 0.000556091915091291
+ 1.529e-05 0.000767792982397207
+ 1.5292e-05 0.000881683999386177
+ 1.5294e-05 0.00118336835561936
+ 1.5296e-05 0.00112163888294949
+ 1.5298e-05 0.0012366697696114
+ 1.53e-05 0.00101048291313299
+ 1.5302e-05 0.000762554995305011
+ 1.5304e-05 0.000917009498237842
+ 1.5306e-05 0.000817954628715763
+ 1.5308e-05 0.000764805598901536
+ 1.531e-05 0.000946577627466107
+ 1.5312e-05 0.000983338002542237
+ 1.5314e-05 0.000801508047614325
+ 1.5316e-05 0.000254919952723434
+ 1.5318e-05 0.000246180585657292
+ 1.532e-05 0.000235559361556024
+ 1.5322e-05 0.000196623103612523
+ 1.5324e-05 0.000175748501652584
+ 1.5326e-05 0.000372699911484763
+ 1.5328e-05 0.000117366905983478
+ 1.533e-05 0.000387929942153011
+ 1.5332e-05 0.000606378355180616
+ 1.5334e-05 0.000505359241810152
+ 1.5336e-05 0.000487988963982991
+ 1.5338e-05 0.000430607964614021
+ 1.534e-05 0.00092032398178376
+ 1.5342e-05 0.00114919618762819
+ 1.5344e-05 0.000836693999948926
+ 1.5346e-05 0.000949966344175646
+ 1.5348e-05 0.00103884272874349
+ 1.535e-05 0.00143130740077428
+ 1.5352e-05 0.00123838359423535
+ 1.5354e-05 0.00115412881157218
+ 1.5356e-05 0.00133615815860563
+ 1.5358e-05 0.00119663359264215
+ 1.536e-05 0.00132447879660891
+ 1.5362e-05 0.00187167558470273
+ 1.5364e-05 0.00173623414450708
+ 1.5366e-05 0.00156136564465148
+ 1.5368e-05 0.00128866805353836
+ 1.537e-05 0.00154316179217792
+ 1.5372e-05 0.00150836986915238
+ 1.5374e-05 0.00117573163416983
+ 1.5376e-05 0.00118626327836224
+ 1.5378e-05 0.00121855188440907
+ 1.538e-05 0.00125196199206563
+ 1.5382e-05 0.00121131691430486
+ 1.5384e-05 0.00128285134112412
+ 1.5386e-05 0.00113143520711029
+ 1.5388e-05 0.000928885510428055
+ 1.539e-05 0.000682041908094003
+ 1.5392e-05 0.000383446631630186
+ 1.5394e-05 5.84581215561691e-06
+ 1.5396e-05 0.000340301482645549
+ 1.5398e-05 0.000418913279005346
+ 1.54e-05 0.000778717117910386
+ 1.5402e-05 0.000744969172186189
+ 1.5404e-05 0.000647844182736981
+ 1.5406e-05 0.000519647104388839
+ 1.5408e-05 0.000386732323296605
+ 1.541e-05 0.000308147817745065
+ 1.5412e-05 0.000328988136846076
+ 1.5414e-05 0.000175498839027939
+ 1.5416e-05 -0.000295522184298981
+ 1.5418e-05 -0.000204525109365871
+ 1.542e-05 -0.000598643557063919
+ 1.5422e-05 -0.000962610926091688
+ 1.5424e-05 -0.000889334323788895
+ 1.5426e-05 -0.00077099035064887
+ 1.5428e-05 -0.000634136911281773
+ 1.543e-05 -0.00066395845846419
+ 1.5432e-05 -0.000939312703247479
+ 1.5434e-05 -0.00100390953576897
+ 1.5436e-05 -0.00102732812056617
+ 1.5438e-05 -0.000938808620312315
+ 1.544e-05 -0.000697761972102144
+ 1.5442e-05 -0.000987273666165642
+ 1.5444e-05 -0.000768473397037031
+ 1.5446e-05 -0.000489852495691414
+ 1.5448e-05 -0.000507854646099552
+ 1.545e-05 -0.000363787841705372
+ 1.5452e-05 -0.000404980981246112
+ 1.5454e-05 -0.000106819330689824
+ 1.5456e-05 0.000181040619744142
+ 1.5458e-05 0.000211131011430335
+ 1.546e-05 8.20551144550367e-05
+ 1.5462e-05 -0.000274070744315643
+ 1.5464e-05 -0.000438480163824396
+ 1.5466e-05 -0.000228199152095315
+ 1.5468e-05 -0.000220873061722569
+ 1.547e-05 -0.000109153609037444
+ 1.5472e-05 -0.00021734402430133
+ 1.5474e-05 -0.000338491756429755
+ 1.5476e-05 -0.000638839589076968
+ 1.5478e-05 -0.000427401065266751
+ 1.548e-05 -0.00040844556496459
+ 1.5482e-05 -0.000442884079493021
+ 1.5484e-05 -0.000440486889005471
+ 1.5486e-05 -0.000684779847675893
+ 1.5488e-05 -0.000467430478749095
+ 1.549e-05 -0.000484476830917888
+ 1.5492e-05 -0.000391152652634912
+ 1.5494e-05 -0.000167125480149699
+ 1.5496e-05 -5.23470802379008e-05
+ 1.5498e-05 2.976146522875e-06
+ 1.55e-05 -5.86399312478399e-05
+ 1.5502e-05 -0.000362940148197341
+ 1.5504e-05 -0.000499537473169844
+ 1.5506e-05 -0.000853297505564038
+ 1.5508e-05 -0.000651412124225461
+ 1.551e-05 -0.000616790302172013
+ 1.5512e-05 -0.000627912020335413
+ 1.5514e-05 -0.000454609761265857
+ 1.5516e-05 -0.000698129950813235
+ 1.5518e-05 -0.000444917928169813
+ 1.552e-05 -0.000618882170080395
+ 1.5522e-05 -0.000592503102832584
+ 1.5524e-05 6.97833947677717e-06
+ 1.5526e-05 -2.00118971775423e-05
+ 1.5528e-05 -7.38218468239067e-05
+ 1.553e-05 -0.000295465247628194
+ 1.5532e-05 -0.000357372499589936
+ 1.5534e-05 -0.000664584523166788
+ 1.5536e-05 -0.000587174019556359
+ 1.5538e-05 -0.000711455216874643
+ 1.554e-05 -0.000701911537541135
+ 1.5542e-05 -0.000728236614227589
+ 1.5544e-05 -0.000646490436257532
+ 1.5546e-05 -0.00068853909739971
+ 1.5548e-05 -0.000390751238900907
+ 1.555e-05 -0.000476557178257534
+ 1.5552e-05 -0.0005023437801772
+ 1.5554e-05 -0.000407899421178485
+ 1.5556e-05 -0.000205961883846405
+ 1.5558e-05 -4.14978345469164e-05
+ 1.556e-05 -1.72962280194137e-05
+ 1.5562e-05 -6.10901320529666e-05
+ 1.5564e-05 -7.42218269215501e-05
+ 1.5566e-05 -0.000238502391479338
+ 1.5568e-05 -0.000274287578994925
+ 1.557e-05 -0.000424868964813561
+ 1.5572e-05 -0.00047212162483171
+ 1.5574e-05 -0.000631957804118023
+ 1.5576e-05 -0.000511788215160907
+ 1.5578e-05 -0.000766645708857767
+ 1.558e-05 -0.000849687599529729
+ 1.5582e-05 -0.00092368901595572
+ 1.5584e-05 -0.000959661886164664
+ 1.5586e-05 -0.00043962308047728
+ 1.5588e-05 -0.000587790603515467
+ 1.559e-05 -0.000406713405800726
+ 1.5592e-05 -0.000364448499432946
+ 1.5594e-05 -0.00034825323322386
+ 1.5596e-05 -0.000292861131053064
+ 1.5598e-05 -0.000250984410615714
+ 1.56e-05 -0.000252354790799318
+ 1.5602e-05 -0.000497181678338922
+ 1.5604e-05 -0.000901655452006718
+ 1.5606e-05 -0.00081075082672734
+ 1.5608e-05 -0.000974675142708625
+ 1.561e-05 -0.000912674181287774
+ 1.5612e-05 -0.000974637718295188
+ 1.5614e-05 -0.000962550685463227
+ 1.5616e-05 -0.000959963406940171
+ 1.5618e-05 -0.000899987127581584
+ 1.562e-05 -0.000872536416545502
+ 1.5622e-05 -0.00114592323382594
+ 1.5624e-05 -0.00118614703938737
+ 1.5626e-05 -0.000998734362002688
+ 1.5628e-05 -0.000924152551506512
+ 1.563e-05 -0.000522555139154369
+ 1.5632e-05 -0.000458950274621693
+ 1.5634e-05 -0.000597807907274348
+ 1.5636e-05 -0.000226061539796656
+ 1.5638e-05 -0.000159290692589955
+ 1.564e-05 -0.000329744870370453
+ 1.5642e-05 -0.000511951401346519
+ 1.5644e-05 -0.000312182732410268
+ 1.5646e-05 -0.000128755494284379
+ 1.5648e-05 -4.35983651511783e-05
+ 1.565e-05 -0.000628631282212382
+ 1.5652e-05 -0.000421205213556238
+ 1.5654e-05 -7.77133133328365e-05
+ 1.5656e-05 -0.000107044832476528
+ 1.5658e-05 -0.000144018706096007
+ 1.566e-05 -0.000291938254937395
+ 1.5662e-05 -1.12610413797501e-05
+ 1.5664e-05 -0.000198675840972171
+ 1.5666e-05 -3.61556323783247e-05
+ 1.5668e-05 0.000189137241567509
+ 1.567e-05 0.000194967079107832
+ 1.5672e-05 -6.02376719283787e-07
+ 1.5674e-05 -0.000211776507890469
+ 1.5676e-05 -0.000276979199183498
+ 1.5678e-05 -0.000419463546984734
+ 1.568e-05 -0.00041983106018178
+ 1.5682e-05 -0.000163942277071407
+ 1.5684e-05 -0.000118980653878385
+ 1.5686e-05 0.00012301108093964
+ 1.5688e-05 0.000387506245301509
+ 1.569e-05 7.43887006977363e-05
+ 1.5692e-05 0.000394005674393861
+ 1.5694e-05 0.000339552802256456
+ 1.5696e-05 0.000266134860476817
+ 1.5698e-05 0.000134967210014371
+ 1.57e-05 0.000410656505198837
+ 1.5702e-05 0.000311944780795896
+ 1.5704e-05 0.000471673260625531
+ 1.5706e-05 0.000353842554832171
+ 1.5708e-05 0.000248128485040893
+ 1.571e-05 0.000525986185163385
+ 1.5712e-05 0.000516796311426588
+ 1.5714e-05 0.000699189375073038
+ 1.5716e-05 0.000866979527311846
+ 1.5718e-05 0.0010884441541379
+ 1.572e-05 0.000978610463030318
+ 1.5722e-05 0.00109051235719871
+ 1.5724e-05 0.000618268085782528
+ 1.5726e-05 0.000881138378568356
+ 1.5728e-05 0.000622329941583774
+ 1.573e-05 0.000314984746784072
+ 1.5732e-05 0.000287647958741976
+ 1.5734e-05 0.000400625872820601
+ 1.5736e-05 0.000826363148587755
+ 1.5738e-05 0.000967259043287669
+ 1.574e-05 0.00112087882376552
+ 1.5742e-05 0.00123451511810707
+ 1.5744e-05 0.00111309500081114
+ 1.5746e-05 0.00128110375215069
+ 1.5748e-05 0.00134649460541809
+ 1.575e-05 0.00132015545233828
+ 1.5752e-05 0.00132350893534378
+ 1.5754e-05 0.00127510711614657
+ 1.5756e-05 0.00163540699814788
+ 1.5758e-05 0.00141045865172804
+ 1.576e-05 0.00159103579481091
+ 1.5762e-05 0.00142544789488088
+ 1.5764e-05 0.00110021962734097
+ 1.5766e-05 0.00118947854528508
+ 1.5768e-05 0.00116429772549077
+ 1.577e-05 0.00114957286740484
+ 1.5772e-05 0.000990234896770863
+ 1.5774e-05 0.000840444679214612
+ 1.5776e-05 0.000732472568600706
+ 1.5778e-05 0.000474278296584234
+ 1.578e-05 0.00062964802430538
+ 1.5782e-05 0.00054450991552321
+ 1.5784e-05 0.000880932958050171
+ 1.5786e-05 0.000627508734500756
+ 1.5788e-05 0.000717630512213932
+ 1.579e-05 0.000617534869007008
+ 1.5792e-05 0.000934535213387478
+ 1.5794e-05 0.000873907455449449
+ 1.5796e-05 0.000387996056648801
+ 1.5798e-05 0.000427347344050014
+ 1.58e-05 0.000447123288489575
+ 1.5802e-05 0.000715155506947774
+ 1.5804e-05 0.000678543573687359
+ 1.5806e-05 0.000909950637095776
+ 1.5808e-05 0.000860574823683317
+ 1.581e-05 0.000657065079612223
+ 1.5812e-05 0.000887817596358943
+ 1.5814e-05 0.000589280092283665
+ 1.5816e-05 0.000665140242747013
+ 1.5818e-05 0.000789658359897121
+ 1.582e-05 0.000781224117622779
+ 1.5822e-05 0.000731647958628852
+ 1.5824e-05 0.000944127416426972
+ 1.5826e-05 0.00096825673223322
+ 1.5828e-05 0.00093587676837916
+ 1.583e-05 0.000752217427436417
+ 1.5832e-05 0.000603595179415783
+ 1.5834e-05 0.000828184261662911
+ 1.5836e-05 0.00069724110590259
+ 1.5838e-05 0.000666863835983627
+ 1.584e-05 0.000887463718196243
+ 1.5842e-05 0.000682822430135139
+ 1.5844e-05 0.000934389757010468
+ 1.5846e-05 0.0010945684372982
+ 1.5848e-05 0.000862554240676516
+ 1.585e-05 0.00113807652651963
+ 1.5852e-05 0.00121568394212498
+ 1.5854e-05 0.000909833609104949
+ 1.5856e-05 0.00088327445005051
+ 1.5858e-05 0.00100712873011961
+ 1.586e-05 0.00104591034540474
+ 1.5862e-05 0.00079639809322993
+ 1.5864e-05 0.000902789855806946
+ 1.5866e-05 0.00116699818382639
+ 1.5868e-05 0.00117295656692368
+ 1.587e-05 0.00113676428760935
+ 1.5872e-05 0.00149239435877973
+ 1.5874e-05 0.00159903239369337
+ 1.5876e-05 0.00178361550374077
+ 1.5878e-05 0.00154560080975206
+ 1.588e-05 0.00155178312841831
+ 1.5882e-05 0.00133598116328384
+ 1.5884e-05 0.00132471675448449
+ 1.5886e-05 0.00131454499749124
+ 1.5888e-05 0.00123991295887728
+ 1.589e-05 0.00113521406700962
+ 1.5892e-05 0.0014357964562166
+ 1.5894e-05 0.00162520528984603
+ 1.5896e-05 0.00192670802237254
+ 1.5898e-05 0.00163295486830467
+ 1.59e-05 0.00142163977376289
+ 1.5902e-05 0.00136259496442186
+ 1.5904e-05 0.00166429547375343
+ 1.5906e-05 0.00206103886846513
+ 1.5908e-05 0.00248143152792116
+ 1.591e-05 0.00253178812300591
+ 1.5912e-05 0.00256986601398728
+ 1.5914e-05 0.00245532859606598
+ 1.5916e-05 0.00229383445693002
+ 1.5918e-05 0.00211859380557636
+ 1.592e-05 0.00194405648578893
+ 1.5922e-05 0.00184687780940319
+ 1.5924e-05 0.00187245166675413
+ 1.5926e-05 0.00156696106888433
+ 1.5928e-05 0.00158009659707928
+ 1.593e-05 0.00135321238582486
+ 1.5932e-05 0.00117144364029764
+ 1.5934e-05 0.00119813087728581
+ 1.5936e-05 0.00113188257766709
+ 1.5938e-05 0.00115927551627974
+ 1.594e-05 0.00107834321891933
+ 1.5942e-05 0.000981448559564503
+ 1.5944e-05 0.0010789746503296
+ 1.5946e-05 0.000746799565807749
+ 1.5948e-05 0.000729711379907325
+ 1.595e-05 0.000864399790865721
+ 1.5952e-05 0.000375403197416681
+ 1.5954e-05 0.000366586964767786
+ 1.5956e-05 0.000379422009796165
+ 1.5958e-05 0.000702620580089762
+ 1.596e-05 0.000631315602428047
+ 1.5962e-05 0.000827079500268724
+ 1.5964e-05 0.000835730666322069
+ 1.5966e-05 0.00078547622752601
+ 1.5968e-05 0.000984000241444059
+ 1.597e-05 0.00111793755931733
+ 1.5972e-05 0.00133115061015376
+ 1.5974e-05 0.00116207681914165
+ 1.5976e-05 0.00110601654479667
+ 1.5978e-05 0.000868569159210447
+ 1.598e-05 0.00095715642975741
+ 1.5982e-05 0.000746858133525483
+ 1.5984e-05 0.000577064445559306
+ 1.5986e-05 0.000650266753039699
+ 1.5988e-05 0.000753434041065394
+ 1.599e-05 0.000793569160515587
+ 1.5992e-05 0.000760942754643444
+ 1.5994e-05 0.00100775807575091
+ 1.5996e-05 0.00105723272294354
+ 1.5998e-05 0.00110779160205207
+ 1.6e-05 0.00114090704739194
+ 1.6002e-05 0.0011461436547999
+ 1.6004e-05 0.000963109878312394
+ 1.6006e-05 0.00112560346206183
+ 1.6008e-05 0.000942608535078813
+ 1.601e-05 0.000886771160265151
+ 1.6012e-05 0.00110190231871091
+ 1.6014e-05 0.000628848286721812
+ 1.6016e-05 0.000131780592220817
+ 1.6018e-05 9.7795927613797e-05
+ 1.602e-05 0.000389249541119715
+ 1.6022e-05 0.000401837632111114
+ 1.6024e-05 0.000684526359930283
+ 1.6026e-05 0.000720737591289311
+ 1.6028e-05 0.000291665034039559
+ 1.603e-05 0.000331482947178891
+ 1.6032e-05 0.000384896584294943
+ 1.6034e-05 0.000263343384589385
+ 1.6036e-05 5.45955031634136e-05
+ 1.6038e-05 -5.91193690461553e-05
+ 1.604e-05 0.00011242192098544
+ 1.6042e-05 0.000180599936008528
+ 1.6044e-05 4.90396255796856e-05
+ 1.6046e-05 0.00012164583741353
+ 1.6048e-05 -0.000302361160156316
+ 1.605e-05 -0.000286324384169103
+ 1.6052e-05 -0.000327991254266771
+ 1.6054e-05 -0.000315986483921633
+ 1.6056e-05 -0.000123952298031336
+ 1.6058e-05 -8.91219872179202e-05
+ 1.606e-05 5.40829999776836e-05
+ 1.6062e-05 4.40150364276772e-05
+ 1.6064e-05 0.000189151115002494
+ 1.6066e-05 0.00029359287750527
+ 1.6068e-05 5.99417482030673e-05
+ 1.607e-05 0.000180602511146018
+ 1.6072e-05 0.000267326469789868
+ 1.6074e-05 0.000293636604573298
+ 1.6076e-05 0.000278127248250626
+ 1.6078e-05 0.000330522299642391
+ 1.608e-05 0.000493431585850259
+ 1.6082e-05 0.000560754765796308
+ 1.6084e-05 0.000926197827017848
+ 1.6086e-05 0.000428636856665816
+ 1.6088e-05 -1.31794169401905e-06
+ 1.609e-05 8.18809470939105e-05
+ 1.6092e-05 -2.30852703987136e-06
+ 1.6094e-05 -2.63836591436916e-05
+ 1.6096e-05 -0.000131017301181561
+ 1.6098e-05 4.38877432044156e-05
+ 1.61e-05 -6.5086627650346e-05
+ 1.6102e-05 -0.000101995219781396
+ 1.6104e-05 -0.000284559658729643
+ 1.6106e-05 -0.000292426379912458
+ 1.6108e-05 -0.000495402723786612
+ 1.611e-05 -0.000450842623464128
+ 1.6112e-05 -0.000819180359624117
+ 1.6114e-05 -0.000956917865234499
+ 1.6116e-05 -0.00102923259979356
+ 1.6118e-05 -0.000768177040551699
+ 1.612e-05 -0.000774111163953518
+ 1.6122e-05 -0.000620682110776507
+ 1.6124e-05 -0.000852471759078964
+ 1.6126e-05 -0.00091712717648097
+ 1.6128e-05 -0.000985773704987835
+ 1.613e-05 -0.000835008071168465
+ 1.6132e-05 -0.000849386459721088
+ 1.6134e-05 -0.00105339822312268
+ 1.6136e-05 -0.00101980649665737
+ 1.6138e-05 -0.000959949133079286
+ 1.614e-05 -0.000775769012093641
+ 1.6142e-05 -0.000765987961524653
+ 1.6144e-05 -0.000622874643379158
+ 1.6146e-05 -0.00052769883626193
+ 1.6148e-05 -0.000125867327048107
+ 1.615e-05 2.44963715293633e-05
+ 1.6152e-05 -1.68342838933936e-05
+ 1.6154e-05 -0.000257659610299915
+ 1.6156e-05 -0.000677565745329501
+ 1.6158e-05 -0.000915979718361635
+ 1.616e-05 -0.000807920513770868
+ 1.6162e-05 -0.00107026688943054
+ 1.6164e-05 -0.00101620500899619
+ 1.6166e-05 -0.000920203376779325
+ 1.6168e-05 -0.00118134292178925
+ 1.617e-05 -0.00167766096333515
+ 1.6172e-05 -0.00209442972480675
+ 1.6174e-05 -0.00205009068675494
+ 1.6176e-05 -0.00243472908667042
+ 1.6178e-05 -0.00257413289158537
+ 1.618e-05 -0.00264183363327294
+ 1.6182e-05 -0.00256009028720688
+ 1.6184e-05 -0.00269935572690345
+ 1.6186e-05 -0.0027361086703167
+ 1.6188e-05 -0.00221898389702569
+ 1.619e-05 -0.00235514450257731
+ 1.6192e-05 -0.00263977914972354
+ 1.6194e-05 -0.00262143397239985
+ 1.6196e-05 -0.00215451815531581
+ 1.6198e-05 -0.00236095418872193
+ 1.62e-05 -0.00216586019049351
+ 1.6202e-05 -0.002551716043471
+ 1.6204e-05 -0.00268751108304716
+ 1.6206e-05 -0.00269474764401534
+ 1.6208e-05 -0.00273930336508599
+ 1.621e-05 -0.00263494680086863
+ 1.6212e-05 -0.00287616439972448
+ 1.6214e-05 -0.0027842188437066
+ 1.6216e-05 -0.002271681472488
+ 1.6218e-05 -0.0022047723356972
+ 1.622e-05 -0.00199699568899678
+ 1.6222e-05 -0.0022264852299276
+ 1.6224e-05 -0.00245499390201993
+ 1.6226e-05 -0.00219840218639706
+ 1.6228e-05 -0.00198209500590615
+ 1.623e-05 -0.00160275186538348
+ 1.6232e-05 -0.00149782442763562
+ 1.6234e-05 -0.00192656246419696
+ 1.6236e-05 -0.00184035003828052
+ 1.6238e-05 -0.00195213011536157
+ 1.624e-05 -0.00205050875545607
+ 1.6242e-05 -0.00202949060481945
+ 1.6244e-05 -0.00178702064395216
+ 1.6246e-05 -0.00217139404521031
+ 1.6248e-05 -0.00218869327277085
+ 1.625e-05 -0.00236441267042415
+ 1.6252e-05 -0.00238368585034376
+ 1.6254e-05 -0.00241175879127291
+ 1.6256e-05 -0.00255211065207788
+ 1.6258e-05 -0.00243237041054671
+ 1.626e-05 -0.00225111481612745
+ 1.6262e-05 -0.00192528851348347
+ 1.6264e-05 -0.00202157159868923
+ 1.6266e-05 -0.0019858763730077
+ 1.6268e-05 -0.00193706125527756
+ 1.627e-05 -0.00151640370516539
+ 1.6272e-05 -0.00138443118826809
+ 1.6274e-05 -0.00127142732491963
+ 1.6276e-05 -0.00126840567942729
+ 1.6278e-05 -0.0012048331213658
+ 1.628e-05 -0.00129734019530159
+ 1.6282e-05 -0.00117582406883198
+ 1.6284e-05 -0.00103031046282355
+ 1.6286e-05 -0.00109270698485192
+ 1.6288e-05 -0.000872071354316331
+ 1.629e-05 -0.00101364002187034
+ 1.6292e-05 -0.00093864494215613
+ 1.6294e-05 -0.000908539854387508
+ 1.6296e-05 -0.000982055187218328
+ 1.6298e-05 -0.000792909498995831
+ 1.63e-05 -0.00122619825757736
+ 1.6302e-05 -0.000867840664754622
+ 1.6304e-05 -0.000915810070807759
+ 1.6306e-05 -0.000955104480752544
+ 1.6308e-05 -0.00071459513911642
+ 1.631e-05 -0.000636291124997452
+ 1.6312e-05 -0.000576084092586518
+ 1.6314e-05 -0.000461030217510945
+ 1.6316e-05 -0.000495465742652037
+ 1.6318e-05 -0.000421768511832402
+ 1.632e-05 -0.000598865489327852
+ 1.6322e-05 -0.000441260811446042
+ 1.6324e-05 -0.000467524404569263
+ 1.6326e-05 -0.00039321740556271
+ 1.6328e-05 -0.000381624903500053
+ 1.633e-05 -0.000250304261462257
+ 1.6332e-05 -8.69266197534805e-05
+ 1.6334e-05 -0.000223902282170631
+ 1.6336e-05 -0.000598541713178114
+ 1.6338e-05 -0.000785625556852957
+ 1.634e-05 -0.000442307671717499
+ 1.6342e-05 -0.000693268412204385
+ 1.6344e-05 -0.000458371073105618
+ 1.6346e-05 -0.0003988443739709
+ 1.6348e-05 -0.00028832169957737
+ 1.635e-05 -0.000298032160793948
+ 1.6352e-05 -0.000558855000896867
+ 1.6354e-05 -0.000611212333942092
+ 1.6356e-05 -0.000555068191667586
+ 1.6358e-05 -0.000708383716832457
+ 1.636e-05 -0.000399141769994712
+ 1.6362e-05 -0.000523168658830872
+ 1.6364e-05 -0.000516087195237511
+ 1.6366e-05 -0.000244944451992721
+ 1.6368e-05 -0.000198947832786985
+ 1.637e-05 -0.000411777743829007
+ 1.6372e-05 -0.000516038480669577
+ 1.6374e-05 -0.000208869179211552
+ 1.6376e-05 -0.000327674460260349
+ 1.6378e-05 -5.30047381340018e-05
+ 1.638e-05 9.04755151177139e-06
+ 1.6382e-05 -0.000311247948687918
+ 1.6384e-05 -0.000483553355044714
+ 1.6386e-05 -0.000511363601738899
+ 1.6388e-05 -0.000722688857182589
+ 1.639e-05 -0.000857054442543892
+ 1.6392e-05 -0.00121474627847022
+ 1.6394e-05 -0.00124320806206463
+ 1.6396e-05 -0.00113207189299929
+ 1.6398e-05 -0.000992036271372677
+ 1.64e-05 -0.00134153550969004
+ 1.6402e-05 -0.0015691958629387
+ 1.6404e-05 -0.00153845021033325
+ 1.6406e-05 -0.00132119728478711
+ 1.6408e-05 -0.00129189155791117
+ 1.641e-05 -0.00140037204437045
+ 1.6412e-05 -0.00125043658802521
+ 1.6414e-05 -0.00117178881286837
+ 1.6416e-05 -0.00105940003657863
+ 1.6418e-05 -0.00111603931957716
+ 1.642e-05 -0.00111193853768978
+ 1.6422e-05 -0.00119024164606967
+ 1.6424e-05 -0.0012000951134361
+ 1.6426e-05 -0.0011607507856644
+ 1.6428e-05 -0.00107284099172232
+ 1.643e-05 -0.00117417282830133
+ 1.6432e-05 -0.00114740708329857
+ 1.6434e-05 -0.0008807465035599
+ 1.6436e-05 -0.000962352763389022
+ 1.6438e-05 -0.000687518875238276
+ 1.644e-05 -0.00071707967624011
+ 1.6442e-05 -0.000447454637311073
+ 1.6444e-05 -0.000300423330395721
+ 1.6446e-05 0.000172059723806679
+ 1.6448e-05 0.000220873502131186
+ 1.645e-05 -6.22800070066037e-05
+ 1.6452e-05 0.000168995209496848
+ 1.6454e-05 0.000265984915427859
+ 1.6456e-05 0.000104995628913906
+ 1.6458e-05 0.000146634824880968
+ 1.646e-05 0.00023546800182534
+ 1.6462e-05 0.000399488524331023
+ 1.6464e-05 0.000487283240973855
+ 1.6466e-05 0.000650489757381287
+ 1.6468e-05 0.000620009145857251
+ 1.647e-05 0.00055651716408227
+ 1.6472e-05 0.000462890877453363
+ 1.6474e-05 0.000406707573258916
+ 1.6476e-05 0.00068025045539109
+ 1.6478e-05 0.00100865575918388
+ 1.648e-05 0.000943127774803853
+ 1.6482e-05 0.000712029816727758
+ 1.6484e-05 0.000573756053039545
+ 1.6486e-05 0.000539745856018089
+ 1.6488e-05 0.000669694040931117
+ 1.649e-05 0.000632573815550507
+ 1.6492e-05 0.000751757374017925
+ 1.6494e-05 0.000862419143789526
+ 1.6496e-05 0.0012443770288593
+ 1.6498e-05 0.00128994256541687
+ 1.65e-05 0.00150433598183405
+ 1.6502e-05 0.00129298009035199
+ 1.6504e-05 0.00122165015922539
+ 1.6506e-05 0.00143431857162813
+ 1.6508e-05 0.00179760519614228
+ 1.651e-05 0.00151241130064469
+ 1.6512e-05 0.00127702874235422
+ 1.6514e-05 0.00114885337410386
+ 1.6516e-05 0.000882306112624127
+ 1.6518e-05 0.000804381084155726
+ 1.652e-05 0.000686495943266552
+ 1.6522e-05 0.000369885678558234
+ 1.6524e-05 0.000123834282812598
+ 1.6526e-05 0.000140706023259314
+ 1.6528e-05 -5.43137492712496e-05
+ 1.653e-05 8.60218806440516e-06
+ 1.6532e-05 7.78263572267961e-05
+ 1.6534e-05 0.000366648747786933
+ 1.6536e-05 0.000321266369248677
+ 1.6538e-05 0.000369051052728405
+ 1.654e-05 0.000544419824740704
+ 1.6542e-05 0.000606163710599332
+ 1.6544e-05 0.000339156018159089
+ 1.6546e-05 0.000143471667649393
+ 1.6548e-05 0.000439326110864207
+ 1.655e-05 0.000208460942615238
+ 1.6552e-05 0.000373635996386249
+ 1.6554e-05 0.00025027682661883
+ 1.6556e-05 6.46692460929948e-05
+ 1.6558e-05 0.000172068432905034
+ 1.656e-05 3.75574782013919e-05
+ 1.6562e-05 6.15251080116654e-05
+ 1.6564e-05 2.32855890163913e-05
+ 1.6566e-05 -0.000158757060162859
+ 1.6568e-05 -0.000688115012072845
+ 1.657e-05 -0.000607300348379536
+ 1.6572e-05 -0.000684673324909995
+ 1.6574e-05 -0.000716113023871721
+ 1.6576e-05 -0.00122901924676335
+ 1.6578e-05 -0.0013236362051599
+ 1.658e-05 -0.00157324042934985
+ 1.6582e-05 -0.00142614562783472
+ 1.6584e-05 -0.00138741176202586
+ 1.6586e-05 -0.00115000171843444
+ 1.6588e-05 -0.00129172828562946
+ 1.659e-05 -0.00109163710635285
+ 1.6592e-05 -0.000977618612410753
+ 1.6594e-05 -0.000943332721538675
+ 1.6596e-05 -0.00113096535324164
+ 1.6598e-05 -0.000961340133050852
+ 1.66e-05 -0.000648156625485014
+ 1.6602e-05 -0.000927892987545119
+ 1.6604e-05 -0.000648543679736985
+ 1.6606e-05 -0.000681317787907122
+ 1.6608e-05 -0.000858714951206874
+ 1.661e-05 -0.00109882619392795
+ 1.6612e-05 -0.0011968702355439
+ 1.6614e-05 -0.00168941274423261
+ 1.6616e-05 -0.00166930089967703
+ 1.6618e-05 -0.00154729265461367
+ 1.662e-05 -0.00149213110922738
+ 1.6622e-05 -0.00154705005866252
+ 1.6624e-05 -0.00161588606641596
+ 1.6626e-05 -0.00153084209700702
+ 1.6628e-05 -0.0014966585367583
+ 1.663e-05 -0.00164475071560011
+ 1.6632e-05 -0.00168624295868865
+ 1.6634e-05 -0.00170472591250766
+ 1.6636e-05 -0.00194453077084902
+ 1.6638e-05 -0.00157678922040305
+ 1.664e-05 -0.00177016359581723
+ 1.6642e-05 -0.00193366426545348
+ 1.6644e-05 -0.00182024355228265
+ 1.6646e-05 -0.0016535252616139
+ 1.6648e-05 -0.00155560225734979
+ 1.665e-05 -0.00130441678194648
+ 1.6652e-05 -0.00149157785450712
+ 1.6654e-05 -0.00138780731423027
+ 1.6656e-05 -0.00132618889597338
+ 1.6658e-05 -0.0010495349236485
+ 1.666e-05 -0.00151229949473892
+ 1.6662e-05 -0.001296346849275
+ 1.6664e-05 -0.00138042358149326
+ 1.6666e-05 -0.000946722829044222
+ 1.6668e-05 -0.000988510846059907
+ 1.667e-05 -0.000927859807244325
+ 1.6672e-05 -0.000680485762196855
+ 1.6674e-05 -0.000778266303481168
+ 1.6676e-05 -0.000405504661458328
+ 1.6678e-05 -0.000379841405671722
+ 1.668e-05 -0.000737085788624754
+ 1.6682e-05 -0.000510043148128307
+ 1.6684e-05 -0.000502857493586156
+ 1.6686e-05 -0.00054182252225661
+ 1.6688e-05 -0.000146700362654932
+ 1.669e-05 -5.8863285158859e-05
+ 1.6692e-05 0.000134703134003636
+ 1.6694e-05 0.000395293270429165
+ 1.6696e-05 4.45379528903954e-05
+ 1.6698e-05 -2.30198798797162e-05
+ 1.67e-05 -6.77883674986046e-05
+ 1.6702e-05 2.05748184126361e-05
+ 1.6704e-05 9.4841480197872e-05
+ 1.6706e-05 3.80185700045414e-05
+ 1.6708e-05 0.000344528867739461
+ 1.671e-05 0.000249076054837605
+ 1.6712e-05 0.0001227892746261
+ 1.6714e-05 0.000174447991231345
+ 1.6716e-05 0.000189816839221267
+ 1.6718e-05 0.000235443396747144
+ 1.672e-05 -6.71035250670103e-05
+ 1.6722e-05 -0.000311125692488064
+ 1.6724e-05 -0.000419837194654608
+ 1.6726e-05 -0.000288700645053102
+ 1.6728e-05 -0.00035154714925939
+ 1.673e-05 -0.000524629306915268
+ 1.6732e-05 -0.000490020550795387
+ 1.6734e-05 -0.000350935889425599
+ 1.6736e-05 -0.000241590227203761
+ 1.6738e-05 -0.000306975807032687
+ 1.674e-05 3.65714195487857e-05
+ 1.6742e-05 0.00017197619021404
+ 1.6744e-05 -5.68229388061117e-05
+ 1.6746e-05 -0.000213678114657113
+ 1.6748e-05 -6.53027887606784e-05
+ 1.675e-05 -0.000361192970295382
+ 1.6752e-05 -0.000228722841234742
+ 1.6754e-05 -1.58039820118255e-05
+ 1.6756e-05 3.02813147515122e-05
+ 1.6758e-05 0.000138203519319443
+ 1.676e-05 0.000124205961461643
+ 1.6762e-05 -1.53120932339511e-05
+ 1.6764e-05 -0.000185470830555582
+ 1.6766e-05 -0.00035932342897522
+ 1.6768e-05 -0.000181029743530883
+ 1.677e-05 0.00019628019508673
+ 1.6772e-05 0.000220284428058481
+ 1.6774e-05 0.000300927741640765
+ 1.6776e-05 0.000207814565561226
+ 1.6778e-05 2.7667016867773e-05
+ 1.678e-05 3.8369290390381e-05
+ 1.6782e-05 4.33094876603826e-05
+ 1.6784e-05 0.000188344132935878
+ 1.6786e-05 -6.88875831212248e-05
+ 1.6788e-05 -0.000196396595940787
+ 1.679e-05 -0.000162251440642717
+ 1.6792e-05 0.000329911280961574
+ 1.6794e-05 7.19865154684996e-05
+ 1.6796e-05 -2.488610599012e-05
+ 1.6798e-05 -0.000385166611627221
+ 1.68e-05 -0.000471607075662687
+ 1.6802e-05 -0.000415956194760336
+ 1.6804e-05 -0.00069494194389782
+ 1.6806e-05 -0.000708666749293106
+ 1.6808e-05 -0.000852938622626237
+ 1.681e-05 -0.000397774313366526
+ 1.6812e-05 -0.00040020652994823
+ 1.6814e-05 -0.000200479741086265
+ 1.6816e-05 -0.000279548055966727
+ 1.6818e-05 -0.000231311331811216
+ 1.682e-05 -8.48744213100966e-05
+ 1.6822e-05 -8.35478080247003e-05
+ 1.6824e-05 0.000402751762869164
+ 1.6826e-05 0.000418318683441978
+ 1.6828e-05 0.000135241481846079
+ 1.683e-05 0.000347659455666533
+ 1.6832e-05 0.000825751955017222
+ 1.6834e-05 0.000649126540211839
+ 1.6836e-05 0.000215064762668658
+ 1.6838e-05 0.000500414264993318
+ 1.684e-05 0.000554134394418625
+ 1.6842e-05 0.000834617624146969
+ 1.6844e-05 0.000772950816362877
+ 1.6846e-05 0.000967004251782661
+ 1.6848e-05 0.000937081642902244
+ 1.685e-05 0.000487938007695193
+ 1.6852e-05 0.000271485684071085
+ 1.6854e-05 0.000691260614355926
+ 1.6856e-05 0.000862497522969732
+ 1.6858e-05 0.000992088186059147
+ 1.686e-05 0.000720953514784568
+ 1.6862e-05 0.000501536535720658
+ 1.6864e-05 0.000554294687609038
+ 1.6866e-05 0.000578015808545685
+ 1.6868e-05 0.000291486499925907
+ 1.687e-05 2.52281217255425e-05
+ 1.6872e-05 0.000197913071850908
+ 1.6874e-05 0.000133717804664652
+ 1.6876e-05 0.000470344413048863
+ 1.6878e-05 0.000320532695657155
+ 1.688e-05 0.000391793217551502
+ 1.6882e-05 0.000460003535111665
+ 1.6884e-05 0.00053052568637881
+ 1.6886e-05 0.000677934129521247
+ 1.6888e-05 0.000522990967520544
+ 1.689e-05 0.000612743436769045
+ 1.6892e-05 0.000557457037870212
+ 1.6894e-05 0.000448892993414163
+ 1.6896e-05 0.000837070961186818
+ 1.6898e-05 0.000802976796782101
+ 1.69e-05 0.00047644367390611
+ 1.6902e-05 0.000472231398267601
+ 1.6904e-05 0.000318380924672473
+ 1.6906e-05 0.000289341763280706
+ 1.6908e-05 -6.62505514600938e-05
+ 1.691e-05 -0.000250674476679775
+ 1.6912e-05 -0.000278626938124186
+ 1.6914e-05 -0.000520156864029148
+ 1.6916e-05 -0.00042264905089936
+ 1.6918e-05 -0.000519295683154989
+ 1.692e-05 -0.00047610903988175
+ 1.6922e-05 -0.000600342442238161
+ 1.6924e-05 -0.000635855260729375
+ 1.6926e-05 -0.000907020484260141
+ 1.6928e-05 -0.000883553071031709
+ 1.693e-05 -0.000838126085381069
+ 1.6932e-05 -0.000739532211402987
+ 1.6934e-05 -0.000727515459724807
+ 1.6936e-05 -0.000718900997024027
+ 1.6938e-05 -0.000673009348492939
+ 1.694e-05 -0.000621352184141898
+ 1.6942e-05 -0.00101944711630797
+ 1.6944e-05 -0.00103777191032472
+ 1.6946e-05 -0.00134856014127028
+ 1.6948e-05 -0.000890144962037693
+ 1.695e-05 -0.000776475556763608
+ 1.6952e-05 -0.00082493808411969
+ 1.6954e-05 -0.00109062825285441
+ 1.6956e-05 -0.00121746492958668
+ 1.6958e-05 -0.00117189736401656
+ 1.696e-05 -0.00132256271630417
+ 1.6962e-05 -0.00108451828556613
+ 1.6964e-05 -0.00117435245289835
+ 1.6966e-05 -0.00128547581679944
+ 1.6968e-05 -0.00116226586764291
+ 1.697e-05 -0.00125827260664494
+ 1.6972e-05 -0.0012426932408007
+ 1.6974e-05 -0.00141204273457303
+ 1.6976e-05 -0.00151864139188304
+ 1.6978e-05 -0.00152803038862368
+ 1.698e-05 -0.00137193963605283
+ 1.6982e-05 -0.00163732562482971
+ 1.6984e-05 -0.00163395405858012
+ 1.6986e-05 -0.0015829924388775
+ 1.6988e-05 -0.0016304926066251
+ 1.699e-05 -0.00180258323679363
+ 1.6992e-05 -0.00170424372936126
+ 1.6994e-05 -0.00188135663252651
+ 1.6996e-05 -0.0018338879926947
+ 1.6998e-05 -0.00172887113838622
+ 1.7e-05 -0.00191235912723432
+ 1.7002e-05 -0.00182026624308879
+ 1.7004e-05 -0.00168736216210556
+ 1.7006e-05 -0.00172575883672483
+ 1.7008e-05 -0.00174478881367408
+ 1.701e-05 -0.00162252974169183
+ 1.7012e-05 -0.00169720075448915
+ 1.7014e-05 -0.00182101171414509
+ 1.7016e-05 -0.00177213464135748
+ 1.7018e-05 -0.00188828939526805
+ 1.702e-05 -0.00177961153262337
+ 1.7022e-05 -0.00199630295529755
+ 1.7024e-05 -0.00202111916608022
+ 1.7026e-05 -0.00232126183982999
+ 1.7028e-05 -0.00196916170634809
+ 1.703e-05 -0.0022783262944251
+ 1.7032e-05 -0.00245444558891643
+ 1.7034e-05 -0.00271031399996349
+ 1.7036e-05 -0.0027684393274763
+ 1.7038e-05 -0.00274631811167603
+ 1.704e-05 -0.00294615126399506
+ 1.7042e-05 -0.00271982774946667
+ 1.7044e-05 -0.002652893288444
+ 1.7046e-05 -0.00280586432395154
+ 1.7048e-05 -0.00279635595692934
+ 1.705e-05 -0.00252513504535722
+ 1.7052e-05 -0.0026666534052465
+ 1.7054e-05 -0.00273728103872107
+ 1.7056e-05 -0.00247433733033941
+ 1.7058e-05 -0.00234994400780905
+ 1.706e-05 -0.00266806359592143
+ 1.7062e-05 -0.00254391382187505
+ 1.7064e-05 -0.00247693005954183
+ 1.7066e-05 -0.00238112819707772
+ 1.7068e-05 -0.00243649223871036
+ 1.707e-05 -0.00223603817989255
+ 1.7072e-05 -0.00231810952267578
+ 1.7074e-05 -0.00237162604842269
+ 1.7076e-05 -0.00274538487899763
+ 1.7078e-05 -0.00277984187142869
+ 1.708e-05 -0.00283791285717946
+ 1.7082e-05 -0.00302717475813876
+ 1.7084e-05 -0.00260468471146443
+ 1.7086e-05 -0.00259093700733963
+ 1.7088e-05 -0.00272808159673217
+ 1.709e-05 -0.00235911735725027
+ 1.7092e-05 -0.00253831940988653
+ 1.7094e-05 -0.00261827477836946
+ 1.7096e-05 -0.0025566488712198
+ 1.7098e-05 -0.00269693732828932
+ 1.71e-05 -0.002535937694158
+ 1.7102e-05 -0.00234270856319235
+ 1.7104e-05 -0.00218741682786084
+ 1.7106e-05 -0.0023214479106734
+ 1.7108e-05 -0.0023553258825249
+ 1.711e-05 -0.00224281022526075
+ 1.7112e-05 -0.00209725619099656
+ 1.7114e-05 -0.00208154723643044
+ 1.7116e-05 -0.00186372976597063
+ 1.7118e-05 -0.00188177191826631
+ 1.712e-05 -0.0018960331111046
+ 1.7122e-05 -0.00192028092480264
+ 1.7124e-05 -0.00212656296591224
+ 1.7126e-05 -0.00185640497819529
+ 1.7128e-05 -0.00173974972128775
+ 1.713e-05 -0.00172042108929612
+ 1.7132e-05 -0.00197736566745211
+ 1.7134e-05 -0.00178152520043134
+ 1.7136e-05 -0.0016983896779424
+ 1.7138e-05 -0.00146842685051186
+ 1.714e-05 -0.00122483130519444
+ 1.7142e-05 -0.00117825662668668
+ 1.7144e-05 -0.000893756472623072
+ 1.7146e-05 -0.000724741845432917
+ 1.7148e-05 -0.000960061810273683
+ 1.715e-05 -0.000606115007410764
+ 1.7152e-05 -0.000819463722174184
+ 1.7154e-05 -0.000601305296974652
+ 1.7156e-05 -0.000300799803689316
+ 1.7158e-05 -0.000412025340045346
+ 1.716e-05 -0.00033386236943956
+ 1.7162e-05 -0.000179569298859553
+ 1.7164e-05 -0.000393355420694975
+ 1.7166e-05 -0.000501107591777922
+ 1.7168e-05 -0.000669933475065934
+ 1.717e-05 -0.000636196084320823
+ 1.7172e-05 -0.000879513049564093
+ 1.7174e-05 -0.00115594356373254
+ 1.7176e-05 -0.00127034544413317
+ 1.7178e-05 -0.000994331822268721
+ 1.718e-05 -0.00119731251923719
+ 1.7182e-05 -0.000911659636602697
+ 1.7184e-05 -0.00119763333202138
+ 1.7186e-05 -0.00104717885756443
+ 1.7188e-05 -0.000632835121234145
+ 1.719e-05 -0.000466949585363716
+ 1.7192e-05 -0.000499703413883039
+ 1.7194e-05 -0.000772129137310498
+ 1.7196e-05 -0.000740943687086033
+ 1.7198e-05 -0.000875728598433499
+ 1.72e-05 -0.000863353016546954
+ 1.7202e-05 -0.000966658902186351
+ 1.7204e-05 -0.000955852519833704
+ 1.7206e-05 -0.000840431835236113
+ 1.7208e-05 -0.00109227965234456
+ 1.721e-05 -0.000991722603142743
+ 1.7212e-05 -0.00108661754560362
+ 1.7214e-05 -0.000966956051004043
+ 1.7216e-05 -0.00095807775763034
+ 1.7218e-05 -0.00115131925836625
+ 1.722e-05 -0.00112222365277977
+ 1.7222e-05 -0.000426368783010284
+ 1.7224e-05 -0.000629904637198707
+ 1.7226e-05 -0.000393192453805046
+ 1.7228e-05 -0.000113472364843611
+ 1.723e-05 -0.000329098615700819
+ 1.7232e-05 -0.000389262294633706
+ 1.7234e-05 -0.000871457116478769
+ 1.7236e-05 -0.000597709224793713
+ 1.7238e-05 -0.000387723685944456
+ 1.724e-05 -0.000272883597819387
+ 1.7242e-05 -0.000407546992140296
+ 1.7244e-05 -0.000194276044022237
+ 1.7246e-05 -1.60391243540145e-06
+ 1.7248e-05 0.000116922855987178
+ 1.725e-05 0.00013453012886928
+ 1.7252e-05 0.000309351841017533
+ 1.7254e-05 5.53187006809516e-05
+ 1.7256e-05 0.00014509627307891
+ 1.7258e-05 -0.000265821592835205
+ 1.726e-05 5.26130118790099e-05
+ 1.7262e-05 0.000213003075394077
+ 1.7264e-05 0.000335002791120621
+ 1.7266e-05 0.000132576598156301
+ 1.7268e-05 0.000244204363732526
+ 1.727e-05 0.000373553674407557
+ 1.7272e-05 0.000240448099390797
+ 1.7274e-05 0.000326198483886873
+ 1.7276e-05 0.000316740204634312
+ 1.7278e-05 0.000180829251507493
+ 1.728e-05 0.000137426734392764
+ 1.7282e-05 0.000119924866563332
+ 1.7284e-05 8.19335249014108e-05
+ 1.7286e-05 -0.000308203509637698
+ 1.7288e-05 -0.00048904210683872
+ 1.729e-05 -0.000335084971275846
+ 1.7292e-05 -0.000144258851963991
+ 1.7294e-05 4.71156632687566e-05
+ 1.7296e-05 -0.000137192094463913
+ 1.7298e-05 -0.000252323005686917
+ 1.73e-05 -0.000169559508506677
+ 1.7302e-05 -0.000419552887755855
+ 1.7304e-05 -0.000394702012209441
+ 1.7306e-05 -0.000228307259613172
+ 1.7308e-05 -9.42722979593643e-05
+ 1.731e-05 0.000165393217964253
+ 1.7312e-05 0.000390665117037035
+ 1.7314e-05 0.000516966414212835
+ 1.7316e-05 0.000412821927149087
+ 1.7318e-05 0.000425170457911895
+ 1.732e-05 0.000346736206764303
+ 1.7322e-05 1.18974658837456e-05
+ 1.7324e-05 2.18055120330357e-05
+ 1.7326e-05 0.000185979296361997
+ 1.7328e-05 0.000256917518049758
+ 1.733e-05 0.00031994619929937
+ 1.7332e-05 0.000645750882258345
+ 1.7334e-05 0.000951818664972987
+ 1.7336e-05 0.000944315939240915
+ 1.7338e-05 0.00105326285455969
+ 1.734e-05 0.00100149900192668
+ 1.7342e-05 0.00106843885471366
+ 1.7344e-05 0.000895883296036001
+ 1.7346e-05 0.000755409382959935
+ 1.7348e-05 0.000793578703383572
+ 1.735e-05 0.000794490912263523
+ 1.7352e-05 0.000842190516789325
+ 1.7354e-05 0.000588481973719592
+ 1.7356e-05 0.000676007513454907
+ 1.7358e-05 0.000986594726485158
+ 1.736e-05 0.00088865704120824
+ 1.7362e-05 0.000935405500958419
+ 1.7364e-05 0.000854187220750313
+ 1.7366e-05 0.000943239642261015
+ 1.7368e-05 0.00104368852302637
+ 1.737e-05 0.00116023688428154
+ 1.7372e-05 0.00081706709621206
+ 1.7374e-05 0.000695484637116163
+ 1.7376e-05 0.000820874118214753
+ 1.7378e-05 0.000828897019976354
+ 1.738e-05 0.000872385851441241
+ 1.7382e-05 0.00105913013885986
+ 1.7384e-05 0.000919197492038215
+ 1.7386e-05 0.000729720145554209
+ 1.7388e-05 0.000436977955756437
+ 1.739e-05 0.000347678068907488
+ 1.7392e-05 -1.40751856708249e-06
+ 1.7394e-05 0.000182810662369277
+ 1.7396e-05 0.000220060834448115
+ 1.7398e-05 0.000574575931019564
+ 1.74e-05 0.000680363714900468
+ 1.7402e-05 0.00107202282842707
+ 1.7404e-05 0.000855827177294379
+ 1.7406e-05 0.00057858777058854
+ 1.7408e-05 0.000644799024490252
+ 1.741e-05 0.000769585917220674
+ 1.7412e-05 0.00077836658953836
+ 1.7414e-05 0.000772001307655375
+ 1.7416e-05 0.000777645300988056
+ 1.7418e-05 0.000649842091143928
+ 1.742e-05 0.000611292008500914
+ 1.7422e-05 0.000568119519206234
+ 1.7424e-05 0.000585405726046496
+ 1.7426e-05 0.000694690662239014
+ 1.7428e-05 0.000528484767706291
+ 1.743e-05 0.000403017727118435
+ 1.7432e-05 0.000501747286578821
+ 1.7434e-05 0.000777699678142967
+ 1.7436e-05 0.000581505783294061
+ 1.7438e-05 0.000677735411800521
+ 1.744e-05 0.000346411061314813
+ 1.7442e-05 0.000639303572935776
+ 1.7444e-05 0.000698024182225093
+ 1.7446e-05 0.000554216798059193
+ 1.7448e-05 0.000490589530792402
+ 1.745e-05 0.000585984871455813
+ 1.7452e-05 0.000817875528559955
+ 1.7454e-05 0.000938295478200278
+ 1.7456e-05 0.000821747358858734
+ 1.7458e-05 0.000904858452459052
+ 1.746e-05 0.000966740837820459
+ 1.7462e-05 0.000954202064839288
+ 1.7464e-05 0.00107513946640335
+ 1.7466e-05 0.00107809869526985
+ 1.7468e-05 0.00091436515036402
+ 1.747e-05 0.000629236661377055
+ 1.7472e-05 0.000711737839229243
+ 1.7474e-05 0.000352887201820464
+ 1.7476e-05 0.000370807663530663
+ 1.7478e-05 0.000473475994405693
+ 1.748e-05 0.000886908350084133
+ 1.7482e-05 0.000826883899427244
+ 1.7484e-05 0.000709036195841199
+ 1.7486e-05 0.000540400553107296
+ 1.7488e-05 0.000879443646901137
+ 1.749e-05 0.000932436470635942
+ 1.7492e-05 0.00094119412447438
+ 1.7494e-05 0.000687559701224018
+ 1.7496e-05 0.000637485624538454
+ 1.7498e-05 0.000909120655543545
+ 1.75e-05 0.000706863945557155
+ 1.7502e-05 0.000782175519613896
+ 1.7504e-05 0.00081746219240035
+ 1.7506e-05 0.000776544124261381
+ 1.7508e-05 0.000725542568973545
+ 1.751e-05 0.000732615784556526
+ 1.7512e-05 0.000621132494439928
+ 1.7514e-05 0.000633839088631376
+ 1.7516e-05 0.000834537621525139
+ 1.7518e-05 0.000749575840932314
+ 1.752e-05 0.000423871948800927
+ 1.7522e-05 0.000279691939880008
+ 1.7524e-05 1.33838360697858e-05
+ 1.7526e-05 -0.000614580789917886
+ 1.7528e-05 -0.000419059920224191
+ 1.753e-05 -8.70901977065639e-05
+ 1.7532e-05 -0.000106867372052845
+ 1.7534e-05 -0.00016391224056738
+ 1.7536e-05 -0.000455863879354145
+ 1.7538e-05 -0.000361323918327034
+ 1.754e-05 -0.000117501730312752
+ 1.7542e-05 -0.000219122387515226
+ 1.7544e-05 -0.000461117045991074
+ 1.7546e-05 -0.000482631325218264
+ 1.7548e-05 -0.000515519814708942
+ 1.755e-05 -0.000448623684294893
+ 1.7552e-05 -0.000408246463290594
+ 1.7554e-05 -0.00011685455048025
+ 1.7556e-05 4.96078995110842e-05
+ 1.7558e-05 -0.000288695015353784
+ 1.756e-05 -0.000472203269877745
+ 1.7562e-05 -0.000781063252574714
+ 1.7564e-05 -0.00113296596510805
+ 1.7566e-05 -0.00116307391064469
+ 1.7568e-05 -0.000949134550167156
+ 1.757e-05 -0.000829826809648133
+ 1.7572e-05 -0.000721200632501784
+ 1.7574e-05 -0.000922951126844334
+ 1.7576e-05 -0.00103855770652664
+ 1.7578e-05 -0.00062088870532459
+ 1.758e-05 -0.000918863643229442
+ 1.7582e-05 -0.000978560409388661
+ 1.7584e-05 -0.00098351778392712
+ 1.7586e-05 -0.00102909373506945
+ 1.7588e-05 -0.00112223653103387
+ 1.759e-05 -0.00101911477376625
+ 1.7592e-05 -0.000736887900465059
+ 1.7594e-05 -0.000532494660810456
+ 1.7596e-05 -0.000895788270123185
+ 1.7598e-05 -0.000718499081717473
+ 1.76e-05 -0.0012498218140879
+ 1.7602e-05 -0.00117046375096312
+ 1.7604e-05 -0.000957095135708993
+ 1.7606e-05 -0.000668368767033655
+ 1.7608e-05 -0.000623354093249855
+ 1.761e-05 -0.000636979376093962
+ 1.7612e-05 -0.000560939773425451
+ 1.7614e-05 -0.000560399807264524
+ 1.7616e-05 -0.000526807740881202
+ 1.7618e-05 -0.000621102006717276
+ 1.762e-05 -0.000646066007487021
+ 1.7622e-05 -0.000787671487240195
+ 1.7624e-05 -0.000913435735766247
+ 1.7626e-05 -0.000990378851042395
+ 1.7628e-05 -0.000659676013271721
+ 1.763e-05 -0.00052045892751345
+ 1.7632e-05 -0.000509383533735153
+ 1.7634e-05 -0.000609621303327964
+ 1.7636e-05 -0.000299280954341991
+ 1.7638e-05 -0.000199700470355464
+ 1.764e-05 -0.000636865255490969
+ 1.7642e-05 -0.000794037391851753
+ 1.7644e-05 -0.00049294849593159
+ 1.7646e-05 -0.000434467179967209
+ 1.7648e-05 -0.000164707582130254
+ 1.765e-05 5.44860919099831e-05
+ 1.7652e-05 0.000330825218009961
+ 1.7654e-05 -4.86801773856967e-05
+ 1.7656e-05 -0.000127166924965285
+ 1.7658e-05 4.27968052301236e-05
+ 1.766e-05 0.000432962673696438
+ 1.7662e-05 0.000314202520321037
+ 1.7664e-05 0.000573776123771538
+ 1.7666e-05 0.000413468249419974
+ 1.7668e-05 5.44375567230543e-05
+ 1.767e-05 -0.000385178094599989
+ 1.7672e-05 -0.000383498414267671
+ 1.7674e-05 -0.000286676615663119
+ 1.7676e-05 -0.000590524192846833
+ 1.7678e-05 -0.000602533876975352
+ 1.768e-05 -0.000722222243433906
+ 1.7682e-05 -0.00106226280033902
+ 1.7684e-05 -0.00116653388844764
+ 1.7686e-05 -0.00112089862572788
+ 1.7688e-05 -0.00129053851583106
+ 1.769e-05 -0.00108051077796853
+ 1.7692e-05 -0.00089460124847741
+ 1.7694e-05 -0.00066930441724151
+ 1.7696e-05 -0.000553210027543193
+ 1.7698e-05 -0.000731825349240731
+ 1.77e-05 -0.000892059179320059
+ 1.7702e-05 -0.000818687865095372
+ 1.7704e-05 -0.000768406141398261
+ 1.7706e-05 -0.000777919017604003
+ 1.7708e-05 -0.000749740208261663
+ 1.771e-05 -0.000909492122006504
+ 1.7712e-05 -0.000957090966579348
+ 1.7714e-05 -0.000849693588591393
+ 1.7716e-05 -0.000997246731193123
+ 1.7718e-05 -0.00103422390065734
+ 1.772e-05 -0.000917035660251516
+ 1.7722e-05 -0.000980769501358006
+ 1.7724e-05 -0.00136779836761837
+ 1.7726e-05 -0.00103272360577606
+ 1.7728e-05 -0.000946745630809511
+ 1.773e-05 -0.000802758186200176
+ 1.7732e-05 -0.000637204201219375
+ 1.7734e-05 -0.000520402294541584
+ 1.7736e-05 -0.000694608329900495
+ 1.7738e-05 -0.000501439897969194
+ 1.774e-05 -0.000802222054880481
+ 1.7742e-05 -0.000906089629725183
+ 1.7744e-05 -0.000935309292713761
+ 1.7746e-05 -0.00106122777636508
+ 1.7748e-05 -0.000939736196903236
+ 1.775e-05 -0.000901965993328028
+ 1.7752e-05 -0.000720934060540287
+ 1.7754e-05 -0.000715216059496311
+ 1.7756e-05 -0.00094140398385175
+ 1.7758e-05 -0.00118920752681813
+ 1.776e-05 -0.00110644873081602
+ 1.7762e-05 -0.00131519267360351
+ 1.7764e-05 -0.00137283923451369
+ 1.7766e-05 -0.00128379957390839
+ 1.7768e-05 -0.00115295298314339
+ 1.777e-05 -0.00141008160619629
+ 1.7772e-05 -0.00168626261571376
+ 1.7774e-05 -0.00150421476782726
+ 1.7776e-05 -0.00179205005178729
+ 1.7778e-05 -0.00137044325889782
+ 1.778e-05 -0.00169195681891829
+ 1.7782e-05 -0.00144786888866597
+ 1.7784e-05 -0.00144339376050135
+ 1.7786e-05 -0.00143126116681201
+ 1.7788e-05 -0.0012192878104019
+ 1.779e-05 -0.0011922734818311
+ 1.7792e-05 -0.00125967811747659
+ 1.7794e-05 -0.0016224119114205
+ 1.7796e-05 -0.00149467289965811
+ 1.7798e-05 -0.00141398157969563
+ 1.78e-05 -0.00120788803692126
+ 1.7802e-05 -0.00117419434541449
+ 1.7804e-05 -0.00154619263043647
+ 1.7806e-05 -0.00129901649263683
+ 1.7808e-05 -0.00129577912298549
+ 1.781e-05 -0.000640579527488097
+ 1.7812e-05 -0.000993841481216834
+ 1.7814e-05 -0.000930110486959012
+ 1.7816e-05 -0.000544376457990738
+ 1.7818e-05 -0.000474531146331116
+ 1.782e-05 -0.000616142308846838
+ 1.7822e-05 -0.000810015439050324
+ 1.7824e-05 -0.00104954284613084
+ 1.7826e-05 -0.000798025322663183
+ 1.7828e-05 -0.000755809548766549
+ 1.783e-05 -0.000388054245861544
+ 1.7832e-05 -0.000454257455413174
+ 1.7834e-05 -0.000265756305778881
+ 1.7836e-05 -0.000482836055672706
+ 1.7838e-05 -0.000383253513054584
+ 1.784e-05 -0.000256658298861167
+ 1.7842e-05 -0.000190898044969709
+ 1.7844e-05 -0.000136213153717552
+ 1.7846e-05 -0.000113644685177613
+ 1.7848e-05 -0.000456724257195967
+ 1.785e-05 -0.00090115278795428
+ 1.7852e-05 -0.000754713620735408
+ 1.7854e-05 -0.00060599582396874
+ 1.7856e-05 -0.000873100044540737
+ 1.7858e-05 -0.00103047129680524
+ 1.786e-05 -0.000965303183495113
+ 1.7862e-05 -0.00115007782111833
+ 1.7864e-05 -0.0012967616025492
+ 1.7866e-05 -0.00123717681803572
+ 1.7868e-05 -0.00135794125991679
+ 1.787e-05 -0.00135301038928613
+ 1.7872e-05 -0.00146140902302579
+ 1.7874e-05 -0.00145068316221928
+ 1.7876e-05 -0.0014090811904952
+ 1.7878e-05 -0.0013971889587034
+ 1.788e-05 -0.00141039380833048
+ 1.7882e-05 -0.00116538642453246
+ 1.7884e-05 -0.00077183951316559
+ 1.7886e-05 -0.000751018571900377
+ 1.7888e-05 -0.00070683281943105
+ 1.789e-05 -0.000594743875825397
+ 1.7892e-05 -0.000489843863352454
+ 1.7894e-05 -0.000412349327911157
+ 1.7896e-05 -0.000375883092836098
+ 1.7898e-05 -0.000168701822381453
+ 1.79e-05 -1.91387487458655e-05
+ 1.7902e-05 0.000133988030743831
+ 1.7904e-05 0.00039793837909946
+ 1.7906e-05 0.000198822690549108
+ 1.7908e-05 7.99608048073025e-05
+ 1.791e-05 -6.66942214915281e-05
+ 1.7912e-05 7.53618371069866e-05
+ 1.7914e-05 -8.27378809499901e-05
+ 1.7916e-05 -0.000243994919417155
+ 1.7918e-05 -0.000274761290992248
+ 1.792e-05 -0.000399017961478918
+ 1.7922e-05 -0.000192021879561474
+ 1.7924e-05 -0.000322394175922555
+ 1.7926e-05 -0.000607484306289518
+ 1.7928e-05 -0.000501066338991807
+ 1.793e-05 -0.000905733720315336
+ 1.7932e-05 -0.000747771604130375
+ 1.7934e-05 -0.000959662366612949
+ 1.7936e-05 -0.00102509255190164
+ 1.7938e-05 -0.001238477360063
+ 1.794e-05 -0.00132134705634063
+ 1.7942e-05 -0.00132220045071031
+ 1.7944e-05 -0.00155417066676198
+ 1.7946e-05 -0.0015399912284194
+ 1.7948e-05 -0.00167364875480602
+ 1.795e-05 -0.00189757097638587
+ 1.7952e-05 -0.00171060570223134
+ 1.7954e-05 -0.00173146752941575
+ 1.7956e-05 -0.00202810120676328
+ 1.7958e-05 -0.00185153444511122
+ 1.796e-05 -0.00188558753125872
+ 1.7962e-05 -0.00208954384436225
+ 1.7964e-05 -0.00226734057241125
+ 1.7966e-05 -0.00222182487811128
+ 1.7968e-05 -0.00272765983121991
+ 1.797e-05 -0.00250338827558707
+ 1.7972e-05 -0.00273971143940034
+ 1.7974e-05 -0.00254857632835749
+ 1.7976e-05 -0.0025702369845342
+ 1.7978e-05 -0.00235253686473349
+ 1.798e-05 -0.00230376243263242
+ 1.7982e-05 -0.00240947446957697
+ 1.7984e-05 -0.00224037087562998
+ 1.7986e-05 -0.00185574197163428
+ 1.7988e-05 -0.00179039900643253
+ 1.799e-05 -0.00195859469471913
+ 1.7992e-05 -0.00193226163561432
+ 1.7994e-05 -0.00182508886023755
+ 1.7996e-05 -0.00164057343967877
+ 1.7998e-05 -0.00200115332359184
+ 1.8e-05 -0.00199276033452919
+ 1.8002e-05 -0.00160662412268743
+ 1.8004e-05 -0.00133079090445106
+ 1.8006e-05 -0.00126349862721134
+ 1.8008e-05 -0.000807012240408464
+ 1.801e-05 -0.000797999004400559
+ 1.8012e-05 -0.000679181293775794
+ 1.8014e-05 -0.000830082895046846
+ 1.8016e-05 -0.000750296730927457
+ 1.8018e-05 -0.000817791008807227
+ 1.802e-05 -0.000976653819348588
+ 1.8022e-05 -0.00113021988790956
+ 1.8024e-05 -0.000913225366551288
+ 1.8026e-05 -0.000992632382580029
+ 1.8028e-05 -0.00103075824505298
+ 1.803e-05 -0.00115424470750028
+ 1.8032e-05 -0.00113192460543044
+ 1.8034e-05 -0.00133983553022698
+ 1.8036e-05 -0.0015470090464012
+ 1.8038e-05 -0.00116754132462494
+ 1.804e-05 -0.00102087297709872
+ 1.8042e-05 -0.000992626150771319
+ 1.8044e-05 -0.00116042826201912
+ 1.8046e-05 -0.00128152206651805
+ 1.8048e-05 -0.00135520858191523
+ 1.805e-05 -0.00116535836947263
+ 1.8052e-05 -0.000915684382080845
+ 1.8054e-05 -0.000854261979910794
+ 1.8056e-05 -0.000750223851859191
+ 1.8058e-05 -0.000519342001951156
+ 1.806e-05 -0.000444374759348992
+ 1.8062e-05 -0.000149470990207001
+ 1.8064e-05 -0.000148832574945959
+ 1.8066e-05 -0.00030565153918707
+ 1.8068e-05 -0.000253882507248124
+ 1.807e-05 -0.000186621414749035
+ 1.8072e-05 -0.0003566320781568
+ 1.8074e-05 -0.000600825657474306
+ 1.8076e-05 -0.000412730250235423
+ 1.8078e-05 -0.000105613567279854
+ 1.808e-05 -0.000273486858048578
+ 1.8082e-05 -0.000427611660670042
+ 1.8084e-05 -0.000226151032171992
+ 1.8086e-05 -4.39103459475994e-05
+ 1.8088e-05 -0.000163402097059434
+ 1.809e-05 -0.000207376271835155
+ 1.8092e-05 -0.000124758238300644
+ 1.8094e-05 -0.000111216279134309
+ 1.8096e-05 -2.90478733640807e-06
+ 1.8098e-05 8.76726815533166e-05
+ 1.81e-05 -9.06488493150343e-05
+ 1.8102e-05 -3.6170856796031e-05
+ 1.8104e-05 -6.79051464883074e-05
+ 1.8106e-05 8.21675305412336e-05
+ 1.8108e-05 -6.79070224874382e-05
+ 1.811e-05 -1.30972060497188e-05
+ 1.8112e-05 -0.000145267425321462
+ 1.8114e-05 -0.000565669759949874
+ 1.8116e-05 -0.000447088260518621
+ 1.8118e-05 -0.00059107157584065
+ 1.812e-05 -0.000468699642357851
+ 1.8122e-05 -0.000269030289475096
+ 1.8124e-05 -0.000350854477239355
+ 1.8126e-05 -0.000267735807972239
+ 1.8128e-05 -0.000295975534862576
+ 1.813e-05 -0.000237503309744508
+ 1.8132e-05 -0.000459633392085562
+ 1.8134e-05 -0.000606219380989956
+ 1.8136e-05 -0.000381454261979004
+ 1.8138e-05 0.000125571048956539
+ 1.814e-05 0.000142095069048556
+ 1.8142e-05 0.000332389366834041
+ 1.8144e-05 0.000699364531182413
+ 1.8146e-05 0.00065392866036839
+ 1.8148e-05 0.00076137008597961
+ 1.815e-05 0.0010323835266207
+ 1.8152e-05 0.00091612429145974
+ 1.8154e-05 0.00109927433378916
+ 1.8156e-05 0.00127439192577708
+ 1.8158e-05 0.00176557657906278
+ 1.816e-05 0.00169740383626962
+ 1.8162e-05 0.00180391550299708
+ 1.8164e-05 0.00181630674055232
+ 1.8166e-05 0.00204738043368429
+ 1.8168e-05 0.00178892921181165
+ 1.817e-05 0.00172355744139045
+ 1.8172e-05 0.00203957697824355
+ 1.8174e-05 0.00184391039847991
+ 1.8176e-05 0.00183322699464852
+ 1.8178e-05 0.00190930253864844
+ 1.818e-05 0.00203675303137962
+ 1.8182e-05 0.00220046362962845
+ 1.8184e-05 0.00247777819099234
+ 1.8186e-05 0.00213082494488497
+ 1.8188e-05 0.00215594856796362
+ 1.819e-05 0.00223796321986466
+ 1.8192e-05 0.00215447220061009
+ 1.8194e-05 0.0019557816693737
+ 1.8196e-05 0.00175773716459551
+ 1.8198e-05 0.00187048003385251
+ 1.82e-05 0.0019904169766258
+ 1.8202e-05 0.0019805971233384
+ 1.8204e-05 0.00184775272630034
+ 1.8206e-05 0.00215830447035067
+ 1.8208e-05 0.00233474696896595
+ 1.821e-05 0.00228590866177381
+ 1.8212e-05 0.00252246308714071
+ 1.8214e-05 0.0022902937228506
+ 1.8216e-05 0.00233811004792751
+ 1.8218e-05 0.00236768604790782
+ 1.822e-05 0.00231193025409951
+ 1.8222e-05 0.00223228384202785
+ 1.8224e-05 0.0019436814080234
+ 1.8226e-05 0.00157060461064837
+ 1.8228e-05 0.00167917228975396
+ 1.823e-05 0.00147050900122774
+ 1.8232e-05 0.0013668266980495
+ 1.8234e-05 0.00132642788829231
+ 1.8236e-05 0.000971354074730969
+ 1.8238e-05 0.000893886759555762
+ 1.824e-05 0.000353984880514195
+ 1.8242e-05 0.00052060188182961
+ 1.8244e-05 0.000831577829054348
+ 1.8246e-05 0.000834918543552329
+ 1.8248e-05 0.00082816638937947
+ 1.825e-05 0.00100797875753965
+ 1.8252e-05 0.00100241775530053
+ 1.8254e-05 0.000877543424564659
+ 1.8256e-05 0.000699395248631494
+ 1.8258e-05 0.000659461408981991
+ 1.826e-05 0.000619395483564519
+ 1.8262e-05 0.000898326627688391
+ 1.8264e-05 0.000833373305287464
+ 1.8266e-05 0.000736285045105972
+ 1.8268e-05 0.000644232075769047
+ 1.827e-05 0.000285122930260088
+ 1.8272e-05 0.000165063310899261
+ 1.8274e-05 0.000129728894449176
+ 1.8276e-05 -1.16631119357524e-05
+ 1.8278e-05 0.000139603939596123
+ 1.828e-05 -2.24996873269802e-05
+ 1.8282e-05 0.000232613879712626
+ 1.8284e-05 0.000399138026017271
+ 1.8286e-05 0.000539093837935673
+ 1.8288e-05 8.67269830494922e-05
+ 1.829e-05 6.75195303922848e-05
+ 1.8292e-05 -0.000214993483885549
+ 1.8294e-05 -0.000119967215183142
+ 1.8296e-05 0.000259513909339556
+ 1.8298e-05 0.000325070380085149
+ 1.83e-05 0.000618389916340319
+ 1.8302e-05 0.000757643036725141
+ 1.8304e-05 0.00078703457183849
+ 1.8306e-05 0.000801261265191808
+ 1.8308e-05 0.000793160504820348
+ 1.831e-05 0.000316179130843526
+ 1.8312e-05 8.1145653923825e-05
+ 1.8314e-05 -7.67585989649666e-05
+ 1.8316e-05 -0.000108510726516538
+ 1.8318e-05 -0.000304564361111553
+ 1.832e-05 -0.000379219907963075
+ 1.8322e-05 -0.00025132895151762
+ 1.8324e-05 -0.000432922907565471
+ 1.8326e-05 -0.00048821160294056
+ 1.8328e-05 -0.000489283259037267
+ 1.833e-05 -0.000832539251769962
+ 1.8332e-05 -0.000855653118905938
+ 1.8334e-05 -0.000788955088283945
+ 1.8336e-05 -0.00090525356208607
+ 1.8338e-05 -0.000884924556267286
+ 1.834e-05 -0.00074697771892611
+ 1.8342e-05 -0.000266508517346005
+ 1.8344e-05 3.88716699145503e-05
+ 1.8346e-05 0.000200501985153395
+ 1.8348e-05 0.000475958495044538
+ 1.835e-05 0.00033283495852336
+ 1.8352e-05 0.000606505261690113
+ 1.8354e-05 0.000425638417470154
+ 1.8356e-05 0.000495290617607776
+ 1.8358e-05 0.000534669849513374
+ 1.836e-05 0.000479012336024049
+ 1.8362e-05 0.000512904832067198
+ 1.8364e-05 0.00047216979268563
+ 1.8366e-05 0.000246937494717663
+ 1.8368e-05 0.000214167910337248
+ 1.837e-05 0.000281460098085958
+ 1.8372e-05 0.000321085526389146
+ 1.8374e-05 0.00052534114047615
+ 1.8376e-05 0.000798877980597863
+ 1.8378e-05 0.000794117981163316
+ 1.838e-05 0.00105352391211367
+ 1.8382e-05 0.00127776497629115
+ 1.8384e-05 0.00113336539188034
+ 1.8386e-05 0.00120273433564124
+ 1.8388e-05 0.00107072538972199
+ 1.839e-05 0.00160744909788601
+ 1.8392e-05 0.00154177927120836
+ 1.8394e-05 0.00143288713267228
+ 1.8396e-05 0.00108719324292801
+ 1.8398e-05 0.00134632661476412
+ 1.84e-05 0.00160661351944524
+ 1.8402e-05 0.00178714814461197
+ 1.8404e-05 0.0016646252524087
+ 1.8406e-05 0.00173786471807554
+ 1.8408e-05 0.00143326132635592
+ 1.841e-05 0.00129248106241737
+ 1.8412e-05 0.00161836320136185
+ 1.8414e-05 0.00184201546689272
+ 1.8416e-05 0.00168108122949709
+ 1.8418e-05 0.00161033391842772
+ 1.842e-05 0.00142277450564574
+ 1.8422e-05 0.00142285113106786
+ 1.8424e-05 0.00128344866684907
+ 1.8426e-05 0.00130663683191433
+ 1.8428e-05 0.0013074252437021
+ 1.843e-05 0.0013924094874703
+ 1.8432e-05 0.00156218668765489
+ 1.8434e-05 0.00136255975219695
+ 1.8436e-05 0.0013698378001085
+ 1.8438e-05 0.00115373960515519
+ 1.844e-05 0.00139885048993942
+ 1.8442e-05 0.00125607383963707
+ 1.8444e-05 0.00109493635751169
+ 1.8446e-05 0.00110019086613438
+ 1.8448e-05 0.000580656770876002
+ 1.845e-05 0.000603553164067481
+ 1.8452e-05 0.000407747731431928
+ 1.8454e-05 0.000184035633408545
+ 1.8456e-05 2.44981496038185e-05
+ 1.8458e-05 -0.000177933977213501
+ 1.846e-05 -0.000228915324697893
+ 1.8462e-05 -0.000443257738058062
+ 1.8464e-05 -0.000533002885450057
+ 1.8466e-05 -0.000764262551440073
+ 1.8468e-05 -0.00115652143699661
+ 1.847e-05 -0.00111889369929615
+ 1.8472e-05 -0.00101753555303892
+ 1.8474e-05 -0.00070811705074788
+ 1.8476e-05 -0.000766295103180073
+ 1.8478e-05 -0.000414329813854253
+ 1.848e-05 -0.000513909140663444
+ 1.8482e-05 -0.000490187191249043
+ 1.8484e-05 -0.000591150816827743
+ 1.8486e-05 -0.00045469369893655
+ 1.8488e-05 -0.000495566505960574
+ 1.849e-05 -0.000688206471704257
+ 1.8492e-05 -0.000568237138346082
+ 1.8494e-05 -0.000407916139793378
+ 1.8496e-05 -0.000469421068604653
+ 1.8498e-05 -0.000347029372386938
+ 1.85e-05 -0.00029161826685023
+ 1.8502e-05 -0.000121817906035582
+ 1.8504e-05 -0.000205811958307015
+ 1.8506e-05 -0.000255450513229035
+ 1.8508e-05 -0.000435707641410105
+ 1.851e-05 -0.000708251671192271
+ 1.8512e-05 -0.000236564006919696
+ 1.8514e-05 -0.000115307475579178
+ 1.8516e-05 0.000178753140285933
+ 1.8518e-05 0.000128037410742618
+ 1.852e-05 0.000594053134312292
+ 1.8522e-05 0.000939742765821216
+ 1.8524e-05 0.00128818567590854
+ 1.8526e-05 0.00132467733392581
+ 1.8528e-05 0.00126350076534082
+ 1.853e-05 0.00135649841773728
+ 1.8532e-05 0.00132000197735324
+ 1.8534e-05 0.00148805132649651
+ 1.8536e-05 0.00136297937627642
+ 1.8538e-05 0.00132711229968016
+ 1.854e-05 0.0012202804880067
+ 1.8542e-05 0.00130545852240799
+ 1.8544e-05 0.0013306504519371
+ 1.8546e-05 0.00118407255855005
+ 1.8548e-05 0.00145803734372419
+ 1.855e-05 0.00171823533761751
+ 1.8552e-05 0.00168186147044392
+ 1.8554e-05 0.00164222752782637
+ 1.8556e-05 0.00147075777313727
+ 1.8558e-05 0.0010078731367031
+ 1.856e-05 0.00105419331228484
+ 1.8562e-05 0.000843664408376998
+ 1.8564e-05 0.000860495016349115
+ 1.8566e-05 0.000486149076517001
+ 1.8568e-05 0.000558399506739235
+ 1.857e-05 0.000585905752724149
+ 1.8572e-05 0.000902659863232565
+ 1.8574e-05 0.00097828148414635
+ 1.8576e-05 0.00113518720573359
+ 1.8578e-05 0.00104053640571821
+ 1.858e-05 0.00111418593892016
+ 1.8582e-05 0.000914358806537483
+ 1.8584e-05 0.000831834916912324
+ 1.8586e-05 0.000522801239285601
+ 1.8588e-05 0.000802816659926896
+ 1.859e-05 0.00090551538796282
+ 1.8592e-05 0.000698817701698857
+ 1.8594e-05 0.000635334996620882
+ 1.8596e-05 0.000246969763089578
+ 1.8598e-05 -7.61225081990017e-05
+ 1.86e-05 -0.000608441034771231
+ 1.8602e-05 -0.000559822303445493
+ 1.8604e-05 -0.000534064712076892
+ 1.8606e-05 -0.000644042665186239
+ 1.8608e-05 -0.000582036551946523
+ 1.861e-05 -0.00047263397529002
+ 1.8612e-05 -0.000648178751406784
+ 1.8614e-05 -0.000685298004870933
+ 1.8616e-05 -0.000727098359378276
+ 1.8618e-05 -0.00106196208908823
+ 1.862e-05 -0.000780915221073121
+ 1.8622e-05 -0.000737696827677858
+ 1.8624e-05 -0.000943151604323839
+ 1.8626e-05 -0.00101390578352099
+ 1.8628e-05 -0.000901475201233158
+ 1.863e-05 -0.000772935446566594
+ 1.8632e-05 -0.000478911536557785
+ 1.8634e-05 -0.000193406946777602
+ 1.8636e-05 1.67117928075881e-05
+ 1.8638e-05 -8.9101880665783e-05
+ 1.864e-05 -7.25613212516643e-05
+ 1.8642e-05 -0.000198611575973668
+ 1.8644e-05 -0.00054753734385393
+ 1.8646e-05 -0.000429383099462119
+ 1.8648e-05 -0.000340709199371511
+ 1.865e-05 -0.000464198779735479
+ 1.8652e-05 -0.000577045535519767
+ 1.8654e-05 -0.000153075027465588
+ 1.8656e-05 -0.000338894011329955
+ 1.8658e-05 -0.000371900993030003
+ 1.866e-05 -0.0003908857050815
+ 1.8662e-05 0.000203872812725559
+ 1.8664e-05 0.000547670814119543
+ 1.8666e-05 0.000515617767875077
+ 1.8668e-05 0.000612879880267466
+ 1.867e-05 0.000652819763675332
+ 1.8672e-05 0.000792515893848219
+ 1.8674e-05 0.000797307966676966
+ 1.8676e-05 0.000974339647873057
+ 1.8678e-05 0.00107603263089491
+ 1.868e-05 0.00098742233974014
+ 1.8682e-05 0.000491738459737715
+ 1.8684e-05 0.000333714595113787
+ 1.8686e-05 0.000254814100959701
+ 1.8688e-05 -2.40250916550824e-05
+ 1.869e-05 0.00022005402649598
+ 1.8692e-05 0.000162908359506338
+ 1.8694e-05 -4.93590668690822e-05
+ 1.8696e-05 0.000248921258281121
+ 1.8698e-05 0.000123584433288397
+ 1.87e-05 8.10651680513729e-05
+ 1.8702e-05 -0.000406787952454337
+ 1.8704e-05 -0.000559575261822119
+ 1.8706e-05 -0.000730425282881108
+ 1.8708e-05 -0.000637919602828969
+ 1.871e-05 -0.00107290419806228
+ 1.8712e-05 -0.00104219998520925
+ 1.8714e-05 -0.0010986486576935
+ 1.8716e-05 -0.00107345032362052
+ 1.8718e-05 -0.00125480032766962
+ 1.872e-05 -0.000924082970487863
+ 1.8722e-05 -0.000695015305047911
+ 1.8724e-05 -0.000400970226832054
+ 1.8726e-05 -0.000491388441187429
+ 1.8728e-05 -0.000324449410643353
+ 1.873e-05 -0.000303993036785759
+ 1.8732e-05 -0.000537605949137472
+ 1.8734e-05 -0.000389824785957453
+ 1.8736e-05 -0.00063288722954267
+ 1.8738e-05 -0.000779049006510479
+ 1.874e-05 -0.000620841417532865
+ 1.8742e-05 -0.000626795149286329
+ 1.8744e-05 -0.000689095742738236
+ 1.8746e-05 -0.000762928691832252
+ 1.8748e-05 -0.0007973011363238
+ 1.875e-05 -0.000743983011378379
+ 1.8752e-05 -0.00073415000302726
+ 1.8754e-05 -0.000715092969040394
+ 1.8756e-05 -0.000527778780263242
+ 1.8758e-05 -0.000126415113117781
+ 1.876e-05 0.000207431656268805
+ 1.8762e-05 0.000237671131527578
+ 1.8764e-05 0.000250846882169289
+ 1.8766e-05 -5.47330207484822e-05
+ 1.8768e-05 2.15984959994215e-06
+ 1.877e-05 -7.04511566512198e-05
+ 1.8772e-05 0.000253543108858542
+ 1.8774e-05 0.000235411287290609
+ 1.8776e-05 0.000382106763841674
+ 1.8778e-05 8.17823589152564e-05
+ 1.878e-05 -5.83703371205034e-05
+ 1.8782e-05 4.20612138577934e-05
+ 1.8784e-05 -0.000142090243253081
+ 1.8786e-05 -0.000243802328426806
+ 1.8788e-05 -5.53436432685812e-05
+ 1.879e-05 0.000169970811152725
+ 1.8792e-05 -0.000179706552707193
+ 1.8794e-05 -0.000462737462125958
+ 1.8796e-05 -0.000132676510246685
+ 1.8798e-05 -0.000251837872926065
+ 1.88e-05 -0.000135093947329551
+ 1.8802e-05 -7.94064654039666e-05
+ 1.8804e-05 -0.000371809964760753
+ 1.8806e-05 1.50028421946807e-05
+ 1.8808e-05 -0.000363877458527914
+ 1.881e-05 -0.000123377894592238
+ 1.8812e-05 1.2811660882976e-05
+ 1.8814e-05 -0.000296918808100253
+ 1.8816e-05 -0.000329798309819274
+ 1.8818e-05 -0.000549817988925393
+ 1.882e-05 -0.000346198435463708
+ 1.8822e-05 -6.66315818862417e-05
+ 1.8824e-05 1.69347827789754e-05
+ 1.8826e-05 0.000240936130252611
+ 1.8828e-05 0.000330134296669508
+ 1.883e-05 0.00034952119217172
+ 1.8832e-05 0.000210240992552585
+ 1.8834e-05 8.78046313656612e-05
+ 1.8836e-05 3.13013438198161e-05
+ 1.8838e-05 -3.96400949919502e-05
+ 1.884e-05 -0.000261235496931161
+ 1.8842e-05 -0.000494610283108093
+ 1.8844e-05 -0.000436597809142954
+ 1.8846e-05 -0.000288062846514796
+ 1.8848e-05 -0.000262674906003619
+ 1.885e-05 -0.000302341693999368
+ 1.8852e-05 -0.000140223513375638
+ 1.8854e-05 0.00023454183536072
+ 1.8856e-05 0.000527014342228835
+ 1.8858e-05 0.000182273081823403
+ 1.886e-05 -0.00026078654163907
+ 1.8862e-05 -0.000312683728913259
+ 1.8864e-05 -2.70541523683977e-05
+ 1.8866e-05 -5.98458017545266e-05
+ 1.8868e-05 1.72117345187951e-05
+ 1.887e-05 -5.66824114533846e-05
+ 1.8872e-05 0.000117259432747196
+ 1.8874e-05 7.57331049905738e-05
+ 1.8876e-05 -9.72701125666866e-05
+ 1.8878e-05 -0.000109336872113005
+ 1.888e-05 0.000115298337468082
+ 1.8882e-05 3.77331077342647e-05
+ 1.8884e-05 1.05195253519928e-05
+ 1.8886e-05 -8.55561460458874e-05
+ 1.8888e-05 -0.000240003930592732
+ 1.889e-05 -0.000443363968879118
+ 1.8892e-05 -7.7812993499419e-05
+ 1.8894e-05 0.000176624866022795
+ 1.8896e-05 0.000358557986733986
+ 1.8898e-05 0.000464101095040098
+ 1.89e-05 0.000352785560681956
+ 1.8902e-05 0.000330124526391667
+ 1.8904e-05 0.000398615559099292
+ 1.8906e-05 0.000341021323247243
+ 1.8908e-05 0.000388255978854247
+ 1.891e-05 0.00021647711601904
+ 1.8912e-05 7.71408572144328e-05
+ 1.8914e-05 0.00018853905855496
+ 1.8916e-05 0.000498572150393277
+ 1.8918e-05 0.000487204538096627
+ 1.892e-05 0.000631967866946658
+ 1.8922e-05 0.000433954505070858
+ 1.8924e-05 0.000481410364117515
+ 1.8926e-05 0.000364509142357512
+ 1.8928e-05 0.000639485142029836
+ 1.893e-05 0.000949669276082883
+ 1.8932e-05 0.00124721833066374
+ 1.8934e-05 0.00125036985198169
+ 1.8936e-05 0.00148138884212673
+ 1.8938e-05 0.00150200948271206
+ 1.894e-05 0.00177041709168142
+ 1.8942e-05 0.00197492984256542
+ 1.8944e-05 0.00204197086283961
+ 1.8946e-05 0.00205084573400968
+ 1.8948e-05 0.00208486478107915
+ 1.895e-05 0.00196343927984464
+ 1.8952e-05 0.00180090055613793
+ 1.8954e-05 0.0016328118839375
+ 1.8956e-05 0.00177678471357813
+ 1.8958e-05 0.00216452763569084
+ 1.896e-05 0.0021572870860743
+ 1.8962e-05 0.00199579802555944
+ 1.8964e-05 0.00171147663852671
+ 1.8966e-05 0.00181881226158478
+ 1.8968e-05 0.00209604358393832
+ 1.897e-05 0.00206783547342924
+ 1.8972e-05 0.00215067879120551
+ 1.8974e-05 0.00214145938565687
+ 1.8976e-05 0.00202262309268552
+ 1.8978e-05 0.00183740365942075
+ 1.898e-05 0.00182684947003576
+ 1.8982e-05 0.00203561029748311
+ 1.8984e-05 0.00209849194008015
+ 1.8986e-05 0.00205971405690771
+ 1.8988e-05 0.00168923874540052
+ 1.899e-05 0.0014290285495097
+ 1.8992e-05 0.00138892797897941
+ 1.8994e-05 0.00133874290519026
+ 1.8996e-05 0.00117353370821517
+ 1.8998e-05 0.00127468616935059
+ 1.9e-05 0.00121688884137995
+ 1.9002e-05 0.00143095150449048
+ 1.9004e-05 0.0011869343643373
+ 1.9006e-05 0.00131646361635142
+ 1.9008e-05 0.00109910058470398
+ 1.901e-05 0.00150598091795558
+ 1.9012e-05 0.00138915562747848
+ 1.9014e-05 0.0015202614305778
+ 1.9016e-05 0.00139034132066279
+ 1.9018e-05 0.00114733036465474
+ 1.902e-05 0.00113604472626647
+ 1.9022e-05 0.000838887923671475
+ 1.9024e-05 0.000858421870765998
+ 1.9026e-05 0.000993015637716643
+ 1.9028e-05 0.00120589742495421
+ 1.903e-05 0.00111539615978087
+ 1.9032e-05 0.000787935608733465
+ 1.9034e-05 0.0010441517381752
+ 1.9036e-05 0.00090872167532823
+ 1.9038e-05 0.000864102481448544
+ 1.904e-05 0.000799740937678003
+ 1.9042e-05 0.000886962592453756
+ 1.9044e-05 0.00108701910851753
+ 1.9046e-05 0.00077141665290428
+ 1.9048e-05 0.000974505191331712
+ 1.905e-05 0.000841020480403522
+ 1.9052e-05 0.000573597518992662
+ 1.9054e-05 0.000892702306660577
+ 1.9056e-05 0.00111054858648493
+ 1.9058e-05 0.00109347168287121
+ 1.906e-05 0.00117456642131048
+ 1.9062e-05 0.000894465123339296
+ 1.9064e-05 0.000847126522054615
+ 1.9066e-05 0.000686331502041682
+ 1.9068e-05 0.000867010692461452
+ 1.907e-05 0.000655895221271137
+ 1.9072e-05 0.000746379327542991
+ 1.9074e-05 0.000874178119041726
+ 1.9076e-05 0.000720290958569975
+ 1.9078e-05 0.000708757683108256
+ 1.908e-05 0.000780228513244819
+ 1.9082e-05 0.000543591149463438
+ 1.9084e-05 0.000680810706501976
+ 1.9086e-05 0.000628653789132008
+ 1.9088e-05 0.000732352159534244
+ 1.909e-05 0.000589567357032828
+ 1.9092e-05 0.000726715996729526
+ 1.9094e-05 0.000923485413679388
+ 1.9096e-05 0.000910895388813214
+ 1.9098e-05 0.000823768633787978
+ 1.91e-05 0.000965572617805018
+ 1.9102e-05 0.000863266940743256
+ 1.9104e-05 0.000822447474363099
+ 1.9106e-05 0.00112973720550713
+ 1.9108e-05 0.00108984871206446
+ 1.911e-05 0.000904626154176874
+ 1.9112e-05 0.00114686725126122
+ 1.9114e-05 0.00130798041064989
+ 1.9116e-05 0.00140400464054236
+ 1.9118e-05 0.00130289475812712
+ 1.912e-05 0.00132886188672075
+ 1.9122e-05 0.0011396619706328
+ 1.9124e-05 0.0011244624506017
+ 1.9126e-05 0.00149067668003851
+ 1.9128e-05 0.00139770530910343
+ 1.913e-05 0.00151934359009671
+ 1.9132e-05 0.00182182078813353
+ 1.9134e-05 0.00195035375459851
+ 1.9136e-05 0.00163552612971264
+ 1.9138e-05 0.00179842106127453
+ 1.914e-05 0.0018653024954535
+ 1.9142e-05 0.00182771176760073
+ 1.9144e-05 0.00175248789570135
+ 1.9146e-05 0.00187454587425213
+ 1.9148e-05 0.00181702343475647
+ 1.915e-05 0.00182804280858657
+ 1.9152e-05 0.0015990828029509
+ 1.9154e-05 0.00153456283918384
+ 1.9156e-05 0.00128763294449201
+ 1.9158e-05 0.000999611333230793
+ 1.916e-05 0.000980099239915266
+ 1.9162e-05 0.000737727426844941
+ 1.9164e-05 0.000714345767884338
+ 1.9166e-05 0.000587647931500281
+ 1.9168e-05 0.000738256618978612
+ 1.917e-05 0.000541821478186491
+ 1.9172e-05 0.000606869734867882
+ 1.9174e-05 0.000174973353808513
+ 1.9176e-05 -8.77560979584416e-05
+ 1.9178e-05 -0.000354528733241229
+ 1.918e-05 -0.000373990927999974
+ 1.9182e-05 -0.000648875088270299
+ 1.9184e-05 -0.000419216941288633
+ 1.9186e-05 -0.000199019674950224
+ 1.9188e-05 -0.000487591398806147
+ 1.919e-05 -0.000378460261451021
+ 1.9192e-05 -0.000307438789238126
+ 1.9194e-05 -0.000282347252848972
+ 1.9196e-05 -0.000206418519305387
+ 1.9198e-05 -0.000422506328398665
+ 1.92e-05 -0.000252270452870122
+ 1.9202e-05 3.98941252158674e-06
+ 1.9204e-05 -0.000205664273985712
+ 1.9206e-05 -0.000303643867957187
+ 1.9208e-05 -0.000319403513444006
+ 1.921e-05 -0.0004377109333022
+ 1.9212e-05 -0.000625182033079043
+ 1.9214e-05 -0.00050651077318041
+ 1.9216e-05 -0.000771887897278904
+ 1.9218e-05 -0.00100627221282867
+ 1.922e-05 -0.00117062808929669
+ 1.9222e-05 -0.000671374342896071
+ 1.9224e-05 -0.000316658754054789
+ 1.9226e-05 -0.000142255592750028
+ 1.9228e-05 -1.48046289496651e-05
+ 1.923e-05 0.000216670107646683
+ 1.9232e-05 -2.44016331446465e-05
+ 1.9234e-05 -1.54233570388748e-06
+ 1.9236e-05 0.000428703595043017
+ 1.9238e-05 0.000497839556158188
+ 1.924e-05 0.000830869438272295
+ 1.9242e-05 0.00122850450159498
+ 1.9244e-05 0.000783361867620842
+ 1.9246e-05 0.000546031094481807
+ 1.9248e-05 0.000708247485784407
+ 1.925e-05 0.000874108015215934
+ 1.9252e-05 0.000898180044129264
+ 1.9254e-05 0.000668930438665183
+ 1.9256e-05 0.000698885818005723
+ 1.9258e-05 0.000594205565089835
+ 1.926e-05 0.000719532424642739
+ 1.9262e-05 0.000894333874239853
+ 1.9264e-05 0.0012132143461479
+ 1.9266e-05 0.00143948034633983
+ 1.9268e-05 0.00126039782996217
+ 1.927e-05 0.00126471845126748
+ 1.9272e-05 0.00117412909979451
+ 1.9274e-05 0.00142584912801349
+ 1.9276e-05 0.00143609080272608
+ 1.9278e-05 0.00103598473542545
+ 1.928e-05 0.000467610970316423
+ 1.9282e-05 0.000345430379430043
+ 1.9284e-05 0.000415326368697518
+ 1.9286e-05 0.000451969181352722
+ 1.9288e-05 0.000759547095702851
+ 1.929e-05 0.000474488255691896
+ 1.9292e-05 0.000167400900751662
+ 1.9294e-05 0.000622262666858812
+ 1.9296e-05 0.000412092144678083
+ 1.9298e-05 0.00058858126334765
+ 1.93e-05 0.000470516250934561
+ 1.9302e-05 0.000742891100152716
+ 1.9304e-05 0.000800905886357114
+ 1.9306e-05 0.000978839431299721
+ 1.9308e-05 0.00103966882951256
+ 1.931e-05 0.00111428609683959
+ 1.9312e-05 0.00124916480612418
+ 1.9314e-05 0.00145357148838203
+ 1.9316e-05 0.00165759908783625
+ 1.9318e-05 0.00172729023008294
+ 1.932e-05 0.00178297521997863
+ 1.9322e-05 0.00197270873307301
+ 1.9324e-05 0.00204993791171266
+ 1.9326e-05 0.00208900322477187
+ 1.9328e-05 0.00184435213326516
+ 1.933e-05 0.00204127379353577
+ 1.9332e-05 0.00204814573662049
+ 1.9334e-05 0.00193002324041434
+ 1.9336e-05 0.00156905271684152
+ 1.9338e-05 0.00163751549491973
+ 1.934e-05 0.00189037556343797
+ 1.9342e-05 0.00185107981469467
+ 1.9344e-05 0.00181404595528426
+ 1.9346e-05 0.00150376052590549
+ 1.9348e-05 0.00117383512738009
+ 1.935e-05 0.000836278913291972
+ 1.9352e-05 0.00110310973969905
+ 1.9354e-05 0.00113399436437305
+ 1.9356e-05 0.00113020287046532
+ 1.9358e-05 0.00109898639665809
+ 1.936e-05 0.00101249998728649
+ 1.9362e-05 0.000960339594846025
+ 1.9364e-05 0.00107704049670521
+ 1.9366e-05 0.00138511881381258
+ 1.9368e-05 0.0014537157708996
+ 1.937e-05 0.00133008824201707
+ 1.9372e-05 0.00126054055283824
+ 1.9374e-05 0.00149499847712626
+ 1.9376e-05 0.00127746269846543
+ 1.9378e-05 0.00149840255276248
+ 1.938e-05 0.0016193548799665
+ 1.9382e-05 0.00145545734668555
+ 1.9384e-05 0.00131867299236463
+ 1.9386e-05 0.00132749557991047
+ 1.9388e-05 0.000584899497143586
+ 1.939e-05 0.000268254393990747
+ 1.9392e-05 0.000334131000349683
+ 1.9394e-05 9.89371843767841e-05
+ 1.9396e-05 7.88024958015232e-05
+ 1.9398e-05 -5.47225679917174e-05
+ 1.94e-05 -3.10522812623472e-05
+ 1.9402e-05 0.000190628980492508
+ 1.9404e-05 0.000290446779235646
+ 1.9406e-05 0.00068227543673194
+ 1.9408e-05 0.000555317496500149
+ 1.941e-05 0.00059378245920624
+ 1.9412e-05 0.000439728010550538
+ 1.9414e-05 0.000655770778438995
+ 1.9416e-05 0.000570323112753423
+ 1.9418e-05 0.00097463297799363
+ 1.942e-05 0.00059644427630796
+ 1.9422e-05 0.000728032925442482
+ 1.9424e-05 0.000699265234704805
+ 1.9426e-05 0.000747426911774365
+ 1.9428e-05 0.00107092299931165
+ 1.943e-05 0.000900326304092935
+ 1.9432e-05 0.000975116302471762
+ 1.9434e-05 0.000826499507101342
+ 1.9436e-05 0.000641682582040277
+ 1.9438e-05 0.000520655948818152
+ 1.944e-05 0.000144280458432381
+ 1.9442e-05 0.000112913797343128
+ 1.9444e-05 -7.52865264823437e-05
+ 1.9446e-05 -0.000214997936437545
+ 1.9448e-05 -0.000428351793682198
+ 1.945e-05 0.000167356141848463
+ 1.9452e-05 0.000250468147979045
+ 1.9454e-05 0.000281795364849495
+ 1.9456e-05 0.000293887843603416
+ 1.9458e-05 0.000407402347286101
+ 1.946e-05 0.000467213237987261
+ 1.9462e-05 0.000738485744496018
+ 1.9464e-05 0.000741519201186328
+ 1.9466e-05 0.000497333867837472
+ 1.9468e-05 0.000437337276767338
+ 1.947e-05 0.00037079723068005
+ 1.9472e-05 0.000524927475303038
+ 1.9474e-05 0.000583361204546003
+ 1.9476e-05 0.000650602699869425
+ 1.9478e-05 0.000649760019320209
+ 1.948e-05 0.000998463407837784
+ 1.9482e-05 0.000672927471848245
+ 1.9484e-05 0.000504652418935145
+ 1.9486e-05 0.000490382737011612
+ 1.9488e-05 0.000493292013343075
+ 1.949e-05 0.000637335499479108
+ 1.9492e-05 0.000617726717301268
+ 1.9494e-05 0.000270399704809368
+ 1.9496e-05 6.05488411201999e-05
+ 1.9498e-05 -0.000247191994357101
+ 1.95e-05 -0.000287727103817733
+ 1.9502e-05 -9.53687734509157e-05
+ 1.9504e-05 0.000169997324744944
+ 1.9506e-05 -2.84539807567356e-05
+ 1.9508e-05 0.00066792417292772
+ 1.951e-05 0.000472614612479027
+ 1.9512e-05 0.000501816826930749
+ 1.9514e-05 0.000621213794342693
+ 1.9516e-05 0.00063981490848869
+ 1.9518e-05 0.000978558360128077
+ 1.952e-05 0.00105182686093797
+ 1.9522e-05 0.0010046845827045
+ 1.9524e-05 0.00101825989622437
+ 1.9526e-05 0.00107560992757538
+ 1.9528e-05 0.000764744678013342
+ 1.953e-05 0.000569310932702637
+ 1.9532e-05 0.0010369454693301
+ 1.9534e-05 0.00131256897176938
+ 1.9536e-05 0.00112745187826083
+ 1.9538e-05 0.00116612829585356
+ 1.954e-05 0.00108516270755285
+ 1.9542e-05 0.0012159509650483
+ 1.9544e-05 0.00113717085132548
+ 1.9546e-05 0.00105458883498795
+ 1.9548e-05 0.0011371228403775
+ 1.955e-05 0.00128807883704684
+ 1.9552e-05 0.00122664889506727
+ 1.9554e-05 0.0011950152993713
+ 1.9556e-05 0.00145182053748738
+ 1.9558e-05 0.0011704557325982
+ 1.956e-05 0.000956157244441071
+ 1.9562e-05 0.00101286629415381
+ 1.9564e-05 0.000777866879256758
+ 1.9566e-05 0.000852844448159558
+ 1.9568e-05 0.000772919505600471
+ 1.957e-05 0.000660591631869325
+ 1.9572e-05 0.000653494867121017
+ 1.9574e-05 0.000753995351380158
+ 1.9576e-05 0.000904483999049932
+ 1.9578e-05 0.000530331684572422
+ 1.958e-05 0.00037254873560123
+ 1.9582e-05 0.00067040804409559
+ 1.9584e-05 0.000857650172111474
+ 1.9586e-05 0.000349585470994604
+ 1.9588e-05 0.000181088363492424
+ 1.959e-05 0.000230260489799651
+ 1.9592e-05 0.000229960117972129
+ 1.9594e-05 0.00053823406229287
+ 1.9596e-05 0.000344719250117571
+ 1.9598e-05 7.00478424752601e-05
+ 1.96e-05 0.000299925763539967
+ 1.9602e-05 0.000304810175836332
+ 1.9604e-05 0.000499069202747291
+ 1.9606e-05 0.000382446190647399
+ 1.9608e-05 0.000567015306534874
+ 1.961e-05 0.00043694797964502
+ 1.9612e-05 3.53810923595991e-05
+ 1.9614e-05 0.000174048967002687
+ 1.9616e-05 0.000169659039233436
+ 1.9618e-05 0.000210541287555267
+ 1.962e-05 0.000372572862103051
+ 1.9622e-05 0.000151989253270337
+ 1.9624e-05 0.000264798290233056
+ 1.9626e-05 0.00021399312423742
+ 1.9628e-05 0.000256002849976438
+ 1.963e-05 0.000374046913562039
+ 1.9632e-05 0.000511231082804968
+ 1.9634e-05 0.000542350387852393
+ 1.9636e-05 0.000441306565007419
+ 1.9638e-05 0.000679758871548987
+ 1.964e-05 0.000906026465616672
+ 1.9642e-05 0.000801604931466978
+ 1.9644e-05 0.000770442978482813
+ 1.9646e-05 0.000895341326570053
+ 1.9648e-05 0.00111005459412208
+ 1.965e-05 0.00104440100634309
+ 1.9652e-05 0.000891736454820202
+ 1.9654e-05 0.000708499883538977
+ 1.9656e-05 0.000751662941697089
+ 1.9658e-05 0.000536039525347568
+ 1.966e-05 0.000365733966350973
+ 1.9662e-05 0.000377209261482513
+ 1.9664e-05 0.000358487660986038
+ 1.9666e-05 0.000250892405196439
+ 1.9668e-05 7.45461057603641e-05
+ 1.967e-05 0.000622379718870306
+ 1.9672e-05 0.000760594898883967
+ 1.9674e-05 0.000965250665497566
+ 1.9676e-05 0.00126859023424912
+ 1.9678e-05 0.000996789596072279
+ 1.968e-05 0.00109489720119891
+ 1.9682e-05 0.00126165566990509
+ 1.9684e-05 0.00145994702180849
+ 1.9686e-05 0.00133631953297872
+ 1.9688e-05 0.00141545897402154
+ 1.969e-05 0.00110308985228017
+ 1.9692e-05 0.00123167663935729
+ 1.9694e-05 0.00168340809798916
+ 1.9696e-05 0.00169097253525343
+ 1.9698e-05 0.00195087353022117
+ 1.97e-05 0.00220799801469998
+ 1.9702e-05 0.00221323418115528
+ 1.9704e-05 0.00207007812701499
+ 1.9706e-05 0.00216478744724148
+ 1.9708e-05 0.00232655907550038
+ 1.971e-05 0.00217980961363361
+ 1.9712e-05 0.00174881367873329
+ 1.9714e-05 0.00165981522911992
+ 1.9716e-05 0.00118809099908946
+ 1.9718e-05 0.00128179615537597
+ 1.972e-05 0.00153382784425622
+ 1.9722e-05 0.0012759184478517
+ 1.9724e-05 0.00111700051163271
+ 1.9726e-05 0.000995313209251023
+ 1.9728e-05 0.000825808012749313
+ 1.973e-05 0.0012819247304725
+ 1.9732e-05 0.0013519143415903
+ 1.9734e-05 0.00151490174404818
+ 1.9736e-05 0.0013011730312516
+ 1.9738e-05 0.00117558443177492
+ 1.974e-05 0.00130032510406361
+ 1.9742e-05 0.000952081236652721
+ 1.9744e-05 0.0007729369631078
+ 1.9746e-05 0.000704926631694541
+ 1.9748e-05 0.000996747014995785
+ 1.975e-05 0.000856597225584756
+ 1.9752e-05 0.00106827185047855
+ 1.9754e-05 0.000794714626386754
+ 1.9756e-05 0.000714612889299446
+ 1.9758e-05 0.000175214433044995
+ 1.976e-05 0.000186490757640259
+ 1.9762e-05 -0.000122312695924486
+ 1.9764e-05 1.2276053805041e-05
+ 1.9766e-05 0.000208057971957937
+ 1.9768e-05 0.0001525023759463
+ 1.977e-05 0.000256306676863921
+ 1.9772e-05 0.000343448231254725
+ 1.9774e-05 0.000113153271552566
+ 1.9776e-05 0.000153279844252664
+ 1.9778e-05 0.000162898665714529
+ 1.978e-05 0.000115312068082327
+ 1.9782e-05 -0.000106442323267548
+ 1.9784e-05 -0.000262812016792523
+ 1.9786e-05 -0.000354147601277111
+ 1.9788e-05 3.19015681407817e-05
+ 1.979e-05 0.000118002562919159
+ 1.9792e-05 -1.46370996143171e-05
+ 1.9794e-05 5.11048205263611e-05
+ 1.9796e-05 -0.000181176790418687
+ 1.9798e-05 0.000127681792702391
+ 1.98e-05 0.000333525355470115
+ 1.9802e-05 0.000861356572121499
+ 1.9804e-05 0.000943253780638153
+ 1.9806e-05 0.000958203281262147
+ 1.9808e-05 0.000861327997132919
+ 1.981e-05 0.000831714779853042
+ 1.9812e-05 0.000842612963212698
+ 1.9814e-05 0.0009286739505182
+ 1.9816e-05 0.000670544550011372
+ 1.9818e-05 0.000950354613229414
+ 1.982e-05 0.000923094610074467
+ 1.9822e-05 0.00104423872376776
+ 1.9824e-05 0.00100104013558722
+ 1.9826e-05 0.000889182896839038
+ 1.9828e-05 0.000856091755153668
+ 1.983e-05 0.000523403138186195
+ 1.9832e-05 0.000439334149973378
+ 1.9834e-05 0.00048701608939966
+ 1.9836e-05 0.000330491456280195
+ 1.9838e-05 0.000330666512118127
+ 1.984e-05 9.99466509296348e-05
+ 1.9842e-05 0.000130046181660111
+ 1.9844e-05 -0.000333848577957828
+ 1.9846e-05 -0.000279594268942069
+ 1.9848e-05 -0.00023678224811229
+ 1.985e-05 2.19546748347105e-05
+ 1.9852e-05 -1.36296371578324e-06
+ 1.9854e-05 -0.000159056150032071
+ 1.9856e-05 -0.000107817985766799
+ 1.9858e-05 -9.15910378230422e-05
+ 1.986e-05 -4.36128112026174e-05
+ 1.9862e-05 0.000107075988477594
+ 1.9864e-05 0.000217867356825698
+ 1.9866e-05 8.13249267031564e-05
+ 1.9868e-05 0.000125622100710258
+ 1.987e-05 0.000174110324141341
+ 1.9872e-05 0.00011681879476479
+ 1.9874e-05 0.000241267340294191
+ 1.9876e-05 0.000324990722909659
+ 1.9878e-05 0.000700452517712182
+ 1.988e-05 0.000389551001693973
+ 1.9882e-05 0.000590131549105584
+ 1.9884e-05 0.000202137656530466
+ 1.9886e-05 0.000224643481156716
+ 1.9888e-05 0.000170727027776682
+ 1.989e-05 -0.000256068096839223
+ 1.9892e-05 -0.000235234352392834
+ 1.9894e-05 -0.000282593617755365
+ 1.9896e-05 -0.000313884867787318
+ 1.9898e-05 -0.000262943138387277
+ 1.99e-05 -0.000337693296513201
+ 1.9902e-05 -0.000442314888882522
+ 1.9904e-05 -0.000514879920158498
+ 1.9906e-05 -0.000591140801893868
+ 1.9908e-05 -0.0005744776546623
+ 1.991e-05 -0.000389042645106556
+ 1.9912e-05 -0.000595631012573913
+ 1.9914e-05 -0.000615375144967282
+ 1.9916e-05 -0.000977111019454315
+ 1.9918e-05 -0.00138812347059921
+ 1.992e-05 -0.00129382410681555
+ 1.9922e-05 -0.00156301499051794
+ 1.9924e-05 -0.0019077961710316
+ 1.9926e-05 -0.0019292233693563
+ 1.9928e-05 -0.00204614306199564
+ 1.993e-05 -0.0022803451161923
+ 1.9932e-05 -0.00242469272138741
+ 1.9934e-05 -0.00245197902679893
+ 1.9936e-05 -0.00242776854995832
+ 1.9938e-05 -0.00238831161779008
+ 1.994e-05 -0.00232226050244199
+ 1.9942e-05 -0.00230701483636827
+ 1.9944e-05 -0.00226042447889671
+ 1.9946e-05 -0.00199756706909923
+ 1.9948e-05 -0.00179168650263893
+ 1.995e-05 -0.00166009550424648
+ 1.9952e-05 -0.00137414880337791
+ 1.9954e-05 -0.001601956911195
+ 1.9956e-05 -0.00168865189505597
+ 1.9958e-05 -0.00161596257050152
+ 1.996e-05 -0.00177928018079473
+ 1.9962e-05 -0.00154373126704873
+ 1.9964e-05 -0.00118096455582094
+ 1.9966e-05 -0.000845081933102381
+ 1.9968e-05 -0.000937400310898528
+ 1.997e-05 -0.000986466110631863
+ 1.9972e-05 -0.000952668766385286
+ 1.9974e-05 -0.00118567652611027
+ 1.9976e-05 -0.00141527651347349
+ 1.9978e-05 -0.00187346210582939
+ 1.998e-05 -0.00169635625091734
+ 1.9982e-05 -0.00187770962372023
+ 1.9984e-05 -0.00201306283947447
+ 1.9986e-05 -0.00183500606180111
+ 1.9988e-05 -0.00136715512624643
+ 1.999e-05 -0.00122136645304858
+ 1.9992e-05 -0.00102934172157477
+ 1.9994e-05 -0.00102661288856417
+ 1.9996e-05 -0.00106079791890114
+ 1.9998e-05 -0.000872948587415461
+ 2e-05 -0.00104157877675445
+ 2.0002e-05 -0.000943583388963179
+ 2.0004e-05 -0.000866776662785629
+ 2.0006e-05 -0.000866960300690216
+ 2.0008e-05 -0.000951869603005456
+ 2.001e-05 -0.000997612761145479
+ 2.0012e-05 -0.000789729066227527
+ 2.0014e-05 -0.000947219870156643
+ 2.0016e-05 -0.00132518259524933
+ 2.0018e-05 -0.00110502513137368
+ 2.002e-05 -0.00111578472982338
+ 2.0022e-05 -0.000899367600142837
+ 2.0024e-05 -0.00112276224786977
+ 2.0026e-05 -0.000688475324448395
+ 2.0028e-05 -0.00034785448079994
+ 2.003e-05 -0.000143164237937844
+ 2.0032e-05 -0.000110966319330357
+ 2.0034e-05 7.19140691545885e-05
+ 2.0036e-05 8.32723030598088e-05
+ 2.0038e-05 0.000385743737340957
+ 2.004e-05 -1.14469028662645e-05
+ 2.0042e-05 -0.000118268313249138
+ 2.0044e-05 0.000273783784503421
+ 2.0046e-05 0.00033990704373598
+ 2.0048e-05 0.000490600680034819
+ 2.005e-05 0.000501927173526167
+ 2.0052e-05 0.000729046537041506
+ 2.0054e-05 0.000984856924734559
+ 2.0056e-05 0.000968729322372904
+ 2.0058e-05 0.00095771344677223
+ 2.006e-05 0.000670098250483194
+ 2.0062e-05 0.000972252036017949
+ 2.0064e-05 0.000869148029091743
+ 2.0066e-05 0.000949661552836956
+ 2.0068e-05 0.000887707750091984
+ 2.007e-05 0.00106580293897529
+ 2.0072e-05 0.00133877074231387
+ 2.0074e-05 0.00151222083062294
+ 2.0076e-05 0.00150490463746009
+ 2.0078e-05 0.00159327355435053
+ 2.008e-05 0.00135709705938064
+ 2.0082e-05 0.00182483590754535
+ 2.0084e-05 0.00190378387397438
+ 2.0086e-05 0.00176954096833733
+ 2.0088e-05 0.0019289250581287
+ 2.009e-05 0.00214769635680628
+ 2.0092e-05 0.00223682266582153
+ 2.0094e-05 0.00234468206237998
+ 2.0096e-05 0.00245761339312926
+ 2.0098e-05 0.00246461615170416
+ 2.01e-05 0.00240217120130146
+ 2.0102e-05 0.00233107115221118
+ 2.0104e-05 0.00279703044838144
+ 2.0106e-05 0.00262597761770573
+ 2.0108e-05 0.00264906031189387
+ 2.011e-05 0.00285918604239848
+ 2.0112e-05 0.00281842573893899
+ 2.0114e-05 0.00325419011317076
+ 2.0116e-05 0.0030805929286765
+ 2.0118e-05 0.00301796761067021
+ 2.012e-05 0.00332604362494317
+ 2.0122e-05 0.0031157970372029
+ 2.0124e-05 0.00295103335924773
+ 2.0126e-05 0.0026261447385235
+ 2.0128e-05 0.00236801066204135
+ 2.013e-05 0.00215332439104933
+ 2.0132e-05 0.00234427613641533
+ 2.0134e-05 0.00209295780446304
+ 2.0136e-05 0.00209155577591379
+ 2.0138e-05 0.00196694475480726
+ 2.014e-05 0.00180200888329955
+ 2.0142e-05 0.00178243661372439
+ 2.0144e-05 0.00198669745831996
+ 2.0146e-05 0.0017824609662606
+ 2.0148e-05 0.00169936310021116
+ 2.015e-05 0.00134296180955947
+ 2.0152e-05 0.00116497278226758
+ 2.0154e-05 0.00111257013236214
+ 2.0156e-05 0.000925679927175456
+ 2.0158e-05 0.00123096893173026
+ 2.016e-05 0.0010022670605642
+ 2.0162e-05 0.00131425499986946
+ 2.0164e-05 0.0013602580684512
+ 2.0166e-05 0.00132728424117409
+ 2.0168e-05 0.00149147597303545
+ 2.017e-05 0.00171339701049702
+ 2.0172e-05 0.00162613286043296
+ 2.0174e-05 0.00150823529326778
+ 2.0176e-05 0.00105583545362818
+ 2.0178e-05 0.000775876917849018
+ 2.018e-05 0.000757653990324883
+ 2.0182e-05 0.000689624540196818
+ 2.0184e-05 0.000737929289400029
+ 2.0186e-05 0.000357366038183679
+ 2.0188e-05 0.000181683986493065
+ 2.019e-05 0.000321889087683765
+ 2.0192e-05 0.000108794745010292
+ 2.0194e-05 -6.58619827730741e-06
+ 2.0196e-05 -0.000214745808631678
+ 2.0198e-05 -0.000388967779648538
+ 2.02e-05 -0.000578266314583041
+ 2.0202e-05 -0.000658988128667513
+ 2.0204e-05 -0.000450454394672198
+ 2.0206e-05 -0.00010343319120958
+ 2.0208e-05 -0.000375108863487576
+ 2.021e-05 -0.00018746185098613
+ 2.0212e-05 -0.000124674781668223
+ 2.0214e-05 0.000434374606259402
+ 2.0216e-05 0.00035416524597644
+ 2.0218e-05 0.000167065221006936
+ 2.022e-05 0.000136213260584079
+ 2.0222e-05 -2.46019265472602e-05
+ 2.0224e-05 2.06465494568357e-05
+ 2.0226e-05 0.000226850909547577
+ 2.0228e-05 0.000103249925393091
+ 2.023e-05 8.81126876517285e-05
+ 2.0232e-05 -0.000221553706624661
+ 2.0234e-05 -0.000452243830290728
+ 2.0236e-05 -0.000657312581993363
+ 2.0238e-05 -0.00100929091657801
+ 2.024e-05 -0.0009332294702416
+ 2.0242e-05 -0.0012694929323919
+ 2.0244e-05 -0.00166557445893682
+ 2.0246e-05 -0.0014826679014919
+ 2.0248e-05 -0.000972952237119916
+ 2.025e-05 -0.00114317148927765
+ 2.0252e-05 -0.000951204020548799
+ 2.0254e-05 -0.000668223714267592
+ 2.0256e-05 -0.000739551808876408
+ 2.0258e-05 -0.000540053315702805
+ 2.026e-05 -0.000538798494204059
+ 2.0262e-05 -0.000849799688562997
+ 2.0264e-05 -0.00105866739288472
+ 2.0266e-05 -0.00114972347240285
+ 2.0268e-05 -0.000925113920140699
+ 2.027e-05 -0.00102067451846696
+ 2.0272e-05 -0.00158413894271446
+ 2.0274e-05 -0.00162258820990928
+ 2.0276e-05 -0.00166179317004107
+ 2.0278e-05 -0.00148875030286842
+ 2.028e-05 -0.00133971397112595
+ 2.0282e-05 -0.00158859896056448
+ 2.0284e-05 -0.00144734932138039
+ 2.0286e-05 -0.000987126457404793
+ 2.0288e-05 -0.000832739973044145
+ 2.029e-05 -0.000592326591652556
+ 2.0292e-05 -0.00066769157431311
+ 2.0294e-05 -0.000620923164664581
+ 2.0296e-05 -0.000442373485947834
+ 2.0298e-05 -0.000562611699814171
+ 2.03e-05 -0.00050338699771095
+ 2.0302e-05 -0.000517263762733277
+ 2.0304e-05 -0.00056254544598999
+ 2.0306e-05 -0.000465408773337329
+ 2.0308e-05 -0.000694472073978688
+ 2.031e-05 -0.000806046126783543
+ 2.0312e-05 -0.000824093787589498
+ 2.0314e-05 -0.00113094260040394
+ 2.0316e-05 -0.00132296941753681
+ 2.0318e-05 -0.00117956123954557
+ 2.032e-05 -0.00116981579565471
+ 2.0322e-05 -0.00120144756144115
+ 2.0324e-05 -0.00115037022598397
+ 2.0326e-05 -0.000884948849088581
+ 2.0328e-05 -0.001011370521827
+ 2.033e-05 -0.000911821701457444
+ 2.0332e-05 -0.000983281755899686
+ 2.0334e-05 -0.00103089367771058
+ 2.0336e-05 -0.00113360759600856
+ 2.0338e-05 -0.0014348945522441
+ 2.034e-05 -0.00151054686414486
+ 2.0342e-05 -0.00172242177172351
+ 2.0344e-05 -0.00183316171475192
+ 2.0346e-05 -0.00212527430813299
+ 2.0348e-05 -0.00177111397229625
+ 2.035e-05 -0.00160363352073226
+ 2.0352e-05 -0.00142764159412128
+ 2.0354e-05 -0.00112048777202396
+ 2.0356e-05 -0.00100774030567275
+ 2.0358e-05 -0.00090969554010229
+ 2.036e-05 -0.00115590458436954
+ 2.0362e-05 -0.000862683111223245
+ 2.0364e-05 -0.00058515734162318
+ 2.0366e-05 -0.000633019776033433
+ 2.0368e-05 -0.00069419178918448
+ 2.037e-05 -0.000845719716418018
+ 2.0372e-05 -0.000607809023502785
+ 2.0374e-05 -0.000333313589248654
+ 2.0376e-05 -0.000447953568570564
+ 2.0378e-05 -0.00035937238915765
+ 2.038e-05 -0.000450616578776427
+ 2.0382e-05 -0.000588849617254822
+ 2.0384e-05 -0.000567650304879397
+ 2.0386e-05 -0.000453076253888707
+ 2.0388e-05 -0.000262527299168471
+ 2.039e-05 -0.000565249863732216
+ 2.0392e-05 -0.000777660768785316
+ 2.0394e-05 -0.00102931890894071
+ 2.0396e-05 -0.00112244692616125
+ 2.0398e-05 -0.000720058395256104
+ 2.04e-05 -0.00116330056521996
+ 2.0402e-05 -0.000823001925445095
+ 2.0404e-05 -0.000735701448177955
+ 2.0406e-05 -0.000788224318372588
+ 2.0408e-05 -0.000439163408101318
+ 2.041e-05 -0.000138392874621438
+ 2.0412e-05 -8.65033212366743e-05
+ 2.0414e-05 0.000114175440849475
+ 2.0416e-05 0.000197151223209768
+ 2.0418e-05 0.000100217663355832
+ 2.042e-05 3.8461433391704e-05
+ 2.0422e-05 -0.000250530669204184
+ 2.0424e-05 -0.00026919537264855
+ 2.0426e-05 -0.000398984350552213
+ 2.0428e-05 -0.000330802697064887
+ 2.043e-05 -0.000291564677563033
+ 2.0432e-05 -0.000377025486005136
+ 2.0434e-05 -0.000345389758320809
+ 2.0436e-05 -0.000613591439347549
+ 2.0438e-05 -0.000260420844337511
+ 2.044e-05 -0.000608608725759307
+ 2.0442e-05 -0.000794039128984552
+ 2.0444e-05 -0.000769625156428822
+ 2.0446e-05 -0.000914454292293563
+ 2.0448e-05 -0.000751071796111315
+ 2.045e-05 -0.0010529716864071
+ 2.0452e-05 -0.000892190472015828
+ 2.0454e-05 -0.000808734662429074
+ 2.0456e-05 -0.000718358932791989
+ 2.0458e-05 -0.000715764843340327
+ 2.046e-05 -0.000799418662643932
+ 2.0462e-05 -0.00078086286544947
+ 2.0464e-05 -0.000694266063809125
+ 2.0466e-05 -0.000805260392003959
+ 2.0468e-05 -0.000897601879046817
+ 2.047e-05 -0.000703902432904108
+ 2.0472e-05 -0.000844511646020863
+ 2.0474e-05 -0.000898544356350995
+ 2.0476e-05 -0.00086136723679609
+ 2.0478e-05 -0.000616478634360536
+ 2.048e-05 -0.000624824086936567
+ 2.0482e-05 -0.000348050475891619
+ 2.0484e-05 -0.000461168577299101
+ 2.0486e-05 -0.000406891902508864
+ 2.0488e-05 -6.0063004888172e-05
+ 2.049e-05 -1.80858104488327e-05
+ 2.0492e-05 0.000163280778062283
+ 2.0494e-05 0.000111831454080026
+ 2.0496e-05 -4.40043688240466e-05
+ 2.0498e-05 -0.000119512370105151
+ 2.05e-05 0.000260742669142303
+ 2.0502e-05 0.00052718210165511
+ 2.0504e-05 0.000708592431956041
+ 2.0506e-05 0.000458906221711696
+ 2.0508e-05 0.000750829660583215
+ 2.051e-05 0.000428965051332689
+ 2.0512e-05 0.000533983646551044
+ 2.0514e-05 0.000839937588467838
+ 2.0516e-05 0.000743567878026041
+ 2.0518e-05 0.000707845200194074
+ 2.052e-05 0.000978794562204269
+ 2.0522e-05 0.000971849818918824
+ 2.0524e-05 0.000862668119557674
+ 2.0526e-05 0.00081388431334979
+ 2.0528e-05 0.000395264871932589
+ 2.053e-05 0.000440026869661071
+ 2.0532e-05 0.000232190671205788
+ 2.0534e-05 -4.66850323937256e-05
+ 2.0536e-05 0.000107221368131148
+ 2.0538e-05 -2.57490242258097e-06
+ 2.054e-05 -0.000198818503671478
+ 2.0542e-05 -0.000584117720542497
+ 2.0544e-05 -0.000569546936191373
+ 2.0546e-05 -0.000603157515197309
+ 2.0548e-05 -0.000649229484573232
+ 2.055e-05 -0.000517916614825679
+ 2.0552e-05 -0.000588984239223465
+ 2.0554e-05 -0.000669848904237356
+ 2.0556e-05 -0.000610686287928631
+ 2.0558e-05 -0.000456884934086881
+ 2.056e-05 -0.000962209441941115
+ 2.0562e-05 -0.000808288967062081
+ 2.0564e-05 -0.000815282216975914
+ 2.0566e-05 -0.000784237160569875
+ 2.0568e-05 -0.00104686729019432
+ 2.057e-05 -0.00103151816690683
+ 2.0572e-05 -0.0012509930877384
+ 2.0574e-05 -0.0012716815972561
+ 2.0576e-05 -0.00130010237463644
+ 2.0578e-05 -0.00144910796747743
+ 2.058e-05 -0.0012080494471448
+ 2.0582e-05 -0.00100963713026355
+ 2.0584e-05 -0.00136382229200101
+ 2.0586e-05 -0.00161730939570093
+ 2.0588e-05 -0.00145424934079252
+ 2.059e-05 -0.00130856098073869
+ 2.0592e-05 -0.00130673833012976
+ 2.0594e-05 -0.00120533929767644
+ 2.0596e-05 -0.00101854865062475
+ 2.0598e-05 -0.00120237288381673
+ 2.06e-05 -0.00131172980702761
+ 2.0602e-05 -0.00140288644070461
+ 2.0604e-05 -0.00152677752916991
+ 2.0606e-05 -0.00118693281653203
+ 2.0608e-05 -0.00134774659096542
+ 2.061e-05 -0.00121597006993558
+ 2.0612e-05 -0.00104583439592421
+ 2.0614e-05 -0.00123757890621879
+ 2.0616e-05 -0.000798827980212332
+ 2.0618e-05 -0.000715706428770714
+ 2.062e-05 -0.000784919915698728
+ 2.0622e-05 -0.000719670563408638
+ 2.0624e-05 -0.000921502702044121
+ 2.0626e-05 -0.000989344832117185
+ 2.0628e-05 -0.000947563402675497
+ 2.063e-05 -0.00105807366325863
+ 2.0632e-05 -0.00092308456476234
+ 2.0634e-05 -0.00066375959494757
+ 2.0636e-05 -0.000620589297451544
+ 2.0638e-05 -0.00108898232270129
+ 2.064e-05 -0.00119215387308092
+ 2.0642e-05 -0.00129176907869538
+ 2.0644e-05 -0.00127442001481865
+ 2.0646e-05 -0.000853641551975623
+ 2.0648e-05 -0.000999571292496421
+ 2.065e-05 -0.000972823778408746
+ 2.0652e-05 -0.00118547722032139
+ 2.0654e-05 -0.000805673658789853
+ 2.0656e-05 -0.000517449518123303
+ 2.0658e-05 -0.000236213900919631
+ 2.066e-05 -0.000150548143125607
+ 2.0662e-05 -7.15548185236911e-05
+ 2.0664e-05 -8.78216866780666e-05
+ 2.0666e-05 -0.000320959123069847
+ 2.0668e-05 -0.000447837779441448
+ 2.067e-05 -0.000590952246753729
+ 2.0672e-05 -0.000509529961594182
+ 2.0674e-05 -0.000425731757817686
+ 2.0676e-05 -0.000323862696542523
+ 2.0678e-05 -0.000316989170406755
+ 2.068e-05 -0.000416162797037477
+ 2.0682e-05 -0.000564575070325732
+ 2.0684e-05 -0.000560054085296401
+ 2.0686e-05 -0.000659121258026785
+ 2.0688e-05 -0.000655666468195462
+ 2.069e-05 -0.00104643606099525
+ 2.0692e-05 -0.000740160950623291
+ 2.0694e-05 -0.000711782153629533
+ 2.0696e-05 -0.000773830504080286
+ 2.0698e-05 -0.0010245191116217
+ 2.07e-05 -0.00117293739385299
+ 2.0702e-05 -0.00100596398704059
+ 2.0704e-05 -0.00114833161535302
+ 2.0706e-05 -0.0010317977903463
+ 2.0708e-05 -0.00113790023238251
+ 2.071e-05 -0.00119614667116969
+ 2.0712e-05 -0.00163230517351554
+ 2.0714e-05 -0.00146401336974546
+ 2.0716e-05 -0.00114815440375659
+ 2.0718e-05 -0.00118156582075792
+ 2.072e-05 -0.00139103094995916
+ 2.0722e-05 -0.0015271722525628
+ 2.0724e-05 -0.00165494662065509
+ 2.0726e-05 -0.00179993751505165
+ 2.0728e-05 -0.00148679834914928
+ 2.073e-05 -0.00141137478787721
+ 2.0732e-05 -0.00129131810139482
+ 2.0734e-05 -0.00148672095633832
+ 2.0736e-05 -0.00139868608704715
+ 2.0738e-05 -0.000976853776673276
+ 2.074e-05 -0.000773136614171115
+ 2.0742e-05 -0.000655513849167189
+ 2.0744e-05 -0.000865439088587211
+ 2.0746e-05 -0.000935236183690302
+ 2.0748e-05 -0.000535153592073634
+ 2.075e-05 -0.000902540961831177
+ 2.0752e-05 -0.00059445398003484
+ 2.0754e-05 -0.000628521563227669
+ 2.0756e-05 -0.000966450624238717
+ 2.0758e-05 -0.00111469598059179
+ 2.076e-05 -0.000993031819150831
+ 2.0762e-05 -0.000744746502841483
+ 2.0764e-05 -0.000535693370092564
+ 2.0766e-05 -0.000535224388427259
+ 2.0768e-05 -0.000526830506817114
+ 2.077e-05 -0.000463852364890579
+ 2.0772e-05 -0.000836639524576842
+ 2.0774e-05 -0.000643400402144587
+ 2.0776e-05 -0.000681087488447732
+ 2.0778e-05 -0.000699151935050016
+ 2.078e-05 -0.000636336462163919
+ 2.0782e-05 -0.000407321565087814
+ 2.0784e-05 -0.000436585951937009
+ 2.0786e-05 -0.000171141393779605
+ 2.0788e-05 -0.000156789516193565
+ 2.079e-05 -4.26025548359443e-06
+ 2.0792e-05 -0.000118003706390787
+ 2.0794e-05 -0.000283157454671416
+ 2.0796e-05 -0.000593386927249985
+ 2.0798e-05 -0.000477899670361298
+ 2.08e-05 -0.000682446828816544
+ 2.0802e-05 -0.000545586241308
+ 2.0804e-05 -0.000464885457896011
+ 2.0806e-05 -0.000670244234278561
+ 2.0808e-05 -0.000492066660655953
+ 2.081e-05 -0.00026800150437879
+ 2.0812e-05 -6.35467401317091e-05
+ 2.0814e-05 -0.000270446833473359
+ 2.0816e-05 -0.000368401708044828
+ 2.0818e-05 -0.00014038692125864
+ 2.082e-05 8.64893908425326e-05
+ 2.0822e-05 5.25514023269586e-05
+ 2.0824e-05 -0.000366653776048591
+ 2.0826e-05 -0.000110335326795175
+ 2.0828e-05 0.000128062076179971
+ 2.083e-05 0.000362502844241962
+ 2.0832e-05 0.000507111511934886
+ 2.0834e-05 0.000428722366033943
+ 2.0836e-05 0.000757182737490077
+ 2.0838e-05 0.000294433910818989
+ 2.084e-05 0.000409116984179565
+ 2.0842e-05 0.000413579728921029
+ 2.0844e-05 0.000475605140954358
+ 2.0846e-05 0.000160053751090696
+ 2.0848e-05 3.1986938733953e-05
+ 2.085e-05 0.000268333752628624
+ 2.0852e-05 0.000674999061527167
+ 2.0854e-05 0.00114329557787515
+ 2.0856e-05 0.00107376976165541
+ 2.0858e-05 0.000864367255456685
+ 2.086e-05 0.000667879273850386
+ 2.0862e-05 0.000879813326308521
+ 2.0864e-05 0.000755534808747829
+ 2.0866e-05 0.000469530908762299
+ 2.0868e-05 0.000112684616792557
+ 2.087e-05 -0.00013096738273854
+ 2.0872e-05 -0.00052425511802231
+ 2.0874e-05 -0.000389953634220791
+ 2.0876e-05 -0.000480815791617734
+ 2.0878e-05 -0.000632592177293477
+ 2.088e-05 -0.000492038357732299
+ 2.0882e-05 -0.000114037507214602
+ 2.0884e-05 -0.000106076686834496
+ 2.0886e-05 0.000146923539857023
+ 2.0888e-05 0.000305719603199181
+ 2.089e-05 0.000222483816801616
+ 2.0892e-05 0.000273211003715843
+ 2.0894e-05 0.000212030954620789
+ 2.0896e-05 3.63970766969257e-05
+ 2.0898e-05 -1.49979107678683e-06
+ 2.09e-05 0.000330231280405225
+ 2.0902e-05 0.000241441117664562
+ 2.0904e-05 0.000200065574743311
+ 2.0906e-05 0.000283576510938442
+ 2.0908e-05 0.000521521717857526
+ 2.091e-05 0.000746599342681254
+ 2.0912e-05 0.00075452736227938
+ 2.0914e-05 0.000813818240828675
+ 2.0916e-05 0.000724978178709086
+ 2.0918e-05 0.0008093269445015
+ 2.092e-05 0.00084251485552005
+ 2.0922e-05 0.000864218664949413
+ 2.0924e-05 0.000667745999921704
+ 2.0926e-05 0.000724144258718914
+ 2.0928e-05 0.000487650396289895
+ 2.093e-05 0.000388975159934016
+ 2.0932e-05 0.000413924194606511
+ 2.0934e-05 0.000581830693678027
+ 2.0936e-05 0.000456274375185045
+ 2.0938e-05 0.000416678294329288
+ 2.094e-05 0.000397324293179892
+ 2.0942e-05 0.000626824062740126
+ 2.0944e-05 0.000840906306949589
+ 2.0946e-05 0.000339380590637521
+ 2.0948e-05 3.87879791749221e-05
+ 2.095e-05 0.000200093493221283
+ 2.0952e-05 0.000496989654194265
+ 2.0954e-05 0.000437545321719143
+ 2.0956e-05 0.000445857313412278
+ 2.0958e-05 0.000562556396602862
+ 2.096e-05 0.000756645703419645
+ 2.0962e-05 0.000842112190707386
+ 2.0964e-05 0.00102648911469559
+ 2.0966e-05 0.00104244007019457
+ 2.0968e-05 0.000830203287565302
+ 2.097e-05 0.000951745771300517
+ 2.0972e-05 0.000657481447223841
+ 2.0974e-05 0.000495046681467833
+ 2.0976e-05 0.000382414628766531
+ 2.0978e-05 0.000172453957410044
+ 2.098e-05 0.000399662731526041
+ 2.0982e-05 0.000236125994107283
+ 2.0984e-05 0.000396220400555955
+ 2.0986e-05 -5.27719535813377e-05
+ 2.0988e-05 5.52885357181461e-05
+ 2.099e-05 0.000371586101589966
+ 2.0992e-05 0.000574532606563892
+ 2.0994e-05 0.000551440007590549
+ 2.0996e-05 0.000500984805858134
+ 2.0998e-05 0.000694566141274359
+ 2.1e-05 0.000696435982883876
+ 2.1002e-05 0.000596970173155788
+ 2.1004e-05 0.00078730054900925
+ 2.1006e-05 0.000917453278956395
+ 2.1008e-05 0.0008715486660034
+ 2.101e-05 0.000751203671338576
+ 2.1012e-05 0.000403837731728252
+ 2.1014e-05 0.000341053609040756
+ 2.1016e-05 0.000460303275146807
+ 2.1018e-05 0.000489733184496757
+ 2.102e-05 0.000459962753661825
+ 2.1022e-05 0.000636430514698145
+ 2.1024e-05 0.000409972810108193
+ 2.1026e-05 0.000312726458644973
+ 2.1028e-05 0.000390213234876682
+ 2.103e-05 0.000494211752432234
+ 2.1032e-05 0.000391514497778984
+ 2.1034e-05 0.000500456561423609
+ 2.1036e-05 0.000541239609397339
+ 2.1038e-05 0.000310141719673721
+ 2.104e-05 3.66201195626729e-05
+ 2.1042e-05 1.18842039906238e-05
+ 2.1044e-05 -9.52440812581718e-05
+ 2.1046e-05 -0.000106381658698491
+ 2.1048e-05 -0.000131221050655328
+ 2.105e-05 8.49545490433111e-05
+ 2.1052e-05 -1.04454763646734e-05
+ 2.1054e-05 0.000232148635061923
+ 2.1056e-05 0.0002975734613268
+ 2.1058e-05 -6.27536672750665e-05
+ 2.106e-05 2.67885235535508e-05
+ 2.1062e-05 -0.000400622850944097
+ 2.1064e-05 4.00943958560612e-05
+ 2.1066e-05 0.000285504828810656
+ 2.1068e-05 0.000458921024258028
+ 2.107e-05 0.000231740031055283
+ 2.1072e-05 0.000207740412049638
+ 2.1074e-05 4.21123197397985e-05
+ 2.1076e-05 0.000264455423173242
+ 2.1078e-05 0.000381298299581858
+ 2.108e-05 0.000228403437442669
+ 2.1082e-05 4.38915642396073e-05
+ 2.1084e-05 5.17533475907748e-05
+ 2.1086e-05 0.000168391140605813
+ 2.1088e-05 0.00022992194472258
+ 2.109e-05 0.000324770323451874
+ 2.1092e-05 0.000235404299432784
+ 2.1094e-05 7.75137075979114e-05
+ 2.1096e-05 0.000178108379574826
+ 2.1098e-05 0.000149137490433355
+ 2.11e-05 -0.000154786478410144
+ 2.1102e-05 -0.0004273096978104
+ 2.1104e-05 -0.000403221103845665
+ 2.1106e-05 -0.000338381946828387
+ 2.1108e-05 -0.000370812000012823
+ 2.111e-05 -0.000491897908933115
+ 2.1112e-05 -0.000395603220276683
+ 2.1114e-05 -0.000334292524166307
+ 2.1116e-05 -0.000102145874129575
+ 2.1118e-05 -0.000344272339363443
+ 2.112e-05 -0.000262746721722118
+ 2.1122e-05 -0.000434163017184895
+ 2.1124e-05 -0.000666925597619661
+ 2.1126e-05 -0.000738581710864099
+ 2.1128e-05 -0.000445757624893598
+ 2.113e-05 -0.000417671388854897
+ 2.1132e-05 -0.000345851150276156
+ 2.1134e-05 -0.000272179454389086
+ 2.1136e-05 -0.000328109841037626
+ 2.1138e-05 -0.000197239657094389
+ 2.114e-05 -0.000161294359829235
+ 2.1142e-05 -0.000213606410288476
+ 2.1144e-05 -0.000241010679859393
+ 2.1146e-05 -0.00024448834192825
+ 2.1148e-05 -0.000555989987108021
+ 2.115e-05 -0.00102858553406865
+ 2.1152e-05 -0.000745208979248114
+ 2.1154e-05 -0.000716666330457056
+ 2.1156e-05 -0.000257667136655338
+ 2.1158e-05 -0.000460927720731538
+ 2.116e-05 -0.000107453835850328
+ 2.1162e-05 0.000191038957586933
+ 2.1164e-05 0.000117971157302067
+ 2.1166e-05 9.30003465513241e-05
+ 2.1168e-05 -2.36727291360398e-05
+ 2.117e-05 -3.84025334432505e-05
+ 2.1172e-05 -4.42699899523549e-05
+ 2.1174e-05 -0.000517963716537835
+ 2.1176e-05 -0.000525043255022458
+ 2.1178e-05 -0.000528140593121074
+ 2.118e-05 -0.000566602237977281
+ 2.1182e-05 -0.00030692495148377
+ 2.1184e-05 -0.000253309674259124
+ 2.1186e-05 -5.49468348087133e-05
+ 2.1188e-05 9.91208442340762e-05
+ 2.119e-05 -2.45680726745776e-05
+ 2.1192e-05 -5.11956711987333e-05
+ 2.1194e-05 0.000172776061348793
+ 2.1196e-05 0.00014253835495154
+ 2.1198e-05 0.000204597474486594
+ 2.12e-05 0.000131855750791004
+ 2.1202e-05 -2.79738946568617e-06
+ 2.1204e-05 -0.000252707248202826
+ 2.1206e-05 -0.000138078845725592
+ 2.1208e-05 2.37562683857972e-05
+ 2.121e-05 0.000175236552447164
+ 2.1212e-05 0.000151680670405906
+ 2.1214e-05 6.04070666918249e-05
+ 2.1216e-05 -6.15263186034476e-05
+ 2.1218e-05 0.000151936366388921
+ 2.122e-05 9.70072796123557e-05
+ 2.1222e-05 7.01782089068524e-05
+ 2.1224e-05 -3.29494070873487e-05
+ 2.1226e-05 -8.6380822165508e-05
+ 2.1228e-05 -0.000181968973001581
+ 2.123e-05 -0.000328364754109104
+ 2.1232e-05 -0.000961615741702859
+ 2.1234e-05 -0.000868851900032725
+ 2.1236e-05 -0.000751913889915674
+ 2.1238e-05 -0.000695193181020865
+ 2.124e-05 -0.000666336454527694
+ 2.1242e-05 -0.000596230967864693
+ 2.1244e-05 -0.000694732923382411
+ 2.1246e-05 -0.000831478173085946
+ 2.1248e-05 -0.000536747285416921
+ 2.125e-05 -0.000430673382286402
+ 2.1252e-05 -0.000344833933333435
+ 2.1254e-05 -8.25588260258031e-06
+ 2.1256e-05 6.09766061863923e-05
+ 2.1258e-05 -0.000160150327681199
+ 2.126e-05 -0.000295586030793514
+ 2.1262e-05 -0.000152764262272707
+ 2.1264e-05 0.000185266851183814
+ 2.1266e-05 -2.28672282355372e-05
+ 2.1268e-05 -8.42182160906858e-05
+ 2.127e-05 -0.000272721967220141
+ 2.1272e-05 -0.000289620233915
+ 2.1274e-05 -0.000226413518447608
+ 2.1276e-05 -0.000256361610374395
+ 2.1278e-05 -0.000362421406574749
+ 2.128e-05 -0.000574317910299872
+ 2.1282e-05 -0.00067116218940206
+ 2.1284e-05 -0.000570423912586497
+ 2.1286e-05 -0.000543228036031315
+ 2.1288e-05 -0.000733178492803764
+ 2.129e-05 -0.000404108058489116
+ 2.1292e-05 -0.000404786726293814
+ 2.1294e-05 -0.000659908631872251
+ 2.1296e-05 -0.000775727675979772
+ 2.1298e-05 -0.000760695445540834
+ 2.13e-05 -0.000860608857180458
+ 2.1302e-05 -0.00100757864590426
+ 2.1304e-05 -0.00115231730620156
+ 2.1306e-05 -0.00111374708805782
+ 2.1308e-05 -0.000937552510080799
+ 2.131e-05 -0.000945138912778817
+ 2.1312e-05 -0.000828044478276449
+ 2.1314e-05 -0.000895185859267269
+ 2.1316e-05 -0.00115049915915207
+ 2.1318e-05 -0.00110873115525823
+ 2.132e-05 -0.00118243258342033
+ 2.1322e-05 -0.00116914601094599
+ 2.1324e-05 -0.00124384043874625
+ 2.1326e-05 -0.00121408279569372
+ 2.1328e-05 -0.000863257861827277
+ 2.133e-05 -0.00071364512241503
+ 2.1332e-05 -0.000524468308388617
+ 2.1334e-05 -0.000312933131517046
+ 2.1336e-05 -0.000341929992074068
+ 2.1338e-05 -7.56362365815441e-05
+ 2.134e-05 -0.000342386235476608
+ 2.1342e-05 -0.000421727106476035
+ 2.1344e-05 -0.000582586609782169
+ 2.1346e-05 -0.000634127431656231
+ 2.1348e-05 -0.000244433370939963
+ 2.135e-05 -0.000407832156584819
+ 2.1352e-05 -0.000323229169933529
+ 2.1354e-05 -0.000707504535794626
+ 2.1356e-05 -0.000746026045199353
+ 2.1358e-05 -0.000639483800967965
+ 2.136e-05 6.26431875981071e-06
+ 2.1362e-05 -0.000102593578545567
+ 2.1364e-05 -0.000163301514314254
+ 2.1366e-05 -0.000325554285969858
+ 2.1368e-05 -0.000375214919032623
+ 2.137e-05 -0.000253007993926705
+ 2.1372e-05 -0.000431644750076344
+ 2.1374e-05 -0.000455909772694417
+ 2.1376e-05 -0.000368432787689344
+ 2.1378e-05 -0.000384633854255528
+ 2.138e-05 -0.000629044134010714
+ 2.1382e-05 -0.000383449776994576
+ 2.1384e-05 -0.000549241022707738
+ 2.1386e-05 -0.00076130709084042
+ 2.1388e-05 -0.000667526830752266
+ 2.139e-05 -0.0006356538785046
+ 2.1392e-05 -0.000710517079890931
+ 2.1394e-05 -0.00057530531033743
+ 2.1396e-05 -0.000622705970257102
+ 2.1398e-05 -0.000634689899704764
+ 2.14e-05 -0.000634576670885458
+ 2.1402e-05 -0.000878148258947288
+ 2.1404e-05 -0.000767859377000916
+ 2.1406e-05 -0.000975988984861891
+ 2.1408e-05 -0.000721906415781026
+ 2.141e-05 -0.00108538065324051
+ 2.1412e-05 -0.00101103620484732
+ 2.1414e-05 -0.00112132975923052
+ 2.1416e-05 -0.00113144571606671
+ 2.1418e-05 -0.00149223294866237
+ 2.142e-05 -0.0013244634543032
+ 2.1422e-05 -0.00136587941003677
+ 2.1424e-05 -0.00139147402969104
+ 2.1426e-05 -0.00117421077893306
+ 2.1428e-05 -0.00116734035673829
+ 2.143e-05 -0.00111239026193024
+ 2.1432e-05 -0.00119075494353623
+ 2.1434e-05 -0.00116149489287307
+ 2.1436e-05 -0.00109167102130531
+ 2.1438e-05 -0.000793793438430409
+ 2.144e-05 -0.00123418093942102
+ 2.1442e-05 -0.00111577859107177
+ 2.1444e-05 -0.00127217602662029
+ 2.1446e-05 -0.00124886533541705
+ 2.1448e-05 -0.0012521455220327
+ 2.145e-05 -0.000800791311019754
+ 2.1452e-05 -0.000947778610133366
+ 2.1454e-05 -0.000959551516619135
+ 2.1456e-05 -0.000891240051238064
+ 2.1458e-05 -0.000654412252188542
+ 2.146e-05 -0.000539161257579311
+ 2.1462e-05 -0.000662410575830997
+ 2.1464e-05 -0.000472083621428137
+ 2.1466e-05 -0.000568977570758284
+ 2.1468e-05 -0.000610610840298768
+ 2.147e-05 -0.000680026964748735
+ 2.1472e-05 -0.000965252276007796
+ 2.1474e-05 -0.00144516659839956
+ 2.1476e-05 -0.0017545863528093
+ 2.1478e-05 -0.00150296295371594
+ 2.148e-05 -0.00166279441859275
+ 2.1482e-05 -0.00200835650318506
+ 2.1484e-05 -0.00198967461343925
+ 2.1486e-05 -0.00185500278533385
+ 2.1488e-05 -0.0016499242694754
+ 2.149e-05 -0.0018583360271173
+ 2.1492e-05 -0.00198720250873149
+ 2.1494e-05 -0.00204718094923893
+ 2.1496e-05 -0.00176857773024015
+ 2.1498e-05 -0.00182186427189874
+ 2.15e-05 -0.00182872388920758
+ 2.1502e-05 -0.0017084787873615
+ 2.1504e-05 -0.00150211728060338
+ 2.1506e-05 -0.00158657401578553
+ 2.1508e-05 -0.00189911585167182
+ 2.151e-05 -0.00169962732644665
+ 2.1512e-05 -0.00170359138874634
+ 2.1514e-05 -0.00152678403776732
+ 2.1516e-05 -0.00143370515436024
+ 2.1518e-05 -0.00138957691768853
+ 2.152e-05 -0.00111268292332484
+ 2.1522e-05 -0.000983816334848046
+ 2.1524e-05 -0.00105496563594506
+ 2.1526e-05 -0.00102055519005352
+ 2.1528e-05 -0.00114837302918225
+ 2.153e-05 -0.00118121776015318
+ 2.1532e-05 -0.00139734909175646
+ 2.1534e-05 -0.00115629874161796
+ 2.1536e-05 -0.0010941438078464
+ 2.1538e-05 -0.00132546052107853
+ 2.154e-05 -0.00154144625186774
+ 2.1542e-05 -0.00150696335615914
+ 2.1544e-05 -0.00141021589126533
+ 2.1546e-05 -0.00168198064494179
+ 2.1548e-05 -0.00139784675533906
+ 2.155e-05 -0.00151487978425577
+ 2.1552e-05 -0.00114856762081851
+ 2.1554e-05 -0.00122052852613202
+ 2.1556e-05 -0.00132848374146669
+ 2.1558e-05 -0.001569139236933
+ 2.156e-05 -0.0016571657047419
+ 2.1562e-05 -0.00147133791648328
+ 2.1564e-05 -0.001307948299175
+ 2.1566e-05 -0.00118993653430455
+ 2.1568e-05 -0.00140777390722539
+ 2.157e-05 -0.00148036477633877
+ 2.1572e-05 -0.00104910636102886
+ 2.1574e-05 -0.000474317809371363
+ 2.1576e-05 -0.000345109210097308
+ 2.1578e-05 -6.397371766285e-05
+ 2.158e-05 0.000115802727836316
+ 2.1582e-05 0.000144294948013569
+ 2.1584e-05 2.71525194862801e-06
+ 2.1586e-05 4.60157240601831e-05
+ 2.1588e-05 -4.28658387033749e-05
+ 2.159e-05 -0.000203485912745042
+ 2.1592e-05 -0.000343442666025253
+ 2.1594e-05 -7.68470426255779e-05
+ 2.1596e-05 0.00016354283064738
+ 2.1598e-05 -0.000109617399948714
+ 2.16e-05 -3.24288362522361e-05
+ 2.1602e-05 0.000364492602423871
+ 2.1604e-05 1.50644880471512e-05
+ 2.1606e-05 -0.000146932893211814
+ 2.1608e-05 -0.000244123984645801
+ 2.161e-05 -0.000349509759410709
+ 2.1612e-05 -0.000256970580164556
+ 2.1614e-05 -0.000225559592545102
+ 2.1616e-05 3.73396938395332e-07
+ 2.1618e-05 -7.12269109706785e-05
+ 2.162e-05 -0.000192479931137313
+ 2.1622e-05 0.000123021785231654
+ 2.1624e-05 0.000160107657708796
+ 2.1626e-05 0.000114759469835714
+ 2.1628e-05 0.000103401211313033
+ 2.163e-05 -4.60244090905128e-05
+ 2.1632e-05 0.000109981999044345
+ 2.1634e-05 0.000290394304166752
+ 2.1636e-05 9.38221450506654e-05
+ 2.1638e-05 0.000182647630890176
+ 2.164e-05 0.000153259671824132
+ 2.1642e-05 3.73957316227663e-05
+ 2.1644e-05 7.13453666542703e-05
+ 2.1646e-05 -3.63124018599759e-06
+ 2.1648e-05 0.000101887944298105
+ 2.165e-05 -9.1209833501236e-05
+ 2.1652e-05 0.000217763816521782
+ 2.1654e-05 8.72348260896348e-05
+ 2.1656e-05 0.000253270518793325
+ 2.1658e-05 -3.05908055920923e-05
+ 2.166e-05 -8.22105443925582e-05
+ 2.1662e-05 -0.000174198093600172
+ 2.1664e-05 1.35661147430055e-05
+ 2.1666e-05 -0.000299537932169051
+ 2.1668e-05 -0.000535252790272824
+ 2.167e-05 -0.000711124153812667
+ 2.1672e-05 -0.00061571734307366
+ 2.1674e-05 -0.000756407525645422
+ 2.1676e-05 -0.0007638033253641
+ 2.1678e-05 -0.000735187487216378
+ 2.168e-05 -0.00118669485810495
+ 2.1682e-05 -0.000681095885430534
+ 2.1684e-05 -0.000294270303033156
+ 2.1686e-05 -0.000664900759236651
+ 2.1688e-05 -0.000829580882167924
+ 2.169e-05 -0.000896049345063287
+ 2.1692e-05 -0.000977138996932369
+ 2.1694e-05 -0.00128234326781206
+ 2.1696e-05 -0.00146330088280375
+ 2.1698e-05 -0.00164083649413873
+ 2.17e-05 -0.00142746725699609
+ 2.1702e-05 -0.00119966553514815
+ 2.1704e-05 -0.0011545361506416
+ 2.1706e-05 -0.00101166702637103
+ 2.1708e-05 -0.0011415084137364
+ 2.171e-05 -0.000951882212033251
+ 2.1712e-05 -0.00108688378989587
+ 2.1714e-05 -0.00148878601975722
+ 2.1716e-05 -0.00142586847957753
+ 2.1718e-05 -0.0013050770855903
+ 2.172e-05 -0.00103636572888741
+ 2.1722e-05 -0.00107606758100672
+ 2.1724e-05 -0.000710303136720578
+ 2.1726e-05 -0.000736546969280998
+ 2.1728e-05 -0.000729021766440239
+ 2.173e-05 -0.000655056314605569
+ 2.1732e-05 -0.000803294198029592
+ 2.1734e-05 -0.000619349452242367
+ 2.1736e-05 -0.000758908217621895
+ 2.1738e-05 -0.000395947218106999
+ 2.174e-05 -0.000210416086443539
+ 2.1742e-05 -0.000427579411097189
+ 2.1744e-05 -0.000474189869931377
+ 2.1746e-05 -0.000442395434643573
+ 2.1748e-05 -0.000766605104782365
+ 2.175e-05 -0.000325498709638667
+ 2.1752e-05 -0.000184675788652763
+ 2.1754e-05 0.000190269291787447
+ 2.1756e-05 0.000111455526236177
+ 2.1758e-05 0.000573029444783562
+ 2.176e-05 0.000469134089109478
+ 2.1762e-05 0.000310986338406742
+ 2.1764e-05 0.000376825475113305
+ 2.1766e-05 0.000397546962892065
+ 2.1768e-05 0.000403302839637603
+ 2.177e-05 0.000357660345589102
+ 2.1772e-05 0.000530833740279676
+ 2.1774e-05 0.00067180057466357
+ 2.1776e-05 0.000518836589932579
+ 2.1778e-05 0.000661177835430957
+ 2.178e-05 0.000579024654491135
+ 2.1782e-05 0.000285421254611091
+ 2.1784e-05 6.68390876376735e-05
+ 2.1786e-05 0.0001474064383038
+ 2.1788e-05 0.000237530583201993
+ 2.179e-05 0.000460426343429786
+ 2.1792e-05 0.000442591719373477
+ 2.1794e-05 0.000412257003088159
+ 2.1796e-05 0.000137016832418916
+ 2.1798e-05 -5.96931790066976e-05
+ 2.18e-05 -7.4588008908733e-05
+ 2.1802e-05 -0.000512640327324633
+ 2.1804e-05 -0.000459662323199733
+ 2.1806e-05 -0.000308881647331514
+ 2.1808e-05 -0.000154822993726553
+ 2.181e-05 -7.55741662689681e-05
+ 2.1812e-05 -0.000101164317817377
+ 2.1814e-05 -9.45673489516776e-05
+ 2.1816e-05 -0.000194475229314978
+ 2.1818e-05 9.66236780416855e-05
+ 2.182e-05 0.000218063865679566
+ 2.1822e-05 0.00022214381510047
+ 2.1824e-05 -2.89915548481438e-05
+ 2.1826e-05 -0.000194006798553455
+ 2.1828e-05 1.28092617721536e-05
+ 2.183e-05 0.000390498896536327
+ 2.1832e-05 0.000472957643760284
+ 2.1834e-05 0.000626094366843693
+ 2.1836e-05 0.000760832455537853
+ 2.1838e-05 0.000619123225759302
+ 2.184e-05 0.000823603976861609
+ 2.1842e-05 0.00126671129977724
+ 2.1844e-05 0.00140971509180597
+ 2.1846e-05 0.00128953870723296
+ 2.1848e-05 0.0011527101982914
+ 2.185e-05 0.000989216657862388
+ 2.1852e-05 0.000673425883748485
+ 2.1854e-05 0.000376030997856321
+ 2.1856e-05 0.000258169132139437
+ 2.1858e-05 0.000252097483634346
+ 2.186e-05 0.000182620575478404
+ 2.1862e-05 0.000374481288084749
+ 2.1864e-05 0.000428278793591536
+ 2.1866e-05 0.000351178573306522
+ 2.1868e-05 0.000458645851033887
+ 2.187e-05 0.000425190546634159
+ 2.1872e-05 0.000395648012624688
+ 2.1874e-05 0.000230264820958425
+ 2.1876e-05 0.000283570640378552
+ 2.1878e-05 -8.80897965700457e-05
+ 2.188e-05 -0.000350530164100284
+ 2.1882e-05 -0.000525929095894724
+ 2.1884e-05 -0.000595482981981296
+ 2.1886e-05 -0.000420994524158994
+ 2.1888e-05 -0.000296405950776614
+ 2.189e-05 -0.000390878055068554
+ 2.1892e-05 0.000221418312947602
+ 2.1894e-05 1.83205929282523e-05
+ 2.1896e-05 -0.000169776857099973
+ 2.1898e-05 -0.000553364905922322
+ 2.19e-05 -0.000621938225502205
+ 2.1902e-05 -0.000555791139636363
+ 2.1904e-05 -0.000272997455644548
+ 2.1906e-05 -0.000185436694466951
+ 2.1908e-05 -0.000282382454937691
+ 2.191e-05 -0.000152956638044837
+ 2.1912e-05 -0.00051953776294623
+ 2.1914e-05 -0.000630479384888764
+ 2.1916e-05 -0.000742060108902837
+ 2.1918e-05 -0.000272367275091389
+ 2.192e-05 -0.000453263121053377
+ 2.1922e-05 -0.000579860368857519
+ 2.1924e-05 -0.000635520768711022
+ 2.1926e-05 -0.000706357617704852
+ 2.1928e-05 -0.000479890633842052
+ 2.193e-05 -0.000735619577597831
+ 2.1932e-05 -0.000562142747310248
+ 2.1934e-05 -0.000788508995473818
+ 2.1936e-05 -0.000929043011668101
+ 2.1938e-05 -0.000811268425416033
+ 2.194e-05 -0.00100057610815481
+ 2.1942e-05 -0.00068630624298189
+ 2.1944e-05 -0.000493462497032858
+ 2.1946e-05 -0.000239984712467874
+ 2.1948e-05 -0.000211800348227229
+ 2.195e-05 -0.000298711354821999
+ 2.1952e-05 -0.0003849469794483
+ 2.1954e-05 -3.11223507716606e-05
+ 2.1956e-05 8.02333163368967e-05
+ 2.1958e-05 -0.000144618870670733
+ 2.196e-05 -0.000207612848572133
+ 2.1962e-05 -0.000295002172411813
+ 2.1964e-05 -0.000292147837851605
+ 2.1966e-05 -0.000447498552456574
+ 2.1968e-05 -0.000395833909959961
+ 2.197e-05 -0.000248209337134361
+ 2.1972e-05 -0.000274537907184221
+ 2.1974e-05 -0.000289787024834065
+ 2.1976e-05 -0.000158098000910698
+ 2.1978e-05 0.000197400275233122
+ 2.198e-05 -3.28134133889777e-05
+ 2.1982e-05 -0.000343897472807177
+ 2.1984e-05 -0.000620343344082903
+ 2.1986e-05 -0.000459397203890454
+ 2.1988e-05 -0.000550994737416981
+ 2.199e-05 -0.000121855017213611
+ 2.1992e-05 -0.000200295703950136
+ 2.1994e-05 -0.000220040463659497
+ 2.1996e-05 -0.000409044169615313
+ 2.1998e-05 -0.00041097641003533
+ 2.2e-05 -0.000395111448785082
+ 2.2002e-05 -0.000530240353060745
+ 2.2004e-05 -0.000238922718226621
+ 2.2006e-05 -0.000193154979729065
+ 2.2008e-05 -0.00034223883209959
+ 2.201e-05 -0.000339292935036104
+ 2.2012e-05 -0.000491549621110093
+ 2.2014e-05 -0.000445740273480022
+ 2.2016e-05 -0.000557905394318142
+ 2.2018e-05 -0.000348996857162967
+ 2.202e-05 -0.00033531942251687
+ 2.2022e-05 -0.000254178020988911
+ 2.2024e-05 -0.000665335326217116
+ 2.2026e-05 -0.000867282456784037
+ 2.2028e-05 -0.000688089841718867
+ 2.203e-05 -0.000622279698394336
+ 2.2032e-05 -0.000711608282671672
+ 2.2034e-05 -0.000246350057263971
+ 2.2036e-05 -0.000409209012338529
+ 2.2038e-05 -0.000742034427212065
+ 2.204e-05 -0.000883918174740649
+ 2.2042e-05 -0.000958960261856113
+ 2.2044e-05 -0.000830953814201934
+ 2.2046e-05 -0.000555716423562259
+ 2.2048e-05 -0.000506092274274096
+ 2.205e-05 -0.000760013416867579
+ 2.2052e-05 -0.000794567427175695
+ 2.2054e-05 -0.000735967884457545
+ 2.2056e-05 -0.000709826495589334
+ 2.2058e-05 -0.00044596510361293
+ 2.206e-05 -0.000389366007079559
+ 2.2062e-05 -0.000573664695479805
+ 2.2064e-05 -0.000901508463895713
+ 2.2066e-05 -0.00092352148538335
+ 2.2068e-05 -0.000954797198026009
+ 2.207e-05 -0.000948811486441331
+ 2.2072e-05 -0.000842507415904822
+ 2.2074e-05 -0.000728546337559088
+ 2.2076e-05 -0.00043170804592377
+ 2.2078e-05 -0.000471104662797545
+ 2.208e-05 -0.000307908302877844
+ 2.2082e-05 -0.000281061121292469
+ 2.2084e-05 -0.000483091748291651
+ 2.2086e-05 -0.000299066256617789
+ 2.2088e-05 -0.000673748585311148
+ 2.209e-05 -0.000812611312429949
+ 2.2092e-05 -0.000600488845415372
+ 2.2094e-05 -0.000590472051116513
+ 2.2096e-05 -0.000175798843887942
+ 2.2098e-05 -0.000125969435684672
+ 2.21e-05 -0.000342533389417825
+ 2.2102e-05 -2.43345274510097e-05
+ 2.2104e-05 -0.000292591356410639
+ 2.2106e-05 -0.000505183848741379
+ 2.2108e-05 -0.000597755390594387
+ 2.211e-05 -0.000771402229608589
+ 2.2112e-05 -0.000668307831080369
+ 2.2114e-05 -0.000614235634037906
+ 2.2116e-05 -0.000752524602143863
+ 2.2118e-05 -0.000488193948752678
+ 2.212e-05 -0.000668095983855524
+ 2.2122e-05 -0.000463354190997255
+ 2.2124e-05 -0.000389891137958415
+ 2.2126e-05 -0.000350771479709182
+ 2.2128e-05 -0.000450387638945987
+ 2.213e-05 -0.000548287413215433
+ 2.2132e-05 -0.000240305273523916
+ 2.2134e-05 -8.58331750766433e-05
+ 2.2136e-05 -0.000143020772123291
+ 2.2138e-05 -0.000530207258073493
+ 2.214e-05 -0.000247761306019361
+ 2.2142e-05 -3.58945248569471e-05
+ 2.2144e-05 -5.25331003697694e-05
+ 2.2146e-05 4.11751085645053e-05
+ 2.2148e-05 0.000223544741255074
+ 2.215e-05 0.000292878539930659
+ 2.2152e-05 0.000332712676523583
+ 2.2154e-05 0.000792315392294688
+ 2.2156e-05 0.000817305189297869
+ 2.2158e-05 0.00104644244987206
+ 2.216e-05 0.000762306697587642
+ 2.2162e-05 0.00109471103092679
+ 2.2164e-05 0.00104974140486586
+ 2.2166e-05 0.00111093846911096
+ 2.2168e-05 0.00121514089687732
+ 2.217e-05 0.00108150337579004
+ 2.2172e-05 0.001135296816616
+ 2.2174e-05 0.00106633876160227
+ 2.2176e-05 0.000756623066151335
+ 2.2178e-05 0.00112724858854135
+ 2.218e-05 0.000647024353637981
+ 2.2182e-05 0.000502138720760817
+ 2.2184e-05 0.000622148658680514
+ 2.2186e-05 0.000847286530763411
+ 2.2188e-05 0.000784275176080563
+ 2.219e-05 0.000999055859363138
+ 2.2192e-05 0.000830270376510979
+ 2.2194e-05 0.000981532296013673
+ 2.2196e-05 0.00132858405079531
+ 2.2198e-05 0.00150621828149729
+ 2.22e-05 0.00172894279337313
+ 2.2202e-05 0.0015638421652199
+ 2.2204e-05 0.00122260864248609
+ 2.2206e-05 0.00127385276860121
+ 2.2208e-05 0.00158774899059071
+ 2.221e-05 0.00168948359487673
+ 2.2212e-05 0.00148694909362045
+ 2.2214e-05 0.00137874628213461
+ 2.2216e-05 0.00128198438970658
+ 2.2218e-05 0.00101073387038379
+ 2.222e-05 0.00103008059911733
+ 2.2222e-05 0.00114259445549294
+ 2.2224e-05 0.000994278603976276
+ 2.2226e-05 0.00115012284740763
+ 2.2228e-05 0.00116359059051558
+ 2.223e-05 0.00114024573518051
+ 2.2232e-05 0.00089177102018293
+ 2.2234e-05 0.000925193061601631
+ 2.2236e-05 0.000984298272170942
+ 2.2238e-05 0.00103858600828648
+ 2.224e-05 0.00120438422500106
+ 2.2242e-05 0.00123725353349341
+ 2.2244e-05 0.000946337745864556
+ 2.2246e-05 0.000971190911340129
+ 2.2248e-05 0.000829879909246668
+ 2.225e-05 0.000750249333737526
+ 2.2252e-05 0.000468936301511163
+ 2.2254e-05 0.000362890907800788
+ 2.2256e-05 0.000732822922739312
+ 2.2258e-05 0.000718616518738878
+ 2.226e-05 0.000607363675765799
+ 2.2262e-05 0.000773461107792638
+ 2.2264e-05 0.000627325220043408
+ 2.2266e-05 0.000663633871035721
+ 2.2268e-05 0.00079185908815725
+ 2.227e-05 0.000525308037766477
+ 2.2272e-05 0.0011453002190958
+ 2.2274e-05 0.00118694934451587
+ 2.2276e-05 0.00119267801550412
+ 2.2278e-05 0.00119775677818143
+ 2.228e-05 0.00140099140772675
+ 2.2282e-05 0.00137719962935534
+ 2.2284e-05 0.00143210348254459
+ 2.2286e-05 0.00149235846127754
+ 2.2288e-05 0.00159565284701593
+ 2.229e-05 0.00161087280689289
+ 2.2292e-05 0.001561232701259
+ 2.2294e-05 0.00163833133098383
+ 2.2296e-05 0.00172955197302159
+ 2.2298e-05 0.00165257918771066
+ 2.23e-05 0.00135521021632507
+ 2.2302e-05 0.00145260185793417
+ 2.2304e-05 0.00130671235592448
+ 2.2306e-05 0.00152377371384111
+ 2.2308e-05 0.00131305303639719
+ 2.231e-05 0.00124417010533075
+ 2.2312e-05 0.00151547029020825
+ 2.2314e-05 0.00111118163244705
+ 2.2316e-05 0.000933208800801112
+ 2.2318e-05 0.00070913278969634
+ 2.232e-05 0.000551762644298143
+ 2.2322e-05 0.000477271756458017
+ 2.2324e-05 0.00051031579704313
+ 2.2326e-05 0.000496316611790492
+ 2.2328e-05 0.00052606412076652
+ 2.233e-05 0.000293644845780531
+ 2.2332e-05 0.000100826867004721
+ 2.2334e-05 4.90184825958374e-05
+ 2.2336e-05 0.000170170129725843
+ 2.2338e-05 0.000213654026602672
+ 2.234e-05 0.000551016514994608
+ 2.2342e-05 0.000489104139733383
+ 2.2344e-05 0.000851636108895645
+ 2.2346e-05 0.000622441755402761
+ 2.2348e-05 0.000636875004302793
+ 2.235e-05 0.000199916271521582
+ 2.2352e-05 0.0001819662359463
+ 2.2354e-05 0.000380254496530685
+ 2.2356e-05 0.000322589152566179
+ 2.2358e-05 0.000201158093422644
+ 2.236e-05 -0.00010519843543365
+ 2.2362e-05 0.000200714002411556
+ 2.2364e-05 0.000315535896591743
+ 2.2366e-05 0.00022039547225072
+ 2.2368e-05 0.000444560178648864
+ 2.237e-05 0.000486502463393866
+ 2.2372e-05 0.000283585104686943
+ 2.2374e-05 0.000246719863929701
+ 2.2376e-05 -0.00015260655392575
+ 2.2378e-05 -0.000102988340189392
+ 2.238e-05 -0.000258445085587175
+ 2.2382e-05 1.89842717771616e-06
+ 2.2384e-05 0.000164361544120036
+ 2.2386e-05 0.000137198497440478
+ 2.2388e-05 0.000269371067405569
+ 2.239e-05 0.000322279833248243
+ 2.2392e-05 0.000421926669885021
+ 2.2394e-05 0.00036592325347123
+ 2.2396e-05 0.00051260806251717
+ 2.2398e-05 0.00019957837186983
+ 2.24e-05 0.000252166427108196
+ 2.2402e-05 0.000541460887829351
+ 2.2404e-05 0.000153260254035044
+ 2.2406e-05 4.80833391828084e-05
+ 2.2408e-05 -0.000162338450685118
+ 2.241e-05 -0.000125394683398105
+ 2.2412e-05 -0.000171748031581145
+ 2.2414e-05 -0.000390583261723917
+ 2.2416e-05 -0.000402507313839328
+ 2.2418e-05 -0.000217639014664061
+ 2.242e-05 -9.36490754276528e-06
+ 2.2422e-05 -9.40680371150308e-05
+ 2.2424e-05 -2.89028606612248e-05
+ 2.2426e-05 -1.09477458133395e-05
+ 2.2428e-05 0.000394245639360404
+ 2.243e-05 0.000897774883416809
+ 2.2432e-05 0.00131758417681666
+ 2.2434e-05 0.00148897430177977
+ 2.2436e-05 0.00150506672082357
+ 2.2438e-05 0.00173286486984096
+ 2.244e-05 0.00190704228853441
+ 2.2442e-05 0.00178038872570396
+ 2.2444e-05 0.00163228822311503
+ 2.2446e-05 0.00168703850583744
+ 2.2448e-05 0.00166634274266745
+ 2.245e-05 0.00154819151122068
+ 2.2452e-05 0.00134848159164055
+ 2.2454e-05 0.00128229714553026
+ 2.2456e-05 0.00127734736730972
+ 2.2458e-05 0.00132329526985768
+ 2.246e-05 0.00115442781417734
+ 2.2462e-05 0.00128666683737993
+ 2.2464e-05 0.00126479427347812
+ 2.2466e-05 0.000985971489180779
+ 2.2468e-05 0.000943565558036523
+ 2.247e-05 0.000723967452136226
+ 2.2472e-05 0.000866508584550463
+ 2.2474e-05 0.000603694953733835
+ 2.2476e-05 0.000491039628271343
+ 2.2478e-05 0.000536861604079537
+ 2.248e-05 0.000571252641619432
+ 2.2482e-05 0.000881236362761696
+ 2.2484e-05 0.00101796021225523
+ 2.2486e-05 0.00097765055743899
+ 2.2488e-05 0.00095777892482423
+ 2.249e-05 0.00104597430729579
+ 2.2492e-05 0.000859404746578872
+ 2.2494e-05 0.000302867797249468
+ 2.2496e-05 0.00023868138113014
+ 2.2498e-05 0.000248125928154539
+ 2.25e-05 0.000275976532088927
+ 2.2502e-05 0.000504272244593686
+ 2.2504e-05 0.000646201530980253
+ 2.2506e-05 0.000509158335643579
+ 2.2508e-05 0.000818919675236616
+ 2.251e-05 0.00104214357771145
+ 2.2512e-05 0.000890789598715307
+ 2.2514e-05 0.000892800644856709
+ 2.2516e-05 0.000735183835478126
+ 2.2518e-05 0.0010018292486463
+ 2.252e-05 0.00105128462642733
+ 2.2522e-05 0.00119192911732704
+ 2.2524e-05 0.0011270167356097
+ 2.2526e-05 0.00105626117723971
+ 2.2528e-05 0.00125211194412722
+ 2.253e-05 0.00104101841065358
+ 2.2532e-05 0.00102659703374947
+ 2.2534e-05 0.00124118214704733
+ 2.2536e-05 0.00149275874879555
+ 2.2538e-05 0.00158151749694431
+ 2.254e-05 0.00135830109780657
+ 2.2542e-05 0.00125221196992293
+ 2.2544e-05 0.00122642875755493
+ 2.2546e-05 0.00119080414374884
+ 2.2548e-05 0.00118561104297129
+ 2.255e-05 0.00109726536010126
+ 2.2552e-05 0.000913976374881989
+ 2.2554e-05 0.000477221560657719
+ 2.2556e-05 0.000299837492843184
+ 2.2558e-05 0.000141766653087727
+ 2.256e-05 0.000415231270212598
+ 2.2562e-05 0.000393925694491821
+ 2.2564e-05 0.000756095185100441
+ 2.2566e-05 0.000904918077012334
+ 2.2568e-05 0.000558369282024158
+ 2.257e-05 0.000760182809158745
+ 2.2572e-05 0.000690363901481217
+ 2.2574e-05 0.000742909806326156
+ 2.2576e-05 0.000792026103750386
+ 2.2578e-05 0.000633785789634683
+ 2.258e-05 0.000610626331403029
+ 2.2582e-05 0.000589873655458739
+ 2.2584e-05 0.000495266194845416
+ 2.2586e-05 0.000211227181296797
+ 2.2588e-05 0.000408596158093169
+ 2.259e-05 0.000578819102964543
+ 2.2592e-05 0.000919477847201838
+ 2.2594e-05 0.000774475323399111
+ 2.2596e-05 0.000709350322974239
+ 2.2598e-05 0.000652186285655925
+ 2.26e-05 0.000417384620491598
+ 2.2602e-05 0.000109621963798262
+ 2.2604e-05 0.000214860337155698
+ 2.2606e-05 0.000268821626937887
+ 2.2608e-05 -0.000175774689469202
+ 2.261e-05 -6.38645786575247e-05
+ 2.2612e-05 -5.46672747276958e-06
+ 2.2614e-05 0.00023813827500354
+ 2.2616e-05 0.000251433658412623
+ 2.2618e-05 0.000274068561837056
+ 2.262e-05 0.000602573143469065
+ 2.2622e-05 0.000791300785238042
+ 2.2624e-05 0.000399076105150527
+ 2.2626e-05 0.000544922914570369
+ 2.2628e-05 0.000680483069757932
+ 2.263e-05 0.000823339271474055
+ 2.2632e-05 0.000778313797110542
+ 2.2634e-05 0.000727271866512671
+ 2.2636e-05 0.000871706116466666
+ 2.2638e-05 0.000811526722462347
+ 2.264e-05 0.000960214748040954
+ 2.2642e-05 0.000838983450811195
+ 2.2644e-05 0.000631385547146216
+ 2.2646e-05 0.000538970293164474
+ 2.2648e-05 0.000652365124198405
+ 2.265e-05 0.00067982846142159
+ 2.2652e-05 0.000595124149490301
+ 2.2654e-05 0.000601740398912184
+ 2.2656e-05 0.0006353421328289
+ 2.2658e-05 0.000903374665115385
+ 2.266e-05 0.000680025695806628
+ 2.2662e-05 0.000418405040338617
+ 2.2664e-05 0.000133027091229572
+ 2.2666e-05 5.13827327977865e-05
+ 2.2668e-05 -4.43654178683536e-06
+ 2.267e-05 -0.000390693345853715
+ 2.2672e-05 -0.00057979710490071
+ 2.2674e-05 -0.000436662763656664
+ 2.2676e-05 -0.000543039548869921
+ 2.2678e-05 -0.000438209491202044
+ 2.268e-05 -0.000425415812810126
+ 2.2682e-05 -0.000241212996002228
+ 2.2684e-05 -0.000450976301534616
+ 2.2686e-05 -0.000583817607595428
+ 2.2688e-05 -0.000911968405591971
+ 2.269e-05 -0.000912971077300717
+ 2.2692e-05 -0.000707010190311903
+ 2.2694e-05 -0.000825996943442038
+ 2.2696e-05 -0.00111888447576391
+ 2.2698e-05 -0.00102325226581376
+ 2.27e-05 -0.000832597301584726
+ 2.2702e-05 -0.000729930389932891
+ 2.2704e-05 -0.000613569255873607
+ 2.2706e-05 -0.000538717996902292
+ 2.2708e-05 -0.000522365102010024
+ 2.271e-05 -0.000426085764501177
+ 2.2712e-05 -0.000328732846727205
+ 2.2714e-05 -0.000615195669378991
+ 2.2716e-05 -0.000483454885349687
+ 2.2718e-05 -0.00021865630142084
+ 2.272e-05 -0.000274496955870336
+ 2.2722e-05 -2.32959117536558e-06
+ 2.2724e-05 0.000179135486364693
+ 2.2726e-05 6.63834206554529e-05
+ 2.2728e-05 2.95330203432135e-05
+ 2.273e-05 -0.000281147084029001
+ 2.2732e-05 -0.000519501508932066
+ 2.2734e-05 -0.000527486570552783
+ 2.2736e-05 -0.000881979870907637
+ 2.2738e-05 -0.00058596152308756
+ 2.274e-05 -0.000532339662108637
+ 2.2742e-05 -0.000610375777848551
+ 2.2744e-05 -0.00028612651954588
+ 2.2746e-05 -0.000299106100459512
+ 2.2748e-05 -0.000488650330524398
+ 2.275e-05 -0.000466423543537218
+ 2.2752e-05 -0.000337915949254929
+ 2.2754e-05 -0.000579956138006543
+ 2.2756e-05 -0.000619506091519603
+ 2.2758e-05 -0.000633618260300693
+ 2.276e-05 -0.000435512862056837
+ 2.2762e-05 -0.000215165689128788
+ 2.2764e-05 -0.000181353493922676
+ 2.2766e-05 -0.000303363168732668
+ 2.2768e-05 -0.000361488729065807
+ 2.277e-05 -0.000244860516199039
+ 2.2772e-05 -0.000498622861408954
+ 2.2774e-05 -0.000474697651724285
+ 2.2776e-05 -0.000795061670280202
+ 2.2778e-05 -0.000793182366960186
+ 2.278e-05 -0.000987417083358032
+ 2.2782e-05 -0.000790911409887393
+ 2.2784e-05 -0.0010113522255657
+ 2.2786e-05 -0.000848826534248683
+ 2.2788e-05 -0.000604344404828407
+ 2.279e-05 -0.000573310685974464
+ 2.2792e-05 -0.000627818069426432
+ 2.2794e-05 -0.000814637586577533
+ 2.2796e-05 -0.00104005887666299
+ 2.2798e-05 -0.00104036055429536
+ 2.28e-05 -0.00100242411010281
+ 2.2802e-05 -0.000710618162349241
+ 2.2804e-05 -0.000741022885748315
+ 2.2806e-05 -0.00106226335660987
+ 2.2808e-05 -0.00122719490197876
+ 2.281e-05 -0.00155140751375616
+ 2.2812e-05 -0.00157115940582303
+ 2.2814e-05 -0.00159730412311221
+ 2.2816e-05 -0.00144500080153596
+ 2.2818e-05 -0.00146185817618344
+ 2.282e-05 -0.00120963009133601
+ 2.2822e-05 -0.00111437762946053
+ 2.2824e-05 -0.0011243214618092
+ 2.2826e-05 -0.00108563302588521
+ 2.2828e-05 -0.00132305339552647
+ 2.283e-05 -0.00134060106265785
+ 2.2832e-05 -0.00125473193457429
+ 2.2834e-05 -0.0012461586594166
+ 2.2836e-05 -0.00120000234489465
+ 2.2838e-05 -0.00113231777898149
+ 2.284e-05 -0.00102959304582518
+ 2.2842e-05 -0.0007744690531499
+ 2.2844e-05 -0.00102708422428974
+ 2.2846e-05 -0.000855643104667925
+ 2.2848e-05 -0.000765606409972436
+ 2.285e-05 -0.000965455101373583
+ 2.2852e-05 -0.000869004512133198
+ 2.2854e-05 -0.000630952733122815
+ 2.2856e-05 -0.000917247524004661
+ 2.2858e-05 -0.000886439795463041
+ 2.286e-05 -0.000682799916621855
+ 2.2862e-05 -0.000601541193525395
+ 2.2864e-05 -0.000585223087565613
+ 2.2866e-05 -8.32107147960388e-05
+ 2.2868e-05 6.26481110840636e-05
+ 2.287e-05 3.00486261655125e-05
+ 2.2872e-05 0.000114710890426793
+ 2.2874e-05 -0.00019065742692694
+ 2.2876e-05 -0.00017172941736218
+ 2.2878e-05 -0.000424060174273952
+ 2.288e-05 -0.000644470709966892
+ 2.2882e-05 -0.000676835824617549
+ 2.2884e-05 -0.000107328418773922
+ 2.2886e-05 -0.000204452327825769
+ 2.2888e-05 -0.000160751740896331
+ 2.289e-05 -0.000343248165163374
+ 2.2892e-05 -8.04510013924745e-05
+ 2.2894e-05 0.000163361331192366
+ 2.2896e-05 0.000343796795711303
+ 2.2898e-05 0.000370229656786106
+ 2.29e-05 0.000222407968382191
+ 2.2902e-05 0.00016654156996068
+ 2.2904e-05 0.000207445807886929
+ 2.2906e-05 0.000281977439964319
+ 2.2908e-05 0.000165284838288392
+ 2.291e-05 0.000201355000896863
+ 2.2912e-05 6.1131483839657e-05
+ 2.2914e-05 0.000169350048312379
+ 2.2916e-05 0.000144562974181971
+ 2.2918e-05 -3.20426953665739e-05
+ 2.292e-05 0.000158955347038759
+ 2.2922e-05 0.00052801960739933
+ 2.2924e-05 0.000733312915252092
+ 2.2926e-05 0.000743733193802467
+ 2.2928e-05 0.000893610424810537
+ 2.293e-05 0.00113365762535849
+ 2.2932e-05 0.00107252909399659
+ 2.2934e-05 0.00106587837459897
+ 2.2936e-05 0.00107921951754974
+ 2.2938e-05 0.0013096159210802
+ 2.294e-05 0.00163975921306456
+ 2.2942e-05 0.0015983682784192
+ 2.2944e-05 0.00134244042086568
+ 2.2946e-05 0.000784350690548764
+ 2.2948e-05 0.000639496723394263
+ 2.295e-05 0.000474618195552577
+ 2.2952e-05 4.7313494270917e-05
+ 2.2954e-05 -0.000265976920147046
+ 2.2956e-05 -0.000686774567718685
+ 2.2958e-05 -0.000659442678969167
+ 2.296e-05 -0.000759596316034441
+ 2.2962e-05 -0.000709204977854717
+ 2.2964e-05 -0.00056382617857766
+ 2.2966e-05 -0.000532915815627202
+ 2.2968e-05 -0.000737124774352422
+ 2.297e-05 -0.000877157489513506
+ 2.2972e-05 -0.000932177926100933
+ 2.2974e-05 -0.000735772745275296
+ 2.2976e-05 -0.00086202044768614
+ 2.2978e-05 -0.00115581046281296
+ 2.298e-05 -0.00123436762336029
+ 2.2982e-05 -0.000961779776771914
+ 2.2984e-05 -0.000983155766699738
+ 2.2986e-05 -0.000804576118850259
+ 2.2988e-05 -0.000826463880038521
+ 2.299e-05 -0.000837020953251022
+ 2.2992e-05 -0.00036808062817146
+ 2.2994e-05 -0.000798020787332719
+ 2.2996e-05 -0.000476670424961604
+ 2.2998e-05 -0.000197499190209721
+ 2.3e-05 2.14158357323018e-05
+ 2.3002e-05 7.18485510215423e-05
+ 2.3004e-05 -0.000257978729198037
+ 2.3006e-05 -0.000324053327676877
+ 2.3008e-05 -0.000406800814907291
+ 2.301e-05 -0.000407324719207645
+ 2.3012e-05 -0.000242872952136398
+ 2.3014e-05 -0.00029669299232278
+ 2.3016e-05 -0.000455829200286622
+ 2.3018e-05 -0.000746079833467277
+ 2.302e-05 -0.000484347332204138
+ 2.3022e-05 -0.00058714551600941
+ 2.3024e-05 -0.000331978738744972
+ 2.3026e-05 -0.00035106701344099
+ 2.3028e-05 -0.000589464731217702
+ 2.303e-05 -0.000313098481534533
+ 2.3032e-05 -0.000201910271727946
+ 2.3034e-05 -0.000150738371146889
+ 2.3036e-05 -0.000141096302207527
+ 2.3038e-05 -0.000392107636364566
+ 2.304e-05 -0.000504478414496103
+ 2.3042e-05 -0.000372120121788737
+ 2.3044e-05 -0.000291669224554624
+ 2.3046e-05 -0.000437083544074225
+ 2.3048e-05 -0.000477271237484289
+ 2.305e-05 -0.000734620110429735
+ 2.3052e-05 -0.000369327488469099
+ 2.3054e-05 -0.00038065691746543
+ 2.3056e-05 -2.58678330811442e-05
+ 2.3058e-05 0.000324440975433877
+ 2.306e-05 0.000498664380185934
+ 2.3062e-05 0.000241537253619742
+ 2.3064e-05 0.00011948605477163
+ 2.3066e-05 0.000224974783838656
+ 2.3068e-05 0.000317977245458897
+ 2.307e-05 0.00034042889361915
+ 2.3072e-05 0.000419497149384488
+ 2.3074e-05 0.000313444445477982
+ 2.3076e-05 0.0004671215154184
+ 2.3078e-05 0.000471360191243988
+ 2.308e-05 0.000797619010789713
+ 2.3082e-05 0.000637753117543498
+ 2.3084e-05 0.000332480071555124
+ 2.3086e-05 0.000404142082590968
+ 2.3088e-05 0.000212471233649404
+ 2.309e-05 -1.4603492379657e-05
+ 2.3092e-05 -0.00021113892508597
+ 2.3094e-05 -0.000151723294467044
+ 2.3096e-05 -0.000567673434662742
+ 2.3098e-05 -0.000596820421346222
+ 2.31e-05 -0.000692208422311731
+ 2.3102e-05 -0.000431967448864801
+ 2.3104e-05 -0.000560936544156349
+ 2.3106e-05 -0.000471514338492363
+ 2.3108e-05 -0.000332068712342986
+ 2.311e-05 -2.10382213924761e-05
+ 2.3112e-05 -4.98572456362108e-05
+ 2.3114e-05 -0.000318246927941364
+ 2.3116e-05 -0.000248251158667401
+ 2.3118e-05 -0.000436813298703743
+ 2.312e-05 -0.000446274562450153
+ 2.3122e-05 -0.000225797994492156
+ 2.3124e-05 1.18210445770278e-06
+ 2.3126e-05 0.000364270294281197
+ 2.3128e-05 0.000329357092864855
+ 2.313e-05 0.000255676309034108
+ 2.3132e-05 0.000344619630451595
+ 2.3134e-05 7.70273430333691e-05
+ 2.3136e-05 0.000291403892693109
+ 2.3138e-05 0.000442462787225781
+ 2.314e-05 0.000392701052962035
+ 2.3142e-05 0.000186912807825498
+ 2.3144e-05 0.000133613857791825
+ 2.3146e-05 0.000180651631512073
+ 2.3148e-05 -0.000153301589860159
+ 2.315e-05 -0.000139235097707958
+ 2.3152e-05 -0.000341955353339018
+ 2.3154e-05 -0.000532149262627001
+ 2.3156e-05 -0.00051093406450143
+ 2.3158e-05 -0.000710713671421905
+ 2.316e-05 -0.000455928025694063
+ 2.3162e-05 -0.000217720929394498
+ 2.3164e-05 -0.000364892520918858
+ 2.3166e-05 -4.65482243476273e-05
+ 2.3168e-05 6.07603968581868e-05
+ 2.317e-05 0.000100181094157149
+ 2.3172e-05 0.0003708765931871
+ 2.3174e-05 0.000233222577614024
+ 2.3176e-05 5.13153411238501e-06
+ 2.3178e-05 -0.00011902032460331
+ 2.318e-05 -0.000296233326366997
+ 2.3182e-05 -0.000175952539101436
+ 2.3184e-05 -0.000321850802840979
+ 2.3186e-05 -0.000388321294530316
+ 2.3188e-05 -0.000151658961884076
+ 2.319e-05 -0.000206714573842274
+ 2.3192e-05 -0.000132848403501692
+ 2.3194e-05 -0.000136597488657572
+ 2.3196e-05 -2.18022233958965e-05
+ 2.3198e-05 0.000344145140996655
+ 2.32e-05 0.000361308653047457
+ 2.3202e-05 0.000481713408180411
+ 2.3204e-05 0.000191801302249633
+ 2.3206e-05 0.000160544855233422
+ 2.3208e-05 0.000643510366805909
+ 2.321e-05 0.000732690399214964
+ 2.3212e-05 0.000609648548349007
+ 2.3214e-05 0.000864019585609811
+ 2.3216e-05 0.000956685971890234
+ 2.3218e-05 0.00055525042955157
+ 2.322e-05 0.000498300958471774
+ 2.3222e-05 0.000290033687388444
+ 2.3224e-05 0.000225913831380183
+ 2.3226e-05 2.1870472411442e-05
+ 2.3228e-05 -3.17109812033046e-05
+ 2.323e-05 0.000136582980716881
+ 2.3232e-05 0.000252059001947034
+ 2.3234e-05 0.000226908024301952
+ 2.3236e-05 0.000195959093465931
+ 2.3238e-05 7.51038200220556e-05
+ 2.324e-05 0.000136169906040549
+ 2.3242e-05 2.64719957910893e-05
+ 2.3244e-05 -0.000105761734016784
+ 2.3246e-05 2.86442085802597e-05
+ 2.3248e-05 5.05014423671419e-05
+ 2.325e-05 -0.000147701493722229
+ 2.3252e-05 -0.000126126436148925
+ 2.3254e-05 -4.15413531218147e-05
+ 2.3256e-05 -0.000361555580034948
+ 2.3258e-05 -0.000530098614346751
+ 2.326e-05 -0.000522645987204255
+ 2.3262e-05 -0.000664090099859676
+ 2.3264e-05 -0.000683377657682909
+ 2.3266e-05 -0.000759323175642903
+ 2.3268e-05 -0.000797083677502597
+ 2.327e-05 -0.000721735647262725
+ 2.3272e-05 -0.000872671839444981
+ 2.3274e-05 -0.000760086552663966
+ 2.3276e-05 -0.000843378267611132
+ 2.3278e-05 -0.000704247220144785
+ 2.328e-05 -0.00113100983391688
+ 2.3282e-05 -0.000877920512129866
+ 2.3284e-05 -0.000807472796959505
+ 2.3286e-05 -0.000714084042855228
+ 2.3288e-05 -0.000767437902934587
+ 2.329e-05 -0.000659996510300901
+ 2.3292e-05 -0.000524727144172218
+ 2.3294e-05 -0.000488217563090254
+ 2.3296e-05 -7.0740445875413e-06
+ 2.3298e-05 0.000318863109575654
+ 2.33e-05 0.000388793077441277
+ 2.3302e-05 0.000274537031571345
+ 2.3304e-05 0.000402885283805348
+ 2.3306e-05 -2.95059921208447e-05
+ 2.3308e-05 0.000164594587268106
+ 2.331e-05 0.000324590205896076
+ 2.3312e-05 0.000262487386013491
+ 2.3314e-05 0.000389262395209753
+ 2.3316e-05 0.000175048750819428
+ 2.3318e-05 0.000253489806505625
+ 2.332e-05 -0.000313858195519976
+ 2.3322e-05 -9.34325983658827e-05
+ 2.3324e-05 -0.000334537923633727
+ 2.3326e-05 -0.000480130635565159
+ 2.3328e-05 -0.000746370685758497
+ 2.333e-05 -0.000918136043053803
+ 2.3332e-05 -0.00113251812456979
+ 2.3334e-05 -0.00100051365720044
+ 2.3336e-05 -0.000894761956952078
+ 2.3338e-05 -0.000790348930505858
+ 2.334e-05 -0.000480246987393012
+ 2.3342e-05 -0.000718052184515252
+ 2.3344e-05 -0.00102004109687786
+ 2.3346e-05 -0.00121548935991627
+ 2.3348e-05 -0.000781177444095909
+ 2.335e-05 -0.000883571978596373
+ 2.3352e-05 -0.000928342994027443
+ 2.3354e-05 -0.000571996902418418
+ 2.3356e-05 -0.000851553819904167
+ 2.3358e-05 -0.000922764104903409
+ 2.336e-05 -0.00085062288326332
+ 2.3362e-05 -0.000698839345499436
+ 2.3364e-05 -0.000417950642868168
+ 2.3366e-05 -0.000639751154400308
+ 2.3368e-05 -0.000741352702070894
+ 2.337e-05 -0.00049330719058636
+ 2.3372e-05 -0.000377923560506367
+ 2.3374e-05 -0.000686512054195124
+ 2.3376e-05 -0.000281211016020912
+ 2.3378e-05 -0.000184844555213444
+ 2.338e-05 0.000136239255034906
+ 2.3382e-05 -0.000115389650392856
+ 2.3384e-05 -3.28173144079525e-05
+ 2.3386e-05 -6.43066176387713e-05
+ 2.3388e-05 3.52833445719681e-05
+ 2.339e-05 0.000128979517856629
+ 2.3392e-05 -0.000173595236825554
+ 2.3394e-05 -0.000541326276629036
+ 2.3396e-05 -0.000645736465332499
+ 2.3398e-05 -0.000784320368562195
+ 2.34e-05 -0.000606456072948875
+ 2.3402e-05 -0.000451836448861577
+ 2.3404e-05 -0.000297855967009679
+ 2.3406e-05 -0.000327170635433564
+ 2.3408e-05 -0.000319389599767107
+ 2.341e-05 -0.000341009434920905
+ 2.3412e-05 -0.000473474381479415
+ 2.3414e-05 -0.000442222917302913
+ 2.3416e-05 -0.000455967268720136
+ 2.3418e-05 -0.000726697666285941
+ 2.342e-05 -0.000706456767790437
+ 2.3422e-05 -0.000598849038746494
+ 2.3424e-05 -0.000513812987006316
+ 2.3426e-05 -0.000828405665764748
+ 2.3428e-05 -0.000779207405343739
+ 2.343e-05 -0.000815167512220337
+ 2.3432e-05 -0.00090232259135391
+ 2.3434e-05 -0.0010889061876353
+ 2.3436e-05 -0.000987028651858412
+ 2.3438e-05 -0.000901379593665333
+ 2.344e-05 -0.00052222814540119
+ 2.3442e-05 -0.00082003691800907
+ 2.3444e-05 -0.000753033372866926
+ 2.3446e-05 -0.000617379690930841
+ 2.3448e-05 -0.000834977579913167
+ 2.345e-05 -0.000783526646625124
+ 2.3452e-05 -0.000913179626473054
+ 2.3454e-05 -0.000927485526470817
+ 2.3456e-05 -0.000742314636489474
+ 2.3458e-05 -0.000770669906091778
+ 2.346e-05 -0.000875498197257487
+ 2.3462e-05 -0.000394948183886479
+ 2.3464e-05 -0.000170451195134229
+ 2.3466e-05 -7.12097750340691e-05
+ 2.3468e-05 -0.000452647221620773
+ 2.347e-05 -0.000532844669182934
+ 2.3472e-05 -0.00042641552131135
+ 2.3474e-05 -0.000281863694981078
+ 2.3476e-05 5.31397822453988e-05
+ 2.3478e-05 0.000234621870342307
+ 2.348e-05 0.000502801871165889
+ 2.3482e-05 0.000197555447718967
+ 2.3484e-05 0.000305688293881914
+ 2.3486e-05 0.000512760028543414
+ 2.3488e-05 0.000587070742368836
+ 2.349e-05 0.000620778850976815
+ 2.3492e-05 0.000942264015848181
+ 2.3494e-05 0.000858610933656644
+ 2.3496e-05 0.000745979194380596
+ 2.3498e-05 0.000730947593740664
+ 2.35e-05 0.000760973069499875
+ 2.3502e-05 0.00048778712537964
+ 2.3504e-05 0.000321353083739162
+ 2.3506e-05 0.000180840373305353
+ 2.3508e-05 0.000356102766955401
+ 2.351e-05 0.000191377401811287
+ 2.3512e-05 0.000312561406853814
+ 2.3514e-05 -2.6229722521919e-05
+ 2.3516e-05 -8.04184111239397e-05
+ 2.3518e-05 -0.000238600976946602
+ 2.352e-05 -0.000108168682369165
+ 2.3522e-05 1.79407649225063e-05
+ 2.3524e-05 0.00014496041675724
+ 2.3526e-05 0.000408385976364092
+ 2.3528e-05 0.000442611448212704
+ 2.353e-05 0.000661251339333515
+ 2.3532e-05 0.000889742436977941
+ 2.3534e-05 0.000562170414753936
+ 2.3536e-05 0.000608101393941025
+ 2.3538e-05 0.000370464443848387
+ 2.354e-05 0.000429174800852396
+ 2.3542e-05 0.000271354602169785
+ 2.3544e-05 0.00034480478730533
+ 2.3546e-05 0.000757136956033638
+ 2.3548e-05 0.000781228748233454
+ 2.355e-05 0.00113642607948414
+ 2.3552e-05 0.00107286930175473
+ 2.3554e-05 0.000722573781371571
+ 2.3556e-05 0.000783002983148763
+ 2.3558e-05 0.000445669515619793
+ 2.356e-05 0.000471026887704377
+ 2.3562e-05 0.000873665185307495
+ 2.3564e-05 0.000967644526834973
+ 2.3566e-05 0.000593741994455022
+ 2.3568e-05 0.000785120797548065
+ 2.357e-05 0.000834052126395853
+ 2.3572e-05 0.000722966258547016
+ 2.3574e-05 0.000681054196111952
+ 2.3576e-05 0.000468840861714987
+ 2.3578e-05 0.000710182661298576
+ 2.358e-05 0.00111603196623476
+ 2.3582e-05 0.00109843921507969
+ 2.3584e-05 0.00130431646290469
+ 2.3586e-05 0.00108988064228418
+ 2.3588e-05 0.000975421681564573
+ 2.359e-05 0.00106531400501445
+ 2.3592e-05 0.000819044410457373
+ 2.3594e-05 0.000819452062511383
+ 2.3596e-05 0.00115817882665403
+ 2.3598e-05 0.00111325657259042
+ 2.36e-05 0.00121100518607169
+ 2.3602e-05 0.00129549523521915
+ 2.3604e-05 0.00118209845784891
+ 2.3606e-05 0.00111894062182291
+ 2.3608e-05 0.00148369588233574
+ 2.361e-05 0.00158791527519183
+ 2.3612e-05 0.00175477966768865
+ 2.3614e-05 0.00155099807126687
+ 2.3616e-05 0.00148372254064751
+ 2.3618e-05 0.00109579938687096
+ 2.362e-05 0.000967453306913242
+ 2.3622e-05 0.00115773625390043
+ 2.3624e-05 0.000664470912298048
+ 2.3626e-05 0.000338897338343288
+ 2.3628e-05 0.000409664840732534
+ 2.363e-05 0.000580219454806514
+ 2.3632e-05 0.000670993827150039
+ 2.3634e-05 0.000585424015838032
+ 2.3636e-05 0.000373836988426072
+ 2.3638e-05 0.000504588270082878
+ 2.364e-05 0.000509221383227341
+ 2.3642e-05 -5.39570344105823e-05
+ 2.3644e-05 -7.89794572887886e-06
+ 2.3646e-05 -4.95941043616237e-05
+ 2.3648e-05 -6.44177101569807e-05
+ 2.365e-05 0.00015475073955096
+ 2.3652e-05 0.000342149742795562
+ 2.3654e-05 0.000382733284525581
+ 2.3656e-05 0.000637388629760356
+ 2.3658e-05 0.000346018178775995
+ 2.366e-05 1.59675277017274e-05
+ 2.3662e-05 5.94056660928718e-05
+ 2.3664e-05 9.75053455523785e-05
+ 2.3666e-05 0.000197389646723251
+ 2.3668e-05 0.000251893241998392
+ 2.367e-05 3.54776132116244e-05
+ 2.3672e-05 2.35349426517442e-05
+ 2.3674e-05 -0.000108066635201632
+ 2.3676e-05 -5.0957592867971e-05
+ 2.3678e-05 0.000401494721295118
+ 2.368e-05 0.000531148317309189
+ 2.3682e-05 0.000780998044701585
+ 2.3684e-05 0.00075340618553953
+ 2.3686e-05 0.000313091387957002
+ 2.3688e-05 -9.85927680647917e-05
+ 2.369e-05 -0.00027225981857903
+ 2.3692e-05 -0.000183139220404016
+ 2.3694e-05 -0.000226360161314246
+ 2.3696e-05 -0.000390861207673408
+ 2.3698e-05 -9.20758201328324e-05
+ 2.37e-05 0.000148778313485782
+ 2.3702e-05 0.000293849552048048
+ 2.3704e-05 0.000224407259372712
+ 2.3706e-05 0.000318073485562924
+ 2.3708e-05 -5.72048563304467e-06
+ 2.371e-05 -0.000315248059811087
+ 2.3712e-05 -0.000466491676366672
+ 2.3714e-05 -0.000405158347995964
+ 2.3716e-05 -0.000736804672689577
+ 2.3718e-05 -0.000745903062862619
+ 2.372e-05 -0.000342351184243402
+ 2.3722e-05 -0.000509366514870598
+ 2.3724e-05 -0.000786493000503626
+ 2.3726e-05 -0.000677422395909225
+ 2.3728e-05 -0.00059793142798703
+ 2.373e-05 -0.000379165060320574
+ 2.3732e-05 -0.000263634242606103
+ 2.3734e-05 -6.94266306647996e-05
+ 2.3736e-05 -1.47258623642876e-05
+ 2.3738e-05 8.03458891113114e-05
+ 2.374e-05 -0.000218540475480623
+ 2.3742e-05 -0.000346236920322367
+ 2.3744e-05 -0.000108083665349981
+ 2.3746e-05 -0.000268458538742241
+ 2.3748e-05 -0.000285363896584711
+ 2.375e-05 -0.000142539617139013
+ 2.3752e-05 -4.46627291421708e-06
+ 2.3754e-05 0.00025185530394257
+ 2.3756e-05 0.00022197137279435
+ 2.3758e-05 -2.88983773640991e-05
+ 2.376e-05 0.00012151436942672
+ 2.3762e-05 0.000203848625141486
+ 2.3764e-05 0.000111954926782173
+ 2.3766e-05 2.47435363698841e-05
+ 2.3768e-05 -0.000121088770272731
+ 2.377e-05 -0.000176000155254544
+ 2.3772e-05 -0.000110349515499228
+ 2.3774e-05 -4.96777436346422e-05
+ 2.3776e-05 -9.29675928638199e-05
+ 2.3778e-05 6.3986902645787e-05
+ 2.378e-05 -8.95283076540515e-05
+ 2.3782e-05 -0.000478471161067552
+ 2.3784e-05 -0.00107757928625196
+ 2.3786e-05 -0.00102172598028306
+ 2.3788e-05 -0.000860138866740345
+ 2.379e-05 -0.000951938714084551
+ 2.3792e-05 -0.00102557129978228
+ 2.3794e-05 -0.000993074990045319
+ 2.3796e-05 -0.00113142331776506
+ 2.3798e-05 -0.000818391450369544
+ 2.38e-05 -0.00102550984605693
+ 2.3802e-05 -0.00109696593383694
+ 2.3804e-05 -0.00131479182395711
+ 2.3806e-05 -0.00154076577003962
+ 2.3808e-05 -0.00165974972464578
+ 2.381e-05 -0.00169563385802506
+ 2.3812e-05 -0.0014594090144668
+ 2.3814e-05 -0.0014625172931352
+ 2.3816e-05 -0.00173821834026174
+ 2.3818e-05 -0.00176339229169516
+ 2.382e-05 -0.00147943578230108
+ 2.3822e-05 -0.0014393707388881
+ 2.3824e-05 -0.00155608315235576
+ 2.3826e-05 -0.00152085568294684
+ 2.3828e-05 -0.00145748308781209
+ 2.383e-05 -0.00108992750607863
+ 2.3832e-05 -0.00120371516662787
+ 2.3834e-05 -0.00129820523379958
+ 2.3836e-05 -0.00102005569256474
+ 2.3838e-05 -0.000961245483775731
+ 2.384e-05 -0.00111510365738009
+ 2.3842e-05 -0.00111630812987904
+ 2.3844e-05 -0.00121198777775565
+ 2.3846e-05 -0.00148100835993402
+ 2.3848e-05 -0.00148167155505732
+ 2.385e-05 -0.00145356274862876
+ 2.3852e-05 -0.00129344909826965
+ 2.3854e-05 -0.00121235111895445
+ 2.3856e-05 -0.00148805049765237
+ 2.3858e-05 -0.00155497608298185
+ 2.386e-05 -0.00174723891864222
+ 2.3862e-05 -0.00185397412681068
+ 2.3864e-05 -0.00176926597570783
+ 2.3866e-05 -0.00159132905308725
+ 2.3868e-05 -0.00135716424840645
+ 2.387e-05 -0.00160933230414992
+ 2.3872e-05 -0.00148166417430756
+ 2.3874e-05 -0.00122094351704082
+ 2.3876e-05 -0.00120242584604615
+ 2.3878e-05 -0.00133007346324806
+ 2.388e-05 -0.00117295987855337
+ 2.3882e-05 -0.00142651013861655
+ 2.3884e-05 -0.00150595024667591
+ 2.3886e-05 -0.00159429529759261
+ 2.3888e-05 -0.0016375055390767
+ 2.389e-05 -0.0013945383799489
+ 2.3892e-05 -0.00126825122808196
+ 2.3894e-05 -0.00130827161965583
+ 2.3896e-05 -0.00142035134123579
+ 2.3898e-05 -0.00142784498893831
+ 2.39e-05 -0.00164598836528917
+ 2.3902e-05 -0.0016342597618278
+ 2.3904e-05 -0.00192757881111731
+ 2.3906e-05 -0.00154838752287807
+ 2.3908e-05 -0.00162419461551473
+ 2.391e-05 -0.00174990172307235
+ 2.3912e-05 -0.0014748258361455
+ 2.3914e-05 -0.00133960665081335
+ 2.3916e-05 -0.00115132466106886
+ 2.3918e-05 -0.000889936732463444
+ 2.392e-05 -0.000703104849097251
+ 2.3922e-05 -0.000640646884793347
+ 2.3924e-05 -0.000578698155627428
+ 2.3926e-05 -0.000583743793495694
+ 2.3928e-05 -0.000851668228151032
+ 2.393e-05 -0.000630524925543482
+ 2.3932e-05 -0.000538884934560116
+ 2.3934e-05 -0.000315334929083823
+ 2.3936e-05 -0.000230764797124458
+ 2.3938e-05 -0.000304112622714081
+ 2.394e-05 -0.000370398057812582
+ 2.3942e-05 -7.34578653945561e-06
+ 2.3944e-05 0.000297973608765637
+ 2.3946e-05 0.000327773632166714
+ 2.3948e-05 0.000174925638872678
+ 2.395e-05 0.000219498593079437
+ 2.3952e-05 0.000143683641128362
+ 2.3954e-05 -0.000120552826297492
+ 2.3956e-05 -0.000417520823730157
+ 2.3958e-05 -0.000657562125922324
+ 2.396e-05 -0.000678120278908649
+ 2.3962e-05 -0.000502484056867756
+ 2.3964e-05 -0.000204931558665278
+ 2.3966e-05 -0.000289287870011633
+ 2.3968e-05 -0.000516461100895243
+ 2.397e-05 -0.00063948483911119
+ 2.3972e-05 -0.000811137267755251
+ 2.3974e-05 -0.000991944449608451
+ 2.3976e-05 -0.00102891496232592
+ 2.3978e-05 -0.00147481074381322
+ 2.398e-05 -0.00182721360373263
+ 2.3982e-05 -0.00149946823027399
+ 2.3984e-05 -0.0014958867106113
+ 2.3986e-05 -0.00168272949057967
+ 2.3988e-05 -0.00142171815075176
+ 2.399e-05 -0.00107911938133653
+ 2.3992e-05 -0.00119517734287163
+ 2.3994e-05 -0.00122744070014104
+ 2.3996e-05 -0.000982627985060376
+ 2.3998e-05 -0.00080133710324444
+ 2.4e-05 -0.000678048853293389
+ 2.4002e-05 -0.000639904265253218
+ 2.4004e-05 -0.000689281335112463
+ 2.4006e-05 -0.000955766287478703
+ 2.4008e-05 -0.000827965412803775
+ 2.401e-05 -0.00127572621506708
+ 2.4012e-05 -0.00114782163477876
+ 2.4014e-05 -0.00107338000342347
+ 2.4016e-05 -0.000892294688906265
+ 2.4018e-05 -0.000652687432804113
+ 2.402e-05 -0.000624261011633509
+ 2.4022e-05 -0.000784715673364416
+ 2.4024e-05 -0.000756991768659918
+ 2.4026e-05 -0.000728365726500735
+ 2.4028e-05 -0.000430488870420265
+ 2.403e-05 -0.000854339111001219
+ 2.4032e-05 -0.000960245402863308
+ 2.4034e-05 -0.0010489829133817
+ 2.4036e-05 -0.00114460112615812
+ 2.4038e-05 -0.000883417653761424
+ 2.404e-05 -0.000576292922106524
+ 2.4042e-05 -0.000551871895079444
+ 2.4044e-05 -0.000914624043922449
+ 2.4046e-05 -0.00090046407218334
+ 2.4048e-05 -0.00100969026979207
+ 2.405e-05 -0.000648711251877991
+ 2.4052e-05 -0.000853627043050236
+ 2.4054e-05 -0.00110277717860361
+ 2.4056e-05 -0.00104977917846986
+ 2.4058e-05 -0.00126816492807158
+ 2.406e-05 -0.00114061306640446
+ 2.4062e-05 -0.000822296619037261
+ 2.4064e-05 -0.00092481790056185
+ 2.4066e-05 -0.00101816135750993
+ 2.4068e-05 -0.00106250969878881
+ 2.407e-05 -0.0013973068475229
+ 2.4072e-05 -0.00139633553401451
+ 2.4074e-05 -0.00155601651817248
+ 2.4076e-05 -0.00127893787477521
+ 2.4078e-05 -0.00135312221643797
+ 2.408e-05 -0.00130840788861747
+ 2.4082e-05 -0.00147754632842991
+ 2.4084e-05 -0.0013657766065559
+ 2.4086e-05 -0.00109753388355985
+ 2.4088e-05 -0.00124790141040918
+ 2.409e-05 -0.00141241800919783
+ 2.4092e-05 -0.00132009224244324
+ 2.4094e-05 -0.00125747081184757
+ 2.4096e-05 -0.000948456626394301
+ 2.4098e-05 -0.00119955471567643
+ 2.41e-05 -0.00132864759708196
+ 2.4102e-05 -0.00124771735998708
+ 2.4104e-05 -0.000663306124152734
+ 2.4106e-05 -0.000317504950883807
+ 2.4108e-05 -0.000229687527109783
+ 2.411e-05 -0.000482330141565817
+ 2.4112e-05 -0.000414433585075267
+ 2.4114e-05 -0.000572051752520033
+ 2.4116e-05 -0.000499995560678092
+ 2.4118e-05 -0.000402146909099805
+ 2.412e-05 -0.000375208918556393
+ 2.4122e-05 -0.000654897956570234
+ 2.4124e-05 -0.000636942497343683
+ 2.4126e-05 -0.000431927023018557
+ 2.4128e-05 -0.000587955479540571
+ 2.413e-05 -0.000583919347189136
+ 2.4132e-05 -0.000410849225576123
+ 2.4134e-05 -0.0005565836659484
+ 2.4136e-05 -0.000804962938419247
+ 2.4138e-05 -0.000687716755927799
+ 2.414e-05 -0.00061065813660226
+ 2.4142e-05 -0.00031354298805863
+ 2.4144e-05 -0.000310753313127732
+ 2.4146e-05 -0.000463226055984746
+ 2.4148e-05 -0.000640008473249168
+ 2.415e-05 -0.000725486297210884
+ 2.4152e-05 -0.000741529436022559
+ 2.4154e-05 -0.000775025947331695
+ 2.4156e-05 -0.00072389192526281
+ 2.4158e-05 -0.000783964627644297
+ 2.416e-05 -0.000679847833835576
+ 2.4162e-05 -0.000699243421467951
+ 2.4164e-05 -0.000336857655189386
+ 2.4166e-05 -0.00026891503890638
+ 2.4168e-05 -0.000481768675433046
+ 2.417e-05 -0.000833388843602417
+ 2.4172e-05 -0.000914264875385877
+ 2.4174e-05 -0.000935217489587662
+ 2.4176e-05 -0.000716010388656843
+ 2.4178e-05 -0.000560888595529582
+ 2.418e-05 -0.000679513839075443
+ 2.4182e-05 -0.000872509867824741
+ 2.4184e-05 -0.000667009783876827
+ 2.4186e-05 -0.000835748167695636
+ 2.4188e-05 -0.000677286783358816
+ 2.419e-05 -0.00063904537578426
+ 2.4192e-05 -0.000257903496135883
+ 2.4194e-05 -0.000368990075829033
+ 2.4196e-05 -0.000446932503474198
+ 2.4198e-05 -0.000476398887751666
+ 2.42e-05 -0.000358784673832754
+ 2.4202e-05 -0.000627767344945983
+ 2.4204e-05 -0.000112970182447379
+ 2.4206e-05 4.73040820556155e-05
+ 2.4208e-05 0.0002341477372174
+ 2.421e-05 0.000386349588794192
+ 2.4212e-05 0.000596699078893147
+ 2.4214e-05 0.00033823338543688
+ 2.4216e-05 0.000161038334124872
+ 2.4218e-05 0.000126193556432681
+ 2.422e-05 0.000231580248788291
+ 2.4222e-05 0.000419044240944815
+ 2.4224e-05 0.000713642017545626
+ 2.4226e-05 0.000745390054540731
+ 2.4228e-05 0.000669687324905679
+ 2.423e-05 0.000466061369837701
+ 2.4232e-05 0.000447096638093605
+ 2.4234e-05 0.000164869232471966
+ 2.4236e-05 0.000209475294454248
+ 2.4238e-05 0.000344009046532112
+ 2.424e-05 0.000437282743445977
+ 2.4242e-05 -0.000133908988448934
+ 2.4244e-05 -0.000178961987420593
+ 2.4246e-05 -0.000315623934359731
+ 2.4248e-05 -0.000189837673391456
+ 2.425e-05 -0.00042102988433689
+ 2.4252e-05 -0.000297963355851324
+ 2.4254e-05 -9.72509220191682e-05
+ 2.4256e-05 -0.000270804142313177
+ 2.4258e-05 7.07440696926872e-05
+ 2.426e-05 2.0286029041216e-05
+ 2.4262e-05 0.000129763775735325
+ 2.4264e-05 0.000134730984969239
+ 2.4266e-05 0.000285661380446737
+ 2.4268e-05 0.000570151516782581
+ 2.427e-05 0.000525740220729128
+ 2.4272e-05 0.000712495131478652
+ 2.4274e-05 0.00109326466921054
+ 2.4276e-05 0.00108863872879623
+ 2.4278e-05 0.00118832754809791
+ 2.428e-05 0.00107947382540147
+ 2.4282e-05 0.00113976115503385
+ 2.4284e-05 0.0010082750300963
+ 2.4286e-05 0.000821675447570401
+ 2.4288e-05 0.000591730855737636
+ 2.429e-05 0.000649631311306343
+ 2.4292e-05 0.000462369421799293
+ 2.4294e-05 0.000503428290561029
+ 2.4296e-05 0.000588071673328037
+ 2.4298e-05 0.000810205043469651
+ 2.43e-05 0.000579618319919224
+ 2.4302e-05 0.000520897533551089
+ 2.4304e-05 0.000683603072586389
+ 2.4306e-05 0.000608127657413166
+ 2.4308e-05 0.000893257389572456
+ 2.431e-05 0.000728388778695243
+ 2.4312e-05 0.00070403698961453
+ 2.4314e-05 0.000637565272350158
+ 2.4316e-05 0.000418329681279233
+ 2.4318e-05 0.000476314643306323
+ 2.432e-05 0.000478908095662186
+ 2.4322e-05 0.000287625788283279
+ 2.4324e-05 0.000253361345548642
+ 2.4326e-05 0.000634912060244742
+ 2.4328e-05 0.000848780281287917
+ 2.433e-05 0.000756498177937287
+ 2.4332e-05 0.000650304727240062
+ 2.4334e-05 0.000695293969700472
+ 2.4336e-05 0.000851954818315332
+ 2.4338e-05 0.000233543237625749
+ 2.434e-05 0.000155250579078941
+ 2.4342e-05 -0.000256608280104819
+ 2.4344e-05 0.000124278121607523
+ 2.4346e-05 1.95906033138384e-05
+ 2.4348e-05 -2.62846987003642e-05
+ 2.435e-05 -0.000207426266458748
+ 2.4352e-05 -0.000570958043204508
+ 2.4354e-05 -0.000327518146693701
+ 2.4356e-05 -0.000294419315812342
+ 2.4358e-05 -5.17375780551658e-05
+ 2.436e-05 0.000100502102145187
+ 2.4362e-05 5.8419570565668e-05
+ 2.4364e-05 0.000146622231911516
+ 2.4366e-05 0.000294060027860143
+ 2.4368e-05 0.000275605703899803
+ 2.437e-05 0.000275398742547936
+ 2.4372e-05 0.000452690927474288
+ 2.4374e-05 0.000532614046528065
+ 2.4376e-05 0.000397623709319711
+ 2.4378e-05 0.000829160023486627
+ 2.438e-05 0.000407585847070418
+ 2.4382e-05 0.000236288821721352
+ 2.4384e-05 -5.56802228263469e-05
+ 2.4386e-05 0.000371009394511532
+ 2.4388e-05 0.000232384067808803
+ 2.439e-05 -3.94896488018193e-05
+ 2.4392e-05 0.000102455893316284
+ 2.4394e-05 -7.42691319373845e-05
+ 2.4396e-05 -0.000204054473884403
+ 2.4398e-05 7.83891986443774e-06
+ 2.44e-05 -3.48617193999087e-05
+ 2.4402e-05 2.75156487346023e-06
+ 2.4404e-05 1.1418184779593e-05
+ 2.4406e-05 -1.07272973927064e-05
+ 2.4408e-05 -7.43103857044121e-05
+ 2.441e-05 -0.000284847893315068
+ 2.4412e-05 -8.37129503114123e-05
+ 2.4414e-05 -2.51264423490686e-05
+ 2.4416e-05 0.000227059196014394
+ 2.4418e-05 -3.2062458720192e-06
+ 2.442e-05 3.42084287086396e-05
+ 2.4422e-05 0.000125768243281771
+ 2.4424e-05 0.000324401285668976
+ 2.4426e-05 0.000304044823406826
+ 2.4428e-05 0.000543451270241112
+ 2.443e-05 0.000385203666303684
+ 2.4432e-05 0.000365743769788478
+ 2.4434e-05 0.000676315392581806
+ 2.4436e-05 0.001017332605069
+ 2.4438e-05 0.00130977603713215
+ 2.444e-05 0.0014361008670304
+ 2.4442e-05 0.00168471200412083
+ 2.4444e-05 0.00165793753824834
+ 2.4446e-05 0.00195375164891725
+ 2.4448e-05 0.00211744864553485
+ 2.445e-05 0.00201731932364193
+ 2.4452e-05 0.00212476624340655
+ 2.4454e-05 0.00241225768139886
+ 2.4456e-05 0.00230326429734559
+ 2.4458e-05 0.00276053458198182
+ 2.446e-05 0.00248222938005229
+ 2.4462e-05 0.00236727142430249
+ 2.4464e-05 0.00257971894290063
+ 2.4466e-05 0.00288701105936178
+ 2.4468e-05 0.0031680194456069
+ 2.447e-05 0.00294626401624466
+ 2.4472e-05 0.00289562066074053
+ 2.4474e-05 0.00276820517360327
+ 2.4476e-05 0.00278631799680808
+ 2.4478e-05 0.00279390216735876
+ 2.448e-05 0.00274278256324549
+ 2.4482e-05 0.00265849316995901
+ 2.4484e-05 0.00239310715186283
+ 2.4486e-05 0.00222939821638247
+ 2.4488e-05 0.00205814489003152
+ 2.449e-05 0.00172659001831477
+ 2.4492e-05 0.00190083323923641
+ 2.4494e-05 0.00197393388382575
+ 2.4496e-05 0.00181399954452213
+ 2.4498e-05 0.00209085546162165
+ 2.45e-05 0.00165853153293791
+ 2.4502e-05 0.00138240038364402
+ 2.4504e-05 0.00143963022578257
+ 2.4506e-05 0.00122109327673534
+ 2.4508e-05 0.0011487885176834
+ 2.451e-05 0.00141628790801513
+ 2.4512e-05 0.00111537714080416
+ 2.4514e-05 0.00109780056703396
+ 2.4516e-05 0.00139337107126494
+ 2.4518e-05 0.00132493514376085
+ 2.452e-05 0.00149709533167064
+ 2.4522e-05 0.0012143926398548
+ 2.4524e-05 0.00102355969812399
+ 2.4526e-05 0.000966596333783219
+ 2.4528e-05 0.000719597529234813
+ 2.453e-05 0.00047381398014205
+ 2.4532e-05 0.000337962486039953
+ 2.4534e-05 0.000541005365859326
+ 2.4536e-05 0.000280858867668806
+ 2.4538e-05 0.000209867308651151
+ 2.454e-05 0.000388133807377724
+ 2.4542e-05 0.000326271189786554
+ 2.4544e-05 0.000389286224480986
+ 2.4546e-05 0.000347557499828064
+ 2.4548e-05 0.000223244562469015
+ 2.455e-05 0.000298037467121169
+ 2.4552e-05 0.000209172452265254
+ 2.4554e-05 0.000398003505233006
+ 2.4556e-05 0.000390470655211496
+ 2.4558e-05 0.000182719813620104
+ 2.456e-05 0.000292515796132598
+ 2.4562e-05 8.49225637368493e-05
+ 2.4564e-05 5.31581337508314e-05
+ 2.4566e-05 -9.18869603575383e-05
+ 2.4568e-05 -0.00013238416773559
+ 2.457e-05 -0.00019511657562512
+ 2.4572e-05 -0.0006022658679146
+ 2.4574e-05 -0.000394469128333026
+ 2.4576e-05 -0.000238518545285273
+ 2.4578e-05 -0.000476230801239255
+ 2.458e-05 -0.000669823103598709
+ 2.4582e-05 -0.000511835372068381
+ 2.4584e-05 -0.000670268767714891
+ 2.4586e-05 -0.000621438381675018
+ 2.4588e-05 -0.000400390077298717
+ 2.459e-05 -0.000620155623544679
+ 2.4592e-05 -0.000651324122288747
+ 2.4594e-05 -0.000619236226508142
+ 2.4596e-05 -0.000774920018983482
+ 2.4598e-05 -0.000784546164140526
+ 2.46e-05 -0.00108196151727781
+ 2.4602e-05 -0.00108770894906346
+ 2.4604e-05 -0.00115079355327148
+ 2.4606e-05 -0.00119911758854849
+ 2.4608e-05 -0.00136046644935477
+ 2.461e-05 -0.00154054560119307
+ 2.4612e-05 -0.00146871171037028
+ 2.4614e-05 -0.00119229440927054
+ 2.4616e-05 -0.00120753636264598
+ 2.4618e-05 -0.00127712618604135
+ 2.462e-05 -0.00159933661283118
+ 2.4622e-05 -0.00158271123814652
+ 2.4624e-05 -0.00137786105174194
+ 2.4626e-05 -0.00138564774539601
+ 2.4628e-05 -0.00119964999409465
+ 2.463e-05 -0.00130921070335007
+ 2.4632e-05 -0.000944490819537371
+ 2.4634e-05 -0.000944449733215388
+ 2.4636e-05 -0.000738883861971813
+ 2.4638e-05 -0.000670932110266535
+ 2.464e-05 -0.000343799444586597
+ 2.4642e-05 -0.000642941659788629
+ 2.4644e-05 -0.00102688841412184
+ 2.4646e-05 -0.00145955656407774
+ 2.4648e-05 -0.00159150488065932
+ 2.465e-05 -0.00159750006315458
+ 2.4652e-05 -0.001769980721654
+ 2.4654e-05 -0.00135816061174184
+ 2.4656e-05 -0.00157263192392175
+ 2.4658e-05 -0.0014295377910344
+ 2.466e-05 -0.00150675102824268
+ 2.4662e-05 -0.00154818064919862
+ 2.4664e-05 -0.00128235143106432
+ 2.4666e-05 -0.00143099851923234
+ 2.4668e-05 -0.0016013593990995
+ 2.467e-05 -0.00172308846036244
+ 2.4672e-05 -0.00192897037699368
+ 2.4674e-05 -0.00182469259433176
+ 2.4676e-05 -0.00200742610569456
+ 2.4678e-05 -0.00177075774903151
+ 2.468e-05 -0.00141333661696883
+ 2.4682e-05 -0.00146795480159684
+ 2.4684e-05 -0.00162439760192159
+ 2.4686e-05 -0.00131498982635314
+ 2.4688e-05 -0.00115816426627123
+ 2.469e-05 -0.00123062551958664
+ 2.4692e-05 -0.000724815304691507
+ 2.4694e-05 -0.000767190312269141
+ 2.4696e-05 -0.000839119240952616
+ 2.4698e-05 -0.000627482344683773
+ 2.47e-05 -0.000538862118774189
+ 2.4702e-05 -0.000525570955370222
+ 2.4704e-05 -0.000571736283168518
+ 2.4706e-05 -0.000462749396631618
+ 2.4708e-05 -0.000295468431866472
+ 2.471e-05 0.000173632698859492
+ 2.4712e-05 0.000139744498726836
+ 2.4714e-05 7.31680530220844e-05
+ 2.4716e-05 0.000221565518493496
+ 2.4718e-05 0.000195147065599099
+ 2.472e-05 -0.000107255676888361
+ 2.4722e-05 -0.000291024525195783
+ 2.4724e-05 -0.000389997483595854
+ 2.4726e-05 -0.000124516042281739
+ 2.4728e-05 -1.926624595688e-06
+ 2.473e-05 0.000171568782903325
+ 2.4732e-05 0.00012863735282079
+ 2.4734e-05 0.000378205361765761
+ 2.4736e-05 0.000591132215403296
+ 2.4738e-05 0.000490579762461244
+ 2.474e-05 0.000579681494521495
+ 2.4742e-05 0.000435484762754132
+ 2.4744e-05 0.00034145290257103
+ 2.4746e-05 0.000101244120823761
+ 2.4748e-05 -0.000194590404855309
+ 2.475e-05 -0.000300388348533087
+ 2.4752e-05 -0.000498952123035499
+ 2.4754e-05 -0.000417216305898878
+ 2.4756e-05 -0.000286113149810788
+ 2.4758e-05 -0.000284950175614301
+ 2.476e-05 -0.000186419069556474
+ 2.4762e-05 -0.000414573419719089
+ 2.4764e-05 -0.000466204166905358
+ 2.4766e-05 -0.00068986784912337
+ 2.4768e-05 -0.000549488344413453
+ 2.477e-05 -0.000225106123826879
+ 2.4772e-05 5.01996933881936e-05
+ 2.4774e-05 8.03332561850566e-05
+ 2.4776e-05 0.000249975440271554
+ 2.4778e-05 0.000140659573807273
+ 2.478e-05 0.000184370782196693
+ 2.4782e-05 3.13117270026209e-05
+ 2.4784e-05 0.000179560098490082
+ 2.4786e-05 0.000289904679509153
+ 2.4788e-05 0.000117064644341677
+ 2.479e-05 0.000164439561314439
+ 2.4792e-05 0.000341670046648169
+ 2.4794e-05 0.000472515974435211
+ 2.4796e-05 0.000130861388876613
+ 2.4798e-05 0.000395588372923834
+ 2.48e-05 0.000105242113099818
+ 2.4802e-05 -0.00011232842841753
+ 2.4804e-05 -4.90752918242324e-05
+ 2.4806e-05 0.000250606484857091
+ 2.4808e-05 0.000163833833607657
+ 2.481e-05 0.000373181196306856
+ 2.4812e-05 0.00039126174256684
+ 2.4814e-05 0.000434763754983586
+ 2.4816e-05 0.000448357851142389
+ 2.4818e-05 0.000616114019493703
+ 2.482e-05 0.000302681100822411
+ 2.4822e-05 0.000363502868953759
+ 2.4824e-05 0.000451239491946377
+ 2.4826e-05 0.000506443894983888
+ 2.4828e-05 0.000638992039408922
+ 2.483e-05 0.00112791780116237
+ 2.4832e-05 0.00134037258920965
+ 2.4834e-05 0.00138590148334349
+ 2.4836e-05 0.00143240877066176
+ 2.4838e-05 0.0015910258224671
+ 2.484e-05 0.001647600488573
+ 2.4842e-05 0.00130329866104625
+ 2.4844e-05 0.000957093139314068
+ 2.4846e-05 0.000929950239397235
+ 2.4848e-05 0.000880844103555125
+ 2.485e-05 0.00099777252988099
+ 2.4852e-05 0.00119142607745789
+ 2.4854e-05 0.0013606189388807
+ 2.4856e-05 0.00141536554606679
+ 2.4858e-05 0.00132426706944927
+ 2.486e-05 0.00114856896813767
+ 2.4862e-05 0.00103817297569457
+ 2.4864e-05 0.000971549564666066
+ 2.4866e-05 0.00121258938992396
+ 2.4868e-05 0.000937369738303321
+ 2.487e-05 0.000614052359237506
+ 2.4872e-05 0.000632049894694771
+ 2.4874e-05 0.000412732792239043
+ 2.4876e-05 0.000500642678508854
+ 2.4878e-05 0.000571172710425062
+ 2.488e-05 0.000647487901403714
+ 2.4882e-05 0.000624159093360033
+ 2.4884e-05 0.000723847779203601
+ 2.4886e-05 0.000889653041756763
+ 2.4888e-05 0.000648983335234483
+ 2.489e-05 0.000668702343660484
+ 2.4892e-05 0.000631115276740891
+ 2.4894e-05 0.000423518169240551
+ 2.4896e-05 0.000575078093285547
+ 2.4898e-05 0.000635305686520119
+ 2.49e-05 0.000456891967576569
+ 2.4902e-05 0.000657272826900771
+ 2.4904e-05 0.000655398976832577
+ 2.4906e-05 0.00100309576635731
+ 2.4908e-05 0.000645906778187094
+ 2.491e-05 0.000542453442244842
+ 2.4912e-05 0.000147699106655071
+ 2.4914e-05 -7.18173939115428e-05
+ 2.4916e-05 0.000109866683352427
+ 2.4918e-05 0.000176932818618612
+ 2.492e-05 0.000305055709931876
+ 2.4922e-05 0.000363571483837792
+ 2.4924e-05 6.19482936525104e-05
+ 2.4926e-05 0.000203978457368353
+ 2.4928e-05 0.000274378851737561
+ 2.493e-05 0.000271183725027348
+ 2.4932e-05 -0.000128935569878035
+ 2.4934e-05 0.000151462830026078
+ 2.4936e-05 0.000349671966534376
+ 2.4938e-05 0.000197534728560679
+ 2.494e-05 0.000355813649421294
+ 2.4942e-05 0.00056486020527966
+ 2.4944e-05 0.00052559572687219
+ 2.4946e-05 0.000507160692492016
+ 2.4948e-05 0.00021716645910954
+ 2.495e-05 0.000204175533667023
+ 2.4952e-05 -9.51230741560642e-05
+ 2.4954e-05 -0.000126604765427724
+ 2.4956e-05 -0.000438268556821819
+ 2.4958e-05 -0.000120814434547251
+ 2.496e-05 -0.000125205471036728
+ 2.4962e-05 -0.000122918748451826
+ 2.4964e-05 -9.13666246438639e-05
+ 2.4966e-05 -0.000117491237596048
+ 2.4968e-05 7.42619438071362e-06
+ 2.497e-05 0.000131649760538433
+ 2.4972e-05 0.000133316639635268
+ 2.4974e-05 0.000296565882970617
+ 2.4976e-05 7.20023692162816e-05
+ 2.4978e-05 0.00029227843118414
+ 2.498e-05 0.000390101605178931
+ 2.4982e-05 0.000207717742480366
+ 2.4984e-05 -0.000235898759990718
+ 2.4986e-05 -0.000181787037590552
+ 2.4988e-05 -7.94241569347267e-05
+ 2.499e-05 -2.18558149686867e-05
+ 2.4992e-05 7.22783538530153e-05
+ 2.4994e-05 7.69999030008789e-06
+ 2.4996e-05 -2.72841022202667e-05
+ 2.4998e-05 -4.25459214397494e-05
+ 2.5e-05 -0.000302554805698597
+ 2.5002e-05 -4.18658540596235e-05
+ 2.5004e-05 0.000116926793215615
+ 2.5006e-05 -0.000213604564917812
+ 2.5008e-05 -1.94790824716836e-05
+ 2.501e-05 -0.000359203696541823
+ 2.5012e-05 -0.000107494923668948
+ 2.5014e-05 -9.91832242467955e-05
+ 2.5016e-05 -0.000125011469789839
+ 2.5018e-05 -0.000107558564573633
+ 2.502e-05 4.96583948275823e-05
+ 2.5022e-05 0.000201188410106607
+ 2.5024e-05 -0.000223739236209876
+ 2.5026e-05 -0.000132831550387969
+ 2.5028e-05 2.25230709575835e-05
+ 2.503e-05 0.000104227676751297
+ 2.5032e-05 -0.000232921398902282
+ 2.5034e-05 -0.000562986841044964
+ 2.5036e-05 -0.000822214155303679
+ 2.5038e-05 -0.000729754455108635
+ 2.504e-05 -0.000834742913156747
+ 2.5042e-05 -0.000846250393778161
+ 2.5044e-05 -0.000836399998948448
+ 2.5046e-05 -0.000870266469152212
+ 2.5048e-05 -0.00101971769107122
+ 2.505e-05 -0.000985199995180012
+ 2.5052e-05 -0.000981087881721694
+ 2.5054e-05 -0.000948200788607111
+ 2.5056e-05 -0.00120371754352212
+ 2.5058e-05 -0.00102830857003062
+ 2.506e-05 -0.000948572671237628
+ 2.5062e-05 -0.000787949611618939
+ 2.5064e-05 -0.000714087895708006
+ 2.5066e-05 -0.000634446382129636
+ 2.5068e-05 -0.000809452562133576
+ 2.507e-05 -0.00067637685625478
+ 2.5072e-05 -0.000263180127479831
+ 2.5074e-05 -0.000319026186505966
+ 2.5076e-05 -0.000259353357136545
+ 2.5078e-05 -4.63477849394316e-05
+ 2.508e-05 -7.00999175216116e-05
+ 2.5082e-05 -0.000160782777719504
+ 2.5084e-05 -2.87500039339668e-05
+ 2.5086e-05 -0.000118826946963656
+ 2.5088e-05 -0.000270808651726647
+ 2.509e-05 -0.00031071482572931
+ 2.5092e-05 -0.000101208734194176
+ 2.5094e-05 -3.43701782823916e-05
+ 2.5096e-05 0.000257838024380798
+ 2.5098e-05 0.000198995616390597
+ 2.51e-05 5.89907279785672e-05
+ 2.5102e-05 0.000100032194349736
+ 2.5104e-05 0.000253415397061857
+ 2.5106e-05 0.000248984658181908
+ 2.5108e-05 -8.80948364660472e-06
+ 2.511e-05 -3.52050815655649e-05
+ 2.5112e-05 0.000311437860754368
+ 2.5114e-05 0.000570753399127824
+ 2.5116e-05 0.000921315815111461
+ 2.5118e-05 0.00140572537574101
+ 2.512e-05 0.00133199205845388
+ 2.5122e-05 0.00161459917881754
+ 2.5124e-05 0.00152503903082273
+ 2.5126e-05 0.00170307793070653
+ 2.5128e-05 0.00160049220014338
+ 2.513e-05 0.00142572029165626
+ 2.5132e-05 0.00165895841189655
+ 2.5134e-05 0.0015829314594875
+ 2.5136e-05 0.00172761728717253
+ 2.5138e-05 0.00130765843830523
+ 2.514e-05 0.00107936019994334
+ 2.5142e-05 0.000844402751903712
+ 2.5144e-05 0.00105802726037111
+ 2.5146e-05 0.00107934424990254
+ 2.5148e-05 0.000952142737958903
+ 2.515e-05 0.000786804894470472
+ 2.5152e-05 0.000645093533413172
+ 2.5154e-05 0.000600161879013941
+ 2.5156e-05 0.000607382311214235
+ 2.5158e-05 0.000892257295643523
+ 2.516e-05 0.00116715561123831
+ 2.5162e-05 0.000867649601048491
+ 2.5164e-05 0.000900674327006059
+ 2.5166e-05 0.00101889254427083
+ 2.5168e-05 0.000717366187201979
+ 2.517e-05 0.000667341745137474
+ 2.5172e-05 0.000642172947978367
+ 2.5174e-05 0.000437799924779352
+ 2.5176e-05 0.000554551162572139
+ 2.5178e-05 0.000721215139660084
+ 2.518e-05 0.00102256362636448
+ 2.5182e-05 0.00118939098356922
+ 2.5184e-05 0.00113095627286761
+ 2.5186e-05 0.00106211030359098
+ 2.5188e-05 0.000718360136220121
+ 2.519e-05 0.000537416693485529
+ 2.5192e-05 0.000624233619129496
+ 2.5194e-05 0.000694383584014387
+ 2.5196e-05 0.000883041828151323
+ 2.5198e-05 0.000705245381108984
+ 2.52e-05 0.000817132626600148
+ 2.5202e-05 0.000876029996880931
+ 2.5204e-05 0.000800854520236073
+ 2.5206e-05 0.000771156618879145
+ 2.5208e-05 0.000902862836894711
+ 2.521e-05 0.0008293439814419
+ 2.5212e-05 0.000725000798241453
+ 2.5214e-05 0.000757562193101947
+ 2.5216e-05 0.000645234670222398
+ 2.5218e-05 0.000783749101547453
+ 2.522e-05 0.000831202011273885
+ 2.5222e-05 0.000957404338144997
+ 2.5224e-05 0.000928070125354551
+ 2.5226e-05 0.00101082574876928
+ 2.5228e-05 0.000742184997694035
+ 2.523e-05 0.000703468664631004
+ 2.5232e-05 0.000626291109120291
+ 2.5234e-05 0.000721509077368611
+ 2.5236e-05 0.000496476203809072
+ 2.5238e-05 0.000480251112220924
+ 2.524e-05 0.000444062733273484
+ 2.5242e-05 0.000890414543557527
+ 2.5244e-05 0.000950373931232016
+ 2.5246e-05 0.00113068681125921
+ 2.5248e-05 0.00139878436912535
+ 2.525e-05 0.00150482034723286
+ 2.5252e-05 0.00131055048298303
+ 2.5254e-05 0.00149196741650959
+ 2.5256e-05 0.00169851771977873
+ 2.5258e-05 0.0016540564552804
+ 2.526e-05 0.00171387693968944
+ 2.5262e-05 0.00153287655873755
+ 2.5264e-05 0.00154021684977098
+ 2.5266e-05 0.00146960711823889
+ 2.5268e-05 0.00142604859896278
+ 2.527e-05 0.00153099679936478
+ 2.5272e-05 0.00147077909213104
+ 2.5274e-05 0.00179604401266756
+ 2.5276e-05 0.00153737851555551
+ 2.5278e-05 0.0015101234753684
+ 2.528e-05 0.00164171799203081
+ 2.5282e-05 0.0017189652611362
+ 2.5284e-05 0.00164341637707792
+ 2.5286e-05 0.00176885213531584
+ 2.5288e-05 0.00196433032453392
+ 2.529e-05 0.00245273240602869
+ 2.5292e-05 0.00220532613983469
+ 2.5294e-05 0.00246748255388703
+ 2.5296e-05 0.00238424489280219
+ 2.5298e-05 0.00268250489940738
+ 2.53e-05 0.00244609351883223
+ 2.5302e-05 0.00247939005326053
+ 2.5304e-05 0.00279616349046825
+ 2.5306e-05 0.00251043602043148
+ 2.5308e-05 0.00260092639112274
+ 2.531e-05 0.00245097271409034
+ 2.5312e-05 0.00243280298261554
+ 2.5314e-05 0.00239991492554673
+ 2.5316e-05 0.0026341046744989
+ 2.5318e-05 0.0027998339300334
+ 2.532e-05 0.00260264035022946
+ 2.5322e-05 0.00244486100446649
+ 2.5324e-05 0.00241176206948268
+ 2.5326e-05 0.00223995598064168
+ 2.5328e-05 0.00199386854003547
+ 2.533e-05 0.00192414161774879
+ 2.5332e-05 0.0020867107843008
+ 2.5334e-05 0.00196781030851723
+ 2.5336e-05 0.00213762020952922
+ 2.5338e-05 0.00207376415908806
+ 2.534e-05 0.00227487781685913
+ 2.5342e-05 0.00225463679020619
+ 2.5344e-05 0.00190744542969277
+ 2.5346e-05 0.00209567988615094
+ 2.5348e-05 0.00191355859565604
+ 2.535e-05 0.0022988433880799
+ 2.5352e-05 0.00214501194608208
+ 2.5354e-05 0.00194321973469684
+ 2.5356e-05 0.00176065123923774
+ 2.5358e-05 0.001918532306036
+ 2.536e-05 0.00229275200741341
+ 2.5362e-05 0.00202283459985259
+ 2.5364e-05 0.001899008315446
+ 2.5366e-05 0.00180007466106263
+ 2.5368e-05 0.00194909487671415
+ 2.537e-05 0.00200686613012752
+ 2.5372e-05 0.00167480821779397
+ 2.5374e-05 0.0019672403459429
+ 2.5376e-05 0.00174679853725336
+ 2.5378e-05 0.00186167206334954
+ 2.538e-05 0.00188769000508558
+ 2.5382e-05 0.00209357649494838
+ 2.5384e-05 0.00212823633343972
+ 2.5386e-05 0.00198812667338819
+ 2.5388e-05 0.00196622152873353
+ 2.539e-05 0.00225634922461884
+ 2.5392e-05 0.00189240003837617
+ 2.5394e-05 0.00205510607214667
+ 2.5396e-05 0.00184985865603406
+ 2.5398e-05 0.00165557897066342
+ 2.54e-05 0.00150641612217776
+ 2.5402e-05 0.00142106398623499
+ 2.5404e-05 0.00187226717057814
+ 2.5406e-05 0.00195962540711931
+ 2.5408e-05 0.00204727578082427
+ 2.541e-05 0.0021983459903875
+ 2.5412e-05 0.00214611006565124
+ 2.5414e-05 0.00196474596109302
+ 2.5416e-05 0.00164244242712771
+ 2.5418e-05 0.0016622004885993
+ 2.542e-05 0.0017403621268643
+ 2.5422e-05 0.00186718442156742
+ 2.5424e-05 0.00174363530955927
+ 2.5426e-05 0.00172254746987539
+ 2.5428e-05 0.00142321593021088
+ 2.543e-05 0.00149642811958951
+ 2.5432e-05 0.00185668416775368
+ 2.5434e-05 0.00211118926570564
+ 2.5436e-05 0.0023355109864319
+ 2.5438e-05 0.00193592840944644
+ 2.544e-05 0.00151298089433222
+ 2.5442e-05 0.00103354078693805
+ 2.5444e-05 0.000905865234581047
+ 2.5446e-05 0.000952324076802378
+ 2.5448e-05 0.000890674406406614
+ 2.545e-05 0.000631455472248645
+ 2.5452e-05 0.000605136286714019
+ 2.5454e-05 0.000595141660968346
+ 2.5456e-05 0.000725221828262045
+ 2.5458e-05 0.000490836013679052
+ 2.546e-05 0.000337887022486614
+ 2.5462e-05 0.000472899416571294
+ 2.5464e-05 0.000118068367105042
+ 2.5466e-05 -0.000422481876739086
+ 2.5468e-05 -0.000636218550583015
+ 2.547e-05 -0.000697498069555244
+ 2.5472e-05 -0.000348983930026089
+ 2.5474e-05 -0.000484687898589359
+ 2.5476e-05 -0.000480001286020698
+ 2.5478e-05 -0.000643177180452424
+ 2.548e-05 -0.00105014640711118
+ 2.5482e-05 -0.000876940298535706
+ 2.5484e-05 -0.00103831955277912
+ 2.5486e-05 -0.000857983493494245
+ 2.5488e-05 -0.00104737763580661
+ 2.549e-05 -0.00112785923815843
+ 2.5492e-05 -0.00122610517327415
+ 2.5494e-05 -0.000647581575228908
+ 2.5496e-05 -0.000801374843010971
+ 2.5498e-05 -0.00053621179007452
+ 2.55e-05 -0.00044728499495686
+ 2.5502e-05 -0.000730593631137271
+ 2.5504e-05 -0.000833233801416527
+ 2.5506e-05 -0.000688707115347728
+ 2.5508e-05 -0.000926208446695702
+ 2.551e-05 -0.000805534904416176
+ 2.5512e-05 -0.00099695215985808
+ 2.5514e-05 -0.00116298107385618
+ 2.5516e-05 -0.00122948338273427
+ 2.5518e-05 -0.00129834670853366
+ 2.552e-05 -0.00125984905278203
+ 2.5522e-05 -0.00116110137293108
+ 2.5524e-05 -0.00114010005646521
+ 2.5526e-05 -0.00112658519873958
+ 2.5528e-05 -0.00081089329659169
+ 2.553e-05 -0.00107730720958971
+ 2.5532e-05 -0.000975295740429568
+ 2.5534e-05 -0.000895864516326534
+ 2.5536e-05 -0.000481453933562643
+ 2.5538e-05 -0.000925972617417054
+ 2.554e-05 -0.000854509173028429
+ 2.5542e-05 -0.00111825722026942
+ 2.5544e-05 -0.000851565070250076
+ 2.5546e-05 -0.00102035350116036
+ 2.5548e-05 -0.000792497927390478
+ 2.555e-05 -0.000857381977973171
+ 2.5552e-05 -0.00100825869430281
+ 2.5554e-05 -0.00114993419137201
+ 2.5556e-05 -0.000889280207730637
+ 2.5558e-05 -0.0010074162960982
+ 2.556e-05 -0.000970110916459257
+ 2.5562e-05 -0.000721884441660085
+ 2.5564e-05 -0.000524047403998324
+ 2.5566e-05 2.9071183401848e-05
+ 2.5568e-05 0.000142792272782385
+ 2.557e-05 -5.74333601071408e-05
+ 2.5572e-05 -0.000244592181445247
+ 2.5574e-05 -0.000200659189430117
+ 2.5576e-05 -0.000177936570903204
+ 2.5578e-05 0.000115494854107446
+ 2.558e-05 0.000343350653148591
+ 2.5582e-05 -3.12885132092268e-05
+ 2.5584e-05 0.000199706007979648
+ 2.5586e-05 -3.35341043146575e-05
+ 2.5588e-05 -0.000353145977929306
+ 2.559e-05 -0.000340815552596903
+ 2.5592e-05 -4.90165596393387e-05
+ 2.5594e-05 -0.000115218950030289
+ 2.5596e-05 -5.87682958753126e-05
+ 2.5598e-05 -0.000329432528023175
+ 2.56e-05 -0.000321497151811499
+ 2.5602e-05 -0.000560506919061592
+ 2.5604e-05 -0.000530614064320517
+ 2.5606e-05 -0.000521219619851686
+ 2.5608e-05 -0.000315165310561726
+ 2.561e-05 0.000135461776785043
+ 2.5612e-05 -0.00014522744338255
+ 2.5614e-05 -9.58828678506223e-05
+ 2.5616e-05 -0.000230071118648357
+ 2.5618e-05 -8.89914250527967e-05
+ 2.562e-05 -0.000285258264916827
+ 2.5622e-05 -0.000374006463045528
+ 2.5624e-05 -0.000285165632389142
+ 2.5626e-05 -1.68722923058988e-05
+ 2.5628e-05 0.000183202857603126
+ 2.563e-05 0.000271873689645477
+ 2.5632e-05 0.000374341493579768
+ 2.5634e-05 0.000201398388480461
+ 2.5636e-05 2.35775151806478e-05
+ 2.5638e-05 0.00038934307794069
+ 2.564e-05 0.000234166150897421
+ 2.5642e-05 0.000369004567048623
+ 2.5644e-05 0.000788305826733863
+ 2.5646e-05 0.000933715983400975
+ 2.5648e-05 0.000791628317176877
+ 2.565e-05 0.000909370373687042
+ 2.5652e-05 0.000651265484455751
+ 2.5654e-05 0.000449125059504799
+ 2.5656e-05 0.000142834562742702
+ 2.5658e-05 -0.00014138556581238
+ 2.566e-05 -0.000187268272837443
+ 2.5662e-05 -0.000493119681080865
+ 2.5664e-05 -0.000856018438392676
+ 2.5666e-05 -0.000710916518233902
+ 2.5668e-05 -0.000399232896442793
+ 2.567e-05 -0.00023255351100146
+ 2.5672e-05 -0.000267402641568062
+ 2.5674e-05 -0.000182294839444176
+ 2.5676e-05 -0.000129482026026954
+ 2.5678e-05 -0.000462400892972502
+ 2.568e-05 -0.000532477391217237
+ 2.5682e-05 -7.02580796289794e-05
+ 2.5684e-05 5.21791950600674e-05
+ 2.5686e-05 -5.08754064231972e-05
+ 2.5688e-05 0.000236903428213103
+ 2.569e-05 0.000172520598690945
+ 2.5692e-05 0.000224872987562229
+ 2.5694e-05 0.000165712571986298
+ 2.5696e-05 0.000165737787430315
+ 2.5698e-05 0.000129459828527549
+ 2.57e-05 0.000107877086368485
+ 2.5702e-05 0.00043642569920076
+ 2.5704e-05 0.000268461770199997
+ 2.5706e-05 7.67082152897131e-05
+ 2.5708e-05 0.000242726355766973
+ 2.571e-05 0.00026818127821735
+ 2.5712e-05 0.000378702298551636
+ 2.5714e-05 0.00037920045437335
+ 2.5716e-05 0.000368706825588029
+ 2.5718e-05 0.000568652385195541
+ 2.572e-05 0.000180499582440363
+ 2.5722e-05 0.000382995649867604
+ 2.5724e-05 0.000201751489175426
+ 2.5726e-05 0.000217717783598644
+ 2.5728e-05 0.00034696259729225
+ 2.573e-05 0.00011375642049457
+ 2.5732e-05 -0.000114113986844859
+ 2.5734e-05 -0.000393291137834186
+ 2.5736e-05 -0.000654300610087131
+ 2.5738e-05 -0.00021525379495925
+ 2.574e-05 -0.000130212160188468
+ 2.5742e-05 0.000174112288357023
+ 2.5744e-05 -1.43793199661657e-05
+ 2.5746e-05 2.32110526829138e-05
+ 2.5748e-05 -0.000551981718941283
+ 2.575e-05 -0.000289553988230871
+ 2.5752e-05 -0.000477782602838694
+ 2.5754e-05 -0.000508119044638655
+ 2.5756e-05 -0.000307327391666536
+ 2.5758e-05 -0.0003034684104415
+ 2.576e-05 -0.000453696579567143
+ 2.5762e-05 -0.000256242393383211
+ 2.5764e-05 -0.000390982998339725
+ 2.5766e-05 -0.000295034687748638
+ 2.5768e-05 -0.000410413443763604
+ 2.577e-05 -0.000317738833691584
+ 2.5772e-05 -9.72773200891475e-05
+ 2.5774e-05 0.00018381094743675
+ 2.5776e-05 0.00031981060548073
+ 2.5778e-05 0.00014977202063748
+ 2.578e-05 -1.98835875769118e-05
+ 2.5782e-05 -0.000129705392293605
+ 2.5784e-05 -7.38687487207224e-06
+ 2.5786e-05 9.42846466587021e-05
+ 2.5788e-05 0.000437259643346648
+ 2.579e-05 0.000424356022011612
+ 2.5792e-05 0.000212929504545416
+ 2.5794e-05 0.000525973695442977
+ 2.5796e-05 0.000379725798044395
+ 2.5798e-05 0.000358843826101304
+ 2.58e-05 0.000661324431840496
+ 2.5802e-05 0.000504899568217038
+ 2.5804e-05 0.000942747984498854
+ 2.5806e-05 0.000765573705844347
+ 2.5808e-05 0.000305991720927588
+ 2.581e-05 0.000100189288203425
+ 2.5812e-05 0.00011917936715475
+ 2.5814e-05 3.53089780278044e-05
+ 2.5816e-05 0.000110360612048223
+ 2.5818e-05 -2.40143128888245e-05
+ 2.582e-05 -0.000134265359041222
+ 2.5822e-05 -0.000146437191973033
+ 2.5824e-05 -0.000574937745426437
+ 2.5826e-05 -0.000485259567311515
+ 2.5828e-05 -0.000450209631003114
+ 2.583e-05 -0.000806298149716294
+ 2.5832e-05 -0.000880123258091537
+ 2.5834e-05 -0.000779557720380057
+ 2.5836e-05 -0.000699016741318927
+ 2.5838e-05 -0.000576820871191202
+ 2.584e-05 -0.000783650671063027
+ 2.5842e-05 -0.000672523543083768
+ 2.5844e-05 -0.000494459613287234
+ 2.5846e-05 -0.000334178537066727
+ 2.5848e-05 -0.000607585343467657
+ 2.585e-05 -0.000884288935763608
+ 2.5852e-05 -0.00100448325579525
+ 2.5854e-05 -0.000779649331773856
+ 2.5856e-05 -0.000768902077602436
+ 2.5858e-05 -0.000498855646998502
+ 2.586e-05 -0.000701615333364522
+ 2.5862e-05 -0.00020424018837167
+ 2.5864e-05 4.5201508908216e-05
+ 2.5866e-05 0.00012285617548314
+ 2.5868e-05 -0.000167299692931352
+ 2.587e-05 -0.000204976797823346
+ 2.5872e-05 -2.06196876387261e-05
+ 2.5874e-05 -0.000286101632954909
+ 2.5876e-05 -4.52539804180694e-05
+ 2.5878e-05 0.000154974401735017
+ 2.588e-05 3.69280282402424e-05
+ 2.5882e-05 0.000167721184328034
+ 2.5884e-05 0.000247429749048981
+ 2.5886e-05 -1.47793952374974e-05
+ 2.5888e-05 7.57960147145833e-05
+ 2.589e-05 -0.000100677223347817
+ 2.5892e-05 -4.42171167661985e-05
+ 2.5894e-05 -1.72710664094651e-05
+ 2.5896e-05 0.000109878711643652
+ 2.5898e-05 -0.000126670432522471
+ 2.59e-05 -0.000318754978081145
+ 2.5902e-05 -0.000141832147892513
+ 2.5904e-05 0.000152241896650703
+ 2.5906e-05 -4.98637298139455e-05
+ 2.5908e-05 -0.000348267433405436
+ 2.591e-05 -0.000712033393044571
+ 2.5912e-05 -0.000987138207560369
+ 2.5914e-05 -0.000950768362975408
+ 2.5916e-05 -0.00105928261458439
+ 2.5918e-05 -0.000833934954386645
+ 2.592e-05 -0.000580483484098133
+ 2.5922e-05 -0.000299559739844019
+ 2.5924e-05 -8.31150672260222e-05
+ 2.5926e-05 -0.000322589707883397
+ 2.5928e-05 -9.53600847018772e-05
+ 2.593e-05 -5.95286826705693e-05
+ 2.5932e-05 -0.00026081443973033
+ 2.5934e-05 -0.00038863040671074
+ 2.5936e-05 0.000114954679895491
+ 2.5938e-05 -0.000153330556517637
+ 2.594e-05 7.02894865219833e-05
+ 2.5942e-05 0.000357123737450763
+ 2.5944e-05 0.000192354268354178
+ 2.5946e-05 4.99741983926615e-05
+ 2.5948e-05 -0.00035964329294309
+ 2.595e-05 5.66150626543116e-06
+ 2.5952e-05 -9.12576227753759e-05
+ 2.5954e-05 -0.000450909781108268
+ 2.5956e-05 -0.00046498730386687
+ 2.5958e-05 -0.000422314813173066
+ 2.596e-05 -0.000298623621059026
+ 2.5962e-05 -5.42294555143873e-05
+ 2.5964e-05 0.000303706603297827
+ 2.5966e-05 0.000273590137795543
+ 2.5968e-05 0.000635256220224431
+ 2.597e-05 0.000648026552741247
+ 2.5972e-05 0.000409750732404482
+ 2.5974e-05 0.000259747057703463
+ 2.5976e-05 0.000465114886277955
+ 2.5978e-05 0.000712982713176108
+ 2.598e-05 0.000447698847930918
+ 2.5982e-05 0.000305524856303096
+ 2.5984e-05 0.000298286436058832
+ 2.5986e-05 0.000411042266713204
+ 2.5988e-05 0.000371081520973526
+ 2.599e-05 5.5333150050256e-05
+ 2.5992e-05 0.000103405287565945
+ 2.5994e-05 7.55871103070553e-05
+ 2.5996e-05 0.000235027076254155
+ 2.5998e-05 0.000151312065984404
+ 2.6e-05 0.00019243169974398
+ 2.6002e-05 0.000102527024619796
+ 2.6004e-05 -0.000117156652032258
+ 2.6006e-05 -0.000139832672250331
+ 2.6008e-05 -0.000242824200036455
+ 2.601e-05 -0.000464178756724138
+ 2.6012e-05 -0.000239175260374787
+ 2.6014e-05 -2.55222779519279e-05
+ 2.6016e-05 0.000383524822048533
+ 2.6018e-05 3.37492360217384e-05
+ 2.602e-05 0.000251584497008661
+ 2.6022e-05 8.70669499598079e-06
+ 2.6024e-05 -9.39043555917664e-05
+ 2.6026e-05 0.000282833651045884
+ 2.6028e-05 0.00032149418248897
+ 2.603e-05 1.00233664021565e-06
+ 2.6032e-05 7.75293477866587e-05
+ 2.6034e-05 0.000274739331681462
+ 2.6036e-05 0.000189619860330798
+ 2.6038e-05 -5.51836351267517e-05
+ 2.604e-05 2.85021048828057e-05
+ 2.6042e-05 0.00026567395035889
+ 2.6044e-05 0.000176237120517149
+ 2.6046e-05 0.000395781790361449
+ 2.6048e-05 0.000181502321292582
+ 2.605e-05 0.000166607140454152
+ 2.6052e-05 2.86842398456001e-05
+ 2.6054e-05 0.00022313382936719
+ 2.6056e-05 -4.24995280818885e-06
+ 2.6058e-05 7.29895190170944e-05
+ 2.606e-05 -6.58414991825121e-05
+ 2.6062e-05 0.000181333114466603
+ 2.6064e-05 0.000180421490312554
+ 2.6066e-05 0.000605978444417797
+ 2.6068e-05 0.000786841021479239
+ 2.607e-05 0.00080198639301606
+ 2.6072e-05 0.000462823357314301
+ 2.6074e-05 0.000368530652572372
+ 2.6076e-05 0.000281438514125321
+ 2.6078e-05 0.000276297141836083
+ 2.608e-05 0.000393285004842401
+ 2.6082e-05 0.000387814939245323
+ 2.6084e-05 0.000449715390393236
+ 2.6086e-05 0.000500197149192006
+ 2.6088e-05 0.000264245971158671
+ 2.609e-05 0.000267551213122696
+ 2.6092e-05 0.00040627599428747
+ 2.6094e-05 0.000477218751390123
+ 2.6096e-05 0.000394765388159005
+ 2.6098e-05 0.00055646177185484
+ 2.61e-05 0.000732013965487591
+ 2.6102e-05 0.00023008588244677
+ 2.6104e-05 0.0001213468463057
+ 2.6106e-05 0.000304509337748086
+ 2.6108e-05 0.000101255793613418
+ 2.611e-05 0.000398417734807407
+ 2.6112e-05 0.000317192030233509
+ 2.6114e-05 0.000279798646417595
+ 2.6116e-05 0.000268812622273423
+ 2.6118e-05 0.00046634014173195
+ 2.612e-05 0.000509965998568691
+ 2.6122e-05 0.000321311497933881
+ 2.6124e-05 0.000128340311395624
+ 2.6126e-05 0.000122225878309209
+ 2.6128e-05 0.000343738897846381
+ 2.613e-05 0.00043592401725746
+ 2.6132e-05 0.00068044172578441
+ 2.6134e-05 0.000708250504051471
+ 2.6136e-05 0.000477176838487662
+ 2.6138e-05 0.000788345738545616
+ 2.614e-05 0.000681651708480563
+ 2.6142e-05 0.000398208304095438
+ 2.6144e-05 0.000401535386811098
+ 2.6146e-05 0.000242632370649145
+ 2.6148e-05 0.000589462508956978
+ 2.615e-05 0.000761370429093675
+ 2.6152e-05 0.000563716162975296
+ 2.6154e-05 0.000544292781757136
+ 2.6156e-05 0.000583561163806623
+ 2.6158e-05 0.000690460056921425
+ 2.616e-05 0.0007987431308304
+ 2.6162e-05 0.0008419526755897
+ 2.6164e-05 0.000500322198920144
+ 2.6166e-05 0.000506687628370694
+ 2.6168e-05 0.000771501654495753
+ 2.617e-05 0.00105565806550418
+ 2.6172e-05 0.000913088965009084
+ 2.6174e-05 0.000929757831581755
+ 2.6176e-05 0.000858306982732839
+ 2.6178e-05 0.000734537444290417
+ 2.618e-05 0.000625255236761694
+ 2.6182e-05 0.00106570948342784
+ 2.6184e-05 0.0014117600053777
+ 2.6186e-05 0.00143008033982804
+ 2.6188e-05 0.00143129807916822
+ 2.619e-05 0.00159344040091552
+ 2.6192e-05 0.00154879868129204
+ 2.6194e-05 0.00184901497570921
+ 2.6196e-05 0.00216120820741744
+ 2.6198e-05 0.00197641164260675
+ 2.62e-05 0.00222704779698929
+ 2.6202e-05 0.00218090755597939
+ 2.6204e-05 0.00230109685926091
+ 2.6206e-05 0.00218407075334878
+ 2.6208e-05 0.00212411437646529
+ 2.621e-05 0.00252079717850311
+ 2.6212e-05 0.00179474722480892
+ 2.6214e-05 0.00151849147155791
+ 2.6216e-05 0.00114335272979946
+ 2.6218e-05 0.000889744814292469
+ 2.622e-05 0.00103604810772944
+ 2.6222e-05 0.000909262379694504
+ 2.6224e-05 0.000711313167813355
+ 2.6226e-05 0.000196847809748634
+ 2.6228e-05 0.000320735629684548
+ 2.623e-05 0.000116902476275004
+ 2.6232e-05 0.000657106277585101
+ 2.6234e-05 0.000291682963454585
+ 2.6236e-05 0.000335336229597667
+ 2.6238e-05 0.000340909504643607
+ 2.624e-05 0.000395006339296169
+ 2.6242e-05 0.00035306846576589
+ 2.6244e-05 0.000467045661283983
+ 2.6246e-05 0.000492896615348594
+ 2.6248e-05 0.000627284545080839
+ 2.625e-05 0.000515359445802781
+ 2.6252e-05 0.000462844133798929
+ 2.6254e-05 0.000513480395075152
+ 2.6256e-05 0.000674175897316048
+ 2.6258e-05 0.000727202807408245
+ 2.626e-05 0.00048376576074349
+ 2.6262e-05 0.000785189431425842
+ 2.6264e-05 0.000628046212802471
+ 2.6266e-05 0.000600613836639951
+ 2.6268e-05 0.000882042871618244
+ 2.627e-05 0.00100330383015086
+ 2.6272e-05 0.000701055503954167
+ 2.6274e-05 0.000531239529117888
+ 2.6276e-05 0.000455366102611883
+ 2.6278e-05 0.000811159808528826
+ 2.628e-05 0.000917862630720042
+ 2.6282e-05 0.000753106695455968
+ 2.6284e-05 0.000630276239710207
+ 2.6286e-05 0.00077388234928764
+ 2.6288e-05 0.000525439212826369
+ 2.629e-05 0.000466597282540655
+ 2.6292e-05 0.000820312451811887
+ 2.6294e-05 0.000665299004843275
+ 2.6296e-05 0.000801699884676063
+ 2.6298e-05 0.000682635730655967
+ 2.63e-05 0.000836416531985107
+ 2.6302e-05 0.000835710810943202
+ 2.6304e-05 0.00104242136753574
+ 2.6306e-05 0.00152669287102339
+ 2.6308e-05 0.00170299362828684
+ 2.631e-05 0.00152630777976164
+ 2.6312e-05 0.0014149516186545
+ 2.6314e-05 0.00123016477888928
+ 2.6316e-05 0.00104322602003874
+ 2.6318e-05 0.000747023484856711
+ 2.632e-05 0.000629364314758494
+ 2.6322e-05 0.000783275396028785
+ 2.6324e-05 0.000585417794054918
+ 2.6326e-05 0.000524010277503603
+ 2.6328e-05 -1.27728123411809e-05
+ 2.633e-05 0.000117115672920523
+ 2.6332e-05 -0.000170895384722529
+ 2.6334e-05 -0.00014653310657716
+ 2.6336e-05 -0.000210494638647759
+ 2.6338e-05 -0.000752699792458381
+ 2.634e-05 -0.000525191404395032
+ 2.6342e-05 -0.000310348939833812
+ 2.6344e-05 -0.000414742635273873
+ 2.6346e-05 -0.000406670110491763
+ 2.6348e-05 -0.000175633833662631
+ 2.635e-05 -0.00022082107184597
+ 2.6352e-05 9.59993784338053e-05
+ 2.6354e-05 2.81062303553356e-06
+ 2.6356e-05 -0.000131849975059551
+ 2.6358e-05 8.58522138510794e-05
+ 2.636e-05 0.000104851867146941
+ 2.6362e-05 -0.00013185103970266
+ 2.6364e-05 -0.000112400431305973
+ 2.6366e-05 -2.32310912992226e-05
+ 2.6368e-05 0.000236282777082647
+ 2.637e-05 0.000389129173630116
+ 2.6372e-05 0.00039181401391365
+ 2.6374e-05 0.00042712202899515
+ 2.6376e-05 0.000723122864963698
+ 2.6378e-05 0.000558010615553953
+ 2.638e-05 0.000534890307372225
+ 2.6382e-05 0.00034545182057054
+ 2.6384e-05 0.000200563213137518
+ 2.6386e-05 -0.000110520152324674
+ 2.6388e-05 -0.00029164178550407
+ 2.639e-05 -0.000417207979291708
+ 2.6392e-05 -0.00067134577719843
+ 2.6394e-05 -0.00054728818352425
+ 2.6396e-05 -0.000691011639934299
+ 2.6398e-05 -0.000721643531922731
+ 2.64e-05 -0.000430622621631649
+ 2.6402e-05 -0.000544363824250336
+ 2.6404e-05 -0.000391104718045786
+ 2.6406e-05 -0.000364764024973269
+ 2.6408e-05 -0.000279752065416185
+ 2.641e-05 -0.000351741270379504
+ 2.6412e-05 -0.000381134156888021
+ 2.6414e-05 -0.000373283920991444
+ 2.6416e-05 -0.000296455424780172
+ 2.6418e-05 -0.000461252504179711
+ 2.642e-05 -0.000462551463923941
+ 2.6422e-05 -0.00076049507328072
+ 2.6424e-05 -0.00112873864480241
+ 2.6426e-05 -0.000935392061363067
+ 2.6428e-05 -0.00104772393311777
+ 2.643e-05 -0.00091665441147902
+ 2.6432e-05 -0.000660325241235825
+ 2.6434e-05 -0.00083371663284646
+ 2.6436e-05 -0.00109685915029237
+ 2.6438e-05 -0.00117979823521775
+ 2.644e-05 -0.0012725835085285
+ 2.6442e-05 -0.000927358173729476
+ 2.6444e-05 -0.000734659442449269
+ 2.6446e-05 -0.000478343297444185
+ 2.6448e-05 -0.000613691821778562
+ 2.645e-05 -0.000929822871088613
+ 2.6452e-05 -0.00110248212862487
+ 2.6454e-05 -0.00124052962427748
+ 2.6456e-05 -0.00130286827476966
+ 2.6458e-05 -0.000973732813000112
+ 2.646e-05 -0.00114577642934082
+ 2.6462e-05 -0.000924156286368737
+ 2.6464e-05 -0.000855294440680063
+ 2.6466e-05 -0.000936729517661486
+ 2.6468e-05 -0.000693869577070481
+ 2.647e-05 -0.0007447426678832
+ 2.6472e-05 -0.000617092432072448
+ 2.6474e-05 -0.000603460954889086
+ 2.6476e-05 -0.000341550982747627
+ 2.6478e-05 -0.000530934877412187
+ 2.648e-05 -0.000312503088542312
+ 2.6482e-05 -0.00068819952157558
+ 2.6484e-05 -0.000733838993717763
+ 2.6486e-05 -0.000666281995216849
+ 2.6488e-05 -0.000775302668472662
+ 2.649e-05 -0.000733496658612816
+ 2.6492e-05 -0.000786426924622336
+ 2.6494e-05 -0.000941642195914307
+ 2.6496e-05 -0.000936875452360927
+ 2.6498e-05 -0.000800138100431875
+ 2.65e-05 -0.000984624164631196
+ 2.6502e-05 -0.00107615532584798
+ 2.6504e-05 -0.00121830788234574
+ 2.6506e-05 -0.00114612963767503
+ 2.6508e-05 -0.000679148572779665
+ 2.651e-05 -0.00082170191918898
+ 2.6512e-05 -0.000729531528542171
+ 2.6514e-05 -0.000701058070289533
+ 2.6516e-05 -0.00076689537254068
+ 2.6518e-05 -0.00114396816036218
+ 2.652e-05 -0.00111052714233876
+ 2.6522e-05 -0.00114187538865562
+ 2.6524e-05 -0.00114342880781803
+ 2.6526e-05 -0.00120654722051044
+ 2.6528e-05 -0.00111205978539581
+ 2.653e-05 -0.00141524625720668
+ 2.6532e-05 -0.00162057127835371
+ 2.6534e-05 -0.00157060625291454
+ 2.6536e-05 -0.0015209540818298
+ 2.6538e-05 -0.00100170253000101
+ 2.654e-05 -0.00100082606348622
+ 2.6542e-05 -0.00110517979034173
+ 2.6544e-05 -0.000895671573942871
+ 2.6546e-05 -0.00089579207567338
+ 2.6548e-05 -0.000413027820028738
+ 2.655e-05 -0.00036972878400171
+ 2.6552e-05 -0.000759698028235287
+ 2.6554e-05 -0.000808442986239247
+ 2.6556e-05 -0.000747657909937562
+ 2.6558e-05 -0.0011181549861935
+ 2.656e-05 -0.00106254567246304
+ 2.6562e-05 -0.00123434487328734
+ 2.6564e-05 -0.00104709188472281
+ 2.6566e-05 -0.000777768755916707
+ 2.6568e-05 -0.000539858927061989
+ 2.657e-05 -0.000386849928944175
+ 2.6572e-05 -0.000616554087094721
+ 2.6574e-05 -0.000433873213431594
+ 2.6576e-05 -0.000118684511646716
+ 2.6578e-05 -8.49036635837218e-05
+ 2.658e-05 0.000311175886920604
+ 2.6582e-05 0.000342719073710415
+ 2.6584e-05 0.000184058674817122
+ 2.6586e-05 -0.000203701063032395
+ 2.6588e-05 -0.000237802241924083
+ 2.659e-05 0.000219838430736437
+ 2.6592e-05 0.00035006036850187
+ 2.6594e-05 0.000226238432390841
+ 2.6596e-05 0.000330953989603209
+ 2.6598e-05 0.000448922276757066
+ 2.66e-05 0.00059058395279897
+ 2.6602e-05 0.000474657835121259
+ 2.6604e-05 0.00047692649938523
+ 2.6606e-05 0.000856691443777247
+ 2.6608e-05 0.00115499099914002
+ 2.661e-05 0.00131888748657616
+ 2.6612e-05 0.00138650696461168
+ 2.6614e-05 0.00111400015447443
+ 2.6616e-05 0.000919450516316872
+ 2.6618e-05 0.000689214128005064
+ 2.662e-05 0.000741504701217928
+ 2.6622e-05 0.00090301554671037
+ 2.6624e-05 0.000828562464580406
+ 2.6626e-05 0.00100944780386043
+ 2.6628e-05 0.00100705879762707
+ 2.663e-05 0.000769979818279463
+ 2.6632e-05 0.000705272060100512
+ 2.6634e-05 0.000601523146542174
+ 2.6636e-05 0.000553480170405322
+ 2.6638e-05 0.000318888945368167
+ 2.664e-05 1.02199545258462e-05
+ 2.6642e-05 -0.000273406629408224
+ 2.6644e-05 -0.000333596826182819
+ 2.6646e-05 -0.000477546047456628
+ 2.6648e-05 -0.000276161152871744
+ 2.665e-05 -0.000229828066616373
+ 2.6652e-05 -0.000413719378404635
+ 2.6654e-05 -0.000253612182015532
+ 2.6656e-05 -0.000893502413473862
+ 2.6658e-05 -0.00108491626713747
+ 2.666e-05 -0.00103862569465804
+ 2.6662e-05 -0.00130401771680701
+ 2.6664e-05 -0.00129338615829851
+ 2.6666e-05 -0.00136217508085371
+ 2.6668e-05 -0.00138129992142962
+ 2.667e-05 -0.00157679786262425
+ 2.6672e-05 -0.00172895260669787
+ 2.6674e-05 -0.00166231081371606
+ 2.6676e-05 -0.00154494701851626
+ 2.6678e-05 -0.00121784468666005
+ 2.668e-05 -0.000990794666167009
+ 2.6682e-05 -0.000850588020790837
+ 2.6684e-05 -0.000621863156656127
+ 2.6686e-05 -0.000807216866522529
+ 2.6688e-05 -0.00100351759928554
+ 2.669e-05 -0.00124050901658461
+ 2.6692e-05 -0.000765182561833662
+ 2.6694e-05 -0.000711995650928417
+ 2.6696e-05 -0.000812918403426078
+ 2.6698e-05 -0.000912036034160541
+ 2.67e-05 -0.00106537474925293
+ 2.6702e-05 -0.00128374657910857
+ 2.6704e-05 -0.00120933781757436
+ 2.6706e-05 -0.00110421501240509
+ 2.6708e-05 -0.000910526142977288
+ 2.671e-05 -0.00100606844911621
+ 2.6712e-05 -0.00107713563908224
+ 2.6714e-05 -0.000994068133657997
+ 2.6716e-05 -0.000946148360313861
+ 2.6718e-05 -0.00105721409237031
+ 2.672e-05 -0.000811874812180513
+ 2.6722e-05 -0.000859610183838023
+ 2.6724e-05 -0.000710092096289319
+ 2.6726e-05 -0.000692897964863346
+ 2.6728e-05 -0.000657038173631591
+ 2.673e-05 -0.000892680230328939
+ 2.6732e-05 -0.00098110546786628
+ 2.6734e-05 -0.00100469736133777
+ 2.6736e-05 -0.00126459824276408
+ 2.6738e-05 -0.00106540673126192
+ 2.674e-05 -0.00079296950334236
+ 2.6742e-05 -0.000684904075041193
+ 2.6744e-05 -0.000666080140212426
+ 2.6746e-05 -0.00046859877917437
+ 2.6748e-05 -0.000409890995392776
+ 2.675e-05 -0.000596347211606131
+ 2.6752e-05 -0.000647663302996321
+ 2.6754e-05 -0.000772587360162269
+ 2.6756e-05 -0.000684164770298041
+ 2.6758e-05 -0.00138923651163004
+ 2.676e-05 -0.00123080825329622
+ 2.6762e-05 -0.00120851366215213
+ 2.6764e-05 -0.00104902056234058
+ 2.6766e-05 -0.00111886541841505
+ 2.6768e-05 -0.00078383737689769
+ 2.677e-05 -0.00105745068908516
+ 2.6772e-05 -0.00104794120706612
+ 2.6774e-05 -0.00144199937845563
+ 2.6776e-05 -0.00169364604109602
+ 2.6778e-05 -0.00154686293331397
+ 2.678e-05 -0.0011994041602345
+ 2.6782e-05 -0.00101916956218929
+ 2.6784e-05 -0.00103078324922995
+ 2.6786e-05 -0.000675566523180965
+ 2.6788e-05 -0.000673062051147047
+ 2.679e-05 -0.000767502145937352
+ 2.6792e-05 -0.000774572992992514
+ 2.6794e-05 -0.000653641427669148
+ 2.6796e-05 -0.000457017225205591
+ 2.6798e-05 -0.000689816505969445
+ 2.68e-05 -0.000252557290612929
+ 2.6802e-05 -0.000402746502814683
+ 2.6804e-05 -0.000193990997072152
+ 2.6806e-05 -0.000309055462431806
+ 2.6808e-05 -0.000166010539000275
+ 2.681e-05 -0.000136268188712446
+ 2.6812e-05 -2.30381158694308e-05
+ 2.6814e-05 -0.000102567499943098
+ 2.6816e-05 0.000188766492673013
+ 2.6818e-05 0.000109082190940086
+ 2.682e-05 -2.47028195119227e-05
+ 2.6822e-05 -7.31081688472484e-05
+ 2.6824e-05 -0.000183542640273239
+ 2.6826e-05 -0.000267190743684917
+ 2.6828e-05 -7.72362827760125e-05
+ 2.683e-05 -0.000126109498525276
+ 2.6832e-05 -0.000132427505524277
+ 2.6834e-05 -0.000383454042673787
+ 2.6836e-05 -0.000252669580882255
+ 2.6838e-05 -9.85755456847456e-05
+ 2.684e-05 -7.91639160295153e-05
+ 2.6842e-05 -0.000122382081386201
+ 2.6844e-05 -0.000129077205001201
+ 2.6846e-05 -0.000304294906204956
+ 2.6848e-05 -0.000237923974681689
+ 2.685e-05 -8.3471844359303e-06
+ 2.6852e-05 -6.07481923183353e-05
+ 2.6854e-05 9.04800807720863e-05
+ 2.6856e-05 2.65169761983714e-05
+ 2.6858e-05 0.000104270738246962
+ 2.686e-05 0.000241038777723379
+ 2.6862e-05 0.000270062699934205
+ 2.6864e-05 0.000327054697767977
+ 2.6866e-05 0.000405283090301051
+ 2.6868e-05 0.000288056243867024
+ 2.687e-05 0.000212235415844669
+ 2.6872e-05 -0.00013559155747313
+ 2.6874e-05 0.000112511244637144
+ 2.6876e-05 0.000370569397493822
+ 2.6878e-05 0.000257154408731155
+ 2.688e-05 0.000137132150200754
+ 2.6882e-05 0.000162047491597136
+ 2.6884e-05 0.000295970420518146
+ 2.6886e-05 0.000299287778721601
+ 2.6888e-05 0.000392160219218047
+ 2.689e-05 0.000392420003203111
+ 2.6892e-05 0.000229342182925141
+ 2.6894e-05 0.000441506201450547
+ 2.6896e-05 0.000470165774467017
+ 2.6898e-05 0.000323129417743575
+ 2.69e-05 0.000137827785205114
+ 2.6902e-05 0.000352721278829373
+ 2.6904e-05 0.000298377319082234
+ 2.6906e-05 0.000477389852649837
+ 2.6908e-05 0.000671269375878855
+ 2.691e-05 0.000571366976893342
+ 2.6912e-05 0.000252659099274678
+ 2.6914e-05 0.000395453934129371
+ 2.6916e-05 0.000260568679819979
+ 2.6918e-05 0.000392801853499521
+ 2.692e-05 0.000298292393029275
+ 2.6922e-05 0.000315844693081455
+ 2.6924e-05 5.30476713155032e-05
+ 2.6926e-05 -7.79330638673994e-05
+ 2.6928e-05 -5.53230520282304e-05
+ 2.693e-05 1.80979932698866e-05
+ 2.6932e-05 -2.82530561138058e-05
+ 2.6934e-05 0.000158640088311036
+ 2.6936e-05 0.000119251350589618
+ 2.6938e-05 -4.58675150549419e-06
+ 2.694e-05 5.01517060965417e-05
+ 2.6942e-05 0.000291145767354477
+ 2.6944e-05 -0.0001389753378243
+ 2.6946e-05 -0.000328036835715175
+ 2.6948e-05 -0.000356347889923567
+ 2.695e-05 -0.000438835637982919
+ 2.6952e-05 -0.000448414410775858
+ 2.6954e-05 -0.000308627985327747
+ 2.6956e-05 -7.51730439769304e-05
+ 2.6958e-05 -4.66201803812482e-05
+ 2.696e-05 -0.000199398696748275
+ 2.6962e-05 -0.000120348446118615
+ 2.6964e-05 -0.000148404633989163
+ 2.6966e-05 -0.000209467991169694
+ 2.6968e-05 -0.000114258004334131
+ 2.697e-05 -0.000449478153768995
+ 2.6972e-05 -0.000456613958922514
+ 2.6974e-05 -0.000618661134138032
+ 2.6976e-05 -0.000642803776853035
+ 2.6978e-05 -0.000690427680935592
+ 2.698e-05 -0.000733583227362602
+ 2.6982e-05 -0.000849995475397927
+ 2.6984e-05 -0.00074454604614334
+ 2.6986e-05 -0.000890631967028017
+ 2.6988e-05 -0.000935326729279024
+ 2.699e-05 -0.000773283913279092
+ 2.6992e-05 -0.000736609453399462
+ 2.6994e-05 -0.00063684053215306
+ 2.6996e-05 -0.000791917766664652
+ 2.6998e-05 -0.00094159823061266
+ 2.7e-05 -0.000901355270061533
+ 2.7002e-05 -0.00099119856744563
+ 2.7004e-05 -0.000671944724123
+ 2.7006e-05 -0.000618966654147435
+ 2.7008e-05 -0.000645394581829881
+ 2.701e-05 -0.00035102204298893
+ 2.7012e-05 -0.000850004501083266
+ 2.7014e-05 -0.000710120076086047
+ 2.7016e-05 -0.000687035772493682
+ 2.7018e-05 -0.000955949041982106
+ 2.702e-05 -0.00103171111687865
+ 2.7022e-05 -0.00108706159309909
+ 2.7024e-05 -0.00113409282649696
+ 2.7026e-05 -0.000657353886229829
+ 2.7028e-05 -0.00073978644017887
+ 2.703e-05 -0.000536083696353877
+ 2.7032e-05 -0.000706220577562251
+ 2.7034e-05 -0.000353061195349919
+ 2.7036e-05 -0.000244590010101378
+ 2.7038e-05 -0.000224439778249734
+ 2.704e-05 -3.95966725079438e-05
+ 2.7042e-05 -6.16813822225128e-05
+ 2.7044e-05 -0.000591532270024623
+ 2.7046e-05 -0.000618873008361759
+ 2.7048e-05 -0.000620117073474892
+ 2.705e-05 -0.000241380695555535
+ 2.7052e-05 -5.23995187576458e-05
+ 2.7054e-05 -0.000124452178125853
+ 2.7056e-05 9.10658780445857e-06
+ 2.7058e-05 -0.000211778766149311
+ 2.706e-05 -0.000192800643421394
+ 2.7062e-05 -0.000103380513147385
+ 2.7064e-05 -9.16596806736189e-05
+ 2.7066e-05 0.000165349382588111
+ 2.7068e-05 0.000207608102940268
+ 2.707e-05 0.000399642610061485
+ 2.7072e-05 0.000315697667641167
+ 2.7074e-05 0.000440291249004085
+ 2.7076e-05 0.00053912778790625
+ 2.7078e-05 0.000251272068819119
+ 2.708e-05 0.000138855856542936
+ 2.7082e-05 0.000441761927981832
+ 2.7084e-05 0.000616017578490579
+ 2.7086e-05 0.000788486119781687
+ 2.7088e-05 0.000457968400071879
+ 2.709e-05 0.000584698677744023
+ 2.7092e-05 0.000711528625091131
+ 2.7094e-05 0.000812681602980963
+ 2.7096e-05 0.000512822992611186
+ 2.7098e-05 0.000261659114472979
+ 2.71e-05 0.000146289138783682
+ 2.7102e-05 0.000287228036420178
+ 2.7104e-05 0.000662072512053462
+ 2.7106e-05 0.000509243485668712
+ 2.7108e-05 0.00038092210635742
+ 2.711e-05 -0.000178998195398339
+ 2.7112e-05 -0.000137287483282974
+ 2.7114e-05 -0.000189421950256252
+ 2.7116e-05 -0.000135107690374714
+ 2.7118e-05 0.000474802039977835
+ 2.712e-05 0.000164001689901717
+ 2.7122e-05 0.000136827898066891
+ 2.7124e-05 0.000140998170496756
+ 2.7126e-05 0.000240316065353705
+ 2.7128e-05 0.000119059654944876
+ 2.713e-05 -0.000149586044884025
+ 2.7132e-05 1.57310305156186e-05
+ 2.7134e-05 -0.000127269102934641
+ 2.7136e-05 -0.000203661252769759
+ 2.7138e-05 -0.000232894125487822
+ 2.714e-05 -0.000396503442672849
+ 2.7142e-05 -0.000309929449631611
+ 2.7144e-05 -0.000601947193891238
+ 2.7146e-05 -0.000700058409390524
+ 2.7148e-05 -0.000732311976188383
+ 2.715e-05 -0.00044385836509139
+ 2.7152e-05 -0.000468310305943738
+ 2.7154e-05 -0.000433452178674982
+ 2.7156e-05 -0.000595371617926203
+ 2.7158e-05 -0.000839177228881654
+ 2.716e-05 -0.000707631651089663
+ 2.7162e-05 -0.000752417622193886
+ 2.7164e-05 -0.000559675345925647
+ 2.7166e-05 -0.000677581759534243
+ 2.7168e-05 -0.00067121324104661
+ 2.717e-05 -0.000537479621557281
+ 2.7172e-05 -0.000324872399459333
+ 2.7174e-05 -0.000543445863649114
+ 2.7176e-05 -0.000809121145948156
+ 2.7178e-05 -0.000887733544475739
+ 2.718e-05 -0.00068855094897753
+ 2.7182e-05 -0.000877435240267629
+ 2.7184e-05 -0.00108335934447689
+ 2.7186e-05 -0.000935808792537909
+ 2.7188e-05 -0.00088624652083357
+ 2.719e-05 -0.000803998738094744
+ 2.7192e-05 -0.000769417728151838
+ 2.7194e-05 -0.000766328700499125
+ 2.7196e-05 -0.000530347006636291
+ 2.7198e-05 -0.000469241540684733
+ 2.72e-05 -0.000369598221635084
+ 2.7202e-05 -0.00027869316408261
+ 2.7204e-05 -0.000141308349882645
+ 2.7206e-05 -0.000261390779948039
+ 2.7208e-05 -0.000808571187937823
+ 2.721e-05 -0.000406062667178285
+ 2.7212e-05 -0.000429578485188787
+ 2.7214e-05 -0.000131197342166245
+ 2.7216e-05 -0.000160041930640827
+ 2.7218e-05 -0.000224217233477233
+ 2.722e-05 -0.000544811460761812
+ 2.7222e-05 -0.000578260271944956
+ 2.7224e-05 -0.000500185665125398
+ 2.7226e-05 -0.00060434694425237
+ 2.7228e-05 -0.000546182062611612
+ 2.723e-05 -0.00071040019077908
+ 2.7232e-05 -0.000329020713097918
+ 2.7234e-05 -0.00036301229368999
+ 2.7236e-05 -0.000770529292559783
+ 2.7238e-05 -0.000387103845185622
+ 2.724e-05 -0.000114560074249518
+ 2.7242e-05 3.59118742400133e-05
+ 2.7244e-05 5.92416500882848e-05
+ 2.7246e-05 2.08991227262532e-05
+ 2.7248e-05 4.89116610253652e-06
+ 2.725e-05 -0.000115106329262073
+ 2.7252e-05 -0.00016156699050149
+ 2.7254e-05 0.000188014426110805
+ 2.7256e-05 0.000395820665024188
+ 2.7258e-05 0.000261861139707081
+ 2.726e-05 0.000564878197574584
+ 2.7262e-05 0.000768485345044194
+ 2.7264e-05 0.000771309178238035
+ 2.7266e-05 0.000794986185066603
+ 2.7268e-05 0.000424142673207463
+ 2.727e-05 9.56947211121615e-05
+ 2.7272e-05 9.33870281145502e-05
+ 2.7274e-05 -7.05281281688815e-05
+ 2.7276e-05 -0.000456129156556485
+ 2.7278e-05 -0.000226823177160726
+ 2.728e-05 -6.48430119389475e-05
+ 2.7282e-05 -0.000166744282659055
+ 2.7284e-05 -0.000240970751579584
+ 2.7286e-05 -0.000239356129443887
+ 2.7288e-05 -0.000338943527920878
+ 2.729e-05 7.70175440737779e-05
+ 2.7292e-05 -0.000135262768975173
+ 2.7294e-05 -0.000244122653501725
+ 2.7296e-05 -0.000392903075754002
+ 2.7298e-05 -0.000372568870860759
+ 2.73e-05 -0.000731371356082405
+ 2.7302e-05 -0.000635524861608905
+ 2.7304e-05 -0.000489482185467306
+ 2.7306e-05 -0.000289205005239805
+ 2.7308e-05 -0.000245267156655783
+ 2.731e-05 -0.000391277679685969
+ 2.7312e-05 -0.000317090327003476
+ 2.7314e-05 -8.38106576709527e-05
+ 2.7316e-05 8.78488299578879e-05
+ 2.7318e-05 0.000296768475523152
+ 2.732e-05 0.000330316074343371
+ 2.7322e-05 0.000357552170912934
+ 2.7324e-05 0.00053476601309409
+ 2.7326e-05 0.000373457198552421
+ 2.7328e-05 0.000367453783621376
+ 2.733e-05 0.000304184740158551
+ 2.7332e-05 0.000136505217776974
+ 2.7334e-05 7.40864756806128e-05
+ 2.7336e-05 -7.77203698705331e-05
+ 2.7338e-05 -0.000501080828303741
+ 2.734e-05 -0.00077329857982288
+ 2.7342e-05 -0.000762063796108931
+ 2.7344e-05 -0.00103365500023525
+ 2.7346e-05 -0.00106142794804689
+ 2.7348e-05 -0.00115475412123297
+ 2.735e-05 -0.000845062732883559
+ 2.7352e-05 -0.000938829047446857
+ 2.7354e-05 -0.000763099174403866
+ 2.7356e-05 -0.000204827655479709
+ 2.7358e-05 6.00776118188569e-05
+ 2.736e-05 0.000325017574424344
+ 2.7362e-05 0.00060885155091757
+ 2.7364e-05 0.000460819094651823
+ 2.7366e-05 0.000555985778939223
+ 2.7368e-05 0.000906562659225258
+ 2.737e-05 0.000977261570518959
+ 2.7372e-05 0.000730044728061726
+ 2.7374e-05 0.000426110849303425
+ 2.7376e-05 0.000489837450105676
+ 2.7378e-05 0.000419343682987285
+ 2.738e-05 0.000422810573257179
+ 2.7382e-05 0.000621075232375735
+ 2.7384e-05 0.000439450139653149
+ 2.7386e-05 0.000121596076058153
+ 2.7388e-05 0.000233666643859387
+ 2.739e-05 0.000350543121303011
+ 2.7392e-05 0.0003802265238663
+ 2.7394e-05 0.000646772256275239
+ 2.7396e-05 0.000496481366243761
+ 2.7398e-05 0.000715809786779074
+ 2.74e-05 0.000633690293476023
+ 2.7402e-05 0.000585876209018223
+ 2.7404e-05 0.000626580259038875
+ 2.7406e-05 0.000417164490318582
+ 2.7408e-05 0.000104962490259551
+ 2.741e-05 -7.58419238828083e-05
+ 2.7412e-05 6.51106123556979e-05
+ 2.7414e-05 0.000188784965999859
+ 2.7416e-05 -0.000102792178046879
+ 2.7418e-05 -0.000163254564155912
+ 2.742e-05 0.000169320112390248
+ 2.7422e-05 -0.000195914673292697
+ 2.7424e-05 -0.000225769748478529
+ 2.7426e-05 -0.000552252172451444
+ 2.7428e-05 -0.000671741841427364
+ 2.743e-05 -0.000785935185798914
+ 2.7432e-05 -0.000843176042116721
+ 2.7434e-05 -0.000683291511719749
+ 2.7436e-05 -0.000626121772673827
+ 2.7438e-05 -0.000578891542525745
+ 2.744e-05 -0.00089636065675195
+ 2.7442e-05 -0.000871531141856952
+ 2.7444e-05 -0.000948339578163059
+ 2.7446e-05 -0.00124613831123045
+ 2.7448e-05 -0.000900581162712242
+ 2.745e-05 -0.000949708316527186
+ 2.7452e-05 -0.00117069886609602
+ 2.7454e-05 -0.000871499142766442
+ 2.7456e-05 -0.0008127425242323
+ 2.7458e-05 -0.000978421414291459
+ 2.746e-05 -0.00116181780200199
+ 2.7462e-05 -0.00136021513144957
+ 2.7464e-05 -0.00140812997388536
+ 2.7466e-05 -0.001472605104572
+ 2.7468e-05 -0.00138976381752565
+ 2.747e-05 -0.00147291757201996
+ 2.7472e-05 -0.00163734580458975
+ 2.7474e-05 -0.00183735665043738
+ 2.7476e-05 -0.00180922109897121
+ 2.7478e-05 -0.00187340319893678
+ 2.748e-05 -0.00193142400884589
+ 2.7482e-05 -0.00182781547556883
+ 2.7484e-05 -0.00186167806242775
+ 2.7486e-05 -0.00158765819218192
+ 2.7488e-05 -0.00142371309990043
+ 2.749e-05 -0.0011706568402134
+ 2.7492e-05 -0.00128183243286769
+ 2.7494e-05 -0.00132747922361929
+ 2.7496e-05 -0.00102454845749891
+ 2.7498e-05 -0.000939126845108483
+ 2.75e-05 -0.00127346083314302
+ 2.7502e-05 -0.00125158890694666
+ 2.7504e-05 -0.00155836904115377
+ 2.7506e-05 -0.00140979381767664
+ 2.7508e-05 -0.00139139606331105
+ 2.751e-05 -0.00122155037651479
+ 2.7512e-05 -0.00133910509281163
+ 2.7514e-05 -0.00118577735708856
+ 2.7516e-05 -0.0010563411110814
+ 2.7518e-05 -0.000713846260086021
+ 2.752e-05 -0.000609971444633136
+ 2.7522e-05 -0.000784920570847483
+ 2.7524e-05 -0.000297627389695151
+ 2.7526e-05 -0.000126398471035449
+ 2.7528e-05 -0.000177072555432054
+ 2.753e-05 -8.30133705047108e-05
+ 2.7532e-05 -0.000483959089373465
+ 2.7534e-05 -0.000633076490960927
+ 2.7536e-05 -0.000904624747468672
+ 2.7538e-05 -0.000772069196661785
+ 2.754e-05 -0.00116072662836268
+ 2.7542e-05 -0.000997580223346289
+ 2.7544e-05 -0.000927399255357751
+ 2.7546e-05 -0.000807188701093912
+ 2.7548e-05 -0.000805842154930188
+ 2.755e-05 -0.000699386731732238
+ 2.7552e-05 -0.000584368063330028
+ 2.7554e-05 -0.000801593796232725
+ 2.7556e-05 -0.000582247168729217
+ 2.7558e-05 -0.000650191751678648
+ 2.756e-05 -0.000872060383016865
+ 2.7562e-05 -0.000776495561324802
+ 2.7564e-05 -0.000952475695477143
+ 2.7566e-05 -0.00144782666173715
+ 2.7568e-05 -0.00137565133763808
+ 2.757e-05 -0.00110375110240121
+ 2.7572e-05 -0.0010665589059602
+ 2.7574e-05 -0.000931027820787683
+ 2.7576e-05 -0.000958234078799635
+ 2.7578e-05 -0.000548915702150772
+ 2.758e-05 -0.000546337114537679
+ 2.7582e-05 -6.02451802113783e-05
+ 2.7584e-05 -0.00024754223284485
+ 2.7586e-05 -0.000335872491468612
+ 2.7588e-05 -0.000475448766926589
+ 2.759e-05 -0.000508252869456406
+ 2.7592e-05 -0.00116777457820377
+ 2.7594e-05 -0.00112446793867497
+ 2.7596e-05 -0.0014373637088539
+ 2.7598e-05 -0.00160437480050488
+ 2.76e-05 -0.0012183798934448
+ 2.7602e-05 -0.00125242196619135
+ 2.7604e-05 -0.00105459405892115
+ 2.7606e-05 -0.000802533637594161
+ 2.7608e-05 -0.000764264539154945
+ 2.761e-05 -0.000908801613768755
+ 2.7612e-05 -0.00117010406540545
+ 2.7614e-05 -0.00128943713272222
+ 2.7616e-05 -0.00103572801859748
+ 2.7618e-05 -0.000996081203092498
+ 2.762e-05 -0.000858005396870479
+ 2.7622e-05 -0.00115983483773307
+ 2.7624e-05 -0.000846422760512323
+ 2.7626e-05 -0.00108530020198432
+ 2.7628e-05 -0.00112774839887722
+ 2.763e-05 -0.000794640342801058
+ 2.7632e-05 -0.000482742914218088
+ 2.7634e-05 -0.000561963645718019
+ 2.7636e-05 -0.000750199867539539
+ 2.7638e-05 -0.000424845624777536
+ 2.764e-05 -0.000706069746737216
+ 2.7642e-05 -0.000519059820804413
+ 2.7644e-05 -0.00058181145389531
+ 2.7646e-05 -0.000466638779565962
+ 2.7648e-05 -0.000737082785469724
+ 2.765e-05 -0.000911635351285701
+ 2.7652e-05 -0.00056928542024666
+ 2.7654e-05 -0.000553806647547136
+ 2.7656e-05 -0.000476894161372145
+ 2.7658e-05 -0.000517863798961382
+ 2.766e-05 -0.000696541310961121
+ 2.7662e-05 -0.000578463813061068
+ 2.7664e-05 -0.0002379553948233
+ 2.7666e-05 -0.00034146575607223
+ 2.7668e-05 -0.000226051384268794
+ 2.767e-05 7.71540870436885e-05
+ 2.7672e-05 1.80872258371601e-05
+ 2.7674e-05 -0.000130145953417271
+ 2.7676e-05 -0.000110450317068425
+ 2.7678e-05 -4.01967590702463e-05
+ 2.768e-05 1.71209081331692e-05
+ 2.7682e-05 -3.64470612657263e-05
+ 2.7684e-05 -6.3206397456274e-05
+ 2.7686e-05 8.72549891992804e-05
+ 2.7688e-05 -0.000138298223019251
+ 2.769e-05 2.77260668882555e-05
+ 2.7692e-05 -7.83837141203138e-05
+ 2.7694e-05 0.000105167732530063
+ 2.7696e-05 0.000312873896153334
+ 2.7698e-05 0.000269607024617314
+ 2.77e-05 0.000349233675881603
+ 2.7702e-05 6.23310723843793e-05
+ 2.7704e-05 0.000227329334575978
+ 2.7706e-05 0.000424550411530994
+ 2.7708e-05 8.79949264122393e-05
+ 2.771e-05 0.000109148653469174
+ 2.7712e-05 -0.000107966548561391
+ 2.7714e-05 -0.000408202730400156
+ 2.7716e-05 -0.000522980678982741
+ 2.7718e-05 -0.000366400231639815
+ 2.772e-05 -0.000103244140938371
+ 2.7722e-05 -0.000101452042451713
+ 2.7724e-05 -0.000124334280374905
+ 2.7726e-05 -0.00019918617574945
+ 2.7728e-05 -5.19297650735331e-05
+ 2.773e-05 0.000293706632979978
+ 2.7732e-05 0.000644474191947934
+ 2.7734e-05 0.000506910003325219
+ 2.7736e-05 0.000501779192454355
+ 2.7738e-05 0.000201784622216849
+ 2.774e-05 0.000187537817351435
+ 2.7742e-05 0.000480472035788172
+ 2.7744e-05 0.00036261584735364
+ 2.7746e-05 0.000315956181417808
+ 2.7748e-05 0.00029663044268643
+ 2.775e-05 0.000469194950418669
+ 2.7752e-05 0.00072696838639175
+ 2.7754e-05 0.00041205988545594
+ 2.7756e-05 0.000505338996322751
+ 2.7758e-05 0.000682367562051619
+ 2.776e-05 0.000571772005316024
+ 2.7762e-05 0.000494799178215897
+ 2.7764e-05 0.000532089140612415
+ 2.7766e-05 0.000509990227278392
+ 2.7768e-05 0.000280801813626907
+ 2.777e-05 0.000265897981915626
+ 2.7772e-05 -9.66541051203769e-05
+ 2.7774e-05 -0.000544185344236823
+ 2.7776e-05 -0.000563806586302738
+ 2.7778e-05 -0.000374690431715258
+ 2.778e-05 -0.000574334582015657
+ 2.7782e-05 -0.00063870712320129
+ 2.7784e-05 -0.000743876399628824
+ 2.7786e-05 -0.000637020699726448
+ 2.7788e-05 -0.000656103734183092
+ 2.779e-05 -0.000785081216114499
+ 2.7792e-05 -0.000709103562504492
+ 2.7794e-05 -0.000968319362392677
+ 2.7796e-05 -0.000988362115848516
+ 2.7798e-05 -0.00111337972037712
+ 2.78e-05 -0.00100740346696065
+ 2.7802e-05 -0.000889474525323831
+ 2.7804e-05 -0.000969284709262017
+ 2.7806e-05 -0.00107473949539845
+ 2.7808e-05 -0.00106315645125842
+ 2.781e-05 -0.000665577378038306
+ 2.7812e-05 -0.000526280911048564
+ 2.7814e-05 -0.000502970011108324
+ 2.7816e-05 -0.000807827855105806
+ 2.7818e-05 -0.00095095623925091
+ 2.782e-05 -0.00101611610184713
+ 2.7822e-05 -0.000669033932738431
+ 2.7824e-05 -0.000323854468622727
+ 2.7826e-05 -0.000533437968150953
+ 2.7828e-05 -0.000274375014411703
+ 2.783e-05 -0.000230598162235884
+ 2.7832e-05 -0.000162701963428008
+ 2.7834e-05 -0.000286293112818681
+ 2.7836e-05 -6.76320916149423e-05
+ 2.7838e-05 -3.85185207030026e-05
+ 2.784e-05 -0.000269508386654362
+ 2.7842e-05 -0.000525215007133667
+ 2.7844e-05 -0.000406659214005537
+ 2.7846e-05 -0.00065979276268244
+ 2.7848e-05 -0.000640289070619678
+ 2.785e-05 -0.000614363381549511
+ 2.7852e-05 -0.000512282780346971
+ 2.7854e-05 -0.000220992264432838
+ 2.7856e-05 -0.000535117851817425
+ 2.7858e-05 -0.000303282544128462
+ 2.786e-05 -0.000307609186359635
+ 2.7862e-05 -0.000342598308287885
+ 2.7864e-05 -0.000153984539088318
+ 2.7866e-05 -0.000289527538567386
+ 2.7868e-05 -0.000445029403964718
+ 2.787e-05 -0.000578439692033644
+ 2.7872e-05 -0.000458685217597864
+ 2.7874e-05 -0.000817041670073792
+ 2.7876e-05 -0.000733944122455907
+ 2.7878e-05 -0.000784336253084271
+ 2.788e-05 -0.00116813729969824
+ 2.7882e-05 -0.00119062444783922
+ 2.7884e-05 -0.00119100498697274
+ 2.7886e-05 -0.00155535447833435
+ 2.7888e-05 -0.00179488993330535
+ 2.789e-05 -0.00168290411767901
+ 2.7892e-05 -0.00153388761145373
+ 2.7894e-05 -0.00157362521882717
+ 2.7896e-05 -0.00167313155523517
+ 2.7898e-05 -0.00153417661250028
+ 2.79e-05 -0.00177476602985763
+ 2.7902e-05 -0.00171240663629709
+ 2.7904e-05 -0.0015337059089423
+ 2.7906e-05 -0.00181229826914594
+ 2.7908e-05 -0.00194357509869622
+ 2.791e-05 -0.0020363825195919
+ 2.7912e-05 -0.00189495840837053
+ 2.7914e-05 -0.00167805345024634
+ 2.7916e-05 -0.00143241287146735
+ 2.7918e-05 -0.00163129677434444
+ 2.792e-05 -0.00166666102437301
+ 2.7922e-05 -0.00143367929676061
+ 2.7924e-05 -0.00127410460412207
+ 2.7926e-05 -0.00106642262029427
+ 2.7928e-05 -0.000763263927611075
+ 2.793e-05 -0.000942184906840229
+ 2.7932e-05 -0.00115187133811825
+ 2.7934e-05 -0.00112119707733054
+ 2.7936e-05 -0.000742372703386539
+ 2.7938e-05 -0.000895017799486999
+ 2.794e-05 -0.000655813098713194
+ 2.7942e-05 -0.000458113529718686
+ 2.7944e-05 -0.000808655373258951
+ 2.7946e-05 -0.00070926952819371
+ 2.7948e-05 -0.000936489295062288
+ 2.795e-05 -0.00131356533388622
+ 2.7952e-05 -0.00100607861494776
+ 2.7954e-05 -0.00122134843030191
+ 2.7956e-05 -0.00111391981970811
+ 2.7958e-05 -0.00104771795957041
+ 2.796e-05 -0.000943270909642191
+ 2.7962e-05 -0.00106265730797535
+ 2.7964e-05 -0.000789313474986307
+ 2.7966e-05 -0.000825914253656744
+ 2.7968e-05 -0.000898811080634438
+ 2.797e-05 -0.000941086849451195
+ 2.7972e-05 -0.000804411962334319
+ 2.7974e-05 -0.000770980273207014
+ 2.7976e-05 -0.000506791212798473
+ 2.7978e-05 -0.000684404660755234
+ 2.798e-05 -0.000824644233158589
+ 2.7982e-05 -0.000808372539116493
+ 2.7984e-05 -0.000858764123937918
+ 2.7986e-05 -0.000777256614130559
+ 2.7988e-05 -0.000609668736648735
+ 2.799e-05 -0.000998648969254572
+ 2.7992e-05 -0.00103916133897773
+ 2.7994e-05 -0.00113332291922589
+ 2.7996e-05 -0.00101048014890899
+ 2.7998e-05 -0.00118810904882231
+ 2.8e-05 -0.00120192451152506
+ 2.8002e-05 -0.000829712972129226
+ 2.8004e-05 -0.000607623935961313
+ 2.8006e-05 -0.00039395234472651
+ 2.8008e-05 -8.27251437852132e-05
+ 2.801e-05 8.18094150142675e-05
+ 2.8012e-05 -0.000373803162784386
+ 2.8014e-05 -0.000309793702988235
+ 2.8016e-05 -0.000675693887359564
+ 2.8018e-05 -0.000420759650220898
+ 2.802e-05 -0.000353311216534858
+ 2.8022e-05 -0.000644215629714487
+ 2.8024e-05 -0.000666889683542979
+ 2.8026e-05 -0.000384993847331306
+ 2.8028e-05 -0.000286618682815794
+ 2.803e-05 -0.000186723337712777
+ 2.8032e-05 -0.000109924295422941
+ 2.8034e-05 3.36796702654378e-06
+ 2.8036e-05 -0.00018836985660352
+ 2.8038e-05 -0.000101447840525693
+ 2.804e-05 3.00368260953778e-05
+ 2.8042e-05 4.86968383374028e-05
+ 2.8044e-05 9.35541762705093e-05
+ 2.8046e-05 -8.26572160074858e-05
+ 2.8048e-05 -0.000217645950472597
+ 2.805e-05 -0.000271505080378684
+ 2.8052e-05 -0.000132364000170318
+ 2.8054e-05 -0.000112647493320633
+ 2.8056e-05 -0.00020743279900328
+ 2.8058e-05 7.63249667666714e-05
+ 2.806e-05 0.000269257098839306
+ 2.8062e-05 0.000387071848659651
+ 2.8064e-05 0.000219058902053208
+ 2.8066e-05 0.000254161038215675
+ 2.8068e-05 0.000310130996799028
+ 2.807e-05 0.000336967690221766
+ 2.8072e-05 0.000318087984832417
+ 2.8074e-05 0.000234048104972359
+ 2.8076e-05 0.000480129590510441
+ 2.8078e-05 0.000201105796340537
+ 2.808e-05 0.000567631174357476
+ 2.8082e-05 0.000531565799986716
+ 2.8084e-05 0.000191560619407129
+ 2.8086e-05 8.99506098532211e-05
+ 2.8088e-05 0.000217867819553601
+ 2.809e-05 6.43180151568783e-05
+ 2.8092e-05 0.000157161244050575
+ 2.8094e-05 4.32976044728878e-05
+ 2.8096e-05 0.000150230438694047
+ 2.8098e-05 -6.63556125180068e-06
+ 2.81e-05 7.50215949578893e-05
+ 2.8102e-05 9.37773953013036e-05
+ 2.8104e-05 0.00030432082400005
+ 2.8106e-05 0.000558568039196597
+ 2.8108e-05 0.000876203618435485
+ 2.811e-05 0.0010088635459527
+ 2.8112e-05 0.00115243992714054
+ 2.8114e-05 0.000825209819782773
+ 2.8116e-05 0.000938243543245349
+ 2.8118e-05 0.00111047004020024
+ 2.812e-05 0.000837797133074191
+ 2.8122e-05 0.00046787283608067
+ 2.8124e-05 0.000506101617805028
+ 2.8126e-05 0.000803839791384346
+ 2.8128e-05 0.000656391156155089
+ 2.813e-05 0.000948549596356426
+ 2.8132e-05 0.000985683272768269
+ 2.8134e-05 0.000991619683951707
+ 2.8136e-05 0.000737227980300725
+ 2.8138e-05 0.000797236953552656
+ 2.814e-05 0.000734831038125349
+ 2.8142e-05 0.000508956444090057
+ 2.8144e-05 0.000308811944502365
+ 2.8146e-05 0.000295967556329197
+ 2.8148e-05 0.000184871661368212
+ 2.815e-05 4.69536643023661e-05
+ 2.8152e-05 0.000186921378483958
+ 2.8154e-05 0.000300914495639966
+ 2.8156e-05 0.000267054536882414
+ 2.8158e-05 0.000230975228802658
+ 2.816e-05 6.97471769686556e-05
+ 2.8162e-05 -0.000168638287971699
+ 2.8164e-05 -0.000365368277322176
+ 2.8166e-05 -0.000252922244622818
+ 2.8168e-05 -0.000133230165024878
+ 2.817e-05 -0.000129942305992831
+ 2.8172e-05 2.85064838344012e-05
+ 2.8174e-05 -4.26018873165904e-05
+ 2.8176e-05 0.000187552803154949
+ 2.8178e-05 0.000308659166626818
+ 2.818e-05 0.000285551017540262
+ 2.8182e-05 0.000197920453149212
+ 2.8184e-05 0.000535984438293325
+ 2.8186e-05 0.00067877327111818
+ 2.8188e-05 0.000564764168544208
+ 2.819e-05 0.000781318542360015
+ 2.8192e-05 0.000841822092613279
+ 2.8194e-05 0.00106482122265673
+ 2.8196e-05 0.00103313317549373
+ 2.8198e-05 0.000976612929258702
+ 2.82e-05 0.000814531323644771
+ 2.8202e-05 0.000707361187090456
+ 2.8204e-05 0.000762297458377689
+ 2.8206e-05 0.000513557893277002
+ 2.8208e-05 0.000374210954984583
+ 2.821e-05 0.000350837303886455
+ 2.8212e-05 0.000114630792873595
+ 2.8214e-05 0.00015527423104091
+ 2.8216e-05 8.92110959850114e-05
+ 2.8218e-05 0.000210974020993509
+ 2.822e-05 0.000309463615132262
+ 2.8222e-05 0.000115246239736289
+ 2.8224e-05 0.000172366480202899
+ 2.8226e-05 0.000155760514925409
+ 2.8228e-05 0.000156865173257755
+ 2.823e-05 0.000215497124247405
+ 2.8232e-05 0.000389202796772807
+ 2.8234e-05 0.00068517103910182
+ 2.8236e-05 0.00077724033880827
+ 2.8238e-05 0.000742504513543685
+ 2.824e-05 0.000653320271452318
+ 2.8242e-05 0.000844307935966915
+ 2.8244e-05 0.00040950942108301
+ 2.8246e-05 0.00011338557971822
+ 2.8248e-05 -0.000256458589518032
+ 2.825e-05 -0.000433683788755092
+ 2.8252e-05 -0.000639455001199719
+ 2.8254e-05 -0.000525706415992473
+ 2.8256e-05 -0.000706283425868739
+ 2.8258e-05 -0.000904720012903797
+ 2.826e-05 -0.000775603448371379
+ 2.8262e-05 -0.000603895608542286
+ 2.8264e-05 -0.000706269734858912
+ 2.8266e-05 -0.000484985415763066
+ 2.8268e-05 -0.00068351712074137
+ 2.827e-05 -0.000785761777564491
+ 2.8272e-05 -0.000602797016650739
+ 2.8274e-05 -0.000692316512041705
+ 2.8276e-05 -0.000729757035975704
+ 2.8278e-05 -0.000423041415062153
+ 2.828e-05 -0.000159273324861797
+ 2.8282e-05 -0.000216995371720488
+ 2.8284e-05 -0.000117507735074934
+ 2.8286e-05 -0.000139687810521601
+ 2.8288e-05 3.80579919569231e-05
+ 2.829e-05 -6.05679834571188e-06
+ 2.8292e-05 3.8118003000024e-05
+ 2.8294e-05 3.88772455720704e-05
+ 2.8296e-05 0.000126624377956969
+ 2.8298e-05 0.000293576833406162
+ 2.83e-05 0.000469695464893244
+ 2.8302e-05 0.000735045511904786
+ 2.8304e-05 0.000612326546903521
+ 2.8306e-05 0.000233425892368799
+ 2.8308e-05 0.000107202932911365
+ 2.831e-05 0.000104017519223116
+ 2.8312e-05 8.27051672600246e-06
+ 2.8314e-05 -0.000136031864938159
+ 2.8316e-05 -0.0001506880958545
+ 2.8318e-05 -0.000112478213237801
+ 2.832e-05 1.44803345768742e-05
+ 2.8322e-05 -2.62415349590234e-05
+ 2.8324e-05 -1.61700804198871e-05
+ 2.8326e-05 0.000320475337435166
+ 2.8328e-05 0.000286592810550286
+ 2.833e-05 0.00041122124784965
+ 2.8332e-05 0.000522507275988555
+ 2.8334e-05 0.000676922806123756
+ 2.8336e-05 0.000591736367639023
+ 2.8338e-05 0.000749334322827345
+ 2.834e-05 0.00103325975548321
+ 2.8342e-05 0.00109816636037333
+ 2.8344e-05 0.000915842049443572
+ 2.8346e-05 0.000818672073324438
+ 2.8348e-05 0.000675372054406626
+ 2.835e-05 0.000337935090514666
+ 2.8352e-05 0.000515532755094364
+ 2.8354e-05 0.000409047275404989
+ 2.8356e-05 0.000600566985566101
+ 2.8358e-05 0.000990228620623932
+ 2.836e-05 0.000987178036265185
+ 2.8362e-05 0.000713042896318995
+ 2.8364e-05 0.000550933068351828
+ 2.8366e-05 0.000466381444886859
+ 2.8368e-05 0.000420330810281032
+ 2.837e-05 0.000420116920729395
+ 2.8372e-05 0.000333470859828045
+ 2.8374e-05 0.000282697568354357
+ 2.8376e-05 0.000573468232165471
+ 2.8378e-05 0.00035582044828677
+ 2.838e-05 0.000334909469378383
+ 2.8382e-05 7.25242088412747e-05
+ 2.8384e-05 0.000116562190998451
+ 2.8386e-05 0.000287742434235165
+ 2.8388e-05 0.000229304863998345
+ 2.839e-05 8.37502247601452e-05
+ 2.8392e-05 -0.000117729055638737
+ 2.8394e-05 -0.000354719608622141
+ 2.8396e-05 -8.05576245754703e-05
+ 2.8398e-05 -0.000339180196816041
+ 2.84e-05 -0.000354937599887733
+ 2.8402e-05 -0.000384259599142086
+ 2.8404e-05 -0.000353851758080513
+ 2.8406e-05 -0.000321738183031318
+ 2.8408e-05 2.17488521983125e-05
+ 2.841e-05 -0.000400058067011905
+ 2.8412e-05 -0.000604324688485446
+ 2.8414e-05 -0.000840873053167206
+ 2.8416e-05 -0.000819890950507101
+ 2.8418e-05 -0.000676542954813893
+ 2.842e-05 -0.000793845019592973
+ 2.8422e-05 -0.000987110941966948
+ 2.8424e-05 -0.000847344071639744
+ 2.8426e-05 -0.000545743896240923
+ 2.8428e-05 -0.000564207480804115
+ 2.843e-05 -0.000415484835305919
+ 2.8432e-05 -0.000380615752412492
+ 2.8434e-05 -0.000624430071528953
+ 2.8436e-05 -0.000528893577758163
+ 2.8438e-05 -0.000453358605834928
+ 2.844e-05 -0.000135724216689214
+ 2.8442e-05 -8.83322675210137e-05
+ 2.8444e-05 8.01448747210323e-05
+ 2.8446e-05 -0.00051327784093215
+ 2.8448e-05 -0.000613470266522767
+ 2.845e-05 -0.000541392599229815
+ 2.8452e-05 -0.000336447528048434
+ 2.8454e-05 -0.000471159021423485
+ 2.8456e-05 -0.00019240283953492
+ 2.8458e-05 -3.341741795973e-05
+ 2.846e-05 -0.000521053982965859
+ 2.8462e-05 -0.000821275358366409
+ 2.8464e-05 -0.000809734548457112
+ 2.8466e-05 -0.000630970196051969
+ 2.8468e-05 -0.000611985037778339
+ 2.847e-05 -0.000672959640510543
+ 2.8472e-05 -0.00057843944392862
+ 2.8474e-05 -0.000255103261243709
+ 2.8476e-05 -0.000189915415839586
+ 2.8478e-05 -0.000417863143423319
+ 2.848e-05 -0.000461576610224436
+ 2.8482e-05 -0.00010205804860169
+ 2.8484e-05 0.000131362553180387
+ 2.8486e-05 0.000323781583182867
+ 2.8488e-05 0.000147780638990133
+ 2.849e-05 -1.68117465267525e-05
+ 2.8492e-05 4.52495730573642e-05
+ 2.8494e-05 -0.000199774722170306
+ 2.8496e-05 -0.000414742932975895
+ 2.8498e-05 -0.000610678585210305
+ 2.85e-05 -0.000211427876593188
+ 2.8502e-05 -0.000138816559627425
+ 2.8504e-05 -0.000120798552232896
+ 2.8506e-05 -0.000309883645971566
+ 2.8508e-05 -0.000245299297599017
+ 2.851e-05 -0.000196244452068183
+ 2.8512e-05 -0.000321236538111128
+ 2.8514e-05 -4.78415261554591e-05
+ 2.8516e-05 -0.000116911591936443
+ 2.8518e-05 7.89461690475169e-05
+ 2.852e-05 3.79400057086422e-05
+ 2.8522e-05 0.000204328912432073
+ 2.8524e-05 0.000215138236824564
+ 2.8526e-05 0.000247587251722063
+ 2.8528e-05 0.000184743993706285
+ 2.853e-05 0.000114553192375426
+ 2.8532e-05 0.000256773232930118
+ 2.8534e-05 0.000454772091891534
+ 2.8536e-05 0.000491763878502273
+ 2.8538e-05 0.000434303975105995
+ 2.854e-05 0.000315441250010273
+ 2.8542e-05 0.000897968243296358
+ 2.8544e-05 0.00132322902677021
+ 2.8546e-05 0.00107093567991569
+ 2.8548e-05 0.00105508857663833
+ 2.855e-05 0.00112532064680146
+ 2.8552e-05 0.0013779002226157
+ 2.8554e-05 0.00137536290137629
+ 2.8556e-05 0.00137888088403788
+ 2.8558e-05 0.00142710576721416
+ 2.856e-05 0.00154784061322072
+ 2.8562e-05 0.00143715515447055
+ 2.8564e-05 0.00135304683952658
+ 2.8566e-05 0.0014019247922459
+ 2.8568e-05 0.00117086845193186
+ 2.857e-05 0.000876861769055653
+ 2.8572e-05 0.0005675158102684
+ 2.8574e-05 0.000757367027124674
+ 2.8576e-05 0.000591337667913711
+ 2.8578e-05 0.000794041665496296
+ 2.858e-05 0.000767902045930188
+ 2.8582e-05 0.000690720907990873
+ 2.8584e-05 0.000628136102083806
+ 2.8586e-05 0.000559525469433478
+ 2.8588e-05 0.000719192701858029
+ 2.859e-05 0.000576682969581969
+ 2.8592e-05 0.000569012825230132
+ 2.8594e-05 0.000631285155890397
+ 2.8596e-05 0.00058996124772305
+ 2.8598e-05 0.000316122102560381
+ 2.86e-05 0.000424516344121704
+ 2.8602e-05 0.000475530001006461
+ 2.8604e-05 0.000595351342164645
+ 2.8606e-05 0.000790630119679072
+ 2.8608e-05 0.000581208076654766
+ 2.861e-05 0.000886139240400279
+ 2.8612e-05 0.000931665418950625
+ 2.8614e-05 0.00114514515711321
+ 2.8616e-05 0.000560693188674185
+ 2.8618e-05 0.000675715505031415
+ 2.862e-05 0.000601073942004838
+ 2.8622e-05 0.000632147173118671
+ 2.8624e-05 0.000361712555016981
+ 2.8626e-05 0.000325059212943787
+ 2.8628e-05 5.95482433980357e-05
+ 2.863e-05 0.000365466795909762
+ 2.8632e-05 0.000456760405807817
+ 2.8634e-05 0.000199742250000963
+ 2.8636e-05 0.000105477401111512
+ 2.8638e-05 -7.43369338270382e-05
+ 2.864e-05 3.05072927031068e-05
+ 2.8642e-05 0.000162142156258739
+ 2.8644e-05 0.000461379756638557
+ 2.8646e-05 0.000647476731591425
+ 2.8648e-05 0.000765491034581391
+ 2.865e-05 0.00100610583669284
+ 2.8652e-05 0.000984117078009799
+ 2.8654e-05 0.00112224715090192
+ 2.8656e-05 0.00118184992158205
+ 2.8658e-05 0.000792285917463572
+ 2.866e-05 0.000649659868763771
+ 2.8662e-05 0.000589906598902378
+ 2.8664e-05 0.000568923330670746
+ 2.8666e-05 0.000452652580987953
+ 2.8668e-05 0.000532583283214349
+ 2.867e-05 0.000258786327468502
+ 2.8672e-05 0.000203560722627584
+ 2.8674e-05 0.00027301376851105
+ 2.8676e-05 0.000595577282030596
+ 2.8678e-05 0.000514840884389542
+ 2.868e-05 0.000251879589857085
+ 2.8682e-05 0.000517996267325574
+ 2.8684e-05 0.0003182917769683
+ 2.8686e-05 0.000562375466689923
+ 2.8688e-05 0.000606754196471349
+ 2.869e-05 0.000689788053706665
+ 2.8692e-05 0.000512361411585133
+ 2.8694e-05 0.00082463036144549
+ 2.8696e-05 0.000638389874359277
+ 2.8698e-05 0.000478150534380442
+ 2.87e-05 0.000306221164961533
+ 2.8702e-05 0.00033934330905813
+ 2.8704e-05 -4.42391349633397e-05
+ 2.8706e-05 -0.00022993034910645
+ 2.8708e-05 -0.000236750850340185
+ 2.871e-05 -0.000353052783253245
+ 2.8712e-05 -0.000507816881526687
+ 2.8714e-05 -0.000665273846126764
+ 2.8716e-05 -0.000781461428970383
+ 2.8718e-05 -0.0010901236524206
+ 2.872e-05 -0.00111682559559193
+ 2.8722e-05 -0.000826142080652226
+ 2.8724e-05 -0.000893160386775015
+ 2.8726e-05 -0.000831357027499252
+ 2.8728e-05 -0.000941241308028119
+ 2.873e-05 -0.000809758886033473
+ 2.8732e-05 -0.000635749692709569
+ 2.8734e-05 -0.000604578157846619
+ 2.8736e-05 -0.000522283166889892
+ 2.8738e-05 -0.000731746323328174
+ 2.874e-05 -0.000673617056543799
+ 2.8742e-05 -0.000369474248387639
+ 2.8744e-05 -0.000620278695523201
+ 2.8746e-05 -0.000367825026344468
+ 2.8748e-05 -0.00019001386710512
+ 2.875e-05 0.000118947183188048
+ 2.8752e-05 -0.000141253498922317
+ 2.8754e-05 -1.42360703762923e-05
+ 2.8756e-05 -0.000551121425227635
+ 2.8758e-05 -0.000429386306994278
+ 2.876e-05 -0.000414523039721265
+ 2.8762e-05 -0.000391363475738569
+ 2.8764e-05 -0.000609961403594724
+ 2.8766e-05 -0.000560028798240033
+ 2.8768e-05 -0.000616998064856546
+ 2.877e-05 -0.000714484232369483
+ 2.8772e-05 -0.000174499881423605
+ 2.8774e-05 -0.000119461248453158
+ 2.8776e-05 -0.000258379715880515
+ 2.8778e-05 -4.51164228336977e-05
+ 2.878e-05 -0.00022694617858176
+ 2.8782e-05 -0.000260875680030207
+ 2.8784e-05 -8.10213998168376e-05
+ 2.8786e-05 -0.000347757940400004
+ 2.8788e-05 -5.71189988722674e-05
+ 2.879e-05 -0.000285188794537379
+ 2.8792e-05 -0.000726271823918281
+ 2.8794e-05 -0.000166505954117093
+ 2.8796e-05 7.34811879420378e-05
+ 2.8798e-05 -0.000415002831670686
+ 2.88e-05 -0.00039809463435743
+ 2.8802e-05 -0.000359373113742834
+ 2.8804e-05 -0.000597084431675059
+ 2.8806e-05 -0.000402168148097543
+ 2.8808e-05 -0.000245365941984128
+ 2.881e-05 -0.000132785758730336
+ 2.8812e-05 -0.00036233754188682
+ 2.8814e-05 -0.00050762851875802
+ 2.8816e-05 -0.000630061501047417
+ 2.8818e-05 -0.000708936075013917
+ 2.882e-05 -0.000358398887824918
+ 2.8822e-05 -0.000620199605538277
+ 2.8824e-05 -0.000613964298614966
+ 2.8826e-05 -0.000471835996524645
+ 2.8828e-05 -0.000862562130832048
+ 2.883e-05 -0.00103173327367998
+ 2.8832e-05 -0.000875275243532942
+ 2.8834e-05 -0.00100926037358499
+ 2.8836e-05 -0.00128511526994758
+ 2.8838e-05 -0.00100036839681827
+ 2.884e-05 -0.00108823724762408
+ 2.8842e-05 -0.00109484382699796
+ 2.8844e-05 -0.00118753034495828
+ 2.8846e-05 -0.00142430314898985
+ 2.8848e-05 -0.00138199456292612
+ 2.885e-05 -0.00139367166075281
+ 2.8852e-05 -0.00112815366680512
+ 2.8854e-05 -0.00109874008640164
+ 2.8856e-05 -0.00103710239981033
+ 2.8858e-05 -0.000770522954032906
+ 2.886e-05 -0.000881968349690964
+ 2.8862e-05 -0.00103244893975697
+ 2.8864e-05 -0.00105492077922019
+ 2.8866e-05 -0.000927200455711763
+ 2.8868e-05 -0.000752497785639193
+ 2.887e-05 -0.000676478563288369
+ 2.8872e-05 -0.000705195362544938
+ 2.8874e-05 -0.000870310531760685
+ 2.8876e-05 -0.000845289111646751
+ 2.8878e-05 -0.00110742673838453
+ 2.888e-05 -0.000803600252209066
+ 2.8882e-05 -0.000713016200263148
+ 2.8884e-05 -0.000619248013736657
+ 2.8886e-05 -0.000398481262834414
+ 2.8888e-05 -0.000461247178069359
+ 2.889e-05 -0.000470827054711993
+ 2.8892e-05 -0.000345832095843415
+ 2.8894e-05 -0.000423306393565431
+ 2.8896e-05 -0.000397446849810922
+ 2.8898e-05 -0.000542061616483109
+ 2.89e-05 -0.000811516804052208
+ 2.8902e-05 -0.000928710220668346
+ 2.8904e-05 -0.000903576325444792
+ 2.8906e-05 -0.0011764135768048
+ 2.8908e-05 -0.00133963612283015
+ 2.891e-05 -0.0017432575424415
+ 2.8912e-05 -0.00159038223055686
+ 2.8914e-05 -0.00165592926896456
+ 2.8916e-05 -0.0014124707096448
+ 2.8918e-05 -0.0015945714799682
+ 2.892e-05 -0.00170465135336693
+ 2.8922e-05 -0.00219733452692506
+ 2.8924e-05 -0.00194504924502779
+ 2.8926e-05 -0.00207144262887227
+ 2.8928e-05 -0.00154965332546772
+ 2.893e-05 -0.00122910597767858
+ 2.8932e-05 -0.00117822399866346
+ 2.8934e-05 -0.0014047514866416
+ 2.8936e-05 -0.00128791555818126
+ 2.8938e-05 -0.00120716029395571
+ 2.894e-05 -0.00104230798498277
+ 2.8942e-05 -0.000811709668113698
+ 2.8944e-05 -0.000817347679240436
+ 2.8946e-05 -0.00137163292495572
+ 2.8948e-05 -0.00139589870232345
+ 2.895e-05 -0.00124721839117934
+ 2.8952e-05 -0.00139111160526144
+ 2.8954e-05 -0.00147745930184405
+ 2.8956e-05 -0.0013217028935379
+ 2.8958e-05 -0.00127539902686365
+ 2.896e-05 -0.00110946954423784
+ 2.8962e-05 -0.00116756848321492
+ 2.8964e-05 -0.00104285199921371
+ 2.8966e-05 -0.00111905899507699
+ 2.8968e-05 -0.00103990901657198
+ 2.897e-05 -0.00103416280423306
+ 2.8972e-05 -0.00103163654966055
+ 2.8974e-05 -0.000919363799841906
+ 2.8976e-05 -0.00107722364412125
+ 2.8978e-05 -0.000779462534947244
+ 2.898e-05 -0.001133302992007
+ 2.8982e-05 -0.000971397833709941
+ 2.8984e-05 -0.00101768193162409
+ 2.8986e-05 -0.00104062877368361
+ 2.8988e-05 -0.0012872444048676
+ 2.899e-05 -0.00104747675580605
+ 2.8992e-05 -0.000852782345172083
+ 2.8994e-05 -0.000881932792786062
+ 2.8996e-05 -0.000653439217379298
+ 2.8998e-05 -0.00081672406363514
+ 2.9e-05 -0.000963656051520836
+ 2.9002e-05 -0.000774734487446984
+ 2.9004e-05 -0.00111782966118361
+ 2.9006e-05 -0.00154655080652359
+ 2.9008e-05 -0.00138223102032948
+ 2.901e-05 -0.00128492559224564
+ 2.9012e-05 -0.00115224578875568
+ 2.9014e-05 -0.00101258607939087
+ 2.9016e-05 -0.000605536449859918
+ 2.9018e-05 -0.000767796700857582
+ 2.902e-05 -0.000701603587619296
+ 2.9022e-05 -0.000869575406618198
+ 2.9024e-05 -0.000552944646738898
+ 2.9026e-05 -0.000564247971119754
+ 2.9028e-05 -0.000632597515422962
+ 2.903e-05 -0.000627107845678766
+ 2.9032e-05 -0.00079409366410476
+ 2.9034e-05 -0.000990485850138328
+ 2.9036e-05 -0.00100925886678304
+ 2.9038e-05 -0.000968698216208507
+ 2.904e-05 -0.00101446968291354
+ 2.9042e-05 -0.000674633413385375
+ 2.9044e-05 -0.000968186455184013
+ 2.9046e-05 -0.000916489156934917
+ 2.9048e-05 -0.000488851784610282
+ 2.905e-05 -0.00042088148774542
+ 2.9052e-05 0.000123679543301153
+ 2.9054e-05 0.000256433370145293
+ 2.9056e-05 0.000196644135161993
+ 2.9058e-05 0.00053577134207726
+ 2.906e-05 0.000375618673681704
+ 2.9062e-05 0.000101375947166611
+ 2.9064e-05 -0.000138905620404027
+ 2.9066e-05 0.000311767060141061
+ 2.9068e-05 0.000231260359819663
+ 2.907e-05 -8.58031113127913e-05
+ 2.9072e-05 -6.14181087335403e-05
+ 2.9074e-05 -0.000546152586543694
+ 2.9076e-05 -0.000235702006214571
+ 2.9078e-05 -0.000455337170094316
+ 2.908e-05 -0.000380970298210753
+ 2.9082e-05 -0.000161251052780155
+ 2.9084e-05 -9.65927234873738e-05
+ 2.9086e-05 -9.31967653831111e-05
+ 2.9088e-05 -0.000394509017589715
+ 2.909e-05 -0.000256749894789204
+ 2.9092e-05 -1.67881602553173e-05
+ 2.9094e-05 0.000197990410407497
+ 2.9096e-05 0.000586732722797936
+ 2.9098e-05 0.000436206760989676
+ 2.91e-05 0.000135255438089903
+ 2.9102e-05 1.25867321700354e-05
+ 2.9104e-05 -0.000316282953317109
+ 2.9106e-05 -0.000391998646641964
+ 2.9108e-05 -0.000167459401506136
+ 2.911e-05 -4.81277735476203e-05
+ 2.9112e-05 -0.000317586379368224
+ 2.9114e-05 -0.000403268007019289
+ 2.9116e-05 -0.000388195853858967
+ 2.9118e-05 -0.00052033727424805
+ 2.912e-05 -0.000437102113669831
+ 2.9122e-05 -0.000428208832149123
+ 2.9124e-05 -0.000201049495346562
+ 2.9126e-05 -0.000301979905939566
+ 2.9128e-05 -0.000248242398337855
+ 2.913e-05 -0.00017172905389384
+ 2.9132e-05 -0.000331064648554448
+ 2.9134e-05 -0.00067649918931031
+ 2.9136e-05 -0.000702190724723215
+ 2.9138e-05 -0.000664842486374191
+ 2.914e-05 -0.000797406348221923
+ 2.9142e-05 -0.000722930842011918
+ 2.9144e-05 -0.000916106603429699
+ 2.9146e-05 -0.000978942735780277
+ 2.9148e-05 -0.00103209479658988
+ 2.915e-05 -0.000992040066283104
+ 2.9152e-05 -0.000706376042686511
+ 2.9154e-05 -0.000733977238266808
+ 2.9156e-05 -0.000941016867373985
+ 2.9158e-05 -0.000861001998948807
+ 2.916e-05 -0.000741248804325937
+ 2.9162e-05 -0.00102805287107418
+ 2.9164e-05 -0.00127200699521592
+ 2.9166e-05 -0.00127684397192337
+ 2.9168e-05 -0.00112419920701268
+ 2.917e-05 -0.00086245679247034
+ 2.9172e-05 -0.000789089949418507
+ 2.9174e-05 -0.000757850533965556
+ 2.9176e-05 -0.000940305208472434
+ 2.9178e-05 -0.000972897912026297
+ 2.918e-05 -0.000751571055700469
+ 2.9182e-05 -0.000463350268614906
+ 2.9184e-05 -0.000661953055541493
+ 2.9186e-05 -0.000476587010322134
+ 2.9188e-05 -0.000680075088140717
+ 2.919e-05 -0.00067639904637059
+ 2.9192e-05 -0.000356711575586357
+ 2.9194e-05 -0.000622827690345275
+ 2.9196e-05 -0.0007667985924617
+ 2.9198e-05 -0.000612460548453693
+ 2.92e-05 -0.000202512917366315
+ 2.9202e-05 -0.000417156828308613
+ 2.9204e-05 -0.000563868139007752
+ 2.9206e-05 -0.000697163711241968
+ 2.9208e-05 -0.000554839760077816
+ 2.921e-05 -0.000614693978986823
+ 2.9212e-05 -0.000633363588674108
+ 2.9214e-05 -0.000677565847584218
+ 2.9216e-05 -0.000208451678509427
+ 2.9218e-05 -0.000609321180751696
+ 2.922e-05 -0.000658658918023361
+ 2.9222e-05 -0.000427142733008785
+ 2.9224e-05 -0.000617556149504216
+ 2.9226e-05 -0.000575107451869493
+ 2.9228e-05 -0.000797950088779951
+ 2.923e-05 -0.000586410369206576
+ 2.9232e-05 -0.000670391144447602
+ 2.9234e-05 -0.000390172481583873
+ 2.9236e-05 -0.000305094947457932
+ 2.9238e-05 -0.000377581888810649
+ 2.924e-05 -0.000376040098640095
+ 2.9242e-05 -0.000517637709969586
+ 2.9244e-05 -0.00041452880346206
+ 2.9246e-05 -0.000524961022278914
+ 2.9248e-05 -0.000531465890406562
+ 2.925e-05 -0.000396030883651782
+ 2.9252e-05 -0.000134274774652934
+ 2.9254e-05 -0.000486853272482034
+ 2.9256e-05 -0.000323928027489723
+ 2.9258e-05 -0.000171855554443934
+ 2.926e-05 -0.000531558569193693
+ 2.9262e-05 -0.000462504713080381
+ 2.9264e-05 -0.000464119647461211
+ 2.9266e-05 -0.000436926426640403
+ 2.9268e-05 -0.000354944116792178
+ 2.927e-05 -0.000237894735231733
+ 2.9272e-05 -0.000138304336992884
+ 2.9274e-05 -0.000492585108469936
+ 2.9276e-05 -0.000842235605942422
+ 2.9278e-05 -0.000812166867723824
+ 2.928e-05 -0.000876530146593882
+ 2.9282e-05 -0.000570462315769842
+ 2.9284e-05 -0.000179072350471748
+ 2.9286e-05 -8.67752874191247e-07
+ 2.9288e-05 5.7131710188959e-06
+ 2.929e-05 0.000277754108077781
+ 2.9292e-05 8.52753082737278e-05
+ 2.9294e-05 8.59331879157477e-05
+ 2.9296e-05 0.000115863355023067
+ 2.9298e-05 -1.76025612706062e-05
+ 2.93e-05 -5.7284604581514e-05
+ 2.9302e-05 -2.41030854149566e-05
+ 2.9304e-05 -5.18625341269322e-05
+ 2.9306e-05 -0.000238125631847969
+ 2.9308e-05 -0.000232184868140321
+ 2.931e-05 -0.00032612226319132
+ 2.9312e-05 -0.000455770758914322
+ 2.9314e-05 -0.000312321970044799
+ 2.9316e-05 -0.000551575814284505
+ 2.9318e-05 -0.000419336020067022
+ 2.932e-05 -0.000652577217443146
+ 2.9322e-05 -0.000398814222895674
+ 2.9324e-05 -0.000489427597622541
+ 2.9326e-05 2.10879919380682e-05
+ 2.9328e-05 -1.50692397825218e-05
+ 2.933e-05 0.000110207919658622
+ 2.9332e-05 -6.50840116011467e-06
+ 2.9334e-05 -0.000103577094115621
+ 2.9336e-05 3.60604145895034e-05
+ 2.9338e-05 -6.731041879439e-05
+ 2.934e-05 -0.000203224522164872
+ 2.9342e-05 1.67114035707164e-05
+ 2.9344e-05 7.32089604295249e-05
+ 2.9346e-05 0.000295972573895836
+ 2.9348e-05 0.000253852319871763
+ 2.935e-05 0.000220152390072032
+ 2.9352e-05 -1.43251237817993e-05
+ 2.9354e-05 -0.000131437523333133
+ 2.9356e-05 -1.17867115010057e-05
+ 2.9358e-05 0.000147126131363283
+ 2.936e-05 0.000204107509185735
+ 2.9362e-05 -0.000227100341428715
+ 2.9364e-05 -9.65606871680079e-05
+ 2.9366e-05 0.000261663752775188
+ 2.9368e-05 0.000234153851360685
+ 2.937e-05 -0.000186898511158485
+ 2.9372e-05 0.000276651437143225
+ 2.9374e-05 0.000301131390328256
+ 2.9376e-05 0.000441489570627059
+ 2.9378e-05 0.000537580825677732
+ 2.938e-05 0.000348162039502912
+ 2.9382e-05 0.000115305190836825
+ 2.9384e-05 0.000198573972180432
+ 2.9386e-05 0.000264151746177995
+ 2.9388e-05 0.000398721901357522
+ 2.939e-05 0.000536622111289786
+ 2.9392e-05 0.000259696088124224
+ 2.9394e-05 4.62652849780303e-05
+ 2.9396e-05 -0.000142735278641897
+ 2.9398e-05 -2.35772166827745e-05
+ 2.94e-05 5.73506094764388e-05
+ 2.9402e-05 0.000141211265006542
+ 2.9404e-05 0.000130697623024402
+ 2.9406e-05 0.00028831677707816
+ 2.9408e-05 0.000467413578687027
+ 2.941e-05 0.000209028421239806
+ 2.9412e-05 0.000349811083379368
+ 2.9414e-05 0.000295133052540872
+ 2.9416e-05 0.000387062569889605
+ 2.9418e-05 0.000398682932728481
+ 2.942e-05 0.000560908643954011
+ 2.9422e-05 9.9800561126416e-05
+ 2.9424e-05 0.000351866813879652
+ 2.9426e-05 0.000284146560060096
+ 2.9428e-05 0.000275916918749255
+ 2.943e-05 0.000141691159748863
+ 2.9432e-05 0.00030024253614205
+ 2.9434e-05 0.000254854706839643
+ 2.9436e-05 0.000400855319113624
+ 2.9438e-05 0.000684458134165541
+ 2.944e-05 0.000589236739190539
+ 2.9442e-05 0.000427501330614903
+ 2.9444e-05 0.000338280463028224
+ 2.9446e-05 0.000380816738580167
+ 2.9448e-05 0.00028754557235806
+ 2.945e-05 0.000580453713195059
+ 2.9452e-05 0.000472335901866947
+ 2.9454e-05 0.000737681393429251
+ 2.9456e-05 0.000641902582052783
+ 2.9458e-05 0.000915038835634375
+ 2.946e-05 0.00101726640963657
+ 2.9462e-05 0.00110484114513947
+ 2.9464e-05 0.00079942270104842
+ 2.9466e-05 0.000882621334671251
+ 2.9468e-05 0.000715097864991467
+ 2.947e-05 0.000646885555177524
+ 2.9472e-05 0.000657997189383018
+ 2.9474e-05 0.000677403659545852
+ 2.9476e-05 0.000538067492007293
+ 2.9478e-05 0.000462093129141643
+ 2.948e-05 0.000754163464984073
+ 2.9482e-05 0.000395949088439114
+ 2.9484e-05 0.000413560408106064
+ 2.9486e-05 0.00051342232514787
+ 2.9488e-05 0.000413473646008314
+ 2.949e-05 0.000513978747311298
+ 2.9492e-05 0.000327991349934488
+ 2.9494e-05 0.000638135058627226
+ 2.9496e-05 0.000330674260906279
+ 2.9498e-05 0.000605292764096237
+ 2.95e-05 0.000479366304660546
+ 2.9502e-05 0.000464882811719426
+ 2.9504e-05 0.000513136093949314
+ 2.9506e-05 0.000739922940415769
+ 2.9508e-05 0.000599175556399416
+ 2.951e-05 0.000537043413952709
+ 2.9512e-05 0.000661286452327922
+ 2.9514e-05 0.000469189120628645
+ 2.9516e-05 0.000887559147577277
+ 2.9518e-05 0.000674826939042077
+ 2.952e-05 0.000545202477950039
+ 2.9522e-05 0.000369434209823355
+ 2.9524e-05 0.000311742742996335
+ 2.9526e-05 0.000192718005566915
+ 2.9528e-05 0.000122907248506583
+ 2.953e-05 -2.82306456740782e-05
+ 2.9532e-05 -0.000214154419854809
+ 2.9534e-05 -0.000558722792192773
+ 2.9536e-05 -0.000471480535167278
+ 2.9538e-05 -0.000567304682436657
+ 2.954e-05 -0.000706965251621039
+ 2.9542e-05 -0.000817091209872827
+ 2.9544e-05 -0.00125824291966555
+ 2.9546e-05 -0.00114592865935901
+ 2.9548e-05 -0.0012493707921431
+ 2.955e-05 -0.00122304837040749
+ 2.9552e-05 -0.0013172497229209
+ 2.9554e-05 -0.0013339955936991
+ 2.9556e-05 -0.00127080639316615
+ 2.9558e-05 -0.00116622010662727
+ 2.956e-05 -0.00118160256011053
+ 2.9562e-05 -0.00130779035259962
+ 2.9564e-05 -0.00132797072679796
+ 2.9566e-05 -0.00146152510887153
+ 2.9568e-05 -0.00171604187666648
+ 2.957e-05 -0.00176295196384555
+ 2.9572e-05 -0.00169741101591349
+ 2.9574e-05 -0.00143310171638289
+ 2.9576e-05 -0.00145833838057003
+ 2.9578e-05 -0.00138734602403018
+ 2.958e-05 -0.00112930899512377
+ 2.9582e-05 -0.000964455362237135
+ 2.9584e-05 -0.000822669116587956
+ 2.9586e-05 -0.000724741870149119
+ 2.9588e-05 -0.00108025953395902
+ 2.959e-05 -0.00126749225056049
+ 2.9592e-05 -0.00178783695692249
+ 2.9594e-05 -0.00175208109115398
+ 2.9596e-05 -0.0019125069745323
+ 2.9598e-05 -0.00188410553247036
+ 2.96e-05 -0.00169404332123978
+ 2.9602e-05 -0.00188617744550787
+ 2.9604e-05 -0.00175443957851484
+ 2.9606e-05 -0.00202601855288182
+ 2.9608e-05 -0.00211777994656823
+ 2.961e-05 -0.00197028894084619
+ 2.9612e-05 -0.00218457019675356
+ 2.9614e-05 -0.00236484223063902
+ 2.9616e-05 -0.00235214151287219
+ 2.9618e-05 -0.00244979972090485
+ 2.962e-05 -0.00262665988507307
+ 2.9622e-05 -0.00270942253968218
+ 2.9624e-05 -0.00280302767190902
+ 2.9626e-05 -0.00266121398722062
+ 2.9628e-05 -0.00246254339981868
+ 2.963e-05 -0.00209781097038725
+ 2.9632e-05 -0.00183434234863961
+ 2.9634e-05 -0.00164111869201166
+ 2.9636e-05 -0.00115380611741717
+ 2.9638e-05 -0.000936952445738547
+ 2.964e-05 -0.00105509747959449
+ 2.9642e-05 -0.000809090048445454
+ 2.9644e-05 -0.000607072099382327
+ 2.9646e-05 -0.000376702386768452
+ 2.9648e-05 -0.000223037697911082
+ 2.965e-05 -0.000282338556143267
+ 2.9652e-05 -0.000415889219498931
+ 2.9654e-05 -0.000274634583005917
+ 2.9656e-05 -0.000102961927713051
+ 2.9658e-05 -0.00030920545717486
+ 2.966e-05 -5.21813975983987e-05
+ 2.9662e-05 0.000240755681679756
+ 2.9664e-05 0.000384826721505827
+ 2.9666e-05 0.000654719963373312
+ 2.9668e-05 0.000885123093338325
+ 2.967e-05 0.001047316886656
+ 2.9672e-05 0.000974533858965162
+ 2.9674e-05 0.000778218654962846
+ 2.9676e-05 0.000740797098111563
+ 2.9678e-05 0.000655880062832484
+ 2.968e-05 0.000568910066258428
+ 2.9682e-05 0.000569870109463187
+ 2.9684e-05 0.000805276839159424
+ 2.9686e-05 0.000737236137690789
+ 2.9688e-05 0.00083263042591758
+ 2.969e-05 0.000890776126633122
+ 2.9692e-05 0.000713120991682156
+ 2.9694e-05 0.000677541390173927
+ 2.9696e-05 0.000693648489410789
+ 2.9698e-05 0.000647797891144049
+ 2.97e-05 0.000859565978333315
+ 2.9702e-05 0.000784644900536443
+ 2.9704e-05 0.000582372695191278
+ 2.9706e-05 0.000464309948930286
+ 2.9708e-05 0.000342632367767216
+ 2.971e-05 0.000323810458498085
+ 2.9712e-05 0.000425702537893457
+ 2.9714e-05 0.00037632225121944
+ 2.9716e-05 0.000679930221806428
+ 2.9718e-05 0.000730133091353415
+ 2.972e-05 0.000320988106883234
+ 2.9722e-05 -0.000162821762944467
+ 2.9724e-05 5.46082983439277e-05
+ 2.9726e-05 0.000216033994858272
+ 2.9728e-05 0.000212698054708097
+ 2.973e-05 0.000429168906963815
+ 2.9732e-05 0.0004187466687529
+ 2.9734e-05 0.000367633450892638
+ 2.9736e-05 0.000233796543040804
+ 2.9738e-05 3.7158655631813e-05
+ 2.974e-05 0.000153631403388204
+ 2.9742e-05 0.000165985621975946
+ 2.9744e-05 -2.87819750919474e-05
+ 2.9746e-05 8.58724757524466e-05
+ 2.9748e-05 2.91354070688602e-05
+ 2.975e-05 -0.00023933355093804
+ 2.9752e-05 -0.000460900537137821
+ 2.9754e-05 -0.000444549763880448
+ 2.9756e-05 -0.000751318044222835
+ 2.9758e-05 -0.000700213765173007
+ 2.976e-05 -0.000849751946849441
+ 2.9762e-05 -0.000840933955882282
+ 2.9764e-05 -0.00114384691518053
+ 2.9766e-05 -0.00141971440565169
+ 2.9768e-05 -0.00150234268201714
+ 2.977e-05 -0.0013588355577594
+ 2.9772e-05 -0.00165282481387281
+ 2.9774e-05 -0.0014446680773109
+ 2.9776e-05 -0.00142826755672756
+ 2.9778e-05 -0.0013399898947249
+ 2.978e-05 -0.00114819920843549
+ 2.9782e-05 -0.00138680221416706
+ 2.9784e-05 -0.00180121553740074
+ 2.9786e-05 -0.00172879660917437
+ 2.9788e-05 -0.00186657807547662
+ 2.979e-05 -0.00176600467006481
+ 2.9792e-05 -0.00163512119953046
+ 2.9794e-05 -0.0011657803907303
+ 2.9796e-05 -0.00121560169309077
+ 2.9798e-05 -0.00131956300758027
+ 2.98e-05 -0.00136252457557949
+ 2.9802e-05 -0.00137612264377027
+ 2.9804e-05 -0.00103538248760912
+ 2.9806e-05 -0.0012644001697345
+ 2.9808e-05 -0.00161840061721336
+ 2.981e-05 -0.00127022276112389
+ 2.9812e-05 -0.00110079882173801
+ 2.9814e-05 -0.00101306659707997
+ 2.9816e-05 -0.00118975099337821
+ 2.9818e-05 -0.00136751984292352
+ 2.982e-05 -0.0013523549671373
+ 2.9822e-05 -0.00100334876160017
+ 2.9824e-05 -0.000631502056604325
+ 2.9826e-05 -0.000400160012276824
+ 2.9828e-05 -0.000162540276026027
+ 2.983e-05 3.86751231646513e-05
+ 2.9832e-05 -2.62598259352842e-05
+ 2.9834e-05 -0.000145544146218095
+ 2.9836e-05 -0.000485746124110122
+ 2.9838e-05 -0.000399004203360183
+ 2.984e-05 -0.000167823765143669
+ 2.9842e-05 -0.000207961815816679
+ 2.9844e-05 -0.000433339177855878
+ 2.9846e-05 -0.000507851395437025
+ 2.9848e-05 -0.000383415862843223
+ 2.985e-05 -0.000726340236393034
+ 2.9852e-05 -0.00108340969035896
+ 2.9854e-05 -0.000995502809346176
+ 2.9856e-05 -0.00110454730324096
+ 2.9858e-05 -0.0011271308944769
+ 2.986e-05 -0.00114074575041433
+ 2.9862e-05 -0.000947772485409008
+ 2.9864e-05 -0.00070936277903894
+ 2.9866e-05 -0.00104778188972156
+ 2.9868e-05 -0.000988916684352326
+ 2.987e-05 -0.00128852472635474
+ 2.9872e-05 -0.00160023333835817
+ 2.9874e-05 -0.00176167789299388
+ 2.9876e-05 -0.00186078134117935
+ 2.9878e-05 -0.00211855938563341
+ 2.988e-05 -0.00162928472490364
+ 2.9882e-05 -0.00168996482700646
+ 2.9884e-05 -0.00175953368671037
+ 2.9886e-05 -0.00186372185567348
+ 2.9888e-05 -0.001605256705979
+ 2.989e-05 -0.00143771166671684
+ 2.9892e-05 -0.001698569528288
+ 2.9894e-05 -0.0017446049667879
+ 2.9896e-05 -0.00138906613422316
+ 2.9898e-05 -0.000757385264501422
+ 2.99e-05 -0.000559986908036917
+ 2.9902e-05 -0.000713977260712387
+ 2.9904e-05 -0.000741600975790977
+ 2.9906e-05 -0.000695929787889523
+ 2.9908e-05 -0.000502249375745576
+ 2.991e-05 -0.00072045562098677
+ 2.9912e-05 -0.00085458087762827
+ 2.9914e-05 -0.000725102485787026
+ 2.9916e-05 -0.000755843859082936
+ 2.9918e-05 -0.000505084812084093
+ 2.992e-05 -0.00108502218964337
+ 2.9922e-05 -0.000984720408305144
+ 2.9924e-05 -0.000719980956113646
+ 2.9926e-05 -0.000753747319664851
+ 2.9928e-05 -0.000981505500591345
+ 2.993e-05 -0.00105162144800502
+ 2.9932e-05 -0.00145647227760968
+ 2.9934e-05 -0.00154467361811966
+ 2.9936e-05 -0.00133066751775556
+ 2.9938e-05 -0.00125489372066284
+ 2.994e-05 -0.00169885478031322
+ 2.9942e-05 -0.00141538020706578
+ 2.9944e-05 -0.00151342902203052
+ 2.9946e-05 -0.0015418863287313
+ 2.9948e-05 -0.00191839732755128
+ 2.995e-05 -0.00192255127273431
+ 2.9952e-05 -0.00174236415406758
+ 2.9954e-05 -0.00169469128918852
+ 2.9956e-05 -0.00185949244401508
+ 2.9958e-05 -0.00245357300860302
+ 2.996e-05 -0.0025708335157178
+ 2.9962e-05 -0.00203169257930133
+ 2.9964e-05 -0.00190571013290974
+ 2.9966e-05 -0.00155556726993402
+ 2.9968e-05 -0.00164675069164621
+ 2.997e-05 -0.00137571560890266
+ 2.9972e-05 -0.00186638614249742
+ 2.9974e-05 -0.00169494320034494
+ 2.9976e-05 -0.00163436811759732
+ 2.9978e-05 -0.00170467833095977
+ 2.998e-05 -0.00185825541736693
+ 2.9982e-05 -0.00198700517469869
+ 2.9984e-05 -0.00183345363813509
+ 2.9986e-05 -0.00156158788344472
+ 2.9988e-05 -0.00137494761810698
+ 2.999e-05 -0.00104760364747395
+ 2.9992e-05 -0.000956973492828681
+ 2.9994e-05 -0.000921854766500128
+ 2.9996e-05 -0.000841751314123122
+ 2.9998e-05 -0.00111512112877032
+ 3e-05 -0.00123692892004645
+ 3.0002e-05 -0.00123706991643225
+ 3.0004e-05 -0.00144435201969902
+ 3.0006e-05 -0.00143797560765589
+ 3.0008e-05 -0.00144732559521094
+ 3.001e-05 -0.00131107994766742
+ 3.0012e-05 -0.00123227766475742
+ 3.0014e-05 -0.00126265446203065
+ 3.0016e-05 -0.000957798519283483
+ 3.0018e-05 -0.000948388781627852
+ 3.002e-05 -0.000886952431618514
+ 3.0022e-05 -0.000926505223967903
+ 3.0024e-05 -0.00103425182841506
+ 3.0026e-05 -0.000872475644542391
+ 3.0028e-05 -0.0010716915596029
+ 3.003e-05 -0.00101327878193372
+ 3.0032e-05 -0.000762107673313776
+ 3.0034e-05 -0.000932826693509627
+ 3.0036e-05 -0.000860226352638005
+ 3.0038e-05 -0.000831093711918131
+ 3.004e-05 -0.000570543401166206
+ 3.0042e-05 -9.59917021523519e-05
+ 3.0044e-05 -0.000144979831087726
+ 3.0046e-05 -0.00036419417358078
+ 3.0048e-05 -0.000622048223977451
+ 3.005e-05 -0.000835793236772859
+ 3.0052e-05 -0.000562311900469144
+ 3.0054e-05 -0.000456142926743695
+ 3.0056e-05 -0.000620389483715104
+ 3.0058e-05 -0.00087996736296306
+ 3.006e-05 -0.000646034362878609
+ 3.0062e-05 -0.000703389456241615
+ 3.0064e-05 -0.000681708462417863
+ 3.0066e-05 -0.000761990934192089
+ 3.0068e-05 -0.000802231735305865
+ 3.007e-05 -0.000829680586411569
+ 3.0072e-05 -0.000737960138866331
+ 3.0074e-05 -0.000678113072193035
+ 3.0076e-05 -0.000883109172034571
+ 3.0078e-05 -0.000617609962447807
+ 3.008e-05 -0.000584478805065993
+ 3.0082e-05 -0.000806150638112569
+ 3.0084e-05 -0.000919603584541784
+ 3.0086e-05 -0.00139714995669116
+ 3.0088e-05 -0.00128607852397593
+ 3.009e-05 -0.000860475731439274
+ 3.0092e-05 -0.000802242923850526
+ 3.0094e-05 -0.000888826898658606
+ 3.0096e-05 -0.00112563576657048
+ 3.0098e-05 -0.00102110622998286
+ 3.01e-05 -0.00112985807133427
+ 3.0102e-05 -0.00115728592570442
+ 3.0104e-05 -0.000913143783891421
+ 3.0106e-05 -0.000921765980697128
+ 3.0108e-05 -0.00100714482948392
+ 3.011e-05 -0.0011725744061011
+ 3.0112e-05 -0.00126765215113726
+ 3.0114e-05 -0.00146431257082229
+ 3.0116e-05 -0.00144412050737056
+ 3.0118e-05 -0.00159229107181111
+ 3.012e-05 -0.00199025309155287
+ 3.0122e-05 -0.00179921177775051
+ 3.0124e-05 -0.00208675703580128
+ 3.0126e-05 -0.00238739011920741
+ 3.0128e-05 -0.00215210908303298
+ 3.013e-05 -0.00252666500300648
+ 3.0132e-05 -0.00242188222600407
+ 3.0134e-05 -0.00230535917358572
+ 3.0136e-05 -0.00207235367023265
+ 3.0138e-05 -0.00212975393681452
+ 3.014e-05 -0.00191173329221581
+ 3.0142e-05 -0.00176607866177369
+ 3.0144e-05 -0.00161237191564788
+ 3.0146e-05 -0.00189717234944984
+ 3.0148e-05 -0.00208635950173395
+ 3.015e-05 -0.00187100954068043
+ 3.0152e-05 -0.00191877850844953
+ 3.0154e-05 -0.00160398407149065
+ 3.0156e-05 -0.00144717597115253
+ 3.0158e-05 -0.00121739471685966
+ 3.016e-05 -0.00103693403170879
+ 3.0162e-05 -0.000862756692214248
+ 3.0164e-05 -0.000844203863258169
+ 3.0166e-05 -0.000694039166393535
+ 3.0168e-05 -0.000484639040286024
+ 3.017e-05 -0.000757502988113669
+ 3.0172e-05 -0.00066391907278252
+ 3.0174e-05 -0.000589209671265545
+ 3.0176e-05 -0.000685857907001423
+ 3.0178e-05 -0.000681315135856345
+ 3.018e-05 -0.0010005101176092
+ 3.0182e-05 -0.00103662174168416
+ 3.0184e-05 -0.00147561575628179
+ 3.0186e-05 -0.00154938541074154
+ 3.0188e-05 -0.00138144532187344
+ 3.019e-05 -0.000983741703757724
+ 3.0192e-05 -0.000960419303590881
+ 3.0194e-05 -0.0011741970529753
+ 3.0196e-05 -0.000784592273656016
+ 3.0198e-05 -0.000613952031741484
+ 3.02e-05 -0.000519462917483113
+ 3.0202e-05 -0.000420931213409111
+ 3.0204e-05 -0.000538242546074685
+ 3.0206e-05 -0.000442451925923603
+ 3.0208e-05 -0.000245057123590803
+ 3.021e-05 -0.000320229506752975
+ 3.0212e-05 -0.000210457817878979
+ 3.0214e-05 0.000240961884311136
+ 3.0216e-05 0.000516124721318024
+ 3.0218e-05 0.000361613190128835
+ 3.022e-05 0.000178135181946439
+ 3.0222e-05 0.000150334954005085
+ 3.0224e-05 -0.000102364449758395
+ 3.0226e-05 -3.7932884554437e-06
+ 3.0228e-05 -2.94328511256203e-05
+ 3.023e-05 1.30675233755695e-05
+ 3.0232e-05 -0.000300699781547922
+ 3.0234e-05 8.65250476228179e-05
+ 3.0236e-05 6.363207355438e-05
+ 3.0238e-05 0.000312553509537286
+ 3.024e-05 5.51821950322087e-05
+ 3.0242e-05 6.0910918882167e-05
+ 3.0244e-05 -4.92277527552442e-05
+ 3.0246e-05 0.000357652918508729
+ 3.0248e-05 0.000496996618067048
+ 3.025e-05 -7.94405348430632e-05
+ 3.0252e-05 -0.000316006886369301
+ 3.0254e-05 -0.000255861892821246
+ 3.0256e-05 -0.000357589971114381
+ 3.0258e-05 -0.000456014515319318
+ 3.026e-05 -0.000618982977646181
+ 3.0262e-05 -0.000725938850214117
+ 3.0264e-05 -0.000648019593339619
+ 3.0266e-05 -0.000592814665678637
+ 3.0268e-05 -0.00076721534796555
+ 3.027e-05 -0.00064048085987256
+ 3.0272e-05 -0.000367269418332914
+ 3.0274e-05 -0.000464147804151967
+ 3.0276e-05 -0.000525231926903622
+ 3.0278e-05 -0.000653410461717698
+ 3.028e-05 -0.000950878877602862
+ 3.0282e-05 -0.000979651849728915
+ 3.0284e-05 -0.000936852269376488
+ 3.0286e-05 -0.000816743421235105
+ 3.0288e-05 -0.000672309987045972
+ 3.029e-05 -0.000379740841654258
+ 3.0292e-05 -0.000381113887413636
+ 3.0294e-05 -0.000409951390647287
+ 3.0296e-05 -0.000521842166993969
+ 3.0298e-05 -0.00016890513480793
+ 3.03e-05 -0.000228661766411114
+ 3.0302e-05 -0.000173462092769488
+ 3.0304e-05 -0.000259601291925521
+ 3.0306e-05 -0.000341890403266256
+ 3.0308e-05 -0.000698932089450407
+ 3.031e-05 -0.000814724824434313
+ 3.0312e-05 -0.00093433209545807
+ 3.0314e-05 -0.0005076394173969
+ 3.0316e-05 -0.000248223336023056
+ 3.0318e-05 -0.000225430419580628
+ 3.032e-05 -0.000125951859718592
+ 3.0322e-05 9.14340558654564e-05
+ 3.0324e-05 -0.000207196473105904
+ 3.0326e-05 -0.00046579003284841
+ 3.0328e-05 -0.00052556538953972
+ 3.033e-05 -0.000742026389500138
+ 3.0332e-05 -0.000832110637168869
+ 3.0334e-05 -0.000593518372043654
+ 3.0336e-05 -0.000470779497354069
+ 3.0338e-05 -0.000395980559723721
+ 3.034e-05 -0.000663594472836518
+ 3.0342e-05 -0.000752449838298448
+ 3.0344e-05 -0.000905588326134734
+ 3.0346e-05 -0.00111471497505613
+ 3.0348e-05 -0.0012797329423714
+ 3.035e-05 -0.00163743596135222
+ 3.0352e-05 -0.00141795677562044
+ 3.0354e-05 -0.0013586702317617
+ 3.0356e-05 -0.00152117156992214
+ 3.0358e-05 -0.00133557748899413
+ 3.036e-05 -0.00126466624254686
+ 3.0362e-05 -0.00110204622928136
+ 3.0364e-05 -0.000705868271970578
+ 3.0366e-05 -0.000515356157631607
+ 3.0368e-05 -0.000584241131216685
+ 3.037e-05 -0.00064774386548465
+ 3.0372e-05 -0.000758271702132902
+ 3.0374e-05 -0.000827248308091262
+ 3.0376e-05 -0.000572998147922357
+ 3.0378e-05 -0.000659600120112803
+ 3.038e-05 -0.00054012764912627
+ 3.0382e-05 -0.00121239486436276
+ 3.0384e-05 -0.00112501923488622
+ 3.0386e-05 -0.000979616980550895
+ 3.0388e-05 -0.00103645454942894
+ 3.039e-05 -0.00120373468719743
+ 3.0392e-05 -0.00108485869036194
+ 3.0394e-05 -0.00104612669765131
+ 3.0396e-05 -0.00124859802805838
+ 3.0398e-05 -0.00139674860454472
+ 3.04e-05 -0.00121033178166838
+ 3.0402e-05 -0.000948434515403862
+ 3.0404e-05 -0.000881032735568779
+ 3.0406e-05 -0.000602075419668623
+ 3.0408e-05 -0.000489410477402159
+ 3.041e-05 -0.000288959886169148
+ 3.0412e-05 -0.000181597332535868
+ 3.0414e-05 -0.000238018229620598
+ 3.0416e-05 -0.000132998026724967
+ 3.0418e-05 -0.000135003890236808
+ 3.042e-05 -1.7786337911726e-06
+ 3.0422e-05 -0.000190559020408043
+ 3.0424e-05 -0.000174972506199138
+ 3.0426e-05 -0.000145339735162408
+ 3.0428e-05 -0.000207710895059915
+ 3.043e-05 -0.000352282794735146
+ 3.0432e-05 -0.000163550643869001
+ 3.0434e-05 -0.000289794351898428
+ 3.0436e-05 -0.000358396323603683
+ 3.0438e-05 -0.000778784846321443
+ 3.044e-05 -0.000867835857674709
+ 3.0442e-05 -0.000979224118367583
+ 3.0444e-05 -0.0010654653846202
+ 3.0446e-05 -0.00100907438370406
+ 3.0448e-05 -0.000845505573985506
+ 3.045e-05 -0.000818146203514661
+ 3.0452e-05 -0.00101599121828103
+ 3.0454e-05 -0.000901402073491271
+ 3.0456e-05 -0.00102788805068039
+ 3.0458e-05 -0.000825193101163069
+ 3.046e-05 -0.00077298768926933
+ 3.0462e-05 -0.000742202281927116
+ 3.0464e-05 -0.00096224714568782
+ 3.0466e-05 -0.00105118343413739
+ 3.0468e-05 -0.000886041297389284
+ 3.047e-05 -0.00103973105086571
+ 3.0472e-05 -0.000565125537778128
+ 3.0474e-05 -0.000952857007766457
+ 3.0476e-05 -0.00113183545339037
+ 3.0478e-05 -0.000869765592801046
+ 3.048e-05 -0.000843385281806566
+ 3.0482e-05 -0.000940835510057784
+ 3.0484e-05 -0.000758805442392425
+ 3.0486e-05 -0.000472923794926381
+ 3.0488e-05 -6.74373951597008e-05
+ 3.049e-05 -0.000189451671680194
+ 3.0492e-05 -8.03128302898786e-05
+ 3.0494e-05 -8.99879703514417e-06
+ 3.0496e-05 0.000213462231835947
+ 3.0498e-05 0.000129934112581425
+ 3.05e-05 0.000230909436511008
+ 3.0502e-05 -4.17171042612985e-05
+ 3.0504e-05 -0.000194483870808216
+ 3.0506e-05 -0.000341256990980924
+ 3.0508e-05 -0.00043647386737417
+ 3.051e-05 -0.000842169812634993
+ 3.0512e-05 -0.000907168450101235
+ 3.0514e-05 -0.000727044504594153
+ 3.0516e-05 -0.0004868498308007
+ 3.0518e-05 -0.00049461562517503
+ 3.052e-05 -0.00047378038706808
+ 3.0522e-05 -0.00056107526286429
+ 3.0524e-05 -0.00103493319645377
+ 3.0526e-05 -0.00111220208017274
+ 3.0528e-05 -0.00114306290003797
+ 3.053e-05 -0.00110399454003949
+ 3.0532e-05 -0.00134582022880746
+ 3.0534e-05 -0.0012693127705791
+ 3.0536e-05 -0.00120266128776661
+ 3.0538e-05 -0.00148006853156181
+ 3.054e-05 -0.00153345477748845
+ 3.0542e-05 -0.00162403981289272
+ 3.0544e-05 -0.00180500595638025
+ 3.0546e-05 -0.00186441301107711
+ 3.0548e-05 -0.00171019378078427
+ 3.055e-05 -0.00134720138699557
+ 3.0552e-05 -0.00117830811484445
+ 3.0554e-05 -0.00127324177936988
+ 3.0556e-05 -0.00109131918734175
+ 3.0558e-05 -0.0011073473380042
+ 3.056e-05 -0.00112966040150675
+ 3.0562e-05 -0.00118757526538162
+ 3.0564e-05 -0.000922027235622263
+ 3.0566e-05 -0.000538803386814455
+ 3.0568e-05 -0.000571688499732186
+ 3.057e-05 -0.000658048951289141
+ 3.0572e-05 -0.000445501833368169
+ 3.0574e-05 -0.000831485462717537
+ 3.0576e-05 -0.000647177042338142
+ 3.0578e-05 -0.000712978944810041
+ 3.058e-05 -0.000739413756454732
+ 3.0582e-05 -0.000909475291869801
+ 3.0584e-05 -0.000476927271692133
+ 3.0586e-05 -0.000414889512790009
+ 3.0588e-05 -0.000861742593155443
+ 3.059e-05 -0.00093280740773217
+ 3.0592e-05 -0.000865264090956166
+ 3.0594e-05 -0.000818218528085933
+ 3.0596e-05 -0.00032241415646973
+ 3.0598e-05 -0.000125396489865751
+ 3.06e-05 -0.000130578730893537
+ 3.0602e-05 -0.000316539247176763
+ 3.0604e-05 9.18764519762668e-05
+ 3.0606e-05 0.000182883038668883
+ 3.0608e-05 0.000231936860649019
+ 3.061e-05 -1.50897014128965e-05
+ 3.0612e-05 -1.60026111080327e-05
+ 3.0614e-05 -0.000107906329810849
+ 3.0616e-05 8.23352258287148e-05
+ 3.0618e-05 -0.00013845774190594
+ 3.062e-05 2.48192814971011e-05
+ 3.0622e-05 -2.19774931610959e-05
+ 3.0624e-05 0.000313023731689496
+ 3.0626e-05 0.000264493355005919
+ 3.0628e-05 0.000287301945039111
+ 3.063e-05 -2.7801200776458e-05
+ 3.0632e-05 -0.000204121771102476
+ 3.0634e-05 -0.000552904700382564
+ 3.0636e-05 -0.00137823051038582
+ 3.0638e-05 -0.00132866692102295
+ 3.064e-05 -0.00151051415743399
+ 3.0642e-05 -0.00160226103472314
+ 3.0644e-05 -0.00178693591018908
+ 3.0646e-05 -0.00163830301448803
+ 3.0648e-05 -0.0013881536127164
+ 3.065e-05 -0.0017845596272949
+ 3.0652e-05 -0.00170585725731468
+ 3.0654e-05 -0.00128965469906133
+ 3.0656e-05 -0.00137004543062415
+ 3.0658e-05 -0.00157309221827095
+ 3.066e-05 -0.00120809990350518
+ 3.0662e-05 -0.00123056320967226
+ 3.0664e-05 -0.00114937406140241
+ 3.0666e-05 -0.00117130760289765
+ 3.0668e-05 -0.000897140636875835
+ 3.067e-05 -0.000927579991366408
+ 3.0672e-05 -0.000788657375042192
+ 3.0674e-05 -0.000643866391269279
+ 3.0676e-05 -0.000713565688325853
+ 3.0678e-05 -0.000941545509514015
+ 3.068e-05 -0.00116800436343952
+ 3.0682e-05 -0.00140284421050987
+ 3.0684e-05 -0.00127576042694509
+ 3.0686e-05 -0.00100010251436194
+ 3.0688e-05 -0.000975435396152113
+ 3.069e-05 -0.000964537154720917
+ 3.0692e-05 -0.00115199379791796
+ 3.0694e-05 -0.00145511450300122
+ 3.0696e-05 -0.00132793365643972
+ 3.0698e-05 -0.00141241260702008
+ 3.07e-05 -0.00141283315523936
+ 3.0702e-05 -0.00131009652613386
+ 3.0704e-05 -0.00153149345571103
+ 3.0706e-05 -0.00148827651288461
+ 3.0708e-05 -0.00149914300921719
+ 3.071e-05 -0.00136159082249477
+ 3.0712e-05 -0.00151897718937496
+ 3.0714e-05 -0.00158619245294891
+ 3.0716e-05 -0.0015143169713675
+ 3.0718e-05 -0.00161631662164633
+ 3.072e-05 -0.00156842882274885
+ 3.0722e-05 -0.00142009886881721
+ 3.0724e-05 -0.00140115635909469
+ 3.0726e-05 -0.00118721446455448
+ 3.0728e-05 -0.00115314271208246
+ 3.073e-05 -0.00153724887969281
+ 3.0732e-05 -0.00151119931450316
+ 3.0734e-05 -0.00139268295398532
+ 3.0736e-05 -0.00143159613400253
+ 3.0738e-05 -0.00149257957079394
+ 3.074e-05 -0.00107615010722333
+ 3.0742e-05 -0.0014022515426333
+ 3.0744e-05 -0.00174673894044521
+ 3.0746e-05 -0.00135229448156885
+ 3.0748e-05 -0.00157634783278362
+ 3.075e-05 -0.00128889333104714
+ 3.0752e-05 -0.00107318085795871
+ 3.0754e-05 -0.00116110295880645
+ 3.0756e-05 -0.00093504139319488
+ 3.0758e-05 -0.000577265269418103
+ 3.076e-05 -0.000461925222916251
+ 3.0762e-05 -0.000760718654518731
+ 3.0764e-05 -0.000814104002821205
+ 3.0766e-05 -0.00100856661807815
+ 3.0768e-05 -0.00128854411229236
+ 3.077e-05 -0.00116307764094233
+ 3.0772e-05 -0.00112477535888124
+ 3.0774e-05 -0.00131192090637133
+ 3.0776e-05 -0.00152483953230331
+ 3.0778e-05 -0.00148409589192472
+ 3.078e-05 -0.0013628682563862
+ 3.0782e-05 -0.00136732729894428
+ 3.0784e-05 -0.00116355081320498
+ 3.0786e-05 -0.00110225954406228
+ 3.0788e-05 -0.000897936837447949
+ 3.079e-05 -0.000917410803111673
+ 3.0792e-05 -0.000726180116634327
+ 3.0794e-05 -0.000701747409377708
+ 3.0796e-05 -0.000959220532491321
+ 3.0798e-05 -0.00105118208318488
+ 3.08e-05 -0.00127765063892195
+ 3.0802e-05 -0.00109485539254612
+ 3.0804e-05 -0.00101597517796059
+ 3.0806e-05 -0.00113929878188547
+ 3.0808e-05 -0.00127647183451997
+ 3.081e-05 -0.00148399377492128
+ 3.0812e-05 -0.00163936692318774
+ 3.0814e-05 -0.00180443048609586
+ 3.0816e-05 -0.00205823494790265
+ 3.0818e-05 -0.00198069387482773
+ 3.082e-05 -0.00209455263042631
+ 3.0822e-05 -0.00217849813874028
+ 3.0824e-05 -0.00220594792617494
+ 3.0826e-05 -0.00240051183812274
+ 3.0828e-05 -0.00230972924599838
+ 3.083e-05 -0.00234753164461695
+ 3.0832e-05 -0.00220557340583376
+ 3.0834e-05 -0.00242860692428762
+ 3.0836e-05 -0.00234519882645787
+ 3.0838e-05 -0.00228193182486009
+ 3.084e-05 -0.00255927985310112
+ 3.0842e-05 -0.00247181769944025
+ 3.0844e-05 -0.00193552761348512
+ 3.0846e-05 -0.00211640577880424
+ 3.0848e-05 -0.00206363395075659
+ 3.085e-05 -0.00205441407833746
+ 3.0852e-05 -0.00179077570671552
+ 3.0854e-05 -0.00163420761379874
+ 3.0856e-05 -0.0016540272927627
+ 3.0858e-05 -0.00145627939260011
+ 3.086e-05 -0.00152751261621151
+ 3.0862e-05 -0.0014800194803288
+ 3.0864e-05 -0.00156635124959748
+ 3.0866e-05 -0.00152088885293115
+ 3.0868e-05 -0.00148285103818329
+ 3.087e-05 -0.00134478930192471
+ 3.0872e-05 -0.000985668759008687
+ 3.0874e-05 -0.00115394927696605
+ 3.0876e-05 -0.00109814938138505
+ 3.0878e-05 -0.00110354373478914
+ 3.088e-05 -0.00095974067472668
+ 3.0882e-05 -0.000891920626385805
+ 3.0884e-05 -0.00106998333791522
+ 3.0886e-05 -0.0010946797234885
+ 3.0888e-05 -0.000974668851703171
+ 3.089e-05 -0.00107555274796525
+ 3.0892e-05 -0.000922509196290466
+ 3.0894e-05 -0.00106859307189405
+ 3.0896e-05 -0.00123822673229832
+ 3.0898e-05 -0.00110649865301494
+ 3.09e-05 -0.00153389454410664
+ 3.0902e-05 -0.0015013512093605
+ 3.0904e-05 -0.00140117170982341
+ 3.0906e-05 -0.00151896074258896
+ 3.0908e-05 -0.00176926139490299
+ 3.091e-05 -0.0014787923055037
+ 3.0912e-05 -0.00143742942093192
+ 3.0914e-05 -0.00141647079010296
+ 3.0916e-05 -0.00119139238831793
+ 3.0918e-05 -0.00108662585521256
+ 3.092e-05 -0.00148773343689615
+ 3.0922e-05 -0.00168006497101073
+ 3.0924e-05 -0.0015073152689668
+ 3.0926e-05 -0.00129566742120471
+ 3.0928e-05 -0.000846619702074584
+ 3.093e-05 -0.000736978610021747
+ 3.0932e-05 -0.00111522796153008
+ 3.0934e-05 -0.00115657666693728
+ 3.0936e-05 -0.00119091479514619
+ 3.0938e-05 -0.00137603840896868
+ 3.094e-05 -0.00147069930979465
+ 3.0942e-05 -0.00157894502330748
+ 3.0944e-05 -0.00151028454491976
+ 3.0946e-05 -0.00173362787722473
+ 3.0948e-05 -0.00160934691460313
+ 3.095e-05 -0.00117862474885912
+ 3.0952e-05 -0.00118425577867117
+ 3.0954e-05 -0.00122442019499912
+ 3.0956e-05 -0.00107111479205272
+ 3.0958e-05 -0.000891946713219149
+ 3.096e-05 -0.000769791139156211
+ 3.0962e-05 -0.00061905189473994
+ 3.0964e-05 -0.000593552760981609
+ 3.0966e-05 -0.000549890170166506
+ 3.0968e-05 -0.000952714182736874
+ 3.097e-05 -0.00108163819081519
+ 3.0972e-05 -0.000949922700362212
+ 3.0974e-05 -0.00105599029588928
+ 3.0976e-05 -0.00104047951091811
+ 3.0978e-05 -0.00130979669440548
+ 3.098e-05 -0.00104686498511931
+ 3.0982e-05 -0.00116615151405197
+ 3.0984e-05 -0.00118118803771746
+ 3.0986e-05 -0.00104027081662093
+ 3.0988e-05 -0.000742464231822668
+ 3.099e-05 -0.000947398101726136
+ 3.0992e-05 -0.000519056724311021
+ 3.0994e-05 -0.000159482930298991
+ 3.0996e-05 0.000270503767348665
+ 3.0998e-05 -4.02103267435501e-05
+ 3.1e-05 -0.000105915572845769
+ 3.1002e-05 0.000181788572218007
+ 3.1004e-05 7.69974740456581e-05
+ 3.1006e-05 3.35028420541539e-05
+ 3.1008e-05 3.06729988562895e-05
+ 3.101e-05 -0.000208432845827918
+ 3.1012e-05 -0.000247762895992101
+ 3.1014e-05 -0.000351827826458254
+ 3.1016e-05 -0.000542317496126184
+ 3.1018e-05 -3.54870646729722e-05
+ 3.102e-05 -0.000173260718375391
+ 3.1022e-05 -0.000512232512524717
+ 3.1024e-05 -0.000546742576268639
+ 3.1026e-05 -0.000793616555847099
+ 3.1028e-05 -0.000778190895001622
+ 3.103e-05 -0.00112160964290416
+ 3.1032e-05 -0.00106449513438311
+ 3.1034e-05 -0.000867708660267309
+ 3.1036e-05 -0.000742389764575258
+ 3.1038e-05 -0.00113792197259333
+ 3.104e-05 -0.00120225712754153
+ 3.1042e-05 -0.0012581466514141
+ 3.1044e-05 -0.00137067442723622
+ 3.1046e-05 -0.00144367335540127
+ 3.1048e-05 -0.00157929175479441
+ 3.105e-05 -0.00125870387468688
+ 3.1052e-05 -0.00148094370358992
+ 3.1054e-05 -0.00142841744905257
+ 3.1056e-05 -0.00118171591188448
+ 3.1058e-05 -0.000965515794384627
+ 3.106e-05 -0.000959935882194774
+ 3.1062e-05 -0.00103018765585455
+ 3.1064e-05 -0.000956521728134577
+ 3.1066e-05 -0.000918892647476219
+ 3.1068e-05 -0.000630572704607574
+ 3.107e-05 -0.000450699338898158
+ 3.1072e-05 -0.000256090486814321
+ 3.1074e-05 -0.00012632364303489
+ 3.1076e-05 0.000151739815491946
+ 3.1078e-05 0.000219057007767819
+ 3.108e-05 0.000198778385687318
+ 3.1082e-05 -0.00019692375950647
+ 3.1084e-05 -0.000318818959200334
+ 3.1086e-05 -0.000673406065897323
+ 3.1088e-05 -0.000855984727305746
+ 3.109e-05 -0.000926089150415052
+ 3.1092e-05 -0.000728114368093709
+ 3.1094e-05 -0.000611118704101564
+ 3.1096e-05 -0.000300917476905857
+ 3.1098e-05 -0.000527151894723568
+ 3.11e-05 -0.000836989207483037
+ 3.1102e-05 -0.000626795495028426
+ 3.1104e-05 -0.000458440681317249
+ 3.1106e-05 -0.000448710564057351
+ 3.1108e-05 -0.000206462511712032
+ 3.111e-05 0.000214861120465276
+ 3.1112e-05 0.000417632795964419
+ 3.1114e-05 0.000594832442934733
+ 3.1116e-05 0.000461486311701435
+ 3.1118e-05 0.000236311624249194
+ 3.112e-05 0.000423638777543411
+ 3.1122e-05 0.000193070885855668
+ 3.1124e-05 0.000323328542324997
+ 3.1126e-05 2.60077848226296e-05
+ 3.1128e-05 -0.000146433578919035
+ 3.113e-05 -0.00035063026357365
+ 3.1132e-05 -0.000345892692535594
+ 3.1134e-05 2.04111909520565e-05
+ 3.1136e-05 -0.000237356880805211
+ 3.1138e-05 -7.76850816325601e-05
+ 3.114e-05 -0.00029486090590208
+ 3.1142e-05 -0.000367371479134897
+ 3.1144e-05 -0.000487961424185011
+ 3.1146e-05 -0.000487706782038063
+ 3.1148e-05 -0.000548446533957181
+ 3.115e-05 -0.000508478238619896
+ 3.1152e-05 -0.000420329335509059
+ 3.1154e-05 -0.000486668735601235
+ 3.1156e-05 -0.000426020061302611
+ 3.1158e-05 -0.000143826693973503
+ 3.116e-05 -0.000158350482370215
+ 3.1162e-05 -9.93561007065346e-05
+ 3.1164e-05 -4.60164705621979e-06
+ 3.1166e-05 0.000398283005183094
+ 3.1168e-05 0.000250222599815061
+ 3.117e-05 0.000704772787616492
+ 3.1172e-05 0.000493305757550464
+ 3.1174e-05 0.000319680114069535
+ 3.1176e-05 0.000101965242408372
+ 3.1178e-05 -0.000201164538528316
+ 3.118e-05 -0.000302602525700923
+ 3.1182e-05 3.06700294855588e-05
+ 3.1184e-05 -0.000152060791899197
+ 3.1186e-05 -7.96286859523538e-05
+ 3.1188e-05 0.000273594939204463
+ 3.119e-05 0.000346707535484221
+ 3.1192e-05 0.000538678869206082
+ 3.1194e-05 0.000515149387634754
+ 3.1196e-05 0.00080620613367488
+ 3.1198e-05 0.000370559476242223
+ 3.12e-05 0.000372844363040734
+ 3.1202e-05 2.02029895176363e-05
+ 3.1204e-05 -4.32831809256998e-05
+ 3.1206e-05 0.000178818520574348
+ 3.1208e-05 0.000356650545306231
+ 3.121e-05 0.000208669157259709
+ 3.1212e-05 -0.000167957693850478
+ 3.1214e-05 0.000270469454836188
+ 3.1216e-05 0.000513968427938091
+ 3.1218e-05 0.000608947171359841
+ 3.122e-05 0.00062945758892275
+ 3.1222e-05 0.00095717413148015
+ 3.1224e-05 0.000638209530509205
+ 3.1226e-05 0.000750050192146077
+ 3.1228e-05 0.000602687826346702
+ 3.123e-05 0.000788583411237443
+ 3.1232e-05 0.000728330322170679
+ 3.1234e-05 0.000453143254913514
+ 3.1236e-05 0.000501589886371994
+ 3.1238e-05 0.000498813409225749
+ 3.124e-05 0.000663527171827055
+ 3.1242e-05 0.000676361754649685
+ 3.1244e-05 0.000965708766758526
+ 3.1246e-05 0.00107616367417988
+ 3.1248e-05 0.000955236164910723
+ 3.125e-05 0.00071702934731376
+ 3.1252e-05 0.000928197293272551
+ 3.1254e-05 0.000810465508495106
+ 3.1256e-05 0.000721474111749978
+ 3.1258e-05 0.000925064456313212
+ 3.126e-05 0.00106928017785229
+ 3.1262e-05 0.00132174153212186
+ 3.1264e-05 0.00142359597662923
+ 3.1266e-05 0.00134175913485046
+ 3.1268e-05 0.00138974843710271
+ 3.127e-05 0.00128697823231701
+ 3.1272e-05 0.00100641271455304
+ 3.1274e-05 0.00114231441109985
+ 3.1276e-05 0.000794114355008019
+ 3.1278e-05 0.00110674199338364
+ 3.128e-05 0.001242114544574
+ 3.1282e-05 0.00101155340279637
+ 3.1284e-05 0.00101732874353639
+ 3.1286e-05 0.00100725486347655
+ 3.1288e-05 0.00115034071828562
+ 3.129e-05 0.00145442219339701
+ 3.1292e-05 0.00124934032909164
+ 3.1294e-05 0.00115940769146126
+ 3.1296e-05 0.0013217073404518
+ 3.1298e-05 0.00128511682812254
+ 3.13e-05 0.00103108510726053
+ 3.1302e-05 0.00100013387378382
+ 3.1304e-05 0.00110165621528976
+ 3.1306e-05 0.00119308710741993
+ 3.1308e-05 0.00139324861883063
+ 3.131e-05 0.00105045838207339
+ 3.1312e-05 0.00105394318172282
+ 3.1314e-05 0.000978494915205004
+ 3.1316e-05 0.00105112888070787
+ 3.1318e-05 0.00112483407724564
+ 3.132e-05 0.000863884113131463
+ 3.1322e-05 0.00119761113627461
+ 3.1324e-05 0.00122678894237722
+ 3.1326e-05 0.00127881534216603
+ 3.1328e-05 0.00109952995565919
+ 3.133e-05 0.00131052750050894
+ 3.1332e-05 0.000942892621858719
+ 3.1334e-05 0.00055231081708499
+ 3.1336e-05 0.000266626320130464
+ 3.1338e-05 0.000179064663633959
+ 3.134e-05 0.000315436906732328
+ 3.1342e-05 0.000346503655346418
+ 3.1344e-05 0.000281330452496458
+ 3.1346e-05 0.000327464819024379
+ 3.1348e-05 0.000554112577649086
+ 3.135e-05 0.000485872340380805
+ 3.1352e-05 0.000461103844315961
+ 3.1354e-05 0.000476188002696834
+ 3.1356e-05 0.000531466002147626
+ 3.1358e-05 0.000290928446866506
+ 3.136e-05 0.000410571282850166
+ 3.1362e-05 -9.30860623421341e-05
+ 3.1364e-05 1.45610470533238e-06
+ 3.1366e-05 -0.000170881542812871
+ 3.1368e-05 -0.000129290000497636
+ 3.137e-05 -0.000278633073318683
+ 3.1372e-05 -0.000388881927023644
+ 3.1374e-05 -0.000521507464415368
+ 3.1376e-05 -0.000428445508306086
+ 3.1378e-05 -0.000918514568121655
+ 3.138e-05 -0.000967163729497563
+ 3.1382e-05 -0.00101409185626986
+ 3.1384e-05 -0.00116924264804138
+ 3.1386e-05 -0.000803203107493636
+ 3.1388e-05 -0.000720587154395544
+ 3.139e-05 -0.000696884304566784
+ 3.1392e-05 -0.000720983321842913
+ 3.1394e-05 -0.000616849746126965
+ 3.1396e-05 -0.000564244867787495
+ 3.1398e-05 -0.000539323850053951
+ 3.14e-05 -0.000626638857192265
+ 3.1402e-05 -0.000523883982408349
+ 3.1404e-05 -0.000256242331246733
+ 3.1406e-05 -0.000359102725836528
+ 3.1408e-05 -0.000385081858039559
+ 3.141e-05 -0.000600129049684288
+ 3.1412e-05 -0.000255776096986395
+ 3.1414e-05 -0.000198773585010066
+ 3.1416e-05 -0.000374808681796277
+ 3.1418e-05 -0.000610784244287626
+ 3.142e-05 -0.000516405444881574
+ 3.1422e-05 -0.000790180943885199
+ 3.1424e-05 -0.000834069558470934
+ 3.1426e-05 -0.000621887284043878
+ 3.1428e-05 -0.000816511934928698
+ 3.143e-05 -0.00100100219170871
+ 3.1432e-05 -0.00119030754537559
+ 3.1434e-05 -0.000953680201921933
+ 3.1436e-05 -0.00114652504353043
+ 3.1438e-05 -0.00118500251029611
+ 3.144e-05 -0.00131415577660858
+ 3.1442e-05 -0.00118203507151077
+ 3.1444e-05 -0.00118798249263727
+ 3.1446e-05 -0.00126756060075734
+ 3.1448e-05 -0.00142536368817826
+ 3.145e-05 -0.00116683741809698
+ 3.1452e-05 -0.00130996009794766
+ 3.1454e-05 -0.00150414212786285
+ 3.1456e-05 -0.00166421147982556
+ 3.1458e-05 -0.001630701265465
+ 3.146e-05 -0.00157919784660214
+ 3.1462e-05 -0.00200493404237821
+ 3.1464e-05 -0.00197989443813398
+ 3.1466e-05 -0.00206704783530802
+ 3.1468e-05 -0.00211395732495339
+ 3.147e-05 -0.00222088906864967
+ 3.1472e-05 -0.00193193163174858
+ 3.1474e-05 -0.00190719303420491
+ 3.1476e-05 -0.00179168670423823
+ 3.1478e-05 -0.00193458842083562
+ 3.148e-05 -0.00215502429398387
+ 3.1482e-05 -0.00222029602334071
+ 3.1484e-05 -0.00192856359506188
+ 3.1486e-05 -0.00176630103807322
+ 3.1488e-05 -0.00132521875823813
+ 3.149e-05 -0.00147137501517204
+ 3.1492e-05 -0.00123004595045901
+ 3.1494e-05 -0.00115068517333174
+ 3.1496e-05 -0.000960409558720257
+ 3.1498e-05 -0.000811565271835417
+ 3.15e-05 -0.000961125920766719
+ 3.1502e-05 -0.000538923691736478
+ 3.1504e-05 -0.000285685019312273
+ 3.1506e-05 -4.4521662084142e-05
+ 3.1508e-05 -0.000323784317553716
+ 3.151e-05 -3.31956556020344e-05
+ 3.1512e-05 -0.000307665734854783
+ 3.1514e-05 -0.00030588663179429
+ 3.1516e-05 -0.000161122070331171
+ 3.1518e-05 0.000146958728800823
+ 3.152e-05 0.000383212928879721
+ 3.1522e-05 0.000512465179080034
+ 3.1524e-05 0.000429224471451083
+ 3.1526e-05 0.000342964460748846
+ 3.1528e-05 0.000392699700364027
+ 3.153e-05 0.000481575332315386
+ 3.1532e-05 0.000543963268705204
+ 3.1534e-05 0.000673159715473584
+ 3.1536e-05 0.00076270228113103
+ 3.1538e-05 0.00081615388202208
+ 3.154e-05 0.000997852843762867
+ 3.1542e-05 0.00118558407856172
+ 3.1544e-05 0.00127254709146113
+ 3.1546e-05 0.00159548617161389
+ 3.1548e-05 0.00158689057262659
+ 3.155e-05 0.00150998523713822
+ 3.1552e-05 0.00158657867686739
+ 3.1554e-05 0.00152675373873187
+ 3.1556e-05 0.0013638877871882
+ 3.1558e-05 0.0015405621085516
+ 3.156e-05 0.00192408137164024
+ 3.1562e-05 0.00196079460435513
+ 3.1564e-05 0.00173222911167012
+ 3.1566e-05 0.0016503615864448
+ 3.1568e-05 0.00160913325922392
+ 3.157e-05 0.00151683007534427
+ 3.1572e-05 0.00144794760734879
+ 3.1574e-05 0.00124246074120144
+ 3.1576e-05 0.0011947204538704
+ 3.1578e-05 0.00133679547429545
+ 3.158e-05 0.00148693219330134
+ 3.1582e-05 0.00133160602693413
+ 3.1584e-05 0.00146123489662814
+ 3.1586e-05 0.00158991819127281
+ 3.1588e-05 0.00165345091986052
+ 3.159e-05 0.00165273280586994
+ 3.1592e-05 0.00155537881602859
+ 3.1594e-05 0.00138576188232259
+ 3.1596e-05 0.00104392011543298
+ 3.1598e-05 0.00129177391746719
+ 3.16e-05 0.00102978284581292
+ 3.1602e-05 0.000870191574883694
+ 3.1604e-05 0.00118302092748813
+ 3.1606e-05 0.00126664345372187
+ 3.1608e-05 0.00137246107332173
+ 3.161e-05 0.00132771367097731
+ 3.1612e-05 0.00134921520865996
+ 3.1614e-05 0.00122796753871563
+ 3.1616e-05 0.00119051572356129
+ 3.1618e-05 0.00118298694452594
+ 3.162e-05 0.00113335121142793
+ 3.1622e-05 0.00135407870300489
+ 3.1624e-05 0.00136409421005389
+ 3.1626e-05 0.00118586637670826
+ 3.1628e-05 0.00121801914044973
+ 3.163e-05 0.000861222280133086
+ 3.1632e-05 0.000749957298826234
+ 3.1634e-05 0.000802828818656389
+ 3.1636e-05 0.000917904705579541
+ 3.1638e-05 0.000819065424407392
+ 3.164e-05 0.000785052111364276
+ 3.1642e-05 0.000576901179108953
+ 3.1644e-05 0.000418348087002077
+ 3.1646e-05 0.000450937234409837
+ 3.1648e-05 0.000594884351441018
+ 3.165e-05 0.000277792419243149
+ 3.1652e-05 0.000397425801193609
+ 3.1654e-05 0.000552520943747149
+ 3.1656e-05 0.00062119872343835
+ 3.1658e-05 0.000847674382921884
+ 3.166e-05 0.000898297655604739
+ 3.1662e-05 0.00102425731759216
+ 3.1664e-05 0.001029923959035
+ 3.1666e-05 0.00108714824166134
+ 3.1668e-05 0.00111217933058311
+ 3.167e-05 0.000823315281942133
+ 3.1672e-05 0.000698958104951059
+ 3.1674e-05 0.000524815961962554
+ 3.1676e-05 0.000342772750079995
+ 3.1678e-05 0.00059328210890149
+ 3.168e-05 0.000676321210741771
+ 3.1682e-05 0.000909470524588493
+ 3.1684e-05 0.00123300283984547
+ 3.1686e-05 0.00127621536134401
+ 3.1688e-05 0.00138328192630102
+ 3.169e-05 0.00145656039977144
+ 3.1692e-05 0.00120295165945341
+ 3.1694e-05 0.00120311796340524
+ 3.1696e-05 0.00111996679269001
+ 3.1698e-05 0.000947448177351438
+ 3.17e-05 0.000877524573141018
+ 3.1702e-05 0.000864559077207419
+ 3.1704e-05 0.00059547591014202
+ 3.1706e-05 0.000721590225670277
+ 3.1708e-05 0.000914013461142651
+ 3.171e-05 0.000773360122169421
+ 3.1712e-05 0.00104045677363371
+ 3.1714e-05 0.00101120850396009
+ 3.1716e-05 0.000844643643407196
+ 3.1718e-05 0.00107001695107715
+ 3.172e-05 0.00119591336164896
+ 3.1722e-05 0.00123543687031503
+ 3.1724e-05 0.0010907455469217
+ 3.1726e-05 0.000828135799533182
+ 3.1728e-05 0.000486030887923083
+ 3.173e-05 0.000613484697671459
+ 3.1732e-05 0.000543391451257517
+ 3.1734e-05 0.000381768242746412
+ 3.1736e-05 0.000506975481868484
+ 3.1738e-05 0.000467145113713957
+ 3.174e-05 0.00012465408441062
+ 3.1742e-05 0.000205018021858236
+ 3.1744e-05 0.000383479209963579
+ 3.1746e-05 0.000255706172665853
+ 3.1748e-05 0.000336525698488642
+ 3.175e-05 -0.000236934482305174
+ 3.1752e-05 0.000211677413593865
+ 3.1754e-05 0.000166069551236296
+ 3.1756e-05 8.23835623494574e-05
+ 3.1758e-05 0.00036214843130783
+ 3.176e-05 0.000116315110935417
+ 3.1762e-05 -0.000238206686301341
+ 3.1764e-05 1.19057990378565e-05
+ 3.1766e-05 -0.000345435222864946
+ 3.1768e-05 -0.000513923380560279
+ 3.177e-05 -0.000384490107041234
+ 3.1772e-05 -0.000234522309585221
+ 3.1774e-05 -0.000307091550025237
+ 3.1776e-05 -0.000560381298447148
+ 3.1778e-05 -0.000329994054747535
+ 3.178e-05 -0.000742202863112375
+ 3.1782e-05 -0.000836358212081839
+ 3.1784e-05 -0.000786309253239582
+ 3.1786e-05 -0.00064567508737027
+ 3.1788e-05 -0.000574746967758484
+ 3.179e-05 -0.000373849943797554
+ 3.1792e-05 -0.000364109754297587
+ 3.1794e-05 -0.000353138991808034
+ 3.1796e-05 -0.000341299514528056
+ 3.1798e-05 -0.000395194109616502
+ 3.18e-05 -0.000458951422664909
+ 3.1802e-05 -0.000592150103886459
+ 3.1804e-05 -0.000658574733913287
+ 3.1806e-05 -0.000541715125401882
+ 3.1808e-05 -0.000284999807391304
+ 3.181e-05 -0.000376244234087698
+ 3.1812e-05 -0.000358232656576141
+ 3.1814e-05 -0.000279954841047184
+ 3.1816e-05 -0.000239268329078449
+ 3.1818e-05 -0.00018986142147256
+ 3.182e-05 -0.00010808520481588
+ 3.1822e-05 -0.000495385501429041
+ 3.1824e-05 -0.000377649706937463
+ 3.1826e-05 -0.000614631378894524
+ 3.1828e-05 -0.000763823187949787
+ 3.183e-05 -0.000915167777632329
+ 3.1832e-05 -0.000727871432887727
+ 3.1834e-05 -0.000789841051414753
+ 3.1836e-05 -0.000710916496809396
+ 3.1838e-05 -0.00077556875427019
+ 3.184e-05 -0.000862520187099112
+ 3.1842e-05 -0.000912605351086443
+ 3.1844e-05 -0.000450029796530303
+ 3.1846e-05 -0.000119750899535704
+ 3.1848e-05 -0.0004207995185459
+ 3.185e-05 -0.000199013925924164
+ 3.1852e-05 -2.468371720235e-05
+ 3.1854e-05 -9.79937787923984e-05
+ 3.1856e-05 0.000265407348873668
+ 3.1858e-05 0.000126530912243814
+ 3.186e-05 -0.000166128984944699
+ 3.1862e-05 -0.000505333246301742
+ 3.1864e-05 -0.000626264003628426
+ 3.1866e-05 -0.000484488510847556
+ 3.1868e-05 -0.000233802383645305
+ 3.187e-05 -0.000149173164282776
+ 3.1872e-05 0.000147806257849238
+ 3.1874e-05 -8.83525962231227e-06
+ 3.1876e-05 -0.000241040594648957
+ 3.1878e-05 -0.000189656054548267
+ 3.188e-05 -0.000327794013780579
+ 3.1882e-05 -0.000521374525191005
+ 3.1884e-05 -0.000683458866426856
+ 3.1886e-05 -0.000652479934646575
+ 3.1888e-05 -0.000629091426656333
+ 3.189e-05 -0.000855930275083558
+ 3.1892e-05 -0.000794148518781827
+ 3.1894e-05 -0.000864526382079551
+ 3.1896e-05 -0.00078793771679999
+ 3.1898e-05 -0.000555940489609139
+ 3.19e-05 -0.000574828295160612
+ 3.1902e-05 -0.000568016361014167
+ 3.1904e-05 -0.000263616751525061
+ 3.1906e-05 -0.000457053221406032
+ 3.1908e-05 -0.000661045782437387
+ 3.191e-05 -0.000344133124077576
+ 3.1912e-05 -0.00048343591607266
+ 3.1914e-05 -0.000874188610697392
+ 3.1916e-05 -0.00121631524668547
+ 3.1918e-05 -0.0011236846229897
+ 3.192e-05 -0.00147147069381563
+ 3.1922e-05 -0.00138172604910965
+ 3.1924e-05 -0.00113637444572885
+ 3.1926e-05 -0.00105837135745049
+ 3.1928e-05 -0.00127600814548049
+ 3.193e-05 -0.00119043609602013
+ 3.1932e-05 -0.000734386206735289
+ 3.1934e-05 -0.000952576162404566
+ 3.1936e-05 -0.000784387401458664
+ 3.1938e-05 -0.000795829499633545
+ 3.194e-05 -0.00077970550179077
+ 3.1942e-05 -0.000584292569074375
+ 3.1944e-05 -0.000481641683492755
+ 3.1946e-05 -0.00036836669323925
+ 3.1948e-05 -0.000220041743002659
+ 3.195e-05 -0.000293097541565907
+ 3.1952e-05 -0.000688485281044834
+ 3.1954e-05 -0.00058816448897527
+ 3.1956e-05 -0.000648367819990745
+ 3.1958e-05 -0.000802114037930321
+ 3.196e-05 -0.000649408422267896
+ 3.1962e-05 -0.000809917181247132
+ 3.1964e-05 -0.000688237987663323
+ 3.1966e-05 -0.00051180192693329
+ 3.1968e-05 -0.000344023776735842
+ 3.197e-05 -0.000278762737118877
+ 3.1972e-05 -0.000419848436837456
+ 3.1974e-05 -0.000484860000397208
+ 3.1976e-05 -0.000591367559793179
+ 3.1978e-05 -0.000560331783972683
+ 3.198e-05 -0.000597929463173919
+ 3.1982e-05 -0.000593022534209314
+ 3.1984e-05 -0.000460297985130662
+ 3.1986e-05 -0.000494229792366877
+ 3.1988e-05 -0.000473361615482527
+ 3.199e-05 -0.000348670171320258
+ 3.1992e-05 -0.000513127948154917
+ 3.1994e-05 -0.000503152722508822
+ 3.1996e-05 -0.000220129587477942
+ 3.1998e-05 -3.81504693931377e-05
+ 3.2e-05 0.00019483492664294
+ )
.control
set num_threads=1
set numdgt=15
set wr_singlescale
set wr_vecnames
tran 5n 3.2e-05
wrdata rms_1mV.dat v(fout) v(vref_injected) i(vdd) v(vref) i(vdd12)
quit
.endc
.end
