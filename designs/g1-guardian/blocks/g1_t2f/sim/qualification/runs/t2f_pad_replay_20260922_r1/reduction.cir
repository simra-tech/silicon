* Prescribed saved-core-wave actual TEMP pad reduction
.lib /foss/pdks/ihp-sg13g2/libs.tech/ngspice/models/cornerHBT.lib hbt_typ
.lib /foss/pdks/ihp-sg13g2/libs.tech/ngspice/models/cornerMOShv.lib mos_tt
.lib /foss/pdks/ihp-sg13g2/libs.tech/ngspice/models/cornerMOSlv.lib mos_tt
.lib /foss/pdks/ihp-sg13g2/libs.tech/ngspice/models/cornerRES.lib res_typ
.lib /foss/pdks/ihp-sg13g2/libs.tech/ngspice/models/cornerCAP.lib cap_typ
.lib /foss/pdks/ihp-sg13g2/libs.tech/ngspice/models/cornerDIO.lib dio_tt
.option gmin=1e-15 abstol=1e-13 reltol=1e-4 vntol=1e-6 method=gear
.temp 25
.global sub!
Vsub sub! 0 dc 0
.include io.spi
Vpad12 pad_vdd 0 1.2
Vpad33 pad_iovdd 0 3.3
Rroute fout pad_c2p 210.936
Croute_near fout 0 11.72035f
Croute_far pad_c2p 0 11.72035f
Xpad temp_pad pad_c2p pad_vdd 0 pad_iovdd 0 sg13g2_IOPadOut16mA
Cexternal temp_pad 0 10p
Vreplay fout 0 PWL(
+ 0 6.1920998144163666e-08
+ 5.0000000000000002e-11 6.1920998746091801e-08
+ 1e-10 6.1920997694566002e-08
+ 2.0000000000000001e-10 6.1920998358489021e-08
+ 4.0000000000000001e-10 6.1920997703009492e-08
+ 8.0000000000000003e-10 6.1920998625103388e-08
+ 1.6000000000000001e-09 6.1920997989481527e-08
+ 3.2000000000000001e-09 6.1920997922177123e-08
+ 6.4000000000000002e-09 6.1920997963837776e-08
+ 1.14e-08 6.1920997986940348e-08
+ 1.6400000000000001e-08 6.1920998389287973e-08
+ 2.14e-08 6.19209981961915e-08
+ 2.6400000000000001e-08 6.1920997984121648e-08
+ 3.1400000000000003e-08 6.1920998067063035e-08
+ 3.6400000000000002e-08 6.1920998093951169e-08
+ 4.1399999999999987e-08 6.1920998181554705e-08
+ 4.6399999999999992e-08 6.19209982124553e-08
+ 5.139999999999999e-08 6.1920998305044922e-08
+ 5.6399999999999989e-08 6.1920998105660751e-08
+ 6.1399999999999994e-08 6.1920998156401148e-08
+ 6.6399999999999999e-08 6.1920997959510034e-08
+ 7.1400000000000004e-08 6.1920997956907525e-08
+ 7.6400000000000009e-08 6.1920998338764086e-08
+ 8.1400000000000014e-08 6.1920998076712235e-08
+ 8.6400000000000019e-08 6.1920998124526332e-08
+ 9.1400000000000024e-08 6.1920998242270066e-08
+ 9.6400000000000029e-08 6.1920998015780166e-08
+ 1.0139999999999999e-07 6.1920998099914294e-08
+ 1.064e-07 6.1920998135367652e-08
+ 1.114e-07 6.1920998134391778e-08
+ 1.164e-07 6.1920998025646935e-08
+ 1.2139999999999999e-07 6.1920998051233617e-08
+ 1.2639999999999999e-07 6.1920998132873789e-08
+ 1.314000000000001e-07 6.1920998169194548e-08
+ 1.3640000000000011e-07 6.1920998212020958e-08
+ 1.4140000000000009e-07 6.1920998256906835e-08
+ 1.4640000000000009e-07 6.1920998089723072e-08
+ 1.514000000000001e-07 6.1920998117478144e-08
+ 1.564000000000001e-07 6.1920998191528915e-08
+ 1.6140000000000011e-07 6.1920997978267327e-08
+ 1.6640000000000009e-07 6.1920998344077126e-08
+ 1.7140000000000009e-07 6.1920998135258703e-08
+ 1.764000000000001e-07 6.192099818307268e-08
+ 1.814000000000001e-07 6.1920998188168603e-08
+ 1.8640000000000011e-07 6.1920998280216745e-08
+ 1.9140000000000011e-07 6.1920998029007896e-08
+ 1.9640000000000009e-07 6.1920998115743845e-08
+ 2.014000000000001e-07 6.1920998186866938e-08
+ 2.064000000000001e-07 6.1920998221454205e-08
+ 2.1140000000000011e-07 6.1920998257339828e-08
+ 2.1640000000000011e-07 6.1920998096336904e-08
+ 2.2140000000000009e-07 6.192099812506756e-08
+ 2.2640000000000009e-07 6.1920997964280642e-08
+ 2.3140000000000021e-07 6.1920998280000447e-08
+ 2.3640000000000021e-07 6.1920998315562067e-08
+ 2.4140000000000008e-07 6.1920998118996226e-08
+ 2.4640000000000009e-07 6.1920998162038867e-08
+ 2.5140000000000009e-07 6.1920997996264752e-08
+ 2.564000000000002e-07 6.1920998315345478e-08
+ 2.6140000000000021e-07 6.1920998070749388e-08
+ 2.6640000000000021e-07 6.1920998168110598e-08
+ 2.7140000000000022e-07 6.1920998202587989e-08
+ 2.7640000000000023e-07 6.1920998001251897e-08
+ 2.8140000000000018e-07 6.1920998369447272e-08
+ 2.8640000000000018e-07 6.1920998150004316e-08
+ 2.9140000000000019e-07 6.1920998152281815e-08
+ 2.9640000000000019e-07 6.1920998291058515e-08
+ 3.014000000000002e-07 6.192099807172562e-08
+ 3.064000000000002e-07 6.1920998117152712e-08
+ 3.1140000000000021e-07 6.1920998210828441e-08
+ 3.1640000000000021e-07 6.1920998006347395e-08
+ 3.2140000000000022e-07 6.1920998053618888e-08
+ 3.2640000000000022e-07 6.192099806240082e-08
+ 3.3140000000000017e-07 6.1920998151630817e-08
+ 3.3640000000000018e-07 6.1920998233054374e-08
+ 3.4140000000000019e-07 6.1920998033452979e-08
+ 3.4640000000000019e-07 6.1920998277831421e-08
+ 3.514000000000002e-07 6.1920998088205639e-08
+ 3.5640000000000031e-07 6.1920998214297266e-08
+ 3.6140000000000031e-07 6.1920997999191833e-08
+ 3.6640000000000032e-07 6.1920997995939147e-08
+ 3.7140000000000032e-07 6.1920998327597015e-08
+ 3.7640000000000033e-07 6.1920998114117091e-08
+ 3.8140000000000028e-07 6.1920998237716761e-08
+ 3.8640000000000028e-07 6.1920998260701754e-08
+ 3.9140000000000029e-07 6.1920998107069698e-08
+ 3.9640000000000029e-07 6.1920997905516832e-08
+ 4.014000000000003e-07 6.1920998193047565e-08
+ 4.064000000000003e-07 6.1920997995396834e-08
+ 4.1140000000000031e-07 6.1920998035187544e-08
+ 4.1640000000000031e-07 6.192099808408481e-08
+ 4.2140000000000032e-07 6.1920998169411534e-08
+ 4.2640000000000032e-07 6.1920998154449981e-08
+ 4.3140000000000028e-07 6.1920998285096012e-08
+ 4.3640000000000028e-07 6.1920998303527648e-08
+ 4.4140000000000029e-07 6.1920998154232797e-08
+ 4.4640000000000029e-07 6.1920998194456618e-08
+ 4.514000000000003e-07 6.1920998245739923e-08
+ 4.5640000000000041e-07 6.192099804776409e-08
+ 4.6140000000000041e-07 6.1920998085928377e-08
+ 4.6640000000000042e-07 6.1920998171038116e-08
+ 4.7140000000000042e-07 6.1920998203997332e-08
+ 4.7640000000000037e-07 6.1920998206816946e-08
+ 4.8140000000000038e-07 6.192099830114231e-08
+ 4.8640000000000033e-07 6.1920998087553966e-08
+ 4.9140000000000028e-07 6.1920997925900004e-08
+ 4.9640000000000024e-07 6.1920998186542551e-08
+ 5.0140000000000019e-07 6.192099826102675e-08
+ 5.0640000000000014e-07 6.1920998134283265e-08
+ 5.1140000000000009e-07 6.1920997911913426e-08
+ 5.1640000000000004e-07 6.1920998154449955e-08
+ 5.214e-07 6.192099829160096e-08
+ 5.2639999999999995e-07 6.192099802933268e-08
+ 5.313999999999999e-07 6.1920998165184152e-08
+ 5.3639999999999985e-07 6.1920998184481759e-08
+ 5.4139999999999981e-07 6.1920997942704966e-08
+ 5.4639999999999976e-07 6.1920998032043252e-08
+ 5.5139999999999971e-07 6.1920998390046743e-08
+ 5.5639999999999966e-07 6.1920998170495909e-08
+ 5.6139999999999961e-07 6.1920998210502916e-08
+ 5.6639999999999957e-07 6.1920998298323305e-08
+ 5.7139999999999952e-07 6.1920998097528705e-08
+ 5.7639999999999947e-07 6.1920998099372312e-08
+ 5.8139999999999942e-07 6.1920998149029129e-08
+ 5.8639999999999937e-07 6.1920998269049357e-08
+ 5.9139999999999933e-07 6.1920998287373578e-08
+ 5.9639999999999928e-07 6.1920998138403246e-08
+ 6.0139999999999923e-07 6.1920998173314848e-08
+ 6.0639999999999918e-07 6.1920998224706189e-08
+ 6.1139999999999914e-07 6.1920998026730211e-08
+ 6.1639999999999909e-07 6.1920998064678399e-08
+ 6.2139999999999904e-07 6.1920998154883239e-08
+ 6.2639999999999899e-07 6.1920998144800489e-08
+ 6.3139999999999894e-07 6.1920998281734972e-08
+ 6.363999999999989e-07 6.1920998024020301e-08
+ 6.4139999999999885e-07 6.1920998320982667e-08
+ 6.463999999999988e-07 6.1920998157160619e-08
+ 6.5139999999999875e-07 6.1920997994855038e-08
+ 6.563999999999987e-07 6.1920998029332799e-08
+ 6.6139999999999866e-07 6.1920998073243053e-08
+ 6.6639999999999861e-07 6.1920998119646721e-08
+ 6.7139999999999856e-07 6.192099821245399e-08
+ 6.7639999999999851e-07 6.192099801296124e-08
+ 6.8139999999999847e-07 6.1920998262003207e-08
+ 6.8639999999999842e-07 6.1920998067496318e-08
+ 6.9139999999999837e-07 6.1920998436017312e-08
+ 6.9639999999999832e-07 6.1920997937067154e-08
+ 7.0139999999999827e-07 6.1920998226115268e-08
+ 7.0639999999999823e-07 6.1920998106853281e-08
+ 7.1139999999999818e-07 6.192099817635019e-08
+ 7.1639999999999813e-07 6.1920997934031084e-08
+ 7.2139999999999808e-07 6.1920998273170013e-08
+ 7.2639999999999803e-07 6.1920998310358029e-08
+ 7.3139999999999799e-07 6.1920998112057081e-08
+ 7.3639999999999794e-07 6.192099819901069e-08
+ 7.4139999999999789e-07 6.1920998229801476e-08
+ 7.4639999999999784e-07 6.1920998274362384e-08
+ 7.5139999999999779e-07 6.1920998356545081e-08
+ 7.5639999999999775e-07 6.1920998150763628e-08
+ 7.613999999999977e-07 6.1920997907576789e-08
+ 7.6639999999999765e-07 6.1920998281301384e-08
+ 7.713999999999976e-07 6.1920998067497205e-08
+ 7.7639999999999756e-07 6.1920998148269724e-08
+ 7.8139999999999751e-07 6.1920997937283942e-08
+ 7.8639999999999746e-07 6.1920998224489336e-08
+ 7.9139999999999741e-07 6.1920998029440809e-08
+ 7.9639999999999736e-07 6.1920998112925316e-08
+ 8.0139999999999732e-07 6.1920998100997927e-08
+ 8.0639999999999727e-07 6.1920997949209636e-08
+ 8.1139999999999722e-07 6.1920998261460789e-08
+ 8.1639999999999717e-07 6.1920998333234999e-08
+ 8.2139999999999712e-07 6.1920998123766133e-08
+ 8.2639999999999708e-07 6.1920998208876877e-08
+ 8.3139999999999703e-07 6.1920998000926795e-08
+ 8.3639999999999698e-07 6.1920998091457306e-08
+ 8.4139999999999693e-07 6.1920998082241614e-08
+ 8.4639999999999689e-07 6.1920998127236414e-08
+ 8.5139999999999684e-07 6.1920998247582868e-08
+ 8.5639999999999679e-07 6.1920998271435541e-08
+ 8.6139999999999674e-07 6.1920998074651815e-08
+ 8.6639999999999669e-07 6.192099816344927e-08
+ 8.7139999999999665e-07 6.1920997910178742e-08
+ 8.763999999999966e-07 6.1920998244980558e-08
+ 8.8139999999999655e-07 6.1920998081591039e-08
+ 8.863999999999965e-07 6.1920998118346102e-08
+ 8.9139999999999645e-07 6.192099791787618e-08
+ 8.9639999999999641e-07 6.1920997962546514e-08
+ 9.0139999999999636e-07 6.1920998288023212e-08
+ 9.0639999999999631e-07 6.1920998078663191e-08
+ 9.1139999999999626e-07 6.1920998116611444e-08
+ 9.1639999999999622e-07 6.1920998205949306e-08
+ 9.2139999999999617e-07 6.1920997959943953e-08
+ 9.2639999999999612e-07 6.1920998298973588e-08
+ 9.3139999999999607e-07 6.1920998334210635e-08
+ 9.3639999999999602e-07 6.1920998133091066e-08
+ 9.4139999999999598e-07 6.1920998259617314e-08
+ 9.4639999999999593e-07 6.192099803952377e-08
+ 9.5139999999999588e-07 6.192099828336154e-08
+ 9.5639999999999583e-07 6.1920998423440355e-08
+ 9.6139999999999578e-07 6.1920997962329171e-08
+ 9.6639999999999574e-07 6.1920998006672815e-08
+ 9.7139999999999569e-07 6.1920998337245885e-08
+ 9.7639999999999564e-07 6.192099784935541e-08
+ 9.8139999999999559e-07 6.1920998144149597e-08
+ 9.8639999999999554e-07 6.1920998178302164e-08
+ 9.913999999999955e-07 6.1920998258533271e-08
+ 9.9569999999999773e-07 6.1920998235143144e-08
+ 9.9999999999999995e-07 6.1920998417845398e-08
+ 1.0000836117280381e-06 0.000149748142425829
+ 1.0002508351841141e-06 0.00023536507188221729
+ 1.0005852820962659e-06 0.00023560058302706899
+ 1.0009820607169901e-06 0.00022372401324906299
+ 1.0016938282749951e-06 0.00022128642315581771
+ 1.002013314942463e-06 0.0002217218791553838
+ 1.002425331178789e-06 0.00022184902258335449
+ 1.0026792099333619e-06 0.00022184320127412499
+ 1.0029664044265011e-06 0.00022183768273244719
+ 1.0033613335955161e-06 0.0002218371892574336
+ 1.003695332883304e-06 0.000221837122903465
+ 1.0038584171912021e-06 0.0002218371407082189
+ 1.0039729183887571e-06 0.0002218368971012452
+ 1.0040676679532559e-06 0.00022183673794308779
+ 1.0041348333986199e-06 0.00022183674140326381
+ 1.004198587744339e-06 0.0002218364855641146
+ 1.0042634446883409e-06 0.0002218363133028182
+ 1.0043318133431381e-06 0.00022183636148017519
+ 1.0044040513382341e-06 0.00022183664442312179
+ 1.004481361361859e-06 0.00022183717971255409
+ 1.004559951799435e-06 0.00022183767401431789
+ 1.0046506162193211e-06 0.00022183754872962349
+ 1.004752576891067e-06 0.0002218364895690988
+ 1.004802797201425e-06 0.00022182667115122989
+ 1.0048405871549671e-06 0.00022180006938718759
+ 1.004872138640148e-06 0.0002217947520835968
+ 1.004917917590009e-06 0.00022192439366392689
+ 1.0049543824889621e-06 0.00022196990305949109
+ 1.0049949503384111e-06 0.0002218692697292348
+ 1.005076086037309e-06 0.0002217719531858066
+ 1.005155582054991e-06 0.00022179379889749731
+ 1.0052383484995369e-06 0.0002218268917460031
+ 1.005333503053044e-06 0.00022184191480057049
+ 1.0054513199511461e-06 0.00022184322024225591
+ 1.005608461970775e-06 0.00022184003169626779
+ 1.005803451430656e-06 0.0002218376707274575
+ 1.0060724585602549e-06 0.00022183688448308079
+ 1.0064832369367331e-06 0.0002218369986388913
+ 1.007056717237683e-06 0.00022183721512039769
+ 1.00777899337771e-06 0.0002218372537519961
+ 1.008378726826703e-06 0.00022183714386865181
+ 1.0091096078840691e-06 0.0002218373248794833
+ 1.009605544698122e-06 0.0002218375013101293
+ 1.0100000000000001e-06 0.00022183688980300289
+ 1.010049245652903e-06 9.9763645462273623e-05
+ 1.010147736958709e-06 1.098950454540273e-06
+ 1.0103379218651879e-06 -1.9371813968010881e-05
+ 1.0107182916781469e-06 -5.3396483472288724e-06
+ 1.011313753533199e-06 3.4983301617894702e-07
+ 1.012429232695319e-06 3.1634782473832992e-07
+ 1.0140466122994359e-06 7.0976958453545864e-08
+ 1.015728355204822e-06 5.9211808834418932e-08
+ 1.017791140934476e-06 6.1689439472442653e-08
+ 1.019984204748593e-06 6.1939225124204324e-08
+ 1.02270305876589e-06 6.1923912602977692e-08
+ 1.025854814805674e-06 6.1920927938615078e-08
+ 1.0300718176497131e-06 6.1920973297975282e-08
+ 1.0346102478103501e-06 6.1920997842200947e-08
+ 1.03961024781035e-06 6.1920998753711471e-08
+ 1.04461024781035e-06 6.1920999005606179e-08
+ 1.0496102478103499e-06 6.1920998605458325e-08
+ 1.054610247810349e-06 6.1920998769690351e-08
+ 1.059610247810349e-06 6.1920998487576565e-08
+ 1.064610247810349e-06 6.1920998240730213e-08
+ 1.0696102478103489e-06 6.1920998120522619e-08
+ 1.0746102478103491e-06 6.1920998120235872e-08
+ 1.079610247810349e-06 6.1920998179773183e-08
+ 1.084610247810349e-06 6.1920998017577041e-08
+ 1.0896102478103489e-06 6.1920998229881071e-08
+ 1.0946102478103491e-06 6.1920998241573342e-08
+ 1.099610247810349e-06 6.1920998330078795e-08
+ 1.104610247810349e-06 6.1920998119838719e-08
+ 1.1096102478103489e-06 6.1920998174417062e-08
+ 1.1146102478103489e-06 6.1920998248081083e-08
+ 1.1196102478103491e-06 6.1920998214291549e-08
+ 1.124610247810349e-06 6.1920998203305465e-08
+ 1.129610247810349e-06 6.1920998156125942e-08
+ 1.1346102478103489e-06 6.1920997903146648e-08
+ 1.1396102478103491e-06 6.192099827634186e-08
+ 1.144610247810349e-06 6.1920998253968425e-08
+ 1.149610247810349e-06 6.192099813437628e-08
+ 1.1546102478103489e-06 6.1920998106582217e-08
+ 1.159610247810348e-06 6.1920998340760887e-08
+ 1.164610247810348e-06 6.1920998169212191e-08
+ 1.1696102478103479e-06 6.1920998279080344e-08
+ 1.1746102478103479e-06 6.1920998042416242e-08
+ 1.1796102478103481e-06 6.1920998318320469e-08
+ 1.184610247810348e-06 6.1920998135711376e-08
+ 1.189610247810348e-06 6.1920998155468207e-08
+ 1.1946102478103479e-06 6.1920998219217601e-08
+ 1.1996102478103481e-06 6.1920998280840744e-08
+ 1.204610247810348e-06 6.192099808062922e-08
+ 1.209610247810348e-06 6.1920998136733506e-08
+ 1.2146102478103479e-06 6.1920998275328187e-08
+ 1.2196102478103481e-06 6.1920998221468512e-08
+ 1.2246102478103481e-06 6.1920998250800389e-08
+ 1.229610247810348e-06 6.1920998004498997e-08
+ 1.234610247810348e-06 6.1920998043678308e-08
+ 1.2396102478103479e-06 6.1920998006587344e-08
+ 1.2446102478103481e-06 6.1920997958146734e-08
+ 1.249610247810348e-06 6.1920997870477964e-08
+ 1.254610247810348e-06 6.1920997322549119e-08
+ 1.2596102478103479e-06 6.1920995231925374e-08
+ 1.2618423775084551e-06 6.1920952001141232e-08
+ 1.263431093354935e-06 6.1920786295601972e-08
+ 1.265346673431756e-06 6.1921147409984268e-08
+ 1.2667405469382819e-06 6.1921209899119405e-08
+ 1.2684544796365079e-06 6.1920831879121465e-08
+ 1.269600108848193e-06 6.1921002169894927e-08
+ 1.270109191938138e-06 6.1921586157040792e-08
+ 1.270704918213471e-06 6.1921090868268538e-08
+ 1.271008696743563e-06 6.1923960842921522e-08
+ 1.27129133335183e-06 6.1923029184350584e-08
+ 1.2715135038039829e-06 6.1913119368331193e-08
+ 1.2717060758459231e-06 6.1789383235511011e-08
+ 1.271904828591074e-06 6.1871730375666391e-08
+ 1.272131348118364e-06 6.1979766559023747e-08
+ 1.272260070085474e-06 6.0991807299173092e-08
+ 1.2723197851965021e-06 5.6761089564333841e-08
+ 1.2723724362417229e-06 5.5006612227439933e-08
+ 1.272414808821284e-06 5.9082823348485501e-08
+ 1.272476147422866e-06 9.3336968385765473e-08
+ 1.272541156524705e-06 1.367635942452086e-07
+ 1.2726043759772729e-06 1.8074087464653041e-07
+ 1.272632529479559e-06 3.4220861762721281e-07
+ 1.272652572582664e-06 6.6582133512119299e-07
+ 1.2726734378682141e-06 8.1398334843395447e-07
+ 1.2726998870249949e-06 3.1299852192963231e-07
+ 1.272723696332353e-06 -6.9822797119493751e-07
+ 1.2727446742477219e-06 -2.5592840764056899e-06
+ 1.2727634287623951e-06 -4.1766456096363874e-06
+ 1.272783418047291e-06 -4.6914689902272812e-06
+ 1.2727952409180281e-06 -5.3839778978244081e-06
+ 1.272805086477119e-06 -3.1975087815666971e-06
+ 1.272816892389481e-06 -4.5269896569195591e-07
+ 1.272829274273475e-06 3.4568361781324909e-07
+ 1.2728456327239379e-06 -7.597144623921256e-07
+ 1.272865742297101e-06 -2.3574850648739558e-06
+ 1.272887792671135e-06 -3.2457291768873099e-06
+ 1.2729148732785201e-06 -3.6209839352713301e-06
+ 1.272937607245063e-06 -2.9007557098646491e-06
+ 1.272961232876646e-06 -1.117965439445853e-06
+ 1.272986191373656e-06 -2.562895954477442e-07
+ 1.2730133496771689e-06 -1.0127496911876629e-06
+ 1.2730429658175861e-06 -2.4353542830230409e-06
+ 1.2730733095979669e-06 -3.541000523816729e-06
+ 1.273095658162825e-06 -3.9479602274434183e-06
+ 1.273120151817057e-06 -2.3837818936135828e-06
+ 1.273141043459548e-06 1.398409111407744e-06
+ 1.273159866125852e-06 -1.63599133152039e-06
+ 1.2731781691730271e-06 -3.8685746374501103e-05
+ 1.27319807729764e-06 -0.0001189697002361134
+ 1.27321809066647e-06 -0.00018554844295599681
+ 1.273233878295026e-06 -0.00016400046590546921
+ 1.273248907540694e-06 -5.3432568499693433e-05
+ 1.2732637135275299e-06 8.0770983980836699e-05
+ 1.273280444354944e-06 0.00017330910291253881
+ 1.27330061358099e-06 0.00019090027023582621
+ 1.2733252763426191e-06 0.00015660057792345441
+ 1.2733540269891891e-06 0.0001073798011796487
+ 1.2733855460864499e-06 7.1845025472229009e-05
+ 1.2734203181943379e-06 5.765106054081394e-05
+ 1.2734594014748769e-06 6.0240096848297739e-05
+ 1.273506937711095e-06 7.9223480034580781e-05
+ 1.2735682167562671e-06 -1.4449694598653229e-05
+ 1.273623710667243e-06 -0.001367942968955836
+ 1.2736683574299739e-06 -0.0051221563984727133
+ 1.2736887389514571e-06 -0.0076270886864581184
+ 1.2737014464603479e-06 -0.0085961108867367592
+ 1.2737126875591219e-06 -0.0075933389242020333
+ 1.2737225380245841e-06 -0.003693519130864575
+ 1.27373266080376e-06 0.0052444411214855402
+ 1.273743858620936e-06 0.023529446922807999
+ 1.273756607540456e-06 0.057499316472199649
+ 1.273771201447313e-06 0.114015522695928
+ 1.2737815817457401e-06 0.1643193308820794
+ 1.2737925245445189e-06 0.22398573266066499
+ 1.2738073492637081e-06 0.31071353157769649
+ 1.2738208927737631e-06 0.3922635033618011
+ 1.273840425947912e-06 0.50855893169502286
+ 1.2738624820542301e-06 0.63373239285421923
+ 1.273895229287096e-06 0.79970995720981308
+ 1.2739313810289851e-06 0.94620033857451324
+ 1.2739765266547899e-06 1.0704932190260441
+ 1.2740161541341651e-06 1.134528222801219
+ 1.2740559912380861e-06 1.1697034703618649
+ 1.2741084291780311e-06 1.191431036781714
+ 1.2741561527770221e-06 1.1985980731301651
+ 1.2742235106891121e-06 1.201339855744491
+ 1.2742982201199701e-06 1.201288192612405
+ 1.274418919377989e-06 1.2005461781015609
+ 1.274550629826982e-06 1.200107097774596
+ 1.274680097226501e-06 1.1999856708795329
+ 1.2748034492900609e-06 1.199978604760829
+ 1.2749232615616659e-06 1.19999011476279
+ 1.2750517538814149e-06 1.199997683661485
+ 1.275170641965655e-06 1.199999958670334
+ 1.275294963506385e-06 1.200000290234033
+ 1.2754127095024e-06 1.200000142155708
+ 1.275534178412172e-06 1.2000000146737151
+ 1.2756517929995649e-06 1.1999999662627749
+ 1.27577204053976e-06 1.1999999561680561
+ 1.2758899833642961e-06 1.199999958023932
+ 1.276009711129182e-06 1.1999999634626131
+ 1.276067848691542e-06 1.199999984724557
+ 1.2761128720731831e-06 1.2000000023851609
+ 1.276164997538444e-06 1.199999977355898
+ 1.2762267779716469e-06 1.199999923850654
+ 1.276257543483307e-06 1.199999903206453
+ 1.276288064774894e-06 1.1999998854178731
+ 1.276312126141206e-06 1.199999847867405
+ 1.276334850549956e-06 1.199999778138408
+ 1.276357222336066e-06 1.199999687221899
+ 1.2763845960855039e-06 1.199999643586896
+ 1.2764042171725589e-06 1.19999988500576
+ 1.276428494833642e-06 1.200000192269459
+ 1.276465339504342e-06 1.200000338265875
+ 1.276516015140363e-06 1.200000210394699
+ 1.2765681272844971e-06 1.200000020820976
+ 1.276640821790288e-06 1.1999998842200139
+ 1.2767113560433191e-06 1.199999865618985
+ 1.276795879709901e-06 1.1999999046972629
+ 1.2768915059568359e-06 1.1999999506335739
+ 1.276998147835012e-06 1.19999997206654
+ 1.2771369685561941e-06 1.1999999716190879
+ 1.2773343208933519e-06 1.199999963272059
+ 1.277703857749708e-06 1.1999999588186481
+ 1.27804880509586e-06 1.199999959616072
+ 1.2785588253632909e-06 1.1999999604484879
+ 1.279090594654454e-06 1.199999960554877
+ 1.2796038619479071e-06 1.1999999604380469
+ 1.2800818944762669e-06 1.1999999604709639
+ 1.280421557342231e-06 1.199999960638326
+ 1.2808099241750589e-06 1.1999999604419449
+ 1.281254351684546e-06 1.1999999604485101
+ 1.281819970532865e-06 1.1999999604756899
+ 1.282467171867075e-06 1.199999960482554
+ 1.2834389833727939e-06 1.1999999604821661
+ 1.2848299547067689e-06 1.1999999604810621
+ 1.2872384083829329e-06 1.1999999604809151
+ 1.2909784444200059e-06 1.199999960480941
+ 1.2959784444200061e-06 1.1999999604808771
+ 1.300978444420006e-06 1.1999999604808571
+ 1.305978444420006e-06 1.1999999604808611
+ 1.3109784444200059e-06 1.199999960480866
+ 1.3159784444200061e-06 1.199999960480868
+ 1.320978444420006e-06 1.199999960480868
+ 1.325978444420006e-06 1.199999960480868
+ 1.3309784444200059e-06 1.199999960480868
+ 1.335978444420005e-06 1.199999960480868
+ 1.340978444420005e-06 1.199999960480868
+ 1.3459784444200049e-06 1.199999960480868
+ 1.3509784444200049e-06 1.199999960480868
+ 1.3559784444200051e-06 1.199999960480868
+ 1.360978444420005e-06 1.199999960480868
+ 1.365978444420005e-06 1.199999960480868
+ 1.3709784444200049e-06 1.199999960480868
+ 1.3759784444200051e-06 1.199999960480868
+ 1.380978444420005e-06 1.199999960480868
+ 1.385978444420005e-06 1.199999960480868
+ 1.3909784444200049e-06 1.199999960480868
+ 1.3959784444200051e-06 1.199999960480868
+ 1.4009784444200051e-06 1.199999960480868
+ 1.405978444420005e-06 1.199999960480868
+ 1.410978444420005e-06 1.199999960480868
+ 1.4159784444200049e-06 1.199999960480868
+ 1.4209784444200051e-06 1.199999960480868
+ 1.425978444420005e-06 1.199999960480868
+ 1.430978444420005e-06 1.199999960480868
+ 1.4359784444200049e-06 1.199999960480868
+ 1.440978444420004e-06 1.199999960480868
+ 1.445978444420004e-06 1.199999960480868
+ 1.4509784444200039e-06 1.199999960480868
+ 1.4559784444200041e-06 1.199999960480868
+ 1.4609784444200041e-06 1.199999960480868
+ 1.465978444420004e-06 1.199999960480868
+ 1.470978444420004e-06 1.199999960480868
+ 1.4759784444200039e-06 1.199999960480868
+ 1.4809784444200041e-06 1.199999960480868
+ 1.485978444420004e-06 1.199999960480868
+ 1.490978444420004e-06 1.199999960480868
+ 1.4959784444200039e-06 1.199999960480868
+ 1.5009784444200041e-06 1.199999960480868
+ 1.505978444420004e-06 1.199999960480868
+ 1.510978444420004e-06 1.1999999604808671
+ 1.515978444420004e-06 1.1999999604808651
+ 1.5209784444200039e-06 1.1999999604808631
+ 1.5259784444200041e-06 1.1999999604808571
+ 1.530978444420004e-06 1.1999999604808469
+ 1.535978444420004e-06 1.199999960480828
+ 1.5409784444200039e-06 1.1999999604807901
+ 1.545978444420003e-06 1.199999960480717
+ 1.550978444420003e-06 1.1999999604805729
+ 1.5559784444200029e-06 1.199999960480298
+ 1.5609784444200031e-06 1.1999999604797851
+ 1.5659784444200031e-06 1.1999999604788749
+ 1.570978444420003e-06 1.19999996047725
+ 1.575978444420003e-06 1.199999960473819
+ 1.5809784444200029e-06 1.1999999604586249
+ 1.583215126295815e-06 1.1999999603341669
+ 1.5849260757562239e-06 1.1999999600635509
+ 1.5870357753989299e-06 1.1999999602427851
+ 1.588445821255852e-06 1.199999960493376
+ 1.590135300715753e-06 1.199999960370179
+ 1.59123066743007e-06 1.199999960614005
+ 1.5916943495944389e-06 1.199999961213307
+ 1.5923394119457971e-06 1.199999961760208
+ 1.592668721661812e-06 1.199999964996681
+ 1.5929352042666151e-06 1.1999999682980149
+ 1.5931484516898439e-06 1.1999999602210041
+ 1.593357485498464e-06 1.199999906761811
+ 1.5935687731215181e-06 1.199999856694731
+ 1.5938092010471911e-06 1.199999802546408
+ 1.5939154848366819e-06 1.199999540850309
+ 1.5939757192746831e-06 1.199999109397937
+ 1.5940260795809371e-06 1.1999986879369049
+ 1.594078179190175e-06 1.199998288899971
+ 1.594141880019435e-06 1.1999979057278909
+ 1.5942137745680541e-06 1.199998278492947
+ 1.5942775816425609e-06 1.199999327157709
+ 1.594298471113945e-06 1.1999997487264069
+ 1.5943181783994091e-06 1.1999998110536341
+ 1.5943383672863991e-06 1.200000354082525
+ 1.594362698372276e-06 1.200003244041185
+ 1.594386766470685e-06 1.200008179916731
+ 1.5944137178340141e-06 1.200010993305918
+ 1.594435664871243e-06 1.200009931205918
+ 1.5944542414880431e-06 1.2000071456734891
+ 1.5944674128773651e-06 1.200004340635541
+ 1.5944833335468069e-06 1.200001372057391
+ 1.5945039493192079e-06 1.19999903444864
+ 1.594531279582131e-06 1.1999977149102929
+ 1.594562990338072e-06 1.1999971381262431
+ 1.5945928118157719e-06 1.19999714863705
+ 1.5946264933608621e-06 1.199998785886359
+ 1.594652815363451e-06 1.200001394571425
+ 1.594681181842168e-06 1.200004354372995
+ 1.5947067047782161e-06 1.2000064568691129
+ 1.594725319660839e-06 1.2000078098090641
+ 1.594741055007569e-06 1.2000091164171769
+ 1.5947568502766519e-06 1.200010984337931
+ 1.5947705756848781e-06 1.2000128805525789
+ 1.594786558764852e-06 1.200013241027474
+ 1.59479623901117e-06 1.2000124055545269
+ 1.594811000163275e-06 1.200010314310729
+ 1.594835186358812e-06 1.2000061417197281
+ 1.594858532638426e-06 1.199995753084083
+ 1.5948827782994189e-06 1.1999522164221541
+ 1.594904140321622e-06 1.1998808989133449
+ 1.594932608159006e-06 1.199748204268777
+ 1.5949735429637419e-06 1.1994390918057041
+ 1.5949932058175949e-06 1.2000363528369229
+ 1.5950096744931389e-06 1.202253746579335
+ 1.595032346751728e-06 1.2089188493218841
+ 1.595056160213156e-06 1.214962976284754
+ 1.595071882752351e-06 1.2031745318556579
+ 1.5950875056862031e-06 1.1632261527563721
+ 1.5951047266150799e-06 1.0887644646057659
+ 1.595123400342305e-06 0.98631766957121469
+ 1.595144419041132e-06 0.8603053400859475
+ 1.595165161552939e-06 0.73421473416823146
+ 1.595179887245053e-06 0.64609718079612011
+ 1.595191133479966e-06 0.58031220770445369
+ 1.5952039461426331e-06 0.50747770680668236
+ 1.595217168447835e-06 0.43521672676758072
+ 1.5952296305727629e-06 0.37048237217350571
+ 1.5952505953558879e-06 0.27170270772722221
+ 1.595272936552921e-06 0.18437168998941111
+ 1.595295783287793e-06 0.1167850859798566
+ 1.595322780637815e-06 0.063317873210516212
+ 1.5953398328369061e-06 0.041796091745541893
+ 1.5953570493784949e-06 0.027094064805173429
+ 1.595376917239059e-06 0.01612095304684296
+ 1.5953982370256891e-06 0.0090137326511322072
+ 1.595422983410097e-06 0.0043958986839325118
+ 1.595451056130714e-06 0.0017773630440438581
+ 1.5954853005470811e-06 0.00041721779696344467
+ 1.595527311757879e-06 -0.0001056345823612981
+ 1.595583149514895e-06 -0.00019037831047005429
+ 1.5956609894109199e-06 -0.00010473953957202651
+ 1.59575055190469e-06 -2.8413506209266511e-05
+ 1.595851008929805e-06 4.943570634834363e-07
+ 1.59598042570908e-06 4.5219488848680247e-06
+ 1.596158346268636e-06 1.7385068306341769e-06
+ 1.5963016820730399e-06 3.3863059263133668e-07
+ 1.596426896836794e-06 2.4031149103064189e-08
+ 1.5965440742916431e-06 1.6301486346432089e-08
+ 1.5966615710857999e-06 4.5739188692764799e-08
+ 1.5967893788248069e-06 6.0617938238480731e-08
+ 1.596909061995942e-06 6.4329531777376029e-08
+ 1.5970342143242931e-06 6.6325539522913517e-08
+ 1.597152819748898e-06 6.9351205068278385e-08
+ 1.597274733586895e-06 7.3932211953436314e-08
+ 1.597392715712282e-06 8.5132863525567365e-08
+ 1.5975131044381571e-06 1.2902586243635239e-07
+ 1.5975882764239859e-06 3.1585391867384132e-07
+ 1.597638506495609e-06 6.0561290515659372e-07
+ 1.597691736750384e-06 6.6106463084668442e-07
+ 1.5977570459924889e-06 2.4279455660624178e-07
+ 1.5977926826233461e-06 -1.4379804247213701e-07
+ 1.597822897816031e-06 -5.4428554707861642e-07
+ 1.597847303603805e-06 -9.9063680445403251e-07
+ 1.597870287102573e-06 -1.501509782910033e-06
+ 1.5978916256728421e-06 -1.7808465387355031e-06
+ 1.597920374689848e-06 -1.6526048935549071e-06
+ 1.5979411021732269e-06 -1.7584499184801169e-06
+ 1.597963948385529e-06 -6.9598523405599099e-07
+ 1.5980044636108211e-06 1.1042298876355791e-06
+ 1.598043778691974e-06 1.434176817203383e-06
+ 1.598103522838892e-06 7.5223718097701064e-07
+ 1.5981676679941551e-06 1.946423877916802e-07
+ 1.598246554634533e-06 3.2586616984023681e-08
+ 1.5983307165329809e-06 -2.0060547574609521e-08
+ 1.5984300890361789e-06 -8.150559320860441e-09
+ 1.5985447415283349e-06 4.6657659904623413e-08
+ 1.5986698668362441e-06 7.3821335918820373e-08
+ 1.598837556995047e-06 7.0494438474004875e-08
+ 1.599079267713698e-06 6.1858860839152106e-08
+ 1.599389909915717e-06 6.0710778757150028e-08
+ 1.599738533550874e-06 6.1714044534273278e-08
+ 1.600169099543083e-06 6.2032404078881934e-08
+ 1.600682665757256e-06 6.2064166513234388e-08
+ 1.601291596690356e-06 6.1574524585996862e-08
+ 1.6016848654622359e-06 6.0250382237939174e-08
+ 1.602023947071166e-06 6.3084536097263281e-08
+ 1.602451253534568e-06 6.2229024267916629e-08
+ 1.6029127075897721e-06 6.1720954229922613e-08
+ 1.603457761058365e-06 6.1910008407856468e-08
+ 1.604044271738244e-06 6.192220120662546e-08
+ 1.604857241090052e-06 6.1919085525963114e-08
+ 1.605998457085095e-06 6.1921782173264262e-08
+ 1.6079779965198321e-06 6.1921400662832012e-08
+ 1.61098488624307e-06 6.1921012628146286e-08
+ 1.61598488624307e-06 6.1920981457446098e-08
+ 1.6209848862430699e-06 6.1920995018670695e-08
+ 1.6259848862430701e-06 6.1920997611412275e-08
+ 1.63098488624307e-06 6.1920997839654633e-08
+ 1.63598488624307e-06 6.1920998218048259e-08
+ 1.6409848862430699e-06 6.1920998169271509e-08
+ 1.645984886243069e-06 6.1920998066001385e-08
+ 1.650984886243069e-06 6.192099812429402e-08
+ 1.6559848862430689e-06 6.1920998174301284e-08
+ 1.6609848862430691e-06 6.1920998250308395e-08
+ 1.6659848862430691e-06 6.1920998042745553e-08
+ 1.670984886243069e-06 6.1920998066338755e-08
+ 1.675984886243069e-06 6.1920998140628971e-08
+ 1.6809848862430689e-06 6.1920998202740349e-08
+ 1.6859848862430691e-06 6.1920998019616987e-08
+ 1.690984886243069e-06 6.1920998323680692e-08
+ 1.695984886243069e-06 6.1920998111986605e-08
+ 1.7009848862430689e-06 6.1920997922522646e-08
+ 1.7059848862430691e-06 6.1920998028074968e-08
+ 1.710984886243069e-06 6.192099804602586e-08
+ 1.715984886243069e-06 6.1920998101161881e-08
+ 1.720984886243069e-06 6.192099816312479e-08
+ 1.7259848862430689e-06 6.1920998239175749e-08
+ 1.7309848862430691e-06 6.192099828789588e-08
+ 1.735984886243069e-06 6.1920998032164377e-08
+ 1.740984886243069e-06 6.1920998087481809e-08
+ 1.7459848862430689e-06 6.1920998154393548e-08
+ 1.750984886243068e-06 6.1920998240166049e-08
+ 1.755984886243068e-06 6.1920998021056903e-08
+ 1.7609848862430679e-06 6.1920998127533458e-08
+ 1.7659848862430681e-06 6.1920998124179102e-08
+ 1.7709848862430681e-06 6.1920997971533322e-08
+ 1.775984886243068e-06 6.1920998027055988e-08
+ 1.780984886243068e-06 6.1920998072825479e-08
+ 1.7859848862430679e-06 6.1920998106350209e-08
+ 1.7909848862430681e-06 6.1920998214796804e-08
+ 1.795984886243068e-06 6.1920998000484392e-08
+ 1.800984886243068e-06 6.192099806991559e-08
+ 1.8059848862430679e-06 6.1920998065738037e-08
+ 1.8109848862430681e-06 6.1920998170207309e-08
+ 1.815984886243068e-06 6.1920998219176057e-08
+ 1.820984886243068e-06 6.1920998296776861e-08
+ 1.8259848862430679e-06 6.1920998094771004e-08
+ 1.8309848862430679e-06 6.1920998141702599e-08
+ 1.8359848862430681e-06 6.1920997911509457e-08
+ 1.840984886243068e-06 6.1920998249629776e-08
+ 1.845984886243068e-06 6.1920998064126279e-08
+ 1.8509848862430671e-06 6.1920998068971347e-08
+ 1.855984886243067e-06 6.1920998189516378e-08
+ 1.860984886243067e-06 6.1920998182398389e-08
+ 1.8659848862430669e-06 6.1920998335885868e-08
+ 1.8709848862430671e-06 6.192099823411208e-08
+ 1.875984886243067e-06 6.1920998280893802e-08
+ 1.880984886243067e-06 6.1920998289779668e-08
+ 1.885984886243067e-06 6.1920998111458546e-08
+ 1.8909848862430669e-06 6.1920997949987001e-08
+ 1.8959848862430671e-06 6.1920997821296054e-08
+ 1.900984886243067e-06 6.1920997679363998e-08
+ 1.905984886243067e-06 6.1920996851198498e-08
+ 1.9109848862430671e-06 6.1920985781327491e-08
+ 1.9129214000631578e-06 6.1920813487690958e-08
+ 1.9148208021725348e-06 6.1921183458522656e-08
+ 1.9161808783026498e-06 6.1921154824639122e-08
+ 1.9178788878045128e-06 6.1920766456005998e-08
+ 1.9190642456919262e-06 6.1921144601914406e-08
+ 1.9195818200526201e-06 6.1921388376982224e-08
+ 1.92022355294878e-06 6.1921088833967362e-08
+ 1.9205482570460228e-06 6.1923570492388293e-08
+ 1.9208370552476819e-06 6.1922820015030732e-08
+ 1.9210642956149538e-06 6.1911090490808384e-08
+ 1.921267103803351e-06 6.1806916804538156e-08
+ 1.9214751515366469e-06 6.1896590989208165e-08
+ 1.9217128317692188e-06 6.1958591603632886e-08
+ 1.9218402567053589e-06 6.0993863955279036e-08
+ 1.9219003287536561e-06 5.726189146819297e-08
+ 1.92195538193667e-06 5.6073622953644307e-08
+ 1.921999634175438e-06 5.9967271894842611e-08
+ 1.9220631452379199e-06 9.1311379918992831e-08
+ 1.922130110653665e-06 1.3085419461362439e-07
+ 1.9221951652174932e-06 1.733766285599783e-07
+ 1.9222242997768221e-06 3.379777716811051e-07
+ 1.9222448485663068e-06 6.619697914609805e-07
+ 1.9222670681306838e-06 7.7280062818591408e-07
+ 1.9222947684470058e-06 2.3430325166970759e-07
+ 1.9223174850551872e-06 -8.3255887997822945e-07
+ 1.9223383829758259e-06 -2.727084377622286e-06
+ 1.922357645334556e-06 -4.2460297600283469e-06
+ 1.9223725319751119e-06 -5.0678102455812236e-06
+ 1.9223876951380231e-06 -4.4391678465679113e-06
+ 1.9223981219940879e-06 -2.235338987514028e-06
+ 1.922410895547195e-06 -5.5423904218500458e-07
+ 1.9224290172538911e-06 -6.4798992149376647e-07
+ 1.922449771113603e-06 -1.826552126517034e-06
+ 1.9224739425175578e-06 -2.7844179091565838e-06
+ 1.922503017184605e-06 -3.4404020044721779e-06
+ 1.9225262001468302e-06 -3.061031301375687e-06
+ 1.9225500115387189e-06 -1.404628980149562e-06
+ 1.9225773715820961e-06 -3.2232943199371619e-07
+ 1.9226064705080241e-06 -1.060912629260386e-06
+ 1.9226353669162891e-06 -2.4232724037162668e-06
+ 1.9226667417454798e-06 -3.58285802515807e-06
+ 1.9226902206597619e-06 -3.9374041742728631e-06
+ 1.9227150606051922e-06 -1.9079107245372471e-06
+ 1.9227347759698361e-06 1.7145526696527651e-06
+ 1.9227532706533192e-06 -3.2295424267358231e-06
+ 1.9227737517089922e-06 -5.1801779525135557e-05
+ 1.922793259512462e-06 -0.0001327588252447993
+ 1.922814794583065e-06 -0.000188326015186039
+ 1.9228286667217831e-06 -0.0001472597366278969
+ 1.9228426437679699e-06 -3.2524041815005867e-05
+ 1.922857732537017e-06 0.00010068234358989199
+ 1.922873935051001e-06 0.0001792311497944973
+ 1.9228959198839911e-06 0.00018783307636561469
+ 1.9229194558281879e-06 0.0001512698291634375
+ 1.922950190048059e-06 0.0001002795181395116
+ 1.9229810114112162e-06 6.9016997479092777e-05
+ 1.9230171762161049e-06 5.709687112604786e-05
+ 1.9230562518839692e-06 6.1642803136983368e-05
+ 1.9231060371920072e-06 8.3011801002188929e-05
+ 1.92316888196813e-06 -9.2297484014014876e-05
+ 1.9232194954263089e-06 -0.0015933591070975391
+ 1.9232645485404189e-06 -0.0056896600044957909
+ 1.92328211074342e-06 -0.0078564901949242823
+ 1.9232958272294071e-06 -0.0085725677401110242
+ 1.9233058382086268e-06 -0.0072376120342548759
+ 1.923315741054937e-06 -0.002724297906387221
+ 1.9233260151016532e-06 0.0073875472446813467
+ 1.9233376238039741e-06 0.028189447808505751
+ 1.9233503090767858e-06 0.064428766649152092
+ 1.9233660574038658e-06 0.1287829453207153
+ 1.9233765765675822e-06 0.18189870791429419
+ 1.9233882434547401e-06 0.24721332258821041
+ 1.9234028161845368e-06 0.33353147493510382
+ 1.9234174624980258e-06 0.42175263693035331
+ 1.923437811114383e-06 0.5418003770621006
+ 1.923462236417135e-06 0.67724048401510795
+ 1.9234966702589751e-06 0.84345382721643869
+ 1.9235344486966481e-06 0.98352978538305169
+ 1.9235834573138639e-06 1.099668377013779
+ 1.9236178683820882e-06 1.1456192812600661
+ 1.923657205458194e-06 1.1748957294845019
+ 1.923708527148443e-06 1.1927902573880731
+ 1.9237586001327121e-06 1.19909069300228
+ 1.9238286164805719e-06 1.201318339785943
+ 1.9239095305961358e-06 1.2011555544583701
+ 1.9240392443915119e-06 1.200440265649849
+ 1.9241736739373129e-06 1.200074563741049
+ 1.9243025784379751e-06 1.1999837776706621
+ 1.924424543186622e-06 1.1999817442126259
+ 1.924543455213563e-06 1.1999920568591891
+ 1.9246702091116502e-06 1.1999982663240649
+ 1.9247888124192151e-06 1.200000043407826
+ 1.9249124111197199e-06 1.200000252426463
+ 1.9250302611404598e-06 1.200000110578759
+ 1.9251514360795371e-06 1.2000000025670789
+ 1.9252691754721181e-06 1.1999999637176471
+ 1.9253892391408081e-06 1.199999956493099
+ 1.9255072456568888e-06 1.1999999585448859
+ 1.92562684209303e-06 1.1999999635839249
+ 1.9256848141227429e-06 1.1999999831618819
+ 1.9257307552985392e-06 1.1999999986152401
+ 1.9257840244699931e-06 1.1999999755296651
+ 1.9258473531132131e-06 1.1999999266539301
+ 1.925879042716335e-06 1.199999908101351
+ 1.925910800133455e-06 1.1999998928435689
+ 1.925935582516966e-06 1.199999858366271
+ 1.9259588135403611e-06 1.199999792530174
+ 1.9259815548285601e-06 1.1999997058276151
+ 1.926009721564718e-06 1.199999659611876
+ 1.9260302998837241e-06 1.1999998946213051
+ 1.9260550297111942e-06 1.200000189520364
+ 1.926091786243747e-06 1.20000032279781
+ 1.926143924789863e-06 1.200000192338323
+ 1.9261968807504572e-06 1.200000008739363
+ 1.9262700623962218e-06 1.199999884502126
+ 1.9263492756178671e-06 1.1999998717481311
+ 1.9264408030977241e-06 1.199999913634668
+ 1.9265385875231682e-06 1.199999955025691
+ 1.9266501215501749e-06 1.199999972645633
+ 1.9267913147840882e-06 1.199999970369527
+ 1.9269990620755461e-06 1.199999962282517
+ 1.927389315120846e-06 1.1999999587846251
+ 1.9277586755319609e-06 1.1999999597618149
+ 1.9283073765750408e-06 1.199999960498608
+ 1.9288893996068691e-06 1.1999999605494731
+ 1.9294353730993121e-06 1.1999999604455609
+ 1.9299191650843271e-06 1.199999960459071
+ 1.9302680449582679e-06 1.1999999606245351
+ 1.9306705941785561e-06 1.1999999604496709
+ 1.9311315800857149e-06 1.1999999604520519
+ 1.9317197524757481e-06 1.199999960475792
+ 1.9323821522964632e-06 1.1999999604820819
+ 1.933380379878521e-06 1.199999960481994
+ 1.9348002756997131e-06 1.1999999604810649
+ 1.937296883841262e-06 1.1999999604809219
+ 1.9411479643121251e-06 1.199999960480939
+ 1.9461479643121251e-06 1.199999960480878
+ 1.951147964312125e-06 1.199999960480858
+ 1.956147964312125e-06 1.1999999604808611
+ 1.961147964312125e-06 1.199999960480866
+ 1.9661479643121249e-06 1.199999960480868
+ 1.9711479643121249e-06 1.199999960480868
+ 1.9761479643121248e-06 1.199999960480868
+ 1.9811479643121252e-06 1.199999960480868
+ 1.9861479643121251e-06 1.199999960480868
+ 1.9911479643121251e-06 1.199999960480868
+ 1.996147964312125e-06 1.199999960480868
+ 2.001147964312125e-06 1.199999960480868
+ 2.0061479643121249e-06 1.199999960480868
+ 2.011147964312124e-06 1.199999960480868
+ 2.016147964312124e-06 1.199999960480868
+ 2.021147964312124e-06 1.199999960480868
+ 2.0261479643121239e-06 1.199999960480868
+ 2.0311479643121239e-06 1.199999960480868
+ 2.0361479643121238e-06 1.199999960480868
+ 2.0411479643121242e-06 1.199999960480868
+ 2.0461479643121241e-06 1.199999960480868
+ 2.0511479643121241e-06 1.199999960480868
+ 2.056147964312124e-06 1.199999960480868
+ 2.061147964312124e-06 1.199999960480868
+ 2.0661479643121239e-06 1.199999960480868
+ 2.0711479643121239e-06 1.199999960480868
+ 2.0761479643121239e-06 1.199999960480868
+ 2.0811479643121238e-06 1.199999960480868
+ 2.0861479643121242e-06 1.199999960480868
+ 2.0911479643121241e-06 1.199999960480868
+ 2.0961479643121241e-06 1.199999960480868
+ 2.101147964312124e-06 1.199999960480868
+ 2.106147964312124e-06 1.199999960480868
+ 2.1111479643121239e-06 1.199999960480868
+ 2.116147964312123e-06 1.199999960480868
+ 2.121147964312123e-06 1.199999960480868
+ 2.1261479643121229e-06 1.199999960480868
+ 2.1311479643121229e-06 1.199999960480868
+ 2.1361479643121229e-06 1.199999960480868
+ 2.1411479643121228e-06 1.199999960480868
+ 2.1461479643121232e-06 1.199999960480868
+ 2.1511479643121231e-06 1.199999960480868
+ 2.1561479643121231e-06 1.199999960480868
+ 2.161147964312123e-06 1.199999960480868
+ 2.166147964312123e-06 1.1999999604808671
+ 2.1711479643121229e-06 1.199999960480866
+ 2.1761479643121229e-06 1.1999999604808631
+ 2.1811479643121228e-06 1.1999999604808591
+ 2.1861479643121228e-06 1.19999996048085
+ 2.1911479643121232e-06 1.199999960480834
+ 2.1961479643121231e-06 1.1999999604808029
+ 2.2011479643121231e-06 1.199999960480743
+ 2.206147964312123e-06 1.199999960480628
+ 2.211147964312123e-06 1.199999960480407
+ 2.2161479643121229e-06 1.199999960479998
+ 2.221147964312122e-06 1.199999960479271
+ 2.226147964312122e-06 1.199999960477997
+ 2.2311479643121219e-06 1.199999960475558
+ 2.2361479643121219e-06 1.1999999604681559
+ 2.2395200339885489e-06 1.199999960417669
+ 2.241310576439441e-06 1.199999960151231
+ 2.243279256473515e-06 1.199999960153582
+ 2.244894896632873e-06 1.199999960379968
+ 2.2469420431782329e-06 1.1999999604586651
+ 2.2484969935242111e-06 1.1999999605272951
+ 2.249049575195742e-06 1.199999961381677
+ 2.2495413998142419e-06 1.1999999622598549
+ 2.2498162166150781e-06 1.1999999649929061
+ 2.2501157721956878e-06 1.1999999674081689
+ 2.2503441336314942e-06 1.199999958702535
+ 2.250562186986493e-06 1.199999901471235
+ 2.2507730124716881e-06 1.199999853596295
+ 2.2509937853478598e-06 1.199999797525892
+ 2.2510934425431481e-06 1.199999550216261
+ 2.2511569158075449e-06 1.199999139727925
+ 2.2512068357787198e-06 1.199998735229783
+ 2.2512579871430068e-06 1.199998352220276
+ 2.2513221020603488e-06 1.1999979447999951
+ 2.2513938277160201e-06 1.199998257981626
+ 2.251462739977786e-06 1.1999993273876339
+ 2.251484615111883e-06 1.199999758409354
+ 2.251504219456453e-06 1.1999997783176111
+ 2.2515249881356481e-06 1.200000440641106
+ 2.2515500339221318e-06 1.2000035405028311
+ 2.2515738440545461e-06 1.2000083618357511
+ 2.2516006033384209e-06 1.2000108960282481
+ 2.2516217789101269e-06 1.200009758279373
+ 2.2516398227503458e-06 1.2000070227638899
+ 2.2516524258075829e-06 1.200004343949963
+ 2.251668216407349e-06 1.200001416143853
+ 2.251689152198719e-06 1.199999064380697
+ 2.2517170137528219e-06 1.199997737462241
+ 2.2517484038893269e-06 1.199997163888928
+ 2.2517783161703081e-06 1.199997174398606
+ 2.2518123389701651e-06 1.1999988510793571
+ 2.25183856245379e-06 1.2000014636839209
+ 2.251867138174853e-06 1.200004432813462
+ 2.2518927415192399e-06 1.200006525450469
+ 2.2519111960017139e-06 1.200007872786742
+ 2.2519269358329908e-06 1.200009192010115
+ 2.2519426489744141e-06 1.2000110838568689
+ 2.2519563801187629e-06 1.200012942330476
+ 2.2519721498470171e-06 1.200013215329357
+ 2.2519827158329361e-06 1.200012253941676
+ 2.2519971974984781e-06 1.2000101476921929
+ 2.2520214447533821e-06 1.2000059139463921
+ 2.252044285818965e-06 1.199995185772422
+ 2.252068162842566e-06 1.199951324291491
+ 2.2520896449591819e-06 1.1998791055300839
+ 2.252118294091763e-06 1.199744701061332
+ 2.2521595740814099e-06 1.199441826476104
+ 2.2521790222712421e-06 1.2000938111450119
+ 2.2521955729551828e-06 1.202422361531039
+ 2.2522205615390159e-06 1.2101005517151029
+ 2.252243373849092e-06 1.2145046420723009
+ 2.252259003800251e-06 1.199639989439284
+ 2.252275620476307e-06 1.1522739812003859
+ 2.252293277450741e-06 1.07147293181008
+ 2.252311068081299e-06 0.97165209688989307
+ 2.2523326739143101e-06 0.8415188118584479
+ 2.2523534484449408e-06 0.7155136828059423
+ 2.252367890144276e-06 0.62952191266017121
+ 2.2523790974961539e-06 0.56436239804045063
+ 2.2523949760110701e-06 0.47522000073224052
+ 2.2524065319460518e-06 0.41318767528478778
+ 2.2524197688952989e-06 0.34592513944834069
+ 2.2524398377543301e-06 0.25427805313801061
+ 2.2524629631093499e-06 0.16809312932238291
+ 2.2524851090691862e-06 0.1067712939909659
+ 2.2525086666243602e-06 0.062345844300208793
+ 2.2525259335730491e-06 0.040953534034079017
+ 2.2525437275032188e-06 0.026135304112980672
+ 2.2525657945004529e-06 0.014565199077858479
+ 2.252586387749277e-06 0.0082507070936812081
+ 2.2526128788759961e-06 0.0037617955839220388
+ 2.252640286000194e-06 0.0015183247309600279
+ 2.252676742631135e-06 0.00027576710544941022
+ 2.2527189353717939e-06 -0.0001352873455056565
+ 2.2527790247337931e-06 -0.00018142594827696729
+ 2.252860017241618e-06 -8.9069667770426517e-05
+ 2.2529491523507272e-06 -2.179043693807712e-05
+ 2.2530544117150991e-06 2.283686503256076e-06
+ 2.253187403940243e-06 4.1994700835442273e-06
+ 2.2533483932525189e-06 1.418942677154542e-06
+ 2.2534858457327592e-06 2.3799715828137871e-07
+ 2.253610054847939e-06 6.3573515574430818e-09
+ 2.253728565191334e-06 1.8675302263990091e-08
+ 2.2538472080104088e-06 4.8944340600736512e-08
+ 2.2539755794409619e-06 6.1736980562533492e-08
+ 2.2540955878171631e-06 6.4539245137592993e-08
+ 2.2542206465708719e-06 6.629316444843066e-08
+ 2.2543392339597498e-06 6.9242822590129293e-08
+ 2.2544610050915279e-06 7.3765517635193033e-08
+ 2.2545789738431322e-06 8.4841868557677993e-08
+ 2.2546993004997412e-06 1.2796882486445379e-07
+ 2.2547754280255001e-06 3.1094717971491089e-07
+ 2.2548261423699329e-06 5.9711016191425844e-07
+ 2.2548798126464812e-06 6.501111554494099e-07
+ 2.2549455838093892e-06 2.3608384399841769e-07
+ 2.254981311842664e-06 -1.4398901291817291e-07
+ 2.255011750924725e-06 -5.3904964999922279e-07
+ 2.2550363145545201e-06 -9.7983047377500299e-07
+ 2.2550594258873918e-06 -1.483469944977423e-06
+ 2.2550808716321e-06 -1.753944647981262e-06
+ 2.2551097250465879e-06 -1.6255509589770861e-06
+ 2.255130467704168e-06 -1.728417014849606e-06
+ 2.2551534497377861e-06 -6.6857042248002448e-07
+ 2.2551944624531529e-06 1.1102722362761201e-06
+ 2.2552339255714848e-06 1.415722773914332e-06
+ 2.2552942922077338e-06 7.2826023301688871e-07
+ 2.255358942644365e-06 1.813169340885685e-07
+ 2.255439412358263e-06 2.9758612617187709e-08
+ 2.2555245899789401e-06 -1.7111083774615081e-08
+ 2.2556256358561381e-06 -5.2383211728815017e-09
+ 2.2557408158420501e-06 4.7467122661980458e-08
+ 2.2558676682871e-06 7.3642065287745777e-08
+ 2.2560367458539598e-06 7.014824736420905e-08
+ 2.2562828232361421e-06 6.1767306225302768e-08
+ 2.2565958277378059e-06 6.0751654578997301e-08
+ 2.256950604982948e-06 6.1736470363803141e-08
+ 2.2573865378631748e-06 6.2029624593681865e-08
+ 2.2579111863594801e-06 6.2058089024794803e-08
+ 2.258526977647754e-06 6.1588440073155036e-08
+ 2.2589228576058021e-06 6.0288679706931069e-08
+ 2.2592650175900459e-06 6.3046617432655968e-08
+ 2.2596973389082832e-06 6.2223875243782672e-08
+ 2.2601616342415492e-06 6.172665234785948e-08
+ 2.260710745569784e-06 6.1910253506751656e-08
+ 2.261302528074993e-06 6.1922273175741219e-08
+ 2.2621231958742192e-06 6.1919148570186178e-08
+ 2.263277483663185e-06 6.1921755213773541e-08
+ 2.2652811283796909e-06 6.1921388407050094e-08
+ 2.2683243161807001e-06 6.1921012235585253e-08
+ 2.2733243161807001e-06 6.1920982296121597e-08
+ 2.2783243161807e-06 6.1920994831652821e-08
+ 2.2833243161807e-06 6.1920997584328595e-08
+ 2.2883243161807e-06 6.1920997903049861e-08
+ 2.2933243161806991e-06 6.1920998219915186e-08
+ 2.298324316180699e-06 6.1920998005491177e-08
+ 2.303324316180699e-06 6.1920998327547067e-08
+ 2.3083243161806989e-06 6.1920998188144886e-08
+ 2.3133243161806989e-06 6.1920998215311495e-08
+ 2.3183243161806988e-06 6.1920998257824661e-08
+ 2.3233243161806992e-06 6.1920998283732157e-08
+ 2.3283243161806991e-06 6.1920998166538663e-08
+ 2.3333243161806991e-06 6.1920997983151822e-08
+ 2.3383243161806991e-06 6.1920998195775528e-08
+ 2.343324316180699e-06 6.1920998093655819e-08
+ 2.348324316180699e-06 6.192099811247128e-08
+ 2.3533243161806989e-06 6.1920998201203235e-08
+ 2.3583243161806989e-06 6.1920998253504701e-08
+ 2.3633243161806988e-06 6.1920998033994485e-08
+ 2.3683243161806992e-06 6.1920998368504921e-08
+ 2.3733243161806991e-06 6.1920998136836924e-08
+ 2.3783243161806991e-06 6.1920997935947337e-08
+ 2.383324316180699e-06 6.1920998224021707e-08
+ 2.388324316180699e-06 6.1920998298491256e-08
+ 2.3933243161806989e-06 6.1920998155131379e-08
+ 2.3983243161806981e-06 6.1920998158339676e-08
+ 2.403324316180698e-06 6.1920998260198074e-08
+ 2.408324316180698e-06 6.1920998300895268e-08
+ 2.4133243161806979e-06 6.192099806457113e-08
+ 2.4183243161806979e-06 6.1920998458160262e-08
+ 2.4233243161806978e-06 6.1920998216509306e-08
+ 2.4283243161806982e-06 6.1920998059855909e-08
+ 2.4333243161806981e-06 6.1920998101283973e-08
+ 2.4383243161806981e-06 6.1920998158106914e-08
+ 2.443324316180698e-06 6.1920997978898088e-08
+ 2.448324316180698e-06 6.1920998001567972e-08
+ 2.4533243161806979e-06 6.1920998089834245e-08
+ 2.4583243161806979e-06 6.1920998095704818e-08
+ 2.4633243161806979e-06 6.1920998209564999e-08
+ 2.4683243161806978e-06 6.1920998175109777e-08
+ 2.4733243161806982e-06 6.1920998304159455e-08
+ 2.4783243161806981e-06 6.1920998124758922e-08
+ 2.4833243161806981e-06 6.1920998120352538e-08
+ 2.488324316180698e-06 6.1920997968713457e-08
+ 2.493324316180698e-06 6.1920997950861324e-08
+ 2.4983243161806979e-06 6.1920998285024319e-08
+ 2.503324316180697e-06 6.1920998123110808e-08
+ 2.508324316180697e-06 6.1920998187129968e-08
+ 2.513324316180697e-06 6.1920998184100383e-08
+ 2.5183243161806969e-06 6.1920998182995494e-08
+ 2.5233243161806969e-06 6.1920998040774216e-08
+ 2.5283243161806968e-06 6.1920998068000793e-08
+ 2.5333243161806972e-06 6.1920998253913857e-08
+ 2.5383243161806971e-06 6.192099804549121e-08
+ 2.5433243161806971e-06 6.1920997993990508e-08
+ 2.548324316180697e-06 6.1920997866940913e-08
+ 2.553324316180697e-06 6.1920997870804746e-08
+ 2.5583243161806969e-06 6.1920997531157002e-08
+ 2.5633243161806969e-06 6.1920997368821417e-08
+ 2.5683243161806968e-06 6.1920993287168882e-08
+ 2.5704106583974358e-06 6.1920903259801596e-08
+ 2.5722371391735721e-06 6.1920913808755348e-08
+ 2.5741260631054059e-06 6.1921195315148212e-08
+ 2.5756638815376541e-06 6.192105614941511e-08
+ 2.5773409739968432e-06 6.1920806710220199e-08
+ 2.5783637540271768e-06 6.1921272769133335e-08
+ 2.578736989652529e-06 6.1921877545861377e-08
+ 2.579280317824992e-06 6.1920900034558862e-08
+ 2.579586151831609e-06 6.1925274724306961e-08
+ 2.5798308663447901e-06 6.1916595642675831e-08
+ 2.5800314290473189e-06 6.1820877897932532e-08
+ 2.5802394355444269e-06 6.1867098775978628e-08
+ 2.580480752271287e-06 6.1978852895039778e-08
+ 2.580629542202474e-06 6.1284244788365731e-08
+ 2.5806946859429181e-06 5.7425485001553331e-08
+ 2.5807493325381111e-06 5.5716872470687402e-08
+ 2.580792737829832e-06 5.9381534644421203e-08
+ 2.5808572964931178e-06 9.0815383541614316e-08
+ 2.5809232568757298e-06 1.304132372358184e-07
+ 2.5809887845905411e-06 1.7180884776811571e-07
+ 2.5810183423847018e-06 3.3056030406826642e-07
+ 2.581038946479117e-06 6.5003380522542526e-07
+ 2.581060692971448e-06 7.8381222202465754e-07
+ 2.5810881920830102e-06 2.6690738038592491e-07
+ 2.581111332133274e-06 -7.6362210477464129e-07
+ 2.5811323214677502e-06 -2.6376579127213239e-06
+ 2.5811512928759001e-06 -4.1878313885539162e-06
+ 2.5811664050916752e-06 -5.0006005911482589e-06
+ 2.5811809483335559e-06 -4.6760175216941089e-06
+ 2.5811910795136712e-06 -2.522589103238949e-06
+ 2.581203679595965e-06 -6.5031527212523887e-07
+ 2.5812204726505671e-06 -5.1415878668612176e-07
+ 2.5812393272501051e-06 -1.602398235296823e-06
+ 2.5812637539518531e-06 -2.6490604083304002e-06
+ 2.5812887440136169e-06 -3.3033117243613459e-06
+ 2.5813119920373279e-06 -3.3441777616270892e-06
+ 2.5813362471343081e-06 -2.0442723751345439e-06
+ 2.5813590803507362e-06 -5.5439176988493157e-07
+ 2.5813856618313708e-06 -5.0904154630861673e-07
+ 2.581413382760888e-06 -1.7043927349332131e-06
+ 2.5814429916179751e-06 -2.9715678663504359e-06
+ 2.5814664040648258e-06 -3.6935087488618338e-06
+ 2.5814948056104752e-06 -3.7277268987936951e-06
+ 2.581517312667818e-06 -6.1722037764132455e-07
+ 2.581535512030756e-06 2.213229109999597e-06
+ 2.5815528578243892e-06 -9.7130638466502906e-06
+ 2.581570767052336e-06 -6.1986442551133271e-05
+ 2.5815929039992721e-06 -0.0001537886353878285
+ 2.5816155211365619e-06 -0.00018295255357373601
+ 2.581628881439298e-06 -0.0001127026239797252
+ 2.5816430930773442e-06 1.762343677820388e-05
+ 2.5816605892550021e-06 0.00014744875849874691
+ 2.5816773822907649e-06 0.00019149403370151221
+ 2.5817003448881909e-06 0.00017473251479931169
+ 2.5817253218444462e-06 0.0001313557965250615
+ 2.581756824178029e-06 8.5417380366624698e-05
+ 2.5817896045463079e-06 6.2124110526130352e-05
+ 2.5818267385516588e-06 5.7350965101562901e-05
+ 2.5818693669039221e-06 6.7890870498721936e-05
+ 2.581923373050325e-06 8.4760861795862965e-05
+ 2.5819929973771049e-06 -0.00065678708203546104
+ 2.5820379905713682e-06 -0.003352543053352993
+ 2.5820772160400911e-06 -0.0076074429945732101
+ 2.582086383649538e-06 -0.0083373258731309283
+ 2.582102462652204e-06 -0.0061487582892122122
+ 2.582113710183415e-06 0.0005655349154750685
+ 2.5821246232043072e-06 0.013986752318010351
+ 2.5821366902630881e-06 0.039712895642694757
+ 2.5821496152695918e-06 0.081644117684865791
+ 2.5821678749676908e-06 0.16364818997075251
+ 2.5821809530624448e-06 0.234585842402774
+ 2.5821966092701611e-06 0.3263295827828499
+ 2.5822111399245711e-06 0.41368883290292707
+ 2.5822307172841359e-06 0.52951932733582985
+ 2.582253970632263e-06 0.65969692161892812
+ 2.582287237948931e-06 0.82389042981096694
+ 2.5823244293833932e-06 0.96756383711781446
+ 2.582371287169439e-06 1.086629892398659
+ 2.5824070797033469e-06 1.1393159312198251
+ 2.5824462450980881e-06 1.1715672459040021
+ 2.5824980163919072e-06 1.1917421976528559
+ 2.5825466712909112e-06 1.198680482210893
+ 2.5826151578096122e-06 1.2013020985721261
+ 2.5826922622373492e-06 1.201236891128969
+ 2.5828160788795278e-06 1.2005126353567019
+ 2.5829485651270479e-06 1.200098588156095
+ 2.5830776494211389e-06 1.1999861486739749
+ 2.5832003821744608e-06 1.1999799329398391
+ 2.583319796228406e-06 1.1999907606766971
+ 2.583447367309143e-06 1.1999978272697249
+ 2.5835661018678969e-06 1.199999962710419
+ 2.5836899950153751e-06 1.2000002712836171
+ 2.583807771898306e-06 1.2000001314251889
+ 2.583929047703634e-06 1.2000000114736471
+ 2.584046710464058e-06 1.19999996587143
+ 2.5841668359953008e-06 1.199999956381288
+ 2.5842847981643651e-06 1.1999999580132159
+ 2.5844044268629249e-06 1.1999999621684641
+ 2.5844719116278749e-06 1.1999999762158411
+ 2.5845188409029661e-06 1.199999995402858
+ 2.5845678236521599e-06 1.199999987773509
+ 2.5846328457180352e-06 1.199999938811074
+ 2.5846831794207789e-06 1.1999999118599329
+ 2.584710967043444e-06 1.1999998936814
+ 2.58473617714345e-06 1.1999998587060059
+ 2.5847590346564569e-06 1.1999997972714429
+ 2.584781825747683e-06 1.1999997134833349
+ 2.5848103622074141e-06 1.199999654188002
+ 2.5848323598980722e-06 1.199999882116962
+ 2.5848572028272992e-06 1.200000182069995
+ 2.5848914431511979e-06 1.2000003217932931
+ 2.5849451886476588e-06 1.200000198085694
+ 2.5849959272319659e-06 1.2000000184299311
+ 2.585069304485142e-06 1.199999886833176
+ 2.5851522356597162e-06 1.19999987089299
+ 2.5852498023519649e-06 1.1999999148378191
+ 2.5853451072760882e-06 1.199999955024561
+ 2.5854602213565298e-06 1.1999999728994011
+ 2.5855987278661149e-06 1.199999970320351
+ 2.5858150369149838e-06 1.199999962037182
+ 2.5862155814971152e-06 1.199999958744953
+ 2.5865892011217208e-06 1.1999999597854329
+ 2.58715045142655e-06 1.1999999605127161
+ 2.5877424803247568e-06 1.199999960548882
+ 2.5882865670362449e-06 1.1999999604389271
+ 2.5888084063211961e-06 1.1999999604797791
+ 2.5891794359095192e-06 1.1999999606091269
+ 2.5895982219310679e-06 1.1999999604392431
+ 2.59007650184949e-06 1.1999999604558349
+ 2.5906757653419909e-06 1.199999960478505
+ 2.5913956032911931e-06 1.1999999604826721
+ 2.5924798096704639e-06 1.199999960481734
+ 2.594099144180239e-06 1.1999999604809519
+ 2.5968746679592231e-06 1.1999999604809359
+ 2.6013506288401121e-06 1.1999999604809231
+ 2.606350628840112e-06 1.1999999604808691
+ 2.611350628840112e-06 1.199999960480858
+ 2.6163506288401119e-06 1.1999999604808631
+ 2.6213506288401111e-06 1.199999960480866
+ 2.626350628840111e-06 1.199999960480868
+ 2.631350628840111e-06 1.1999999604808691
+ 2.6363506288401109e-06 1.199999960480868
+ 2.6413506288401109e-06 1.199999960480868
+ 2.6463506288401108e-06 1.199999960480868
+ 2.6513506288401112e-06 1.199999960480868
+ 2.6563506288401111e-06 1.199999960480868
+ 2.6613506288401111e-06 1.199999960480868
+ 2.666350628840111e-06 1.199999960480868
+ 2.671350628840111e-06 1.199999960480868
+ 2.6763506288401109e-06 1.199999960480868
+ 2.6813506288401109e-06 1.199999960480868
+ 2.6863506288401109e-06 1.199999960480868
+ 2.6913506288401108e-06 1.199999960480868
+ 2.6963506288401112e-06 1.199999960480868
+ 2.7013506288401111e-06 1.199999960480868
+ 2.7063506288401111e-06 1.199999960480868
+ 2.711350628840111e-06 1.199999960480868
+ 2.716350628840111e-06 1.199999960480868
+ 2.7213506288401109e-06 1.199999960480868
+ 2.72635062884011e-06 1.199999960480868
+ 2.73135062884011e-06 1.199999960480868
+ 2.73635062884011e-06 1.199999960480868
+ 2.7413506288401099e-06 1.199999960480868
+ 2.7463506288401099e-06 1.199999960480868
+ 2.7513506288401098e-06 1.199999960480868
+ 2.7563506288401102e-06 1.199999960480868
+ 2.7613506288401101e-06 1.199999960480868
+ 2.7663506288401101e-06 1.199999960480868
+ 2.77135062884011e-06 1.199999960480868
+ 2.77635062884011e-06 1.199999960480868
+ 2.7813506288401099e-06 1.199999960480868
+ 2.7863506288401099e-06 1.199999960480868
+ 2.7913506288401098e-06 1.199999960480868
+ 2.7963506288401098e-06 1.199999960480868
+ 2.8013506288401102e-06 1.199999960480868
+ 2.8063506288401101e-06 1.199999960480868
+ 2.8113506288401101e-06 1.199999960480868
+ 2.81635062884011e-06 1.199999960480868
+ 2.82135062884011e-06 1.1999999604808671
+ 2.8263506288401099e-06 1.1999999604808671
+ 2.831350628840109e-06 1.1999999604808651
+ 2.836350628840109e-06 1.1999999604808631
+ 2.8413506288401089e-06 1.1999999604808571
+ 2.8463506288401089e-06 1.1999999604808469
+ 2.8513506288401089e-06 1.199999960480828
+ 2.8563506288401088e-06 1.199999960480792
+ 2.8613506288401092e-06 1.199999960480723
+ 2.8663506288401091e-06 1.1999999604805891
+ 2.8713506288401091e-06 1.1999999604803371
+ 2.876350628840109e-06 1.1999999604798699
+ 2.881350628840109e-06 1.1999999604790479
+ 2.8863506288401089e-06 1.199999960477599
+ 2.8913506288401089e-06 1.1999999604746681
+ 2.8963506288401088e-06 1.199999960463723
+ 2.898916863599024e-06 1.199999960384494
+ 2.9006116861161871e-06 1.1999999601154361
+ 2.9027022884027849e-06 1.199999960189307
+ 2.9042170844536372e-06 1.199999960421366
+ 2.9060837597242128e-06 1.1999999604297209
+ 2.9073202631037942e-06 1.1999999605207019
+ 2.9078669697441431e-06 1.1999999610486209
+ 2.9085131538549179e-06 1.1999999615465231
+ 2.908840534446684e-06 1.1999999640748671
+ 2.9091432845567091e-06 1.1999999668794381
+ 2.9093813467310101e-06 1.199999965521767
+ 2.909588412444389e-06 1.1999999238403609
+ 2.9098037169639548e-06 1.199999868429183
+ 2.910046820243697e-06 1.1999998262475351
+ 2.9101760203737431e-06 1.1999996519516389
+ 2.910241786963776e-06 1.1999992973927229
+ 2.9102997926058229e-06 1.199998844021315
+ 2.9103450956545622e-06 1.1999985258419481
+ 2.910412816473981e-06 1.199998011621207
+ 2.9104827100124968e-06 1.19999808349829
+ 2.9105635583571509e-06 1.19999913291154
+ 2.9105886432377559e-06 1.199999686211046
+ 2.9106086378103302e-06 1.199999807441382
+ 2.9106271736582919e-06 1.200000078210649
+ 2.910651715924596e-06 1.200002615983141
+ 2.9106791542985202e-06 1.2000078627141579
+ 2.910703560930526e-06 1.200010732102609
+ 2.910724349037469e-06 1.2000101714015761
+ 2.910741522889562e-06 1.2000079922554461
+ 2.9107562437727438e-06 1.2000050347611779
+ 2.910772223593756e-06 1.2000019505073189
+ 2.9107893849169671e-06 1.1999997063934871
+ 2.9108161356279571e-06 1.199998030737325
+ 2.9108458163928559e-06 1.199997328945579
+ 2.910873563248934e-06 1.199997082132634
+ 2.9108976487462071e-06 1.199997563966603
+ 2.9109230097829611e-06 1.199999322514302
+ 2.9109541942990778e-06 1.2000025059241981
+ 2.9109835714873141e-06 1.200005266140451
+ 2.9110076894423481e-06 1.2000070547453241
+ 2.9110241919651139e-06 1.200008291416724
+ 2.9110397774667922e-06 1.2000097306714721
+ 2.9110546488719291e-06 1.2000117650937061
+ 2.911069376508569e-06 1.2000132776444561
+ 2.911082713206977e-06 1.2000129925489591
+ 2.9110969435783888e-06 1.200011364518224
+ 2.9111127790605309e-06 1.200008814424343
+ 2.9111391362968762e-06 1.200003068066674
+ 2.911166955018231e-06 1.1999724049238021
+ 2.911192176000569e-06 1.199900118561926
+ 2.911218742140747e-06 1.1997852055157401
+ 2.9112548273200998e-06 1.199510151576795
+ 2.9112788604247849e-06 1.1996676034914071
+ 2.9112950431604182e-06 1.201011046242318
+ 2.9113129703894482e-06 1.2049296427849789
+ 2.9113341385074752e-06 1.2126377867545719
+ 2.9113507303968819e-06 1.2156899146387921
+ 2.9113647786016209e-06 1.2039141195102681
+ 2.9113809536105261e-06 1.1602507674821141
+ 2.9113979744838602e-06 1.0843047396991621
+ 2.9114156311390721e-06 0.98633874137061239
+ 2.911436891270992e-06 0.85857789278362739
+ 2.9114573745522669e-06 0.73401841280475633
+ 2.911472076336344e-06 0.64605742409079281
+ 2.9114833110301562e-06 0.58035288159589615
+ 2.9114958118812761e-06 0.50926658425681359
+ 2.911508877757285e-06 0.43776289277727609
+ 2.9115216337935949e-06 0.37140851989263152
+ 2.911541204312719e-06 0.27858229782810379
+ 2.911564312654595e-06 0.18715533490336711
+ 2.9115865794342411e-06 0.12025471947827859
+ 2.911613444349428e-06 0.065667976584502227
+ 2.9116296289385241e-06 0.044419579531201112
+ 2.9116462513885789e-06 0.02934580420032299
+ 2.9116656196393781e-06 0.017783008544252049
+ 2.911686842278047e-06 0.01002561158305385
+ 2.9117110168482329e-06 0.0050162812253926794
+ 2.9117386188015931e-06 0.002099122308970065
+ 2.9117716585207208e-06 0.00056826949353044453
+ 2.9118122377863592e-06 -6.1132367750648967e-05
+ 2.9118652084208001e-06 -0.00019500952868791279
+ 2.9119385494083719e-06 -0.0001217718960109989
+ 2.9120304299427218e-06 -3.5688139315738139e-05
+ 2.912125046582771e-06 -2.2101229878852772e-06
+ 2.9122525662371321e-06 4.6979722515921472e-06
+ 2.9124152274358261e-06 2.1959649335690181e-06
+ 2.9125531523047491e-06 4.8941726396679798e-07
+ 2.9126778590035079e-06 3.7132175179810368e-08
+ 2.912796665875677e-06 5.7615544962567257e-09
+ 2.9129155432796101e-06 3.9597756603759311e-08
+ 2.9130457215985618e-06 5.9181181854753282e-08
+ 2.9131658986782579e-06 6.3931810874477085e-08
+ 2.9132919151972368e-06 6.5693952093577266e-08
+ 2.913410362558564e-06 6.8269848455804185e-08
+ 2.9135325400064392e-06 7.2035031696242093e-08
+ 2.9136503159672579e-06 8.0137836426992962e-08
+ 2.9137708477752772e-06 1.068082542242562e-07
+ 2.9138690598331609e-06 2.328451444180622e-07
+ 2.9139233103019222e-06 5.3902293942564955e-07
+ 2.913974425281396e-06 6.8506731460243559e-07
+ 2.9140432069380769e-06 3.3472713513095099e-07
+ 2.9140926081748958e-06 -1.3604920507473759e-07
+ 2.9141212790252229e-06 -5.4035048987497266e-07
+ 2.9141463280645021e-06 -1.0271264078556681e-06
+ 2.9141690564131742e-06 -1.53475135149748e-06
+ 2.914190366852171e-06 -1.7706022516457479e-06
+ 2.9142186380005252e-06 -1.6409799452998609e-06
+ 2.9142385275604331e-06 -1.740944620854043e-06
+ 2.9142615102941429e-06 -6.5473409195236854e-07
+ 2.9143002742954901e-06 1.0734151482162679e-06
+ 2.9143408116697558e-06 1.418307645199189e-06
+ 2.914399122460395e-06 7.5761285732807958e-07
+ 2.9144649562395949e-06 1.872110350028786e-07
+ 2.9145538747568559e-06 1.8818132826379441e-08
+ 2.914636912307307e-06 -1.9537150257178949e-08
+ 2.9147376406304229e-06 -5.5919435912808578e-09
+ 2.9148526427808422e-06 4.798786191171708e-08
+ 2.9149805931335028e-06 7.4038511233065594e-08
+ 2.9151521152088001e-06 7.0048827114142072e-08
+ 2.9154035681523011e-06 6.1653399428731518e-08
+ 2.9157160597612711e-06 6.0777911949412772e-08
+ 2.916076030416819e-06 6.1757989175769848e-08
+ 2.9165128236685902e-06 6.2029302900403384e-08
+ 2.9170457641782511e-06 6.2059136651654677e-08
+ 2.917644392716807e-06 6.1549183574136501e-08
+ 2.9180392342909199e-06 6.0309741116597449e-08
+ 2.9183764273182121e-06 6.3088856878500562e-08
+ 2.918802285872621e-06 6.2187932011293324e-08
+ 2.919275007948221e-06 6.1730142339658964e-08
+ 2.9198322459467511e-06 6.191295365811843e-08
+ 2.9204229425414768e-06 6.1921029445545579e-08
+ 2.9212503550934369e-06 6.1919010027202089e-08
+ 2.9224019915403781e-06 6.192183550039644e-08
+ 2.9244309882957281e-06 6.1921391787909205e-08
+ 2.9274839716692351e-06 6.1921010586933269e-08
+ 2.9324839716692351e-06 6.1920982447171487e-08
+ 2.937483971669235e-06 6.1920994985928213e-08
+ 2.942483971669235e-06 6.1920997713514143e-08
+ 2.9474839716692349e-06 6.1920998007370995e-08
+ 2.9524839716692349e-06 6.1920997934038416e-08
+ 2.9574839716692348e-06 6.1920998040660793e-08
+ 2.9624839716692348e-06 6.1920998049800636e-08
+ 2.9674839716692352e-06 6.1920998094224642e-08
+ 2.9724839716692351e-06 6.1920998167977481e-08
+ 2.9774839716692351e-06 6.1920998037308025e-08
+ 2.982483971669235e-06 6.192099806514649e-08
+ 2.987483971669235e-06 6.1920998176173279e-08
+ 2.9924839716692349e-06 6.1920997895973933e-08
+ 2.997483971669234e-06 6.192099828045447e-08
+ 3.002483971669234e-06 6.1920998237978137e-08
+ 3.0074839716692339e-06 6.192099810501788e-08
+ 3.0124839716692339e-06 6.1920998142372271e-08
+ 3.0174839716692338e-06 6.192099800148e-08
+ 3.0224839716692338e-06 6.1920998216095808e-08
+ 3.0274839716692342e-06 6.1920998121382874e-08
+ 3.0324839716692341e-06 6.1920998112203326e-08
+ 3.0374839716692341e-06 6.1920998148549457e-08
+ 3.042483971669234e-06 6.1920998197024716e-08
+ 3.047483971669234e-06 6.1920998299369603e-08
+ 3.0524839716692339e-06 6.1920998091292465e-08
+ 3.0574839716692339e-06 6.1920998182656218e-08
+ 3.0624839716692338e-06 6.1920997969998207e-08
+ 3.0674839716692338e-06 6.192099820651118e-08
+ 3.0724839716692342e-06 6.1920998292095614e-08
+ 3.0774839716692341e-06 6.1920998112475343e-08
+ 3.0824839716692341e-06 6.1920998225585012e-08
+ 3.087483971669234e-06 6.1920997969736196e-08
+ 3.092483971669234e-06 6.1920998320928695e-08
+ 3.0974839716692339e-06 6.1920998038404442e-08
+ 3.102483971669233e-06 6.1920998407159336e-08
+ 3.107483971669233e-06 6.1920997940319827e-08
+ 3.1124839716692329e-06 6.1920998311029011e-08
+ 3.1174839716692329e-06 6.192099806396206e-08
+ 3.1224839716692328e-06 6.1920998169047376e-08
+ 3.1274839716692328e-06 6.1920998133407089e-08
+ 3.1324839716692332e-06 6.1920998005290854e-08
+ 3.1374839716692331e-06 6.1920998006199376e-08
+ 3.1424839716692331e-06 6.1920998357634828e-08
+ 3.147483971669233e-06 6.1920998170983826e-08
+ 3.152483971669233e-06 6.1920997948654698e-08
+ 3.1574839716692329e-06 6.1920998310472325e-08
+ 3.1624839716692329e-06 6.1920998047191721e-08
+ 3.1674839716692328e-06 6.1920998118046887e-08
+ 3.1724839716692332e-06 6.1920998183437328e-08
+ 3.1774839716692332e-06 6.1920998015802215e-08
+ 3.1824839716692331e-06 6.1920997917502215e-08
+ 3.1874839716692331e-06 6.1920998076464902e-08
+ 3.192483971669233e-06 6.1920998197342486e-08
+ 3.197483971669233e-06 6.1920998134016608e-08
+ 3.2024839716692321e-06 6.1920998052876503e-08
+ 3.207483971669232e-06 6.1920997818736268e-08
+ 3.212483971669232e-06 6.192099790851153e-08
+ 3.2174839716692319e-06 6.1920997600140622e-08
+ 3.2224839716692319e-06 6.1920997303728404e-08
+ 3.2274839716692318e-06 6.1920993399013521e-08
+ 3.229572319231423e-06 6.1920904174634766e-08
+ 3.231398756453807e-06 6.1920912165649787e-08
+ 3.233292684011156e-06 6.1921195368439541e-08
+ 3.234829147388619e-06 6.1921057367425883e-08
+ 3.2365063423076951e-06 6.1920806064005965e-08
+ 3.2375295807485561e-06 6.1921272883389609e-08
+ 3.2379034252356361e-06 6.1921867912994391e-08
+ 3.238448227301398e-06 6.1920902752993739e-08
+ 3.2387544168493001e-06 6.1925264459704631e-08
+ 3.2389992365793392e-06 6.1916757556498294e-08
+ 3.2392000033938449e-06 6.1821780070863523e-08
+ 3.2394081637488558e-06 6.1865847658388235e-08
+ 3.2396496607037019e-06 6.1979241353932362e-08
+ 3.2397992401820901e-06 6.1292453600291409e-08
+ 3.2398645628396291e-06 5.7429127750807088e-08
+ 3.2399191785579241e-06 5.5702294143917283e-08
+ 3.2399626025867592e-06 5.9390496453885289e-08
+ 3.2400271641224269e-06 9.0843314204124633e-08
+ 3.2400931173328281e-06 1.3042528656249561e-07
+ 3.2401586137714111e-06 1.7180885137079531e-07
+ 3.240188165128229e-06 3.3043522376840078e-07
+ 3.2402087729615772e-06 6.4978848916063765e-07
+ 3.240230514933373e-06 7.8390796801097058e-07
+ 3.2402580105192088e-06 2.6738615807320138e-07
+ 3.2402811570826601e-06 -7.6250954451732792e-07
+ 3.2403021472101929e-06 -2.636075330509922e-06
+ 3.240321113641746e-06 -4.1866882844283034e-06
+ 3.240336230017673e-06 -4.9993074638215366e-06
+ 3.2403507635299971e-06 -4.6797372155341537e-06
+ 3.2403608904400528e-06 -2.527363056651957e-06
+ 3.2403734883838219e-06 -6.5205687033198652e-07
+ 3.2403902609879188e-06 -5.121936343865198e-07
+ 3.24040908418099e-06 -1.598635050352613e-06
+ 3.2404335188901128e-06 -2.646989702353626e-06
+ 3.240458508649285e-06 -3.301594104117138e-06
+ 3.240481795555457e-06 -3.3452074404753418e-06
+ 3.2405060785483208e-06 -2.0463439269674439e-06
+ 3.2405289074626262e-06 -5.5569921956052644e-07
+ 3.2405554753618092e-06 -5.0837253928226536e-07
+ 3.2405831841896722e-06 -1.7023897581261339e-06
+ 3.2406127946006708e-06 -2.970141658874087e-06
+ 3.2406362208949721e-06 -3.6929141445395319e-06
+ 3.2406646359719981e-06 -3.7289012452173692e-06
+ 3.2406871656316021e-06 -6.1621862864049957e-07
+ 3.2407053731235241e-06 2.2116175106691191e-06
+ 3.2407227231844462e-06 -9.7562015291456945e-06
+ 3.2407406358756092e-06 -6.2095821649238062e-05
+ 3.2407627688126349e-06 -0.0001538758793085406
+ 3.240785405250069e-06 -0.0001828574004851576
+ 3.2407987745792379e-06 -0.0001123354502415144
+ 3.2408129881045578e-06 1.8061147544518309e-05
+ 3.2408304981200672e-06 0.0001477419329611552
+ 3.2408473084267488e-06 0.0001915387225505807
+ 3.240870307686182e-06 0.00017457330783639019
+ 3.2408952932382712e-06 0.00013114865455361019
+ 3.240926814925972e-06 8.5261384719102356e-05
+ 3.2409595933338981e-06 6.2068988224389394e-05
+ 3.240996760374043e-06 5.736479541897331e-05
+ 3.2410394134389821e-06 6.7974579985897738e-05
+ 3.2410934961863988e-06 8.4570993603029292e-05
+ 3.2411630944516932e-06 -0.00066502859889507678
+ 3.241208043887835e-06 -0.003371980890895646
+ 3.2412468038610018e-06 -0.0075977115528149458
+ 3.2412559203104409e-06 -0.0083480007861654829
+ 3.2412721390468922e-06 -0.0062192636743227453
+ 3.2412834486559519e-06 0.00047272409145925309
+ 3.2412943795696748e-06 0.01385291799272736
+ 3.2413064211377941e-06 0.039427984640059817
+ 3.2413193458236891e-06 0.081234217096807185
+ 3.241337484298645e-06 0.16249909590751729
+ 3.241350427095427e-06 0.23256548076487851
+ 3.2413661521830608e-06 0.32461881225408201
+ 3.241380557964179e-06 0.41122934627140367
+ 3.2414001332597341e-06 0.52712940979731937
+ 3.241423169230692e-06 0.65631879124868564
+ 3.2414563655254499e-06 0.8207563156418789
+ 3.2414933907440631e-06 0.9647329238447403
+ 3.2415400066217191e-06 1.084511951600458
+ 3.2415760296242461e-06 1.138320261864564
+ 3.241615153041634e-06 1.1710282051770791
+ 3.2416670324100021e-06 1.1915830705481689
+ 3.2417154566341939e-06 1.1986146338268191
+ 3.2417837538716628e-06 1.2012991019281469
+ 3.2418602816049298e-06 1.201248810655364
+ 3.241983305595888e-06 1.20052359475683
+ 3.2421155389997171e-06 1.2001023334585239
+ 3.2422446582642218e-06 1.199986557694195
+ 3.242367498903553e-06 1.199979671692315
+ 3.2424869811959132e-06 1.1999905653889831
+ 3.242614668910211e-06 1.1999977596666951
+ 3.2427334209686152e-06 1.1999999496907141
+ 3.2428573574707891e-06 1.2000002738737729
+ 3.242975123871069e-06 1.200000134531916
+ 3.2430964151626521e-06 1.20000001283237
+ 3.2432140669512262e-06 1.199999966211295
+ 3.2433342018931528e-06 1.1999999563726611
+ 3.2434521576752618e-06 1.199999957947095
+ 3.2435717919669309e-06 1.1999999620402499
+ 3.2436405377781812e-06 1.199999975613838
+ 3.2436876721375968e-06 1.1999999950709559
+ 3.2437364103795611e-06 1.199999988569378
+ 3.243801709921465e-06 1.199999939764494
+ 3.2438543664612152e-06 1.199999911943042
+ 3.2438826382053571e-06 1.199999892464138
+ 3.2439074281148181e-06 1.199999855342782
+ 3.243929961284593e-06 1.1999997926843839
+ 3.243952629692409e-06 1.1999997088491601
+ 3.243980924424048e-06 1.1999996552259991
+ 3.244002298353022e-06 1.199999885498523
+ 3.2440270526391572e-06 1.200000184098468
+ 3.2440620635227778e-06 1.2000003227782501
+ 3.2441152062413691e-06 1.200000197464445
+ 3.244166622036677e-06 1.2000000161589499
+ 3.244239701684595e-06 1.199999886462763
+ 3.2443220538451138e-06 1.199999871042104
+ 3.244420538788752e-06 1.199999915288231
+ 3.244515266007994e-06 1.199999955114345
+ 3.2446311862000468e-06 1.1999999729617521
+ 3.2447691845737851e-06 1.1999999702897921
+ 3.2449869782492579e-06 1.199999961983744
+ 3.2453873791565261e-06 1.199999958747441
+ 3.2457619482695699e-06 1.1999999597919511
+ 3.246323260910149e-06 1.199999960513668
+ 3.2469166908486071e-06 1.199999960548483
+ 3.2474604556276201e-06 1.1999999604382829
+ 3.2479861195921682e-06 1.199999960481666
+ 3.2483595684560929e-06 1.1999999606075009
+ 3.2487802168805529e-06 1.199999960438479
+ 3.249260536295102e-06 1.1999999604562159
+ 3.2498611284315591e-06 1.199999960478739
+ 3.2505871351692591e-06 1.1999999604827141
+ 3.2516807765589781e-06 1.199999960481708
+ 3.2533222780603511e-06 1.1999999604809439
+ 3.2561289205696359e-06 1.1999999604809379
+ 3.2606784362835732e-06 1.1999999604809219
+ 3.2656784362835731e-06 1.1999999604808691
+ 3.2706784362835731e-06 1.199999960480858
+ 3.275678436283573e-06 1.1999999604808631
+ 3.280678436283573e-06 1.1999999604808671
+ 3.2856784362835729e-06 1.199999960480868
+ 3.2906784362835729e-06 1.199999960480868
+ 3.2956784362835728e-06 1.199999960480868
+ 3.3006784362835728e-06 1.199999960480868
+ 3.3056784362835732e-06 1.199999960480868
+ 3.3106784362835731e-06 1.199999960480868
+ 3.3156784362835731e-06 1.199999960480868
+ 3.320678436283573e-06 1.199999960480868
+ 3.325678436283573e-06 1.199999960480868
+ 3.3306784362835729e-06 1.199999960480868
+ 3.335678436283572e-06 1.199999960480868
+ 3.340678436283572e-06 1.199999960480868
+ 3.3456784362835719e-06 1.199999960480868
+ 3.3506784362835719e-06 1.199999960480868
+ 3.3556784362835718e-06 1.199999960480868
+ 3.3606784362835718e-06 1.199999960480868
+ 3.3656784362835722e-06 1.199999960480868
+ 3.3706784362835721e-06 1.199999960480868
+ 3.3756784362835721e-06 1.199999960480868
+ 3.380678436283572e-06 1.199999960480868
+ 3.385678436283572e-06 1.199999960480868
+ 3.3906784362835719e-06 1.199999960480868
+ 3.3956784362835719e-06 1.199999960480868
+ 3.4006784362835718e-06 1.199999960480868
+ 3.4056784362835722e-06 1.199999960480868
+ 3.4106784362835722e-06 1.199999960480868
+ 3.4156784362835721e-06 1.199999960480868
+ 3.4206784362835721e-06 1.199999960480868
+ 3.425678436283572e-06 1.199999960480868
+ 3.430678436283572e-06 1.199999960480868
+ 3.4356784362835711e-06 1.199999960480868
+ 3.440678436283571e-06 1.199999960480868
+ 3.445678436283571e-06 1.199999960480868
+ 3.4506784362835709e-06 1.199999960480868
+ 3.4556784362835709e-06 1.199999960480868
+ 3.4606784362835708e-06 1.199999960480868
+ 3.4656784362835712e-06 1.199999960480868
+ 3.4706784362835712e-06 1.199999960480868
+ 3.4756784362835711e-06 1.199999960480868
+ 3.4806784362835711e-06 1.199999960480868
+ 3.485678436283571e-06 1.1999999604808671
+ 3.490678436283571e-06 1.1999999604808651
+ 3.4956784362835709e-06 1.1999999604808631
+ 3.5006784362835709e-06 1.1999999604808571
+ 3.5056784362835708e-06 1.1999999604808469
+ 3.5106784362835712e-06 1.199999960480828
+ 3.5156784362835712e-06 1.1999999604807909
+ 3.5206784362835711e-06 1.1999999604807201
+ 3.5256784362835711e-06 1.199999960480584
+ 3.530678436283571e-06 1.199999960480326
+ 3.535678436283571e-06 1.199999960479851
+ 3.5406784362835701e-06 1.199999960479017
+ 3.54567843628357e-06 1.1999999604775431
+ 3.55067843628357e-06 1.1999999604745331
+ 3.5556784362835699e-06 1.1999999604629319
+ 3.5581761064297731e-06 1.1999999603770499
+ 3.5598650800723899e-06 1.1999999601065841
+ 3.5619750143593501e-06 1.1999999601996361
+ 3.5634612666400068e-06 1.1999999604348599
+ 3.5652879483435581e-06 1.199999960418453
+ 3.566511951949653e-06 1.1999999605288509
+ 3.5670537367509811e-06 1.1999999610546179
+ 3.567700217262836e-06 1.1999999615567949
+ 3.568028100208425e-06 1.1999999641173329
+ 3.5683286133775541e-06 1.1999999669534831
+ 3.568565187817289e-06 1.199999965325111
+ 3.568772163442288e-06 1.199999923020648
+ 3.56898743691763e-06 1.199999867978601
+ 3.5692302598470222e-06 1.199999825557289
+ 3.5693578517876578e-06 1.199999648963493
+ 3.5694231704708801e-06 1.199999295485624
+ 3.5694812062815242e-06 1.199998842861377
+ 3.569526601846023e-06 1.1999985246052181
+ 3.5695941931392261e-06 1.199998011605391
+ 3.5696641853348091e-06 1.1999980852006651
+ 3.5697449965915958e-06 1.1999991361040989
+ 3.5697700470629481e-06 1.1999996880362569
+ 3.5697900221188071e-06 1.1999998055187731
+ 3.5698086080424571e-06 1.20000008679758
+ 3.5698331697446212e-06 1.2000026420455181
+ 3.56986045260041e-06 1.200007872903188
+ 3.5698849067784038e-06 1.2000107374796021
+ 3.5699057191088619e-06 1.200010164678446
+ 3.5699229331915298e-06 1.2000079713446641
+ 3.5699375884015829e-06 1.2000050214125451
+ 3.5699535358352819e-06 1.200001943948779
+ 3.5699707811996269e-06 1.199999694035871
+ 3.56999749563676e-06 1.199998027433874
+ 3.570027208163104e-06 1.199997326983534
+ 3.5700550048506089e-06 1.1999970822915691
+ 3.5700791087099791e-06 1.1999975717107669
+ 3.5701044857357078e-06 1.1999993408484591
+ 3.5701354421586479e-06 1.2000025067944109
+ 3.5701650346967881e-06 1.200005282292838
+ 3.5701892183683388e-06 1.2000070710831161
+ 3.5702057357849728e-06 1.2000083112136439
+ 3.5702213340431269e-06 1.2000097607053539
+ 3.5702361464701348e-06 1.2000117984839149
+ 3.5702509828675801e-06 1.200013289244606
+ 3.5702641183064341e-06 1.200012981664637
+ 3.570278238299817e-06 1.2000113584989021
+ 3.570294342572327e-06 1.200008764449221
+ 3.570323609787763e-06 1.20000150321782
+ 3.5703502142910992e-06 1.1999682773269811
+ 3.5703753572706652e-06 1.1998931521451339
+ 3.570401891144973e-06 1.19977540116488
+ 3.5704398227663552e-06 1.1994742502598379
+ 3.570462256551655e-06 1.1997554601525691
+ 3.570478253129124e-06 1.20130143052393
+ 3.570497170249871e-06 1.205816696436411
+ 3.5705183875544172e-06 1.21372129391468
+ 3.5705341158323108e-06 1.2151991504027211
+ 3.5705480048951059e-06 1.20059024882636
+ 3.5705665073497169e-06 1.1439752354105499
+ 3.5705844490665459e-06 1.057777156981232
+ 3.570602106024245e-06 0.95664322513667022
+ 3.5706236830601069e-06 0.82597830652739768
+ 3.5706449968922801e-06 0.69698405107110584
+ 3.5706593901635911e-06 0.61175362239018305
+ 3.5706708064868971e-06 0.54586250713256845
+ 3.5706855779074591e-06 0.46356986655968252
+ 3.5706967047798741e-06 0.40426770409934382
+ 3.5707107993885478e-06 0.33345036859600691
+ 3.5707304477342052e-06 0.24530422826042089
+ 3.5707539789543062e-06 0.15991345977686211
+ 3.5707759265236882e-06 0.1013878309960969
+ 3.5707956290072052e-06 0.064713121797890474
+ 3.57081175953981e-06 0.043916960112724217
+ 3.570829153272623e-06 0.028460698510819969
+ 3.5708510589619271e-06 0.016028809039689961
+ 3.5708715948626311e-06 0.0091407833297879153
+ 3.5708976613123568e-06 0.0042591078714376692
+ 3.5709245502655968e-06 0.001782315399255497
+ 3.5709598529253079e-06 0.00038890010433916547
+ 3.57100055630288e-06 -0.00010405498277564709
+ 3.5710577730902582e-06 -0.000189764966285423
+ 3.5711341315415791e-06 -0.0001043382462365568
+ 3.571224869413489e-06 -2.7553038919236241e-05
+ 3.57132418944195e-06 5.367055816089358e-07
+ 3.5714546821543601e-06 4.5038874735135882e-06
+ 3.5716309802854789e-06 1.7218788439370641e-06
+ 3.5717738591387012e-06 3.329784085933622e-07
+ 3.5718989547639558e-06 2.28003267758347e-08
+ 3.5720162204257321e-06 1.6329135282224188e-08
+ 3.5721337943355759e-06 4.5914699494421738e-08
+ 3.5722615864815241e-06 6.0687713080198851e-08
+ 3.572381287152714e-06 6.4361011413283856e-08
+ 3.572506399396974e-06 6.6275873818968502e-08
+ 3.5726250056408459e-06 6.9175491603181615e-08
+ 3.5727468931177679e-06 7.3591745130907211e-08
+ 3.5728648780882062e-06 8.4323580613501232e-08
+ 3.5729852519753151e-06 1.2549940968229251e-07
+ 3.5730630999367331e-06 3.0203174429141241e-07
+ 3.5731140639736462e-06 5.901354366135556e-07
+ 3.5731673236046872e-06 6.5541347318494474e-07
+ 3.5732333058206029e-06 2.4997975838819588e-07
+ 3.57326863991319e-06 -1.256562008877911e-07
+ 3.573299861254746e-06 -5.2133057908868589e-07
+ 3.5733247777597269e-06 -9.5860484497529916e-07
+ 3.5733480538107099e-06 -1.464508858167712e-06
+ 3.5733695577035688e-06 -1.751229076560198e-06
+ 3.5733956449824221e-06 -1.6207102037923979e-06
+ 3.573416448303139e-06 -1.7918902943140291e-06
+ 3.5734392421665409e-06 -8.5837010752219125e-07
+ 3.5734760443737428e-06 8.9784216405516732e-07
+ 3.5735161353591351e-06 1.436194117490668e-06
+ 3.5735724811772222e-06 8.6296387496187554e-07
+ 3.5736360107015131e-06 2.4028454613695909e-07
+ 3.5737193506128282e-06 3.3271144969834183e-08
+ 3.5738118609624982e-06 -1.7767177530115279e-08
+ 3.5739217130987972e-06 -8.7031674449560477e-09
+ 3.574032980042927e-06 4.3128709764729037e-08
+ 3.5741639542611791e-06 7.3563583894047808e-08
+ 3.5743277424317571e-06 7.0776120151629654e-08
+ 3.5745839698138769e-06 6.1748386878211888e-08
+ 3.5748901337582232e-06 6.0710831269014106e-08
+ 3.5752552432252839e-06 6.1747287378030234e-08
+ 3.5756861086105032e-06 6.2031896635051268e-08
+ 3.5762236164176062e-06 6.2059085489481855e-08
+ 3.5768237462328851e-06 6.1558642134513068e-08
+ 3.5772184813816919e-06 6.0303069228666966e-08
+ 3.5775562382355388e-06 6.3078684322217855e-08
+ 3.5779834136239589e-06 6.2197117309953878e-08
+ 3.5784531462638289e-06 6.1729554558948764e-08
+ 3.5790073138592651e-06 6.1912181110236309e-08
+ 3.5795981101416329e-06 6.1921340015360418e-08
+ 3.5804222190700321e-06 6.1919034197772351e-08
+ 3.581573035451415e-06 6.1921811523538352e-08
+ 3.5835890051033161e-06 6.1921392788774347e-08
+ 3.5866340901419139e-06 6.1921011794885988e-08
+ 3.5916340901419139e-06 6.1920982061105106e-08
+ 3.5966340901419138e-06 6.1920995028229475e-08
+ 3.6016340901419142e-06 6.1920997643234548e-08
+ 3.6066340901419141e-06 6.1920997965724555e-08
+ 3.6116340901419141e-06 6.192099801954213e-08
+ 3.616634090141914e-06 6.1920998054441966e-08
+ 3.621634090141914e-06 6.1920998083102609e-08
+ 3.6266340901419139e-06 6.1920998199483917e-08
+ 3.631634090141913e-06 6.1920998025738428e-08
+ 3.636634090141913e-06 6.1920998011870487e-08
+ 3.641634090141913e-06 6.1920998090581976e-08
+ 3.6466340901419129e-06 6.1920998205415835e-08
+ 3.6516340901419129e-06 6.1920998220342236e-08
+ 3.6566340901419128e-06 6.1920998037787617e-08
+ 3.6616340901419132e-06 6.1920998100696516e-08
+ 3.6666340901419131e-06 6.1920998151400186e-08
+ 3.6716340901419131e-06 6.1920998218895662e-08
+ 3.676634090141913e-06 6.1920998244103892e-08
+ 3.681634090141913e-06 6.1920998055288734e-08
+ 3.6866340901419129e-06 6.1920998150527822e-08
+ 3.6916340901419129e-06 6.1920997918762614e-08
+ 3.6966340901419128e-06 6.1920998249795477e-08
+ 3.7016340901419128e-06 6.1920998254577944e-08
+ 3.7066340901419132e-06 6.192099810040061e-08
+ 3.7116340901419131e-06 6.1920998120114905e-08
+ 3.7166340901419131e-06 6.1920998219068854e-08
+ 3.721634090141913e-06 6.1920998013024133e-08
+ 3.726634090141913e-06 6.1920998060237259e-08
+ 3.7316340901419129e-06 6.1920998104295757e-08
+ 3.736634090141912e-06 6.1920998197896591e-08
+ 3.741634090141912e-06 6.1920997952893211e-08
+ 3.7466340901419119e-06 6.1920998016342834e-08
+ 3.7516340901419119e-06 6.1920998073390794e-08
+ 3.7566340901419119e-06 6.1920998130982033e-08
+ 3.7616340901419118e-06 6.1920998145311462e-08
+ 3.7666340901419122e-06 6.1920998260796675e-08
+ 3.7716340901419121e-06 6.192099805124165e-08
+ 3.7766340901419121e-06 6.1920998144397143e-08
+ 3.781634090141912e-06 6.1920998147242128e-08
+ 3.786634090141912e-06 6.1920998217096789e-08
+ 3.7916340901419119e-06 6.1920998002133512e-08
+ 3.7966340901419119e-06 6.1920998318764209e-08
+ 3.8016340901419118e-06 6.1920998139265235e-08
+ 3.8066340901419118e-06 6.1920998169020311e-08
+ 3.8116340901419122e-06 6.192099824051144e-08
+ 3.8166340901419117e-06 6.1920998072588072e-08
+ 3.8216340901419117e-06 6.1920998346639269e-08
+ 3.8266340901419116e-06 6.1920998171164271e-08
+ 3.8316340901419124e-06 6.1920997957375259e-08
+ 3.8366340901419124e-06 6.1920998313956952e-08
+ 3.8416340901419106e-06 6.1920998045342423e-08
+ 3.8466340901419114e-06 6.1920998273285104e-08
+ 3.8516340901419114e-06 6.1920998249914962e-08
+ 3.8566340901419113e-06 6.1920998055752418e-08
+ 3.8616340901419113e-06 6.192099829137827e-08
+ 3.8666340901419112e-06 6.1920998008647884e-08
+ 3.8716340901419112e-06 6.1920998139734981e-08
+ 3.8766340901419111e-06 6.1920997874114739e-08
+ 3.8816340901419111e-06 6.19209972233877e-08
+ 3.886634090141911e-06 6.1920993454704852e-08
+ 3.888729298285029e-06 6.1920906091643544e-08
+ 3.890551668301576e-06 6.192090769713249e-08
+ 3.8924635181374756e-06 6.1921195109633124e-08
+ 3.8939920659101164e-06 6.192106231278955e-08
+ 3.8956679322769984e-06 6.192080117010094e-08
+ 3.8966952949309082e-06 6.1921270203522935e-08
+ 3.8970726447423039e-06 6.1921837647292025e-08
+ 3.8976235449610601e-06 6.1920912232288185e-08
+ 3.8979310285183383e-06 6.1925203980054008e-08
+ 3.89817618872985e-06 6.1917546987376771e-08
+ 3.8983770432704581e-06 6.1826138983149631e-08
+ 3.8985855955783717e-06 6.1859458161021313e-08
+ 3.898828107322525e-06 6.1981476057003184e-08
+ 3.8989827248097947e-06 6.1341586290025446e-08
+ 3.8990491919988413e-06 5.7450860921594668e-08
+ 3.8991035931147894e-06 5.5600685145691789e-08
+ 3.8991471219771853e-06 5.9438264029083668e-08
+ 3.8992116802427121e-06 9.1037239523677633e-08
+ 3.8992775709913164e-06 1.3055635598535979e-07
+ 3.8993428517327866e-06 1.7188094151039191e-07
+ 3.8993723525612923e-06 3.2970421027482298e-07
+ 3.8993929788051396e-06 6.4830157769765721e-07
+ 3.899414680137898e-06 7.8486749827622215e-07
+ 3.8994421420051246e-06 2.7108399837265909e-07
+ 3.8994653416910333e-06 -7.5442738829992501e-07
+ 3.8994863374659219e-06 -2.6248257480105799e-06
+ 3.8995052654111037e-06 -4.1789276315636004e-06
+ 3.8995204115099318e-06 -4.9906441921531303e-06
+ 3.8995348738274863e-06 -4.7076497038765394e-06
+ 3.8995449697383947e-06 -2.5629636832175862e-06
+ 3.8995575523430069e-06 -6.6514881079925957e-07
+ 3.8995741752640997e-06 -4.9785475199776299e-07
+ 3.899592957464864e-06 -1.5778641922090451e-06
+ 3.8996173271925049e-06 -2.6328450367710892e-06
+ 3.8996422799359414e-06 -3.2904718047274991e-06
+ 3.8996682434727547e-06 -3.3073900712658531e-06
+ 3.8996917771386604e-06 -1.962720251866146e-06
+ 3.899714790540865e-06 -5.1440409008296848e-07
+ 3.899741863104285e-06 -5.6532208263392768e-07
+ 3.8997722132017262e-06 -1.900312182656744e-06
+ 3.8998005650325639e-06 -3.0625147034911622e-06
+ 3.8998224694446614e-06 -3.720973307170414e-06
+ 3.8998497573430834e-06 -3.6330602565614141e-06
+ 3.8998701864629236e-06 -7.6349057434577355e-07
+ 3.8998876713458956e-06 2.2663915702749479e-06
+ 3.8999048400851221e-06 -6.1783123487822977e-06
+ 3.8999226369810989e-06 -5.2965240004213537e-05
+ 3.8999451948552661e-06 -0.00014632097681966671
+ 3.8999660740295423e-06 -0.00018840834600653841
+ 3.8999790452111518e-06 -0.00013913115186121031
+ 3.8999924892093384e-06 -2.3092602755423409e-05
+ 3.9000077749388068e-06 0.00011020432369209481
+ 3.9000238605282704e-06 0.00018271378014309049
+ 3.9000468308066064e-06 0.0001862632172851698
+ 3.9000698823895174e-06 0.00014849653765582421
+ 3.9001013450310923e-06 9.6934801252772062e-05
+ 3.900132007535777e-06 6.754750470363847e-05
+ 3.9001687465497297e-06 5.6875187103437209e-05
+ 3.9002080168054383e-06 6.2418593160529874e-05
+ 3.9002588928376344e-06 8.4699874969670891e-05
+ 3.9003227241084308e-06 -0.00014692234873799181
+ 3.9003716173248378e-06 -0.001778100209396368
+ 3.9004174922114994e-06 -0.006194483803314511
+ 3.9004331164004334e-06 -0.0080747692063877028
+ 3.9004474067131528e-06 -0.0084013481811896409
+ 3.9004566873553374e-06 -0.0066504148126409054
+ 3.9004667760244877e-06 -0.0012058252647155581
+ 3.9004772935249138e-06 0.01062119222437327
+ 3.9004905030669606e-06 0.037777351188238467
+ 3.9005026844965597e-06 0.076547006179829569
+ 3.9005217088198963e-06 0.16099228535649851
+ 3.9005345779992106e-06 0.23059202691847089
+ 3.9005504647472773e-06 0.32357410681502302
+ 3.9005647906757408e-06 0.40973876027142508
+ 3.9005843895931767e-06 0.52584704816373329
+ 3.9006073022840864e-06 0.65447873355626873
+ 3.9006405245665054e-06 0.81933956583354794
+ 3.900677467608247e-06 0.96342614464797749
+ 3.9007240148213118e-06 1.083613531347668
+ 3.900760129133891e-06 1.1378927012302831
+ 3.9007992271251803e-06 1.170791361343763
+ 3.9008511601824213e-06 1.1915146175270881
+ 3.9008994794672697e-06 1.1985854293349949
+ 3.9009677047178038e-06 1.2012977326953409
+ 3.9010439800306468e-06 1.201253900325236
+ 3.9011666786981936e-06 1.200528299711106
+ 3.9012988082592066e-06 1.20010395473267
+ 3.9014279418501806e-06 1.1999867414149179
+ 3.9015508257600789e-06 1.1999795621484941
+ 3.9016703348972303e-06 1.1999904818330971
+ 3.9017980676098387e-06 1.199997730348529
+ 3.9019168260112034e-06 1.1999999439346121
+ 3.9020407788541654e-06 1.2000002749375469
+ 3.9021585408910021e-06 1.2000001358621051
+ 3.9022798380019514e-06 1.2000000134212241
+ 3.9023974854613121e-06 1.1999999663605969
+ 3.9025176240296274e-06 1.199999956370041
+ 3.902635577347549e-06 1.1999999579185849
+ 3.9027552138116856e-06 1.1999999619835191
+ 3.9028245176070711e-06 1.199999975346822
+ 3.9028717407573016e-06 1.1999999949111251
+ 3.9029203750693748e-06 1.1999999889350601
+ 3.9029857991972083e-06 1.199999940233557
+ 3.9030394793599156e-06 1.199999911974954
+ 3.9030679612660108e-06 1.199999891883468
+ 3.9030925729369308e-06 1.199999853761645
+ 3.9031149670144086e-06 1.1999997905480619
+ 3.9031375846191734e-06 1.199999706686419
+ 3.9031657699740193e-06 1.1999996557896939
+ 3.9031868665579937e-06 1.1999998870899911
+ 3.9032115928969188e-06 1.200000185173093
+ 3.903246974438911e-06 1.200000323233563
+ 3.9032998468237218e-06 1.2000001970599059
+ 3.90335158526737e-06 1.2000000149868211
+ 3.9034245562175938e-06 1.199999886222457
+ 3.9035065645475548e-06 1.199999871120135
+ 3.9036056026597074e-06 1.199999915559367
+ 3.9036999875069446e-06 1.1999999551723179
+ 3.9038163928445782e-06 1.1999999729994679
+ 3.9039541039836198e-06 1.1999999702702371
+ 3.9041728314153638e-06 1.1999999619502459
+ 3.9045733147978841e-06 1.1999999587486501
+ 3.904948487259873e-06 1.1999999597961111
+ 3.905510046116846e-06 1.199999960514387
+ 3.9061044367738156e-06 1.199999960548217
+ 3.9066479900789551e-06 1.19999996043777
+ 3.9071768306426122e-06 1.1999999604832079
+ 3.9075523185020293e-06 1.1999999606061511
+ 3.9079745417769947e-06 1.1999999604378719
+ 3.9084565841775034e-06 1.1999999604565319
+ 3.9090582946819429e-06 1.19999996047893
+ 3.9097894791159909e-06 1.199999960482746
+ 3.9108910748150851e-06 1.1999999604816869
+ 3.9125513295924466e-06 1.199999960480937
+ 3.9153842885281009e-06 1.1999999604809379
+ 3.9199967233855743e-06 1.1999999604809199
+ 3.9249967233855742e-06 1.199999960480868
+ 3.9299967233855742e-06 1.199999960480858
+ 3.9349967233855742e-06 1.1999999604808631
+ 3.9399967233855741e-06 1.199999960480866
+ 3.9449967233855741e-06 1.199999960480868
+ 3.949996723385574e-06 1.199999960480868
+ 3.954996723385574e-06 1.199999960480868
+ 3.9599967233855739e-06 1.1999999604808691
+ 3.9649967233855739e-06 1.199999960480868
+ 3.9699967233855738e-06 1.199999960480868
+ 3.9749967233855738e-06 1.199999960480868
+ 3.9799967233855737e-06 1.199999960480868
+ 3.9849967233855737e-06 1.199999960480868
+ 3.9899967233855736e-06 1.199999960480868
+ 3.9949967233855736e-06 1.199999960480868
+ 3.9999967233855744e-06 1.199999960480868
+ 4.0049967233855726e-06 1.199999960480868
+ 4.0099967233855726e-06 1.199999960480868
+ 4.0149967233855734e-06 1.199999960480868
+ 4.0199967233855733e-06 1.199999960480868
+ 4.0249967233855733e-06 1.199999960480868
+ 4.0299967233855732e-06 1.199999960480868
+ 4.0349967233855732e-06 1.199999960480868
+ 4.0399967233855731e-06 1.199999960480868
+ 4.0449967233855731e-06 1.199999960480868
+ 4.0499967233855731e-06 1.199999960480868
+ 4.054996723385573e-06 1.199999960480868
+ 4.059996723385573e-06 1.199999960480868
+ 4.0649967233855729e-06 1.199999960480868
+ 4.0699967233855729e-06 1.199999960480868
+ 4.0749967233855728e-06 1.199999960480868
+ 4.0799967233855728e-06 1.199999960480868
+ 4.0849967233855727e-06 1.199999960480868
+ 4.0899967233855727e-06 1.199999960480868
+ 4.0949967233855726e-06 1.199999960480868
+ 4.0999967233855734e-06 1.199999960480868
+ 4.1049967233855734e-06 1.199999960480868
+ 4.1099967233855716e-06 1.199999960480868
+ 4.1149967233855716e-06 1.199999960480868
+ 4.1199967233855724e-06 1.199999960480868
+ 4.1249967233855723e-06 1.199999960480868
+ 4.1299967233855723e-06 1.199999960480868
+ 4.1349967233855722e-06 1.199999960480868
+ 4.1399967233855722e-06 1.199999960480868
+ 4.1449967233855721e-06 1.199999960480866
+ 4.1499967233855721e-06 1.1999999604808651
+ 4.154996723385572e-06 1.199999960480862
+ 4.159996723385572e-06 1.1999999604808571
+ 4.1649967233855719e-06 1.199999960480846
+ 4.1699967233855719e-06 1.1999999604808269
+ 4.1749967233855719e-06 1.1999999604807889
+ 4.1799967233855718e-06 1.199999960480717
+ 4.1849967233855718e-06 1.1999999604805791
+ 4.1899967233855717e-06 1.1999999604803171
+ 4.1949967233855717e-06 1.1999999604798339
+ 4.1999967233855716e-06 1.1999999604789879
+ 4.2049967233855724e-06 1.1999999604774889
+ 4.2099967233855724e-06 1.1999999604744049
+ 4.2149967233855706e-06 1.199999960462141
+ 4.2174366790540604e-06 1.199999960369432
+ 4.2191340776386686e-06 1.199999960098201
+ 4.2212667189481749e-06 1.1999999602107441
+ 4.2227280328754639e-06 1.1999999604510989
+ 4.224515897547331e-06 1.199999960404984
+ 4.2257193266384681e-06 1.199999960543064
+ 4.2262493201369361e-06 1.199999961071208
+ 4.2268974436454021e-06 1.1999999615813279
+ 4.2272265435181006e-06 1.19999996422368
+ 4.2275216985876472e-06 1.1999999671369741
+ 4.2277546539097152e-06 1.199999964789215
+ 4.2279621582171693e-06 1.1999999208717269
+ 4.2281775450879913e-06 1.199999866671926
+ 4.228419763933248e-06 1.1999998233365701
+ 4.2285428299267147e-06 1.1999996394481871
+ 4.228606841078715e-06 1.1999992872892249
+ 4.2286648385600408e-06 1.1999988370817229
+ 4.2287105582675034e-06 1.199998518202489
+ 4.2287776781844556e-06 1.199998010132336
+ 4.2288479699521191e-06 1.1999980919927311
+ 4.2289287401590778e-06 1.1999991510073491
+ 4.2289536546369903e-06 1.1999996970157529
+ 4.2289735305832906e-06 1.199999795912404
+ 4.2289923645662732e-06 1.2000001308943851
+ 4.2290170384547727e-06 1.200002775674982
+ 4.2290436061748188e-06 1.20000793343257
+ 4.229068290283578e-06 1.200010765955605
+ 4.2290892205258882e-06 1.200010126813811
+ 4.2291066902259759e-06 1.200007848745309
+ 4.2291210199056908e-06 1.200004935000087
+ 4.2291368148360603e-06 1.200001894192394
+ 4.2291545637518304e-06 1.1999996145546179
+ 4.2291811236277949e-06 1.1999980023491441
+ 4.2292110570005598e-06 1.199997311787484
+ 4.2292392362307899e-06 1.1999970838960849
+ 4.2292635402128524e-06 1.199997634348168
+ 4.2292889939622867e-06 1.199999481397511
+ 4.2293185648318239e-06 1.2000025433660959
+ 4.2293496895231577e-06 1.200005419757918
+ 4.2293742024522037e-06 1.2000072006414151
+ 4.2293907808494399e-06 1.2000084671353151
+ 4.2294064568202356e-06 1.2000099997366029
+ 4.2294208319447454e-06 1.2000120509987271
+ 4.229436878264037e-06 1.2000133527528341
+ 4.2294488609093173e-06 1.200012839050812
+ 4.2294624406026326e-06 1.200011172509369
+ 4.229481294701871e-06 1.200008092256142
+ 4.2295085136038419e-06 1.2000005473464661
+ 4.2295376444629752e-06 1.1999582232815129
+ 4.2295612887019069e-06 1.1998822788989261
+ 4.2295884849805976e-06 1.199755850650658
+ 4.2296280277915153e-06 1.1994425104666031
+ 4.2296482658344598e-06 1.199918506040514
+ 4.229664544300128e-06 1.201881517625621
+ 4.2296860969693173e-06 1.2078194546628711
+ 4.2297083991314671e-06 1.21528030313966
+ 4.2297230199077628e-06 1.211241778712842
+ 4.2297369367546374e-06 1.1868861663393271
+ 4.2297540505799919e-06 1.1246187154340881
+ 4.229774542476129e-06 1.0190655844327969
+ 4.2297953194223114e-06 0.89630292491727459
+ 4.2298156316075329e-06 0.77248472551084657
+ 4.2298327400727452e-06 0.66937394302569742
+ 4.2298449979361927e-06 0.59717971606516618
+ 4.2298564661700488e-06 0.53137679848075636
+ 4.2298697707942706e-06 0.45764617882454861
+ 4.2298831178646999e-06 0.38719453187883301
+ 4.2298979370824243e-06 0.31429990444738543
+ 4.2299183011299816e-06 0.2262193856011496
+ 4.2299421051528764e-06 0.14475559310154021
+ 4.2299643370477022e-06 0.090135835075258117
+ 4.2299806220225348e-06 0.061961249102367028
+ 4.2299964091515259e-06 0.042394894755204048
+ 4.2300141863105796e-06 0.027195069394637679
+ 4.2300356111925584e-06 0.01550990722242097
+ 4.2300569422965507e-06 0.0086362136879289102
+ 4.2300827773943176e-06 0.0040373861284551914
+ 4.2301105948958623e-06 0.001618193806681721
+ 4.2301459174713806e-06 0.00033111711198475098
+ 4.2301879884536596e-06 -0.00012519637301807519
+ 4.2302459108972396e-06 -0.00018620280020398091
+ 4.2303254342629856e-06 -9.5825111900918515e-05
+ 4.2304146474860466e-06 -2.450513043186818e-05
+ 4.2305177497843181e-06 1.6237140014796909e-06
+ 4.2306490240163373e-06 4.3643110685559346e-06
+ 4.2308350005349539e-06 1.5003412917022769e-06
+ 4.2309812176540837e-06 2.6846069068574609e-07
+ 4.2311066002326692e-06 1.9650850181195379e-08
+ 4.2312228169791159e-06 2.1880198433000462e-08
+ 4.2313394943297524e-06 4.8759951816429411e-08
+ 4.231465828700272e-06 6.1321326330145532e-08
+ 4.2315852107393833e-06 6.4640922657725383e-08
+ 4.2317098016849836e-06 6.6687002377355918e-08
+ 4.2318285063788428e-06 6.9794294279238894e-08
+ 4.2319502393386106e-06 7.4742049439852948e-08
+ 4.232068351122114e-06 8.7788743688770546e-08
+ 4.2321886419260989e-06 1.4281409744590811e-07
+ 4.2322571058192306e-06 3.6326043735808909e-07
+ 4.2323069825274934e-06 6.3503089458106344e-07
+ 4.2323638698247776e-06 6.0462753224094448e-07
+ 4.2324292216496763e-06 1.3881619485920929e-07
+ 4.2324661711487203e-06 -2.6705929056692098e-07
+ 4.2324929249516007e-06 -6.7867042662897706e-07
+ 4.2325166460873022e-06 -1.1667235708518951e-06
+ 4.2325391399520764e-06 -1.641928022279809e-06
+ 4.2325604729406154e-06 -1.7242366670216511e-06
+ 4.2325865123769806e-06 -1.685217872559742e-06
+ 4.2326050895451276e-06 -1.674106339872934e-06
+ 4.2326286483697346e-06 -4.4676377325105171e-07
+ 4.2326676876659749e-06 1.1763504240227399e-06
+ 4.2327097051606933e-06 1.3830072136808069e-06
+ 4.232768465437699e-06 6.827763176314798e-07
+ 4.2328373507304953e-06 1.5112412209214791e-07
+ 4.2329162895890918e-06 2.9565642606313162e-08
+ 4.2330011200899242e-06 -1.6601524671254849e-08
+ 4.2331011669376836e-06 -3.3314585019916751e-09
+ 4.2332171345635294e-06 4.9427504037511269e-08
+ 4.2333446970151276e-06 7.3975374330034668e-08
+ 4.2335165692839734e-06 6.9719154044421723e-08
+ 4.2337667341475682e-06 6.1594159137840937e-08
+ 4.2340805942799024e-06 6.0795553285526525e-08
+ 4.2344397339431022e-06 6.1764034638700456e-08
+ 4.2348781098231153e-06 6.2029487331962269e-08
+ 4.2354104306051594e-06 6.2058883805072628e-08
+ 4.2360090571058934e-06 6.1547517254363701e-08
+ 4.2364040135384002e-06 6.0311073492983952e-08
+ 4.2367411097709774e-06 6.3091846320653048e-08
+ 4.2371667025021834e-06 6.2185247991866562e-08
+ 4.2376403518182476e-06 6.1730308050821358e-08
+ 4.2381985703564366e-06 6.1913168728830354e-08
+ 4.2387892850803961e-06 6.1920947825451787e-08
+ 4.2396178336502729e-06 6.191900462648468e-08
+ 4.2407699482811819e-06 6.1921843276878477e-08
+ 4.2428034730772126e-06 6.1921390897488822e-08
+ 4.2458594879649751e-06 6.1921010291492279e-08
+ 4.250859487964975e-06 6.1920982445731504e-08
+ 4.255859487964975e-06 6.1920994954729541e-08
+ 4.2608594879649749e-06 6.1920997773948858e-08
+ 4.2658594879649749e-06 6.1920997991085278e-08
+ 4.2708594879649748e-06 6.1920998056546538e-08
+ 4.2758594879649748e-06 6.1920998055110288e-08
+ 4.2808594879649747e-06 6.1920998372781961e-08
+ 4.2858594879649747e-06 6.1920998246890525e-08
+ 4.2908594879649746e-06 6.1920998069100175e-08
+ 4.2958594879649746e-06 6.1920998109831555e-08
+ 4.3008594879649754e-06 6.1920997878214114e-08
+ 4.3058594879649736e-06 6.1920998239145401e-08
+ 4.3108594879649736e-06 6.1920998248969501e-08
+ 4.3158594879649744e-06 6.1920998100888462e-08
+ 4.3208594879649743e-06 6.1920998162605545e-08
+ 4.3258594879649743e-06 6.1920997931416267e-08
+ 4.3308594879649742e-06 6.1920998199814326e-08
+ 4.3358594879649742e-06 6.1920998271969291e-08
+ 4.3408594879649742e-06 6.1920998342169899e-08
+ 4.3458594879649741e-06 6.1920998178284072e-08
+ 4.3508594879649741e-06 6.1920997981322297e-08
+ 4.355859487964974e-06 6.1920998015500685e-08
+ 4.360859487964974e-06 6.1920998355843261e-08
+ 4.3658594879649739e-06 6.1920998145287507e-08
+ 4.3708594879649739e-06 6.1920998164676289e-08
+ 4.3758594879649738e-06 6.1920998257775997e-08
+ 4.3808594879649738e-06 6.1920998328419206e-08
+ 4.3858594879649737e-06 6.1920998161393454e-08
+ 4.3908594879649737e-06 6.1920998194610765e-08
+ 4.3958594879649736e-06 6.192099800263129e-08
+ 4.4008594879649736e-06 6.1920998048629308e-08
+ 4.4058594879649744e-06 6.1920998097657693e-08
+ 4.4108594879649726e-06 6.1920998107869787e-08
+ 4.4158594879649726e-06 6.1920997976916521e-08
+ 4.4208594879649734e-06 6.1920998031687736e-08
+ 4.4258594879649733e-06 6.1920998302430502e-08
+ 4.4308594879649733e-06 6.1920998108271757e-08
+ 4.4358594879649732e-06 6.1920997964203165e-08
+ 4.4408594879649732e-06 6.1920998212403724e-08
+ 4.4458594879649731e-06 6.1920998041455932e-08
+ 4.4508594879649731e-06 6.1920998057754765e-08
+ 4.4558594879649731e-06 6.1920998131414431e-08
+ 4.460859487964973e-06 6.1920998239663216e-08
+ 4.465859487964973e-06 6.1920997971913163e-08
+ 4.4708594879649729e-06 6.192099809750651e-08
+ 4.4758594879649729e-06 6.1920998116172946e-08
+ 4.4808594879649728e-06 6.1920998199838017e-08
+ 4.4858594879649728e-06 6.1920998211386993e-08
+ 4.4908594879649727e-06 6.1920998047467298e-08
+ 4.4958594879649727e-06 6.1920998207803832e-08
+ 4.5008594879649726e-06 6.1920998207945101e-08
+ 4.5058594879649734e-06 6.1920998072216595e-08
+ 4.5108594879649734e-06 6.1920998125423459e-08
+ 4.5158594879649716e-06 6.1920997932718752e-08
+ 4.5208594879649716e-06 6.1920997952120042e-08
+ 4.5258594879649724e-06 6.1920997962552179e-08
+ 4.5308594879649723e-06 6.1920997949325071e-08
+ 4.5358594879649723e-06 6.1920997766553347e-08
+ 4.5408594879649722e-06 6.1920997451535058e-08
+ 4.5458594879649722e-06 6.1920993413991512e-08
+ 4.5479461463561524e-06 6.1920903177688621e-08
+ 4.5497728017301754e-06 6.1920913935112361e-08
+ 4.5516621008702968e-06 6.1921195278138947e-08
+ 4.5532000405811434e-06 6.192105618944332e-08
+ 4.5548773194012952e-06 6.1920806678185069e-08
+ 4.555900215632562e-06 6.1921273050093661e-08
+ 4.5562735039752983e-06 6.1921876011897376e-08
+ 4.5568169500513014e-06 6.1920900490135599e-08
+ 4.557122825641608e-06 6.1925273400559318e-08
+ 4.5573675630767894e-06 6.1916604380298938e-08
+ 4.557568147105791e-06 6.1820937350606675e-08
+ 4.5577761736723083e-06 6.1867073796796542e-08
+ 4.5580175165130858e-06 6.1978850054128145e-08
+ 4.5581663490576783e-06 6.1284725486088734e-08
+ 4.5582315037041337e-06 5.7426499083328651e-08
+ 4.5582861529843571e-06 5.5717747936853577e-08
+ 4.5583295611364308e-06 5.9382523943914028e-08
+ 4.5583941243454782e-06 9.0812454000289181e-08
+ 4.5584600868645893e-06 1.3040419281368671e-07
+ 4.5585256174473009e-06 1.7179615753925961e-07
+ 4.5585551770437097e-06 3.305447177472439e-07
+ 4.5585757821149562e-06 6.5001267230037433e-07
+ 4.5585975303343917e-06 7.8375795525906827e-07
+ 4.5586250312383302e-06 2.6681645871803519e-07
+ 4.55864816977562e-06 -7.6376180957009103e-07
+ 4.558669158987002e-06 -2.6378073522650018e-06
+ 4.5586881313094926e-06 -4.1878710045346934e-06
+ 4.5587032431065246e-06 -5.0006383821182819e-06
+ 4.5587177877518911e-06 -4.6753859546094993e-06
+ 4.5587279195727224e-06 -2.5218514169623551e-06
+ 4.558740520017014e-06 -6.5005416847378418e-07
+ 4.5587573160492567e-06 -5.1446083945465874e-07
+ 4.5587761752231e-06 -1.602962235964173e-06
+ 4.5588006008469084e-06 -2.649364783899077e-06
+ 4.5588255910944633e-06 -3.3035484795201019e-06
+ 4.5588488336795194e-06 -3.344027205661517e-06
+ 4.5588730849029056e-06 -2.0439905204932558e-06
+ 4.5588959188277751e-06 -5.5422730874280521e-07
+ 4.5589225023549477e-06 -5.0916069240164593e-07
+ 4.5589502250619698e-06 -1.704696387472979e-06
+ 4.5589798337128044e-06 -2.9717891991605352e-06
+ 4.55900324400447e-06 -3.6936036123647748e-06
+ 4.5590316435026239e-06 -3.7275592247660079e-06
+ 4.5590541472354454e-06 -6.1740680075883935e-07
+ 4.5590723453983986e-06 2.213468170319954e-06
+ 4.5590896905553891e-06 -9.706306366243445e-06
+ 4.5591075992835166e-06 -6.1969403739712401e-05
+ 4.5591297368597524e-06 -0.0001537749994934993
+ 4.5591523509830983e-06 -0.00018296724463957159
+ 4.5591657098778687e-06 -0.00011275972914977421
+ 4.5591799212224891e-06 1.7555223896432231e-05
+ 4.5591974152555134e-06 0.0001474029965519382
+ 4.5592142056101874e-06 0.00019148691402349561
+ 4.5592371625044609e-06 0.0001747571641916665
+ 4.5592621381382749e-06 0.00013138800092492959
+ 4.5592936374264627e-06 8.5441763771416132e-05
+ 4.5593264181405147e-06 6.2132755089946564e-05
+ 4.5593635470158742e-06 5.7348865705753808e-05
+ 4.5594061715572286e-06 6.7877907722847667e-05
+ 4.5594601657843758e-06 8.4789612380842152e-05
+ 4.5595297946499068e-06 -0.00065552974329800492
+ 4.5595747947076166e-06 -0.003349582648968849
+ 4.5596140920057067e-06 -0.0076088437392865622
+ 4.5596232674524538e-06 -0.0083354518740028777
+ 4.5596393250674448e-06 -0.0061374759538544354
+ 4.5596505631094554e-06 0.000580576328345095
+ 4.5596614734539707e-06 0.01400868887851876
+ 4.5596735446379152e-06 0.0397593662160255
+ 4.5596864697526308e-06 0.081711046923023556
+ 4.5597047491041248e-06 0.16383514310442229
+ 4.5597178491393238e-06 0.23491415158345369
+ 4.5597334944650561e-06 0.3266090944310639
+ 4.5597480454211696e-06 0.41408993344533701
+ 4.5597676233465474e-06 0.52991025268717851
+ 4.5597909121363054e-06 0.66024825184561031
+ 4.5598241910684556e-06 0.82440130880815865
+ 4.5598614094715401e-06 0.96802361974073203
+ 4.5599083078589726e-06 1.08697492367545
+ 4.5599440634610921e-06 1.1394793872186839
+ 4.5599832355952404e-06 1.171655534184209
+ 4.5600349899899784e-06 1.1917685531704789
+ 4.5600836827814282e-06 1.198691314784319
+ 4.5601522014761516e-06 1.2013025912329001
+ 4.560229401417922e-06 1.201234910076679
+ 4.5603533514062263e-06 1.200510820806393
+ 4.560485880117698e-06 1.200097970656568
+ 4.5606149584276918e-06 1.199986082172164
+ 4.5607376728219223e-06 1.1999799764799279
+ 4.5608570751810847e-06 1.1999907930059339
+ 4.5609846260447216e-06 1.199997838409457
+ 4.5611033574985658e-06 1.199999964841491
+ 4.5612272430195151e-06 1.2000002708489419
+ 4.56134502162785e-06 1.2000001309108179
+ 4.5614662946640444e-06 1.200000011249585
+ 4.5615839592638614e-06 1.1999999658155991
+ 4.5617040831058473e-06 1.1999999563827499
+ 4.5618220463303884e-06 1.1999999580237311
+ 4.5619416739810659e-06 1.199999962187031
+ 4.5620089867125028e-06 1.1999999762986351
+ 4.5620558899162053e-06 1.199999995442385
+ 4.5621049098453684e-06 1.199999987654786
+ 4.56216989796543e-06 1.199999938680721
+ 4.5622199173026833e-06 1.1999999118556961
+ 4.5622476378146484e-06 1.199999893845652
+ 4.5622729087395164e-06 1.1999998591633869
+ 4.5622958128732444e-06 1.1999997978994821
+ 4.5623186225423937e-06 1.1999997141192951
+ 4.5623471922919024e-06 1.1999996541152389
+ 4.5623692743944309e-06 1.1999998817234789
+ 4.5623941325870091e-06 1.200000181842795
+ 4.5624282787213722e-06 1.2000003216362971
+ 4.5624821055649156e-06 1.20000019809272
+ 4.5625327623851916e-06 1.2000000186580371
+ 4.56260618523701e-06 1.1999998868617721
+ 4.5626891975406544e-06 1.1999998708901889
+ 4.5627866522884978e-06 1.199999914802397
+ 4.5628820397728436e-06 1.1999999550256339
+ 4.5629970592831451e-06 1.199999972892394
+ 4.5631356462898364e-06 1.199999970320756
+ 4.5633517917885406e-06 1.1999999620416311
+ 4.5637524289416296e-06 1.1999999587447201
+ 4.5641259779272052e-06 1.199999959785004
+ 4.5646873372577358e-06 1.1999999605127001
+ 4.5652793064551856e-06 1.199999960548906
+ 4.5658234936662837e-06 1.1999999604390019
+ 4.5663449879609314e-06 1.199999960479579
+ 4.5667158107927697e-06 1.19999996060926
+ 4.5671344502141283e-06 1.199999960439329
+ 4.5676125714824116e-06 1.199999960455804
+ 4.568211753892513e-06 1.1999999604784819
+ 4.5689310492017123e-06 1.199999960482667
+ 4.5700144333588731e-06 1.199999960481736
+ 4.5716317773750052e-06 1.199999960480953
+ 4.5744046015308947e-06 1.1999999604809359
+ 4.5788740045696318e-06 1.1999999604809239
+ 4.5838740045696318e-06 1.1999999604808691
+ 4.5888740045696317e-06 1.199999960480858
+ 4.5938740045696317e-06 1.1999999604808631
+ 4.5988740045696316e-06 1.199999960480866
+ 4.6038740045696316e-06 1.199999960480868
+ 4.6088740045696324e-06 1.199999960480868
+ 4.6138740045696306e-06 1.199999960480868
+ 4.6188740045696306e-06 1.199999960480868
+ 4.6238740045696314e-06 1.199999960480868
+ 4.6288740045696313e-06 1.199999960480868
+ 4.6338740045696313e-06 1.199999960480868
+ 4.6388740045696312e-06 1.199999960480868
+ 4.6438740045696312e-06 1.199999960480868
+ 4.6488740045696311e-06 1.199999960480868
+ 4.6538740045696311e-06 1.199999960480868
+ 4.6588740045696311e-06 1.199999960480868
+ 4.663874004569631e-06 1.199999960480868
+ 4.668874004569631e-06 1.199999960480868
+ 4.6738740045696309e-06 1.199999960480868
+ 4.6788740045696309e-06 1.199999960480868
+ 4.6838740045696308e-06 1.199999960480868
+ 4.6888740045696308e-06 1.199999960480868
+ 4.6938740045696307e-06 1.199999960480868
+ 4.6988740045696307e-06 1.199999960480868
+ 4.7038740045696306e-06 1.199999960480868
+ 4.7088740045696314e-06 1.199999960480868
+ 4.7138740045696314e-06 1.199999960480868
+ 4.7188740045696296e-06 1.199999960480868
+ 4.7238740045696296e-06 1.199999960480868
+ 4.7288740045696304e-06 1.199999960480868
+ 4.7338740045696303e-06 1.199999960480868
+ 4.7388740045696303e-06 1.199999960480868
+ 4.7438740045696302e-06 1.199999960480868
+ 4.7488740045696302e-06 1.199999960480868
+ 4.7538740045696301e-06 1.199999960480868
+ 4.7588740045696301e-06 1.199999960480868
+ 4.76387400456963e-06 1.199999960480868
+ 4.76887400456963e-06 1.199999960480868
+ 4.77387400456963e-06 1.199999960480868
+ 4.7788740045696299e-06 1.199999960480868
+ 4.7838740045696299e-06 1.199999960480868
+ 4.7888740045696298e-06 1.199999960480868
+ 4.7938740045696298e-06 1.199999960480868
+ 4.7988740045696297e-06 1.1999999604808671
+ 4.8038740045696297e-06 1.1999999604808671
+ 4.8088740045696296e-06 1.1999999604808651
+ 4.8138740045696304e-06 1.199999960480862
+ 4.8188740045696304e-06 1.199999960480858
+ 4.8238740045696286e-06 1.1999999604808469
+ 4.8288740045696286e-06 1.1999999604808289
+ 4.8338740045696294e-06 1.199999960480792
+ 4.8388740045696293e-06 1.199999960480723
+ 4.8438740045696293e-06 1.19999996048059
+ 4.8488740045696292e-06 1.199999960480338
+ 4.8538740045696292e-06 1.199999960479873
+ 4.8588740045696291e-06 1.1999999604790541
+ 4.8638740045696291e-06 1.199999960477609
+ 4.868874004569629e-06 1.1999999604746909
+ 4.873874004569629e-06 1.199999960463856
+ 4.876453005669751e-06 1.199999960385713
+ 4.8781492020492731e-06 1.199999960116986
+ 4.8802363168473391e-06 1.199999960187631
+ 4.8817562946825718e-06 1.199999960419152
+ 4.8836301366571656e-06 1.199999960431533
+ 4.8848684745755481e-06 1.1999999605195959
+ 4.8854156862528421e-06 1.1999999610481249
+ 4.8860619418146581e-06 1.199999961545249
+ 4.8863892768949216e-06 1.199999964070668
+ 4.8866922592173141e-06 1.199999966871953
+ 4.8869304705865741e-06 1.199999965539835
+ 4.8871376344900976e-06 1.1999999239107391
+ 4.8873529760477681e-06 1.199999868454384
+ 4.8875961078364543e-06 1.199999826273914
+ 4.8877253935209319e-06 1.199999652065592
+ 4.8877911823971589e-06 1.1999992974042
+ 4.8878491811913858e-06 1.199998844001182
+ 4.8878944827884982e-06 1.1999985258082231
+ 4.8879622058540553e-06 1.1999980116037769
+ 4.8880320959116579e-06 1.1999980835454209
+ 4.8881129497150704e-06 1.199999133025718
+ 4.8881380349697862e-06 1.199999686300909
+ 4.8881580288102622e-06 1.1999998073603291
+ 4.8881765665961502e-06 1.200000078518054
+ 4.8882011100748278e-06 1.200002616969823
+ 4.8882285432003046e-06 1.2000078630792581
+ 4.8882529515259926e-06 1.2000107321558731
+ 4.8882737405340571e-06 1.200010170968685
+ 4.888290916267819e-06 1.200007991225114
+ 4.8883056338081574e-06 1.2000050341737349
+ 4.8883216118862548e-06 1.2000019503025059
+ 4.8883387774040481e-06 1.199999705888545
+ 4.8883655262855858e-06 1.199998030655953
+ 4.8883952086416529e-06 1.199997328902729
+ 4.8884229578085131e-06 1.199997082169918
+ 4.8884470441308467e-06 1.199997564340473
+ 4.8884724058859698e-06 1.199999323365905
+ 4.8885035796986661e-06 1.200002505949946
+ 4.8885329668513429e-06 1.2000052668771981
+ 4.8885570879632297e-06 1.200007055501551
+ 4.8885735912098191e-06 1.200008292331934
+ 4.888589177303614e-06 1.2000097320423091
+ 4.8886040460017904e-06 1.2000117666203589
+ 4.8886187784216041e-06 1.200013278183121
+ 4.8886321055915246e-06 1.200012992079865
+ 4.8886463307340644e-06 1.200011364325835
+ 4.8886621781234264e-06 1.200008812308061
+ 4.8886885463162017e-06 1.200003058547275
+ 4.8887163655739252e-06 1.1999723575513981
+ 4.8887416061171233e-06 1.199899968700274
+ 4.8887681586992227e-06 1.1997850582839831
+ 4.8888042788566529e-06 1.199509491618572
+ 4.8888282840727256e-06 1.1996690047763101
+ 4.8888444635440117e-06 1.2010159052888021
+ 4.8888624060093962e-06 1.2049440411634209
+ 4.8888835726839859e-06 1.2126562904866001
+ 4.8889001498655426e-06 1.2156851616825559
+ 4.8889141954289932e-06 1.203866267604615
+ 4.8889303917757184e-06 1.1600643808667881
+ 4.8889474238147412e-06 1.0839900782824139
+ 4.8889650652132091e-06 0.98606647195835684
+ 4.8889863368306696e-06 0.8582242521149307
+ 4.8890068207714563e-06 0.73366534956528451
+ 4.8890215173431849e-06 0.6457434706236953
+ 4.8890327495258044e-06 0.58006084828938553
+ 4.8890452844390346e-06 0.50879389555974763
+ 4.8890583650293734e-06 0.43723256108710179
+ 4.8890710817378427e-06 0.37110583823240639
+ 4.889090807142834e-06 0.27763755571471471
+ 4.8891138211993157e-06 0.1867361317669568
+ 4.8891361503291997e-06 0.1197912098124231
+ 4.8891630516652999e-06 0.065322801335431349
+ 4.8891793711811426e-06 0.044020516740093781
+ 4.8891960848148774e-06 0.028998764869351309
+ 4.8892155266638514e-06 0.01752576403710079
+ 4.8892367626569129e-06 0.009868949647233503
+ 4.889261020318063e-06 0.004919796965687037
+ 4.8892886910096491e-06 0.0020487762911486252
+ 4.8893219060814494e-06 0.00054422596147800102
+ 4.88936269371607e-06 -6.8541147704541286e-05
+ 4.8894160776283476e-06 -0.00019462432051358099
+ 4.8894900629386642e-06 -0.00011922515746201191
+ 4.8895815494740009e-06 -3.4545255440465799e-05
+ 4.8896769835396854e-06 -1.754047612828978e-06
+ 4.889804706425768e-06 4.6816757382365749e-06
+ 4.8899694200062539e-06 2.1273218951734091e-06
+ 4.8901081076438296e-06 4.6516422130855147e-07
+ 4.8902329000136954e-06 3.4598777627323628e-08
+ 4.8903514874925976e-06 7.2991401593437691e-09
+ 4.8904701732243834e-06 4.0559992149443e-08
+ 4.8906000027350984e-06 5.94139132534213e-08
+ 4.8907201067586767e-06 6.3988989542843714e-08
+ 4.8908459917748881e-06 6.5770967265529675e-08
+ 4.8909644600651314e-06 6.8391987845509228e-08
+ 4.8910865961039324e-06 7.2236192299566087e-08
+ 4.8912044014386039e-06 8.064477976815995e-08
+ 4.891324910674849e-06 1.08928043674508e-07
+ 4.8914198858824426e-06 2.4077190110781492e-07
+ 4.891473587969866e-06 5.4429852572711317e-07
+ 4.8915248296439888e-06 6.8263301510763909e-07
+ 4.8915931796976009e-06 3.2801494633944171e-07
+ 4.8916409085430562e-06 -1.31072959625122e-07
+ 4.8916691775982869e-06 -5.234207818541487e-07
+ 4.891694605815901e-06 -1.0031675803341639e-06
+ 4.8917176730553927e-06 -1.5131492560244029e-06
+ 4.8917391453533569e-06 -1.7665976129834469e-06
+ 4.8917677306744821e-06 -1.6351796860573891e-06
+ 4.8917880372225334e-06 -1.7340994271931631e-06
+ 4.8918110236954244e-06 -6.5664695781926781e-07
+ 4.8918532924436531e-06 1.144742618008194e-06
+ 4.8918923638666664e-06 1.41471306185853e-06
+ 4.8919538582042409e-06 7.0640333197965378e-07
+ 4.8920181202114614e-06 1.745803728496296e-07
+ 4.8920971688334406e-06 3.0202396248639297e-08
+ 4.8921823385078924e-06 -1.703563871312415e-08
+ 4.8922825887211974e-06 -4.5537126164421478e-09
+ 4.8923984131034439e-06 4.8111417259969192e-08
+ 4.8925247824041589e-06 7.3628367719909724e-08
+ 4.8926944859900104e-06 7.003428185890744e-08
+ 4.8929395160424566e-06 6.175770509739982e-08
+ 4.8932537693249249e-06 6.075952386679494e-08
+ 4.8936077760676867e-06 6.1735869175930019e-08
+ 4.8940450577642019e-06 6.2030086682014294e-08
+ 4.8945691017745948e-06 6.2057689477387685e-08
+ 4.8951862864317621e-06 6.1590169397907493e-08
+ 4.8955824097441568e-06 6.0289924232090755e-08
+ 4.8959249291701919e-06 6.3044787506089839e-08
+ 4.8963576547723934e-06 6.2223843030660688e-08
+ 4.896822226071937e-06 6.1726784478126598e-08
+ 4.8973717230569824e-06 6.1910268923142533e-08
+ 4.8979638022954461e-06 6.1922286802024285e-08
+ 4.8987852062469807e-06 6.1919157060924116e-08
+ 4.8999405453460497e-06 6.1921754426261123e-08
+ 4.9019468946392622e-06 6.1921387212905043e-08
+ 4.9049931148238639e-06 6.1921011814959134e-08
+ 4.9099931148238639e-06 6.192098237179155e-08
+ 4.9149931148238638e-06 6.1920994903829465e-08
+ 4.9199931148238638e-06 6.1920997778353006e-08
+ 4.9249931148238637e-06 6.1920997695182113e-08
+ 4.9299931148238637e-06 6.1920997925247313e-08
+ 4.9349931148238636e-06 6.1920997980846423e-08
+ 4.9399931148238644e-06 6.192099802940207e-08
+ 4.9449931148238644e-06 6.1920998130272458e-08
+ 4.9499931148238626e-06 6.1920998192352654e-08
+ 4.9549931148238634e-06 6.1920998224791462e-08
+ 4.9599931148238634e-06 6.1920998012077309e-08
+ 4.9649931148238633e-06 6.1920998085607273e-08
+ 4.9699931148238633e-06 6.1920998178055214e-08
+ 4.9749931148238632e-06 6.1920998212125394e-08
+ 4.9799931148238632e-06 6.1920998031631011e-08
+ 4.9849931148238631e-06 6.1920998083418261e-08
+ 4.9899931148238631e-06 6.1920998136169898e-08
+ 4.994993114823863e-06 6.1920998157691629e-08
+ 4.999993114823863e-06 6.1920998287089451e-08
+ 5.0049931148238629e-06 6.1920998085691301e-08
+ 5.0099931148238629e-06 6.1920998105243521e-08
+ 5.0149931148238628e-06 6.1920998155360581e-08
+ 5.0199931148238628e-06 6.1920998253817693e-08
+ 5.0249931148238628e-06 6.1920998041202417e-08
+ 5.0299931148238627e-06 6.1920998356470132e-08
+ 5.0349931148238627e-06 6.1920998129078631e-08
+ 5.0399931148238626e-06 6.1920998220972918e-08
+ 5.0449931148238634e-06 6.1920998253549607e-08
+ 5.0499931148238634e-06 6.1920998097898237e-08
+ 5.0549931148238616e-06 6.1920998089041197e-08
+ 5.0599931148238624e-06 6.1920998187947368e-08
+ 5.0649931148238624e-06 6.1920997944133514e-08
+ 5.0699931148238623e-06 6.1920997997063173e-08
+ 5.0749931148238623e-06 6.1920998092165796e-08
+ 5.0799931148238622e-06 6.1920998143033737e-08
+ 5.0849931148238622e-06 6.192099821797016e-08
+ 5.0899931148238621e-06 6.1920998015028437e-08
+ 5.0949931148238621e-06 6.1920998067092204e-08
+ 5.099993114823862e-06 6.1920998123064856e-08
+ 5.104993114823862e-06 6.1920998133285698e-08
+ 5.1099931148238619e-06 6.1920998245646114e-08
+ 5.1149931148238619e-06 6.1920998014209965e-08
+ 5.1199931148238618e-06 6.1920998131566711e-08
+ 5.1249931148238618e-06 6.1920998196341954e-08
+ 5.1299931148238617e-06 6.1920998225657288e-08
+ 5.1349931148238617e-06 6.192099801957003e-08
+ 5.1399931148238616e-06 6.1920998108005815e-08
+ 5.1449931148238616e-06 6.1920998117821722e-08
+ 5.1499931148238624e-06 6.1920998207176485e-08
+ 5.1549931148238624e-06 6.1920998218114777e-08
+ 5.1599931148238606e-06 6.1920998168189398e-08
+ 5.1649931148238614e-06 6.1920998184716877e-08
+ 5.1699931148238614e-06 6.1920997963713858e-08
+ 5.1749931148238613e-06 6.1920998072406463e-08
+ 5.1799931148238613e-06 6.1920997891775945e-08
+ 5.1849931148238612e-06 6.1920998011209312e-08
+ 5.1899931148238612e-06 6.1920997844053739e-08
+ 5.1949931148238611e-06 6.1920997626557092e-08
+ 5.1999931148238611e-06 6.1920997354698916e-08
+ 5.204993114823861e-06 6.192099342376385e-08
+ 5.2070902168565559e-06 6.1920906446208545e-08
+ 5.2089106503638774e-06 6.1920906100310226e-08
+ 5.2108272273078193e-06 6.1921195131382733e-08
+ 5.2123531140876588e-06 6.1921063512742004e-08
+ 5.2140283847166331e-06 6.1920800729999283e-08
+ 5.215057482848184e-06 6.192126822736173e-08
+ 5.2154361101824458e-06 6.1921827215007996e-08
+ 5.21598888418278e-06 6.1920916443590879e-08
+ 5.2162967435042396e-06 6.1925183749046067e-08
+ 5.2165420006392497e-06 6.1917797907253645e-08
+ 5.2167425818237749e-06 6.1827560742084713e-08
+ 5.2169511459211563e-06 6.1857364861405236e-08
+ 5.2171940746942639e-06 6.1982247188370573e-08
+ 5.2173507441150858e-06 6.1360099442846139e-08
+ 5.2174176781833303e-06 5.7459825457760448e-08
+ 5.2174719895824761e-06 5.5558681415388427e-08
+ 5.2175155629437844e-06 5.9461777334032298e-08
+ 5.217580117702339e-06 9.1125301098564721e-08
+ 5.217645983162606e-06 1.3061636043839121e-07
+ 5.2177111647908563e-06 1.719184579261012e-07
+ 5.2177406414067033e-06 3.2939398996202718e-07
+ 5.2177612759040591e-06 6.4766041059751136e-07
+ 5.2177829600884779e-06 7.8527065329279926e-07
+ 5.2178104072117129e-06 2.7266948208678312e-07
+ 5.2178336301369098e-06 -7.5097517906315864e-07
+ 5.2178546280743066e-06 -2.6199826200118e-06
+ 5.2178735392716912e-06 -4.1755608618986212e-06
+ 5.2178886982159916e-06 -4.9869153652414368e-06
+ 5.2179031303136408e-06 -4.7195511902233133e-06
+ 5.2179132132786434e-06 -2.578258804065557e-06
+ 5.2179257897116456e-06 -6.7084743526691206e-07
+ 5.2179423491718942e-06 -4.9184636582140951e-07
+ 5.2179611280763781e-06 -1.569501758621117e-06
+ 5.2179854618527432e-06 -2.6269069868182909e-06
+ 5.2180103992664554e-06 -3.2858694176328701e-06
+ 5.2180363461866558e-06 -3.3133915499098812e-06
+ 5.2180599864266636e-06 -1.9747422945637049e-06
+ 5.2180829741756411e-06 -5.2056028798415634e-07
+ 5.2181099762791082e-06 -5.588870712914857e-07
+ 5.2181404041817264e-06 -1.8924291885679101e-06
+ 5.2181686793763324e-06 -3.0535501716426961e-06
+ 5.2181906036063157e-06 -3.7152270181313358e-06
+ 5.2182179937000014e-06 -3.6435818364932598e-06
+ 5.2182386027412507e-06 -7.5792213761119793e-07
+ 5.2182561552554558e-06 2.2648158290322589e-06
+ 5.2182733259950793e-06 -6.4015725083229606e-06
+ 5.2182911252883753e-06 -5.3557176296498547e-05
+ 5.2183136493089836e-06 -0.0001468209891178298
+ 5.2183346484169113e-06 -0.00018819669861080851
+ 5.2183476083278784e-06 -0.0001377354199563582
+ 5.21836108961455e-06 -2.073991821139776e-05
+ 5.2183764445281398e-06 0.00011231986647870949
+ 5.2183925614624642e-06 0.0001833907316857956
+ 5.2184157509515556e-06 0.00018562927666769519
+ 5.2184387691882152e-06 0.000147572699439378
+ 5.2184703759484718e-06 9.602305875570817e-05
+ 5.2185010587140364e-06 6.7126025941102138e-05
+ 5.2185379230986562e-06 5.6845820830376097e-05
+ 5.2185773099796309e-06 6.2706602189569185e-05
+ 5.2186284809659236e-06 8.5191343686536985e-05
+ 5.2186926319710866e-06 -0.00016723452470108869
+ 5.218741041765793e-06 -0.001846448464564139
+ 5.2187872514644082e-06 -0.0063787008866784348
+ 5.2188022676235194e-06 -0.0081539494574403674
+ 5.2188166893162133e-06 -0.008300929905703705
+ 5.2188257874582071e-06 -0.0063645485503104242
+ 5.2188358957767777e-06 -0.0005465957925295088
+ 5.2188464814991509e-06 0.011949589617556289
+ 5.218859572817195e-06 0.039734919370422422
+ 5.2188719858564567e-06 0.080186397135759119
+ 5.2188888080249521e-06 0.15504196442510451
+ 5.2189008024218024e-06 0.21927235456494909
+ 5.2189144482221082e-06 0.29857354574532408
+ 5.2189291100309218e-06 0.38663202203976038
+ 5.2189466149217294e-06 0.49116775762976489
+ 5.218969202986836e-06 0.62035498277850754
+ 5.2189992801371239e-06 0.77577954110099923
+ 5.2190362216079269e-06 0.93097851986729951
+ 5.2190786997146041e-06 1.055183694573598
+ 5.2191244871286297e-06 1.1338907441572821
+ 5.2191658135912886e-06 1.1707178451702489
+ 5.2192186064581532e-06 1.1921881104537631
+ 5.21926640556969e-06 1.199007091726441
+ 5.2193330827615501e-06 1.2014457732823809
+ 5.2194078566359871e-06 1.201290724176816
+ 5.2195289269282311e-06 1.200518636030125
+ 5.2196606728274629e-06 1.2000920092476941
+ 5.2197899543266533e-06 1.1999813848126739
+ 5.2199130756499926e-06 1.1999782169052531
+ 5.220032713455633e-06 1.1999904653882181
+ 5.220160704549966e-06 1.199997924327403
+ 5.2202794878089508e-06 1.2000000491202949
+ 5.2204035432343942e-06 1.200000305444318
+ 5.220521277278154e-06 1.2000001388730881
+ 5.2206426150307267e-06 1.200000010680349
+ 5.2207602357240174e-06 1.1999999644399491
+ 5.2208803989717938e-06 1.199999955673773
+ 5.2209983362062639e-06 1.1999999577630189
+ 5.2211179873962886e-06 1.199999961810106
+ 5.2211902861494274e-06 1.1999999741810099
+ 5.2212380202639291e-06 1.1999999942756781
+ 5.2212862291334367e-06 1.199999990429456
+ 5.2213522924263996e-06 1.1999999420452441
+ 5.221410589939395e-06 1.199999912018215
+ 5.2214399775183682e-06 1.19999988894119
+ 5.2214638084985042e-06 1.199999846018498
+ 5.2214855965782996e-06 1.199999780111153
+ 5.2215080227292187e-06 1.1999996958803349
+ 5.221535667370082e-06 1.1999996600419229
+ 5.2215553910275156e-06 1.1999998955601019
+ 5.2215801223819388e-06 1.2000001920051979
+ 5.2216175719367367e-06 1.2000003252278419
+ 5.2216691395217074e-06 1.200000193574964
+ 5.2217226474284318e-06 1.2000000076052559
+ 5.2217953903197754e-06 1.199999884253675
+ 5.2218750991549396e-06 1.199999871642605
+ 5.2219671492709001e-06 1.1999999139132931
+ 5.2220649183386357e-06 1.1999999552051319
+ 5.2221768363080727e-06 1.1999999727186179
+ 5.2223180063176571e-06 1.1999999703406641
+ 5.2225265380801326e-06 1.1999999622363511
+ 5.2229178669411144e-06 1.1999999587793391
+ 5.2232908448093153e-06 1.1999999597686211
+ 5.2238431161255658e-06 1.1999999605008409
+ 5.224431984536151e-06 1.199999960548934
+ 5.2249783835756622e-06 1.1999999604445539
+ 5.2254698217664563e-06 1.19999996046308
+ 5.2258230012828784e-06 1.1999999606213749
+ 5.2262288282297247e-06 1.1999999604473539
+ 5.2266932465540787e-06 1.1999999604528819
+ 5.2272839620205007e-06 1.1999999604763869
+ 5.2279576305386236e-06 1.199999960482214
+ 5.2289725558476901e-06 1.1999999604819369
+ 5.2304298791364447e-06 1.1999999604810381
+ 5.2329800132162263e-06 1.1999999604809251
+ 5.2369437575465116e-06 1.199999960480937
+ 5.2419437575465124e-06 1.1999999604808771
+ 5.2469437575465123e-06 1.199999960480858
+ 5.2519437575465123e-06 1.199999960480862
+ 5.2569437575465123e-06 1.199999960480866
+ 5.2619437575465122e-06 1.199999960480868
+ 5.2669437575465122e-06 1.199999960480868
+ 5.2719437575465121e-06 1.199999960480868
+ 5.2769437575465121e-06 1.199999960480868
+ 5.281943757546512e-06 1.199999960480868
+ 5.286943757546512e-06 1.199999960480868
+ 5.2919437575465119e-06 1.199999960480868
+ 5.2969437575465119e-06 1.199999960480868
+ 5.3019437575465118e-06 1.199999960480868
+ 5.3069437575465118e-06 1.199999960480868
+ 5.3119437575465117e-06 1.199999960480868
+ 5.3169437575465117e-06 1.199999960480868
+ 5.3219437575465116e-06 1.199999960480868
+ 5.3269437575465116e-06 1.199999960480868
+ 5.3319437575465124e-06 1.199999960480868
+ 5.3369437575465106e-06 1.199999960480868
+ 5.3419437575465106e-06 1.199999960480868
+ 5.3469437575465114e-06 1.199999960480868
+ 5.3519437575465113e-06 1.199999960480868
+ 5.3569437575465113e-06 1.199999960480868
+ 5.3619437575465112e-06 1.199999960480868
+ 5.3669437575465112e-06 1.199999960480868
+ 5.3719437575465112e-06 1.199999960480868
+ 5.3769437575465111e-06 1.199999960480868
+ 5.3819437575465111e-06 1.199999960480868
+ 5.386943757546511e-06 1.199999960480868
+ 5.391943757546511e-06 1.199999960480868
+ 5.3969437575465109e-06 1.199999960480868
+ 5.4019437575465109e-06 1.199999960480868
+ 5.4069437575465108e-06 1.199999960480868
+ 5.4119437575465108e-06 1.199999960480868
+ 5.4169437575465107e-06 1.199999960480868
+ 5.4219437575465107e-06 1.199999960480868
+ 5.4269437575465106e-06 1.199999960480868
+ 5.4319437575465106e-06 1.199999960480868
+ 5.4369437575465114e-06 1.199999960480868
+ 5.4419437575465096e-06 1.199999960480868
+ 5.4469437575465096e-06 1.199999960480868
+ 5.4519437575465104e-06 1.199999960480868
+ 5.4569437575465103e-06 1.199999960480868
+ 5.4619437575465103e-06 1.1999999604808671
+ 5.4669437575465102e-06 1.199999960480866
+ 5.4719437575465102e-06 1.1999999604808631
+ 5.4769437575465101e-06 1.1999999604808591
+ 5.4819437575465101e-06 1.19999996048085
+ 5.4869437575465101e-06 1.199999960480834
+ 5.49194375754651e-06 1.1999999604808029
+ 5.49694375754651e-06 1.199999960480743
+ 5.5019437575465099e-06 1.199999960480628
+ 5.5069437575465099e-06 1.199999960480409
+ 5.5119437575465098e-06 1.199999960480002
+ 5.5169437575465098e-06 1.1999999604792779
+ 5.5219437575465097e-06 1.1999999604780101
+ 5.5269437575465097e-06 1.199999960475586
+ 5.5319437575465096e-06 1.1999999604682661
+ 5.5353537568533204e-06 1.1999999604181499
+ 5.5371493642677622e-06 1.1999999601507789
+ 5.5391190956558114e-06 1.199999960154754
+ 5.540729546346381e-06 1.199999960381307
+ 5.5427729560574206e-06 1.1999999604576239
+ 5.5443205177857563e-06 1.199999960526295
+ 5.5448746570029586e-06 1.1999999613655781
+ 5.5453699850582413e-06 1.199999962227515
+ 5.5456456282648374e-06 1.1999999649397239
+ 5.5459466325693327e-06 1.1999999673611561
+ 5.5461761115643719e-06 1.1999999591528601
+ 5.5463940335748243e-06 1.1999999024211381
+ 5.5466053605058891e-06 1.1999998542078381
+ 5.5468512624731456e-06 1.1999997920313079
+ 5.5469522867083511e-06 1.1999994685214579
+ 5.5470101419505639e-06 1.1999989889290821
+ 5.5470580303589203e-06 1.199998605419444
+ 5.5471224696183881e-06 1.1999981056326181
+ 5.5471910034087727e-06 1.1999979701757051
+ 5.5472668532568239e-06 1.199998736827659
+ 5.5472962910159873e-06 1.19999934799271
+ 5.5473203691041341e-06 1.1999998846611919
+ 5.5473370032940694e-06 1.19999987803039
+ 5.5473573895972081e-06 1.200000299409683
+ 5.5473812638365153e-06 1.20000295002531
+ 5.5474061699695133e-06 1.2000078885050891
+ 5.5474310732804229e-06 1.20001073734857
+ 5.5474521569157929e-06 1.200010088726847
+ 5.5474693704034302e-06 1.200007877858958
+ 5.547484190720052e-06 1.2000049055290749
+ 5.5475003020934111e-06 1.200001818577646
+ 5.5475173107631074e-06 1.1999996243661879
+ 5.5475440405993549e-06 1.1999979887835019
+ 5.5475736004137646e-06 1.199997318376105
+ 5.5476013150726532e-06 1.19999708481686
+ 5.5476253772581961e-06 1.1999975677279371
+ 5.5476507157049003e-06 1.1999993208709749
+ 5.5476820350165006e-06 1.200002514421594
+ 5.5477112758530178e-06 1.200005263110276
+ 5.5477353501045458e-06 1.200007050188564
+ 5.5477518431419174e-06 1.20000828368354
+ 5.5477674198739052e-06 1.200009715194625
+ 5.5477823302934763e-06 1.20001174620379
+ 5.5477969903781908e-06 1.2000132731267481
+ 5.5478104690074313e-06 1.200013002736265
+ 5.5478247771217602e-06 1.2000113701227391
+ 5.5478404435953607e-06 1.200008846868966
+ 5.5478666444836164e-06 1.2000032032246359
+ 5.5478915935693003e-06 1.199978432955938
+ 5.5479167547024498e-06 1.199910794984056
+ 5.5479429994554518e-06 1.1998022081935289
+ 5.5479775773189964e-06 1.199562124625144
+ 5.5480054973398101e-06 1.1996396803537981
+ 5.5480221506561839e-06 1.200931565668079
+ 5.5480398293427608e-06 1.204657390931233
+ 5.5480614029615406e-06 1.212400583935582
+ 5.5480785578022286e-06 1.215549288274103
+ 5.5480927561199338e-06 1.2034496103621619
+ 5.5481089843462686e-06 1.159343844174576
+ 5.5481260710976329e-06 1.082862050925657
+ 5.5481437345431081e-06 0.98472344722968186
+ 5.5481650343672528e-06 0.85668688101482449
+ 5.5481855484757066e-06 0.73197347294017867
+ 5.5482002256848278e-06 0.64420543990945522
+ 5.5482114488296591e-06 0.5786103156290141
+ 5.5482241722374586e-06 0.50633887239977471
+ 5.5482373425073954e-06 0.43440886951077862
+ 5.5482498705010466e-06 0.36938883634030067
+ 5.5482704370278556e-06 0.2724734494710328
+ 5.548292974772057e-06 0.18429955769889969
+ 5.548315635603992e-06 0.117191991206112
+ 5.5483427982815287e-06 0.063309660945732024
+ 5.5483598509998131e-06 0.041787199044828909
+ 5.5483770658093258e-06 0.02708838036414642
+ 5.5483969205977613e-06 0.016123105215269481
+ 5.5484182388899423e-06 0.0090155612985490657
+ 5.548442977479887e-06 0.0043981341977888874
+ 5.5484710522997327e-06 0.0017783866324342661
+ 5.5485052907245111e-06 0.00041780959327426213
+ 5.5485473031034698e-06 -0.00010549119450264091
+ 5.5486031295185514e-06 -0.0001904021981012854
+ 5.5486809630108136e-06 -0.00010479627541672869
+ 5.5487705275072978e-06 -2.8436131704129719e-05
+ 5.5488708350899758e-06 4.7011230915765139e-07
+ 5.5490000678530503e-06 4.5181651122635406e-06
+ 5.5491775042822829e-06 1.7421868260481391e-06
+ 5.5493207739088276e-06 3.3970578558930742e-07
+ 5.5494460030034329e-06 2.4075070986190721e-08
+ 5.5495632058007871e-06 1.6259609313760531e-08
+ 5.5496807011418278e-06 4.5732335681471973e-08
+ 5.5498084414014422e-06 6.0617011463077061e-08
+ 5.5499281068874501e-06 6.4360664364710088e-08
+ 5.5500532160491374e-06 6.6298386047283616e-08
+ 5.5501718181611098e-06 6.9204572349216291e-08
+ 5.5502937130360654e-06 7.3637726828668174e-08
+ 5.5504116978801577e-06 8.4456317726185298e-08
+ 5.5505320759935333e-06 1.2613343921487419e-07
+ 5.5506094715359389e-06 3.0435148512683332e-07
+ 5.5506603733158766e-06 5.9194554863010829e-07
+ 5.5507137459888392e-06 6.5392682284843764e-07
+ 5.5507796738004416e-06 2.4618030421310241e-07
+ 5.5508151076816474e-06 -1.304907271597594e-07
+ 5.5508461246901416e-06 -5.2589185069467607e-07
+ 5.5508709504134719e-06 -9.640216448426908e-07
+ 5.5508941850914737e-06 -1.469293753264263e-06
+ 5.5509156746921076e-06 -1.7517076716724949e-06
+ 5.5509447449094357e-06 -1.6241653080420971e-06
+ 5.5509657930518484e-06 -1.7246466903266781e-06
+ 5.5509888025525201e-06 -6.7080532192641002e-07
+ 5.551029152041307e-06 1.0938768956321811e-06
+ 5.5510688662186654e-06 1.4157129072241829e-06
+ 5.5511286294339617e-06 7.3806673341527664e-07
+ 5.5511935845267138e-06 1.8354084712297059e-07
+ 5.5512748557086071e-06 2.9159958010618591e-08
+ 5.5513601107918363e-06 -1.7071827030184181e-08
+ 5.5514616204374614e-06 -5.3921616423020784e-09
+ 5.5515765414953024e-06 4.7241064189004669e-08
+ 5.5517037459610259e-06 7.365011552919304e-08
+ 5.5518726770114748e-06 7.0176139499534869e-08
+ 5.5521196413802722e-06 6.1762210160991597e-08
+ 5.5524325497581951e-06 6.0751497461780091e-08
+ 5.552788378641843e-06 6.1738191409931995e-08
+ 5.5532245662153708e-06 6.2029627478453698e-08
+ 5.5537508297882136e-06 6.2058070751313448e-08
+ 5.5543649013212247e-06 6.15848984280507e-08
+ 5.5547606233025413e-06 6.0291681608432133e-08
+ 5.5551022931645431e-06 6.3049618687083616e-08
+ 5.5555341129167231e-06 6.2220251362035085e-08
+ 5.5559991551152221e-06 6.1727246182226671e-08
+ 5.5565489927551374e-06 6.1910502217728612e-08
+ 5.557140823759255e-06 6.1922155467374791e-08
+ 5.5579620982798058e-06 6.1919135269014289e-08
+ 5.5591163068073244e-06 6.1921761352011617e-08
+ 5.5611219641567346e-06 6.1921388431241633e-08
+ 5.5641662908042259e-06 6.1921012142657679e-08
+ 5.5691662908042259e-06 6.1920982459367332e-08
+ 5.5741662908042258e-06 6.1920995181874488e-08
+ 5.5791662908042258e-06 6.1920997431613505e-08
+ 5.5841662908042258e-06 6.1920998009578111e-08
+ 5.5891662908042257e-06 6.1920998058626361e-08
+ 5.5941662908042257e-06 6.1920998109345516e-08
+ 5.5991662908042256e-06 6.1920997875106112e-08
+ 5.6041662908042264e-06 6.1920997952121762e-08
+ 5.6091662908042264e-06 6.1920998307808631e-08
+ 5.6141662908042246e-06 6.1920998083837728e-08
+ 5.6191662908042254e-06 6.1920998196063148e-08
+ 5.6241662908042254e-06 6.1920998172450318e-08
+ 5.6291662908042253e-06 6.1920998287234492e-08
+ 5.6341662908042253e-06 6.1920998078333681e-08
+ 5.6391662908042252e-06 6.1920998141135073e-08
+ 5.6441662908042252e-06 6.1920997946483871e-08
+ 5.6491662908042251e-06 6.1920998202304921e-08
+ 5.6541662908042251e-06 6.1920998082448065e-08
+ 5.659166290804225e-06 6.1920998099847762e-08
+ 5.664166290804225e-06 6.192099815106848e-08
+ 5.6691662908042249e-06 6.1920998205966499e-08
+ 5.6741662908042249e-06 6.1920998076647252e-08
+ 5.6791662908042248e-06 6.1920998073514289e-08
+ 5.6841662908042248e-06 6.1920998157103153e-08
+ 5.6891662908042247e-06 6.19209982191012e-08
+ 5.6941662908042247e-06 6.1920998232077891e-08
+ 5.6991662908042247e-06 6.1920998081544373e-08
+ 5.7041662908042246e-06 6.192099806815085e-08
+ 5.7091662908042254e-06 6.1920998199813095e-08
+ 5.7141662908042254e-06 6.1920997973573745e-08
+ 5.7191662908042236e-06 6.1920998305366225e-08
+ 5.7241662908042244e-06 6.1920998061336165e-08
+ 5.7291662908042244e-06 6.1920998117517055e-08
+ 5.7341662908042243e-06 6.1920998173264436e-08
+ 5.7391662908042243e-06 6.1920998278341957e-08
+ 5.7441662908042242e-06 6.1920998342653674e-08
+ 5.7491662908042242e-06 6.1920998104908692e-08
+ 5.7541662908042241e-06 6.1920998209556515e-08
+ 5.7591662908042241e-06 6.1920997974745483e-08
+ 5.764166290804224e-06 6.1920998003723698e-08
+ 5.769166290804224e-06 6.192099806783623e-08
+ 5.7741662908042239e-06 6.1920998171311244e-08
+ 5.7791662908042239e-06 6.1920998183283327e-08
+ 5.7841662908042238e-06 6.1920998306496088e-08
+ 5.7891662908042238e-06 6.192099804242683e-08
+ 5.7941662908042237e-06 6.1920998370200549e-08
+ 5.7991662908042237e-06 6.1920997964024388e-08
+ 5.8041662908042236e-06 6.1920998259527026e-08
+ 5.8091662908042236e-06 6.1920998252279282e-08
+ 5.8141662908042244e-06 6.192099827135015e-08
+ 5.8191662908042243e-06 6.1920998238232141e-08
+ 5.8241662908042226e-06 6.1920998095494648e-08
+ 5.8291662908042234e-06 6.1920998029867012e-08
+ 5.8341662908042234e-06 6.1920998176962621e-08
+ 5.8391662908042233e-06 6.1920998141877418e-08
+ 5.8441662908042233e-06 6.1920997877696312e-08
+ 5.8491662908042232e-06 6.1920997917761434e-08
+ 5.8541662908042232e-06 6.192099767839703e-08
+ 5.8591662908042231e-06 6.1920997330462087e-08
+ 5.8641662908042231e-06 6.1920993474298551e-08
+ 5.8662645173507614e-06 6.1920907197630279e-08
+ 5.8680838156348021e-06 6.1920905330272998e-08
+ 5.8700031732559862e-06 6.1921195195097319e-08
+ 5.8715275170847526e-06 6.1921064510844561e-08
+ 5.8732024592907573e-06 6.1920799481442768e-08
+ 5.8742325203171942e-06 6.192126766370437e-08
+ 5.8746118908972088e-06 6.1921821526578244e-08
+ 5.8751657914471862e-06 6.192091828468724e-08
+ 5.875473880396026e-06 6.1925172427474138e-08
+ 5.875719195854623e-06 6.1917938495667546e-08
+ 5.8759196261229102e-06 6.1828403098943714e-08
+ 5.8761281965542557e-06 6.1856143613316451e-08
+ 5.8763713798185902e-06 6.1982669455126205e-08
+ 5.8765292513472368e-06 6.1370539577303957e-08
+ 5.8765964571631004e-06 5.7464427238175909e-08
+ 5.876650712716633e-06 5.5533297336453263e-08
+ 5.8766943139064582e-06 5.9479508097327787e-08
+ 5.8767588640523221e-06 9.1185441629214802e-08
+ 5.8768247149073263e-06 1.3065742939523539e-07
+ 5.8768898282731846e-06 1.719476354981828e-07
+ 5.8769192874172109e-06 3.292010904143098e-07
+ 5.8769399273860421e-06 6.4725404165199712e-07
+ 5.8769616009583554e-06 7.8552103071910745e-07
+ 5.8769890384829249e-06 2.7367307336589729e-07
+ 5.8770122762176297e-06 -7.4878609368763001e-07
+ 5.8770332754100651e-06 -2.6168966074823289e-06
+ 5.8770521758912827e-06 -4.1734089393757972e-06
+ 5.8770673430630233e-06 -4.9845367460491478e-06
+ 5.8770817559986256e-06 -4.7271083396753511e-06
+ 5.8770918308200306e-06 -2.588005661273034e-06
+ 5.8771044034433379e-06 -6.7449788404963614e-07
+ 5.8771209227015503e-06 -4.8805935052107674e-07
+ 5.8771396997565632e-06 -1.564187698470288e-06
+ 5.877164010868905e-06 -2.6231414960476902e-06
+ 5.8771889395763924e-06 -3.2829627632710462e-06
+ 5.8772148765533111e-06 -3.3170888365534328e-06
+ 5.8772385858668611e-06 -1.982149741835515e-06
+ 5.8772615586399657e-06 -5.2438999671433013e-07
+ 5.8772885174903044e-06 -5.5502161227594028e-07
+ 5.8773189937384757e-06 -1.8876512970470359e-06
+ 5.8773472219067061e-06 -3.0480945878072131e-06
+ 5.8773691580072277e-06 -3.7117165236675228e-06
+ 5.8773966106607391e-06 -3.6498688050756301e-06
+ 5.8774173271766942e-06 -7.5464940103972108e-07
+ 5.8774349202878712e-06 2.2635159226876171e-06
+ 5.8774520933376246e-06 -6.5386536760036006e-06
+ 5.8774698949133568e-06 -5.3920031077104627e-05
+ 5.8774923987301913e-06 -0.0001471267850769026
+ 5.8775134708859702e-06 -0.00018805606685167589
+ 5.8775264241728762e-06 -0.00013687079861501311
+ 5.8775399293320144e-06 -1.928936437159947e-05
+ 5.8775553280882651e-06 0.00011361644219738899
+ 5.8775714657806743e-06 0.00018379845790087899
+ 5.8775947928539049e-06 0.00018522589008000771
+ 5.8776177923677144e-06 0.00014699293304259789
+ 5.8776494887538392e-06 9.5457600614970483e-05
+ 5.8776801852328029e-06 6.6866014890299666e-05
+ 5.8777171285089651e-06 5.6830808371791668e-05
+ 5.8777565897575234e-06 6.2891307587727822e-05
+ 5.8778079472572346e-06 8.5481885756710237e-05
+ 5.8778723012884226e-06 -0.0001807517492302591
+ 5.8779204243955013e-06 -0.001891734788079221
+ 5.8779668602943134e-06 -0.0064984870790639523
+ 5.8779815033258161e-06 -0.0082039546353609941
+ 5.8779959893815664e-06 -0.0082224898759157544
+ 5.8780051940107068e-06 -0.0060649649432170582
+ 5.8780151792056702e-06 -7.7732876980851986e-07
+ 5.8780257166721384e-06 0.012854961755060301
+ 5.8780387762957097e-06 0.041170871942027447
+ 5.8780513000412086e-06 0.082633579122778453
+ 5.8780668894185293e-06 0.15219760212297659
+ 5.8780784486524884e-06 0.21378161207829399
+ 5.878091770700454e-06 0.29091441891581032
+ 5.8781062372080509e-06 0.37772495793275229
+ 5.8781234017831821e-06 0.48044760555604982
+ 5.8781455177221087e-06 0.60767059511551691
+ 5.8781748845517232e-06 0.76133013563372598
+ 5.8782114358127433e-06 0.91856627304477401
+ 5.8782530987170786e-06 1.045323017373746
+ 5.8783042772939927e-06 1.135758041651769
+ 5.878346971917492e-06 1.172896373456233
+ 5.878399944066466e-06 1.19327807555202
+ 5.8784481350833143e-06 1.199527186961066
+ 5.8785146543360761e-06 1.201552992007036
+ 5.8785905448901541e-06 1.2012647994812311
+ 5.8787139263643784e-06 1.200466371400557
+ 5.878846547699943e-06 1.200068806261305
+ 5.8789758270108306e-06 1.199976366019692
+ 5.8790986617721352e-06 1.199978498324191
+ 5.8792180930578471e-06 1.1999912831380339
+ 5.8793457732728773e-06 1.1999983304989339
+ 5.8794644929944808e-06 1.200000169169275
+ 5.8795884401166771e-06 1.2000003133278521
+ 5.8797061957586683e-06 1.200000127568877
+ 5.8798274994248047e-06 1.200000003227542
+ 5.8799451460384039e-06 1.199999961811913
+ 5.8800652885594628e-06 1.1999999552772009
+ 5.8801832401499954e-06 1.1999999579352749
+ 5.8803028783202012e-06 1.199999962170049
+ 5.8803718637676454e-06 1.199999975584888
+ 5.8804190339222473e-06 1.199999995042524
+ 5.8804677212920442e-06 1.1999999887770849
+ 5.8805330772721207e-06 1.1999999400172801
+ 5.8805862245823412e-06 1.199999911964182
+ 5.8806145974953283e-06 1.1999998921865269
+ 5.8806393032886646e-06 1.199999854590996
+ 5.8806617702234569e-06 1.199999791675185
+ 5.8806844140520128e-06 1.199999707835542
+ 5.880712658010102e-06 1.19999965546933
+ 5.8807339031947754e-06 1.1999998862241721
+ 5.8807586433999441e-06 1.2000001845818029
+ 5.8807938237841778e-06 1.2000003229931031
+ 5.8808468411741047e-06 1.2000001972947669
+ 5.880898404717312e-06 1.2000000156341351
+ 5.8809714314157597e-06 1.199999886359894
+ 5.8810536321919578e-06 1.199999871077079
+ 5.881152359665038e-06 1.199999915406557
+ 5.8812469361125577e-06 1.1999999551389839
+ 5.8813630689844789e-06 1.199999972978089
+ 5.8815009396881258e-06 1.199999970281286
+ 5.8817191394034774e-06 1.1999999619691979
+ 5.8821195623585596e-06 1.199999958748015
+ 5.8824944778112519e-06 1.199999959793812
+ 5.8830559393628003e-06 1.19999996051397
+ 5.8836499341493776e-06 1.1999999605483549
+ 5.8841935899149894e-06 1.19999996043803
+ 5.8847208669227914e-06 1.1999999604824509
+ 5.8850953492852076e-06 1.1999999606068159
+ 5.885516795999287e-06 1.199999960438167
+ 5.885997988055495e-06 1.1999999604563769
+ 5.8865991462926564e-06 1.1999999604788369
+ 5.8873277808813513e-06 1.1999999604827301
+ 5.8884254557630792e-06 1.199999960481698
+ 5.890076461938708e-06 1.199999960480941
+ 5.8928964432108814e-06 1.1999999604809379
+ 5.8974777751338552e-06 1.1999999604809211
+ 5.9024777751338551e-06 1.199999960480868
+ 5.9074777751338551e-06 1.199999960480858
+ 5.912477775133855e-06 1.1999999604808631
+ 5.917477775133855e-06 1.199999960480866
+ 5.9224777751338549e-06 1.199999960480868
+ 5.9274777751338549e-06 1.199999960480868
+ 5.9324777751338548e-06 1.199999960480868
+ 5.9374777751338548e-06 1.1999999604808691
+ 5.9424777751338547e-06 1.199999960480868
+ 5.9474777751338547e-06 1.199999960480868
+ 5.9524777751338546e-06 1.199999960480868
+ 5.9574777751338546e-06 1.199999960480868
+ 5.9624777751338554e-06 1.199999960480868
+ 5.9674777751338536e-06 1.199999960480868
+ 5.9724777751338536e-06 1.199999960480868
+ 5.9774777751338544e-06 1.199999960480868
+ 5.9824777751338543e-06 1.199999960480868
+ 5.9874777751338543e-06 1.199999960480868
+ 5.9924777751338543e-06 1.199999960480868
+ 5.9974777751338542e-06 1.199999960480868
+ 6.0024777751338542e-06 1.199999960480868
+ 6.0074777751338541e-06 1.199999960480868
+ 6.0124777751338541e-06 1.199999960480868
+ 6.017477775133854e-06 1.199999960480868
+ 6.022477775133854e-06 1.199999960480868
+ 6.0274777751338539e-06 1.199999960480868
+ 6.0324777751338539e-06 1.199999960480868
+ 6.0374777751338538e-06 1.199999960480868
+ 6.0424777751338538e-06 1.199999960480868
+ 6.0474777751338537e-06 1.199999960480868
+ 6.0524777751338537e-06 1.199999960480868
+ 6.0574777751338536e-06 1.199999960480868
+ 6.0624777751338536e-06 1.199999960480868
+ 6.0674777751338544e-06 1.199999960480868
+ 6.0724777751338526e-06 1.199999960480868
+ 6.0774777751338526e-06 1.199999960480868
+ 6.0824777751338534e-06 1.199999960480868
+ 6.0874777751338533e-06 1.199999960480868
+ 6.0924777751338533e-06 1.199999960480868
+ 6.0974777751338532e-06 1.199999960480868
+ 6.1024777751338532e-06 1.199999960480868
+ 6.1074777751338532e-06 1.199999960480868
+ 6.1124777751338531e-06 1.199999960480868
+ 6.1174777751338531e-06 1.199999960480868
+ 6.122477775133853e-06 1.199999960480866
+ 6.127477775133853e-06 1.1999999604808651
+ 6.1324777751338529e-06 1.199999960480862
+ 6.1374777751338529e-06 1.1999999604808571
+ 6.1424777751338528e-06 1.199999960480846
+ 6.1474777751338528e-06 1.199999960480828
+ 6.1524777751338527e-06 1.1999999604807901
+ 6.1574777751338527e-06 1.199999960480719
+ 6.1624777751338526e-06 1.199999960480582
+ 6.1674777751338526e-06 1.199999960480322
+ 6.1724777751338534e-06 1.199999960479843
+ 6.1774777751338516e-06 1.1999999604790019
+ 6.1824777751338516e-06 1.1999999604775149
+ 6.1874777751338524e-06 1.199999960474468
+ 6.1924777751338523e-06 1.1999999604625351
+ 6.1949455883520629e-06 1.199999960373294
+ 6.1966387347409592e-06 1.1999999601022631
+ 6.1987609574394953e-06 1.1999999602051881
+ 6.2002337590384008e-06 1.1999999604431899
+ 6.202039729070599e-06 1.199999960411569
+ 6.2032538241535041e-06 1.19999996053555
+ 6.2037900395043376e-06 1.1999999610625971
+ 6.2044375591976651e-06 1.199999961566935
+ 6.2047660027006974e-06 1.1999999641676049
+ 6.2050640122142701e-06 1.199999967039439
+ 6.2052988790544621e-06 1.199999965082317
+ 6.2055060639899848e-06 1.199999922020595
+ 6.2057213892126164e-06 1.1999998673732
+ 6.2059639072883851e-06 1.1999998245560051
+ 6.206089387283609e-06 1.1999996447005059
+ 6.2061540991985314e-06 1.1999992920126561
+ 6.2062121363734e-06 1.1999988404923621
+ 6.2062576741159162e-06 1.199998522024033
+ 6.206325058767108e-06 1.199998011114439
+ 6.2063951878619814e-06 1.199998088083795
+ 6.2064759704479734e-06 1.1999991422236911
+ 6.2065009625771713e-06 1.1999996917053251
+ 6.2065208973880636e-06 1.1999998016416451
+ 6.2065395828379854e-06 1.200000104297456
+ 6.2065641871382534e-06 1.2000026952627789
+ 6.2065911696180228e-06 1.2000078955786559
+ 6.2066157182639724e-06 1.200010748872965
+ 6.2066365788270636e-06 1.2000101504059
+ 6.2066538842733217e-06 1.200007925727163
+ 6.2066684066943504e-06 1.2000049907898951
+ 6.2066842897970287e-06 1.2000019276082641
+ 6.2067017212869943e-06 1.199999665693354
+ 6.2067283668242859e-06 1.1999980191378541
+ 6.2067581552842104e-06 1.1999973219855
+ 6.2067860766814663e-06 1.1999970826894419
+ 6.206810234366341e-06 1.1999975914870979
+ 6.2068356337504818e-06 1.1999993857849049
+ 6.2068660787711072e-06 1.200002512907022
+ 6.2068961881527412e-06 1.2000053240397981
+ 6.2069205116262684e-06 1.200007112009849
+ 6.2069370586806598e-06 1.2000083606473331
+ 6.2069526859922443e-06 1.200009836079726
+ 6.2069673537896698e-06 1.2000118805875111
+ 6.2069825006660496e-06 1.200013315071063
+ 6.2069951955705593e-06 1.2000129477837269
+ 6.2070090793020583e-06 1.2000113263891059
+ 6.2070259294842576e-06 1.2000086059487181
+ 6.2070545114753736e-06 1.200001404590612
+ 6.2070818005997191e-06 1.1999662800715629
+ 6.2071066884494593e-06 1.199890724088887
+ 6.2071332531470208e-06 1.199771699394045
+ 6.2071715943126794e-06 1.199464986610401
+ 6.2071935266773554e-06 1.199784399410049
+ 6.2072095770699776e-06 1.201411180486353
+ 6.2072289404069146e-06 1.206174400826499
+ 6.2072502717118393e-06 1.2141132538413979
+ 6.2072656829533319e-06 1.214847605759273
+ 6.2072795111900672e-06 1.19895417154816
+ 6.2072977542835502e-06 1.1416210636933739
+ 6.2073167999435908e-06 1.048857396291625
+ 6.2073349375083746e-06 0.94406510783295761
+ 6.2073563876074153e-06 0.81386380966297955
+ 6.2073782483822989e-06 0.68184861049242296
+ 6.2073925644211564e-06 0.59746299868099195
+ 6.207404395265201e-06 0.52961440516317249
+ 6.2074184308317917e-06 0.45200795398919402
+ 6.2074316105345034e-06 0.38271822750663681
+ 6.2074467890792648e-06 0.30852480887442668
+ 6.2074670917404233e-06 0.22161790503636369
+ 6.2074909274882146e-06 0.1412476963976729
+ 6.207513312079895e-06 0.087398028108219006
+ 6.207529191048363e-06 0.060560348952395877
+ 6.2075450718102819e-06 0.041306769526358332
+ 6.2075630554973591e-06 0.026329068405699201
+ 6.2075843709951107e-06 0.01504189952983543
+ 6.2076059906527274e-06 0.0082943632969037506
+ 6.2076318523916566e-06 0.0038623068323710439
+ 6.2076601006066844e-06 0.0015121619652364319
+ 6.2076956797693786e-06 0.00028945346355913932
+ 6.207738538419713e-06 -0.00013753499860438839
+ 6.2077973162461894e-06 -0.0001829640867427631
+ 6.2078789496751946e-06 -8.9805168162150056e-05
+ 6.2079673797114518e-06 -2.2328637148941819e-05
+ 6.2080729395105704e-06 2.2608424579731741e-06
+ 6.208204867931024e-06 4.2353487471250786e-06
+ 6.2083664197761744e-06 1.4374050414951551e-06
+ 6.2085041187940831e-06 2.4224980304629958e-07
+ 6.208628448441715e-06 6.5356684738956497e-09
+ 6.2087469495216989e-06 1.8338807876711768e-08
+ 6.2088655572124988e-06 4.8768622057827313e-08
+ 6.2089939538509993e-06 6.1698971676543614e-08
+ 6.209113942618907e-06 6.4524271511146472e-08
+ 6.209239026696088e-06 6.6266242085527018e-08
+ 6.2093576045309526e-06 6.9198464894736755e-08
+ 6.2094793918863191e-06 7.3684489838758031e-08
+ 6.2095973535900777e-06 8.4613758213560711e-08
+ 6.209717688869325e-06 1.2688267827216821e-07
+ 6.2097945611042794e-06 3.0698308566933341e-07
+ 6.2098453912541203e-06 5.9387091300388035e-07
+ 6.2098988901618397e-06 6.522032954545584e-07
+ 6.2099647584821363e-06 2.4202917197953258e-07
+ 6.2100003347002654e-06 -1.360305321163323e-07
+ 6.2100311040059801e-06 -5.3106037092561739e-07
+ 6.2100558187161499e-06 -9.7008914482401275e-07
+ 6.2100790032256379e-06 -1.4745393087203099e-06
+ 6.2101004777784749e-06 -1.752214548854032e-06
+ 6.2101294654471814e-06 -1.6241580345625111e-06
+ 6.2101503964403584e-06 -1.725599986394577e-06
+ 6.2101733962737957e-06 -6.6966655575096717e-07
+ 6.2102140006363439e-06 1.100027731819959e-06
+ 6.2102536216040572e-06 1.415425220876868e-06
+ 6.2103136200530051e-06 7.3408687748253448e-07
+ 6.2103784660741564e-06 1.8253716997748679e-07
+ 6.2104594707367177e-06 2.9344891436096972e-08
+ 6.2105447139972364e-06 -1.7032677196811832e-08
+ 6.2106460847607662e-06 -5.2899142206953017e-09
+ 6.2107611071836896e-06 4.7333461634268927e-08
+ 6.2108882114181732e-06 7.36433306310115e-08
+ 6.2110572134867206e-06 7.0160902499090107e-08
+ 6.2113039202757177e-06 6.1762900469923771e-08
+ 6.2116168913136101e-06 6.0752186961759695e-08
+ 6.2119724269727044e-06 6.173785978008591e-08
+ 6.2124085919795787e-06 6.2029588931588879e-08
+ 6.212934427142088e-06 6.2057986099617945e-08
+ 6.2135492460630642e-06 6.1586449081121491e-08
+ 6.2139450649943954e-06 6.0291108636566742e-08
+ 6.21428696594418e-06 6.3047898865040137e-08
+ 6.2147190526866177e-06 6.222156348923763e-08
+ 6.2151838472218487e-06 6.1727106284089604e-08
+ 6.2157334626279996e-06 6.1910410283129016e-08
+ 6.2163253551160696e-06 6.1922200637776344e-08
+ 6.2171465054595253e-06 6.1919141936483844e-08
+ 6.21830093594403e-06 6.1921758451531796e-08
+ 6.2203061514673677e-06 6.1921388369884869e-08
+ 6.2233505460082488e-06 6.1921012516657401e-08
+ 6.2283505460082487e-06 6.1920982429149987e-08
+ 6.2333505460082487e-06 6.1920994920568106e-08
+ 6.2383505460082486e-06 6.1920997512186561e-08
+ 6.2433505460082486e-06 6.1920998078109231e-08
+ 6.2483505460082494e-06 6.1920997897195328e-08
+ 6.2533505460082494e-06 6.1920998214734547e-08
+ 6.2583505460082476e-06 6.1920998300985741e-08
+ 6.2633505460082484e-06 6.192099807810665e-08
+ 6.2683505460082484e-06 6.1920998166971233e-08
+ 6.2733505460082483e-06 6.1920998004907823e-08
+ 6.2783505460082483e-06 6.1920997989088993e-08
+ 6.2833505460082482e-06 6.1920998271979866e-08
+ 6.2883505460082482e-06 6.1920998431542e-08
+ 6.2933505460082481e-06 6.1920997888598592e-08
+ 6.2983505460082481e-06 6.1920998054724134e-08
+ 6.303350546008248e-06 6.1920998002536978e-08
+ 6.308350546008248e-06 6.192099811600309e-08
+ 6.3133505460082479e-06 6.1920998130152841e-08
+ 6.3183505460082479e-06 6.1920998216182629e-08
+ 6.3233505460082478e-06 6.1920998054032743e-08
+ 6.3283505460082478e-06 6.1920998065887763e-08
+ 6.3333505460082477e-06 6.1920998147986868e-08
+ 6.3383505460082477e-06 6.1920998156456099e-08
+ 6.3433505460082476e-06 6.1920998004339464e-08
+ 6.3483505460082476e-06 6.1920998049531676e-08
+ 6.3533505460082484e-06 6.1920998096227226e-08
+ 6.3583505460082467e-06 6.192099813271898e-08
+ 6.3633505460082466e-06 6.1920998253549885e-08
+ 6.3683505460082474e-06 6.1920997996742108e-08
+ 6.3733505460082474e-06 6.1920998289401295e-08
+ 6.3783505460082473e-06 6.1920998131677421e-08
+ 6.3833505460082473e-06 6.1920998169322702e-08
+ 6.3883505460082472e-06 6.1920998261066084e-08
+ 6.3933505460082472e-06 6.1920998276371983e-08
+ 6.3983505460082471e-06 6.1920998108339321e-08
+ 6.4033505460082471e-06 6.1920998134920101e-08
+ 6.408350546008247e-06 6.1920998217557192e-08
+ 6.413350546008247e-06 6.1920998258237339e-08
+ 6.4183505460082469e-06 6.1920998075684732e-08
+ 6.4233505460082469e-06 6.1920998182725807e-08
+ 6.4283505460082468e-06 6.1920998196422621e-08
+ 6.4333505460082468e-06 6.1920998226822025e-08
+ 6.4383505460082467e-06 6.1920998015231699e-08
+ 6.4433505460082467e-06 6.1920998082608379e-08
+ 6.4483505460082466e-06 6.1920998189120072e-08
+ 6.4533505460082466e-06 6.1920997915486224e-08
+ 6.4583505460082474e-06 6.1920998293404267e-08
+ 6.4633505460082456e-06 6.1920998094186684e-08
+ 6.4683505460082456e-06 6.1920997882783301e-08
+ 6.4733505460082464e-06 6.1920998236980372e-08
+ 6.4783505460082463e-06 6.19209983765761e-08
+ 6.4833505460082463e-06 6.192099814059775e-08
+ 6.4883505460082463e-06 6.1920998210819706e-08
+ 6.4933505460082462e-06 6.1920998240170867e-08
+ 6.4983505460082462e-06 6.1920998310035534e-08
+ 6.5033505460082461e-06 6.1920997867393096e-08
+ 6.5083505460082461e-06 6.1920998057836159e-08
+ 6.513350546008246e-06 6.1920997899021584e-08
+ 6.518350546008246e-06 6.1920997369253761e-08
+ 6.5233505460082459e-06 6.1920993639759025e-08
+ 6.5254487529599552e-06 6.1920906888757478e-08
+ 6.527268070937849e-06 6.1920905685848469e-08
+ 6.5291873802679382e-06 6.1921194808391507e-08
+ 6.5307117507565923e-06 6.192106437577805e-08
+ 6.5323866985307256e-06 6.1920799854023313e-08
+ 6.5334167432006353e-06 6.1921267118383063e-08
+ 6.533796100923868e-06 6.1921822702432002e-08
+ 6.534349981751808e-06 6.1920917826249345e-08
+ 6.5346580666578816e-06 6.1925172181275806e-08
+ 6.5349033810952778e-06 6.1917937458345657e-08
+ 6.5351038139234028e-06 6.1828388434384986e-08
+ 6.5353123842490031e-06 6.1856164580651495e-08
+ 6.5355555630354318e-06 6.1982660732852447e-08
+ 6.5357134137177387e-06 6.137035960569115e-08
+ 6.5357806148323246e-06 5.7464353701046191e-08
+ 6.535834871373811e-06 5.5533748458089432e-08
+ 6.5358784720702523e-06 5.947917563310835e-08
+ 6.535943022311437e-06 9.1184342188892001e-08
+ 6.536008873418536e-06 1.306566791969606e-07
+ 6.5360739880320111e-06 1.719470818037944e-07
+ 6.5361034474995676e-06 3.2920450762888528e-07
+ 6.5361240873694671e-06 6.4726128567406161e-07
+ 6.5361457611294286e-06 7.8551659792347883e-07
+ 6.5361731988264879e-06 2.7365520037905379e-07
+ 6.5361964362966881e-06 -7.4882509679416191e-07
+ 6.5362174354675021e-06 -2.6169516934840841e-06
+ 6.536236336140122e-06 -4.1734473868160979e-06
+ 6.5362515031642968e-06 -4.9845792957188409e-06
+ 6.5362659164422469e-06 -4.726973432353593e-06
+ 6.5362759914088004e-06 -2.5878314597023528e-06
+ 6.5362885640996636e-06 -6.7443259468891098e-07
+ 6.5363050840751968e-06 -4.8812686590488294e-07
+ 6.536323861162259e-06 -1.5642826407380801e-06
+ 6.5363481726787388e-06 -2.623208672635665e-06
+ 6.5363731015347297e-06 -3.283014527087579e-06
+ 6.536399038685391e-06 -3.317023536001232e-06
+ 6.5364227467557829e-06 -1.982018948756812e-06
+ 6.5364457197875943e-06 -5.2432214638014529e-07
+ 6.5364726794006124e-06 -5.5508920519714322e-07
+ 6.5365031547923564e-06 -1.8877351175550369e-06
+ 6.5365313837897431e-06 -3.048190457813683e-06
+ 6.5365533196831448e-06 -3.7117783044945828e-06
+ 6.5365807712350864e-06 -3.649759085720473e-06
+ 6.5366014858751583e-06 -7.5470623681000058e-07
+ 6.536619078276526e-06 2.263540961503876e-06
+ 6.5366362512787811e-06 -6.5362364779602604e-06
+ 6.5366540528091886e-06 -5.3913636970358149e-05
+ 6.5366765569785396e-06 -0.00014712140122930941
+ 6.5366976278502258e-06 -0.0001880586162826358
+ 6.5367105812519904e-06 -0.0001368860927373769
+ 6.5367240859838462e-06 -1.9314977691143029e-05
+ 6.5367394839579619e-06 0.00011359359887814251
+ 6.5367556212743968e-06 0.00018379132296246679
+ 6.536778945901747e-06 0.0001852330961150856
+ 6.5368019457341086e-06 0.0001470032383678207
+ 6.5368336405325142e-06 9.5467606681900585e-05
+ 6.5368643367611669e-06 6.6870606382218853e-05
+ 6.5369012786335762e-06 5.6831052224749548e-05
+ 6.5369407385523784e-06 6.2887997624511073e-05
+ 6.536992092727287e-06 8.5476853999075903e-05
+ 6.5370564431337704e-06 -0.00018050610599596741
+ 6.5371045712258624e-06 -0.0018909134535578841
+ 6.5371510029975954e-06 -0.0064963346547953016
+ 6.5371656525931799e-06 -0.0082030706225810351
+ 6.5371801376376397e-06 -0.0082239998237084964
+ 6.5371893404159912e-06 -0.0060705473807631596
+ 6.5371993277386234e-06 -1.0876155060637919e-05
+ 6.5372098659764634e-06 0.01283814129266553
+ 6.537222926181859e-06 0.041144322323395967
+ 6.537235447779041e-06 0.08258796057596457
+ 6.5372510581330521e-06 0.15224128878126489
+ 6.5372626243563756e-06 0.21386750481823161
+ 6.5372759514845788e-06 0.29103439799212261
+ 6.5372904212304607e-06 0.37786572781765648
+ 6.5373075909474706e-06 0.48061589451435011
+ 6.5373297144266192e-06 0.6078709434885462
+ 6.5373590923309846e-06 0.76155894093850007
+ 6.5373956501773428e-06 0.91876576294505119
+ 6.5374373250054092e-06 1.045480653826369
+ 6.5374884111066483e-06 1.1357177107132159
+ 6.5375310828983153e-06 1.1728555791998481
+ 6.5375840523903332e-06 1.1932583991616741
+ 6.5376322358297154e-06 1.199518010687795
+ 6.5376987562930957e-06 1.2015511790750071
+ 6.537774624232551e-06 1.201265359346041
+ 6.5378979585897782e-06 1.2004673519382181
+ 6.5380305622416276e-06 1.2000692255250589
+ 6.5381598416079874e-06 1.199976451649956
+ 6.5382826821796186e-06 1.199978490618349
+ 6.5384021176438288e-06 1.199991267587748
+ 6.5385298041336138e-06 1.199998323118288
+ 6.5386485251296241e-06 1.200000167071317
+ 6.5387724744302782e-06 1.2000003132306001
+ 6.5388902296269969e-06 1.200000127789042
+ 6.5390115339766906e-06 1.2000000033645379
+ 6.5391291800626696e-06 1.199999961858556
+ 6.5392493230009176e-06 1.199999955283539
+ 6.5393672742996389e-06 1.1999999579317151
+ 6.5394869127299982e-06 1.1999999621627659
+ 6.5395559619666703e-06 1.199999975555494
+ 6.5396031426684274e-06 1.1999999950264459
+ 6.5396518189439417e-06 1.19999998881381
+ 6.5397171887517997e-06 1.1999999400617409
+ 6.5397704459862266e-06 1.199999911966509
+ 6.539798841462203e-06 1.199999892125432
+ 6.5398235277452712e-06 1.199999854422146
+ 6.539845979592683e-06 1.19999979144503
+ 6.5398686179542256e-06 1.1999997076008071
+ 6.5398968498816899e-06 1.199999655533182
+ 6.5399180645457706e-06 1.1999998864004939
+ 6.5399428017082097e-06 1.2000001847006561
+ 6.5399780229516103e-06 1.200000323042629
+ 6.540031010568424e-06 1.2000001972488961
+ 6.5400826096652421e-06 1.200000015503929
+ 6.5401556245201388e-06 1.1999998863328041
+ 6.5402377868476328e-06 1.1999998710855919
+ 6.5403365760179279e-06 1.199999915436734
+ 6.5404311142088369e-06 1.1999999551454501
+ 6.5405473011608336e-06 1.199999972982337
+ 6.540685139754616e-06 1.1999999702791391
+ 6.5409034435712223e-06 1.1999999619654691
+ 6.5413038755673132e-06 1.199999958748144
+ 6.5416788471749246e-06 1.1999999597942661
+ 6.5422403282911189e-06 1.1999999605140499
+ 6.5428344099162246e-06 1.199999960548326
+ 6.543378043961351e-06 1.199999960437977
+ 6.5439056377666742e-06 1.199999960482605
+ 6.5442803234005357e-06 1.1999999606066809
+ 6.5447019269784516e-06 1.199999960438106
+ 6.5451832907443672e-06 1.199999960456408
+ 6.5457845603599e-06 1.1999999604788569
+ 6.5465137109192026e-06 1.1999999604827329
+ 6.5476121785712057e-06 1.1999999604816951
+ 6.549265054229417e-06 1.1999999604809399
+ 6.5520876582960967e-06 1.1999999604809379
+ 6.5566752652262643e-06 1.1999999604809199
+ 6.5616752652262643e-06 1.199999960480868
+ 6.5666752652262642e-06 1.199999960480858
+ 6.5716752652262642e-06 1.1999999604808631
+ 6.5766752652262641e-06 1.199999960480866
+ 6.5816752652262641e-06 1.199999960480868
+ 6.586675265226264e-06 1.199999960480868
+ 6.591675265226264e-06 1.199999960480868
+ 6.5966752652262639e-06 1.199999960480868
+ 6.6016752652262639e-06 1.199999960480868
+ 6.6066752652262638e-06 1.199999960480868
+ 6.6116752652262638e-06 1.199999960480868
+ 6.6166752652262637e-06 1.199999960480868
+ 6.6216752652262637e-06 1.199999960480868
+ 6.6266752652262636e-06 1.199999960480868
+ 6.6316752652262636e-06 1.199999960480868
+ 6.6366752652262644e-06 1.199999960480868
+ 6.6416752652262627e-06 1.199999960480868
+ 6.6466752652262626e-06 1.199999960480868
+ 6.6516752652262634e-06 1.199999960480868
+ 6.6566752652262634e-06 1.199999960480868
+ 6.6616752652262633e-06 1.199999960480868
+ 6.6666752652262633e-06 1.199999960480868
+ 6.6716752652262632e-06 1.199999960480868
+ 6.6766752652262632e-06 1.199999960480868
+ 6.6816752652262631e-06 1.199999960480868
+ 6.6866752652262631e-06 1.199999960480868
+ 6.691675265226263e-06 1.199999960480868
+ 6.696675265226263e-06 1.199999960480868
+ 6.7016752652262629e-06 1.199999960480868
+ 6.7066752652262629e-06 1.199999960480868
+ 6.7116752652262628e-06 1.199999960480868
+ 6.7166752652262628e-06 1.199999960480868
+ 6.7216752652262627e-06 1.199999960480868
+ 6.7266752652262627e-06 1.199999960480868
+ 6.7316752652262626e-06 1.199999960480868
+ 6.7366752652262626e-06 1.199999960480868
+ 6.7416752652262634e-06 1.199999960480868
+ 6.7466752652262616e-06 1.199999960480868
+ 6.7516752652262616e-06 1.199999960480868
+ 6.7566752652262624e-06 1.199999960480868
+ 6.7616752652262624e-06 1.199999960480868
+ 6.7666752652262623e-06 1.199999960480868
+ 6.7716752652262623e-06 1.199999960480868
+ 6.7766752652262622e-06 1.1999999604808671
+ 6.7816752652262622e-06 1.1999999604808671
+ 6.7866752652262621e-06 1.1999999604808651
+ 6.7916752652262621e-06 1.199999960480862
+ 6.796675265226262e-06 1.1999999604808571
+ 6.801675265226262e-06 1.1999999604808469
+ 6.8066752652262619e-06 1.1999999604808269
+ 6.8116752652262619e-06 1.1999999604807901
+ 6.8166752652262618e-06 1.199999960480719
+ 6.8216752652262618e-06 1.1999999604805811
+ 6.8266752652262617e-06 1.1999999604803211
+ 6.8316752652262617e-06 1.199999960479841
+ 6.8366752652262616e-06 1.199999960478999
+ 6.8416752652262616e-06 1.19999996047751
+ 6.8466752652262624e-06 1.1999999604744549
+ 6.8516752652262606e-06 1.1999999604624561
+ 6.8541373614558922e-06 1.19999996037253
+ 6.855831351125075e-06 1.1999999601014331
+ 6.8579558043874519e-06 1.1999999602062961
+ 6.8594261597257857e-06 1.1999999604448039
+ 6.8612283116902856e-06 1.1999999604102269
+ 6.8624403356337662e-06 1.199999960536972
+ 6.8629753228722528e-06 1.199999961064429
+ 6.8636230763006858e-06 1.199999961569183
+ 6.8639516389869136e-06 1.199999964178893
+ 6.8642490994475229e-06 1.199999967058522
+ 6.8644835905953423e-06 1.1999999650261211
+ 6.8646908386607667e-06 1.1999999217943389
+ 6.8649061774667372e-06 1.199999867234073
+ 6.8651486326634207e-06 1.199999824318766
+ 6.8652736322935522e-06 1.199999643684444
+ 6.8653382052026862e-06 1.1999992911283279
+ 6.8653962375467362e-06 1.199998839864002
+ 6.865441810014138e-06 1.19999852132665
+ 6.8655091439079384e-06 1.199998010948411
+ 6.8655793049078239e-06 1.199998088813965
+ 6.8656600834449196e-06 1.1999991438361219
+ 6.8656850609103179e-06 1.1999996926803049
+ 6.8657049849496684e-06 1.199999800601151
+ 6.8657236971877661e-06 1.200000109058772
+ 6.8657483135583154e-06 1.200002709704916
+ 6.8657752182179442e-06 1.200007902081726
+ 6.8657997918366561e-06 1.2000107519679399
+ 6.865820665193416e-06 1.2000101463506361
+ 6.8658379977073937e-06 1.200007912627604
+ 6.8658524846610556e-06 1.200004981642492
+ 6.865868350969056e-06 1.200001922423005
+ 6.8658858362770921e-06 1.1999996572622269
+ 6.865912464593882e-06 1.1999980165148949
+ 6.8659422763192173e-06 1.1999973203971279
+ 6.8659702374193384e-06 1.199997082837613
+ 6.8659944145884629e-06 1.199997597912519
+ 6.8660198192522473e-06 1.199999400080304
+ 6.8660501159864891e-06 1.200002516039683
+ 6.8660803850599442e-06 1.200005337864267
+ 6.8661047461037313e-06 1.200007125201789
+ 6.866121300476556e-06 1.200008376536513
+ 6.8661369362633853e-06 1.2000098604033509
+ 6.8661515585976108e-06 1.2000119065773589
+ 6.8661668181493447e-06 1.2000133223485701
+ 6.8661793881563112e-06 1.2000129347941351
+ 6.8661932083281011e-06 1.200011310891933
+ 6.8662103217666157e-06 1.2000085446192319
+ 6.866238690371174e-06 1.2000013361065109
+ 6.8662662200242739e-06 1.199965426842696
+ 6.8662909865874037e-06 1.1998897466622951
+ 6.8663175852574196e-06 1.1997700935975431
+ 6.8663560877414e-06 1.1994614457350929
+ 6.8663778081895499e-06 1.199796659811549
+ 6.8663938825516324e-06 1.2014573555644641
+ 6.8664134420415379e-06 1.206328233312369
+ 6.8664348331240239e-06 1.2142697063061689
+ 6.8664501134687167e-06 1.2146665195158219
+ 6.8664639172380803e-06 1.1981992609027601
+ 6.8664820493202757e-06 1.140553341258093
+ 6.8665016704905394e-06 1.044401468055034
+ 6.8665202208412226e-06 0.93680189390612334
+ 6.8665415189656424e-06 0.80738246011926984
+ 6.8665637665825686e-06 0.67321074197558772
+ 6.8665780563418892e-06 0.58921090169427959
+ 6.866590280510062e-06 0.51939201070975283
+ 6.8666041317579974e-06 0.44322791017710927
+ 6.8666199231718579e-06 0.36137027433726621
+ 6.8666358763801261e-06 0.28569803381299269
+ 6.8666558899138954e-06 0.203761833735042
+ 6.8666794744330428e-06 0.12882697402216961
+ 6.8667028217395282e-06 0.077132437881903493
+ 6.8667173847965093e-06 0.054817142892384277
+ 6.8667335951711276e-06 0.036952876692534199
+ 6.8667523704864229e-06 0.02297224670941236
+ 6.8667733786300983e-06 0.01316559856003229
+ 6.8667961717455642e-06 0.0069686200756608214
+ 6.8668223012882872e-06 0.0031702307910351662
+ 6.8668523752884308e-06 0.001111104369621276
+ 6.8668892393462136e-06 0.0001350478709442719
+ 6.8669355719735024e-06 -0.00017535360016564491
+ 6.8669984470793581e-06 -0.00016519590971735419
+ 6.8670899260968539e-06 -6.5292330198666327e-05
+ 6.8671759920533116e-06 -1.398711712083965e-05
+ 6.8672937443222093e-06 4.0858239271131746e-06
+ 6.8674304440677766e-06 3.5416093251432531e-06
+ 6.8675663495971149e-06 1.0565713565810511e-06
+ 6.8676934434240098e-06 1.3344353140911869e-07
+ 6.8678156741515363e-06 -1.1458230515207881e-08
+ 6.8679362673407744e-06 2.1630850945848759e-08
+ 6.8680567960545742e-06 5.241019528538196e-08
+ 6.8681860020648637e-06 6.2890721137514116e-08
+ 6.8683065758088273e-06 6.4771210097799191e-08
+ 6.8684314464273206e-06 6.6390972395349921e-08
+ 6.8685500360455096e-06 6.9414738442236768e-08
+ 6.8686715560535703e-06 7.4126255946868972e-08
+ 6.8687895246386322e-06 8.5921442512777687e-08
+ 6.8689097410573239e-06 1.332642132361157e-07
+ 6.8689826864086882e-06 3.296740487885849e-07
+ 6.8690330111634606e-06 6.1087462212749879e-07
+ 6.8690877200404487e-06 6.356674836646945e-07
+ 6.8691532045186216e-06 2.033581935381064e-07
+ 6.8691897013778741e-06 -1.8610025168300839e-07
+ 6.8692185818696324e-06 -5.824433315921532e-07
+ 6.8692425820438296e-06 -1.034759508857556e-06
+ 6.8692654024764146e-06 -1.5320339192261849e-06
+ 6.8692867360850224e-06 -1.753054072483857e-06
+ 6.869314787878651e-06 -1.6310784244004829e-06
+ 6.8693343630653722e-06 -1.7350465599055069e-06
+ 6.8693574075881611e-06 -6.4348247104225403e-07
+ 6.8693959629806924e-06 1.0710866911098421e-06
+ 6.8694367196584569e-06 1.41477407346374e-06
+ 6.8694948716329468e-06 7.5639824952675653e-07
+ 6.8695609788185768e-06 1.861686409680866e-07
+ 6.8696497032493121e-06 1.9427115451980029e-08
+ 6.8697328488857417e-06 -1.9301141032211909e-08
+ 6.8698336294294556e-06 -5.5796083075233278e-09
+ 6.8699486174225701e-06 4.7965080109118687e-08
+ 6.8700766145296723e-06 7.4037665774756294e-08
+ 6.8702481298525161e-06 7.0047319642142226e-08
+ 6.8704997238603607e-06 6.1650686477659415e-08
+ 6.8708116838623986e-06 6.077846303883101e-08
+ 6.8711715425590882e-06 6.1758420429133167e-08
+ 6.8716075907807418e-06 6.2029203049210696e-08
+ 6.8721401270421842e-06 6.2059007350515269e-08
+ 6.8727395706275138e-06 6.1551967331086419e-08
+ 6.8731342781270672e-06 6.0307878362682839e-08
+ 6.8734717682932161e-06 6.3084294190950917e-08
+ 6.8738981430106702e-06 6.2191849168239113e-08
+ 6.8743696650237501e-06 6.1729890917269974e-08
+ 6.8749256595596169e-06 6.1912640259832066e-08
+ 6.8755164006436644e-06 6.1921156178232645e-08
+ 6.8763424796503453e-06 6.1919018417968328e-08
+ 6.8774937952699234e-06 6.1921826761383035e-08
+ 6.8795175209752627e-06 6.1921391714995444e-08
+ 6.8825673156149316e-06 6.1921011336771819e-08
+ 6.8875673156149324e-06 6.1920982151911696e-08
+ 6.8925673156149324e-06 6.1920994874437514e-08
+ 6.8975673156149306e-06 6.192099751585465e-08
+ 6.9025673156149314e-06 6.1920998037614796e-08
+ 6.9075673156149314e-06 6.1920997976640653e-08
+ 6.9125673156149313e-06 6.1920998023561659e-08
+ 6.9175673156149313e-06 6.1920998070780636e-08
+ 6.9225673156149312e-06 6.1920998209841582e-08
+ 6.9275673156149312e-06 6.1920998207603231e-08
+ 6.9325673156149311e-06 6.1920998028157911e-08
+ 6.9375673156149311e-06 6.1920998079425348e-08
+ 6.942567315614931e-06 6.1920998191866775e-08
+ 6.947567315614931e-06 6.1920998155074774e-08
+ 6.9525673156149309e-06 6.1920998257338054e-08
+ 6.9575673156149309e-06 6.1920998067194563e-08
+ 6.9625673156149308e-06 6.1920998119849546e-08
+ 6.9675673156149308e-06 6.1920997937110631e-08
+ 6.9725673156149308e-06 6.1920998245730778e-08
+ 6.9775673156149307e-06 6.1920998033496072e-08
+ 6.9825673156149307e-06 6.1920998085475625e-08
+ 6.9875673156149306e-06 6.192099819577656e-08
+ 6.9925673156149314e-06 6.1920997937762277e-08
+ 6.9975673156149314e-06 6.1920998051940651e-08
+ 7.0025673156149296e-06 6.1920998038059171e-08
+ 7.0075673156149304e-06 6.1920998113935019e-08
+ 7.0125673156149304e-06 6.1920998199877893e-08
+ 7.0175673156149303e-06 6.1920998275835348e-08
+ 7.0225673156149303e-06 6.1920998068693004e-08
+ 7.0275673156149302e-06 6.1920998112211174e-08
+ 7.0325673156149302e-06 6.1920998159189369e-08
+ 7.0375673156149301e-06 6.1920998163662219e-08
+ 7.0425673156149301e-06 6.1920998307558969e-08
+ 7.04756731561493e-06 6.1920998059404547e-08
+ 7.05256731561493e-06 6.1920998126428384e-08
+ 7.0575673156149299e-06 6.1920998149105534e-08
+ 7.0625673156149299e-06 6.1920998270337601e-08
+ 7.0675673156149298e-06 6.192099801134309e-08
+ 7.0725673156149298e-06 6.1920998157515605e-08
+ 7.0775673156149297e-06 6.192099791674158e-08
+ 7.0825673156149297e-06 6.1920997937480162e-08
+ 7.0875673156149297e-06 6.192099804799627e-08
+ 7.0925673156149296e-06 6.192099805541072e-08
+ 7.0975673156149304e-06 6.1920998130158638e-08
+ 7.1025673156149304e-06 6.1920998232663204e-08
+ 7.1075673156149286e-06 6.1920998200829614e-08
+ 7.1125673156149294e-06 6.1920998044506918e-08
+ 7.1175673156149294e-06 6.1920998117981309e-08
+ 7.1225673156149293e-06 6.1920997969176559e-08
+ 7.1275673156149293e-06 6.1920997944579212e-08
+ 7.1325673156149292e-06 6.1920998168669838e-08
+ 7.1375673156149292e-06 6.1920997875652382e-08
+ 7.1425673156149291e-06 6.192099803365096e-08
+ 7.1475673156149291e-06 6.1920998155206249e-08
+ 7.152567315614929e-06 6.192099799078605e-08
+ 7.157567315614929e-06 6.1920998158817601e-08
+ 7.1625673156149289e-06 6.1920997940528383e-08
+ 7.1675673156149289e-06 6.1920997872516243e-08
+ 7.1725673156149288e-06 6.1920997910931701e-08
+ 7.1775673156149288e-06 6.1920997221284437e-08
+ 7.1825673156149287e-06 6.1920993366331112e-08
+ 7.1846587720813922e-06 6.192090507849837e-08
+ 7.1864848235792082e-06 6.1920909825447811e-08
+ 7.1883871139193736e-06 6.1921195405276554e-08
+ 7.1899209941394446e-06 6.1921059401995052e-08
+ 7.1915981106265672e-06 6.1920804381823903e-08
+ 7.1926218557349736e-06 6.1921271307675327e-08
+ 7.1929966838307872e-06 6.1921858705572269e-08
+ 7.1935439944051646e-06 6.1920904092820436e-08
+ 7.1938507720293933e-06 6.1925244075093817e-08
+ 7.194095745093141e-06 6.1917031620469849e-08
+ 7.1942968378721959e-06 6.1823288631096598e-08
+ 7.1945052317697246e-06 6.1863673404234254e-08
+ 7.1947470202856312e-06 6.1979912803580304e-08
+ 7.1948979505488501e-06 6.1306063911311429e-08
+ 7.1949635757633269e-06 5.7433319175021599e-08
+ 7.195018127727824e-06 5.5673797924247039e-08
+ 7.1950615823859689e-06 5.9408618130372721e-08
+ 7.195126138795616e-06 9.0906457808391381e-08
+ 7.1951920757053374e-06 1.3046769500155619e-07
+ 7.1952575017585793e-06 1.7183681542984849e-07
+ 7.1952870354935484e-06 3.3022673949291573e-07
+ 7.1953076489560844e-06 6.4935578414490245e-07
+ 7.1953293793703164e-06 7.8418531492726256e-07
+ 7.1953568647032338e-06 2.6846876984066792e-07
+ 7.1953800265419773e-06 -7.6011677275998549e-07
+ 7.195401018325817e-06 -2.6327494606100002e-06
+ 7.1954199734612146e-06 -4.1844057793938576e-06
+ 7.195435098656884e-06 -4.9967414390121482e-06
+ 7.1954496109157154e-06 -4.688044215935801e-06
+ 7.1954597284984937e-06 -2.5379165973516041e-06
+ 7.1954723217453566e-06 -6.559066983429505e-07
+ 7.1954890496519752e-06 -5.0788219901333098e-07
+ 7.1955078383558909e-06 -1.5916294177309259e-06
+ 7.1955322680677191e-06 -2.6426493056469548e-06
+ 7.1955572504987007e-06 -3.2981147234907459e-06
+ 7.1955806147492688e-06 -3.3474824654653442e-06
+ 7.1956049538662486e-06 -2.0510319274147601e-06
+ 7.1956277717494042e-06 -5.5858210379733289e-07
+ 7.1956543098220579e-06 -5.0662714924340218e-07
+ 7.1956819913488141e-06 -1.697625347276739e-06
+ 7.1957116053055316e-06 -2.9667459751644501e-06
+ 7.1957350650451952e-06 -3.691482757376342e-06
+ 7.1957635131885198e-06 -3.7317182720962678e-06
+ 7.1957860974912262e-06 -6.1369649188214821e-07
+ 7.1958043246687509e-06 2.207629881339585e-06
+ 7.1958216852722597e-06 -9.8623053100450151e-06
+ 7.1958396064876416e-06 -6.2364344425503568e-05
+ 7.195861729668395e-06 -0.0001540898328852614
+ 7.1958844133496917e-06 -0.00018262122752878441
+ 7.1958978048651409e-06 -0.0001114324568919455
+ 7.1959120231756866e-06 1.913421247007509e-05
+ 7.1959295675255308e-06 0.000148458285288036
+ 7.1959464207183858e-06 0.0001916447606975334
+ 7.195969510486163e-06 0.0001741796764776517
+ 7.1959945178711663e-06 0.00013063765811956491
+ 7.1960260870257266e-06 8.4878506692632726e-05
+ 7.196058861362554e-06 6.1933955447210557e-05
+ 7.1960961096817757e-06 5.7400063037505397e-05
+ 7.196138824587302e-06 6.818294155284576e-05
+ 7.1961930967772978e-06 8.4064809325515419e-05
+ 7.1962626309725914e-06 -0.00068577100191578486
+ 7.1963074753243884e-06 -0.0034208003113765078
+ 7.1963451146742823e-06 -0.0075704057200474528
+ 7.1963541051902861e-06 -0.0083641980673779103
+ 7.1963720862222936e-06 -0.0057212908145381691
+ 7.1963841496848628e-06 0.0024058684561386319
+ 7.196395464887704e-06 0.017937457506065891
+ 7.1964091117887647e-06 0.05056164884587816
+ 7.196421643316798e-06 0.095077239286647644
+ 7.1964340762309154e-06 0.15187971753930041
+ 7.1964447620658092e-06 0.2085737373711983
+ 7.1964576219401447e-06 0.28265206927033831
+ 7.1964717097505883e-06 0.36703220924458008
+ 7.1964886081577283e-06 0.46834269101337173
+ 7.1965100570391372e-06 0.59250132277906487
+ 7.1965386695077709e-06 0.74429889774167712
+ 7.1965745405860996e-06 0.90286523163379484
+ 7.1966154645811324e-06 1.0332375848415669
+ 7.1966751119072071e-06 1.1407983127220931
+ 7.1967200444761794e-06 1.1773196784424811
+ 7.1967730470033987e-06 1.195263007568784
+ 7.1968222261400224e-06 1.2004248917412059
+ 7.1968887402675954e-06 1.201712424249237
+ 7.1969675444929976e-06 1.201189391217955
+ 7.1970965894713038e-06 1.200360799305306
+ 7.1972312873647408e-06 1.2000268036192021
+ 7.1973605333244066e-06 1.1999687252851869
+ 7.1974826675935338e-06 1.199979746915107
+ 7.1976016029115794e-06 1.1999929817145081
+ 7.1977285383319392e-06 1.19999907818931
+ 7.1978471123135612e-06 1.2000003665476699
+ 7.1979708021022209e-06 1.200000314834166
+ 7.1980886145314998e-06 1.200000102566628
+ 7.1982098371358276e-06 1.199999989051957
+ 7.1983275481806549e-06 1.199999957286098
+ 7.1984476406993261e-06 1.1999999547936311
+ 7.198565627917755e-06 1.199999958381097
+ 7.1986852357225294e-06 1.199999963092917
+ 7.1987474071003894e-06 1.199999979497242
+ 7.1987935761294317e-06 1.199999997076687
+ 7.1988441212613747e-06 1.199999983048561
+ 7.1989080483586229e-06 1.1999999336134859
+ 7.1989463140897481e-06 1.1999999111655959
+ 7.1989759227186767e-06 1.199999897073422
+ 7.1990004847481466e-06 1.1999998691786991
+ 7.1990235249573651e-06 1.19999981329205
+ 7.1990463547005151e-06 1.19999973221169
+ 7.1990722738389962e-06 1.1999996473904171
+ 7.199098846630099e-06 1.1999998352951491
+ 7.1991245952111194e-06 1.200000158055865
+ 7.1991532452964066e-06 1.200000314596547
+ 7.199199075129168e-06 1.200000242702024
+ 7.1992495856770277e-06 1.2000000558083579
+ 7.1993172094726604e-06 1.199999906308725
+ 7.1993949907591117e-06 1.199999868741815
+ 7.1994763519550387e-06 1.1999998979098401
+ 7.1995787726435953e-06 1.1999999453055561
+ 7.1996782997292962e-06 1.199999968960108
+ 7.1998139062123396e-06 1.19999997221957
+ 7.1999842387562127e-06 1.19999996488571
+ 7.2003002744658481e-06 1.199999959192763
+ 7.200676365811976e-06 1.1999999594257309
+ 7.2011515912311612e-06 1.1999999603345
+ 7.2017204440583267e-06 1.199999960552294
+ 7.202373800714394e-06 1.199999960490659
+ 7.2027922589336873e-06 1.199999960395191
+ 7.2031370462808317e-06 1.19999996061889
+ 7.2035617671510834e-06 1.1999999605062339
+ 7.2040974550659152e-06 1.199999960444557
+ 7.204661069166851e-06 1.199999960467756
+ 7.2052876279176022e-06 1.1999999604802281
+ 7.2061434020008632e-06 1.199999960482651
+ 7.2074115703442512e-06 1.199999960481416
+ 7.2096640744477303e-06 1.1999999604808771
+ 7.2130709503333578e-06 1.199999960480937
+ 7.2180709503333577e-06 1.199999960480892
+ 7.2230709503333577e-06 1.19999996048086
+ 7.2280709503333576e-06 1.19999996048086
+ 7.2330709503333584e-06 1.1999999604808651
+ 7.2380709503333584e-06 1.1999999604808671
+ 7.2430709503333566e-06 1.199999960480868
+ 7.2480709503333574e-06 1.199999960480868
+ 7.2530709503333574e-06 1.199999960480868
+ 7.2580709503333573e-06 1.199999960480868
+ 7.2630709503333573e-06 1.199999960480868
+ 7.2680709503333572e-06 1.199999960480868
+ 7.2730709503333572e-06 1.199999960480868
+ 7.2780709503333571e-06 1.199999960480868
+ 7.2830709503333571e-06 1.199999960480868
+ 7.288070950333357e-06 1.199999960480868
+ 7.293070950333357e-06 1.199999960480868
+ 7.2980709503333569e-06 1.199999960480868
+ 7.3030709503333569e-06 1.199999960480868
+ 7.3080709503333568e-06 1.199999960480868
+ 7.3130709503333568e-06 1.199999960480868
+ 7.3180709503333567e-06 1.199999960480868
+ 7.3230709503333567e-06 1.199999960480868
+ 7.3280709503333567e-06 1.199999960480868
+ 7.3330709503333566e-06 1.199999960480868
+ 7.3380709503333574e-06 1.199999960480868
+ 7.3430709503333574e-06 1.199999960480868
+ 7.3480709503333556e-06 1.199999960480868
+ 7.3530709503333564e-06 1.199999960480868
+ 7.3580709503333564e-06 1.199999960480868
+ 7.3630709503333563e-06 1.199999960480868
+ 7.3680709503333563e-06 1.199999960480868
+ 7.3730709503333562e-06 1.199999960480868
+ 7.3780709503333562e-06 1.199999960480868
+ 7.3830709503333561e-06 1.199999960480868
+ 7.3880709503333561e-06 1.199999960480868
+ 7.393070950333356e-06 1.199999960480868
+ 7.398070950333356e-06 1.199999960480868
+ 7.4030709503333559e-06 1.199999960480868
+ 7.4080709503333559e-06 1.199999960480868
+ 7.4130709503333558e-06 1.199999960480868
+ 7.4180709503333558e-06 1.199999960480868
+ 7.4230709503333557e-06 1.199999960480868
+ 7.4280709503333557e-06 1.199999960480868
+ 7.4330709503333556e-06 1.199999960480868
+ 7.4380709503333556e-06 1.1999999604808671
+ 7.4430709503333564e-06 1.199999960480866
+ 7.4480709503333563e-06 1.199999960480864
+ 7.4530709503333546e-06 1.19999996048086
+ 7.4580709503333554e-06 1.1999999604808529
+ 7.4630709503333554e-06 1.1999999604808389
+ 7.4680709503333553e-06 1.199999960480814
+ 7.4730709503333553e-06 1.1999999604807641
+ 7.4780709503333552e-06 1.199999960480669
+ 7.4830709503333552e-06 1.1999999604804861
+ 7.4880709503333551e-06 1.199999960480143
+ 7.4930709503333551e-06 1.199999960479526
+ 7.498070950333355e-06 1.199999960478445
+ 7.503070950333355e-06 1.1999999604764751
+ 7.5080709503333549e-06 1.199999960471569
+ 7.5130709503333549e-06 1.1999999604312479
+ 7.5150343393372286e-06 1.1999999601195299
+ 7.5169744634201059e-06 1.199999960188487
+ 7.5183947302613758e-06 1.199999960439216
+ 7.5202487226655586e-06 1.199999960404142
+ 7.5215238260584179e-06 1.199999960517752
+ 7.5220929634160426e-06 1.199999961029528
+ 7.5227203063180903e-06 1.199999961547056
+ 7.5230424665196237e-06 1.1999999639175241
+ 7.5233554759245663e-06 1.199999966553835
+ 7.5236005026180924e-06 1.1999999659700351
+ 7.5238112324358687e-06 1.1999999258238661
+ 7.5240277853436317e-06 1.1999998694074929
+ 7.5242725521642046e-06 1.1999998274247481
+ 7.5244039429972809e-06 1.1999996547070899
+ 7.5244702820860739e-06 1.1999992971277409
+ 7.5245280838365569e-06 1.199998844706561
+ 7.5245735151362466e-06 1.199998526707188
+ 7.5246412735600116e-06 1.199998016381699
+ 7.5247112080646762e-06 1.199998093999042
+ 7.5247923708290424e-06 1.1999991462234749
+ 7.5248174638570947e-06 1.199999694779655
+ 7.5248374172671424e-06 1.199999800053027
+ 7.5248561660810604e-06 1.200000107252037
+ 7.5248808412059552e-06 1.200002704975758
+ 7.5249078728031053e-06 1.2000078917635071
+ 7.5249324147282321e-06 1.200010719272006
+ 7.5249532802201852e-06 1.2000101129826559
+ 7.5249706872024689e-06 1.200007869946617
+ 7.5249850742711088e-06 1.200004960225368
+ 7.5250008842703341e-06 1.200001920181353
+ 7.5250185411607484e-06 1.1999996458574289
+ 7.5250451334850764e-06 1.1999980200461859
+ 7.5250750312718636e-06 1.1999973235358701
+ 7.5251031193125163e-06 1.199997088677538
+ 7.5251273675340111e-06 1.1999976218988939
+ 7.5251527996606247e-06 1.19999944814031
+ 7.5251826705736154e-06 1.200002531314311
+ 7.5252134330552692e-06 1.200005384558321
+ 7.5252378926592629e-06 1.2000071686689699
+ 7.5252544638175023e-06 1.200008428596872
+ 7.5252701236007758e-06 1.2000099397721831
+ 7.5252846037410174e-06 1.2000119898596859
+ 7.5253002729238706e-06 1.2000133426911661
+ 7.5253124889256564e-06 1.2000128861156789
+ 7.5253261476423532e-06 1.200011244027462
+ 7.5253441878935783e-06 1.2000083126078489
+ 7.5253718883289364e-06 1.200000986059155
+ 7.5254002877036843e-06 1.199961866251444
+ 7.5254245284614703e-06 1.1998858571887641
+ 7.5254513575215688e-06 1.1997631584533039
+ 7.5254904499097013e-06 1.199449469802355
+ 7.5255113700037394e-06 1.1998534911413341
+ 7.5255275455686213e-06 1.201662059601353
+ 7.5255480211736848e-06 1.207028554190801
+ 7.5255697680482258e-06 1.214873616534772
+ 7.5255845065220136e-06 1.2135706623349829
+ 7.5255982271372592e-06 1.1942569492350279
+ 7.52561586506086e-06 1.1350703533049971
+ 7.5256363366299376e-06 1.0325872565605041
+ 7.5256559116064727e-06 0.91794900879454788
+ 7.5256767481280474e-06 0.79105936010854705
+ 7.5256958464619084e-06 0.67580006042641305
+ 7.5257089745371912e-06 0.59842440632430327
+ 7.5257205408597666e-06 0.53203952583565683
+ 7.5257341894695739e-06 0.45642187493144082
+ 7.5257471997424994e-06 0.3877578158661743
+ 7.5257620812696038e-06 0.31451935292710698
+ 7.5257824439544341e-06 0.226408043859612
+ 7.5258062540811593e-06 0.1448779513628847
+ 7.5258284909886194e-06 0.090210653988834308
+ 7.5258448274608902e-06 0.061938786300720139
+ 7.5258605945792513e-06 0.042399345336143833
+ 7.5258783526267413e-06 0.027211934636166089
+ 7.5258997861171786e-06 0.015516618613468579
+ 7.5259211024817474e-06 0.0086440421059429586
+ 7.5259469481677776e-06 0.0040400362028142969
+ 7.5259747509762458e-06 0.0016203420803591051
+ 7.5260100801512714e-06 0.00033169409938158982
+ 7.5260521292202439e-06 -0.0001249713670802572
+ 7.5261100493178713e-06 -0.00018626439324875201
+ 7.526189525249608e-06 -9.5934003680346277e-05
+ 7.5262787587663341e-06 -2.453920778242725e-05
+ 7.5263817811161226e-06 1.6091421912153429e-06
+ 7.5265130132543051e-06 4.3658005541798749e-06
+ 7.5266987674554366e-06 1.5035160030978241e-06
+ 7.5268449171102268e-06 2.693338996585849e-07
+ 7.5269702974678962e-06 1.9662392297920969e-08
+ 7.5270865376566649e-06 2.180927048594536e-08
+ 7.5272032329027986e-06 4.8736760903814348e-08
+ 7.5273295924585774e-06 6.1343122175994906e-08
+ 7.5274489794678824e-06 6.4722585343893755e-08
+ 7.527573578436439e-06 6.6801346495011098e-08
+ 7.5276922808507606e-06 6.994715853424904e-08
+ 7.5278140159805616e-06 7.5026995059104314e-08
+ 7.5279321255937192e-06 8.8704997720109681e-08
+ 7.528052419752495e-06 1.4762691140434229e-07
+ 7.5281190978629734e-06 3.7956109109025647e-07
+ 7.5281688712231894e-06 6.4559380445540852e-07
+ 7.5282270223413756e-06 5.8593398847380939e-07
+ 7.5282925233592653e-06 1.041994767321996e-07
+ 7.5283293379928916e-06 -3.1034534698697499e-07
+ 7.5283552731372444e-06 -7.3454235992753299e-07
+ 7.5283787146361407e-06 -1.237336130484103e-06
+ 7.5284009362845503e-06 -1.6900789111977599e-06
+ 7.5284224569300243e-06 -1.6998461530245989e-06
+ 7.528447579383377e-06 -1.7275714509416469e-06
+ 7.528467210501786e-06 -1.5660807229802671e-06
+ 7.5284911867392649e-06 -2.5181010730473222e-07
+ 7.528531873396806e-06 1.280158570466819e-06
+ 7.5285745261039474e-06 1.335419716291857e-06
+ 7.5286351506216206e-06 5.9293202985332672e-07
+ 7.528706413029264e-06 1.17782598825494e-07
+ 7.5287807220877094e-06 2.87402772219628e-08
+ 7.5288670048554577e-06 -1.7245349568521859e-08
+ 7.5289701291676776e-06 1.9394363882285649e-09
+ 7.5290852078071892e-06 5.3026190759694793e-08
+ 7.5292168825451698e-06 7.4497783054053504e-08
+ 7.5293909128875867e-06 6.8810544850090081e-08
+ 7.5296549477490984e-06 6.1206445721543175e-08
+ 7.5299629205437749e-06 6.0883985819927764e-08
+ 7.5303345365911634e-06 6.1826813836620515e-08
+ 7.5307691578879622e-06 6.2028984154640781e-08
+ 7.5313192972384451e-06 6.205727650882453e-08
+ 7.5318885975007014e-06 6.1459777990676243e-08
+ 7.5322919806768242e-06 6.0392809972366638e-08
+ 7.53262239924906e-06 6.3206842038901034e-08
+ 7.5330340708620549e-06 6.2069438794803558e-08
+ 7.5335501630976586e-06 6.1739612918268462e-08
+ 7.5341297093143158e-06 6.1921300282797506e-08
+ 7.5347319705244029e-06 6.1917308234932837e-08
+ 7.5355871754762698e-06 6.1919094976207136e-08
+ 7.5367751200249358e-06 6.1922090844735594e-08
+ 7.5389459622719251e-06 6.1921357231170194e-08
+ 7.5421453473944324e-06 6.1920998859974507e-08
+ 7.5471453473944306e-06 6.192098291214563e-08
+ 7.5521453473944314e-06 6.1920995345072485e-08
+ 7.5571453473944314e-06 6.192099783568279e-08
+ 7.5621453473944313e-06 6.1920998084640292e-08
+ 7.5671453473944313e-06 6.1920998233009005e-08
+ 7.5721453473944312e-06 6.1920998316844885e-08
+ 7.5771453473944312e-06 6.1920998131188154e-08
+ 7.5821453473944311e-06 6.1920998193774333e-08
+ 7.5871453473944311e-06 6.1920998009923661e-08
+ 7.592145347394431e-06 6.1920998084498956e-08
+ 7.597145347394431e-06 6.1920998103904693e-08
+ 7.6021453473944309e-06 6.1920998152859994e-08
+ 7.6071453473944309e-06 6.1920998232870608e-08
+ 7.6121453473944308e-06 6.1920998069802564e-08
+ 7.6171453473944308e-06 6.1920998076434104e-08
+ 7.6221453473944307e-06 6.1920998085502942e-08
+ 7.6271453473944307e-06 6.1920998191596915e-08
+ 7.6321453473944315e-06 6.1920998003543068e-08
+ 7.6371453473944323e-06 6.1920998028098619e-08
+ 7.6421453473944331e-06 6.1920998402736196e-08
+ 7.6471453473944339e-06 6.1920998157200125e-08
+ 7.6521453473944347e-06 6.192099823843257e-08
+ 7.6571453473944355e-06 6.1920997990810257e-08
+ 7.6621453473944363e-06 6.1920998064640679e-08
+ 7.6671453473944371e-06 6.1920998191904799e-08
+ 7.6721453473944379e-06 6.192099797784966e-08
+ 7.6771453473944387e-06 6.1920998256116209e-08
+ 7.6821453473944395e-06 6.1920998053853609e-08
+ 7.6871453473944403e-06 6.1920998083058762e-08
+ 7.6921453473944411e-06 6.1920998162020735e-08
+ 7.6971453473944419e-06 6.1920998225147917e-08
+ 7.7021453473944427e-06 6.1920998065685111e-08
+ 7.7071453473944435e-06 6.1920998112868207e-08
+ 7.7121453473944443e-06 6.1920998175336186e-08
+ 7.7171453473944451e-06 6.1920998202676001e-08
+ 7.7221453473944459e-06 6.1920998244437941e-08
+ 7.7271453473944467e-06 6.192099804149426e-08
+ 7.7321453473944475e-06 6.1920998079791108e-08
+ 7.7371453473944483e-06 6.1920998217619621e-08
+ 7.7421453473944491e-06 6.1920997922638636e-08
+ 7.7471453473944499e-06 6.1920998283498257e-08
+ 7.7521453473944507e-06 6.1920998048593415e-08
+ 7.7571453473944515e-06 6.1920998114560235e-08
+ 7.7621453473944523e-06 6.1920998208499723e-08
+ 7.7671453473944531e-06 6.1920998212768398e-08
+ 7.7721453473944539e-06 6.1920998080187453e-08
+ 7.7771453473944547e-06 6.1920998105296527e-08
+ 7.7821453473944555e-06 6.1920998165944668e-08
+ 7.7871453473944563e-06 6.19209981949824e-08
+ 7.7921453473944571e-06 6.1920998172037138e-08
+ 7.7971453473944579e-06 6.1920997985717961e-08
+ 7.8021453473944587e-06 6.192099813450708e-08
+ 7.8071453473944595e-06 6.1920998207631726e-08
+ 7.8121453473944603e-06 6.1920998086660783e-08
+ 7.8171453473944611e-06 6.1920998207831334e-08
+ 7.8221453473944619e-06 6.1920997904455804e-08
+ 7.8271453473944627e-06 6.1920997941161526e-08
+ 7.8321453473944635e-06 6.1920997793931371e-08
+ 7.8371453473944643e-06 6.1920997170069821e-08
+ 7.8421453473944651e-06 6.1920991996088931e-08
+ 7.8441592775317239e-06 6.1920873605505875e-08
+ 7.8460076583390448e-06 6.1920986618891907e-08
+ 7.8476640484645038e-06 6.1921192075053085e-08
+ 7.849355562302307e-06 6.1920984064332428e-08
+ 7.8511007605971433e-06 6.192087921196089e-08
+ 7.8519711393765044e-06 6.1921345096229649e-08
+ 7.8522899854121296e-06 6.1922387139410246e-08
+ 7.8527785533936942e-06 6.1920605282801033e-08
+ 7.8530786951808963e-06 6.1925763298517223e-08
+ 7.8533098376553975e-06 6.1897693685143511e-08
+ 7.8535110207999312e-06 6.1784733978787286e-08
+ 7.8537093134749425e-06 6.1946299966786919e-08
+ 7.8539506031988666e-06 6.1913360050581117e-08
+ 7.8540517021836954e-06 6.0069425275524809e-08
+ 7.8541088991638358e-06 5.6280947010591862e-08
+ 7.8541566256551213e-06 5.5451026107778378e-08
+ 7.8542079971459991e-06 6.829443464218089e-08
+ 7.854269747915402e-06 1.050036316161469e-07
+ 7.8543392479146754e-06 1.410216795255331e-07
+ 7.8543872102803388e-06 1.9673950603800881e-07
+ 7.8544104023094618e-06 3.5079816100214081e-07
+ 7.8544315522907659e-06 6.658586419630924e-07
+ 7.8544547326566128e-06 7.5925129787584776e-07
+ 7.8544816353520332e-06 2.292477018468621e-07
+ 7.8545040733643713e-06 -8.0703601800106945e-07
+ 7.8545248202305985e-06 -2.6799440743875929e-06
+ 7.8545439637785548e-06 -4.2219661510692942e-06
+ 7.8545590532244457e-06 -5.0229850334602492e-06
+ 7.854573743237964e-06 -4.6044014057706647e-06
+ 7.854583937504341e-06 -2.428539881352756e-06
+ 7.8545965645459923e-06 -6.0596182119121144e-07
+ 7.8546137082219704e-06 -5.3715301712031484e-07
+ 7.854633082045454e-06 -1.661908749394167e-06
+ 7.8546573319981723e-06 -2.6852723321865128e-06
+ 7.8546823822214968e-06 -3.3347744135026929e-06
+ 7.8547050413712642e-06 -3.3240922594975811e-06
+ 7.8547288437859272e-06 -1.9996232972709311e-06
+ 7.8547518063598065e-06 -5.2657761398195488e-07
+ 7.8547786773489829e-06 -5.2766852551917329e-07
+ 7.8548094737081235e-06 -1.863008313998706e-06
+ 7.8548374623865946e-06 -3.0198924236367971e-06
+ 7.8548594947452931e-06 -3.6920317326931159e-06
+ 7.8548873733071653e-06 -3.6884949868172641e-06
+ 7.8549087712314642e-06 -7.307287976109384e-07
+ 7.8549266229219354e-06 2.2499013278914341e-06
+ 7.8549438297368929e-06 -7.4946599701544614e-06
+ 7.8549616586918665e-06 -5.6427415727728047e-05
+ 7.8549840333500552e-06 -0.00014922585874022309
+ 7.8550056013527016e-06 -0.0001868633340638437
+ 7.8550185149289175e-06 -0.00013071798137259311
+ 7.8550322057405753e-06 -9.1115719962814028e-06
+ 7.8550493925891044e-06 0.0001308370108831129
+ 7.8550651259320166e-06 0.00018753344037564641
+ 7.8550876482430795e-06 0.00018167849343930149
+ 7.8551115642421722e-06 0.00014157972386218891
+ 7.8551429106324757e-06 9.244851290076039e-05
+ 7.8551746676635558e-06 6.5232380228319968e-05
+ 7.8552112638570674e-06 5.6964894175079323e-05
+ 7.8552519608467282e-06 6.4278835813032524e-05
+ 7.8553036461110628e-06 8.6765277841391089e-05
+ 7.8553701988097481e-06 -0.00028728372102560673
+ 7.8554170900670183e-06 -0.0022694792859223201
+ 7.8554655848537415e-06 -0.0073446858715754066
+ 7.8554778802600965e-06 -0.0084187907656944304
+ 7.8554923037241472e-06 -0.0070892932165994146
+ 7.8555020756386209e-06 -0.0028485461197327172
+ 7.8555119405624368e-06 0.0061986038474963496
+ 7.8555228665980207e-06 0.02426493522270198
+ 7.8555356308061359e-06 0.058440197209815727
+ 7.8555502010845406e-06 0.1150386145410278
+ 7.8555605646771625e-06 0.16534377633144259
+ 7.8555715211455678e-06 0.22513732781546611
+ 7.8555863363686179e-06 0.31183796255728841
+ 7.8555999213790979e-06 0.39362892328730148
+ 7.8556194878047007e-06 0.51006961102495341
+ 7.855641628406129e-06 0.63560087799035925
+ 7.8556744387259096e-06 0.80157937379777833
+ 7.8557106471019355e-06 0.94779401026320165
+ 7.8557559153340441e-06 1.071715231414226
+ 7.8557949245704098e-06 1.1344519155204991
+ 7.8558345474529097e-06 1.1694832397250059
+ 7.8558869816083718e-06 1.191317020968341
+ 7.855934648304449e-06 1.1985382788020089
+ 7.8560020736343218e-06 1.2013273433118481
+ 7.8560766724281151e-06 1.201289958821137
+ 7.8561972264281948e-06 1.2005511584250601
+ 7.8563287144884045e-06 1.200109739908213
+ 7.8564579727539268e-06 1.1999864019081239
+ 7.8565811587024952e-06 1.199978636396049
+ 7.8567008520975153e-06 1.199990027898282
+ 7.8568289168485188e-06 1.1999976217686461
+ 7.8569477211358293e-06 1.199999939353606
+ 7.85707180103399e-06 1.2000002882564069
+ 7.8571895326678157e-06 1.2000001437219681
+ 7.8573108768204778e-06 1.2000000158766171
+ 7.8574284926532953e-06 1.1999999666776091
+ 7.8575486595753981e-06 1.199999956183837
+ 7.8576665942204292e-06 1.1999999577379341
+ 7.8577862479730555e-06 1.1999999617024499
+ 7.8578589971918445e-06 1.1999999739959211
+ 7.8579068192618128e-06 1.199999994200879
+ 7.8579550049903236e-06 1.199999990540991
+ 7.8580211414215093e-06 1.1999999421497991
+ 7.8580797808274912e-06 1.199999912001624
+ 7.8581092339792244e-06 1.199999888660483
+ 7.85813300205898e-06 1.199999845323775
+ 7.8581547435335302e-06 1.1999997791791319
+ 7.8581771584364091e-06 1.199999694894474
+ 7.8582047544653748e-06 1.199999660570908
+ 7.8582243507358599e-06 1.199999896363608
+ 7.8582490971238668e-06 1.2000001927548489
+ 7.8582867550225592e-06 1.200000325369905
+ 7.8583382086196659e-06 1.2000001931233031
+ 7.858391892145044e-06 1.200000006799872
+ 7.8584646466223576e-06 1.199999884007152
+ 7.8585441041652097e-06 1.199999871703318
+ 7.858635892193241e-06 1.199999913919596
+ 7.858733770591695e-06 1.199999955243193
+ 7.8588455715585694e-06 1.199999972717404
+ 7.8589869003112693e-06 1.19999997033487
+ 7.8591951686034418e-06 1.1999999622392501
+ 7.8595862231289275e-06 1.1999999587811581
+ 7.8599588215029874e-06 1.1999999597685771
+ 7.8605105896266694e-06 1.1999999605005229
+ 7.861098727828716e-06 1.1999999605489211
+ 7.8616453116784217e-06 1.1999999604448599
+ 7.8621350134167219e-06 1.199999960462053
+ 7.8624872561360234e-06 1.199999960622008
+ 7.8628924405945335e-06 1.1999999604479421
+ 7.8633561965227785e-06 1.1999999604527181
+ 7.8639465228313393e-06 1.199999960476251
+ 7.8646176808606895e-06 1.1999999604821801
+ 7.8656289107825151e-06 1.1999999604819489
+ 7.8670776421358213e-06 1.1999999604810441
+ 7.8696159394643921e-06 1.1999999604809239
+ 7.8735537379580685e-06 1.199999960480937
+ 7.8785537379580693e-06 1.1999999604808771
+ 7.8835537379580701e-06 1.199999960480858
+ 7.8885537379580709e-06 1.199999960480862
+ 7.8935537379580717e-06 1.199999960480866
+ 7.8985537379580725e-06 1.199999960480868
+ 7.9035537379580733e-06 1.199999960480868
+ 7.9085537379580741e-06 1.199999960480868
+ 7.9135537379580749e-06 1.199999960480868
+ 7.9185537379580757e-06 1.199999960480868
+ 7.9235537379580765e-06 1.199999960480868
+ 7.9285537379580773e-06 1.199999960480868
+ 7.9335537379580781e-06 1.199999960480868
+ 7.9385537379580789e-06 1.199999960480868
+ 7.9435537379580797e-06 1.199999960480868
+ 7.9485537379580805e-06 1.199999960480868
+ 7.9535537379580813e-06 1.199999960480868
+ 7.9585537379580821e-06 1.199999960480868
+ 7.9635537379580829e-06 1.199999960480868
+ 7.9685537379580837e-06 1.199999960480868
+ 7.9735537379580845e-06 1.199999960480868
+ 7.9785537379580853e-06 1.199999960480868
+ 7.9835537379580861e-06 1.199999960480868
+ 7.9885537379580869e-06 1.199999960480868
+ 7.9935537379580877e-06 1.199999960480868
+ 7.9985537379580885e-06 1.199999960480868
+ 8.0035537379580893e-06 1.199999960480868
+ 8.0085537379580901e-06 1.199999960480868
+ 8.0135537379580908e-06 1.199999960480868
+ 8.0185537379580916e-06 1.199999960480868
+ 8.0235537379580924e-06 1.199999960480868
+ 8.0285537379580932e-06 1.199999960480868
+ 8.033553737958094e-06 1.199999960480868
+ 8.0385537379580948e-06 1.199999960480868
+ 8.0435537379580956e-06 1.199999960480868
+ 8.0485537379580964e-06 1.199999960480868
+ 8.0535537379580972e-06 1.199999960480868
+ 8.058553737958098e-06 1.199999960480868
+ 8.0635537379580988e-06 1.199999960480868
+ 8.0685537379580996e-06 1.199999960480868
+ 8.0735537379581004e-06 1.199999960480868
+ 8.0785537379581012e-06 1.199999960480868
+ 8.083553737958102e-06 1.199999960480868
+ 8.0885537379581028e-06 1.199999960480868
+ 8.0935537379581036e-06 1.199999960480868
+ 8.0985537379581044e-06 1.199999960480866
+ 8.1035537379581052e-06 1.199999960480866
+ 8.108553737958106e-06 1.1999999604808631
+ 8.1135537379581068e-06 1.1999999604808591
+ 8.1185537379581076e-06 1.19999996048085
+ 8.1235537379581084e-06 1.199999960480834
+ 8.1285537379581092e-06 1.1999999604808029
+ 8.13355373795811e-06 1.1999999604807441
+ 8.1385537379581108e-06 1.19999996048063
+ 8.1435537379581116e-06 1.1999999604804119
+ 8.1485537379581124e-06 1.199999960480008
+ 8.1535537379581132e-06 1.199999960479289
+ 8.158553737958114e-06 1.1999999604780289
+ 8.1635537379581148e-06 1.199999960475628
+ 8.1685537379581156e-06 1.199999960468445
+ 8.1720303303682514e-06 1.199999960418932
+ 8.1738329804584026e-06 1.1999999601494009
+ 8.1758011923132876e-06 1.199999960155951
+ 8.1774015250608451e-06 1.199999960383308
+ 8.1794373015718875e-06 1.1999999604558971
+ 8.1809721841136498e-06 1.1999999605247771
+ 8.1815284995430537e-06 1.199999961342253
+ 8.1820288940541167e-06 1.1999999621813819
+ 8.1823064067320424e-06 1.1999999648641759
+ 8.1826088018598793e-06 1.199999967306844
+ 8.1828396579135267e-06 1.19999995982937
+ 8.1830571414583244e-06 1.199999903893429
+ 8.1832690920293948e-06 1.1999998550826909
+ 8.1835143817331384e-06 1.19999979509902
+ 8.183616540281908e-06 1.1999994863734911
+ 8.1836750161277979e-06 1.1999990174231641
+ 8.1837233320457623e-06 1.1999986285179189
+ 8.1837845602412056e-06 1.1999981521096481
+ 8.1838516500286258e-06 1.199997948187246
+ 8.183926481808301e-06 1.199998614516766
+ 8.1839594515428519e-06 1.199999260425276
+ 8.183983795058035e-06 1.19999981348476
+ 8.1840013855979453e-06 1.199999933475042
+ 8.1840197347390402e-06 1.1999999843994209
+ 8.1840429147713645e-06 1.20000199227891
+ 8.1840698119119631e-06 1.2000068789291121
+ 8.1840944458122599e-06 1.2000104214325591
+ 8.1841161893077155e-06 1.200010412740325
+ 8.1841335351490265e-06 1.200008517681179
+ 8.1841521520508529e-06 1.2000050731382761
+ 8.1841671128487936e-06 1.2000021598278729
+ 8.1841832269228359e-06 1.199999905789052
+ 8.1842106247441184e-06 1.1999980370592409
+ 8.1842400540079504e-06 1.199997323755571
+ 8.1842670337970791e-06 1.199997068666244
+ 8.1842909911933096e-06 1.199997450748288
+ 8.1843164401539026e-06 1.199999074337561
+ 8.1843429058861267e-06 1.2000017755102259
+ 8.1843727767527305e-06 1.2000047299749139
+ 8.1843993574033089e-06 1.200006751644388
+ 8.1844174606442509e-06 1.2000080540786311
+ 8.184433203189556e-06 1.200009419877504
+ 8.1844484954859091e-06 1.2000113816640749
+ 8.1844623967067479e-06 1.200013100076772
+ 8.1844776352826553e-06 1.200013091084515
+ 8.1844907066760832e-06 1.20001171542176
+ 8.1845051094637818e-06 1.200009469011478
+ 8.1845304837874635e-06 1.200004678815034
+ 8.1845531938153508e-06 1.199989239549641
+ 8.1845766599699786e-06 1.1999375730682
+ 8.1846040528308888e-06 1.1998356829244829
+ 8.184632853937076e-06 1.199675779525804
+ 8.1846806673575657e-06 1.2001773866377341
+ 8.1846995858657391e-06 1.202782356476392
+ 8.1847229341523034e-06 1.209719397210294
+ 8.1847475852975947e-06 1.21328520956242
+ 8.1847629739177198e-06 1.196867830413288
+ 8.1847799473201397e-06 1.146593761587386
+ 8.1847979858612493e-06 1.0624443977076741
+ 8.1848155919519764e-06 0.96287280526639885
+ 8.1848374930762248e-06 0.83079521477520557
+ 8.1848583644423565e-06 0.70443041051358346
+ 8.1848727203754163e-06 0.61922300900412075
+ 8.1848839651126286e-06 0.55410824110978407
+ 8.1848993470639921e-06 0.4681293433803686
+ 8.1849102308443413e-06 0.40990219563638047
+ 8.1849238857671911e-06 0.34080948069270878
+ 8.1849436456416342e-06 0.25115773363548771
+ 8.1849669331831478e-06 0.16515826032483319
+ 8.1849889838369024e-06 0.1048905148614612
+ 8.1850110428818685e-06 0.063420210067914193
+ 8.1850278728089841e-06 0.042196833752216563
+ 8.1850455025094451e-06 0.0271014240780467
+ 8.1850675158009372e-06 0.015164644264222109
+ 8.1850880673887464e-06 0.0086189294628843637
+ 8.1851143864583813e-06 0.0039654805963720077
+ 8.1851415561794797e-06 0.00162697288654333
+ 8.1851775297552249e-06 0.00032143554653124638
+ 8.1852190673862341e-06 -0.0001230781538027029
+ 8.1852779322176309e-06 -0.00018531050236464121
+ 8.1853568943741583e-06 -9.5480458930567323e-05
+ 8.185446635685244e-06 -2.4148303050698861e-05
+ 8.1855491401343494e-06 1.600651479062963e-06
+ 8.1856807731572668e-06 4.3378323478129779e-06
+ 8.1858657862170895e-06 1.4934837844721889e-06
+ 8.1860116763641611e-06 2.6741279310808739e-07
+ 8.1861369999638273e-06 1.9542795562851159e-08
+ 8.1862533012609012e-06 2.1915870562589209e-08
+ 8.186370059311598e-06 4.879489608808121e-08
+ 8.1864964981258726e-06 6.1332505026837711e-08
+ 8.1866159111714457e-06 6.4635168043702384e-08
+ 8.1867405341143382e-06 6.6675062970817647e-08
+ 8.1868592341631297e-06 6.9779434631082538e-08
+ 8.1869809737091453e-06 7.4715556111034184e-08
+ 8.1870990778979514e-06 8.7708188588790112e-08
+ 8.1872193724954327e-06 1.423936978187599e-07
+ 8.187288007386201e-06 3.6182666869685262e-07
+ 8.1873378989493973e-06 6.3406629317481787e-07
+ 8.1873946877782704e-06 6.0606931917805945e-07
+ 8.187460036396094e-06 1.416345271105223e-07
+ 8.1874969736730921e-06 -2.6338776253229632e-07
+ 8.1875238121106584e-06 -6.7407557913068095e-07
+ 8.1875475502367473e-06 -1.1606208330926239e-06
+ 8.1875700631358985e-06 -1.637352168637788e-06
+ 8.1875913869439793e-06 -1.726064130641245e-06
+ 8.1876175124644715e-06 -1.6817976874389209e-06
+ 8.1876360226561589e-06 -1.6813386385926739e-06
+ 8.1876595671197043e-06 -4.6098612730882978e-07
+ 8.1876984796419532e-06 1.1675588797660829e-06
+ 8.1877404611294585e-06 1.3859379931034511e-06
+ 8.1877990837522668e-06 6.8951403242956768e-07
+ 8.1878678050854919e-06 1.5381443534486289e-07
+ 8.1879471137425981e-06 2.9502318409078761e-08
+ 8.1880319301254343e-06 -1.6595535780619611e-08
+ 8.1881318060480454e-06 -3.6685530694848571e-09
+ 8.1882478443375707e-06 4.9191435912820252e-08
+ 8.1883751670138257e-06 7.3936758788723667e-08
+ 8.1885469475579742e-06 6.9775826950806163e-08
+ 8.1887963807973403e-06 6.1618918328991763e-08
+ 8.1891101563026729e-06 6.0790455079012146e-08
+ 8.1894684157198548e-06 6.176023141253527e-08
+ 8.1899063761195955e-06 6.2029433641483371e-08
+ 8.1904372392278608e-06 6.2058765106025689e-08
+ 8.1910386143216045e-06 6.1554741569006278e-08
+ 8.1914333553636651e-06 6.030629735978045e-08
+ 8.1917712422189095e-06 6.3082394172638823e-08
+ 8.1921980946836845e-06 6.2193580911419514e-08
+ 8.1926693269089581e-06 6.1729697436907453e-08
+ 8.1932250812365869e-06 6.1912508626584055e-08
+ 8.1938159420234592e-06 6.1921222407489869e-08
+ 8.1946419885007461e-06 6.1919031019414267e-08
+ 8.1957938129915261e-06 6.1921822089382232e-08
+ 8.1978175347730852e-06 6.1921391285463899e-08
+ 8.2008680284373512e-06 6.1921011072193627e-08
+ 8.205868028437352e-06 6.1920982439045886e-08
+ 8.2108680284373528e-06 6.1920994738632338e-08
+ 8.2158680284373536e-06 6.192099747836345e-08
+ 8.2208680284373544e-06 6.1920997931181281e-08
+ 8.2258680284373552e-06 6.1920998195941083e-08
+ 8.230868028437356e-06 6.1920998005223899e-08
+ 8.2358680284373568e-06 6.1920998017975795e-08
+ 8.2408680284373576e-06 6.1920998081037464e-08
+ 8.2458680284373584e-06 6.1920998178438629e-08
+ 8.2508680284373592e-06 6.1920997977742775e-08
+ 8.25586802843736e-06 6.1920998037033626e-08
+ 8.2608680284373608e-06 6.1920998096999032e-08
+ 8.2658680284373616e-06 6.1920998114633517e-08
+ 8.2708680284373624e-06 6.1920998254085196e-08
+ 8.2758680284373632e-06 6.1920998207814817e-08
+ 8.280868028437364e-06 6.1920998121259167e-08
+ 8.2858680284373648e-06 6.1920998161757626e-08
+ 8.2908680284373656e-06 6.1920998189243262e-08
+ 8.2958680284373664e-06 6.1920998231580179e-08
+ 8.3008680284373672e-06 6.1920998000691148e-08
+ 8.305868028437368e-06 6.1920998159780637e-08
+ 8.3108680284373688e-06 6.1920997932666659e-08
+ 8.3158680284373696e-06 6.1920998194837809e-08
+ 8.3208680284373704e-06 6.1920998280378899e-08
+ 8.3258680284373712e-06 6.1920998095828168e-08
+ 8.330868028437372e-06 6.1920998109456385e-08
+ 8.3358680284373728e-06 6.1920998164920923e-08
+ 8.3408680284373736e-06 6.1920998200424084e-08
+ 8.3458680284373744e-06 6.1920998279069359e-08
+ 8.3508680284373752e-06 6.1920998390233527e-08
+ 8.355868028437376e-06 6.1920998137206706e-08
+ 8.3608680284373768e-06 6.19209982361108e-08
+ 8.3658680284373776e-06 6.1920998003460416e-08
+ 8.3708680284373784e-06 6.1920998359964804e-08
+ 8.3758680284373792e-06 6.1920998093702724e-08
+ 8.38086802843738e-06 6.192099822892215e-08
+ 8.3858680284373808e-06 6.1920998257782138e-08
+ 8.3908680284373816e-06 6.1920998264309546e-08
+ 8.3958680284373824e-06 6.1920998127510376e-08
+ 8.4008680284373832e-06 6.1920998127974458e-08
+ 8.405868028437384e-06 6.1920998196314836e-08
+ 8.4108680284373848e-06 6.1920998250459181e-08
+ 8.4158680284373856e-06 6.1920998069659614e-08
+ 8.4208680284373864e-06 6.1920998175958887e-08
+ 8.4258680284373872e-06 6.1920998239970319e-08
+ 8.430868028437388e-06 6.1920997988887042e-08
+ 8.4358680284373888e-06 6.1920998040026564e-08
+ 8.4408680284373896e-06 6.192099833813077e-08
+ 8.4458680284373904e-06 6.1920998199258329e-08
+ 8.4508680284373912e-06 6.1920998073259292e-08
+ 8.455868028437392e-06 6.1920998087071806e-08
+ 8.4608680284373928e-06 6.1920998291365274e-08
+ 8.4658680284373936e-06 6.1920998111727122e-08
+ 8.4708680284373944e-06 6.1920998154603254e-08
+ 8.4758680284373952e-06 6.1920998161517611e-08
+ 8.480868028437396e-06 6.192099798593451e-08
+ 8.4858680284373968e-06 6.192099800138639e-08
+ 8.4908680284373976e-06 6.1920997810786824e-08
+ 8.4958680284373984e-06 6.1920997378638582e-08
+ 8.5008680284373992e-06 6.1920993444964331e-08
+ 8.5029593395423007e-06 6.1920904814302573e-08
+ 8.5047854096824716e-06 6.1920910205747155e-08
+ 8.5066873110824913e-06 6.192119489557956e-08
+ 8.5082213102730831e-06 6.1921059465030397e-08
+ 8.5098984292996631e-06 6.1920804305194911e-08
+ 8.5109221544081215e-06 6.1921272052578521e-08
+ 8.5112969373775475e-06 6.1921858039143157e-08
+ 8.5118441296145392e-06 6.1920904601090285e-08
+ 8.5121508793678721e-06 6.1925243732032239e-08
+ 8.5123958452463393e-06 6.1917021697047111e-08
+ 8.512596923016742e-06 6.1823219328991141e-08
+ 8.5128053063271593e-06 6.186377182620763e-08
+ 8.5130470809731529e-06 6.1979884027535128e-08
+ 8.5131979482726157e-06 6.1305440002497609e-08
+ 8.5132635594271866e-06 5.7433140114866648e-08
+ 8.513318114468918e-06 5.5675146709220979e-08
+ 8.5133615676553033e-06 5.9407676966844978e-08
+ 8.5134261243838118e-06 9.0903283563232835e-08
+ 8.513492062051664e-06 1.304655452232463e-07
+ 8.5135574916534793e-06 1.7183530191880971e-07
+ 8.5135870262977781e-06 3.302367123821088e-07
+ 8.5136076394837968e-06 6.4937669201933525e-07
+ 8.5136293704544253e-06 7.8417190664876391e-07
+ 8.5136568562934763e-06 2.6841621176652113e-07
+ 8.5136800173885833e-06 -7.6023295988384199e-07
+ 8.5137010090945645e-06 -2.6329112060622328e-06
+ 8.5137199647803066e-06 -4.1845167699605808e-06
+ 8.513735089544549e-06 -4.9968664220783081e-06
+ 8.5137496028392153e-06 -4.687639581684623e-06
+ 8.5137597208755933e-06 -2.5374020556241908e-06
+ 8.5137723143500201e-06 -6.5571889604504941e-07
+ 8.5137890444317363e-06 -5.0809193746113101e-07
+ 8.5138078332884847e-06 -1.591914023900167e-06
+ 8.5138322642530518e-06 -2.6428520337804889e-06
+ 8.5138572473568757e-06 -3.298273175744988e-06
+ 8.5138806081906204e-06 -3.3473692184705478e-06
+ 8.5139049447803368e-06 -2.0507908949418381e-06
+ 8.5139277632913742e-06 -5.5843610257329256e-07
+ 8.5139543028446068e-06 -5.0672614750196426e-07
+ 8.5139819857654852e-06 -1.6978798775075331e-06
+ 8.514011599537093e-06 -2.9669270416025662e-06
+ 8.5140350574711711e-06 -3.691559651631606e-06
+ 8.5140635038021908e-06 -3.7315653165555019e-06
+ 8.5140860851289648e-06 -6.1383491530121897e-07
+ 8.5141043112330183e-06 2.207850152652993e-06
+ 8.514121671254828e-06 -9.8564882624928372e-06
+ 8.5141395919998653e-06 -6.2349634706430706e-05
+ 8.5141617157116194e-06 -0.0001540781235620483
+ 8.5141843968101941e-06 -0.0001826342651506248
+ 8.5141977871094242e-06 -0.00011148198573684959
+ 8.5142120051524083e-06 1.9075484174571902e-05
+ 8.5142295476078354e-06 0.0001484191692461764
+ 8.5142463984334137e-06 0.00019163909272683911
+ 8.5142694832244319e-06 0.00017420134904825991
+ 8.5142944893864323e-06 0.00013066574254758841
+ 8.5143260559444308e-06 8.4899472006251658e-05
+ 8.5143588304752398e-06 6.1941337966819917e-05
+ 8.5143960743343427e-06 5.7398080253678393e-05
+ 8.5144387858078523e-06 6.8171419967065256e-05
+ 8.5144930475695249e-06 8.4094056784644178e-05
+ 8.514562585244385e-06 -0.00068461445218994158
+ 8.5146074352667965e-06 -0.0034180834914377782
+ 8.51464513527552e-06 -0.0075720093841177881
+ 8.514654132704241e-06 -0.0083636436417256332
+ 8.5146721275616813e-06 -0.0056965756824708096
+ 8.5146841965469138e-06 0.002468626786547056
+ 8.5146955174489424e-06 0.018058185722882369
+ 8.5147091589542872e-06 0.050740320561691532
+ 8.514721707419289e-06 0.095387875340795139
+ 8.5147340875475853e-06 0.1519950774999746
+ 8.5147447741640686e-06 0.20870615918890581
+ 8.5147576399278055e-06 0.28282712319013381
+ 8.5147717245506948e-06 0.36719136699888061
+ 8.5147886375343765e-06 0.46858548702735242
+ 8.5148100908187312e-06 0.59275586751819276
+ 8.5148387269995466e-06 0.7446406986839238
+ 8.5148746010952803e-06 0.90314283681935381
+ 8.514915545708679e-06 1.033473338176748
+ 8.5149752723372291e-06 1.14100542442761
+ 8.5150202879648377e-06 1.177476270860174
+ 8.5150732418470497e-06 1.195313335046895
+ 8.5151224939183381e-06 1.200447370145022
+ 8.5151889976097807e-06 1.2017143466206981
+ 8.5152679672336608e-06 1.2011857278189979
+ 8.5153971922861013e-06 1.20035760656957
+ 8.51553194563693e-06 1.2000257580131251
+ 8.5156611800671433e-06 1.1999686064457711
+ 8.5157832884718552e-06 1.1999798146868861
+ 8.5159022081317463e-06 1.1999930348082279
+ 8.5160291166463916e-06 1.1999990973033621
+ 8.5161476870849798e-06 1.200000370419138
+ 8.516271366883301e-06 1.20000031421827
+ 8.5163891820159406e-06 1.200000101717752
+ 8.5165104009675464e-06 1.199999988667581
+ 8.5166281146627779e-06 1.1999999571862849
+ 8.5167482049231508e-06 1.1999999547937079
+ 8.5168661936848526e-06 1.1999999583989049
+ 8.5169858002018836e-06 1.1999999631292491
+ 8.5170477419504195e-06 1.199999979661033
+ 8.5170938832396562e-06 1.199999997152867
+ 8.5171445228377872e-06 1.199999982772415
+ 8.5172084080115124e-06 1.199999933334795
+ 8.5172460460559591e-06 1.199999911114269
+ 8.5172760188276281e-06 1.1999998971239749
+ 8.5173003839695529e-06 1.199999869362274
+ 8.5173233426577718e-06 1.199999813687568
+ 8.5173461339325885e-06 1.199999732887304
+ 8.5173719535376383e-06 1.199999647515497
+ 8.5173984733701244e-06 1.199999831051801
+ 8.5174244661715873e-06 1.2000001567278391
+ 8.5174527395073473e-06 1.200000313783111
+ 8.5174985973870967e-06 1.200000244330713
+ 8.5175488385624287e-06 1.200000058061893
+ 8.5176165543466382e-06 1.1999999069995539
+ 8.5176939402414868e-06 1.1999998686988069
+ 8.5177749052526698e-06 1.1999998973176991
+ 8.5178775040208657e-06 1.199999944894907
+ 8.5179766305513851e-06 1.1999999687754921
+ 8.5181120625161206e-06 1.199999972279904
+ 8.5182811755517194e-06 1.199999964992376
+ 8.5185947627402131e-06 1.1999999592206081
+ 8.5189710292004884e-06 1.1999999594122159
+ 8.5194437413556914e-06 1.199999960326489
+ 8.5200119878330316e-06 1.199999960551984
+ 8.5206725544842892e-06 1.19999996049199
+ 8.5210955153281875e-06 1.1999999603956959
+ 8.5214429612219224e-06 1.199999960618195
+ 8.5218691699184471e-06 1.1999999605056819
+ 8.5224096872480756e-06 1.1999999604444609
+ 8.5229709129960878e-06 1.1999999604679421
+ 8.5236032459170214e-06 1.199999960480338
+ 8.5244595409016171e-06 1.199999960482651
+ 8.5257442056413519e-06 1.199999960481398
+ 8.5280100617920032e-06 1.199999960480878
+ 8.5314580497863517e-06 1.199999960480937
+ 8.5364580497863525e-06 1.1999999604808911
+ 8.5414580497863533e-06 1.19999996048086
+ 8.5464580497863541e-06 1.1999999604808611
+ 8.5514580497863549e-06 1.1999999604808651
+ 8.5564580497863557e-06 1.199999960480868
+ 8.5614580497863565e-06 1.199999960480868
+ 8.5664580497863573e-06 1.199999960480868
+ 8.5714580497863581e-06 1.199999960480868
+ 8.5764580497863589e-06 1.199999960480868
+ 8.5814580497863597e-06 1.199999960480868
+ 8.5864580497863605e-06 1.199999960480868
+ 8.5914580497863613e-06 1.199999960480868
+ 8.596458049786362e-06 1.199999960480868
+ 8.6014580497863628e-06 1.199999960480868
+ 8.6064580497863636e-06 1.199999960480868
+ 8.6114580497863644e-06 1.199999960480868
+ 8.6164580497863652e-06 1.199999960480868
+ 8.621458049786366e-06 1.199999960480868
+ 8.6264580497863668e-06 1.199999960480868
+ 8.6314580497863676e-06 1.199999960480868
+ 8.6364580497863684e-06 1.199999960480868
+ 8.6414580497863692e-06 1.199999960480868
+ 8.64645804978637e-06 1.199999960480868
+ 8.6514580497863708e-06 1.199999960480868
+ 8.6564580497863716e-06 1.199999960480868
+ 8.6614580497863724e-06 1.199999960480868
+ 8.6664580497863732e-06 1.199999960480868
+ 8.671458049786374e-06 1.199999960480868
+ 8.6764580497863748e-06 1.199999960480868
+ 8.6814580497863756e-06 1.199999960480868
+ 8.6864580497863764e-06 1.199999960480868
+ 8.6914580497863772e-06 1.199999960480868
+ 8.696458049786378e-06 1.199999960480868
+ 8.7014580497863788e-06 1.199999960480868
+ 8.7064580497863796e-06 1.199999960480868
+ 8.7114580497863804e-06 1.199999960480868
+ 8.7164580497863812e-06 1.199999960480868
+ 8.721458049786382e-06 1.199999960480868
+ 8.7264580497863828e-06 1.199999960480868
+ 8.7314580497863836e-06 1.199999960480868
+ 8.7364580497863844e-06 1.199999960480868
+ 8.7414580497863852e-06 1.199999960480868
+ 8.746458049786386e-06 1.199999960480868
+ 8.7514580497863868e-06 1.199999960480868
+ 8.7564580497863876e-06 1.1999999604808671
+ 8.7614580497863884e-06 1.199999960480866
+ 8.7664580497863892e-06 1.199999960480864
+ 8.77145804978639e-06 1.19999996048086
+ 8.7764580497863908e-06 1.1999999604808529
+ 8.7814580497863916e-06 1.1999999604808389
+ 8.7864580497863924e-06 1.199999960480814
+ 8.7914580497863932e-06 1.199999960480763
+ 8.796458049786394e-06 1.199999960480667
+ 8.8014580497863948e-06 1.1999999604804821
+ 8.8064580497863956e-06 1.199999960480135
+ 8.8114580497863964e-06 1.199999960479512
+ 8.8164580497863972e-06 1.1999999604784211
+ 8.821458049786398e-06 1.199999960476428
+ 8.8264580497863988e-06 1.1999999604714111
+ 8.8314580497863996e-06 1.199999960428404
+ 8.8334168236181728e-06 1.199999960107897
+ 8.8353581044101992e-06 1.1999999602014551
+ 8.8367583323050927e-06 1.1999999604523199
+ 8.8385664781480395e-06 1.199999960391668
+ 8.8398267588739147e-06 1.1999999605264331
+ 8.8403903520235897e-06 1.199999961032886
+ 8.8410201975123728e-06 1.199999961552189
+ 8.8413435727356579e-06 1.1999999639551391
+ 8.8416540230495143e-06 1.1999999666271679
+ 8.8418973687132464e-06 1.199999965811978
+ 8.8421074182588321e-06 1.199999925202796
+ 8.8423238466990905e-06 1.1999998692344329
+ 8.8425683536596639e-06 1.199999827231631
+ 8.8426988714080555e-06 1.199999653751961
+ 8.8427649915428609e-06 1.199999297608608
+ 8.8428228938931812e-06 1.1999988458209669
+ 8.8428683489103491e-06 1.199998528219103
+ 8.8429361135806755e-06 1.1999980178566849
+ 8.8430060990908706e-06 1.1999980944756481
+ 8.8430872155223491e-06 1.1999991450444889
+ 8.8431123159584034e-06 1.199999693746999
+ 8.843132285741431e-06 1.1999998011784201
+ 8.8431510114341295e-06 1.2000001020797539
+ 8.8431756754098727e-06 1.2000026886538431
+ 8.843202802062346e-06 1.200007883380354
+ 8.8432273130429511e-06 1.2000107128351349
+ 8.8432481634960189e-06 1.2000101145780011
+ 8.843265542820117e-06 1.2000078816693101
+ 8.843279960048894e-06 1.2000049696049699
+ 8.8432957826267e-06 1.2000019267618429
+ 8.8433133891846861e-06 1.1999996552790591
+ 8.8433399951511361e-06 1.199998023777451
+ 8.8433698701953996e-06 1.1999973259109791
+ 8.8433979152634019e-06 1.1999970889243681
+ 8.8434221387916043e-06 1.1999976149925771
+ 8.8434475617113094e-06 1.1999994322540419
+ 8.843477577668328e-06 1.2000025261322369
+ 8.8435081704077954e-06 1.200005368474049
+ 8.8435325995379247e-06 1.200007153833065
+ 8.8435491658007227e-06 1.2000084107610669
+ 8.8435648174945326e-06 1.200009912437525
+ 8.8435793468741394e-06 1.200011961406197
+ 8.8435948630560168e-06 1.200013336532024
+ 8.8436071961131252e-06 1.200012904689109
+ 8.8436209042048057e-06 1.200011270636747
+ 8.8436386037318744e-06 1.200008400465683
+ 8.8436665425283517e-06 1.200001128340549
+ 8.8436946055446569e-06 1.1999632773129441
+ 8.843719051084059e-06 1.1998873869816791
+ 8.8437457752167687e-06 1.199765972918212
+ 8.8437846487797592e-06 1.1994536823141591
+ 8.843805872763845e-06 1.1998296644435911
+ 8.843822007719213e-06 1.2015780004234491
+ 8.8438420976889839e-06 1.2067371541481451
+ 8.8438636804736614e-06 1.2146456916019479
+ 8.8438786331018354e-06 1.214084103410501
+ 8.8438923812044436e-06 1.1960060618157169
+ 8.8439102210998896e-06 1.1374916931387591
+ 8.8439307680415486e-06 1.035402662042946
+ 8.8439501658674726e-06 0.92206578627078728
+ 8.8439711312078491e-06 0.79444444588362306
+ 8.8439906406194507e-06 0.67668593507845698
+ 8.8440039410436147e-06 0.59829121188884515
+ 8.8440155460733554e-06 0.53169098632319278
+ 8.8440292503591695e-06 0.4557860836168815
+ 8.8440422982093504e-06 0.38696377797009829
+ 8.8440572266762705e-06 0.31357229537062759
+ 8.8440775809902791e-06 0.2256459927081656
+ 8.8441014388604873e-06 0.14417358844911321
+ 8.844123677501053e-06 0.089718089283976343
+ 8.8441399183009295e-06 0.061722762559313631
+ 8.844155711078785e-06 0.042219835173251348
+ 8.8441735139572818e-06 0.027060663232452591
+ 8.8441949243613169e-06 0.0154365238475063
+ 8.8442162959679853e-06 0.0085835736236990531
+ 8.8442421393540187e-06 0.0040098927689741397
+ 8.8442700199069639e-06 0.001601666329358907
+ 8.8443053858715915e-06 0.00032448413090033288
+ 8.8443475736013009e-06 -0.0001271910541726647
+ 8.8444056308443536e-06 -0.00018573469611850589
+ 8.8444854693483291e-06 -9.4895264685069346e-05
+ 8.8445745586394949e-06 -2.416248317401405e-05
+ 8.8446780097103705e-06 1.7257544377985311e-06
+ 8.8448093551546095e-06 4.3450398231100677e-06
+ 8.8449761240834152e-06 1.5311263529401309e-06
+ 8.8451157221712399e-06 2.7149964646785727e-07
+ 8.845240351396923e-06 1.171263057729202e-08
+ 8.8453584141067932e-06 1.7661940456957391e-08
+ 8.8454766479670752e-06 4.7858416653783907e-08
+ 8.8456048239066775e-06 6.1400475179487046e-08
+ 8.8457247051010705e-06 6.4561408484954211e-08
+ 8.8458497973265568e-06 6.6402263644601168e-08
+ 8.8459683837860922e-06 6.9366251421661072e-08
+ 8.8460902068566393e-06 7.3957086925204135e-08
+ 8.846208176643353e-06 8.5417833222543303e-08
+ 8.8463285276426949e-06 1.3079223692278189e-07
+ 8.8464029061225291e-06 3.211145805673407e-07
+ 8.8464534147775438e-06 6.0465165554897177e-07
+ 8.8465076564458262e-06 6.4213423091908288e-07
+ 8.8465732643405857e-06 2.1794753396581411e-07
+ 8.8466094540920123e-06 -1.6725954273861621e-07
+ 8.8466389961536566e-06 -5.6238301842390804e-07
+ 8.8466631494268576e-06 -1.007769167070017e-06
+ 8.8466860637454901e-06 -1.507500681527825e-06
+ 8.8467074431139432e-06 -1.7540482844586981e-06
+ 8.846735902593806e-06 -1.626492882766078e-06
+ 8.8467560826262101e-06 -1.7315450420818189e-06
+ 8.8467790647228469e-06 -6.5888870487235209e-07
+ 8.8468214608633105e-06 1.143441200128412e-06
+ 8.8468604844534169e-06 1.413336717585777e-06
+ 8.8469221192479903e-06 7.0519195106569488e-07
+ 8.8469862862836194e-06 1.7480057635974821e-07
+ 8.8470653423495055e-06 3.0386088488087072e-08
+ 8.8471505368316728e-06 -1.6951700778556841e-08
+ 8.8472508084176934e-06 -4.5365769389629691e-09
+ 8.8473666265482108e-06 4.8101583301986078e-08
+ 8.8474929924997829e-06 7.3623501611550655e-08
+ 8.8476626713854811e-06 7.0034932593732413e-08
+ 8.847907685499615e-06 6.175816006499894e-08
+ 8.8482200100372938e-06 6.0760544377234048e-08
+ 8.8485729924486976e-06 6.1735407876957891e-08
+ 8.8490073657085353e-06 6.2029599609281064e-08
+ 8.8495289728076266e-06 6.2056836911811908e-08
+ 8.8501515929444216e-06 6.160308128267676e-08
+ 8.8505486116620872e-06 6.0285851285073005e-08
+ 8.8508930814021188e-06 6.3028218938523567e-08
+ 8.8513280956173712e-06 6.2236089386360957e-08
+ 8.8517902072392464e-06 6.1725574119871212e-08
+ 8.8523374276892725e-06 6.1909400283844642e-08
+ 8.8529300107884231e-06 6.1922707647334396e-08
+ 8.8537498650095007e-06 6.1919208198641323e-08
+ 8.8549067981911796e-06 6.1921729002470318e-08
+ 8.8569074151696084e-06 6.1921384273058374e-08
+ 8.8599527704634408e-06 6.1921012653478527e-08
+ 8.8649527704634416e-06 6.192098268723509e-08
+ 8.8699527704634424e-06 6.1920994809179436e-08
+ 8.8749527704634432e-06 6.1920997577346635e-08
+ 8.879952770463444e-06 6.1920997977942172e-08
+ 8.8849527704634448e-06 6.1920997858616498e-08
+ 8.8899527704634456e-06 6.1920998085057257e-08
+ 8.8949527704634464e-06 6.1920998238717835e-08
+ 8.8999527704634472e-06 6.1920997968790616e-08
+ 8.904952770463448e-06 6.1920998112417903e-08
+ 8.9099527704634488e-06 6.1920998181081663e-08
+ 8.9149527704634496e-06 6.1920998170146216e-08
+ 8.9199527704634504e-06 6.1920998304829061e-08
+ 8.9249527704634512e-06 6.1920998276066469e-08
+ 8.929952770463452e-06 6.1920998138072837e-08
+ 8.9349527704634528e-06 6.1920997945110937e-08
+ 8.9399527704634536e-06 6.1920997950928597e-08
+ 8.9449527704634544e-06 6.1920998345203204e-08
+ 8.9499527704634552e-06 6.1920998071713484e-08
+ 8.954952770463456e-06 6.1920998163707535e-08
+ 8.9599527704634568e-06 6.1920998247453828e-08
+ 8.9649527704634576e-06 6.1920998212145829e-08
+ 8.9699527704634584e-06 6.1920998057565135e-08
+ 8.9749527704634592e-06 6.1920998140843098e-08
+ 8.97995277046346e-06 6.192099816068102e-08
+ 8.9849527704634608e-06 6.1920998268432584e-08
+ 8.9899527704634616e-06 6.1920998024670081e-08
+ 8.9949527704634624e-06 6.1920998072328522e-08
+ 8.9999527704634632e-06 6.1920998186978998e-08
+ 9.004952770463464e-06 6.1920998212390238e-08
+ 9.0099527704634648e-06 6.1920998053045301e-08
+ 9.0149527704634656e-06 6.1920998086899792e-08
+ 9.0199527704634664e-06 6.1920998135494932e-08
+ 9.0249527704634672e-06 6.1920998188641234e-08
+ 9.029952770463468e-06 6.1920997965314367e-08
+ 9.0349527704634688e-06 6.1920998085570784e-08
+ 9.0399527704634696e-06 6.1920998105104409e-08
+ 9.0449527704634704e-06 6.1920998149035363e-08
+ 9.0499527704634712e-06 6.1920998153828352e-08
+ 9.054952770463472e-06 6.1920998306186047e-08
+ 9.0599527704634728e-06 6.1920998019986479e-08
+ 9.0649527704634736e-06 6.192099809862781e-08
+ 9.0699527704634744e-06 6.1920998199716812e-08
+ 9.0749527704634752e-06 6.1920998015990654e-08
+ 9.079952770463476e-06 6.1920998288064624e-08
+ 9.0849527704634768e-06 6.1920998118429018e-08
+ 9.0899527704634776e-06 6.1920998142843949e-08
+ 9.0949527704634784e-06 6.1920998220979244e-08
+ 9.0999527704634792e-06 6.1920998227977153e-08
+ 9.10495277046348e-06 6.1920998062003336e-08
+ 9.1099527704634808e-06 6.1920997948910541e-08
+ 9.1149527704634816e-06 6.1920998125914341e-08
+ 9.1199527704634824e-06 6.192099809518204e-08
+ 9.1249527704634832e-06 6.1920997894587142e-08
+ 9.129952770463484e-06 6.1920998129865578e-08
+ 9.1349527704634848e-06 6.1920997924745829e-08
+ 9.1399527704634856e-06 6.1920998112603867e-08
+ 9.1449527704634864e-06 6.1920997961977546e-08
+ 9.1499527704634872e-06 6.1920997765857801e-08
+ 9.154952770463488e-06 6.1920997213159446e-08
+ 9.1599527704634888e-06 6.1920993284000317e-08
+ 9.1620529113256569e-06 6.1920907570880403e-08
+ 9.1638703022847069e-06 6.1920903890540075e-08
+ 9.165794348176845e-06 6.1921194984966762e-08
+ 9.1673161272363917e-06 6.1921065909809749e-08
+ 9.1689905522562497e-06 6.1920798204634515e-08
+ 9.1700221401865079e-06 6.1921266456093984e-08
+ 9.1704027504586992e-06 6.1921812060508166e-08
+ 9.1709585925590262e-06 6.1920920772541975e-08
+ 9.1712670833399828e-06 6.1925152640731167e-08
+ 9.1715124994112945e-06 6.191817559438729e-08
+ 9.1717126913659455e-06 6.1829830811472079e-08
+ 9.1719212713539302e-06 6.1854102027574395e-08
+ 9.1721648991798665e-06 6.1983330677462655e-08
+ 9.1723247891193066e-06 6.1387426226210289e-08
+ 9.172392448241474e-06 5.7471125340617997e-08
+ 9.1724466050859019e-06 5.5489445245755427e-08
+ 9.1724902558222307e-06 5.9515724513114633e-08
+ 9.172554794329297e-06 9.1300319395270436e-08
+ 9.172620620967071e-06 1.3073602122618539e-07
+ 9.1726856029124361e-06 1.7200842489832131e-07
+ 9.1727150273303554e-06 3.2885800163198028e-07
+ 9.1727356775688157e-06 6.4651943973696618e-07
+ 9.172757332362527e-06 7.8596475427484802e-07
+ 9.1727847521866694e-06 2.7548325785798629e-07
+ 9.1728080168606854e-06 -7.4483597076995431e-07
+ 9.1728290181130549e-06 -2.6113004743550018e-06
+ 9.1728478990650986e-06 -4.1694921010704686e-06
+ 9.1728630812165381e-06 -4.9802211255085684e-06
+ 9.1728774596303183e-06 -4.740749263223902e-06
+ 9.1728875199139994e-06 -2.6056703066316519e-06
+ 9.1729000858883936e-06 -6.8115453016864453e-07
+ 9.1729165327676932e-06 -4.8128412440966374e-07
+ 9.17293530699386e-06 -1.5545901225170951e-06
+ 9.1729595775398974e-06 -2.61635409955133e-06
+ 9.1729844925118571e-06 -3.277748338709184e-06
+ 9.1730104127066349e-06 -3.3235452455063831e-06
+ 9.1730342493059501e-06 -1.9950857597294989e-06
+ 9.173057197582391e-06 -5.3114133624951887e-07
+ 9.1730840812393246e-06 -5.4846111926386899e-07
+ 9.1731146426441752e-06 -1.879465289357919e-06
+ 9.1731427890567033e-06 -3.0387005673881531e-06
+ 9.1731647451397647e-06 -3.7056472610802102e-06
+ 9.1731923060510612e-06 -3.6604893258379812e-06
+ 9.1732132041870509e-06 -7.4931795651113027e-07
+ 9.1732308669904827e-06 2.260702130357717e-06
+ 9.1732480458903699e-06 -6.7779529181005384e-06
+ 9.17326585291295e-06 -5.4552736602009262e-05
+ 9.1732883224604519e-06 -0.0001476587759413903
+ 9.173309521038147e-06 -0.000187791313281319
+ 9.1733224632680374e-06 -0.0001353477616654227
+ 9.1733360118442083e-06 -1.6746816609371031e-05
+ 9.1733532083351081e-06 0.00012607426873738659
+ 9.173368686184279e-06 0.00018593807557206059
+ 9.1733911875305124e-06 0.0001832611147911865
+ 9.1734148713710999e-06 0.00014403618060882301
+ 9.1734461948034749e-06 9.422091677804221e-05
+ 9.1734776426926861e-06 6.6108756779966911e-05
+ 9.1735141864198284e-06 5.6944038149828093e-05
+ 9.173554403290515e-06 6.3530966560483354e-05
+ 9.1736056549436372e-06 8.6080819717123053e-05
+ 9.1736712308369058e-06 -0.0002256542857196062
+ 9.1737188401670193e-06 -0.002062071289026511
+ 9.173766253238486e-06 -0.0069313843416050564
+ 9.1737796692079508e-06 -0.0083588649560532614
+ 9.1737942411724304e-06 -0.0078105555358838532
+ 9.173803771410315e-06 -0.0047387653356221592
+ 9.1738133876152065e-06 0.0023373263550691839
+ 9.1738238494547954e-06 0.016809743968738949
+ 9.1738367877777481e-06 0.047304336251092809
+ 9.1738498963051799e-06 0.093507928674008381
+ 9.1738619419662845e-06 0.1484200989123183
+ 9.1738725386928209e-06 0.2044641567719061
+ 9.1738852588816504e-06 0.27760904954133248
+ 9.1738992300827978e-06 0.36127211113568358
+ 9.1739159403299924e-06 0.46159252205386608
+ 9.1739371222819029e-06 0.58461919608661528
+ 9.1739653581385759e-06 0.73545446820522742
+ 9.1740009859070811e-06 0.89501268568527415
+ 9.1740415554825054e-06 1.027109311222185
+ 9.174099021769192e-06 1.1351341731187969
+ 9.1741417022159001e-06 1.1729134394019891
+ 9.1741889244775625e-06 1.1917295992910151
+ 9.1742398457743404e-06 1.19915290194803
+ 9.174300504087416e-06 1.20134537197303
+ 9.1743793897410355e-06 1.20126429717508
+ 9.1744923391126455e-06 1.200545479038801
+ 9.174620192295505e-06 1.2001072596180169
+ 9.1747484259790712e-06 1.199984172006878
+ 9.1748721766540161e-06 1.1999775208889369
+ 9.1749925311954651e-06 1.19998974255264
+ 9.1751213219555499e-06 1.199997636986075
+ 9.1752404293915442e-06 1.1999999793309719
+ 9.1753647080428977e-06 1.200000307524526
+ 9.1754824481270358e-06 1.2000001489973069
+ 9.175603810461128e-06 1.2000000160475961
+ 9.1757213932152523e-06 1.199999966066108
+ 9.1758415689708856e-06 1.199999955798466
+ 9.1759594910875083e-06 1.19999995754612
+ 9.1760791552516603e-06 1.1999999612935679
+ 9.1761595896454723e-06 1.1999999716687639
+ 9.1762087876669937e-06 1.1999999929917251
+ 9.1762564008269396e-06 1.19999999304781
+ 9.1763240350839043e-06 1.199999945142276
+ 9.1763961690747607e-06 1.199999911200728
+ 9.1764283619288205e-06 1.1999998739159901
+ 9.1764512516527096e-06 1.199999808760563
+ 9.1764719258794479e-06 1.199999729616845
+ 9.1764954382809599e-06 1.199999640521846
+ 9.1765210681273564e-06 1.1999997472720769
+ 9.1765432026697226e-06 1.200000061334425
+ 9.176568595014547e-06 1.2000002836579129
+ 9.176613292401125e-06 1.2000002958228311
+ 9.1766606652500125e-06 1.2000001227959229
+ 9.1767251253090376e-06 1.199999939070739
+ 9.1767957867887263e-06 1.199999870786953
+ 9.1768696524135196e-06 1.1999998820176621
+ 9.1769607548085532e-06 1.19999992718152
+ 9.1770597958380541e-06 1.1999999620697299
+ 9.1771778702318714e-06 1.199999973277613
+ 9.1773298774430923e-06 1.1999999682105329
+ 9.1775633402982602e-06 1.1999999608516121
+ 9.1779668544608819e-06 1.1999999589920061
+ 9.178357564744585e-06 1.1999999599996931
+ 9.1789295645570584e-06 1.199999960532135
+ 9.1794796661312093e-06 1.1999999605319871
+ 9.1800387608868767e-06 1.199999960426041
+ 9.1806020723093887e-06 1.1999999605048779
+ 9.1810105594627508e-06 1.199999960584861
+ 9.1814594219139767e-06 1.1999999604327041
+ 9.1819755053176754e-06 1.199999960461372
+ 9.1825937675739316e-06 1.199999960481156
+ 9.18341045690225e-06 1.199999960482967
+ 9.1846342735344924e-06 1.1999999604814009
+ 9.1866129125146289e-06 1.19999996048088
+ 9.1897785664015919e-06 1.199999960480947
+ 9.1947785664015927e-06 1.1999999604809011
+ 9.1997785664015935e-06 1.199999960480862
+ 9.2047785664015943e-06 1.1999999604808591
+ 9.2097785664015951e-06 1.199999960480864
+ 9.2147785664015959e-06 1.1999999604808671
+ 9.2197785664015967e-06 1.199999960480868
+ 9.2247785664015975e-06 1.199999960480868
+ 9.2297785664015983e-06 1.1999999604808691
+ 9.2347785664015991e-06 1.199999960480868
+ 9.2397785664015999e-06 1.199999960480868
+ 9.2447785664016007e-06 1.199999960480868
+ 9.2497785664016015e-06 1.199999960480868
+ 9.2547785664016023e-06 1.199999960480868
+ 9.2597785664016031e-06 1.199999960480868
+ 9.2647785664016039e-06 1.199999960480868
+ 9.2697785664016047e-06 1.199999960480868
+ 9.2747785664016055e-06 1.199999960480868
+ 9.2797785664016063e-06 1.199999960480868
+ 9.2847785664016071e-06 1.199999960480868
+ 9.2897785664016079e-06 1.199999960480868
+ 9.2947785664016087e-06 1.199999960480868
+ 9.2997785664016095e-06 1.199999960480868
+ 9.3047785664016103e-06 1.199999960480868
+ 9.3097785664016111e-06 1.199999960480868
+ 9.3147785664016119e-06 1.199999960480868
+ 9.3197785664016127e-06 1.199999960480868
+ 9.3247785664016135e-06 1.199999960480868
+ 9.3297785664016143e-06 1.199999960480868
+ 9.3347785664016151e-06 1.199999960480868
+ 9.3397785664016159e-06 1.199999960480868
+ 9.3447785664016167e-06 1.199999960480868
+ 9.3497785664016175e-06 1.199999960480868
+ 9.3547785664016183e-06 1.199999960480868
+ 9.3597785664016191e-06 1.199999960480868
+ 9.3647785664016199e-06 1.199999960480868
+ 9.3697785664016207e-06 1.199999960480868
+ 9.3747785664016215e-06 1.199999960480868
+ 9.3797785664016223e-06 1.199999960480868
+ 9.3847785664016231e-06 1.199999960480868
+ 9.3897785664016239e-06 1.199999960480868
+ 9.3947785664016247e-06 1.199999960480868
+ 9.3997785664016255e-06 1.199999960480868
+ 9.4047785664016263e-06 1.199999960480868
+ 9.4097785664016271e-06 1.199999960480868
+ 9.4147785664016279e-06 1.1999999604808671
+ 9.4197785664016287e-06 1.1999999604808671
+ 9.4247785664016295e-06 1.199999960480864
+ 9.4297785664016303e-06 1.1999999604808611
+ 9.4347785664016311e-06 1.199999960480854
+ 9.4397785664016319e-06 1.199999960480842
+ 9.4447785664016327e-06 1.1999999604808189
+ 9.4497785664016335e-06 1.199999960480773
+ 9.4547785664016343e-06 1.1999999604806859
+ 9.4597785664016351e-06 1.19999996048052
+ 9.4647785664016359e-06 1.1999999604802061
+ 9.4697785664016367e-06 1.1999999604796381
+ 9.4747785664016375e-06 1.1999999604786411
+ 9.4797785664016383e-06 1.199999960476851
+ 9.4847785664016391e-06 1.199999960472715
+ 9.4897785664016399e-06 1.1999999604476741
+ 9.491823531804812e-06 1.199999960223763
+ 9.4936630226516658e-06 1.1999999601010429
+ 9.4953946465318503e-06 1.1999999603385481
+ 9.4970182678699547e-06 1.199999960487794
+ 9.4987269679310496e-06 1.199999960407812
+ 9.4997063108374997e-06 1.199999960875584
+ 9.5000584977331168e-06 1.199999962179557
+ 9.5005598882744085e-06 1.1999999629967051
+ 9.5008612789271694e-06 1.1999999673783119
+ 9.5011008334030127e-06 1.1999999635578551
+ 9.5013042129929069e-06 1.199999914034898
+ 9.5015151059564218e-06 1.199999863275762
+ 9.5017583366947795e-06 1.199999818429881
+ 9.5018742189029396e-06 1.1999996087122049
+ 9.5019365602046585e-06 1.1999992331505689
+ 9.5019918601757766e-06 1.199998792721173
+ 9.5020393200523409e-06 1.1999984591165369
+ 9.5021044860445213e-06 1.1999979865523369
+ 9.5021754966268758e-06 1.1999981454004709
+ 9.5022578007447765e-06 1.199999293004159
+ 9.5022819184826211e-06 1.199999769369229
+ 9.502300965723409e-06 1.199999703893835
+ 9.5023231876705731e-06 1.2000007926429259
+ 9.5023499583760901e-06 1.2000046419695289
+ 9.5023736323256875e-06 1.2000092346741711
+ 9.5023969977666324e-06 1.200010865994634
+ 9.5024165002931149e-06 1.200009574151838
+ 9.5024336270257523e-06 1.2000069086063241
+ 9.5024458096366616e-06 1.20000431786554
+ 9.5024609490824127e-06 1.2000015096310279
+ 9.5024822773939644e-06 1.1999991115118529
+ 9.5025102562756322e-06 1.1999977800847661
+ 9.5025409412554747e-06 1.199997203897686
+ 9.5025713457417578e-06 1.1999971822527129
+ 9.5026046449793062e-06 1.199998775145902
+ 9.5026310102559013e-06 1.2000013727506731
+ 9.5026593970932834e-06 1.200004332825195
+ 9.5026849499520998e-06 1.200006442303813
+ 9.5027036202679712e-06 1.200007800171752
+ 9.502719347253476e-06 1.2000090982737359
+ 9.5027351548463391e-06 1.200010951744434
+ 9.50274888134504e-06 1.200012855479488
+ 9.5027649169564943e-06 1.2000132399054391
+ 9.5027745502327487e-06 1.2000124188826959
+ 9.5027892923997661e-06 1.2000103404835969
+ 9.5028134155636648e-06 1.2000061895478329
+ 9.5028394533633278e-06 1.1999930553090381
+ 9.50286288933364e-06 1.1999479681438781
+ 9.5028844186288204e-06 1.1998741943645641
+ 9.5029136461722575e-06 1.1997335553994599
+ 9.5029553199462405e-06 1.1994598637916429
+ 9.5029741773240563e-06 1.2002534675057801
+ 9.5029909543138574e-06 1.2028709295212301
+ 9.5030152103660819e-06 1.2106212932562079
+ 9.5030384365941771e-06 1.2137348832466071
+ 9.5030543904297994e-06 1.195062171490946
+ 9.5030735782132585e-06 1.133303205453202
+ 9.5030918561551068e-06 1.0436778499563359
+ 9.503109289625537e-06 0.94313240817395105
+ 9.5031316113587643e-06 0.8079814493485914
+ 9.5031529488477571e-06 0.6793068483078285
+ 9.5031669772953145e-06 0.596660121721446
+ 9.5031788563561734e-06 0.52855758528458674
+ 9.5031927183174146e-06 0.45192768650843068
+ 9.5032066991320251e-06 0.37857715974386102
+ 9.5032220637693507e-06 0.30390376825759968
+ 9.5032423328337436e-06 0.2178946550909463
+ 9.5032661275934751e-06 0.13861426229193541
+ 9.5032886497500256e-06 0.085314288616988171
+ 9.5033041310332359e-06 0.059606567294721767
+ 9.5033201294789766e-06 0.040516248582533387
+ 9.5033383089558502e-06 0.025673545411425719
+ 9.5033595344313391e-06 0.014688132324341831
+ 9.5033813996547517e-06 0.0080320423174816118
+ 9.5034072645634603e-06 0.0037300756089759571
+ 9.5034358653915566e-06 0.001432087391332834
+ 9.5034716287234836e-06 0.00025877022210035429
+ 9.5035151291578224e-06 -0.0001461888191417904
+ 9.5035745700146492e-06 -0.00018014577217378459
+ 9.503657926609581e-06 -8.5153875086755191e-05
+ 9.5037458194740763e-06 -2.0691028526457559e-05
+ 9.5038535955041422e-06 2.7164652633591551e-06
+ 9.5039863907841229e-06 4.1278677323567984e-06
+ 9.5041426511926119e-06 1.3575917302126631e-06
+ 9.5042783301959718e-06 2.1734710253768359e-07
+ 9.5044023000012759e-06 1.8616206501988329e-09
+ 9.5045212350448896e-06 1.88159043605944e-08
+ 9.5046402265092172e-06 4.9547948794451919e-08
+ 9.5047688237846e-06 6.19882438406193e-08
+ 9.50488892673148e-06 6.4611009442445941e-08
+ 9.505013988854259e-06 6.6326761391137424e-08
+ 9.5051325629867273e-06 6.9286854386396899e-08
+ 9.5052543068053635e-06 7.385108051028006e-08
+ 9.5053722644544644e-06 8.5108789076138627e-08
+ 9.505492582025634e-06 1.292762888327492e-07
+ 9.5055678819153724e-06 3.1560189467015032e-07
+ 9.5056185048548099e-06 6.0043216737193959e-07
+ 9.505672447036696e-06 6.4621352213555765e-07
+ 9.5057381459006833e-06 2.2758385226795289e-07
+ 9.5057740761704883e-06 -1.5453561330862331e-07
+ 9.5058041120660815e-06 -5.493975158419882e-07
+ 9.5058284945692967e-06 -9.9212060445143594e-07
+ 9.5058515213638215e-06 -1.493908591638879e-06
+ 9.5058729393377528e-06 -1.7534595622906389e-06
+ 9.5059016181418319e-06 -1.62510602191875e-06
+ 9.5059221054506266e-06 -1.729157945196537e-06
+ 9.505945085014867e-06 -6.6378825164202e-07
+ 9.5059867272126645e-06 1.1253135430916371e-06
+ 9.5060259918872196e-06 1.4142162612850409e-06
+ 9.5060869416162363e-06 7.1743345827082887e-07
+ 9.5061513814341707e-06 1.7813974505675651e-07
+ 9.5062312560687482e-06 3.0016173194139523e-08
+ 9.5063164569084737e-06 -1.6950033660932821e-08
+ 9.5064172016889573e-06 -4.8628889351106477e-09
+ 9.5065326726446644e-06 4.7757403403548229e-08
+ 9.5066593468790767e-06 7.3626372621576454e-08
+ 9.5068287077830195e-06 7.0091740779040421e-08
+ 9.5070743866906724e-06 6.1762551927080004e-08
+ 9.5073871824316905e-06 6.0755858571728994e-08
+ 9.5077412974060064e-06 6.1736826453871087e-08
+ 9.5081767129825727e-06 6.2029325211466547e-08
+ 9.5087002695509976e-06 6.2057446295463609e-08
+ 9.5093192241414732e-06 6.1595309213119259e-08
+ 9.5097156413895878e-06 6.0288141704162761e-08
+ 9.5100588889035383e-06 6.303748521889704e-08
+ 9.5104925259352977e-06 6.2229331759625054e-08
+ 9.5109558486445726e-06 6.1726299478380219e-08
+ 9.5115041375543928e-06 6.1909865404039788e-08
+ 9.5120963905359014e-06 6.1922471102845183e-08
+ 9.5129167751432167e-06 6.1919177901267944e-08
+ 9.5140724745171026e-06 6.1921741526695136e-08
+ 9.5160749373828609e-06 6.1921386535184069e-08
+ 9.5191196021132506e-06 6.19210125073317e-08
+ 9.5241196021132514e-06 6.1920982486664689e-08
+ 9.5291196021132522e-06 6.1920995130971924e-08
+ 9.534119602113253e-06 6.1920997588608692e-08
+ 9.5391196021132538e-06 6.1920998001366775e-08
+ 9.5441196021132546e-06 6.1920998033890405e-08
+ 9.5491196021132554e-06 6.1920998101437405e-08
+ 9.5541196021132562e-06 6.192099819059604e-08
+ 9.559119602113257e-06 6.1920997978126785e-08
+ 9.5641196021132578e-06 6.1920997988609718e-08
+ 9.5691196021132586e-06 6.192099831975435e-08
+ 9.5741196021132594e-06 6.1920998139140324e-08
+ 9.5791196021132602e-06 6.1920998209527796e-08
+ 9.584119602113261e-06 6.1920998030711875e-08
+ 9.5891196021132618e-06 6.1920998078333906e-08
+ 9.5941196021132626e-06 6.1920998149808095e-08
+ 9.5991196021132634e-06 6.1920998203330704e-08
+ 9.6041196021132642e-06 6.1920997932988995e-08
+ 9.609119602113265e-06 6.1920998298637793e-08
+ 9.6141196021132658e-06 6.1920998360924029e-08
+ 9.6191196021132666e-06 6.1920998165705037e-08
+ 9.6241196021132674e-06 6.1920997987391235e-08
+ 9.6291196021132682e-06 6.1920997981236799e-08
+ 9.634119602113269e-06 6.1920998326675496e-08
+ 9.6391196021132698e-06 6.1920998107554915e-08
+ 9.6441196021132706e-06 6.192099817443215e-08
+ 9.6491196021132714e-06 6.1920998260375528e-08
+ 9.6541196021132722e-06 6.1920998254257554e-08
+ 9.659119602113273e-06 6.1920998388423338e-08
+ 9.6641196021132738e-06 6.1920998170323789e-08
+ 9.6691196021132746e-06 6.1920998219903738e-08
+ 9.6741196021132754e-06 6.1920998230014412e-08
+ 9.6791196021132762e-06 6.1920998088115139e-08
+ 9.684119602113277e-06 6.192099812684212e-08
+ 9.6891196021132778e-06 6.1920998188659908e-08
+ 9.6941196021132786e-06 6.1920998261644992e-08
+ 9.6991196021132794e-06 6.1920998048183822e-08
+ 9.7041196021132802e-06 6.1920998045711108e-08
+ 9.709119602113281e-06 6.1920998147323231e-08
+ 9.7141196021132818e-06 6.1920997949483691e-08
+ 9.7191196021132826e-06 6.1920998000362499e-08
+ 9.7241196021132834e-06 6.1920998061222147e-08
+ 9.7291196021132842e-06 6.1920998170226976e-08
+ 9.734119602113285e-06 6.1920997896402982e-08
+ 9.7391196021132858e-06 6.1920998262586389e-08
+ 9.7441196021132866e-06 6.1920998081891948e-08
+ 9.7491196021132874e-06 6.192099810402828e-08
+ 9.7541196021132882e-06 6.19209981485554e-08
+ 9.759119602113289e-06 6.1920998257792606e-08
+ 9.7641196021132898e-06 6.1920998035330811e-08
+ 9.7691196021132906e-06 6.1920998147426741e-08
+ 9.7741196021132914e-06 6.1920998105635869e-08
+ 9.7791196021132922e-06 6.1920998139084592e-08
+ 9.784119602113293e-06 6.1920997907687949e-08
+ 9.7891196021132938e-06 6.1920998177745412e-08
+ 9.7941196021132946e-06 6.1920998225304684e-08
+ 9.7991196021132954e-06 6.1920998166198858e-08
+ 9.8041196021132962e-06 6.1920998026481395e-08
+ 9.809119602113297e-06 6.1920997784450862e-08
+ 9.8141196021132978e-06 6.192099733476872e-08
+ 9.8191196021132986e-06 6.1920993302387536e-08
+ 9.8212185277460963e-06 6.1920907392106542e-08
+ 9.8230371258433514e-06 6.1920904581804377e-08
+ 9.8249582021991685e-06 6.1921194975284143e-08
+ 9.8264816005003602e-06 6.1921065066475543e-08
+ 9.8281563478168713e-06 6.1920799668273924e-08
+ 9.8291869826501125e-06 6.1921266067109402e-08
+ 9.8295668096391872e-06 6.1921818942300363e-08
+ 9.8301214157429728e-06 6.1920919819190828e-08
+ 9.8304296498513708e-06 6.1925164707861629e-08
+ 9.8306750018596986e-06 6.1918026019575501e-08
+ 9.8308753424354163e-06 6.1828925274944482e-08
+ 9.8310839165414111e-06 6.1855392394331477e-08
+ 9.8313272605207402e-06 6.1982917504659183e-08
+ 9.8314858732205154e-06 6.1376831912759981e-08
+ 9.8315532459279379e-06 5.7467038237353269e-08
+ 9.8316074659282366e-06 5.5517375798713573e-08
+ 9.8316510849059223e-06 5.9491871868776908e-08
+ 9.8317156313262245e-06 9.1225614807535485e-08
+ 9.8317814732462465e-06 1.3068489306228489e-07
+ 9.8318465407962291e-06 1.719682406073093e-07
+ 9.8318759879706575e-06 3.2907793771960659e-07
+ 9.8318966315513185e-06 6.4699198116637171e-07
+ 9.8319182983692792e-06 7.8568057534286528e-07
+ 9.8319457296244717e-06 2.743194913720167e-07
+ 9.8319689769442988e-06 -7.4737548852501035e-07
+ 9.8319899769016396e-06 -2.614902206142174e-06
+ 9.8320088704366644e-06 -4.1720151928812244e-06
+ 9.8320240429371901e-06 -4.9829992553886661e-06
+ 9.8320384435387662e-06 -4.7319786891002758e-06
+ 9.832048513146547e-06 -2.5943021624418932e-06
+ 9.8320610833629907e-06 -6.7686485133208732e-07
+ 9.8320775767526034e-06 -4.8563164272360189e-07
+ 9.8320963527240664e-06 -1.560761917901398e-06
+ 9.8321206493040324e-06 -2.6207167035663511e-06
+ 9.8321455728172589e-06 -3.281096126490939e-06
+ 9.8321715036331268e-06 -3.3194255667727288e-06
+ 9.8321952580123006e-06 -1.9868317202488058e-06
+ 9.832218221668273e-06 -5.2682445809323607e-07
+ 9.8322451532512862e-06 -5.5261885624897497e-07
+ 9.832275660213704e-06 -1.8846646017434979e-06
+ 9.8323038587373219e-06 -3.0446745060109101e-06
+ 9.8323258021868598e-06 -3.7095105158070288e-06
+ 9.8323532941817431e-06 -3.6537654394849519e-06
+ 9.8323740773172401e-06 -7.5277441887919815e-07
+ 9.8323916965553601e-06 2.262591127706352e-06
+ 9.8324088714789376e-06 -6.6262978470096662e-06
+ 9.8324266749200439e-06 -5.4152293612068563e-05
+ 9.8324491660244512e-06 -0.0001473223754373917
+ 9.8324702846645944e-06 -0.00018796183431484461
+ 9.8324832338010492e-06 -0.00013631425840932829
+ 9.832496754616032e-06 -1.8358432769729849e-05
+ 9.8325121819977111e-06 0.0001144455319523716
+ 9.8325283335790229e-06 0.0001840562636797239
+ 9.8325517499723217e-06 0.0001849619873214281
+ 9.8325747381885785e-06 0.00014661672265021939
+ 9.8326064924082393e-06 9.5093398027086895e-05
+ 9.832637198176083e-06 6.6699129034500972e-05
+ 9.8326741927389883e-06 5.6822464780705228e-05
+ 9.8327137027254641e-06 6.3012798778096807e-05
+ 9.8327651818522252e-06 8.566208259904713e-05
+ 9.8328296686128018e-06 -0.00018985554934354399
+ 9.8328776124166614e-06 -0.0019221257140680081
+ 9.8329242015493715e-06 -0.0065775341130678566
+ 9.8329386068354277e-06 -0.0082359690574302941
+ 9.8329531263628098e-06 -0.0081642989885145883
+ 9.8329623974043485e-06 -0.0058545798019161346
+ 9.832972306528368e-06 0.00037802742250770549
+ 9.8329828181169073e-06 0.013487697201336111
+ 9.8329958561129306e-06 0.042166385611731319
+ 9.8330084630271834e-06 0.084353923590600094
+ 9.8330233070026483e-06 0.1507604626658757
+ 9.8330346266382204e-06 0.21090596012699939
+ 9.8330477776375495e-06 0.28689089073564211
+ 9.8330621308624773e-06 0.37297309103377468
+ 9.8330791274841794e-06 0.47479522664075702
+ 9.8331009870043667e-06 0.60091437631971845
+ 9.8331299846711561e-06 0.75361191576343356
+ 9.8331663046324819e-06 0.91178348361752426
+ 9.8332076022322399e-06 1.0400290944371871
+ 9.8332621180701169e-06 1.137451733402387
+ 9.8333056589903453e-06 1.174492626056256
+ 9.8333586887289877e-06 1.1940212198598601
+ 9.8334072023630174e-06 1.1998695275571769
+ 9.8334736960140652e-06 1.201617659136446
+ 9.8335505410948383e-06 1.201240707793984
+ 9.833675834914354e-06 1.200428280534267
+ 9.833809165305002e-06 1.2000529966714399
+ 9.8339384367491186e-06 1.1999732838841479
+ 9.8340610345754982e-06 1.1999788639525399
+ 9.8341802970109172e-06 1.1999918916062411
+ 9.8343077226313469e-06 1.1999986099951661
+ 9.8344263916922529e-06 1.2000002462295569
+ 9.8345502503355618e-06 1.2000003156930861
+ 9.8346680246276219e-06 1.20000011880719
+ 9.8347893003535185e-06 1.1999999979938021
+ 9.8349069686536811e-06 1.199999960077256
+ 9.835027094068996e-06 1.199999955062109
+ 9.8351450576767907e-06 1.1999999580827869
+ 9.8352646852816251e-06 1.1999999624698301
+ 9.8353311772608061e-06 1.1999999768214249
+ 9.835377948010997e-06 1.1999999957129019
+ 9.8354271420531474e-06 1.199999987149496
+ 9.8354919565781391e-06 1.199999938087426
+ 9.8355404323357488e-06 1.199999911805534
+ 9.8355678148923219e-06 1.1999998945505059
+ 9.8355933850727893e-06 1.1999998612482039
+ 9.8356165170844238e-06 1.1999998007873161
+ 9.835639416814596e-06 1.199999717011865
+ 9.8356681412017057e-06 1.1999996536939641
+ 9.83569062848685e-06 1.199999879805455
+ 9.8357155635208138e-06 1.2000001808703751
+ 9.8357492698476026e-06 1.2000003210058441
+ 9.8358034784785677e-06 1.200000198182015
+ 9.835853745823911e-06 1.2000000197536069
+ 9.8359274003720037e-06 1.1999998869540911
+ 9.836010631724234e-06 1.1999998708348589
+ 9.8361077461044939e-06 1.1999999146531779
+ 9.8362033607368164e-06 1.199999955006062
+ 9.8363180824131517e-06 1.199999972869582
+ 9.8364568924522831e-06 1.199999970327813
+ 9.836672540980467e-06 1.199999962058345
+ 9.8370734707322879e-06 1.1999999587436061
+ 9.8374467738195994e-06 1.199999959783175
+ 9.8380084500759674e-06 1.199999960512582
+ 9.838600178387181e-06 1.199999960549001
+ 9.839144486373817e-06 1.1999999604390881
+ 9.8396656122077528e-06 1.199999960479381
+ 9.8400362126409086e-06 1.1999999606094149
+ 9.8404546854445982e-06 1.199999960439408
+ 9.840932620485988e-06 1.1999999604557681
+ 9.8415316871034947e-06 1.199999960478459
+ 9.8422503998620864e-06 1.199999960482663
+ 9.8433329017224616e-06 1.1999999604817391
+ 9.8449481619104385e-06 1.1999999604809539
+ 9.8477180970353065e-06 1.199999960480937
+ 9.8521806606917727e-06 1.1999999604809239
+ 9.8571806606917735e-06 1.1999999604808691
+ 9.8621806606917743e-06 1.199999960480858
+ 9.8671806606917751e-06 1.1999999604808631
+ 9.8721806606917759e-06 1.199999960480866
+ 9.8771806606917767e-06 1.199999960480868
+ 9.8821806606917775e-06 1.199999960480868
+ 9.8871806606917783e-06 1.199999960480868
+ 9.8921806606917791e-06 1.1999999604808691
+ 9.8971806606917799e-06 1.199999960480868
+ 9.9021806606917807e-06 1.199999960480868
+ 9.9071806606917815e-06 1.199999960480868
+ 9.9121806606917823e-06 1.199999960480868
+ 9.9171806606917831e-06 1.199999960480868
+ 9.9221806606917839e-06 1.199999960480868
+ 9.9271806606917847e-06 1.199999960480868
+ 9.9321806606917855e-06 1.199999960480868
+ 9.9371806606917863e-06 1.199999960480868
+ 9.9421806606917871e-06 1.199999960480868
+ 9.9471806606917879e-06 1.199999960480868
+ 9.9521806606917887e-06 1.199999960480868
+ 9.9571806606917895e-06 1.199999960480868
+ 9.9621806606917903e-06 1.199999960480868
+ 9.9671806606917911e-06 1.199999960480868
+ 9.9721806606917919e-06 1.199999960480868
+ 9.9771806606917927e-06 1.199999960480868
+ 9.9821806606917935e-06 1.199999960480868
+ 9.9871806606917943e-06 1.199999960480868
+ 9.9921806606917951e-06 1.199999960480868
+ 9.9971806606917959e-06 1.199999960480868
+ 1.00021806606918e-05 1.199999960480868
+ 1.0007180660691801e-05 1.199999960480868
+ 1.00121806606918e-05 1.199999960480868
+ 1.0017180660691801e-05 1.199999960480868
+ 1.00221806606918e-05 1.199999960480868
+ 1.0027180660691801e-05 1.199999960480868
+ 1.00321806606918e-05 1.199999960480868
+ 1.0037180660691801e-05 1.199999960480868
+ 1.00421806606918e-05 1.199999960480868
+ 1.00471806606918e-05 1.199999960480868
+ 1.00521806606918e-05 1.199999960480868
+ 1.0057180660691811e-05 1.199999960480868
+ 1.006218066069181e-05 1.199999960480868
+ 1.006718066069181e-05 1.199999960480868
+ 1.007218066069181e-05 1.1999999604808671
+ 1.007718066069181e-05 1.1999999604808671
+ 1.0082180660691809e-05 1.1999999604808651
+ 1.008718066069181e-05 1.199999960480862
+ 1.0092180660691809e-05 1.1999999604808571
+ 1.009718066069181e-05 1.1999999604808469
+ 1.0102180660691809e-05 1.1999999604808289
+ 1.010718066069181e-05 1.199999960480792
+ 1.0112180660691809e-05 1.1999999604807241
+ 1.011718066069182e-05 1.1999999604805911
+ 1.0122180660691819e-05 1.19999996048034
+ 1.012718066069182e-05 1.199999960479875
+ 1.0132180660691821e-05 1.199999960479057
+ 1.013718066069182e-05 1.199999960477615
+ 1.0142180660691821e-05 1.1999999604747029
+ 1.014718066069182e-05 1.1999999604639271
+ 1.014976663771511e-05 1.1999999603863629
+ 1.0151463578303891e-05 1.199999960117818
+ 1.015354873668748e-05 1.1999999601867339
+ 1.01550715191108e-05 1.199999960417945
+ 1.015694927510749e-05 1.1999999604325
+ 1.015818846029586e-05 1.199999960519029
+ 1.015873591279858e-05 1.199999961047826
+ 1.015938225995251e-05 1.1999999615444701
+ 1.015970958726025e-05 1.199999964068486
+ 1.016001268011146e-05 1.199999966868319
+ 1.0160250963337909e-05 1.199999965549819
+ 1.0160458176848489e-05 1.199999923949675
+ 1.016067353748146e-05 1.1999998684676561
+ 1.016091668206397e-05 1.1999998262873679
+ 1.016104601701508e-05 1.199999652131996
+ 1.016111181873402e-05 1.1999992974131199
+ 1.016116981372292e-05 1.199998843984641
+ 1.0161215113820401e-05 1.1999985257814989
+ 1.0161282838275021e-05 1.199998011572381
+ 1.0161352725799809e-05 1.1999980835350821
+ 1.016143358205834e-05 1.199999133050714
+ 1.0161458667532719e-05 1.19999968632834
+ 1.016147866104113e-05 1.1999998073355631
+ 1.016149719931541e-05 1.2000000786169001
+ 1.0161521743113401e-05 1.2000026172965641
+ 1.016154917433741e-05 1.2000078632247131
+ 1.016157358328039e-05 1.200010732243922
+ 1.0161594372598091e-05 1.2000101708975619
+ 1.016161154885143e-05 1.200007990965047
+ 1.0161626265508639e-05 1.200005034012013
+ 1.016164224314543e-05 1.200001950227805
+ 1.0161659409770211e-05 1.199999705732216
+ 1.016168615816709e-05 1.1999980306145841
+ 1.0161715840940701e-05 1.199997328876852
+ 1.016174359074159e-05 1.199997082170668
+ 1.016176767728802e-05 1.1999975644375469
+ 1.016179303923674e-05 1.1999993235973181
+ 1.0161824210079271e-05 1.200002505953832
+ 1.016185359998809e-05 1.200005267078285
+ 1.0161877721970569e-05 1.2000070557070961
+ 1.016189422541769e-05 1.200008292581483
+ 1.0161909811676509e-05 1.200009732420964
+ 1.0161924679625639e-05 1.2000117670436641
+ 1.0161939413373461e-05 1.200013278333256
+ 1.016195273790971e-05 1.2000129919504421
+ 1.0161966961606949e-05 1.2000113642717301
+ 1.0161982812300561e-05 1.200008811719256
+ 1.0162009183532749e-05 1.200003055900047
+ 1.016203700293995e-05 1.1999723443941881
+ 1.016206224892628e-05 1.1998999270409401
+ 1.016208879774598e-05 1.1997850173325639
+ 1.0162124927625501e-05 1.1995093082740551
+ 1.016214892510598e-05 1.199669396138862
+ 1.0162165103668471e-05 1.201017260326382
+ 1.016218305038872e-05 1.2049480577934799
+ 1.0162204216677719e-05 1.212661449713816
+ 1.0162220789761709e-05 1.2156838179985749
+ 1.0162234834589121e-05 1.203852876895567
+ 1.0162251036925521e-05 1.1600121611364069
+ 1.0162268072109839e-05 1.0839018706443679
+ 1.0162285709242361e-05 0.98599012777441142
+ 1.016230698409213e-05 0.85812503038530574
+ 1.016232746821544e-05 0.73356630982065096
+ 1.016234216332199e-05 0.64565542008198828
+ 1.016235339480713e-05 0.579978906459791
+ 1.0162365939380361e-05 0.5086607074940066
+ 1.0162379024222979e-05 0.43708258311470233
+ 1.0162391730084201e-05 0.37101884316363021
+ 1.016241149922603e-05 0.27736975316971951
+ 1.0162434487025821e-05 0.18661556109731539
+ 1.01624568336749e-05 0.1196591145417316
+ 1.016248374604817e-05 0.065223496244596571
+ 1.0162500103791749e-05 0.043906707471808137
+ 1.016251684332005e-05 0.028900127254985478
+ 1.016253630615438e-05 0.017452789381692781
+ 1.016255754602682e-05 0.0098245167530754338
+ 1.0162581827533781e-05 0.0048924709420989651
+ 1.016260951801265e-05 0.0020345353859254822
+ 1.016264278348552e-05 0.00053745229720609145
+ 1.0162683631089839e-05 -7.0608045943552889e-05
+ 1.0162737134066281e-05 -0.0001944932321018003
+ 1.0162811305365451e-05 -0.000118496763536918
+ 1.016290268252461e-05 -3.4222277117064862e-05
+ 1.016299835235213e-05 -1.6273452479027021e-06
+ 1.0163126136801751e-05 4.6762984103012638e-06
+ 1.016329144665782e-05 2.1077220440165968e-06
+ 1.0163430354523701e-05 4.5834863557547688e-07
+ 1.0163555170880849e-05 3.3914153829981103e-08
+ 1.016367369438668e-05 7.7417871216312221e-09
+ 1.0163792324435869e-05 4.0832383337553857e-08
+ 1.016392205328977e-05 5.9479167105495938e-08
+ 1.016404213623697e-05 6.4005558625489424e-08
+ 1.016416798340824e-05 6.5793606566684047e-08
+ 1.016428645781874e-05 6.8427750613373286e-08
+ 1.0164408581964949e-05 7.2295555425629796e-08
+ 1.016452639580968e-05 8.0796284127495693e-08
+ 1.0164646898560891e-05 1.095695015111188e-07
+ 1.016474095619704e-05 2.431691568661602e-07
+ 1.016479450232224e-05 5.4594338559425997e-07
+ 1.016484578837693e-05 6.8187276288204544e-07
+ 1.016491401351006e-05 3.2581417438455982e-07
+ 1.0164961212306289e-05 -1.29615885650008e-07
+ 1.0164989351437229e-05 -5.1835595687818373e-07
+ 1.01650148998441e-05 -9.9598301518133174e-07
+ 1.016503807377706e-05 -1.506607363755388e-06
+ 1.01650595982914e-05 -1.7652394732732681e-06
+ 1.016508827582877e-05 -1.6336150743000679e-06
+ 1.016510870564087e-05 -1.7320414343474691e-06
+ 1.0165131698725871e-05 -6.5691156684720621e-07
+ 1.016517371264737e-05 1.138938990575759e-06
+ 1.0165212876957151e-05 1.4145668678966951e-06
+ 1.0165274142097351e-05 7.0996484548451781e-07
+ 1.0165338522309521e-05 1.75437831559709e-07
+ 1.0165417809866371e-05 3.0110886763370432e-08
+ 1.01655029730212e-05 -1.7029299912479821e-08
+ 1.0165603349565261e-05 -4.6501336886404162e-09
+ 1.016571907611847e-05 4.8015086619965587e-08
+ 1.0165845535359359e-05 7.3630681889740362e-08
+ 1.016601516044156e-05 7.0049961713341978e-08
+ 1.016626039549082e-05 6.175840171356291e-08
+ 1.0166574513075801e-05 6.0758807329482154e-08
+ 1.016692871506298e-05 6.1735969849781474e-08
+ 1.016736589015338e-05 6.203009004613299e-08
+ 1.0167890176278401e-05 6.2057726337074628e-08
+ 1.0168507012599651e-05 6.1589573185049935e-08
+ 1.016890308925075e-05 6.0290116423123228e-08
+ 1.016924551268396e-05 6.3045338577121215e-08
+ 1.016967813611783e-05 6.2223437497889511e-08
+ 1.0170142760054509e-05 6.1726835619262245e-08
+ 1.017069229482726e-05 6.1910294704200267e-08
+ 1.017128434592638e-05 6.192227292669188e-08
+ 1.0172105734335391e-05 6.1919154607052237e-08
+ 1.0173260945099041e-05 6.1921755376830057e-08
+ 1.0175267212911871e-05 6.1921386589071922e-08
+ 1.0178313216600669e-05 6.1921012572371787e-08
+ 1.018331321660067e-05 6.192098219835397e-08
+ 1.0188313216600669e-05 6.1920994924992001e-08
+ 1.019331321660067e-05 6.1920997804784616e-08
+ 1.0198313216600671e-05 6.1920997978419396e-08
+ 1.020331321660067e-05 6.1920998102962104e-08
+ 1.0208313216600671e-05 6.1920998248322606e-08
+ 1.021331321660067e-05 6.1920998043604153e-08
+ 1.0218313216600671e-05 6.1920998115525707e-08
+ 1.022331321660067e-05 6.1920998154079682e-08
+ 1.0228313216600671e-05 6.1920998278892819e-08
+ 1.023331321660067e-05 6.1920998049156348e-08
+ 1.0238313216600681e-05 6.1920998098291803e-08
+ 1.024331321660068e-05 6.1920998172743325e-08
+ 1.024831321660068e-05 6.1920998219280387e-08
+ 1.025331321660068e-05 6.1920998243809615e-08
+ 1.025831321660068e-05 6.1920998101416706e-08
+ 1.0263313216600679e-05 6.1920998148962505e-08
+ 1.026831321660068e-05 6.1920998220575196e-08
+ 1.0273313216600679e-05 6.1920998009316722e-08
+ 1.027831321660068e-05 6.1920998297218814e-08
+ 1.0283313216600679e-05 6.1920998117712653e-08
+ 1.028831321660068e-05 6.1920998146361412e-08
+ 1.0293313216600679e-05 6.1920998194727867e-08
+ 1.029831321660069e-05 6.1920998062994669e-08
+ 1.0303313216600689e-05 6.1920998111006786e-08
+ 1.030831321660069e-05 6.1920998165182961e-08
+ 1.0313313216600689e-05 6.1920998215117948e-08
+ 1.031831321660069e-05 6.1920998259404682e-08
+ 1.0323313216600691e-05 6.1920998103752942e-08
+ 1.032831321660069e-05 6.19209980946784e-08
+ 1.0333313216600691e-05 6.1920998193802232e-08
+ 1.033831321660069e-05 6.1920998235350945e-08
+ 1.0343313216600691e-05 6.192099805116457e-08
+ 1.034831321660069e-05 6.192099810973044e-08
+ 1.035331321660069e-05 6.1920997893884118e-08
+ 1.035831321660069e-05 6.1920998168855722e-08
+ 1.0363313216600701e-05 6.1920998296053177e-08
+ 1.03683132166007e-05 6.1920998335433327e-08
+ 1.03733132166007e-05 6.1920998063649227e-08
+ 1.03783132166007e-05 6.1920998176220991e-08
+ 1.03833132166007e-05 6.1920998222335066e-08
+ 1.0388313216600699e-05 6.1920998285586074e-08
+ 1.03933132166007e-05 6.1920998074646574e-08
+ 1.0398313216600699e-05 6.1920998149395339e-08
+ 1.04033132166007e-05 6.1920998214490125e-08
+ 1.0408313216600699e-05 6.1920998193366751e-08
+ 1.04133132166007e-05 6.1920998324088353e-08
+ 1.0418313216600699e-05 6.1920998085294691e-08
+ 1.042331321660071e-05 6.1920998168253561e-08
+ 1.0428313216600709e-05 6.1920998011899379e-08
+ 1.043331321660071e-05 6.1920998182392632e-08
+ 1.0438313216600711e-05 6.1920998050168592e-08
+ 1.044331321660071e-05 6.1920998116154311e-08
+ 1.0448313216600711e-05 6.1920998155569216e-08
+ 1.045331321660071e-05 6.1920998069593387e-08
+ 1.0458313216600711e-05 6.1920997915382065e-08
+ 1.046331321660071e-05 6.1920997864357939e-08
+ 1.0468313216600711e-05 6.1920997900590104e-08
+ 1.047331321660071e-05 6.192099755519262e-08
+ 1.047831321660071e-05 6.1920993388931381e-08
+ 1.04804104288749e-05 6.1920906924574412e-08
+ 1.0482230750599681e-05 6.1920905906628295e-08
+ 1.048414760102237e-05 6.1921194652318183e-08
+ 1.048567333532155e-05 6.1921064530510945e-08
+ 1.0487348572927139e-05 6.1920799980566012e-08
+ 1.04883777676567e-05 6.192126818354412e-08
+ 1.0488756468356511e-05 6.1921827135950732e-08
+ 1.0489309352342669e-05 6.1920916848885662e-08
+ 1.048961723396336e-05 6.1925181358519296e-08
+ 1.0489862496790509e-05 6.1917810262765434e-08
+ 1.0490063062811151e-05 6.1827644020436902e-08
+ 1.049027162755186e-05 6.1857245227484381e-08
+ 1.0490514581051831e-05 6.1982286758029343e-08
+ 1.0490671368862881e-05 6.1361141929900693e-08
+ 1.049073832975263e-05 5.7460303301478402e-08
+ 1.049079263575512e-05 5.5556209218548088e-08
+ 1.0490836211800331e-05 5.9463395339709212e-08
+ 1.0490900766185529e-05 9.1130944727328536e-08
+ 1.0490966630200839e-05 1.306202135673916e-07
+ 1.0491031805439171e-05 1.7192109895756361e-07
+ 1.0491061280441399e-05 3.2937536531545097e-07
+ 1.049108191545656e-05 6.4762141161917463e-07
+ 1.0491103598614499e-05 7.852948530882605e-07
+ 1.049113104482376e-05 2.7276586430224148e-07
+ 1.049115426916767e-05 -7.5076502360527211e-07
+ 1.049117526722927e-05 -2.6196868508337638e-06
+ 1.049119417740116e-05 -4.1753548566262153e-06
+ 1.049120933713281e-05 -4.9866874543597422e-06
+ 1.0491223767390331e-05 -4.720276487985164e-06
+ 1.049123384957105e-05 -2.5791930628693258e-06
+ 1.049124642563462e-05 -6.7119666436281333e-07
+ 1.0491262981233259e-05 -4.9148190557378402e-07
+ 1.049128175995173e-05 -1.5689918560485119e-06
+ 1.0491306091547171e-05 -2.626545426028484e-06
+ 1.049133102809094e-05 -3.2855899110927279e-06
+ 1.04913569740365e-05 -3.313750192833863e-06
+ 1.04913806208597e-05 -1.975460791170117e-06
+ 1.0491403607127379e-05 -5.2093056060209035e-07
+ 1.049143060502972e-05 -5.585087591983759e-07
+ 1.049146103760825e-05 -1.891963013572005e-06
+ 1.0491489308234891e-05 -3.0530186648230549e-06
+ 1.049151123362852e-05 -3.7148854656319758e-06
+ 1.0491538629805659e-05 -3.6441981952917161e-06
+ 1.049155924938357e-05 -7.5759961183052652e-07
+ 1.049157680587146e-05 2.264700435213997e-06
+ 1.049159397680052e-05 -6.4148869165176868e-06
+ 1.049161177628926e-05 -5.3592440241214189e-05
+ 1.049163429832842e-05 -0.00014685073191719381
+ 1.049165530455134e-05 -0.00018818339333209061
+ 1.049166826380908e-05 -0.00013765168855560411
+ 1.049168174738219e-05 -2.059921544434711e-05
+ 1.049169710650842e-05 0.0001124458920271614
+ 1.0491713225408549e-05 0.0001834306055656013
+ 1.049173642816073e-05 0.00018559056798465301
+ 1.049175944452028e-05 0.0001475168047529409
+ 1.049179105994832e-05 9.5968318820169009e-05
+ 1.0491821744002989e-05 6.7100807769424149e-05
+ 1.0491858615986221e-05 5.6844258745409023e-05
+ 1.0491898009997509e-05 6.2724275872994361e-05
+ 1.0491949198917881e-05 8.521999469379452e-05
+ 1.049201336941705e-05 -0.00016851121671957061
+ 1.049206175101683e-05 -0.001850733229511476
+ 1.049210798198886e-05 -0.0063901240453653526
+ 1.0492122961853629e-05 -0.0081587812823467314
+ 1.049213739039591e-05 -0.0082939232740412792
+ 1.049214649900198e-05 -0.0063369249939233662
+ 1.0492156595156569e-05 -0.00049591867722395858
+ 1.049216717581084e-05 0.01203332176730396
+ 1.049218026417183e-05 0.039868342175657323
+ 1.04921926870127e-05 0.080412022874515945
+ 1.0492209385327109e-05 0.15473197202546521
+ 1.0492221333706721e-05 0.21868105448306499
+ 1.0492234944655501e-05 0.29774931515172331
+ 1.0492249586369069e-05 0.38568008887370281
+ 1.0492267053597981e-05 0.49001606365643802
+ 1.0492289591631679e-05 0.61899926407419092
+ 1.049231959220348e-05 0.77423996844653231
+ 1.049235649434867e-05 0.92967294563370051
+ 1.049239887940817e-05 1.0541415081868231
+ 1.049244520516833e-05 1.1340325437467109
+ 1.049248667347057e-05 1.1709177732427321
+ 1.0492539485425139e-05 1.192291721669442
+ 1.049258732017444e-05 1.1990577109698211
+ 1.0492653972509189e-05 1.201456571529296
+ 1.0492728841282969e-05 1.2012887059894759
+ 1.049285010348208e-05 1.2005138544176861
+ 1.0492981922747731e-05 1.2000898088480461
+ 1.049311120394964e-05 1.19998088362564
+ 1.04932343012623e-05 1.1999782304009721
+ 1.049335392175673e-05 1.1999905390360539
+ 1.0493481886694381e-05 1.1999979626422119
+ 1.0493600664592741e-05 1.2000000608648309
+ 1.0493724710865281e-05 1.200000306419617
+ 1.049384244669379e-05 1.2000001378808041
+ 1.049396378155055e-05 1.2000000099850969
+ 1.0494081404409229e-05 1.1999999641864181
+ 1.04942015659026e-05 1.1999999556319949
+ 1.0494319504339199e-05 1.199999957777147
+ 1.0494439154421131e-05 1.1999999618406261
+ 1.049451116170709e-05 1.1999999742954099
+ 1.0494558845083111e-05 1.1999999943377679
+ 1.0494607088901239e-05 1.1999999903026379
+ 1.0494673091141989e-05 1.199999941888249
+ 1.04947309788056e-05 1.199999912018298
+ 1.0494760288509621e-05 1.199999889229652
+ 1.049478418650196e-05 1.199999846752803
+ 1.0494806026658989e-05 1.1999997810922041
+ 1.0494828466816489e-05 1.199999696906658
+ 1.049485616181921e-05 1.199999659539156
+ 1.0494876015421379e-05 1.199999894752741
+ 1.0494900734551749e-05 1.2000001912646669
+ 1.049493797557433e-05 1.2000003250667151
+ 1.0494989660859959e-05 1.2000001939999481
+ 1.049504299271452e-05 1.200000008395643
+ 1.049511573150239e-05 1.1999998844906581
+ 1.0495195686697741e-05 1.199999871584339
+ 1.0495287992206821e-05 1.199999913909835
+ 1.049538565556022e-05 1.1999999551700591
+ 1.0495497688490511e-05 1.199999972720277
+ 1.049563870805566e-05 1.199999970345857
+ 1.049584750636166e-05 1.199999962233014
+ 1.049623913768634e-05 1.199999958777491
+ 1.0496612132499239e-05 1.1999999597685309
+ 1.04971646904215e-05 1.199999960501188
+ 1.049775364592837e-05 1.199999960548993
+ 1.0498299982680889e-05 1.1999999604443949
+ 1.049879227513434e-05 1.1999999604635829
+ 1.049914592174357e-05 1.199999960621055
+ 1.04995520679599e-05 1.199999960447073
+ 1.050001681671478e-05 1.199999960452963
+ 1.0500607727715539e-05 1.1999999604764531
+ 1.0501282628249951e-05 1.19999996048223
+ 1.050229937183865e-05 1.199999960481932
+ 1.050376092162419e-05 1.1999999604810361
+ 1.0506316889504419e-05 1.1999999604809251
+ 1.051029344042077e-05 1.1999999604809359
+ 1.0515293440420769e-05 1.199999960480876
+ 1.052029344042077e-05 1.199999960480858
+ 1.0525293440420769e-05 1.199999960480862
+ 1.053029344042077e-05 1.199999960480866
+ 1.0535293440420769e-05 1.199999960480868
+ 1.054029344042077e-05 1.199999960480868
+ 1.0545293440420771e-05 1.199999960480868
+ 1.055029344042077e-05 1.199999960480868
+ 1.0555293440420779e-05 1.199999960480868
+ 1.056029344042078e-05 1.199999960480868
+ 1.0565293440420781e-05 1.199999960480868
+ 1.057029344042078e-05 1.199999960480868
+ 1.0575293440420781e-05 1.199999960480868
+ 1.058029344042078e-05 1.199999960480868
+ 1.0585293440420781e-05 1.199999960480868
+ 1.059029344042078e-05 1.199999960480868
+ 1.059529344042078e-05 1.199999960480868
+ 1.060029344042078e-05 1.199999960480868
+ 1.060529344042078e-05 1.199999960480868
+ 1.061029344042078e-05 1.199999960480868
+ 1.061529344042079e-05 1.199999960480868
+ 1.062029344042079e-05 1.199999960480868
+ 1.062529344042079e-05 1.199999960480868
+ 1.0630293440420789e-05 1.199999960480868
+ 1.063529344042079e-05 1.199999960480868
+ 1.0640293440420789e-05 1.199999960480868
+ 1.064529344042079e-05 1.199999960480868
+ 1.0650293440420789e-05 1.199999960480868
+ 1.065529344042079e-05 1.199999960480868
+ 1.0660293440420789e-05 1.199999960480868
+ 1.066529344042079e-05 1.199999960480868
+ 1.0670293440420791e-05 1.199999960480868
+ 1.067529344042079e-05 1.199999960480868
+ 1.0680293440420799e-05 1.199999960480868
+ 1.06852934404208e-05 1.199999960480868
+ 1.0690293440420801e-05 1.199999960480868
+ 1.06952934404208e-05 1.199999960480868
+ 1.0700293440420801e-05 1.199999960480868
+ 1.07052934404208e-05 1.199999960480868
+ 1.0710293440420801e-05 1.199999960480868
+ 1.07152934404208e-05 1.199999960480868
+ 1.07202934404208e-05 1.199999960480868
+ 1.07252934404208e-05 1.199999960480868
+ 1.07302934404208e-05 1.199999960480868
+ 1.0735293440420799e-05 1.1999999604808671
+ 1.074029344042081e-05 1.199999960480866
+ 1.074529344042081e-05 1.1999999604808631
+ 1.075029344042081e-05 1.1999999604808591
+ 1.0755293440420809e-05 1.19999996048085
+ 1.076029344042081e-05 1.199999960480834
+ 1.0765293440420809e-05 1.1999999604808029
+ 1.077029344042081e-05 1.1999999604807421
+ 1.0775293440420809e-05 1.1999999604806271
+ 1.078029344042081e-05 1.199999960480407
+ 1.0785293440420809e-05 1.199999960479998
+ 1.079029344042081e-05 1.199999960479273
+ 1.0795293440420811e-05 1.1999999604780001
+ 1.080029344042081e-05 1.1999999604755649
+ 1.0805293440420821e-05 1.199999960468177
+ 1.0808672511547959e-05 1.199999960417734
+ 1.0810464776423329e-05 1.199999960151253
+ 1.081243546870184e-05 1.1999999601543481
+ 1.0814050012905591e-05 1.199999960380562
+ 1.081609604698318e-05 1.1999999604582881
+ 1.081764775700158e-05 1.199999960526869
+ 1.0818201027847281e-05 1.1999999613739349
+ 1.081869470327548e-05 1.1999999622436679
+ 1.081896973857518e-05 1.1999999649669799
+ 1.081927021246787e-05 1.199999967380631
+ 1.081949918817321e-05 1.1999999589033279
+ 1.081971725149791e-05 1.199999901902953
+ 1.081992833705984e-05 1.1999998539062411
+ 1.082014986213694e-05 1.199999798147211
+ 1.082024986391668e-05 1.199999551448705
+ 1.08203133176845e-05 1.1999991416171181
+ 1.082036333042374e-05 1.1999987366810689
+ 1.082041442998479e-05 1.1999983548415369
+ 1.0820478563459731e-05 1.199997946527491
+ 1.0820550292545181e-05 1.199998256974351
+ 1.0820619456887179e-05 1.199999327477735
+ 1.082064137900156e-05 1.199999758938495
+ 1.0820660976541541e-05 1.199999776657245
+ 1.0820681778899021e-05 1.200000446249722
+ 1.082070686339329e-05 1.2000035586118061
+ 1.082073065703478e-05 1.200008373403147
+ 1.0820757406676639e-05 1.2000108919447801
+ 1.082077857136594e-05 1.200009746688798
+ 1.082079660307863e-05 1.200007007929371
+ 1.0820809172339269e-05 1.2000043360241119
+ 1.082082497317892e-05 1.2000014095382101
+ 1.082084595899386e-05 1.1999990583028839
+ 1.082087390753194e-05 1.1999977333720071
+ 1.082090529435841e-05 1.199997162344939
+ 1.082093516090311e-05 1.1999971774866369
+ 1.082096936748751e-05 1.1999988757068429
+ 1.082099554593129e-05 1.200001491081905
+ 1.082102419910408e-05 1.2000044638055991
+ 1.0821049829388031e-05 1.200006551733515
+ 1.0821068216393419e-05 1.200007896235183
+ 1.0821083960461569e-05 1.200009222629838
+ 1.082109963625366e-05 1.20001112614554
+ 1.0821113377253959e-05 1.20001296858448
+ 1.082112906434646e-05 1.200013205130438
+ 1.082113998245936e-05 1.2000121906025161
+ 1.0821154391099161e-05 1.2000100727174821
+ 1.082117880588488e-05 1.20000577979407
+ 1.082120150465478e-05 1.199994692686188
+ 1.082122523400865e-05 1.1999502923271319
+ 1.0821246856968179e-05 1.1998770710679181
+ 1.082127567479126e-05 1.1997407740003101
+ 1.082131725743937e-05 1.1994471446219199
+ 1.08213364863349e-05 1.2001589157700461
+ 1.082135313021285e-05 1.202608317090617
+ 1.0821377813364731e-05 1.2103219534591041
+ 1.0821400785711149e-05 1.2142198882887141
+ 1.0821416550186221e-05 1.1978053567490889
+ 1.0821433796822299e-05 1.1463225528657781
+ 1.0821451780057219e-05 1.0619332775399959
+ 1.0821469182199209e-05 0.96328388403208765
+ 1.0821491192579869e-05 0.83045813642401078
+ 1.082151198477139e-05 0.70454632272446704
+ 1.082152625234397e-05 0.6198480340529624
+ 1.082153751804175e-05 0.55459671895707285
+ 1.082155264541624e-05 0.46998128820398238
+ 1.082156331102254e-05 0.41281653281729502
+ 1.0821577187912781e-05 0.34244404400576001
+ 1.082159681440431e-05 0.25312848105762642
+ 1.082162019700975e-05 0.1663732671542266
+ 1.082164219391164e-05 0.105884289449309
+ 1.08216648840116e-05 0.06310232396501618
+ 1.0821681865835789e-05 0.041799784589857912
+ 1.082169954261044e-05 0.026794642237699898
+ 1.082172158929441e-05 0.014966336161192461
+ 1.0821742134780399e-05 0.0085016964703189396
+ 1.0821768522206e-05 0.003898610303496558
+ 1.0821795749343939e-05 0.0015923573978735099
+ 1.082183189165063e-05 0.00030639008047302801
+ 1.082187361887899e-05 -0.00012707374996624509
+ 1.082193289022344e-05 -0.00018411572537961241
+ 1.082201246576189e-05 -9.3436014252293361e-05
+ 1.082210203513247e-05 -2.3378506143006219e-05
+ 1.082220550556203e-05 1.841291506880593e-06
+ 1.082233774527609e-05 4.2988284380932451e-06
+ 1.082250333715305e-05 1.4986760142307459e-06
+ 1.0822642493978211e-05 2.6253650055946402e-07
+ 1.0822766995871281e-05 1.065964727293241e-08
+ 1.082288512825894e-05 1.8084368074153321e-08
+ 1.082300343995659e-05 4.8163217510347441e-08
+ 1.082313162557015e-05 6.1466637087858781e-08
+ 1.082325153558119e-05 6.4496998680815296e-08
+ 1.082337660633243e-05 6.6291935289907215e-08
+ 1.0823495198522321e-05 6.9226702834041837e-08
+ 1.0823617003959631e-05 7.3721634382102213e-08
+ 1.082373497784789e-05 8.4716462746032868e-08
+ 1.082385531853976e-05 1.273797690334167e-07
+ 1.082393185102996e-05 3.088046719839651e-07
+ 1.0823982634474429e-05 5.9530778746291602e-07
+ 1.08240362254653e-05 6.5098384764130755e-07
+ 1.082410205587765e-05 2.3899681744295742e-07
+ 1.082413770825501e-05 -1.399309334658041e-07
+ 1.0824168320064619e-05 -5.3484806705515342e-07
+ 1.082419296386677e-05 -9.746068354853741e-07
+ 1.0824216115073691e-05 -1.478523256767195e-06
+ 1.082423757753796e-05 -1.752548193659521e-06
+ 1.0824266502084169e-05 -1.6242936903012141e-06
+ 1.082428734172279e-05 -1.7264136313940669e-06
+ 1.0824310334892841e-05 -6.6866346475049562e-07
+ 1.08243511460462e-05 1.105082510141339e-06
+ 1.082439069286619e-05 1.4152196819050419e-06
+ 1.0824450881291911e-05 7.308334576706417e-07
+ 1.082451564130268e-05 1.8171054627783631e-07
+ 1.082459641804353e-05 2.9498200569883401e-08
+ 1.08246816487114e-05 -1.7013393194630219e-08
+ 1.082478289542856e-05 -5.2116098710958737e-09
+ 1.0824898003111919e-05 4.7411668244101338e-08
+ 1.082502501881031e-05 7.3638987738592819e-08
+ 1.082519408195824e-05 7.0148550449837212e-08
+ 1.082544056682968e-05 6.176345231580789e-08
+ 1.082575360907126e-05 6.0752692232474859e-08
+ 1.08261089004135e-05 6.1737567971011913e-08
+ 1.082654507080983e-05 6.2029565345034296e-08
+ 1.082707055642889e-05 6.205791888673487e-08
+ 1.082768597572699e-05 6.1587662744073949e-08
+ 1.08280818754269e-05 6.0290692505336112e-08
+ 1.0828423960006199e-05 6.3046570985620743e-08
+ 1.082885625642707e-05 6.2222555504518262e-08
+ 1.0829320872227789e-05 6.172699997163879e-08
+ 1.0829870330818979e-05 6.191034016243783e-08
+ 1.0830462274632861e-05 6.1922237055243929e-08
+ 1.083128335088188e-05 6.1919145990321736e-08
+ 1.08324379729016e-05 6.1921756429197542e-08
+ 1.083444293237654e-05 6.1921388045276525e-08
+ 1.083748745304564e-05 6.192101254206332e-08
+ 1.0842487453045641e-05 6.1920982244172404e-08
+ 1.084748745304564e-05 6.1920994802491833e-08
+ 1.0852487453045651e-05 6.1920997456272275e-08
+ 1.085748745304565e-05 6.1920997844722458e-08
+ 1.0862487453045651e-05 6.1920998209993465e-08
+ 1.086748745304565e-05 6.1920998159762228e-08
+ 1.0872487453045651e-05 6.1920998026460338e-08
+ 1.087748745304565e-05 6.1920998126568012e-08
+ 1.0882487453045651e-05 6.1920998199712378e-08
+ 1.088748745304565e-05 6.1920997939855322e-08
+ 1.089248745304565e-05 6.1920998256995125e-08
+ 1.089748745304565e-05 6.1920998125720688e-08
+ 1.090248745304565e-05 6.1920998138264743e-08
+ 1.0907487453045649e-05 6.192099794671208e-08
+ 1.091248745304566e-05 6.1920998250422335e-08
+ 1.091748745304566e-05 6.1920998341892483e-08
+ 1.092248745304566e-05 6.1920997863274848e-08
+ 1.0927487453045659e-05 6.1920998219925165e-08
+ 1.093248745304566e-05 6.1920997959660263e-08
+ 1.0937487453045659e-05 6.1920998303181846e-08
+ 1.094248745304566e-05 6.192099811099056e-08
+ 1.0947487453045659e-05 6.192099814495146e-08
+ 1.095248745304566e-05 6.1920998246661177e-08
+ 1.0957487453045661e-05 6.1920997988835704e-08
+ 1.096248745304566e-05 6.1920998347254096e-08
+ 1.0967487453045661e-05 6.1920998097528335e-08
+ 1.097248745304566e-05 6.1920998197012262e-08
+ 1.0977487453045671e-05 6.1920997982606782e-08
+ 1.098248745304567e-05 6.1920998023305749e-08
+ 1.0987487453045671e-05 6.1920998102809943e-08
+ 1.099248745304567e-05 6.1920998134495566e-08
+ 1.0997487453045671e-05 6.1920998229930159e-08
+ 1.100248745304567e-05 6.1920997951634242e-08
+ 1.1007487453045671e-05 6.1920998071024264e-08
+ 1.101248745304567e-05 6.1920998123409585e-08
+ 1.101748745304567e-05 6.1920998199321737e-08
+ 1.102248745304567e-05 6.1920997962335841e-08
+ 1.102748745304567e-05 6.1920998266802112e-08
+ 1.1032487453045669e-05 6.1920998075359524e-08
+ 1.103748745304568e-05 6.1920998128081713e-08
+ 1.1042487453045679e-05 6.1920998192845151e-08
+ 1.104748745304568e-05 6.1920997977346986e-08
+ 1.1052487453045679e-05 6.1920998092752909e-08
+ 1.105748745304568e-05 6.192099811090595e-08
+ 1.1062487453045679e-05 6.1920997949619137e-08
+ 1.106748745304568e-05 6.1920998221990218e-08
+ 1.1072487453045679e-05 6.1920998262938265e-08
+ 1.107748745304568e-05 6.1920998084536636e-08
+ 1.1082487453045681e-05 6.1920998157736681e-08
+ 1.108748745304568e-05 6.1920998154039779e-08
+ 1.1092487453045681e-05 6.1920998102814323e-08
+ 1.109748745304568e-05 6.1920998114358046e-08
+ 1.1102487453045691e-05 6.1920998258304757e-08
+ 1.110748745304569e-05 6.1920997943957635e-08
+ 1.1112487453045691e-05 6.1920998127439159e-08
+ 1.111748745304569e-05 6.1920998112821462e-08
+ 1.1122487453045691e-05 6.1920997980791988e-08
+ 1.112748745304569e-05 6.1920997819109134e-08
+ 1.113248745304569e-05 6.1920997128170039e-08
+ 1.113748745304569e-05 6.1920993225726872e-08
+ 1.1139585424581419e-05 6.192090698685959e-08
+ 1.1141404979342361e-05 6.1920905625127959e-08
+ 1.1143323708100891e-05 6.1921194975105392e-08
+ 1.1144848399441021e-05 6.1921064248162822e-08
+ 1.1146523414500571e-05 6.1920799963783669e-08
+ 1.114755326150659e-05 6.1921267486741148e-08
+ 1.1147932464524471e-05 6.1921821390596369e-08
+ 1.114848610869493e-05 6.1920920876664532e-08
+ 1.114879414515e-05 6.1925173998043264e-08
+ 1.114903944733167e-05 6.1917907724004581e-08
+ 1.1149239911099229e-05 6.1828212018672568e-08
+ 1.1149448480139389e-05 6.1856419742422121e-08
+ 1.114969160525272e-05 6.1982574461725279e-08
+ 1.1149849205242311e-05 6.1368203090112493e-08
+ 1.1149916349789269e-05 5.7463433949152257e-08
+ 1.1149970618158039e-05 5.5539084768713328e-08
+ 1.1150014212950569e-05 5.9475247065799118e-08
+ 1.1150078764295719e-05 9.1171308538756757e-08
+ 1.115014461843727e-05 1.3064777433051831e-07
+ 1.1150209747877531e-05 1.719405847801892e-07
+ 1.115023921117876e-05 3.2924539800812712e-07
+ 1.115025984987005e-05 6.4734784482098377e-07
+ 1.1150281525876391e-05 7.8546356689333983e-07
+ 1.1150308965630861e-05 2.7344153583025529e-07
+ 1.115033219994146e-05 -7.4929127281750905e-07
+ 1.115035319885178e-05 -2.6176097638847811e-06
+ 1.1150372101812201e-05 -4.1739067031750489e-06
+ 1.1150387267079119e-05 -4.985086745636234e-06
+ 1.115040168443799e-05 -4.7253634869283019e-06
+ 1.1150411761134859e-05 -2.585752868519268e-06
+ 1.115042433463072e-05 -6.7365298561992163e-07
+ 1.11504408631652e-05 -4.8893194274292521e-07
+ 1.1150459640631569e-05 -1.56541501146803e-06
+ 1.1150483956966641e-05 -2.6240105337227408e-06
+ 1.115050888761417e-05 -3.283632735724516e-06
+ 1.115053482684621e-05 -3.3162427708492869e-06
+ 1.1150558520115831e-05 -1.9804546923990951e-06
+ 1.115058149625744e-05 -5.2351126686141741e-07
+ 1.115060846499394e-05 -5.5589933026593526e-07
+ 1.115063893015182e-05 -1.8887390551818659e-06
+ 1.1150667169068099e-05 -3.0493382567953271e-06
+ 1.115068910247758e-05 -3.7125176948832009e-06
+ 1.115071654084742e-05 -3.648443316215703e-06
+ 1.1150737232994081e-05 -7.5538830015223206e-07
+ 1.1150754816887589e-05 2.2638346725238139e-06
+ 1.1150771989340019e-05 -6.5073219741502016e-06
+ 1.1150789790341971e-05 -5.3837138079233262e-05
+ 1.1150812298738479e-05 -0.00014705697569117169
+ 1.1150833354238661e-05 -0.00018808891984621381
+ 1.11508463090198e-05 -0.00013706891065033179
+ 1.1150859808658019e-05 -1.9621271398713081e-05
+ 1.115087519730139e-05 0.0001133202877419787
+ 1.1150891330148049e-05 0.00018370582040456711
+ 1.115091462557286e-05 0.00018531903664194949
+ 1.1150937629248079e-05 0.00014712628321933511
+ 1.115096930507428e-05 9.5587203769198636e-05
+ 1.115099999833244e-05 6.6925512821495108e-05
+ 1.115103692344824e-05 5.6834028071648018e-05
+ 1.1151076367511821e-05 6.2848552118387364e-05
+ 1.1151127682015519e-05 8.5416393743341124e-05
+ 1.11511919891878e-05 -0.0001775883321699732
+ 1.1151240177109319e-05 -0.001881152774688595
+ 1.115128655989976e-05 -0.0064706950360250747
+ 1.115130128806996e-05 -0.0081924953758036496
+ 1.11513157606599e-05 -0.008241694328171607
+ 1.115132494121679e-05 -0.0061364693204353227
+ 1.115133495411845e-05 -0.0001303278310203086
+ 1.1151345501815301e-05 0.01263937811035184
+ 1.115135856891936e-05 0.040830240169656043
+ 1.1151371065384981e-05 0.082049342167575839
+ 1.115138692865923e-05 0.1527814196309642
+ 1.115139858025819e-05 0.21492411809217349
+ 1.115141196980165e-05 0.29250968749170531
+ 1.1151426478816599e-05 0.37959293549758188
+ 1.115144371231179e-05 0.48268414928904418
+ 1.1151465928077271e-05 0.6103297532035411
+ 1.115149544237492e-05 0.76436600985594128
+ 1.1151532079852119e-05 0.92120504077704135
+ 1.1151573903487479e-05 1.0474104244689979
+ 1.115162387670597e-05 1.1352546291615231
+ 1.115166627276328e-05 1.172374145785209
+ 1.115171920871063e-05 1.1930242417074259
+ 1.1151767303716089e-05 1.199408274560879
+ 1.1151833842345861e-05 1.2015292671233251
+ 1.115190944830777e-05 1.2012717648731179
+ 1.1152032236422871e-05 1.200478920273887
+ 1.115216463460983e-05 1.200074215470057
+ 1.1152293914528401e-05 1.1999774846417299
+ 1.1152416822517021e-05 1.199978406033156
+ 1.1152536306499509e-05 1.199991084616475
+ 1.1152664065882061e-05 1.1999982353916121
+ 1.1152782801711929e-05 1.200000141909124
+ 1.115290677633805e-05 1.2000003119503371
+ 1.11530245263912e-05 1.2000001303659491
+ 1.1153145838691329e-05 1.2000000049885851
+ 1.115326347866187e-05 1.1999999624159481
+ 1.115338362644794e-05 1.1999999553612199
+ 1.1153501574363619e-05 1.199999957890584
+ 1.1153621215823419e-05 1.199999962078367
+ 1.115369101510659e-05 1.1999999752174191
+ 1.11537383208589e-05 1.1999999948413811
+ 1.115378687276882e-05 1.199999989229674
+ 1.1153852404731509e-05 1.199999940567579
+ 1.115390692116691e-05 1.199999911989696
+ 1.115393557205717e-05 1.1999998914011449
+ 1.115396003771065e-05 1.1999998524457529
+ 1.115398231871133e-05 1.1999997887582481
+ 1.115400489672582e-05 1.199999704850385
+ 1.11540329884765e-05 1.199999656356082
+ 1.115405384852144e-05 1.199999888500318
+ 1.1154078557894239e-05 1.200000186177683
+ 1.115411426964972e-05 1.2000003236109431
+ 1.115416691146677e-05 1.2000001966272651
+ 1.115421893584794e-05 1.200000013890181
+ 1.1154291829002329e-05 1.1999998859717651
+ 1.115437350318981e-05 1.1999998711936299
+ 1.115447308968597e-05 1.199999915832018
+ 1.115456714108973e-05 1.1999999552350551
+ 1.115468402821867e-05 1.199999973037692
+ 1.115482146802553e-05 1.199999970249956
+ 1.115504114621297e-05 1.199999961915958
+ 1.115544116230504e-05 1.1999999587512531
+ 1.1155817122476609e-05 1.199999959800429
+ 1.1156378402838401e-05 1.199999960514796
+ 1.115697388332336e-05 1.1999999605479501
+ 1.1157517160647629e-05 1.1999999604373781
+ 1.115804838903915e-05 1.1999999604843601
+ 1.1158425419895619e-05 1.1999999606051319
+ 1.115884883987498e-05 1.1999999604374341
+ 1.115933219853448e-05 1.199999960456769
+ 1.115993476370242e-05 1.199999960479071
+ 1.116066987911846e-05 1.1999999604827689
+ 1.116177752598399e-05 1.1999999604816709
+ 1.116345207988244e-05 1.199999960480933
+ 1.1166305086160759e-05 1.199999960480939
+ 1.117096588477016e-05 1.1999999604809191
+ 1.1175965884770159e-05 1.1999999604808671
+ 1.118096588477016e-05 1.199999960480858
+ 1.1185965884770159e-05 1.1999999604808631
+ 1.119096588477016e-05 1.1999999604808671
+ 1.1195965884770161e-05 1.199999960480868
+ 1.120096588477016e-05 1.199999960480868
+ 1.1205965884770161e-05 1.199999960480868
+ 1.121096588477016e-05 1.199999960480868
+ 1.1215965884770161e-05 1.199999960480868
+ 1.122096588477016e-05 1.199999960480868
+ 1.1225965884770171e-05 1.199999960480868
+ 1.123096588477017e-05 1.199999960480868
+ 1.1235965884770171e-05 1.199999960480868
+ 1.124096588477017e-05 1.199999960480868
+ 1.1245965884770171e-05 1.199999960480868
+ 1.125096588477017e-05 1.199999960480868
+ 1.125596588477017e-05 1.199999960480868
+ 1.126096588477017e-05 1.199999960480868
+ 1.126596588477017e-05 1.199999960480868
+ 1.1270965884770169e-05 1.199999960480868
+ 1.127596588477017e-05 1.199999960480868
+ 1.1280965884770169e-05 1.199999960480868
+ 1.128596588477018e-05 1.199999960480868
+ 1.1290965884770179e-05 1.199999960480868
+ 1.129596588477018e-05 1.199999960480868
+ 1.1300965884770179e-05 1.199999960480868
+ 1.130596588477018e-05 1.199999960480868
+ 1.1310965884770179e-05 1.199999960480868
+ 1.131596588477018e-05 1.199999960480868
+ 1.1320965884770181e-05 1.199999960480868
+ 1.132596588477018e-05 1.199999960480868
+ 1.1330965884770181e-05 1.199999960480868
+ 1.133596588477018e-05 1.199999960480868
+ 1.1340965884770181e-05 1.199999960480868
+ 1.134596588477018e-05 1.199999960480868
+ 1.1350965884770191e-05 1.199999960480868
+ 1.135596588477019e-05 1.199999960480868
+ 1.1360965884770191e-05 1.199999960480868
+ 1.136596588477019e-05 1.199999960480868
+ 1.1370965884770191e-05 1.199999960480868
+ 1.137596588477019e-05 1.199999960480868
+ 1.138096588477019e-05 1.199999960480868
+ 1.138596588477019e-05 1.199999960480868
+ 1.139096588477019e-05 1.199999960480868
+ 1.1395965884770189e-05 1.1999999604808671
+ 1.140096588477019e-05 1.1999999604808651
+ 1.1405965884770189e-05 1.199999960480862
+ 1.14109658847702e-05 1.1999999604808571
+ 1.1415965884770199e-05 1.199999960480846
+ 1.14209658847702e-05 1.1999999604808269
+ 1.1425965884770199e-05 1.1999999604807881
+ 1.14309658847702e-05 1.199999960480715
+ 1.1435965884770199e-05 1.1999999604805749
+ 1.14409658847702e-05 1.19999996048031
+ 1.1445965884770201e-05 1.199999960479821
+ 1.14509658847702e-05 1.1999999604789651
+ 1.1455965884770201e-05 1.1999999604774481
+ 1.14609658847702e-05 1.1999999604743039
+ 1.1465965884770201e-05 1.1999999604614999
+ 1.146836480089972e-05 1.199999960363036
+ 1.147006922610878e-05 1.1999999600922031
+ 1.147221452441331e-05 1.1999999602196749
+ 1.1473661189488101e-05 1.19999996046275
+ 1.1475425055500299e-05 1.199999960395288
+ 1.147660998848124e-05 1.1999999605561451
+ 1.14771280285733e-05 1.199999961090856
+ 1.147777820478764e-05 1.1999999616047601
+ 1.147810835300031e-05 1.199999964339111
+ 1.1478398253064799e-05 1.1999999673252191
+ 1.1478627604918419e-05 1.199999964147368
+ 1.147883577468362e-05 1.1999999185521819
+ 1.147905116689196e-05 1.1999998652773249
+ 1.1479292971537339e-05 1.199999820749603
+ 1.147941172771708e-05 1.19999962763865
+ 1.14794747994745e-05 1.1999992719733941
+ 1.1479532122608759e-05 1.19999882541286
+ 1.147957828949411e-05 1.1999985040172749
+ 1.1479644714510429e-05 1.1999980046507639
+ 1.147971528738489e-05 1.199998103709462
+ 1.1479796255648579e-05 1.199999181280216
+ 1.147982095534439e-05 1.1999997155017921
+ 1.147984062384061e-05 1.1999997751161811
+ 1.147986002279175e-05 1.2000002362110951
+ 1.147988501361571e-05 1.2000030895633069
+ 1.1479910319166881e-05 1.2000081106155831
+ 1.147993814242392e-05 1.200010895016296
+ 1.1479959696022741e-05 1.2000097927120461
+ 1.147997811824194e-05 1.2000069735198149
+ 1.147999089616872e-05 1.200004255850105
+ 1.1480006915477959e-05 1.2000013238319689
+ 1.1480028766871271e-05 1.1999989496619681
+ 1.1480057987619299e-05 1.1999976444654541
+ 1.148008996221312e-05 1.199997104890135
+ 1.148011884317131e-05 1.1999972215525481
+ 1.148015073261645e-05 1.199998945093222
+ 1.148017668381144e-05 1.2000015652928391
+ 1.148020537801563e-05 1.2000045167773179
+ 1.1480231187681421e-05 1.20000658832361
+ 1.148024953087824e-05 1.2000079221763751
+ 1.148026528454784e-05 1.20000925539015
+ 1.1480280897703461e-05 1.2000111724032381
+ 1.148029465233913e-05 1.200012992175409
+ 1.148031024102088e-05 1.200013180442558
+ 1.148032157215452e-05 1.200012100199856
+ 1.14803359236287e-05 1.2000099650748841
+ 1.148036054676434e-05 1.200005594374236
+ 1.148038311089056e-05 1.199993961758272
+ 1.1480406686594061e-05 1.1999486935803061
+ 1.1480429165100679e-05 1.199871550086598
+ 1.148045788323622e-05 1.1997330851377279
+ 1.1480500465011199e-05 1.1994711725489671
+ 1.148051932201359e-05 1.2003505100149869
+ 1.1480536261390379e-05 1.203132041468435
+ 1.1480560359366779e-05 1.2109991555820621
+ 1.148058123935245e-05 1.2147229115060969
+ 1.148059641431978e-05 1.200211593957911
+ 1.14806131342587e-05 1.152358649461372
+ 1.148063072692944e-05 1.0715818224714559
+ 1.1480648322060861e-05 0.97274367110698612
+ 1.1480669969669051e-05 0.84232451496819827
+ 1.148069066960508e-05 0.71674158450856307
+ 1.1480705129271529e-05 0.63061694138770441
+ 1.148071632264956e-05 0.56551390532461399
+ 1.1480732373773209e-05 0.47538016492505042
+ 1.1480744135102619e-05 0.4122700425112974
+ 1.1480757281447299e-05 0.34551283976505998
+ 1.148077743526536e-05 0.25356744259992259
+ 1.1480800535897539e-05 0.16762472904265849
+ 1.1480822693848881e-05 0.10640860650709701
+ 1.148084601863186e-05 0.062467572659406098
+ 1.1480863229213779e-05 0.041102049287213817
+ 1.1480881005139589e-05 0.026249689309278911
+ 1.1480903061308181e-05 0.014638185130930591
+ 1.1480923655675309e-05 0.0082940411238560906
+ 1.1480950122155281e-05 0.0037862089858706331
+ 1.148097750594684e-05 0.001530948701046623
+ 1.1481013899042089e-05 0.00028113462544202781
+ 1.148105601713722e-05 -0.00013392655894071029
+ 1.148111595062403e-05 -0.0001819234538498469
+ 1.148119670162992e-05 -8.9831678455453142e-05
+ 1.148128589335381e-05 -2.2069816239495182e-05
+ 1.1481390796163349e-05 2.2053058188546872e-06
+ 1.1481523574144679e-05 4.2166819032485812e-06
+ 1.148168549128279e-05 1.432518765026826e-06
+ 1.1481823295698199e-05 2.422573958574213e-07
+ 1.1481947570983561e-05 7.1720284621061336e-09
+ 1.148206600680312e-05 1.8606101239139851e-08
+ 1.1482184582088651e-05 4.8815205279739321e-08
+ 1.148231291765037e-05 6.1688101537297985e-08
+ 1.148243290504621e-05 6.4526224130574758e-08
+ 1.1482557967153269e-05 6.628274465035274e-08
+ 1.148267655473308e-05 6.9223557403136205e-08
+ 1.148279833337125e-05 7.3728506242404358e-08
+ 1.1482916302653531e-05 8.473993200052669e-08
+ 1.148303663237088e-05 1.2749112294925299e-07
+ 1.148311308893896e-05 3.0918593430074191e-07
+ 1.148316386184834e-05 5.9557965758684355e-07
+ 1.1483217471194451e-05 6.5073165620624514e-07
+ 1.148328329336621e-05 2.38403881931001e-07
+ 1.148331896254561e-05 -1.40697744384881e-07
+ 1.148334954235794e-05 -5.3558635383702647e-07
+ 1.148337417177738e-05 -9.7548533963088823e-07
+ 1.1483397316313579e-05 -1.4792909091960609e-06
+ 1.1483418776555041e-05 -1.7526040204060701e-06
+ 1.1483447688930269e-05 -1.6243152138039301e-06
+ 1.148346851115387e-05 -1.726554565128043e-06
+ 1.148349150325159e-05 -6.6845651855479076e-07
+ 1.1483532353874719e-05 1.106044959581485e-06
+ 1.1483571886755991e-05 1.4151753442747571e-06
+ 1.148363211143949e-05 7.3020618853469337e-07
+ 1.148369685541243e-05 1.8154704435462231e-07
+ 1.1483777589900071e-05 2.9524814226608198e-08
+ 1.148386281884416e-05 -1.7008784015902029e-08
+ 1.14839640428121e-05 -5.1953490666754094e-09
+ 1.148407916701632e-05 4.7427049062829222e-08
+ 1.148420616678985e-05 7.3638138307426689e-08
+ 1.1484375242485231e-05 7.0146015376218418e-08
+ 1.1484621687984079e-05 6.1763494724030833e-08
+ 1.148493479058398e-05 6.0752781568706339e-08
+ 1.1485290063353961e-05 6.1737534440847321e-08
+ 1.1485726306592879e-05 6.2029572603104005e-08
+ 1.1486251790013589e-05 6.2057926964169274e-08
+ 1.1486867180879779e-05 6.1587540575113978e-08
+ 1.148726307481913e-05 6.0290728521779852e-08
+ 1.148760514238891e-05 6.3046790082044089e-08
+ 1.148803741564548e-05 6.222239568951967e-08
+ 1.1488502072124539e-05 6.1727011030075474e-08
+ 1.148905157140882e-05 6.1910353346081238e-08
+ 1.148964351094814e-05 6.1922231439438954e-08
+ 1.149046462639776e-05 6.1919146439821871e-08
+ 1.149161924758048e-05 6.1921756387065289e-08
+ 1.149362436017383e-05 6.192138783446277e-08
+ 1.149666895916633e-05 6.1921012536807494e-08
+ 1.1501668959166329e-05 6.1920982398555779e-08
+ 1.150666895916633e-05 6.192099499252603e-08
+ 1.1511668959166329e-05 6.1920997648127977e-08
+ 1.151666895916633e-05 6.1920998017593015e-08
+ 1.1521668959166329e-05 6.1920998035207012e-08
+ 1.152666895916633e-05 6.1920998096121598e-08
+ 1.1531668959166331e-05 6.1920998137596302e-08
+ 1.153666895916633e-05 6.1920998295055664e-08
+ 1.1541668959166339e-05 6.1920998311170346e-08
+ 1.154666895916634e-05 6.1920998160383553e-08
+ 1.1551668959166341e-05 6.1920997901702126e-08
+ 1.155666895916634e-05 6.1920998235333568e-08
+ 1.1561668959166341e-05 6.1920998013364957e-08
+ 1.156666895916634e-05 6.1920998061854311e-08
+ 1.1571668959166341e-05 6.1920998211608731e-08
+ 1.157666895916634e-05 6.1920998199644695e-08
+ 1.158166895916634e-05 6.1920998227675424e-08
+ 1.158666895916634e-05 6.1920998056969181e-08
+ 1.159166895916634e-05 6.1920998120990089e-08
+ 1.159666895916634e-05 6.1920997951791525e-08
+ 1.160166895916635e-05 6.1920998001486538e-08
+ 1.160666895916635e-05 6.1920998277874368e-08
+ 1.161166895916635e-05 6.1920998136290111e-08
+ 1.1616668959166349e-05 6.1920998203724402e-08
+ 1.162166895916635e-05 6.1920998173998416e-08
+ 1.1626668959166349e-05 6.1920998274795099e-08
+ 1.163166895916635e-05 6.1920998066582992e-08
+ 1.1636668959166349e-05 6.1920998137213946e-08
+ 1.164166895916635e-05 6.1920998206861415e-08
+ 1.1646668959166349e-05 6.1920998190955725e-08
+ 1.165166895916635e-05 6.192099832455712e-08
+ 1.1656668959166351e-05 6.1920998072176917e-08
+ 1.166166895916635e-05 6.1920998170210498e-08
+ 1.1666668959166359e-05 6.1920998179443899e-08
+ 1.167166895916636e-05 6.1920998055864293e-08
+ 1.1676668959166361e-05 6.192099807452959e-08
+ 1.168166895916636e-05 6.1920998168660269e-08
+ 1.1686668959166361e-05 6.1920998175078383e-08
+ 1.169166895916636e-05 6.192099823983298e-08
+ 1.1696668959166361e-05 6.1920998104879959e-08
+ 1.170166895916636e-05 6.1920998115649824e-08
+ 1.170666895916636e-05 6.1920998152771241e-08
+ 1.171166895916636e-05 6.1920998186535576e-08
+ 1.171666895916636e-05 6.192099829771458e-08
+ 1.1721668959166359e-05 6.1920998074519823e-08
+ 1.172666895916637e-05 6.1920998149673549e-08
+ 1.173166895916637e-05 6.1920998183032949e-08
+ 1.173666895916637e-05 6.1920998050493006e-08
+ 1.1741668959166369e-05 6.1920998075119919e-08
+ 1.174666895916637e-05 6.1920998096034182e-08
+ 1.1751668959166369e-05 6.1920998258939039e-08
+ 1.175666895916637e-05 6.1920998144714251e-08
+ 1.1761668959166369e-05 6.192099793510127e-08
+ 1.176666895916637e-05 6.1920998022773138e-08
+ 1.1771668959166369e-05 6.1920998310220505e-08
+ 1.177666895916637e-05 6.1920997996241379e-08
+ 1.1781668959166371e-05 6.1920998107375728e-08
+ 1.178666895916637e-05 6.1920997596427283e-08
+ 1.1791668959166381e-05 6.1920997218147596e-08
+ 1.179666895916638e-05 6.1920993435039262e-08
+ 1.179876674046461e-05 6.1920906947639397e-08
+ 1.1800586486924761e-05 6.1920905783047366e-08
+ 1.180250474589412e-05 6.1921194833854946e-08
+ 1.180402969738743e-05 6.1921064157555801e-08
+ 1.1805704767413821e-05 6.192080035075476e-08
+ 1.1806734453109949e-05 6.1921267935706184e-08
+ 1.1807113530750839e-05 6.1921823788938263e-08
+ 1.180766698400862e-05 6.1920917134615379e-08
+ 1.180797498146349e-05 6.1925177300304163e-08
+ 1.1808220273759971e-05 6.1917883934769134e-08
+ 1.180842076279298e-05 6.1828069718600797e-08
+ 1.1808629330777909e-05 6.1856625951134156e-08
+ 1.180887241267741e-05 6.1982501425992321e-08
+ 1.180902980969065e-05 6.1366452461789161e-08
+ 1.1809096908395e-05 5.7462670532144363e-08
+ 1.180915118626783e-05 5.5543388631131317e-08
+ 1.1809194776320571e-05 5.9472162380735549e-08
+ 1.180925932850296e-05 9.1160956396595613e-08
+ 1.1809325185105921e-05 1.3064070110320801e-07
+ 1.1809390326312519e-05 1.7193548813462311e-07
+ 1.1809419792641149e-05 3.2927823192057958e-07
+ 1.1809440430393401e-05 6.4741719424213469e-07
+ 1.180946210820508e-05 7.8542095859854433e-07
+ 1.1809489549602919e-05 2.7327031420483442e-07
+ 1.18095127813842e-05 -7.496648233433991e-07
+ 1.1809533780083039e-05 -2.618136726687958e-06
+ 1.180955268487439e-05 -4.1742743309158373e-06
+ 1.1809567848735351e-05 -4.9854929930157144e-06
+ 1.1809582269364119e-05 -4.7240736798978051e-06
+ 1.1809592347449081e-05 -2.5840884844915681e-06
+ 1.180960492159254e-05 -6.7302918347253315e-07
+ 1.1809621456986269e-05 -4.8957761330709216e-07
+ 1.180964023476245e-05 -1.566322086761893e-06
+ 1.1809664554961819e-05 -2.6246530807936911e-06
+ 1.180968948707044e-05 -3.284128429641977e-06
+ 1.180971542798498e-05 -3.3156144598464931e-06
+ 1.180973910943184e-05 -1.9791958686022619e-06
+ 1.180976208809774e-05 -5.2285958125306753e-07
+ 1.1809789064180589e-05 -5.5655378967216159e-07
+ 1.180981952111286e-05 -1.88954903747973e-06
+ 1.18098477680161e-05 -3.050263699513033e-06
+ 1.180986969941714e-05 -3.7131135089722201e-06
+ 1.180989712716661e-05 -3.6473796287241622e-06
+ 1.1809917801129791e-05 -7.5594081930005188e-07
+ 1.1809935378150151e-05 2.2640632957766758e-06
+ 1.1809952550185e-05 -6.4840391991766577e-06
+ 1.180997035078035e-05 -5.3775523348721692e-05
+ 1.18099928625946e-05 -0.0001470050672771466
+ 1.1810013905702309e-05 -0.0001881130613733879
+ 1.1810026861601419e-05 -0.00013721594230327601
+ 1.1810040357161689e-05 -1.9867777553350209e-05
+ 1.181005573832551e-05 0.00011310013533502599
+ 1.1810071867610071e-05 0.000183636766334378
+ 1.181009513959431e-05 0.0001853878910587771
+ 1.18101181464072e-05 0.00014722505568072751
+ 1.181014980698375e-05 9.568337618001338e-05
+ 1.181018049788177e-05 6.6969700866647232e-05
+ 1.18102174095519e-05 5.6836502737937437e-05
+ 1.1810256840917319e-05 6.2816988041538495e-05
+ 1.181030812361114e-05 8.5367358324879965e-05
+ 1.1810372396137211e-05 -0.00017526630197815571
+ 1.181042063249891e-05 -0.001873378788492891
+ 1.181046697636632e-05 -0.0064501969747392
+ 1.1810481767871939e-05 -0.0081839840930862801
+ 1.181049622996292e-05 -0.008255459752369361
+ 1.181050539252127e-05 -0.0061884186159754323
+ 1.18105154261864e-05 -0.00022472294420477831
+ 1.181052598180355e-05 0.01248256357881076
+ 1.1810539054378531e-05 0.04058197582955253
+ 1.181055153135321e-05 0.081624973830101838
+ 1.1810567601047489e-05 0.15324019562531099
+ 1.1810579323857449e-05 0.21581489690904609
+ 1.1810592765936679e-05 0.29375267979404601
+ 1.18106073073129e-05 0.38104320590911062
+ 1.181062459529075e-05 0.48442531145611573
+ 1.1810646888235639e-05 0.61239495682889444
+ 1.181067651770041e-05 0.76672192457122845
+ 1.181071322042328e-05 0.92324097188372323
+ 1.1810755172582571e-05 1.049024265953501
+ 1.181080424049407e-05 1.1349087169648371
+ 1.1810846410428169e-05 1.171995462006987
+ 1.1810899317211711e-05 1.1928374063805831
+ 1.1810947343784289e-05 1.1993199677346309
+ 1.1811013902441001e-05 1.2015113295397759
+ 1.181108930873803e-05 1.201276533200029
+ 1.181121168063487e-05 1.200488014655835
+ 1.181134392167072e-05 1.200078196553783
+ 1.1811473201919331e-05 1.199978327427963
+ 1.1811596161365339e-05 1.19997834817851
+ 1.181171568242226e-05 1.199990941480545
+ 1.1811843497549761e-05 1.1999981655550189
+ 1.181196224475908e-05 1.2000001215728351
+ 1.18120862387776e-05 1.2000003107629029
+ 1.1812203984933381e-05 1.200000132363316
+ 1.1812325303326959e-05 1.2000000062756599
+ 1.1812442938637919e-05 1.199999962863729
+ 1.181256309013384e-05 1.1999999554262371
+ 1.18126810354707e-05 1.19999995785943
+ 1.181280067925644e-05 1.1999999620139941
+ 1.181287106350615e-05 1.1999999749629791
+ 1.181291846801834e-05 1.199999994702069
+ 1.181296693030219e-05 1.1999999895347431
+ 1.1813032588027259e-05 1.199999940941143
+ 1.181308804511316e-05 1.1999999120027229
+ 1.1813116883316209e-05 1.1999998908301011
+ 1.181314118739799e-05 1.199999850917512
+ 1.181316334305618e-05 1.1999997866897461
+ 1.181318587890378e-05 1.199999702720596
+ 1.181321386309723e-05 1.1999996570897431
+ 1.1813234451641969e-05 1.199999890160204
+ 1.1813259149906009e-05 1.200000187425196
+ 1.1813295255889271e-05 1.2000003240322661
+ 1.1813347634400309e-05 1.2000001960416009
+ 1.1813399998527019e-05 1.2000000125333501
+ 1.18134728201531e-05 1.1999998856376439
+ 1.1813554073304649e-05 1.1999998712873541
+ 1.1813654369976399e-05 1.199999916191224
+ 1.181374799897285e-05 1.1999999553233029
+ 1.18138655119043e-05 1.1999999730875821
+ 1.181400261906904e-05 1.199999970221985
+ 1.1814223563090391e-05 1.199999961870033
+ 1.181462244102142e-05 1.1999999587560519
+ 1.1814999663767361e-05 1.1999999598063431
+ 1.1815560110877449e-05 1.19999996051505
+ 1.181615723951917e-05 1.199999960547586
+ 1.1816700079816829e-05 1.1999999604369549
+ 1.181723385702818e-05 1.1999999604855851
+ 1.181761254531719e-05 1.1999999606040399
+ 1.181803725542262e-05 1.199999960436984
+ 1.181852204025578e-05 1.1999999604570231
+ 1.181912553121015e-05 1.1999999604792191
+ 1.1819864885342601e-05 1.199999960482792
+ 1.1820979067527689e-05 1.199999960481654
+ 1.182266909837988e-05 1.1999999604809279
+ 1.182554378130227e-05 1.1999999604809399
+ 1.183025730489597e-05 1.1999999604809179
+ 1.183525730489597e-05 1.1999999604808671
+ 1.184025730489597e-05 1.199999960480858
+ 1.1845257304895969e-05 1.199999960480864
+ 1.185025730489597e-05 1.1999999604808671
+ 1.1855257304895969e-05 1.199999960480868
+ 1.186025730489597e-05 1.199999960480868
+ 1.1865257304895969e-05 1.199999960480868
+ 1.187025730489597e-05 1.199999960480868
+ 1.1875257304895969e-05 1.199999960480868
+ 1.188025730489598e-05 1.199999960480868
+ 1.1885257304895979e-05 1.199999960480868
+ 1.189025730489598e-05 1.199999960480868
+ 1.1895257304895981e-05 1.199999960480868
+ 1.190025730489598e-05 1.199999960480868
+ 1.1905257304895981e-05 1.199999960480868
+ 1.191025730489598e-05 1.199999960480868
+ 1.1915257304895981e-05 1.199999960480868
+ 1.192025730489598e-05 1.199999960480868
+ 1.1925257304895981e-05 1.199999960480868
+ 1.193025730489598e-05 1.199999960480868
+ 1.193525730489598e-05 1.199999960480868
+ 1.194025730489598e-05 1.199999960480868
+ 1.1945257304895991e-05 1.199999960480868
+ 1.195025730489599e-05 1.199999960480868
+ 1.195525730489599e-05 1.199999960480868
+ 1.196025730489599e-05 1.199999960480868
+ 1.196525730489599e-05 1.199999960480868
+ 1.1970257304895989e-05 1.199999960480868
+ 1.197525730489599e-05 1.199999960480868
+ 1.1980257304895989e-05 1.199999960480868
+ 1.198525730489599e-05 1.199999960480868
+ 1.1990257304895989e-05 1.199999960480868
+ 1.199525730489599e-05 1.199999960480868
+ 1.2000257304895991e-05 1.199999960480868
+ 1.2005257304896e-05 1.199999960480868
+ 1.2010257304895999e-05 1.199999960480868
+ 1.2015257304896e-05 1.199999960480868
+ 1.2020257304896001e-05 1.199999960480868
+ 1.2025257304896e-05 1.199999960480868
+ 1.2030257304896001e-05 1.199999960480868
+ 1.2035257304896e-05 1.199999960480868
+ 1.2040257304896001e-05 1.199999960480868
+ 1.2045257304896e-05 1.199999960480868
+ 1.2050257304896001e-05 1.1999999604808671
+ 1.2055257304896e-05 1.1999999604808671
+ 1.2060257304896e-05 1.1999999604808651
+ 1.2065257304896e-05 1.199999960480862
+ 1.2070257304896011e-05 1.199999960480856
+ 1.207525730489601e-05 1.199999960480846
+ 1.208025730489601e-05 1.199999960480826
+ 1.208525730489601e-05 1.1999999604807869
+ 1.209025730489601e-05 1.199999960480713
+ 1.2095257304896009e-05 1.1999999604805709
+ 1.210025730489601e-05 1.199999960480302
+ 1.2105257304896009e-05 1.1999999604798071
+ 1.211025730489601e-05 1.19999996047894
+ 1.2115257304896009e-05 1.1999999604774021
+ 1.212025730489601e-05 1.199999960474192
+ 1.2125257304896011e-05 1.1999999604607621
+ 1.212761444392536e-05 1.199999960355504
+ 1.212932723436136e-05 1.1999999600862481
+ 1.213148047586009e-05 1.1999999602297231
+ 1.213291561987681e-05 1.1999999604741649
+ 1.2134659041689859e-05 1.199999960385969
+ 1.2135821482057369e-05 1.1999999605723251
+ 1.2136324458146199e-05 1.1999999611183181
+ 1.213697677026638e-05 1.19999996163655
+ 1.213730807976018e-05 1.199999964492888
+ 1.2137591497534671e-05 1.199999967563554
+ 1.2137816413381831e-05 1.1999999631778111
+ 1.213802547233077e-05 1.19999991547201
+ 1.213824064152225e-05 1.1999998634754629
+ 1.213848226760959e-05 1.199999817039425
+ 1.2138597281001381e-05 1.199999608322065
+ 1.2138659975289899e-05 1.1999992348657169
+ 1.213871515949768e-05 1.19999879529775
+ 1.213876239761551e-05 1.199998462694045
+ 1.213882761129048e-05 1.1999979859948591
+ 1.2138898501437439e-05 1.1999981369157591
+ 1.213898059830094e-05 1.1999992764935179
+ 1.2139004775106249e-05 1.199999763526177
+ 1.213902387951181e-05 1.1999997123373021
+ 1.21390456157226e-05 1.2000006995937409
+ 1.213907210470885e-05 1.2000043974452279
+ 1.2139095624317939e-05 1.2000090483348429
+ 1.213912185951649e-05 1.20001089642665
+ 1.2139142187434339e-05 1.2000094161098349
+ 1.2139160615305049e-05 1.2000063510972909
+ 1.213917364068276e-05 1.2000036047499609
+ 1.213918936021591e-05 1.200000903849286
+ 1.2139215229912309e-05 1.199998489595824
+ 1.213924570248316e-05 1.1999974433249521
+ 1.213927287439205e-05 1.199997071325744
+ 1.213929975589322e-05 1.1999972735089299
+ 1.2139327978135731e-05 1.1999988477807271
+ 1.2139353386801691e-05 1.2000013920989021
+ 1.2139381854053719e-05 1.200004324177171
+ 1.213940784537421e-05 1.2000064240950119
+ 1.213942679487511e-05 1.200007771283057
+ 1.2139442535881511e-05 1.200009052255586
+ 1.213945833988015e-05 1.200010882610318
+ 1.213947205922618e-05 1.200012800689009
+ 1.21394882217945e-05 1.200013229611071
+ 1.213949774589281e-05 1.200012435694038
+ 1.2139512447641199e-05 1.200010382259677
+ 1.213953656141764e-05 1.200006252263417
+ 1.213956249347723e-05 1.199993572439634
+ 1.2139586124480949e-05 1.1999487856220299
+ 1.2139607593810149e-05 1.1998756098662839
+ 1.213963667522195e-05 1.199736530731951
+ 1.2139678152249341e-05 1.199453031012869
+ 1.2139697145999869e-05 1.200200380034727
+ 1.213971384499954e-05 1.202724831328396
+ 1.2139738290508851e-05 1.2104393500774311
+ 1.2139761385796801e-05 1.2140293901515991
+ 1.213977723937757e-05 1.1966614326711791
+ 1.213979666023701e-05 1.135383035664103
+ 1.2139814325019861e-05 1.0495276242193701
+ 1.213983152235456e-05 0.95086475412542726
+ 1.213985390910507e-05 0.81549556355956709
+ 1.213987493442509e-05 0.68851988487666971
+ 1.213988900765891e-05 0.60537269855362719
+ 1.2139900561744301e-05 0.53886388429728305
+ 1.2139914749240949e-05 0.46003246240644718
+ 1.213992681204957e-05 0.39604460952351389
+ 1.213994144657282e-05 0.32328390282306102
+ 1.213996177119449e-05 0.2339379013343118
+ 1.2139985319048049e-05 0.15128100119337939
+ 1.214000751529546e-05 0.09476180786852885
+ 1.2140024808012419e-05 0.06378021835946393
+ 1.214004040244626e-05 0.043886358668695273
+ 1.214005780036959e-05 0.02846676777038348
+ 1.214007945342417e-05 0.016164037397013518
+ 1.214010030427256e-05 0.0091431880914297787
+ 1.2140126192466909e-05 0.0042855271825292989
+ 1.214015335399078e-05 0.0017758788033457309
+ 1.21401884171224e-05 0.00039167026174280511
+ 1.214022935015164e-05 -0.0001054724541546233
+ 1.2140286226182799e-05 -0.0001900458709314604
+ 1.214036284925611e-05 -0.00010432740668347941
+ 1.214045334814183e-05 -2.764596324158297e-05
+ 1.2140553035201031e-05 5.7571278701354423e-07
+ 1.2140683507046059e-05 4.5147736665443232e-06
+ 1.2140860585815809e-05 1.7198578817572259e-06
+ 1.2141003730066511e-05 3.3181761058638649e-07
+ 1.214112885452621e-05 2.2800377376348891e-08
+ 1.2141246040623189e-05 1.6473391014030181e-08
+ 1.2141363546222539e-05 4.5976372395986778e-08
+ 1.214149123338409e-05 6.0699958705399656e-08
+ 1.2141610909847171e-05 6.4384121373816582e-08
+ 1.214173598603048e-05 6.6314671124511772e-08
+ 1.2141854598965831e-05 6.9228204787930352e-08
+ 1.21419764763517e-05 7.3682624422227155e-08
+ 1.2142094470108711e-05 8.4585959158310243e-08
+ 1.214221483852687e-05 1.2675672862908401e-07
+ 1.214229179676435e-05 3.0660146375101802e-07
+ 1.214234263699516e-05 5.9366665230867413e-07
+ 1.2142396116548991e-05 6.5250744147501194e-07
+ 1.2142461992372709e-05 2.4259347569479472e-07
+ 1.214249753312134e-05 -1.3519170108605311e-07
+ 1.214252834713146e-05 -5.3035112621896372e-07
+ 1.2142553081960671e-05 -9.6930899672181522e-07
+ 1.2142576275055029e-05 -1.473941046098395e-06
+ 1.214259775096389e-05 -1.7522232312971841e-06
+ 1.214262674860375e-05 -1.624273912324326e-06
+ 1.214264769276246e-05 -1.7256060759514721e-06
+ 1.214267069312581e-05 -6.6983609736618907e-07
+ 1.21427112694691e-05 1.099415129595498e-06
+ 1.2142750899731431e-05 1.4155213091659379e-06
+ 1.214281087151562e-05 7.3456346917591643e-07
+ 1.21428757276668e-05 1.8267521365157871e-07
+ 1.214295675183496e-05 2.9334724357188079e-08
+ 1.214304199231237e-05 -1.7046952963903729e-08
+ 1.2143143370704069e-05 -5.3091323203109143e-09
+ 1.214325838159158e-05 4.7322050027866221e-08
+ 1.214338549001068e-05 7.3644525923024686e-08
+ 1.2143554480649099e-05 7.0163449929206676e-08
+ 1.214380119726221e-05 6.1763151464139076e-08
+ 1.2144114347372091e-05 6.0751866926062263e-08
+ 1.214446999214112e-05 6.1737853960457544e-08
+ 1.2144906432549459e-05 6.2029643733571609e-08
+ 1.2145432514108301e-05 6.2058067956052722e-08
+ 1.214604681147809e-05 6.1585133870344682e-08
+ 1.214644255783457e-05 6.0291594044543508e-08
+ 1.214678426788955e-05 6.3049656986583261e-08
+ 1.2147216121839509e-05 6.2220224522787335e-08
+ 1.214768121003059e-05 6.1727232393967321e-08
+ 1.214823110591129e-05 6.1910506400087025e-08
+ 1.2148822951560939e-05 6.1922155847296583e-08
+ 1.214964432474641e-05 6.1919136425774045e-08
+ 1.215079863790561e-05 6.1921761441287923e-08
+ 1.215280469759908e-05 6.1921388563136204e-08
+ 1.2155849376435881e-05 6.1921012179214258e-08
+ 1.216084937643588e-05 6.192098246615818e-08
+ 1.2165849376435881e-05 6.1920994894014074e-08
+ 1.217084937643588e-05 6.1920997680778199e-08
+ 1.2175849376435881e-05 6.1920997938758123e-08
+ 1.218084937643588e-05 6.1920998241062157e-08
+ 1.2185849376435891e-05 6.1920998057843293e-08
+ 1.219084937643589e-05 6.192099815505463e-08
+ 1.2195849376435891e-05 6.1920998180894112e-08
+ 1.220084937643589e-05 6.1920998277887735e-08
+ 1.220584937643589e-05 6.1920998268046642e-08
+ 1.221084937643589e-05 6.192099815096055e-08
+ 1.221584937643589e-05 6.1920998171475185e-08
+ 1.2220849376435889e-05 6.1920998247010658e-08
+ 1.222584937643589e-05 6.1920998010788918e-08
+ 1.2230849376435889e-05 6.1920998076950463e-08
+ 1.223584937643589e-05 6.1920998120281731e-08
+ 1.2240849376435889e-05 6.1920998023520552e-08
+ 1.22458493764359e-05 6.1920998273050462e-08
+ 1.2250849376435899e-05 6.192099827147698e-08
+ 1.22558493764359e-05 6.1920998134046202e-08
+ 1.2260849376435899e-05 6.1920998224940566e-08
+ 1.22658493764359e-05 6.1920998248600896e-08
+ 1.2270849376435901e-05 6.192099802992956e-08
+ 1.22758493764359e-05 6.1920998112217726e-08
+ 1.2280849376435901e-05 6.1920998118053253e-08
+ 1.22858493764359e-05 6.1920998254521551e-08
+ 1.2290849376435901e-05 6.1920998039911248e-08
+ 1.22958493764359e-05 6.1920998084304801e-08
+ 1.2300849376435901e-05 6.1920998170648083e-08
+ 1.23058493764359e-05 6.1920997927495245e-08
+ 1.2310849376435911e-05 6.1920998268720629e-08
+ 1.231584937643591e-05 6.1920998313954438e-08
+ 1.232084937643591e-05 6.19209981335642e-08
+ 1.232584937643591e-05 6.1920998202104558e-08
+ 1.233084937643591e-05 6.1920998184666174e-08
+ 1.2335849376435909e-05 6.1920998323788821e-08
+ 1.234084937643591e-05 6.1920998114991415e-08
+ 1.2345849376435909e-05 6.1920997890910026e-08
+ 1.235084937643591e-05 6.1920998240482694e-08
+ 1.2355849376435909e-05 6.1920998007519107e-08
+ 1.236084937643591e-05 6.1920998328045202e-08
+ 1.2365849376435909e-05 6.1920998068311654e-08
+ 1.237084937643592e-05 6.1920998199112506e-08
+ 1.2375849376435919e-05 6.1920998014955037e-08
+ 1.238084937643592e-05 6.1920998330716068e-08
+ 1.2385849376435919e-05 6.1920998124845716e-08
+ 1.239084937643592e-05 6.1920997932690615e-08
+ 1.2395849376435921e-05 6.1920998239143562e-08
+ 1.240084937643592e-05 6.1920998273529248e-08
+ 1.2405849376435921e-05 6.1920998202719186e-08
+ 1.241084937643592e-05 6.1920997915463103e-08
+ 1.2415849376435921e-05 6.1920998152195074e-08
+ 1.242084937643592e-05 6.1920998139686673e-08
+ 1.242584937643592e-05 6.19209982488236e-08
+ 1.243084937643592e-05 6.1920998071358114e-08
+ 1.2435849376435931e-05 6.192099819657551e-08
+ 1.244084937643593e-05 6.1920997687415456e-08
+ 1.244584937643593e-05 6.1920997808519131e-08
+ 1.245084937643593e-05 6.1920997254798394e-08
+ 1.245584937643593e-05 6.1920993347864298e-08
+ 1.245794698193304e-05 6.1920907097932172e-08
+ 1.245976690581852e-05 6.1920905569844501e-08
+ 1.246168473015316e-05 6.1921195312356563e-08
+ 1.246320992274359e-05 6.1921064095924294e-08
+ 1.246488504403283e-05 6.1920800402341515e-08
+ 1.246591457940425e-05 6.1921267156218344e-08
+ 1.2466293540898341e-05 6.1921827087478318e-08
+ 1.2466846817996349e-05 6.1920916723272304e-08
+ 1.246715477953262e-05 6.1925177500233902e-08
+ 1.2467400062708611e-05 6.1917861564557648e-08
+ 1.246760057529923e-05 6.1827937770615487e-08
+ 1.246780914229571e-05 6.1856817265685086e-08
+ 1.246805218438855e-05 6.1982438156678258e-08
+ 1.246820939352221e-05 6.1364820535833323e-08
+ 1.2468276449760129e-05 5.7461951044562082e-08
+ 1.24683307363719e-05 5.5547354589001997e-08
+ 1.2468374322069639e-05 5.9469381196661218e-08
+ 1.246843887498126e-05 9.1151529835492792e-08
+ 1.246850473386618e-05 1.3063426392765781e-07
+ 1.2468569885773651e-05 1.719309069755453e-07
+ 1.24685993548433e-05 3.2930842244442958e-07
+ 1.2468619991738429e-05 6.4748080300032926e-07
+ 1.2468641671210431e-05 7.8538177923869516e-07
+ 1.2468669114111471e-05 2.7311321938927799e-07
+ 1.246869234357443e-05 -7.5000748407538239e-07
+ 1.2468713342077121e-05 -2.6186198194613621e-06
+ 1.246873224854644e-05 -4.1746112249446627e-06
+ 1.2468747411120091e-05 -4.9858652247192564e-06
+ 1.246876183474668e-05 -4.7228910667567881e-06
+ 1.246877191410534e-05 -2.5825630570539609e-06
+ 1.2468784488844209e-05 -6.7245767881819923e-07
+ 1.246880103052843e-05 -4.9016998762585756e-07
+ 1.2468819808592249e-05 -1.567153599145099e-06
+ 1.2468844132336771e-05 -2.6252423451394179e-06
+ 1.246886906580525e-05 -3.2845832720323331e-06
+ 1.246889500827378e-05 -3.3150362502347031e-06
+ 1.2468918678909101e-05 -1.9780373797826759e-06
+ 1.246894165991494e-05 -5.2226051825125051e-07
+ 1.24689686427618e-05 -5.5715804285545159e-07
+ 1.246899909213212e-05 -1.890296064875517e-06
+ 1.246902734638938e-05 -3.051116742335502e-06
+ 1.246904927593478e-05 -3.7136624570275792e-06
+ 1.2469076693901279e-05 -3.6463969274304061e-06
+ 1.246909735106573e-05 -7.5645214341148015e-07
+ 1.246911492174e-05 2.264267554438234e-06
+ 1.246913209341037e-05 -6.4626020974080692e-06
+ 1.2469149893646369e-05 -5.3718780626553683e-05
+ 1.246917240861849e-05 -0.00014695724928043161
+ 1.2469193440304391e-05 -0.00018813508390287979
+ 1.2469206397238559e-05 -0.0001373511765560063
+ 1.246921988906282e-05 -2.0094637851369272e-05
+ 1.2469235263366629e-05 0.0001128973780280128
+ 1.246925138940077e-05 0.00018357302593056271
+ 1.246927463986097e-05 0.00018545101325167349
+ 1.2469297649596939e-05 0.00014731575621053719
+ 1.24693292961543e-05 9.5771820770971765e-05
+ 1.2469359984904291e-05 6.7010366199824544e-05
+ 1.2469396884231839e-05 5.6838842509801203e-05
+ 1.246943630395988e-05 6.2788081991404588e-05
+ 1.246948755747132e-05 8.5321944351197194e-05
+ 1.24695517982292e-05 -0.0001731497378579642
+ 1.246960007939733e-05 -0.0018662880066140359
+ 1.2469646387834559e-05 -0.0064314433100070836
+ 1.2469661237697461e-05 -0.0081761559283256638
+ 1.2469675689760579e-05 -0.0082677640722183081
+ 1.246968483566951e-05 -0.00623537179099533
+ 1.2469694888578409e-05 -0.00031024572146083769
+ 1.2469705451719841e-05 0.012340685744916461
+ 1.2469718529263751e-05 0.040356991446429992
+ 1.246973098886554e-05 0.08124146125159791
+ 1.2469747250886081e-05 0.15368175032986919
+ 1.2469759041305309e-05 0.2166675090789992
+ 1.246977253362879e-05 0.29494193594720719
+ 1.2469787105414239e-05 0.38242692057511363
+ 1.246980444611052e-05 0.48609008172184309
+ 1.246982681244876e-05 0.61436570372491583
+ 1.246985655225247e-05 0.76896813428934763
+ 1.2469893315910219e-05 0.92517283244905724
+ 1.246993539374047e-05 1.0505582555447781
+ 1.246998362050553e-05 1.134612447574044
+ 1.2470025578303629e-05 1.1716539583718339
+ 1.247007845679665e-05 1.1926667860755
+ 1.2470126422300811e-05 1.1992386977192671
+ 1.247019300416671e-05 1.2014945898965581
+ 1.24702682352502e-05 1.201280620130069
+ 1.247039024282682e-05 1.2004962112084021
+ 1.2470522345853211e-05 1.20008183060315
+ 1.2470651626361251e-05 1.199979111524887
+ 1.247077463093625e-05 1.1999783030360771
+ 1.2470894184533031e-05 1.1999908130868731
+ 1.247102204862656e-05 1.199998101926244
+ 1.2471140805853799e-05 1.2000001028004961
+ 1.24712648169266e-05 1.200000309546672
+ 1.2471382559684401e-05 1.200000134140073
+ 1.247150388344222e-05 1.200000007443754
+ 1.2471621514672371e-05 1.1999999632749581
+ 1.2471741669429999e-05 1.1999999554880101
+ 1.247185961250723e-05 1.199999957832292
+ 1.2471979258343e-05 1.1999999619574671
+ 1.2472050164739081e-05 1.199999974742288
+ 1.2472097658232401e-05 1.1999999945813591
+ 1.2472146045589579e-05 1.1999999897938289
+ 1.247221181492159e-05 1.1999999412597819
+ 1.2472268082104079e-05 1.19999991201088
+ 1.2472297079381389e-05 1.1999998903171041
+ 1.247232124637327e-05 1.199999849564702
+ 1.247234329557212e-05 1.199999784865224
+ 1.247236579728385e-05 1.199999700833505
+ 1.2472393686896959e-05 1.1999996578119709
+ 1.247241403640092e-05 1.1999998916466761
+ 1.247243873289571e-05 1.2000001886033469
+ 1.2472475198182411e-05 1.20000032438849
+ 1.247252734722952e-05 1.2000001954487229
+ 1.247258001939232e-05 1.20000001125724
+ 1.247265279535142e-05 1.1999998853025331
+ 1.247273364849857e-05 1.1999998713773541
+ 1.247283464070563e-05 1.199999916548564
+ 1.2472927865527071e-05 1.1999999554165439
+ 1.247304599344467e-05 1.199999973136826
+ 1.247318279308618e-05 1.199999970193014
+ 1.2473405012008879e-05 1.1999999618236139
+ 1.2473802779437359e-05 1.1999999587608059
+ 1.2474181276475729e-05 1.199999959812375
+ 1.24747409248297e-05 1.199999960515358
+ 1.2475339732884809e-05 1.199999960547216
+ 1.247588214738723e-05 1.199999960436507
+ 1.2476418692889929e-05 1.1999999604868921
+ 1.2476799204240329e-05 1.1999999606028491
+ 1.2477225339827209e-05 1.199999960436517
+ 1.24777117001938e-05 1.1999999604572991
+ 1.247831622054252e-05 1.1999999604793781
+ 1.2479060217207719e-05 1.199999960482816
+ 1.248018158338464e-05 1.199999960481636
+ 1.248188864694788e-05 1.1999999604809231
+ 1.248478282844936e-05 1.199999960480941
+ 1.248955711188259e-05 1.199999960480916
+ 1.2494557111882589e-05 1.1999999604808671
+ 1.249955711188259e-05 1.199999960480858
+ 1.2504557111882589e-05 1.199999960480864
+ 1.250955711188259e-05 1.1999999604808671
+ 1.2514557111882589e-05 1.199999960480868
+ 1.251955711188259e-05 1.199999960480868
+ 1.2524557111882591e-05 1.199999960480868
+ 1.252955711188259e-05 1.199999960480868
+ 1.2534557111882591e-05 1.199999960480868
+ 1.253955711188259e-05 1.199999960480868
+ 1.2544557111882601e-05 1.199999960480868
+ 1.25495571118826e-05 1.199999960480868
+ 1.2554557111882601e-05 1.199999960480868
+ 1.25595571118826e-05 1.199999960480868
+ 1.2564557111882601e-05 1.199999960480868
+ 1.25695571118826e-05 1.199999960480868
+ 1.2574557111882601e-05 1.199999960480868
+ 1.25795571118826e-05 1.199999960480868
+ 1.25845571118826e-05 1.199999960480868
+ 1.25895571118826e-05 1.199999960480868
+ 1.25945571118826e-05 1.199999960480868
+ 1.2599557111882599e-05 1.199999960480868
+ 1.260455711188261e-05 1.199999960480868
+ 1.2609557111882609e-05 1.199999960480868
+ 1.261455711188261e-05 1.199999960480868
+ 1.2619557111882609e-05 1.199999960480868
+ 1.262455711188261e-05 1.199999960480868
+ 1.2629557111882609e-05 1.199999960480868
+ 1.263455711188261e-05 1.199999960480868
+ 1.2639557111882609e-05 1.199999960480868
+ 1.264455711188261e-05 1.199999960480868
+ 1.2649557111882611e-05 1.199999960480868
+ 1.265455711188261e-05 1.199999960480868
+ 1.2659557111882611e-05 1.199999960480868
+ 1.266455711188261e-05 1.199999960480868
+ 1.2669557111882621e-05 1.199999960480868
+ 1.267455711188262e-05 1.199999960480868
+ 1.2679557111882621e-05 1.199999960480868
+ 1.268455711188262e-05 1.199999960480868
+ 1.2689557111882621e-05 1.199999960480868
+ 1.269455711188262e-05 1.199999960480868
+ 1.269955711188262e-05 1.199999960480868
+ 1.270455711188262e-05 1.199999960480868
+ 1.270955711188262e-05 1.1999999604808671
+ 1.271455711188262e-05 1.1999999604808671
+ 1.271955711188262e-05 1.1999999604808651
+ 1.2724557111882619e-05 1.199999960480862
+ 1.272955711188263e-05 1.199999960480856
+ 1.2734557111882629e-05 1.199999960480846
+ 1.273955711188263e-05 1.1999999604808249
+ 1.2744557111882629e-05 1.1999999604807861
+ 1.274955711188263e-05 1.199999960480711
+ 1.2754557111882629e-05 1.1999999604805669
+ 1.275955711188263e-05 1.1999999604802929
+ 1.2764557111882629e-05 1.199999960479792
+ 1.276955711188263e-05 1.1999999604789111
+ 1.2774557111882631e-05 1.199999960477353
+ 1.277955711188263e-05 1.1999999604740681
+ 1.2784557111882631e-05 1.1999999604599041
+ 1.278687193808408e-05 1.1999999603465841
+ 1.2788594891097721e-05 1.1999999600806379
+ 1.27907485922458e-05 1.1999999602409051
+ 1.279217624076546e-05 1.1999999604847069
+ 1.2793903571382871e-05 1.199999960377802
+ 1.2795039306859861e-05 1.199999960591825
+ 1.2795524380003931e-05 1.1999999611550389
+ 1.279617836762076e-05 1.199999961678311
+ 1.279651083764453e-05 1.199999964687865
+ 1.279678675264608e-05 1.1999999678434301
+ 1.279700658453315e-05 1.1999999617489061
+ 1.2797216721228829e-05 1.199999911606912
+ 1.279743119496709e-05 1.1999998612879881
+ 1.279767320288686e-05 1.1999998118833171
+ 1.279778397757388e-05 1.199999580322533
+ 1.2797845857764021e-05 1.1999991819314431
+ 1.279789864420034e-05 1.1999987535865251
+ 1.279794796989539e-05 1.1999983970467989
+ 1.2798012224003429e-05 1.199997959962696
+ 1.279808367038229e-05 1.1999982021932429
+ 1.2798158711662001e-05 1.1999993113843921
+ 1.279818163533662e-05 1.1999997645431739
+ 1.2798200969548051e-05 1.1999997439492061
+ 1.2798222290008541e-05 1.200000577072116
+ 1.279824806851308e-05 1.2000039876973789
+ 1.2798271483867971e-05 1.200008707048595
+ 1.279829787001219e-05 1.200010907474655
+ 1.279831872296197e-05 1.200009599106816
+ 1.2798336773682429e-05 1.200006738989448
+ 1.279834943735935e-05 1.200004045820604
+ 1.2798365100409779e-05 1.2000012193863649
+ 1.279838784767774e-05 1.199998834990863
+ 1.2798417934139911e-05 1.199997584534743
+ 1.27984494995027e-05 1.1999970907789199
+ 1.2798478197890901e-05 1.199997266057738
+ 1.279850851151699e-05 1.1999989755559199
+ 1.279853444321745e-05 1.200001604089411
+ 1.2798563248973639e-05 1.2000045491753379
+ 1.279858920342019e-05 1.200006612960872
+ 1.2798607516525061e-05 1.200007940552458
+ 1.2798623272905611e-05 1.2000092780384899
+ 1.279863883834528e-05 1.2000112021799489
+ 1.2798652605864001e-05 1.200013007455921
+ 1.279866813016425e-05 1.2000131662320319
+ 1.2798679737273619e-05 1.2000120422153331
+ 1.2798694066654139e-05 1.20000989398428
+ 1.27987188172593e-05 1.2000054700429841
+ 1.2798741325095271e-05 1.199993428437907
+ 1.279876482359457e-05 1.1999474913834201
+ 1.279878801270085e-05 1.1998670686394031
+ 1.279881663143411e-05 1.1997269320652719
+ 1.2798859998294221e-05 1.199502976777449
+ 1.279887862283447e-05 1.2005311355981489
+ 1.2798895863833249e-05 1.20360678024375
+ 1.279891961588879e-05 1.211628919209812
+ 1.279893941110269e-05 1.2147429897749991
+ 1.279895432197819e-05 1.1999602647634331
+ 1.27989713209206e-05 1.150411966436957
+ 1.2798989014954071e-05 1.068281566773702
+ 1.279900636215561e-05 0.97040064476870469
+ 1.279902817467645e-05 0.83886782146592886
+ 1.2799048838455949e-05 0.71355319971650133
+ 1.279906324497402e-05 0.62782044620503707
+ 1.2799074436622839e-05 0.56279786911499619
+ 1.27990903007195e-05 0.47380848079173538
+ 1.27991018478231e-05 0.41188444736908542
+ 1.2799115078498099e-05 0.3447370510459753
+ 1.27991351445147e-05 0.25326507684369048
+ 1.279915826333837e-05 0.16732953599130901
+ 1.2799180407972109e-05 0.1062274207709147
+ 1.27992035627241e-05 0.062610376889369476
+ 1.2799220722717831e-05 0.041258037655917193
+ 1.2799238478309039e-05 0.026370159492895909
+ 1.2799260528988351e-05 0.014712201186111841
+ 1.2799281115953191e-05 0.0083399681051783709
+ 1.2799307561496679e-05 0.003811463578990381
+ 1.279933491334018e-05 0.001544509372355311
+ 1.279937124649464e-05 0.00028677250569929383
+ 1.2799413279728481e-05 -0.00013243732682387629
+ 1.279947305925103e-05 -0.00018243164180309211
+ 1.2799553548945621e-05 -9.0637532067245453e-05
+ 1.279964281238941e-05 -2.2363259787988091e-05
+ 1.279974735232739e-05 2.122216437575337e-06
+ 1.279987994039465e-05 4.2347169355351516e-06
+ 1.280004280936273e-05 1.4469710396062479e-06
+ 1.280018097028504e-05 2.4678201284796048e-07
+ 1.280030531017722e-05 8.0218053183860758e-09
+ 1.280042366921189e-05 1.8525107967403099e-08
+ 1.28005421760455e-05 4.8677717146994832e-08
+ 1.2800670475189519e-05 6.1638866459697013e-08
+ 1.280079044188218e-05 6.4521430218457113e-08
+ 1.2800915507553789e-05 6.6288414478971361e-08
+ 1.280103409571474e-05 6.9229504211217359e-08
+ 1.280115588201796e-05 7.3736110851584685e-08
+ 1.280127385205969e-05 8.4761948809915035e-08
+ 1.2801394185113831e-05 1.2759774097703531e-07
+ 1.280147057094179e-05 3.0957823264159828e-07
+ 1.280152133466244e-05 5.958850856177823e-07
+ 1.2801574964167511e-05 6.5046191979934668e-07
+ 1.2801640778339801e-05 2.3773699425771039e-07
+ 1.280167646445029e-05 -1.415548909983597e-07
+ 1.280170700953482e-05 -5.3642879965664983e-07
+ 1.280173162327033e-05 -9.764967486558097e-07
+ 1.2801754760444539e-05 -1.48018268297233e-06
+ 1.2801776218071789e-05 -1.7526734754673951e-06
+ 1.2801805116333271e-05 -1.6243492126578579e-06
+ 1.280182591822105e-05 -1.726723104571158e-06
+ 1.28018489090857e-05 -6.6820904757215287e-07
+ 1.280188980636169e-05 1.10718422817859e-06
+ 1.2801929322855479e-05 1.415123172608226e-06
+ 1.280198959039845e-05 7.2946329270779005e-07
+ 1.2802054315577461e-05 1.8135415310080031e-07
+ 1.280213499909256e-05 2.9557446515646991e-08
+ 1.2802220225633381e-05 -1.700436572991505e-08
+ 1.2802321421628259e-05 -5.1768348236612318e-09
+ 1.280243656551876e-05 4.7445346965234962e-08
+ 1.28025635456817e-05 7.3637242892882381e-08
+ 1.28027326362886e-05 7.0143070984099393e-08
+ 1.280297903365081e-05 6.1763550967585725e-08
+ 1.2803292081805551e-05 6.0752959689351767e-08
+ 1.280364726418016e-05 6.1737467059783419e-08
+ 1.280408340282889e-05 6.2029547447541853e-08
+ 1.280460872185691e-05 6.2057885724759975e-08
+ 1.280522442975215e-05 6.1588271743970212e-08
+ 1.280562036868622e-05 6.0290471014544502e-08
+ 1.280596254502368e-05 6.3045874270744804e-08
+ 1.280639494699283e-05 6.2223085479482539e-08
+ 1.2806859461726989e-05 6.172694328918745e-08
+ 1.280740882901973e-05 6.1910304953039287e-08
+ 1.280800079655297e-05 6.192225462474732e-08
+ 1.2808821819434009e-05 6.1919148366315936e-08
+ 1.280997652630485e-05 6.1921756029550113e-08
+ 1.2811981294539139e-05 6.1921387430744447e-08
+ 1.2815025828901091e-05 6.1921012617086338e-08
+ 1.282002582890109e-05 6.1920982364237683e-08
+ 1.2825025828901091e-05 6.1920994937632313e-08
+ 1.283002582890109e-05 6.1920997435009365e-08
+ 1.2835025828901091e-05 6.1920997947936943e-08
+ 1.284002582890109e-05 6.1920997905010571e-08
+ 1.2845025828901091e-05 6.1920998210722284e-08
+ 1.285002582890109e-05 6.1920998260108328e-08
+ 1.2855025828901101e-05 6.1920998139253813e-08
+ 1.28600258289011e-05 6.1920998123817458e-08
+ 1.28650258289011e-05 6.1920998214050502e-08
+ 1.28700258289011e-05 6.1920998278895969e-08
+ 1.28750258289011e-05 6.1920998115095467e-08
+ 1.28800258289011e-05 6.1920997847265198e-08
+ 1.28850258289011e-05 6.1920998234351195e-08
+ 1.2890025828901099e-05 6.1920997997369812e-08
+ 1.28950258289011e-05 6.1920998057506134e-08
+ 1.2900025828901099e-05 6.1920998115894444e-08
+ 1.29050258289011e-05 6.1920998136766051e-08
+ 1.2910025828901099e-05 6.1920998221604116e-08
+ 1.291502582890111e-05 6.1920998299278229e-08
+ 1.2920025828901109e-05 6.1920998115977811e-08
+ 1.292502582890111e-05 6.1920998148203709e-08
+ 1.2930025828901109e-05 6.1920997963142825e-08
+ 1.293502582890111e-05 6.1920997998809795e-08
+ 1.2940025828901111e-05 6.1920998057988771e-08
+ 1.294502582890111e-05 6.1920998154991129e-08
+ 1.2950025828901111e-05 6.1920998197988004e-08
+ 1.295502582890111e-05 6.192099824953741e-08
+ 1.2960025828901111e-05 6.192099829890928e-08
+ 1.296502582890111e-05 6.1920998304255103e-08
+ 1.297002582890111e-05 6.1920998156288996e-08
+ 1.297502582890111e-05 6.1920997956927073e-08
+ 1.2980025828901121e-05 6.192099800660402e-08
+ 1.298502582890112e-05 6.1920998353241374e-08
+ 1.299002582890112e-05 6.1920998125794896e-08
+ 1.299502582890112e-05 6.1920998210488821e-08
+ 1.300002582890112e-05 6.1920998257238951e-08
+ 1.3005025828901119e-05 6.1920998315808858e-08
+ 1.301002582890112e-05 6.1920998088260894e-08
+ 1.3015025828901119e-05 6.1920998157789025e-08
+ 1.302002582890112e-05 6.1920997944454142e-08
+ 1.3025025828901119e-05 6.1920997972902114e-08
+ 1.303002582890112e-05 6.1920998283571922e-08
+ 1.3035025828901119e-05 6.1920998342599875e-08
+ 1.304002582890113e-05 6.1920998201587974e-08
+ 1.3045025828901129e-05 6.192099825581759e-08
+ 1.305002582890113e-05 6.1920998047507453e-08
+ 1.3055025828901129e-05 6.1920998067622672e-08
+ 1.306002582890113e-05 6.1920998187335956e-08
+ 1.3065025828901131e-05 6.1920998063508633e-08
+ 1.307002582890113e-05 6.192099805803643e-08
+ 1.3075025828901131e-05 6.1920998115768647e-08
+ 1.308002582890113e-05 6.192099811410563e-08
+ 1.3085025828901131e-05 6.1920998108325093e-08
+ 1.309002582890113e-05 6.192099802238255e-08
+ 1.309502582890113e-05 6.192099819837085e-08
+ 1.310002582890113e-05 6.1920998066347093e-08
+ 1.3105025828901141e-05 6.1920997764484258e-08
+ 1.311002582890114e-05 6.1920997352212424e-08
+ 1.311502582890114e-05 6.1920993288587676e-08
+ 1.311712383953007e-05 6.1920906797305065e-08
+ 1.311894335494022e-05 6.1920905375609827e-08
+ 1.312086218016635e-05 6.1921195230274399e-08
+ 1.3122386818147291e-05 6.1921064265477658e-08
+ 1.312406182197962e-05 6.1920799989918142e-08
+ 1.3125091701957711e-05 6.1921267848747717e-08
+ 1.312547093069876e-05 6.1921822669928304e-08
+ 1.3126024614135729e-05 6.1920917923323861e-08
+ 1.3126332658621901e-05 6.192517522956228e-08
+ 1.3126577962837019e-05 6.191791062764169e-08
+ 1.3126778421442299e-05 6.1828240622925274e-08
+ 1.312698699069758e-05 6.1856378229841255e-08
+ 1.3127230124708429e-05 6.1982589868703793e-08
+ 1.312738776636292e-05 6.1368564506843835e-08
+ 1.312745492031535e-05 5.7463584922743701e-08
+ 1.3127509186725241e-05 5.5538197085866467e-08
+ 1.31275527824952e-05 5.9475892398732873e-08
+ 1.312761733366224e-05 9.1173457511660134e-08
+ 1.3127683187299059e-05 1.3064924190746059e-07
+ 1.312774831429768e-05 1.7194164727418989e-07
+ 1.312777777696901e-05 3.2923862804905888e-07
+ 1.312779841585476e-05 6.4733353013953566e-07
+ 1.3127820091489029e-05 7.8547234827833206e-07
+ 1.312784753090369e-05 2.7347687995513372e-07
+ 1.312787076573669e-05 -7.4921416409353625e-07
+ 1.3127891764690359e-05 -2.6175009517613679e-06
+ 1.3127910667272501e-05 -4.1738307663526467e-06
+ 1.312792583282967e-05 -4.9850028807658669e-06
+ 1.312794024951398e-05 -4.7256296658284419e-06
+ 1.3127950325924729e-05 -2.5860964659721688e-06
+ 1.312796289928738e-05 -6.7378185511778273e-07
+ 1.312797942640669e-05 -4.8879882064852786e-07
+ 1.31279982038101e-05 -1.5652278265015081e-06
+ 1.312802251934842e-05 -2.623877939724724e-06
+ 1.312804744969729e-05 -3.283530472086986e-06
+ 1.312807338858392e-05 -3.316372101479452e-06
+ 1.312809708429692e-05 -1.9807138214273141e-06
+ 1.312812005992133e-05 -5.236455125953103e-07
+ 1.3128147027146101e-05 -5.5576489597947678e-07
+ 1.312817749399828e-05 -1.888572557663456e-06
+ 1.3128205731271031e-05 -3.0491479558857671e-06
+ 1.312822766509288e-05 -3.712395133868007e-06
+ 1.312825510564751e-05 -3.6486617358661781e-06
+ 1.3128275801528021e-05 -7.5527498353421159e-07
+ 1.3128293386833379e-05 2.2637867502796888e-06
+ 1.3128310559374539e-05 -6.5121129548310673e-06
+ 1.312832836046227e-05 -5.3849815073580331e-05
+ 1.312835086815704e-05 -0.00014706765366052129
+ 1.312837192620562e-05 -0.00018808392336400919
+ 1.3128384880757521e-05 -0.00013703863552662679
+ 1.3128398381237491e-05 -1.957053230635846e-05
+ 1.31284137714237e-05 0.0001133655812449505
+ 1.312842990500745e-05 0.00018372000731655929
+ 1.312845320526392e-05 0.00018530482974587039
+ 1.3128476208298281e-05 0.00014710592444961641
+ 1.312850788726549e-05 9.5567399483383143e-05
+ 1.312853858101282e-05 6.6916417352509453e-05
+ 1.312857550890061e-05 5.6833527504409581e-05
+ 1.312861495558477e-05 6.2855069124438792e-05
+ 1.3128666276648989e-05 8.5426445630561727e-05
+ 1.312873059096905e-05 -0.00017806917139182981
+ 1.3128778768951939e-05 -0.00188276190524302
+ 1.3128825159809e-05 -0.0064749294913037606
+ 1.312883987495321e-05 -0.008194247483289412
+ 1.312885434965197e-05 -0.0082388088482048
+ 1.312886353390109e-05 -0.0061256548499957816
+ 1.3128873542548371e-05 -0.0001107066566560257
+ 1.312888408864868e-05 0.01267200236231533
+ 1.3128897154617559e-05 0.040881837477917272
+ 1.3128909655175719e-05 0.082137692907634091
+ 1.3128925476283889e-05 0.1526896699113085
+ 1.312893711350672e-05 0.21474528378304991
+ 1.312895049249519e-05 0.29226006671278371
+ 1.312896499493432e-05 0.37930115763358518
+ 1.312898221756841e-05 0.48233433188591301
+ 1.312900441777296e-05 0.60991431821818065
+ 1.312903390896731e-05 0.76389187902307731
+ 1.312907053314193e-05 0.92079407460224427
+ 1.312911233131411e-05 1.047085008284931
+ 1.312916248979231e-05 1.1353288414018261
+ 1.312920493189697e-05 1.1724530703984839
+ 1.312925787361808e-05 1.193062881008415
+ 1.3129305983002661e-05 1.199426452336078
+ 1.3129372518131611e-05 1.2015329261457239
+ 1.3129448166418691e-05 1.201270740672133
+ 1.312957104281062e-05 1.200477024251611
+ 1.312970347426038e-05 1.200073392042845
+ 1.3129832754100201e-05 1.1999773124051081
+ 1.3129955651185919e-05 1.199978419075997
+ 1.3130075127317531e-05 1.1999911145397919
+ 1.313020287490074e-05 1.1999982498533199
+ 1.3130321608325791e-05 1.2000001460861289
+ 1.3130445578850019e-05 1.200000312177377
+ 1.313056332973214e-05 1.200000129946285
+ 1.313068464074404e-05 1.200000004721413
+ 1.3130802281702781e-05 1.199999962323677
+ 1.313092242870391e-05 1.199999955348112
+ 1.3131040377166359e-05 1.1999999578972129
+ 1.313116001813486e-05 1.199999962092007
+ 1.313122969487224e-05 1.1999999752717261
+ 1.3131276980067459e-05 1.19999999487112
+ 1.3131325551551159e-05 1.199999989163681
+ 1.3131391057082539e-05 1.1999999404870321
+ 1.3131445371920591e-05 1.19999991198642
+ 1.313147398228715e-05 1.199999891520158
+ 1.313149848291939e-05 1.19999985276745
+ 1.313152079103252e-05 1.1999997891946741
+ 1.313154337841788e-05 1.1999997052983959
+ 1.3131571492903411e-05 1.1999996562125601
+ 1.313159241036837e-05 1.199999888154462
+ 1.3131617123258179e-05 1.20000018592664
+ 1.313165275366085e-05 1.200000323520054
+ 1.313170545139159e-05 1.2000001967389839
+ 1.313175740543423e-05 1.200000014163902
+ 1.313183031621503e-05 1.199999886036023
+ 1.313191207441727e-05 1.1999998711750131
+ 1.31320115217606e-05 1.1999999157623771
+ 1.31321056571353e-05 1.1999999552186551
+ 1.313222242188716e-05 1.1999999730279749
+ 1.313235992925489e-05 1.1999999702552291
+ 1.313257936387284e-05 1.199999961924765
+ 1.3132979603490091e-05 1.1999999587503201
+ 1.313335532107972e-05 1.199999959799301
+ 1.3133916766940731e-05 1.1999999605147531
+ 1.31345119328028e-05 1.1999999605480189
+ 1.313505529565707e-05 1.199999960437456
+ 1.313558605792509e-05 1.199999960484134
+ 1.3135962787951569e-05 1.199999960605332
+ 1.3136385974405549e-05 1.1999999604375191
+ 1.313686907485611e-05 1.199999960456722
+ 1.3137471473075839e-05 1.1999999604790439
+ 1.3138205817014201e-05 1.1999999604827649
+ 1.313931227692096e-05 1.199999960481674
+ 1.3140984021546029e-05 1.1999999604809339
+ 1.3143833096245099e-05 1.199999960480939
+ 1.314848437098701e-05 1.1999999604809191
+ 1.315348437098701e-05 1.199999960480868
+ 1.315848437098701e-05 1.199999960480858
+ 1.316348437098701e-05 1.1999999604808631
+ 1.3168484370987009e-05 1.199999960480866
+ 1.317348437098701e-05 1.199999960480868
+ 1.3178484370987009e-05 1.199999960480868
+ 1.318348437098701e-05 1.199999960480868
+ 1.3188484370987009e-05 1.199999960480868
+ 1.319348437098702e-05 1.199999960480868
+ 1.3198484370987019e-05 1.199999960480868
+ 1.320348437098702e-05 1.199999960480868
+ 1.3208484370987019e-05 1.199999960480868
+ 1.321348437098702e-05 1.199999960480868
+ 1.3218484370987021e-05 1.199999960480868
+ 1.322348437098702e-05 1.199999960480868
+ 1.3228484370987021e-05 1.199999960480868
+ 1.323348437098702e-05 1.199999960480868
+ 1.3238484370987021e-05 1.199999960480868
+ 1.324348437098702e-05 1.199999960480868
+ 1.3248484370987021e-05 1.199999960480868
+ 1.325348437098702e-05 1.199999960480868
+ 1.3258484370987031e-05 1.199999960480868
+ 1.326348437098703e-05 1.199999960480868
+ 1.326848437098703e-05 1.199999960480868
+ 1.327348437098703e-05 1.199999960480868
+ 1.327848437098703e-05 1.199999960480868
+ 1.328348437098703e-05 1.199999960480868
+ 1.328848437098703e-05 1.199999960480868
+ 1.3293484370987029e-05 1.199999960480868
+ 1.329848437098703e-05 1.199999960480868
+ 1.3303484370987029e-05 1.199999960480868
+ 1.330848437098703e-05 1.199999960480868
+ 1.3313484370987029e-05 1.199999960480868
+ 1.331848437098704e-05 1.199999960480868
+ 1.3323484370987039e-05 1.199999960480868
+ 1.332848437098704e-05 1.199999960480868
+ 1.3333484370987039e-05 1.199999960480868
+ 1.333848437098704e-05 1.199999960480868
+ 1.3343484370987041e-05 1.199999960480868
+ 1.334848437098704e-05 1.199999960480868
+ 1.3353484370987041e-05 1.199999960480868
+ 1.335848437098704e-05 1.199999960480868
+ 1.3363484370987041e-05 1.199999960480868
+ 1.336848437098704e-05 1.199999960480868
+ 1.3373484370987041e-05 1.1999999604808671
+ 1.337848437098704e-05 1.1999999604808651
+ 1.3383484370987051e-05 1.199999960480862
+ 1.338848437098705e-05 1.1999999604808571
+ 1.339348437098705e-05 1.199999960480846
+ 1.339848437098705e-05 1.1999999604808269
+ 1.340348437098705e-05 1.1999999604807889
+ 1.3408484370987049e-05 1.1999999604807161
+ 1.341348437098705e-05 1.199999960480576
+ 1.3418484370987049e-05 1.1999999604803111
+ 1.342348437098705e-05 1.199999960479825
+ 1.3428484370987049e-05 1.1999999604789691
+ 1.343348437098705e-05 1.1999999604774561
+ 1.3438484370987049e-05 1.1999999604743239
+ 1.344348437098706e-05 1.1999999604616289
+ 1.3445891154294659e-05 1.199999960364333
+ 1.344759415169055e-05 1.199999960093348
+ 1.344973733439017e-05 1.1999999602178919
+ 1.3451186571937081e-05 1.199999960460534
+ 1.345295475916474e-05 1.199999960397125
+ 1.345414350695765e-05 1.1999999605534271
+ 1.345466406175139e-05 1.1999999610865639
+ 1.3455313827788561e-05 1.1999999615997119
+ 1.3455643765066221e-05 1.1999999643143411
+ 1.3455934762432879e-05 1.1999999672854831
+ 1.345616486682929e-05 1.199999964291151
+ 1.3456372892902691e-05 1.199999919049715
+ 1.345658829609272e-05 1.1999998655736599
+ 1.3456830169267441e-05 1.199999821318823
+ 1.345694956025666e-05 1.1999996305358269
+ 1.3457012670262449e-05 1.199999277564487
+ 1.3457070358383091e-05 1.1999988299979081
+ 1.3457116391748411e-05 1.1999985098734329
+ 1.345718303776272e-05 1.199998007355727
+ 1.345725356615823e-05 1.1999980995063719
+ 1.345733439875318e-05 1.1999991692692149
+ 1.3457359171901259e-05 1.1999997080965079
+ 1.3457378923882301e-05 1.199999783586885
+ 1.3457398087570769e-05 1.2000001915915799
+ 1.3457422937034001e-05 1.2000029572294
+ 1.3457448714140749e-05 1.2000080312617269
+ 1.3457473674321439e-05 1.2000108026035159
+ 1.3457494750039419e-05 1.200010065354477
+ 1.345751273260126e-05 1.2000076367289401
+ 1.3457526688087441e-05 1.2000047616171881
+ 1.3457542355923369e-05 1.2000017718574509
+ 1.345756097955741e-05 1.199999459558128
+ 1.3457587471269331e-05 1.1999979425882481
+ 1.345761788598975e-05 1.1999972752228569
+ 1.3457647086219639e-05 1.199997094773523
+ 1.345767238485973e-05 1.1999978306978649
+ 1.3457698476039319e-05 1.19999991941636
+ 1.345772601154606e-05 1.2000028367658
+ 1.345775555182759e-05 1.2000055425499681
+ 1.345777910534497e-05 1.2000072374752351
+ 1.345779556635126e-05 1.200008484660805
+ 1.345781134505766e-05 1.2000100259686981
+ 1.34578257489769e-05 1.2000120816372379
+ 1.3457842114978421e-05 1.2000133438043321
+ 1.3457853965275891e-05 1.200012785418108
+ 1.345786753289538e-05 1.2000110928497549
+ 1.34578870363374e-05 1.2000078927202931
+ 1.345791395183026e-05 1.2000000742978161
+ 1.345794243117672e-05 1.199957736894822
+ 1.3457965304762331e-05 1.1998842328284021
+ 1.345799273287495e-05 1.19975759346498
+ 1.3458032093169429e-05 1.199443783149454
+ 1.345805247522159e-05 1.1998893421373109
+ 1.3458068718145851e-05 1.2017906860573
+ 1.3458089832855539e-05 1.2074969763925789
+ 1.345811188538176e-05 1.215158335636199
+ 1.345812631322881e-05 1.2125563755127009
+ 1.345814002194873e-05 1.191074348320883
+ 1.3458157357182169e-05 1.1306592232650501
+ 1.3458177739980651e-05 1.0272982086072699
+ 1.3458199075923651e-05 0.90184774053853878
+ 1.345821895738285e-05 0.78062661733264016
+ 1.3458236422571471e-05 0.67520275106722782
+ 1.345824887918158e-05 0.60171143056735132
+ 1.345826019797182e-05 0.5366287566061847
+ 1.345827371966172e-05 0.461507444070069
+ 1.345828597041612e-05 0.39648186946134811
+ 1.3458300485043241e-05 0.32426122925387241
+ 1.3458320755451549e-05 0.2349803938300308
+ 1.345834422779626e-05 0.15228977535988161
+ 1.3458366413035551e-05 0.095491058775604695
+ 1.3458383873394369e-05 0.064044975958217704
+ 1.3458399492972989e-05 0.044045415165488912
+ 1.3458416868894e-05 0.02858826126884664
+ 1.345843854986899e-05 0.01622216599284439
+ 1.345845934932934e-05 0.0091906536213681653
+ 1.3458485241327311e-05 0.0043087967154099649
+ 1.3458512335123771e-05 0.00179140065972951
+ 1.345854737575545e-05 0.00039769612604004722
+ 1.345858819953811e-05 -0.0001033697855164542
+ 1.345864498387941e-05 -0.00019034386946735439
+ 1.345872133799999e-05 -0.0001051367652517819
+ 1.345881196982314e-05 -2.7953499834378661e-05
+ 1.3458911308110821e-05 4.6099339093786761e-07
+ 1.3459041672118519e-05 4.5257401560973564e-06
+ 1.3459217839320449e-05 1.7414859398520729e-06
+ 1.3459360659530409e-05 3.3844815353268148e-07
+ 1.345948575530029e-05 2.319958687421352e-08
+ 1.34596030416527e-05 1.5930899418799039e-08
+ 1.345972063342825e-05 4.5688409784637483e-08
+ 1.3459848468100309e-05 6.0635297205744877e-08
+ 1.345996817589906e-05 6.4355343197994054e-08
+ 1.346009330635648e-05 6.6271747074158193e-08
+ 1.3460211909534291e-05 6.9164655649741163e-08
+ 1.3460333803587021e-05 7.3569203472198935e-08
+ 1.3460451784507891e-05 8.4258518376983765e-08
+ 1.3460572161882849e-05 1.25189433894194e-07
+ 1.346065023611619e-05 3.0090743762583541e-07
+ 1.346070123276653e-05 5.8927274699888218e-07
+ 1.3460754441776839e-05 6.5608035190146915e-07
+ 1.346082045240109e-05 2.5171558851472712e-07
+ 1.346085583615089e-05 -1.241272362954372e-07
+ 1.3460887077263091e-05 -5.1947013538298409e-07
+ 1.3460911999544089e-05 -9.5609868743585948e-07
+ 1.3460935279772451e-05 -1.461981954541061e-06
+ 1.34609567913885e-05 -1.751063718284538e-06
+ 1.34609827660987e-05 -1.6202791400832469e-06
+ 1.3461003622844949e-05 -1.7938902961600689e-06
+ 1.3461026424052161e-05 -8.6788625909329179e-07
+ 1.346106291068801e-05 8.830336735788275e-07
+ 1.3461103096215981e-05 1.4367637981944461e-06
+ 1.3461159146199259e-05 8.712262147550902e-07
+ 1.3461222687697099e-05 2.4388252591179061e-07
+ 1.346130563299639e-05 3.4399363636948212e-08
+ 1.346139915226452e-05 -1.7787659494789109e-08
+ 1.3461507561720901e-05 -9.3806301089804891e-09
+ 1.346161979658581e-05 4.2896935662216141e-08
+ 1.346174951573459e-05 7.3409657717121221e-08
+ 1.346191402710631e-05 7.0847685448725282e-08
+ 1.346216755981208e-05 6.1814814987125965e-08
+ 1.346247518191624e-05 6.0703994356669762e-08
+ 1.346283771558627e-05 6.1738054001094423e-08
+ 1.3463269601353871e-05 6.2031881657736291e-08
+ 1.3463803734566619e-05 6.2059034296053531e-08
+ 1.346440893856906e-05 6.1569601553401455e-08
+ 1.346480369673318e-05 6.0297015345628792e-08
+ 1.3465142855728449e-05 6.3065742115408419e-08
+ 1.346557196473933e-05 6.2208033603335465e-08
+ 1.34660389722573e-05 6.1728663780249725e-08
+ 1.346659046095041e-05 6.1911320052899564e-08
+ 1.3467181595414839e-05 6.1921723460349971e-08
+ 1.3468003313932589e-05 6.1919072615565309e-08
+ 1.3469154686519679e-05 6.1921785992983875e-08
+ 1.347116158686279e-05 6.1921392251315213e-08
+ 1.347420270917001e-05 6.1921012521966696e-08
+ 1.3479202709170011e-05 6.1920982450561405e-08
+ 1.348420270917001e-05 6.1920994995952993e-08
+ 1.348920270917001e-05 6.1920997645096592e-08
+ 1.349420270917001e-05 6.1920997876114756e-08
+ 1.349920270917001e-05 6.1920998282323898e-08
+ 1.3504202709170009e-05 6.192099828827629e-08
+ 1.350920270917002e-05 6.1920998178142869e-08
+ 1.351420270917002e-05 6.1920997911671294e-08
+ 1.351920270917002e-05 6.1920998059084328e-08
+ 1.3524202709170019e-05 6.1920998082640844e-08
+ 1.352920270917002e-05 6.1920998168196929e-08
+ 1.3534202709170019e-05 6.1920998200963803e-08
+ 1.353920270917002e-05 6.1920997987886603e-08
+ 1.3544202709170019e-05 6.1920998288344145e-08
+ 1.354920270917002e-05 6.192099815935008e-08
+ 1.3554202709170019e-05 6.1920998155626881e-08
+ 1.355920270917002e-05 6.1920998223881126e-08
+ 1.3564202709170021e-05 6.1920998013167361e-08
+ 1.356920270917002e-05 6.1920998053119019e-08
+ 1.3574202709170031e-05 6.1920998191183246e-08
+ 1.357920270917003e-05 6.1920998189161471e-08
+ 1.3584202709170031e-05 6.1920998034904595e-08
+ 1.358920270917003e-05 6.1920998291005893e-08
+ 1.3594202709170031e-05 6.1920998134442692e-08
+ 1.359920270917003e-05 6.1920998151989562e-08
+ 1.3604202709170031e-05 6.1920998253545266e-08
+ 1.360920270917003e-05 6.1920998006084153e-08
+ 1.361420270917003e-05 6.192099834169429e-08
+ 1.361920270917003e-05 6.1920998125653746e-08
+ 1.362420270917003e-05 6.1920998254707607e-08
+ 1.3629202709170029e-05 6.1920998000163208e-08
+ 1.363420270917004e-05 6.1920998060142934e-08
+ 1.363920270917004e-05 6.1920998156657481e-08
+ 1.364420270917004e-05 6.1920997927042308e-08
+ 1.3649202709170039e-05 6.1920998246140795e-08
+ 1.365420270917004e-05 6.1920998275975519e-08
+ 1.3659202709170039e-05 6.192099808918731e-08
+ 1.366420270917004e-05 6.1920998145805931e-08
+ 1.3669202709170039e-05 6.192099819505498e-08
+ 1.367420270917004e-05 6.1920998207120171e-08
+ 1.3679202709170041e-05 6.1920998273725932e-08
+ 1.368420270917004e-05 6.1920998128051379e-08
+ 1.3689202709170041e-05 6.1920998135469654e-08
+ 1.369420270917004e-05 6.1920997967900279e-08
+ 1.3699202709170051e-05 6.1920998032343631e-08
+ 1.370420270917005e-05 6.192099809687285e-08
+ 1.3709202709170051e-05 6.1920998171432079e-08
+ 1.371420270917005e-05 6.1920998185042455e-08
+ 1.3719202709170051e-05 6.1920997982422169e-08
+ 1.372420270917005e-05 6.1920998119996598e-08
+ 1.3729202709170051e-05 6.1920998187276664e-08
+ 1.373420270917005e-05 6.1920998137241911e-08
+ 1.373920270917005e-05 6.1920997995401586e-08
+ 1.374420270917005e-05 6.1920998043415503e-08
+ 1.374920270917005e-05 6.1920998003050942e-08
+ 1.3754202709170049e-05 6.1920998073947798e-08
+ 1.375920270917006e-05 6.192099783818204e-08
+ 1.3764202709170059e-05 6.1920997654286502e-08
+ 1.376920270917006e-05 6.1920997465531245e-08
+ 1.3774202709170059e-05 6.1920993492595098e-08
+ 1.3776301732123621e-05 6.1920907192443804e-08
+ 1.377812023310845e-05 6.1920904763585814e-08
+ 1.378004154810568e-05 6.1921195234363927e-08
+ 1.378156481562871e-05 6.192106518953413e-08
+ 1.3783239536384831e-05 6.1920799216068881e-08
+ 1.378427024960163e-05 6.192126696461617e-08
+ 1.3784650139780489e-05 6.192181823387406e-08
+ 1.3785204844411389e-05 6.1920919751061639e-08
+ 1.3785513098871601e-05 6.1925163160700311e-08
+ 1.378575845598609e-05 6.1918039574466647e-08
+ 1.378595878432436e-05 6.1828997217408072e-08
+ 1.3786167358926159e-05 6.1855287673590248e-08
+ 1.37864107254266e-05 6.1982954228051073e-08
+ 1.37865694409177e-05 6.1377695176166165e-08
+ 1.3786636836731241e-05 5.746738473401717e-08
+ 1.3786691051736041e-05 5.551514666154975e-08
+ 1.378673467321824e-05 5.9493673861368247e-08
+ 1.378679921907083e-05 9.1231374249306319e-08
+ 1.3786865059755829e-05 1.3068883062796749e-07
+ 1.3786930120728181e-05 1.7197125909404679e-07
+ 1.378695956617082e-05 3.2906059975150088e-07
+ 1.378698021026695e-05 6.4695493642425712e-07
+ 1.378700187613551e-05 7.8570300622705581e-07
+ 1.3787029306500261e-05 2.7441079260020341e-07
+ 1.378705255517666e-05 -7.4717621389745526e-07
+ 1.3787073555239319e-05 -2.61462007745502e-06
+ 1.3787092447792481e-05 -4.1718179170543771e-06
+ 1.378710762105201e-05 -4.9827809424577024e-06
+ 1.3787122019902239e-05 -4.7326687835766401e-06
+ 1.378713208877046e-05 -2.595194900597701e-06
+ 1.37871446586459e-05 -6.7720012095725074e-07
+ 1.37871611483698e-05 -4.8528737591405356e-07
+ 1.3787179924187371e-05 -1.5602758986544239e-06
+ 1.378720421870606e-05 -2.6203733677774818e-06
+ 1.378722914150958e-05 -3.2808321919418968e-06
+ 1.3787255071464899e-05 -3.3197543048709309e-06
+ 1.378727883227204e-05 -1.9874901018717019e-06
+ 1.378730179466779e-05 -5.2716758565830538e-07
+ 1.3787328722419921e-05 -5.5228340771412865e-07
+ 1.378735923371243e-05 -1.8842466849136449e-06
+ 1.378738742807118e-05 -3.0441953020543178e-06
+ 1.378740937254427e-05 -3.7092010888697081e-06
+ 1.378743687005929e-05 -3.654308678123083e-06
+ 1.378745766248473e-05 -7.5249357699471948e-07
+ 1.3787475285235941e-05 2.2624507016221391e-06
+ 1.3787492460444591e-05 -6.6384246545528344e-06
+ 1.378751026414701e-05 -5.4184336828162911e-05
+ 1.378753275350896e-05 -0.00014734931987550709
+ 1.3787553878562369e-05 -0.0001879485558201673
+ 1.3787566827136591e-05 -0.00013623720913856521
+ 1.378758035013936e-05 -1.8229718317300899e-05
+ 1.3787595781508929e-05 0.00011455996345679909
+ 1.3787611935046599e-05 0.000184091655533714
+ 1.3787635363850481e-05 0.0001849251809963217
+ 1.378765835055117e-05 0.00014656444717854261
+ 1.378769011278648e-05 9.5042965310250803e-05
+ 1.378772081987083e-05 6.6676056901431263e-05
+ 1.37877578215652e-05 5.6821394781378259e-05
+ 1.3787797338353999e-05 6.3029784868844107e-05
+ 1.3787848834415731e-05 8.5686569549271087e-05
+ 1.3787913339678539e-05 -0.00019114174261267001
+ 1.3787961258991e-05 -0.001926412405633075
+ 1.3788007869818471e-05 -0.0065885853440959393
+ 1.378802224236461e-05 -0.0082403684046265437
+ 1.378803676600148e-05 -0.0081557226198124416
+ 1.3788046046088099e-05 -0.0058243061338084908
+ 1.378805594489222e-05 0.0004322628468771894
+ 1.378806645324583e-05 0.013578571712529739
+ 1.3788079488181559e-05 0.042308872738363729
+ 1.378809210740632e-05 0.084601697976082468
+ 1.3788106850726371e-05 0.15058418467041171
+ 1.378811813926594e-05 0.21054435575954811
+ 1.378813126856321e-05 0.28638369778578132
+ 1.3788145606750009e-05 0.37236913449363229
+ 1.3788162582897849e-05 0.47408132291689892
+ 1.378818440953268e-05 0.6000569672490973
+ 1.378821336106825e-05 0.75263273454534563
+ 1.378824965030652e-05 0.9109127047988016
+ 1.378829090151873e-05 1.03934558137935
+ 1.378834586378076e-05 1.1376951927058709
+ 1.378838951492119e-05 1.1747107755823221
+ 1.3788442552763489e-05 1.1941218488320531
+ 1.378849111041039e-05 1.199915210627009
+ 1.378855760490167e-05 1.201626091224312
+ 1.378863458480505e-05 1.2012371769027621
+ 1.378876015614126e-05 1.2004230179284061
+ 1.378889358945353e-05 1.200050861118932
+ 1.378902286025724e-05 1.199972882643257
+ 1.3789145423988809e-05 1.199978920987264
+ 1.3789264662004849e-05 1.19999197606352
+ 1.378939205110577e-05 1.199998647897552
+ 1.378951071283556e-05 1.2000002564400489
+ 1.378963455886685e-05 1.20000031588289
+ 1.3789752335843449e-05 1.200000117576508
+ 1.37898736076275e-05 1.199999997279291
+ 1.378999127904214e-05 1.1999999598451341
+ 1.379011140203671e-05 1.1999999550354279
+ 1.3790229367364371e-05 1.1999999581041609
+ 1.379034899348407e-05 1.1999999625136131
+ 1.3790415144887341e-05 1.199999977005052
+ 1.3790461863346561e-05 1.19999999581094
+ 1.379051113906983e-05 1.19999998689415
+ 1.3790575880106931e-05 1.199999937792432
+ 1.3790623657290411e-05 1.199999911775069
+ 1.3790650883711989e-05 1.1999998948555439
+ 1.379067659110474e-05 1.1999998621611601
+ 1.379069982778068e-05 1.199999802047873
+ 1.379072276963405e-05 1.1999997182589841
+ 1.379075156078154e-05 1.199999653562881
+ 1.379077422451175e-05 1.1999998790370601
+ 1.379079919638298e-05 1.2000001805200891
+ 1.3790832723835891e-05 1.2000003207365231
+ 1.3790887095662879e-05 1.200000198154819
+ 1.379093720391613e-05 1.200000020149866
+ 1.379101096645342e-05 1.199999886962499
+ 1.3791094254111671e-05 1.199999870817819
+ 1.37911912774702e-05 1.199999914617019
+ 1.379128695477487e-05 1.199999955003785
+ 1.379140159630395e-05 1.1999999728635651
+ 1.3791540474353669e-05 1.19999997032877
+ 1.379175600375658e-05 1.19999996206211
+ 1.379215707582616e-05 1.1999999587432399
+ 1.379253026619754e-05 1.1999999597827731
+ 1.379309206574429e-05 1.199999960512611
+ 1.3793683666876059e-05 1.199999960549025
+ 1.3794228015859941e-05 1.199999960439099
+ 1.3794749089930439e-05 1.1999999604793521
+ 1.3795119660453031e-05 1.199999960609436
+ 1.3795538110722771e-05 1.1999999604394189
+ 1.3796016019674239e-05 1.1999999604557621
+ 1.379661507079248e-05 1.199999960478455
+ 1.3797333699744841e-05 1.1999999604826621
+ 1.379841607621708e-05 1.199999960481738
+ 1.380003103805225e-05 1.199999960480955
+ 1.3802800565141459e-05 1.199999960480937
+ 1.380726215351678e-05 1.1999999604809231
+ 1.3812262153516779e-05 1.1999999604808691
+ 1.381726215351678e-05 1.199999960480858
+ 1.3822262153516781e-05 1.1999999604808631
+ 1.382726215351678e-05 1.199999960480866
+ 1.3832262153516791e-05 1.199999960480868
+ 1.383726215351679e-05 1.199999960480868
+ 1.3842262153516791e-05 1.199999960480868
+ 1.384726215351679e-05 1.199999960480868
+ 1.3852262153516791e-05 1.199999960480868
+ 1.385726215351679e-05 1.199999960480868
+ 1.3862262153516791e-05 1.199999960480868
+ 1.386726215351679e-05 1.199999960480868
+ 1.387226215351679e-05 1.199999960480868
+ 1.387726215351679e-05 1.199999960480868
+ 1.388226215351679e-05 1.199999960480868
+ 1.3887262153516789e-05 1.199999960480868
+ 1.38922621535168e-05 1.199999960480868
+ 1.38972621535168e-05 1.199999960480868
+ 1.39022621535168e-05 1.199999960480868
+ 1.3907262153516799e-05 1.199999960480868
+ 1.39122621535168e-05 1.199999960480868
+ 1.3917262153516799e-05 1.199999960480868
+ 1.39222621535168e-05 1.199999960480868
+ 1.3927262153516799e-05 1.199999960480868
+ 1.39322621535168e-05 1.199999960480868
+ 1.3937262153516801e-05 1.199999960480868
+ 1.39422621535168e-05 1.199999960480868
+ 1.3947262153516801e-05 1.199999960480868
+ 1.39522621535168e-05 1.199999960480868
+ 1.3957262153516811e-05 1.199999960480868
+ 1.396226215351681e-05 1.199999960480868
+ 1.3967262153516811e-05 1.199999960480868
+ 1.397226215351681e-05 1.199999960480868
+ 1.3977262153516811e-05 1.199999960480868
+ 1.398226215351681e-05 1.199999960480868
+ 1.3987262153516811e-05 1.199999960480868
+ 1.399226215351681e-05 1.199999960480868
+ 1.399726215351681e-05 1.199999960480868
+ 1.400226215351681e-05 1.199999960480868
+ 1.400726215351681e-05 1.199999960480868
+ 1.4012262153516809e-05 1.199999960480868
+ 1.401726215351682e-05 1.199999960480868
+ 1.402226215351682e-05 1.199999960480868
+ 1.402726215351682e-05 1.1999999604808671
+ 1.4032262153516819e-05 1.1999999604808671
+ 1.403726215351682e-05 1.1999999604808651
+ 1.4042262153516819e-05 1.199999960480862
+ 1.404726215351682e-05 1.1999999604808571
+ 1.4052262153516819e-05 1.1999999604808469
+ 1.405726215351682e-05 1.1999999604808289
+ 1.4062262153516821e-05 1.1999999604807929
+ 1.406726215351682e-05 1.199999960480723
+ 1.4072262153516821e-05 1.1999999604805911
+ 1.407726215351682e-05 1.19999996048034
+ 1.4082262153516831e-05 1.199999960479875
+ 1.408726215351683e-05 1.199999960479057
+ 1.4092262153516831e-05 1.1999999604776159
+ 1.409726215351683e-05 1.199999960474706
+ 1.4102262153516831e-05 1.199999960463938
+ 1.41048491820218e-05 1.19999996038646
+ 1.41065462356786e-05 1.199999960117943
+ 1.4108631099499101e-05 1.1999999601866
+ 1.411015430519233e-05 1.199999960417768
+ 1.4112032646061379e-05 1.1999999604326439
+ 1.41132719706689e-05 1.199999960518946
+ 1.411381945589416e-05 1.1999999610478
+ 1.4114465810079991e-05 1.1999999615443819
+ 1.4114793133954351e-05 1.1999999640682251
+ 1.4115096241849179e-05 1.199999966867852
+ 1.4115334534505899e-05 1.199999965550997
+ 1.41155417541618e-05 1.1999999239541259
+ 1.411575711694464e-05 1.1999998684690449
+ 1.4116000263129499e-05 1.199999826288719
+ 1.4116129603459721e-05 1.19999965213861
+ 1.411619540655638e-05 1.1999992974124429
+ 1.4116253401039e-05 1.1999988439811879
+ 1.4116298701014369e-05 1.199998525776595
+ 1.4116366425540401e-05 1.1999980115680089
+ 1.4116436312803741e-05 1.199998083535313
+ 1.411651716937296e-05 1.199999133057317
+ 1.4116542254845571e-05 1.1999996863339659
+ 1.411656224828877e-05 1.199999807330236
+ 1.4116580786679841e-05 1.200000078638966
+ 1.411660533054133e-05 1.200002617367335
+ 1.411663276134816e-05 1.200007863254587
+ 1.411665717042346e-05 1.200010732261199
+ 1.411667795980791e-05 1.2000101708810349
+ 1.411669513617184e-05 1.20000799090869
+ 1.411670985264155e-05 1.200005033976868
+ 1.4116725830184871e-05 1.200001950211415
+ 1.411674299704429e-05 1.1999997056988081
+ 1.411676974533742e-05 1.1999980306058511
+ 1.411679942819882e-05 1.199997328871502
+ 1.411682717813393e-05 1.199997082170954
+ 1.4116851264727791e-05 1.199997564458186
+ 1.41168766267175e-05 1.199999323646342
+ 1.411690779693234e-05 1.2000025059547459
+ 1.4116937187424e-05 1.200005267120877
+ 1.41169613095905e-05 1.2000070557506191
+ 1.411697781307999e-05 1.2000082926343101
+ 1.411699339937368e-05 1.200009732501095
+ 1.4117008267164401e-05 1.20001176713323
+ 1.4117023001193231e-05 1.200013278365031
+ 1.4117036325172851e-05 1.20001299192307
+ 1.4117050548564621e-05 1.200011364260231
+ 1.4117066399957349e-05 1.200008811594603
+ 1.411709277183265e-05 1.2000030553395029
+ 1.411712059127162e-05 1.199972341608196
+ 1.411714583841082e-05 1.199899918218517
+ 1.411717238643427e-05 1.199785008657932
+ 1.411720851837243e-05 1.1995092694532641
+ 1.411723251421562e-05 1.1996694791195739
+ 1.411724869258556e-05 1.2010175475193261
+ 1.411726664020794e-05 1.204948909174816
+ 1.411728780641616e-05 1.2126625431296181
+ 1.411730437863192e-05 1.215683532189185
+ 1.4117318423303361e-05 1.2038500362321121
+ 1.411733462691144e-05 1.160001079897294
+ 1.4117351662764159e-05 1.083883149852414
+ 1.411736929899191e-05 0.98597392370670289
+ 1.41173905745284e-05 0.8581039671163464
+ 1.411741105869031e-05 0.73354528631013349
+ 1.4117425753485669e-05 0.64563673026067347
+ 1.4117436984823159e-05 0.57996151107714466
+ 1.4117449531452869e-05 0.50863240180445102
+ 1.41174626172052e-05 0.43705067822553162
+ 1.4117475320774209e-05 0.37100025870974229
+ 1.411749509921634e-05 0.27731274977954412
+ 1.4117518081453479e-05 0.18658979972740899
+ 1.411754043182303e-05 0.1196309579683561
+ 1.411756734658607e-05 0.06520227666874602
+ 1.411758371246554e-05 0.043882444384075708
+ 1.4117600457508319e-05 0.028879117530486019
+ 1.4117619924816459e-05 0.017437253860423271
+ 1.4117641165520069e-05 0.0098150579611127591
+ 1.411766545211938e-05 0.0048866560873536994
+ 1.411769314682741e-05 0.0020315060238680111
+ 1.4117726423068141e-05 0.00053601296038141186
+ 1.4117767283489239e-05 -7.1046066841460003e-05
+ 1.4117820811919141e-05 -0.00019446407771999189
+ 1.4117895022999971e-05 -0.00011834136201369919
+ 1.411798637700966e-05 -3.415358934957018e-05
+ 1.411808209725476e-05 -1.600525106092377e-06
+ 1.411820989503601e-05 4.6751102536544e-06
+ 1.4118375332656761e-05 2.1035423918556159e-06
+ 1.411851428763544e-05 4.5690143162331378e-07
+ 1.4118639109081851e-05 3.3770345303371413e-08
+ 1.411875761886611e-05 7.8363861967494801e-09
+ 1.411887623698283e-05 4.089033557742755e-08
+ 1.411900594430379e-05 5.9493022982622152e-08
+ 1.4119126022742339e-05 6.4009113057894901e-08
+ 1.411925186182322e-05 6.5798481966201896e-08
+ 1.4119370337547449e-05 6.8435444266602958e-08
+ 1.4119492459152629e-05 7.2308346816331298e-08
+ 1.411961027481974e-05 8.0829045528893096e-08
+ 1.4119730776185311e-05 1.0970869478869931e-07
+ 1.4119824638301549e-05 2.4368920692892538e-07
+ 1.411987815118079e-05 5.4630288760946758e-07
+ 1.4119929447241569e-05 6.8170577258077634e-07
+ 1.411999764562534e-05 3.2532631057978291e-07
+ 1.4120044728029169e-05 -1.2930256545649561e-07
+ 1.412007283846027e-05 -5.1726063965729794e-07
+ 1.4120098413299461e-05 -9.9442873983628825e-07
+ 1.412012161064197e-05 -1.5051882399757199e-06
+ 1.412014314668026e-05 -1.7649356354657371e-06
+ 1.412017184404058e-05 -1.633286077823796e-06
+ 1.412019230041896e-05 -1.7315949087725841e-06
+ 1.412021529524703e-05 -6.5694954601596801e-07
+ 1.41202572549175e-05 1.137703921491218e-06
+ 1.4120296439343481e-05 1.414532421387151e-06
+ 1.412035765561289e-05 7.1071617469452397e-07
+ 1.41204220615111e-05 1.7561565116512979e-07
+ 1.412050139961159e-05 3.0090246617208582e-08
+ 1.4120586561584291e-05 -1.7028484352983399e-08
+ 1.412068696457161e-05 -4.6702501307229753e-09
+ 1.41208026707278e-05 4.7995183024378458e-08
+ 1.412092914908241e-05 7.3631277020605934e-08
+ 1.412109875836387e-05 7.0053186168127105e-08
+ 1.4121344037839161e-05 6.175850223901058e-08
+ 1.412165812675704e-05 6.0758667192650449e-08
+ 1.4122012371057871e-05 6.173599797862741e-08
+ 1.412244952392796e-05 6.2030090857248948e-08
+ 1.412297386298583e-05 6.2057733597668906e-08
+ 1.412359062103357e-05 6.1589438673804158e-08
+ 1.412398668724047e-05 6.0290160612905607e-08
+ 1.412432908902871e-05 6.3045462742643788e-08
+ 1.4124761689236959e-05 6.2223343740614071e-08
+ 1.412522632572988e-05 6.172685010310443e-08
+ 1.412577586975725e-05 6.1910300326983682e-08
+ 1.4126367914527901e-05 6.1922269529693602e-08
+ 1.4127189300310171e-05 6.1919153430678189e-08
+ 1.412834448254446e-05 6.1921754984481246e-08
+ 1.41303507354288e-05 6.192138772043219e-08
+ 1.413339669265709e-05 6.1921011963040716e-08
+ 1.413839669265709e-05 6.1920982658885545e-08
+ 1.4143396692657089e-05 6.192099496066433e-08
+ 1.414839669265709e-05 6.1920997724355106e-08
+ 1.4153396692657089e-05 6.1920998049660849e-08
+ 1.415839669265709e-05 6.1920998162812711e-08
+ 1.4163396692657089e-05 6.1920998148142511e-08
+ 1.41683966926571e-05 6.1920998059975354e-08
+ 1.4173396692657099e-05 6.1920998018272031e-08
+ 1.41783966926571e-05 6.1920998108109272e-08
+ 1.4183396692657099e-05 6.1920998218610159e-08
+ 1.41883966926571e-05 6.1920998224472183e-08
+ 1.4193396692657101e-05 6.1920998058610638e-08
+ 1.41983966926571e-05 6.1920998121785691e-08
+ 1.4203396692657101e-05 6.1920998163552369e-08
+ 1.42083966926571e-05 6.1920997984034655e-08
+ 1.4213396692657101e-05 6.1920998032027568e-08
+ 1.42183966926571e-05 6.1920998282102412e-08
+ 1.4223396692657101e-05 6.1920998153897239e-08
+ 1.42283966926571e-05 6.1920998170754518e-08
+ 1.4233396692657111e-05 6.1920998019662939e-08
+ 1.423839669265711e-05 6.1920998029133905e-08
+ 1.4243396692657111e-05 6.1920998113075254e-08
+ 1.424839669265711e-05 6.1920998195813221e-08
+ 1.425339669265711e-05 6.1920997928553759e-08
+ 1.425839669265711e-05 6.1920998087804727e-08
+ 1.426339669265711e-05 6.1920998078446535e-08
+ 1.4268396692657109e-05 6.1920998175545046e-08
+ 1.427339669265711e-05 6.1920998159548286e-08
+ 1.4278396692657109e-05 6.1920998294464845e-08
+ 1.428339669265711e-05 6.1920998076355846e-08
+ 1.4288396692657109e-05 6.1920998121051869e-08
+ 1.429339669265712e-05 6.1920998213449902e-08
+ 1.4298396692657119e-05 6.192099802015611e-08
+ 1.430339669265712e-05 6.1920997995455253e-08
+ 1.4308396692657119e-05 6.1920998360199353e-08
+ 1.431339669265712e-05 6.1920998090359657e-08
+ 1.4318396692657121e-05 6.1920998221460743e-08
+ 1.432339669265712e-05 6.19209979625753e-08
+ 1.4328396692657121e-05 6.1920998308896804e-08
+ 1.433339669265712e-05 6.1920998115613428e-08
+ 1.4338396692657121e-05 6.1920998132238276e-08
+ 1.434339669265712e-05 6.1920998249047997e-08
+ 1.4348396692657121e-05 6.1920998028567809e-08
+ 1.435339669265712e-05 6.1920998341624953e-08
+ 1.4358396692657131e-05 6.1920998126452353e-08
+ 1.436339669265713e-05 6.1920997919064793e-08
+ 1.436839669265713e-05 6.192099828245413e-08
+ 1.437339669265713e-05 6.1920998044420745e-08
+ 1.437839669265713e-05 6.1920998121849311e-08
+ 1.438339669265713e-05 6.1920998184721523e-08
+ 1.438839669265713e-05 6.1920998202233016e-08
+ 1.4393396692657129e-05 6.1920998214750932e-08
+ 1.439839669265713e-05 6.192099818196541e-08
+ 1.4403396692657129e-05 6.1920998255641077e-08
+ 1.440839669265713e-05 6.1920998041189103e-08
+ 1.4413396692657129e-05 6.1920998033889201e-08
+ 1.441839669265714e-05 6.1920997831188036e-08
+ 1.4423396692657139e-05 6.192099762413021e-08
+ 1.442839669265714e-05 6.192099709909566e-08
+ 1.4433396692657139e-05 6.1920993453794384e-08
+ 1.4435493928069209e-05 6.1920906873731961e-08
+ 1.443731422634697e-05 6.1920905941082458e-08
+ 1.443923113414048e-05 6.1921194901423849e-08
+ 1.444075683647232e-05 6.1921063715993105e-08
+ 1.444243206717019e-05 6.1920800675875175e-08
+ 1.4443461282111939e-05 6.1921267673892681e-08
+ 1.4443839998195251e-05 6.1921826969483307e-08
+ 1.444439290527712e-05 6.1920917345783167e-08
+ 1.444470079158373e-05 6.1925182396945466e-08
+ 1.444494605560624e-05 6.1917813618520288e-08
+ 1.444514661845469e-05 6.1827660644897971e-08
+ 1.444535518332982e-05 6.1857219043513376e-08
+ 1.4445598142025471e-05 6.1982298003900892e-08
+ 1.444575495466845e-05 6.136135760202172e-08
+ 1.444582192118229e-05 5.7460398066671023e-08
+ 1.444587622604994e-05 5.5555690276215808e-08
+ 1.444591980265967e-05 5.9463739057295183e-08
+ 1.444598435696428e-05 9.1132135709198437e-08
+ 1.444605022067671e-05 1.3062102452963501e-07
+ 1.4446115394565529e-05 1.7192166048813371e-07
+ 1.4446144869226329e-05 3.293714472613077e-07
+ 1.4446165504350679e-05 6.4761320224876964e-07
+ 1.444618718729281e-05 7.852999399180985e-07
+ 1.444621463330949e-05 2.727861471975105e-07
+ 1.4446237857952059e-05 -7.507207943004084e-07
+ 1.4446258856039711e-05 -2.6196245825761119e-06
+ 1.444627776599568e-05 -4.1753114798000136e-06
+ 1.4446292925893099e-05 -4.9866394735122493e-06
+ 1.444630735576335e-05 -4.7204291451808592e-06
+ 1.4446317437779079e-05 -2.5793897302495728e-06
+ 1.444633001376499e-05 -6.7127019717837426e-07
+ 1.4446346568550961e-05 -4.9140522837042009e-07
+ 1.444636534723052e-05 -1.5688845298233451e-06
+ 1.4446389678367081e-05 -2.6264693314636328e-06
+ 1.4446414614728681e-05 -3.2855311017144551e-06
+ 1.444644056046967e-05 -3.313825573014914e-06
+ 1.44464642086797e-05 -1.97561180717163e-06
+ 1.444648719463681e-05 -5.2100841850169254e-07
+ 1.444651419165629e-05 -5.5842933108143694e-07
+ 1.4446544625218e-05 -1.891865105806948e-06
+ 1.444657289488469e-05 -3.052907011810548e-06
+ 1.444659482052258e-05 -3.714813700642694e-06
+ 1.4446622217977979e-05 -3.6443275675681509e-06
+ 1.4446642839767469e-05 -7.5753196369110091e-07
+ 1.444666039708959e-05 2.2646758848616619e-06
+ 1.444667756805943e-05 -6.4176849483993129e-06
+ 1.4446695367589969e-05 -5.3599850431519862e-05
+ 1.444671788921326e-05 -0.000146856981268473
+ 1.4446738896930859e-05 -0.0001881805875007296
+ 1.444675185605159e-05 -0.0001376340854682542
+ 1.4446765340106079e-05 -2.0569641361658162e-05
+ 1.4446780700118841e-05 0.0001124723740531575
+ 1.4446796819433479e-05 0.00018343897774946929
+ 1.4446820024975641e-05 0.00018558242042282009
+ 1.444684304094231e-05 0.0001475050470238167
+ 1.4446874658192911e-05 9.595681011568096e-05
+ 1.444690534251966e-05 6.7095507095294731e-05
+ 1.444694221610149e-05 5.6843933267579161e-05
+ 1.444698161161376e-05 6.2727997240254063e-05
+ 1.4447032804307929e-05 8.5226004769729601e-05
+ 1.4447096978909929e-05 -0.00016878048595413871
+ 1.444714535459393e-05 -0.0018516367463001649
+ 1.444719159005554e-05 -0.0063925306083045374
+ 1.4447206562293821e-05 -0.0081597977244747613
+ 1.444722099225994e-05 -0.0082924348639811605
+ 1.4447230103062141e-05 -0.0063310807074483761
+ 1.4447240196665681e-05 -0.00048520661350768
+ 1.444725077626473e-05 0.012051029770368401
+ 1.444726386400085e-05 0.039896541924001487
+ 1.4447276288926431e-05 0.08045975711044516
+ 1.444729296133267e-05 0.15466777727778211
+ 1.444730490015241e-05 0.21855845444604771
+ 1.444731850387665e-05 0.29757841218904979
+ 1.444733314140045e-05 0.3854825363964573
+ 1.444735060084813e-05 0.48977721004891023
+ 1.444737312848752e-05 0.61871790092209678
+ 1.4447403113180149e-05 0.77392027257902052
+ 1.44474400070983e-05 0.9294013616037784
+ 1.444748237302729e-05 1.053924861862068
+ 1.4447528811453909e-05 1.1340634612686611
+ 1.444757030923934e-05 1.170960075878217
+ 1.444762312518822e-05 1.192313548445604
+ 1.4447670967458961e-05 1.199068338332177
+ 1.444773761487578e-05 1.201458830060385
+ 1.4447812503914139e-05 1.2012882690578599
+ 1.4447933807329711e-05 1.200512842001334
+ 1.4448065642336289e-05 1.200089345081272
+ 1.444819492348408e-05 1.199980778683067
+ 1.444831801564884e-05 1.1999782336091549
+ 1.444843763243058e-05 1.1999905546662171
+ 1.4448565591762691e-05 1.1999979707231601
+ 1.4448684368511771e-05 1.2000000633302199
+ 1.444880841282426e-05 1.200000306618896
+ 1.4448926149035811e-05 1.200000137669476
+ 1.444904748327313e-05 1.2000000098382499
+ 1.444916510659613e-05 1.1999999641331029
+ 1.4449285267714039e-05 1.199999955623305
+ 1.4449403206408289e-05 1.199999957780185
+ 1.444952285625317e-05 1.1999999618471511
+ 1.444959480140507e-05 1.1999999743200009
+ 1.444964247398862e-05 1.1999999943511319
+ 1.44496907254161e-05 1.1999999902751941
+ 1.4449756714607071e-05 1.199999941854285
+ 1.4449814513881509e-05 1.199999912018209
+ 1.4449843806732469e-05 1.1999998892911361
+ 1.4449867719228689e-05 1.1999998469099169
+ 1.444988957065794e-05 1.1999997813023391
+ 1.4449912013923129e-05 1.199999697126209
+ 1.444993971972677e-05 1.1999996594344069
+ 1.4449959601087439e-05 1.19999989457956
+ 1.444998431795671e-05 1.2000001911086211
+ 1.445002151466596e-05 1.2000003250313189
+ 1.445007322533309e-05 1.2000001940884151
+ 1.4450126519704859e-05 1.200000008562544
+ 1.445019925838694e-05 1.199999884540043
+ 1.445027926574033e-05 1.1999998715720941
+ 1.4450381801277591e-05 1.199999917358394
+ 1.4450474160675251e-05 1.19999995564481
+ 1.4450593660886171e-05 1.1999999732467901
+ 1.445072983588404e-05 1.199999970123756
+ 1.4450955000943881e-05 1.1999999617162129
+ 1.445135031875099e-05 1.19999995877151
+ 1.4451731768269191e-05 1.199999959826511
+ 1.4452289700072891e-05 1.1999999605162279
+ 1.445283119650785e-05 1.199999960545717
+ 1.445338566262883e-05 1.199999960440074
+ 1.44538835522651e-05 1.1999999604666789
+ 1.445424093551064e-05 1.1999999606186851
+ 1.445464925719758e-05 1.199999960445985
+ 1.445511602233302e-05 1.1999999604534259
+ 1.445570837662562e-05 1.1999999604767819
+ 1.4456389599465109e-05 1.1999999604823071
+ 1.445741636782401e-05 1.1999999604819029
+ 1.445890036240356e-05 1.199999960481021
+ 1.446148942820453e-05 1.1999999604809271
+ 1.446553505367097e-05 1.1999999604809339
+ 1.4470535053670969e-05 1.1999999604808751
+ 1.447553505367097e-05 1.199999960480858
+ 1.4480535053670969e-05 1.199999960480862
+ 1.448553505367097e-05 1.199999960480866
+ 1.4490535053670971e-05 1.199999960480868
+ 1.449553505367097e-05 1.199999960480868
+ 1.4500535053670979e-05 1.199999960480868
+ 1.450553505367098e-05 1.199999960480868
+ 1.4510535053670981e-05 1.199999960480868
+ 1.451553505367098e-05 1.199999960480868
+ 1.4520535053670981e-05 1.199999960480868
+ 1.452553505367098e-05 1.199999960480868
+ 1.4530535053670981e-05 1.199999960480868
+ 1.453553505367098e-05 1.199999960480868
+ 1.454053505367098e-05 1.199999960480868
+ 1.454553505367098e-05 1.199999960480868
+ 1.455053505367098e-05 1.199999960480868
+ 1.4555535053670979e-05 1.199999960480868
+ 1.456053505367099e-05 1.199999960480868
+ 1.456553505367099e-05 1.199999960480868
+ 1.457053505367099e-05 1.199999960480868
+ 1.4575535053670989e-05 1.199999960480868
+ 1.458053505367099e-05 1.199999960480868
+ 1.4585535053670989e-05 1.199999960480868
+ 1.459053505367099e-05 1.199999960480868
+ 1.4595535053670989e-05 1.199999960480868
+ 1.460053505367099e-05 1.199999960480868
+ 1.4605535053670989e-05 1.199999960480868
+ 1.461053505367099e-05 1.199999960480868
+ 1.4615535053670991e-05 1.199999960480868
+ 1.462053505367099e-05 1.199999960480868
+ 1.4625535053671001e-05 1.199999960480868
+ 1.4630535053671e-05 1.199999960480868
+ 1.4635535053671001e-05 1.199999960480868
+ 1.4640535053671e-05 1.199999960480868
+ 1.4645535053671001e-05 1.199999960480868
+ 1.4650535053671e-05 1.199999960480868
+ 1.4655535053671001e-05 1.199999960480868
+ 1.4660535053671e-05 1.199999960480868
+ 1.4665535053671e-05 1.199999960480868
+ 1.4670535053671e-05 1.199999960480868
+ 1.4675535053671e-05 1.199999960480868
+ 1.4680535053670999e-05 1.199999960480868
+ 1.468553505367101e-05 1.199999960480868
+ 1.469053505367101e-05 1.1999999604808671
+ 1.469553505367101e-05 1.199999960480866
+ 1.4700535053671009e-05 1.1999999604808631
+ 1.470553505367101e-05 1.199999960480858
+ 1.4710535053671009e-05 1.1999999604808489
+ 1.471553505367101e-05 1.1999999604808329
+ 1.4720535053671009e-05 1.1999999604808009
+ 1.472553505367101e-05 1.1999999604807401
+ 1.4730535053671009e-05 1.199999960480622
+ 1.473553505367101e-05 1.1999999604803979
+ 1.4740535053671011e-05 1.1999999604799809
+ 1.474553505367101e-05 1.199999960479242
+ 1.4750535053671021e-05 1.1999999604779461
+ 1.475553505367102e-05 1.1999999604754501
+ 1.4760535053671021e-05 1.199999960467675
+ 1.476375573080081e-05 1.199999960415123
+ 1.476553032222547e-05 1.199999960152331
+ 1.476750832584548e-05 1.199999960153467
+ 1.476913851890093e-05 1.199999960378251
+ 1.477119040478447e-05 1.199999960460612
+ 1.477275020269895e-05 1.1999999605286999
+ 1.4773300329259181e-05 1.199999961396351
+ 1.477379057194947e-05 1.199999962283641
+ 1.4774064343176099e-05 1.1999999650421791
+ 1.477436313097263e-05 1.199999967437565
+ 1.477459064045221e-05 1.1999999582116421
+ 1.477480900545143e-05 1.1999999005387521
+ 1.477501938629809e-05 1.199999853116267
+ 1.477523843533076e-05 1.1999997964249689
+ 1.477533731643549e-05 1.19999954829768
+ 1.477540093389575e-05 1.199999137201303
+ 1.47754506789815e-05 1.199998734609232
+ 1.4775501982339869e-05 1.1999983496969091
+ 1.477556612032197e-05 1.1999979446862901
+ 1.477563787844754e-05 1.199998263097058
+ 1.47757063038057e-05 1.1999993282623549
+ 1.477572810075472e-05 1.199999757621282
+ 1.477574773487669e-05 1.1999997813964589
+ 1.4775768455432871e-05 1.2000004281387
+ 1.47757934428368e-05 1.2000034994564599
+ 1.4775817325322741e-05 1.2000083306251841
+ 1.4775844144491549e-05 1.200010891021676
+ 1.4775865338894119e-05 1.200009765732867
+ 1.4775883409120749e-05 1.2000070341625519
+ 1.477589604927464e-05 1.200004349425901
+ 1.4775911838099699e-05 1.2000014210516661
+ 1.477593274229671e-05 1.1999990694050999
+ 1.4775960547375501e-05 1.1999977411632361
+ 1.477599195725484e-05 1.199997165441625
+ 1.4776021888630791e-05 1.199997173280658
+ 1.4776055815826261e-05 1.199998838334869
+ 1.477608206275074e-05 1.200001449240309
+ 1.4776110598002801e-05 1.200004416481852
+ 1.4776136187093001e-05 1.2000065117627789
+ 1.4776154678383831e-05 1.200007860810363
+ 1.477617041584521e-05 1.200009175948346
+ 1.47761861479919e-05 1.2000110610140049
+ 1.4776199875663399e-05 1.2000129277967779
+ 1.477621569127191e-05 1.200013220405455
+ 1.477622606064314e-05 1.2000122880374191
+ 1.4776240593552921e-05 1.200010186663625
+ 1.47762647940554e-05 1.2000059745691929
+ 1.4776287736328371e-05 1.1999953684464819
+ 1.477631169518452e-05 1.199951668070744
+ 1.4776333130510829e-05 1.199879788678107
+ 1.4776361718369361e-05 1.199746023133464
+ 1.4776402884545839e-05 1.199440568167836
+ 1.4776422411288491e-05 1.2000724176553561
+ 1.477643893165531e-05 1.202360139130904
+ 1.477646403177225e-05 1.2100277265239721
+ 1.477648679170107e-05 1.214587768289854
+ 1.4776502375329561e-05 1.200226135447805
+ 1.4776518800142349e-05 1.154139932506437
+ 1.4776536363345e-05 1.0744480753457679
+ 1.4776554279148901e-05 0.97427002874907198
+ 1.4776575768398689e-05 0.84492641889566023
+ 1.477659653455177e-05 0.7189146386048394
+ 1.477661102776953e-05 0.63253675494274109
+ 1.4776622230198959e-05 0.56733156609269841
+ 1.4776638349518211e-05 0.47674064705613428
+ 1.4776650183268501e-05 0.41319213871872512
+ 1.477666331001912e-05 0.34647260132357272
+ 1.4776683491942389e-05 0.25427763296829659
+ 1.477670659279706e-05 0.16817518983893159
+ 1.4776728754607309e-05 0.10679416527748919
+ 1.477675237709276e-05 0.062261481930799889
+ 1.477676966794231e-05 0.040868668731536613
+ 1.477678747341128e-05 0.026069834432916061
+ 1.477680954113613e-05 0.01452611007001824
+ 1.4776830141713029e-05 0.0082256876597489401
+ 1.4776856642462931e-05 0.0037482946079564899
+ 1.477688407000028e-05 0.001510898581170747
+ 1.477692055706504e-05 0.00027274609146118968
+ 1.477696279906692e-05 -0.00013609226621837
+ 1.4777022969772661e-05 -0.0001811434711841442
+ 1.477710410990681e-05 -8.8629214349944608e-05
+ 1.4777193204086829e-05 -2.1632110850991711e-05
+ 1.4777298661080011e-05 2.3272775625924249e-06
+ 1.4777431749142049e-05 4.1892149144530772e-06
+ 1.47775922079888e-05 1.411287200531084e-06
+ 1.47777294612276e-05 2.356121388985554e-07
+ 1.477785363419831e-05 5.905394140539138e-09
+ 1.477797218685036e-05 1.871777607955039e-08
+ 1.477809086704429e-05 4.901721994588765e-08
+ 1.477821925597788e-05 6.1762543907640396e-08
+ 1.477833927522741e-05 6.454038206854506e-08
+ 1.477846433053154e-05 6.6285014310600323e-08
+ 1.4778582917574221e-05 6.9228645684177721e-08
+ 1.4778704683822709e-05 7.3740996902222157e-08
+ 1.477882265228107e-05 8.4777202670562021e-08
+ 1.477894297665577e-05 1.2767055079624939e-07
+ 1.477901931273559e-05 3.0982492573635441e-07
+ 1.4779070069389049e-05 5.9605833050437512e-07
+ 1.477912371063687e-05 6.5029977119959469e-07
+ 1.477918951948643e-05 2.373591180450571e-07
+ 1.477922521561537e-05 -1.420376193398908e-07
+ 1.4779255741015589e-05 -5.368956248320267e-07
+ 1.4779280345927151e-05 -9.7705280908300685e-07
+ 1.4779303478992991e-05 -1.4806687766204291e-06
+ 1.4779324935223139e-05 -1.752706033195482e-06
+ 1.477935382574763e-05 -1.624361183715044e-06
+ 1.477937461651442e-05 -1.7268074762462339e-06
+ 1.4779397606750581e-05 -6.6806761717768629e-07
+ 1.4779438529581601e-05 1.1078071439743449e-06
+ 1.4779478037163201e-05 1.415092260859174e-06
+ 1.477953832816186e-05 7.2905427668497985e-07
+ 1.4779603043129079e-05 1.8124572636356371e-07
+ 1.4779683699671641e-05 2.9573482165057639e-08
+ 1.4779768925389561e-05 -1.7001056187237979e-08
+ 1.4779870107063179e-05 -5.1656469360190732e-09
+ 1.477998526177888e-05 4.7455547650611813e-08
+ 1.478011223210464e-05 7.3636671241981627e-08
+ 1.478028133124405e-05 7.014134115126927e-08
+ 1.4780527704399471e-05 6.1763549672931017e-08
+ 1.478084084368962e-05 6.0752996332461067e-08
+ 1.478119604295864e-05 6.1737461067348738e-08
+ 1.478163230785288e-05 6.2029565047773774e-08
+ 1.4782157693390399e-05 6.2057909722839957e-08
+ 1.478277324925306e-05 6.1587854036628082e-08
+ 1.478316916522477e-05 6.0290628030576295e-08
+ 1.4783511281180679e-05 6.3046464057914908e-08
+ 1.4783943609002561e-05 6.2222632923637776e-08
+ 1.478440822594239e-05 6.1726985743494147e-08
+ 1.478495769217597e-05 6.1910338102678987e-08
+ 1.478554964621036e-05 6.192223826585702e-08
+ 1.478637075250645e-05 6.1919147897039606e-08
+ 1.47875254306914e-05 6.1921756493950895e-08
+ 1.478953051626886e-05 6.1921387351897446e-08
+ 1.479257517893447e-05 6.1921012479986036e-08
+ 1.479757517893447e-05 6.1920982280216833e-08
+ 1.480257517893447e-05 6.1920994897702743e-08
+ 1.480757517893447e-05 6.1920997525016595e-08
+ 1.4812575178934469e-05 6.1920998106402871e-08
+ 1.481757517893448e-05 6.1920998067841008e-08
+ 1.4822575178934479e-05 6.1920998371831193e-08
+ 1.482757517893448e-05 6.1920998180093745e-08
+ 1.4832575178934479e-05 6.1920998210378309e-08
+ 1.483757517893448e-05 6.1920998332962162e-08
+ 1.4842575178934479e-05 6.1920998148457144e-08
+ 1.484757517893448e-05 6.1920997977379623e-08
+ 1.4852575178934479e-05 6.1920998011879169e-08
+ 1.485757517893448e-05 6.192099800122192e-08
+ 1.4862575178934481e-05 6.1920998106848543e-08
+ 1.486757517893448e-05 6.1920998159892022e-08
+ 1.4872575178934481e-05 6.1920998166685266e-08
+ 1.487757517893448e-05 6.1920998322759981e-08
+ 1.4882575178934491e-05 6.1920998041573325e-08
+ 1.488757517893449e-05 6.1920998135192833e-08
+ 1.4892575178934491e-05 6.1920998175462764e-08
+ 1.489757517893449e-05 6.1920998230252177e-08
+ 1.4902575178934491e-05 6.192099806688934e-08
+ 1.490757517893449e-05 6.1920998113196552e-08
+ 1.491257517893449e-05 6.1920997906869636e-08
+ 1.491757517893449e-05 6.1920997924523536e-08
+ 1.492257517893449e-05 6.1920998265362236e-08
+ 1.492757517893449e-05 6.1920998339043289e-08
+ 1.493257517893449e-05 6.192099808387112e-08
+ 1.4937575178934489e-05 6.1920998208703791e-08
+ 1.49425751789345e-05 6.1920998272922084e-08
+ 1.4947575178934499e-05 6.1920998027918955e-08
+ 1.49525751789345e-05 6.1920998085621924e-08
+ 1.4957575178934499e-05 6.1920998182894856e-08
+ 1.49625751789345e-05 6.1920997951979792e-08
+ 1.4967575178934499e-05 6.1920998269993137e-08
+ 1.49725751789345e-05 6.1920998060326807e-08
+ 1.4977575178934499e-05 6.1920998148277374e-08
+ 1.49825751789345e-05 6.1920998192642803e-08
+ 1.4987575178934501e-05 6.1920998007163273e-08
+ 1.49925751789345e-05 6.1920998068559371e-08
+ 1.4997575178934501e-05 6.1920998088327214e-08
+ 1.50025751789345e-05 6.1920998121112789e-08
+ 1.5007575178934511e-05 6.1920998236950937e-08
+ 1.501257517893451e-05 6.1920997964539159e-08
+ 1.5017575178934511e-05 6.1920998284963796e-08
+ 1.502257517893451e-05 6.1920998148914303e-08
+ 1.5027575178934511e-05 6.1920997927269577e-08
+ 1.503257517893451e-05 6.1920998189704339e-08
+ 1.503757517893451e-05 6.192099802644038e-08
+ 1.504257517893451e-05 6.1920998148292621e-08
+ 1.504757517893451e-05 6.1920998231942418e-08
+ 1.5052575178934509e-05 6.1920998311681756e-08
+ 1.505757517893451e-05 6.1920997865278214e-08
+ 1.5062575178934509e-05 6.1920998029929666e-08
+ 1.506757517893452e-05 6.1920998058144784e-08
+ 1.5072575178934519e-05 6.1920997971198585e-08
+ 1.507757517893452e-05 6.192099795906063e-08
+ 1.5082575178934519e-05 6.1920997686423541e-08
+ 1.508757517893452e-05 6.1920997357159772e-08
+ 1.5092575178934519e-05 6.1920993491572544e-08
+ 1.5094672974955569e-05 6.1920907059179991e-08
+ 1.5096492706566109e-05 6.1920905464581903e-08
+ 1.509841100191571e-05 6.1921195201556249e-08
+ 1.509993593324435e-05 6.192106439065359e-08
+ 1.510161099899697e-05 6.1920799912973749e-08
+ 1.5102640697229751e-05 6.1921267886106701e-08
+ 1.51030197845863e-05 6.1921823119917019e-08
+ 1.5103573252609089e-05 6.1920918436675974e-08
+ 1.510388125307734e-05 6.1925176972621103e-08
+ 1.5104126546138211e-05 6.1917884177293566e-08
+ 1.510432703320723e-05 6.1828081317334983e-08
+ 1.510453560127433e-05 6.1856611081866953e-08
+ 1.5104778686513359e-05 6.1982509383213467e-08
+ 1.510493609924919e-05 6.1366590424220707e-08
+ 1.510500320150585e-05 5.7462724858381403e-08
+ 1.5105057478644809e-05 5.5543053712529942e-08
+ 1.510510106906339e-05 5.9472399037231449e-08
+ 1.510516562118275e-05 9.1161750656982179e-08
+ 1.51052314775949e-05 1.3064124186622199e-07
+ 1.5105296617897701e-05 1.7193588034254899e-07
+ 1.5105326083994269e-05 3.292756988331846e-07
+ 1.510534672181877e-05 6.4741184540490591e-07
+ 1.510536839949103e-05 7.8542424651315151e-07
+ 1.51053958407623e-05 2.732835129362054e-07
+ 1.510541907273857e-05 -7.4963601320163352e-07
+ 1.5105440071453809e-05 -2.6180960946155922e-06
+ 1.510545897610406e-05 -4.1742459929025227e-06
+ 1.510547414007348e-05 -4.9854616537321792e-06
+ 1.510548856044986e-05 -4.724173193734309e-06
+ 1.51054986384276e-05 -2.5842168612639171e-06
+ 1.5105511212520951e-05 -6.7307726351072991e-07
+ 1.510552774738533e-05 -4.8952775347098644e-07
+ 1.510554652513728e-05 -1.566252099380453e-06
+ 1.510557084503824e-05 -2.6246035042373918e-06
+ 1.5105595777033321e-05 -3.284090171036226e-06
+ 1.5105621717817509e-05 -3.3156630384058408e-06
+ 1.5105645400175589e-05 -1.9792931869680171e-06
+ 1.5105668378645639e-05 -5.2290993129641053e-07
+ 1.5105695354160409e-05 -5.5650311240980042e-07
+ 1.5105725811728291e-05 -1.889486352452565e-06
+ 1.5105754058013899e-05 -3.050192098447335e-06
+ 1.510577598957052e-05 -3.7130674243954111e-06
+ 1.510580341814143e-05 -3.647462018933921e-06
+ 1.5105824093512991e-05 -7.5589798315179659e-07
+ 1.510584167106556e-05 2.264045872584505e-06
+ 1.510585884313189e-05 -6.4858396580144947e-06
+ 1.5105876643758071e-05 -5.3780288511556893e-05
+ 1.510589915530759e-05 -0.0001470090823447326
+ 1.510592019937408e-05 -0.00018811120279402471
+ 1.510593315518651e-05 -0.00013720457804612039
+ 1.510594665106137e-05 -1.9848719406428601e-05
+ 1.510596203280251e-05 0.0001131171620666986
+ 1.5105978162361349e-05 0.00018364211278323799
+ 1.5106001436155889e-05 0.0001853825775908914
+ 1.510602444272478e-05 0.0001472174273576838
+ 1.510605610447971e-05 9.5675943342582524e-05
+ 1.510608679555923e-05 6.6966284592128938e-05
+ 1.5106123708267609e-05 5.6836308892960197e-05
+ 1.510616314061279e-05 6.2819422600553966e-05
+ 1.51062144257622e-05 8.5371161091269589e-05
+ 1.5106278700962151e-05 -0.00017544499844543811
+ 1.510632693356963e-05 -0.0018739772437499731
+ 1.5106373280430511e-05 -0.0064517773089351194
+ 1.510638806703657e-05 -0.0081846419953247995
+ 1.5106402529954129e-05 -0.0082544103297713632
+ 1.510641169390751e-05 -0.0061844369903521403
+ 1.5106421725961829e-05 -0.00021747970611434581
+ 1.510643228095706e-05 0.01249458839245758
+ 1.510644535311171e-05 0.040601028124951123
+ 1.5106457831570319e-05 0.081657497254366621
+ 1.510647388521171e-05 0.15320395025054859
+ 1.510648560243375e-05 0.21574471563950151
+ 1.51064990403758e-05 0.2936547693227966
+ 1.510651357922515e-05 0.38092912241358012
+ 1.5106530862887931e-05 0.48428820474889589
+ 1.5106553149771321e-05 0.61223248540852904
+ 1.510658277015779e-05 0.76653665345281996
+ 1.5106619467800121e-05 0.92308122919283986
+ 1.510666140973095e-05 1.0488975376208161
+ 1.5106710547951049e-05 1.1349345807526909
+ 1.510675273552037e-05 1.1720244565949709
+ 1.51068056446208e-05 1.1928517980054509
+ 1.510685367640338e-05 1.199326794740792
+ 1.51069202333257e-05 1.201512725768167
+ 1.510699565471047e-05 1.201276176774521
+ 1.510711805803346e-05 1.2004873185100551
+ 1.510725031095374e-05 1.2000778899437701
+ 1.5107379591179279e-05 1.199978261921862
+ 1.5107502546736729e-05 1.1999783523246941
+ 1.510762206499083e-05 1.199990952412987
+ 1.51077498759025e-05 1.1999981709287311
+ 1.5107868622250219e-05 1.200000123147491
+ 1.5107992614801339e-05 1.2000003108596951
+ 1.5108110361250779e-05 1.2000001322113629
+ 1.5108231679183071e-05 1.2000000061768079
+ 1.510834931484591e-05 1.1999999628291429
+ 1.5108469466061149e-05 1.199999955421132
+ 1.510858741159279e-05 1.199999957861775
+ 1.5108707055202351e-05 1.1999999620188599
+ 1.510877739486312e-05 1.199999974982102
+ 1.510882479181185e-05 1.199999994712535
+ 1.510887326071132e-05 1.199999989512053
+ 1.510893890887575e-05 1.199999940913294
+ 1.51089942955055e-05 1.1999999120018769
+ 1.5109023119777271e-05 1.199999890873781
+ 1.510904743587005e-05 1.1999998510335499
+ 1.510906960085137e-05 1.1999997868465291
+ 1.510909213976566e-05 1.1999997028823881
+ 1.510912013209961e-05 1.1999996570310021
+ 1.5109140741195279e-05 1.1999998900333311
+ 1.5109165439970611e-05 1.2000001873273329
+ 1.510920151557907e-05 1.200000324000934
+ 1.510925391393882e-05 1.200000196089225
+ 1.5109306251954059e-05 1.2000000126395849
+ 1.51093790782853e-05 1.199999885664677
+ 1.5109460364609751e-05 1.1999998712799369
+ 1.510956060453028e-05 1.1999999161622981
+ 1.5109654266913341e-05 1.199999955315983
+ 1.510977172975801e-05 1.1999999730835791
+ 1.510990886278829e-05 1.1999999702242821
+ 1.511012970429402e-05 1.19999996187376
+ 1.5110528673017179e-05 1.199999958755666
+ 1.511090579340495e-05 1.199999959805861
+ 1.5111466306425769e-05 1.1999999605150271
+ 1.511206330082949e-05 1.1999999605476159
+ 1.511260617602081e-05 1.19999996043699
+ 1.511313973920455e-05 1.199999960485483
+ 1.5113518287524451e-05 1.1999999606041321
+ 1.5113942888457161e-05 1.1999999604370211
+ 1.511442755261877e-05 1.1999999604570011
+ 1.511503096500984e-05 1.1999999604792071
+ 1.5115769961896001e-05 1.19999996048279
+ 1.5116883592384931e-05 1.1999999604816549
+ 1.5118572316076231e-05 1.1999999604809279
+ 1.512144516720486e-05 1.1999999604809399
+ 1.512615422098658e-05 1.1999999604809171
+ 1.513115422098658e-05 1.1999999604808671
+ 1.5136154220986579e-05 1.199999960480858
+ 1.514115422098658e-05 1.1999999604808631
+ 1.5146154220986579e-05 1.1999999604808671
+ 1.515115422098659e-05 1.199999960480868
+ 1.5156154220986589e-05 1.199999960480868
+ 1.516115422098659e-05 1.199999960480868
+ 1.5166154220986589e-05 1.199999960480868
+ 1.517115422098659e-05 1.199999960480868
+ 1.5176154220986589e-05 1.199999960480868
+ 1.518115422098659e-05 1.199999960480868
+ 1.5186154220986589e-05 1.199999960480868
+ 1.519115422098659e-05 1.199999960480868
+ 1.5196154220986591e-05 1.199999960480868
+ 1.520115422098659e-05 1.199999960480868
+ 1.5206154220986591e-05 1.199999960480868
+ 1.521115422098659e-05 1.199999960480868
+ 1.5216154220986601e-05 1.199999960480868
+ 1.52211542209866e-05 1.199999960480868
+ 1.5226154220986601e-05 1.199999960480868
+ 1.52311542209866e-05 1.199999960480868
+ 1.5236154220986601e-05 1.199999960480868
+ 1.52411542209866e-05 1.199999960480868
+ 1.52461542209866e-05 1.199999960480868
+ 1.52511542209866e-05 1.199999960480868
+ 1.52561542209866e-05 1.199999960480868
+ 1.5261154220986599e-05 1.199999960480868
+ 1.52661542209866e-05 1.199999960480868
+ 1.5271154220986601e-05 1.199999960480868
+ 1.5276154220986609e-05 1.199999960480868
+ 1.5281154220986609e-05 1.199999960480868
+ 1.528615422098661e-05 1.199999960480868
+ 1.5291154220986611e-05 1.199999960480868
+ 1.5296154220986608e-05 1.199999960480868
+ 1.5301154220986609e-05 1.199999960480868
+ 1.530615422098661e-05 1.199999960480868
+ 1.5311154220986611e-05 1.199999960480868
+ 1.5316154220986612e-05 1.199999960480868
+ 1.5321154220986609e-05 1.199999960480868
+ 1.532615422098661e-05 1.199999960480868
+ 1.5331154220986611e-05 1.199999960480868
+ 1.5336154220986611e-05 1.199999960480868
+ 1.5341154220986619e-05 1.199999960480868
+ 1.534615422098662e-05 1.1999999604808671
+ 1.5351154220986621e-05 1.1999999604808671
+ 1.5356154220986621e-05 1.1999999604808651
+ 1.5361154220986619e-05 1.199999960480862
+ 1.536615422098662e-05 1.1999999604808571
+ 1.537115422098662e-05 1.199999960480846
+ 1.5376154220986621e-05 1.199999960480826
+ 1.5381154220986619e-05 1.1999999604807869
+ 1.5386154220986619e-05 1.199999960480713
+ 1.539115422098662e-05 1.1999999604805709
+ 1.5396154220986621e-05 1.1999999604803031
+ 1.5401154220986629e-05 1.1999999604798091
+ 1.5406154220986629e-05 1.199999960478942
+ 1.541115422098663e-05 1.1999999604774061
+ 1.5416154220986631e-05 1.199999960474202
+ 1.5421154220986628e-05 1.199999960460826
+ 1.5423514788195041e-05 1.199999960356166
+ 1.5425226836729029e-05 1.199999960086725
+ 1.5427379668381989e-05 1.1999999602288609
+ 1.5428815612978111e-05 1.1999999604732581
+ 1.543056054607684e-05 1.199999960386696
+ 1.5431724976105951e-05 1.199999960570886
+ 1.543222929243077e-05 1.199999961115751
+ 1.543288143923353e-05 1.199999961633607
+ 1.5433212652372172e-05 1.19999996447883
+ 1.5433496640577431e-05 1.19999996754238
+ 1.543372194570357e-05 1.199999963272069
+ 1.5433930924144669e-05 1.1999999157527219
+ 1.5434146125142441e-05 1.199999863637417
+ 1.5434387749955389e-05 1.199999817391405
+ 1.5434503091066129e-05 1.1999996101857049
+ 1.5434565829806991e-05 1.199999238429063
+ 1.5434621200460681e-05 1.199998798160768
+ 1.5434668321855009e-05 1.1999984668388559
+ 1.5434733632500979e-05 1.199997987811124
+ 1.5434804490139509e-05 1.1999981333094569
+ 1.5434886461245491e-05 1.19999926614315
+ 1.5434910689721799e-05 1.199999759333148
+ 1.543492984599112e-05 1.199999718192178
+ 1.543495128674482e-05 1.2000006397570719
+ 1.5434977599129989e-05 1.200004235368932
+ 1.5435001087731681e-05 1.20000891982596
+ 1.54350273604418e-05 1.200010907845352
+ 1.5435047882658031e-05 1.200009495578839
+ 1.5435066135128041e-05 1.2000065141782861
+ 1.5435078997150239e-05 1.200003789313038
+ 1.5435094665752072e-05 1.2000010394021761
+ 1.5435119226065991e-05 1.199998631437821
+ 1.5435150815188168e-05 1.1999974675185501
+ 1.5435178732834851e-05 1.1999970728400069
+ 1.5435208548964651e-05 1.1999973303810629
+ 1.5435236229558518e-05 1.199998978731152
+ 1.543526205136172e-05 1.2000016055619429
+ 1.54352911183619e-05 1.2000045600999421
+ 1.543531737455529e-05 1.200006627325924
+ 1.5435335743177289e-05 1.2000079523534679
+ 1.5435351507392668e-05 1.200009292629731
+ 1.5435367024156208e-05 1.2000112201666511
+ 1.543538079531157e-05 1.200013014633436
+ 1.543539627682266e-05 1.2000131533654741
+ 1.5435408053848812e-05 1.2000120015098641
+ 1.543542237350742e-05 1.2000098448214731
+ 1.5435447206185949e-05 1.200005385368754
+ 1.5435469691351598e-05 1.1999930529435039
+ 1.5435493150179229e-05 1.199946633313304
+ 1.543551679968398e-05 1.1998640356881689
+ 1.5435545378141709e-05 1.1997225671104761
+ 1.5435589251496921e-05 1.199531882731339
+ 1.5435607742256311e-05 1.2006688336727449
+ 1.5435625227826069e-05 1.203961251521841
+ 1.5435648801548541e-05 1.2120958782774309
+ 1.5435667876866202e-05 1.214699911365652
+ 1.543568261271702e-05 1.199521803049453
+ 1.5435701779934461e-05 1.140671323695251
+ 1.5435719100757301e-05 1.0574348472155011
+ 1.5435736327028379e-05 0.95906530100011556
+ 1.543575837653957e-05 0.82578610883750581
+ 1.5435779315991721e-05 0.6990835455621377
+ 1.543579358121988e-05 0.61454916837852591
+ 1.5435804911936901e-05 0.54907046679954119
+ 1.5435819779358241e-05 0.46611485201281189
+ 1.5435830712312219e-05 0.40771272706662948
+ 1.543584469829389e-05 0.33716974557028723
+ 1.5435864337700398e-05 0.24853290002823511
+ 1.5435887791973299e-05 0.16261884992170109
+ 1.5435909759755459e-05 0.1032683378305414
+ 1.5435930666084159e-05 0.064122137885147285
+ 1.543594715048155e-05 0.043086995755011993
+ 1.5435964658769081e-05 0.027801725709696929
+ 1.5435986625524979e-05 0.015604685197516829
+ 1.54360071594632e-05 0.0088868200670889404
+ 1.5436033353285451e-05 0.0041150013181369283
+ 1.543606036768964e-05 0.0017064918402460039
+ 1.543609599837111e-05 0.0003555532874812474
+ 1.5436137091639801e-05 -0.00011357145752327841
+ 1.5436195103260729e-05 -0.00018774247766273911
+ 1.5436272687062071e-05 -0.0001000552267109233
+ 1.543636293743721e-05 -2.5880617113932319e-05
+ 1.54364638352117e-05 1.0832830600812811e-06
+ 1.543659496202545e-05 4.4306911115569634e-06
+ 1.5436775591597371e-05 1.609643951391713e-06
+ 1.5436919977204459e-05 2.999368468026784e-07
+ 1.5437045186330472e-05 2.10022421204379e-08
+ 1.5437161970740271e-05 1.9086623575538539e-08
+ 1.543727913853842e-05 4.7354784636424558e-08
+ 1.543740624602269e-05 6.1008619543590364e-08
+ 1.5437525803099531e-05 6.4494399543049525e-08
+ 1.5437650665795621e-05 6.6472560330622352e-08
+ 1.5437769319340351e-05 6.9471780275530564e-08
+ 1.5437891130465939e-05 7.4131969329230945e-08
+ 1.5438009175725731e-05 8.5913428499825924e-08
+ 1.5438129508419011e-05 1.3325535628567841e-07
+ 1.5438202462380869e-05 3.2992440493764712e-07
+ 1.5438252785698539e-05 6.1134386183480999e-07
+ 1.5438307506331159e-05 6.3562884139981354e-07
+ 1.5438372985201681e-05 2.027157702812483e-07
+ 1.5438409463666891e-05 -1.8685732996387301e-07
+ 1.5438438331507511e-05 -5.8346034691976316e-07
+ 1.5438462322100871e-05 -1.036066739018506e-06
+ 1.5438485136107519e-05 -1.533310260878512e-06
+ 1.5438506465352642e-05 -1.75335357907415e-06
+ 1.5438534498457e-05 -1.63169679648551e-06
+ 1.543855404774539e-05 -1.735636661806487e-06
+ 1.543857709397456e-05 -6.4319841674742845e-07
+ 1.54386156279284e-05 1.0710475962731239e-06
+ 1.543865639572942e-05 1.4149959649778779e-06
+ 1.5438714525053589e-05 7.567590843910296e-07
+ 1.5438780639782681e-05 1.862937093601151e-07
+ 1.5438869349335341e-05 1.9443876668594229e-08
+ 1.5438952483351529e-05 -1.9335590655765811e-08
+ 1.5439053248649711e-05 -5.6121722627929458e-09
+ 1.543916822837731e-05 4.7955693214907089e-08
+ 1.543929621101241e-05 7.4040277098311705e-08
+ 1.5439467710924172e-05 7.0051080424411386e-08
+ 1.5439719266078422e-05 6.1651485776228285e-08
+ 1.544003192061934e-05 6.0777646941479016e-08
+ 1.5440392106452719e-05 6.1758332797539915e-08
+ 1.5440829192369191e-05 6.202939152720324e-08
+ 1.5441362542100572e-05 6.2059200378498999e-08
+ 1.5441960455249129e-05 6.1547081847846792e-08
+ 1.544235538704806e-05 6.0311257116393599e-08
+ 1.5442692358073521e-05 6.3091858536137625e-08
+ 1.5443117847059101e-05 6.2185227428053143e-08
+ 1.5443591385544259e-05 6.1730340693651957e-08
+ 1.544414946540099e-05 6.1913166264707285e-08
+ 1.544474013546389e-05 6.1920943149334603e-08
+ 1.5445568437068271e-05 6.1919003025092939e-08
+ 1.5446720266051301e-05 6.1921842665041261e-08
+ 1.5448752758660528e-05 6.1921390855343347e-08
+ 1.5451807841114829e-05 6.1921010347790668e-08
+ 1.545680784111483e-05 6.1920982298624367e-08
+ 1.546180784111483e-05 6.1920994942572659e-08
+ 1.5466807841114831e-05 6.192099763803415e-08
+ 1.5471807841114839e-05 6.1920998011951431e-08
+ 1.547680784111484e-05 6.1920998135345907e-08
+ 1.548180784111484e-05 6.1920998104023145e-08
+ 1.5486807841114841e-05 6.1920998271512092e-08
+ 1.5491807841114839e-05 6.1920998094117426e-08
+ 1.5496807841114839e-05 6.1920998124604378e-08
+ 1.550180784111484e-05 6.1920997929090698e-08
+ 1.5506807841114841e-05 6.1920998220169693e-08
+ 1.5511807841114838e-05 6.1920998242072046e-08
+ 1.5516807841114839e-05 6.1920998066714441e-08
+ 1.552180784111484e-05 6.1920998188818105e-08
+ 1.5526807841114841e-05 6.1920997944897326e-08
+ 1.5531807841114848e-05 6.1920997961448601e-08
+ 1.5536807841114849e-05 6.1920998115355546e-08
+ 1.554180784111485e-05 6.1920998074210299e-08
+ 1.5546807841114851e-05 6.1920998171082161e-08
+ 1.5551807841114852e-05 6.1920997965347877e-08
+ 1.5556807841114849e-05 6.1920998260937772e-08
+ 1.556180784111485e-05 6.1920998381418428e-08
+ 1.5566807841114851e-05 6.1920998132063933e-08
+ 1.5571807841114851e-05 6.192099798027224e-08
+ 1.5576807841114849e-05 6.1920998041511333e-08
+ 1.558180784111485e-05 6.1920998099373173e-08
+ 1.558680784111485e-05 6.1920998105724173e-08
+ 1.5591807841114851e-05 6.1920998196305069e-08
+ 1.5596807841114859e-05 6.1920998181817007e-08
+ 1.560180784111486e-05 6.1920998313797538e-08
+ 1.560680784111486e-05 6.1920998095683431e-08
+ 1.5611807841114861e-05 6.1920998149265994e-08
+ 1.5616807841114859e-05 6.1920998203062036e-08
+ 1.5621807841114859e-05 6.1920998222597263e-08
+ 1.562680784111486e-05 6.1920998099341422e-08
+ 1.5631807841114861e-05 6.1920998121043439e-08
+ 1.5636807841114858e-05 6.1920998175058412e-08
+ 1.5641807841114859e-05 6.1920998184512755e-08
+ 1.564680784111486e-05 6.1920998046846092e-08
+ 1.5651807841114861e-05 6.1920998102063111e-08
+ 1.5656807841114868e-05 6.1920998125733195e-08
+ 1.5661807841114869e-05 6.1920998200044944e-08
+ 1.566680784111487e-05 6.1920998272297265e-08
+ 1.5671807841114871e-05 6.1920998017233304e-08
+ 1.5676807841114872e-05 6.192099834361994e-08
+ 1.5681807841114869e-05 6.1920998165829591e-08
+ 1.568680784111487e-05 6.1920998233231655e-08
+ 1.5691807841114871e-05 6.1920998005387919e-08
+ 1.5696807841114871e-05 6.1920998373270938e-08
+ 1.5701807841114869e-05 6.1920998139824329e-08
+ 1.570680784111487e-05 6.1920998030896263e-08
+ 1.571180784111487e-05 6.1920998083494349e-08
+ 1.5716807841114871e-05 6.1920998019177284e-08
+ 1.5721807841114879e-05 6.1920998034102719e-08
+ 1.572680784111488e-05 6.1920997982612315e-08
+ 1.573180784111488e-05 6.1920997934088762e-08
+ 1.5736807841114881e-05 6.1920997751335659e-08
+ 1.5741807841114879e-05 6.1920998012510566e-08
+ 1.5746807841114879e-05 6.1920997383427124e-08
+ 1.575180784111488e-05 6.1920993277737885e-08
+ 1.5753894826977489e-05 6.1920903466669568e-08
+ 1.5755721441925931e-05 6.1920913131744386e-08
+ 1.5757611637697421e-05 6.1921195419202993e-08
+ 1.5759149291383779e-05 6.1921056186785608e-08
+ 1.5760826553771572e-05 6.1920806898027785e-08
+ 1.5761849520764759e-05 6.192127254743559e-08
+ 1.5762222917608569e-05 6.1921875022313574e-08
+ 1.576276662469691e-05 6.1920901422129378e-08
+ 1.576307256064827e-05 6.1925269977486679e-08
+ 1.5763317314061679e-05 6.1916632847985197e-08
+ 1.5763517933706921e-05 6.1821103789489431e-08
+ 1.5763725986548979e-05 6.1866836452344123e-08
+ 1.5763967358992611e-05 6.1978924343237567e-08
+ 1.5764116336020441e-05 6.1286234499277879e-08
+ 1.5764181523219819e-05 5.74270329262727e-08
+ 1.5764236166156791e-05 5.5714791947440202e-08
+ 1.5764279577341279e-05 5.9383955315536852e-08
+ 1.576434414034469e-05 9.0818147108383573e-08
+ 1.5764410101075471e-05 1.3040802595644819e-07
+ 1.576447562537424e-05 1.7179831522094859e-07
+ 1.5764505183486261e-05 3.30523754736247e-07
+ 1.576452578908128e-05 6.4997004787542062e-07
+ 1.576454753612288e-05 7.8378609453131791e-07
+ 1.576457503604075e-05 2.6692369111762599e-07
+ 1.576459817608587e-05 -7.6352585753610035e-07
+ 1.576461916547243e-05 -2.637481004626127e-06
+ 1.5764638136689121e-05 -4.1876478146137096e-06
+ 1.5764653249348519e-05 -5.0003869559469428e-06
+ 1.5764667791895949e-05 -4.6762047352525896e-06
+ 1.576467792279015e-05 -2.5228882919291519e-06
+ 1.5764690522761309e-05 -6.5043045186879976e-07
+ 1.5764707314379281e-05 -5.1403330579235504e-07
+ 1.576472616678142e-05 -1.602148115535734e-06
+ 1.5764750594100661e-05 -2.6489172973109671e-06
+ 1.5764775584216029e-05 -3.3031797762948131e-06
+ 1.576479883510982e-05 -3.3442518896783211e-06
+ 1.5764823092310279e-05 -2.044440583220322e-06
+ 1.5764845925250841e-05 -5.5450867752710307e-07
+ 1.576487250578966e-05 -5.090072387817101e-07
+ 1.576490022583655e-05 -1.7042517910315139e-06
+ 1.5764929834825381e-05 -2.971471790640845e-06
+ 1.5764953248203121e-05 -3.6934704894469211e-06
+ 1.5764981650722318e-05 -3.7278194343966749e-06
+ 1.5765004159478099e-05 -6.171768139078595e-07
+ 1.5765022359449299e-05 2.213111707505543e-06
+ 1.576503970555182e-05 -9.7159545346848154e-06
+ 1.5765057615043991e-05 -6.1993856219012995e-05
+ 1.5765079751720709e-05 -0.0001537945199430001
+ 1.5765102370163899e-05 -0.00018294606406479741
+ 1.5765115731076482e-05 -0.0001126777025234233
+ 1.5765129942839311e-05 1.765312168238655e-05
+ 1.5765147439954779e-05 0.0001474686408694525
+ 1.576516423415693e-05 0.00019149702872665341
+ 1.5765187199233829e-05 0.00017472167270537729
+ 1.5765212176768169e-05 0.0001313417651463395
+ 1.5765243680391511e-05 8.54068676634796e-05
+ 1.5765276460640299e-05 6.2120411643099553e-05
+ 1.5765313596893071e-05 5.7351913969088821e-05
+ 1.5765356226922579e-05 6.7896536978802042e-05
+ 1.57654102382391e-05 8.4748278461112169e-05
+ 1.576547986116811e-05 -0.00065735422067708074
+ 1.5765524851376711e-05 -0.0033538878797479792
+ 1.5765564044228769e-05 -0.0076067923242012624
+ 1.5765573208280601e-05 -0.0083381517607554537
+ 1.5765589297016199e-05 -0.0061538443884234526
+ 1.5765600548865529e-05 0.00055876252301468937
+ 1.576561146310862e-05 0.013976884001292921
+ 1.576562352830666e-05 0.03969196036543092
+ 1.5765636453269978e-05 0.081613965789649259
+ 1.5765654704103128e-05 0.1635639049900405
+ 1.5765667772299149e-05 0.23443778488403311
+ 1.5765683433446221e-05 0.32620368703874991
+ 1.576569795494572e-05 0.41350809321024212
+ 1.5765717532073131e-05 0.529343289158418
+ 1.5765740769446979e-05 0.65944851589870024
+ 1.5765774031532139e-05 0.82366019054976825
+ 1.5765811210798949e-05 0.96735646560515998
+ 1.5765858050395698e-05 1.0864743744081029
+ 1.5765893859631449e-05 1.1392423688613571
+ 1.5765933021979639e-05 1.1715274938593649
+ 1.5765984800955169e-05 1.191730357322125
+ 1.576603343880377e-05 1.1986756089135779
+ 1.5766101910943149e-05 1.201301876779165
+ 1.576617897246441e-05 1.201237780424609
+ 1.576630272939294e-05 1.200513450590371
+ 1.5766435196307618e-05 1.2000988662718139
+ 1.576656428287324e-05 1.199986178928055
+ 1.5766687023476549e-05 1.1999799134507561
+ 1.5766806442492061e-05 1.1999907461286039
+ 1.5766934021737829e-05 1.1999978222238621
+ 1.5767052757498209e-05 1.1999999617400641
+ 1.576717665356383e-05 1.200000271477341
+ 1.5767294429643091e-05 1.2000001316573521
+ 1.5767415706440361e-05 1.2000000115752121
+ 1.5767533368384669e-05 1.1999999658967759
+ 1.576765349451528e-05 1.1999999563805359
+ 1.57677714561991e-05 1.199999958007832
+ 1.5767891085215171e-05 1.199999962156173
+ 1.5767958689946141e-05 1.199999976154297
+ 1.5768005639556861e-05 1.199999995364412
+ 1.5768054598150019e-05 1.1999999878515311
+ 1.5768119649738029e-05 1.199999938911853
+ 1.5768170226427869e-05 1.1999999118751989
+ 1.5768198066595259e-05 1.1999998935738569
+ 1.576822323315835e-05 1.1999998583823579
+ 1.5768246057110311e-05 1.199999796826833
+ 1.5768268835523801e-05 1.199999713042629
+ 1.5768297348702669e-05 1.199999654300731
+ 1.5768319284089939e-05 1.199999882460699
+ 1.576834411727552e-05 1.20000018225077
+ 1.5768378432293401e-05 1.2000003218715971
+ 1.5768432118944931e-05 1.2000001980157851
+ 1.576848292468716e-05 1.2000000182043189
+ 1.5768556269284781e-05 1.199999886805573
+ 1.5768639174389329e-05 1.199999870915712
+ 1.57687367948485e-05 1.1999999148780629
+ 1.5768832073897361e-05 1.1999999550376019
+ 1.5768947238227399e-05 1.199999972903431
+ 1.5769085724174711e-05 1.199999970316429
+ 1.576930212401322e-05 1.1999999620328601
+ 1.576970267535689e-05 1.199999958745219
+ 1.5770076398391129e-05 1.19999995978604
+ 1.5770637704007821e-05 1.19999996051281
+ 1.5771229909243778e-05 1.1999999605488429
+ 1.577177402504612e-05 1.199999960438906
+ 1.5772296059915249e-05 1.1999999604798539
+ 1.5772667219601029e-05 1.199999960609033
+ 1.57730861156345e-05 1.199999960439216
+ 1.577356451797857e-05 1.1999999604558571
+ 1.5774163879513101e-05 1.1999999604785161
+ 1.577488404037988e-05 1.199999960482673
+ 1.57759687435233e-05 1.1999999604817331
+ 1.5777589192617941e-05 1.1999999604809519
+ 1.578036635727995e-05 1.1999999604809359
+ 1.5784845997794192e-05 1.1999999604809231
+ 1.5789845997794189e-05 1.1999999604808691
+ 1.579484599779419e-05 1.199999960480858
+ 1.5799845997794191e-05 1.1999999604808631
+ 1.5804845997794191e-05 1.199999960480866
+ 1.5809845997794189e-05 1.199999960480868
+ 1.581484599779419e-05 1.199999960480868
+ 1.581984599779419e-05 1.199999960480868
+ 1.5824845997794191e-05 1.1999999604808691
+ 1.5829845997794199e-05 1.199999960480868
+ 1.58348459977942e-05 1.199999960480868
+ 1.58398459977942e-05 1.199999960480868
+ 1.5844845997794201e-05 1.199999960480868
+ 1.5849845997794199e-05 1.199999960480868
+ 1.5854845997794199e-05 1.199999960480868
+ 1.58598459977942e-05 1.199999960480868
+ 1.5864845997794201e-05 1.199999960480868
+ 1.5869845997794198e-05 1.199999960480868
+ 1.5874845997794199e-05 1.199999960480868
+ 1.58798459977942e-05 1.199999960480868
+ 1.5884845997794201e-05 1.199999960480868
+ 1.5889845997794202e-05 1.199999960480868
+ 1.5894845997794209e-05 1.199999960480868
+ 1.589984599779421e-05 1.199999960480868
+ 1.5904845997794211e-05 1.199999960480868
+ 1.5909845997794212e-05 1.199999960480868
+ 1.5914845997794209e-05 1.199999960480868
+ 1.591984599779421e-05 1.199999960480868
+ 1.5924845997794211e-05 1.199999960480868
+ 1.5929845997794211e-05 1.199999960480868
+ 1.5934845997794209e-05 1.199999960480868
+ 1.593984599779421e-05 1.199999960480868
+ 1.594484599779421e-05 1.199999960480868
+ 1.5949845997794211e-05 1.199999960480868
+ 1.5954845997794219e-05 1.199999960480868
+ 1.595984599779422e-05 1.199999960480868
+ 1.596484599779422e-05 1.199999960480868
+ 1.5969845997794221e-05 1.199999960480868
+ 1.5974845997794219e-05 1.199999960480868
+ 1.5979845997794219e-05 1.199999960480868
+ 1.598484599779422e-05 1.199999960480868
+ 1.5989845997794221e-05 1.199999960480868
+ 1.5994845997794218e-05 1.199999960480868
+ 1.5999845997794219e-05 1.199999960480868
+ 1.600484599779422e-05 1.1999999604808671
+ 1.6009845997794221e-05 1.1999999604808671
+ 1.6014845997794222e-05 1.1999999604808651
+ 1.6019845997794229e-05 1.199999960480862
+ 1.602484599779423e-05 1.1999999604808571
+ 1.6029845997794231e-05 1.1999999604808469
+ 1.6034845997794232e-05 1.1999999604808289
+ 1.6039845997794229e-05 1.199999960480792
+ 1.604484599779423e-05 1.199999960480723
+ 1.6049845997794231e-05 1.19999996048059
+ 1.6054845997794231e-05 1.1999999604803371
+ 1.6059845997794229e-05 1.199999960479871
+ 1.606484599779423e-05 1.199999960479049
+ 1.606984599779423e-05 1.199999960477601
+ 1.6074845997794231e-05 1.1999999604746709
+ 1.6079845997794239e-05 1.199999960463743
+ 1.608241411178541e-05 1.199999960384672
+ 1.608410916822103e-05 1.1999999601156679
+ 1.6086199340717522e-05 1.1999999601890829
+ 1.6087714887005469e-05 1.1999999604210569
+ 1.6089582594403121e-05 1.199999960429976
+ 1.6090819378560451e-05 1.1999999605205429
+ 1.6091366167040589e-05 1.199999961048521
+ 1.6092012374513741e-05 1.1999999615462911
+ 1.6092339754271291e-05 1.199999964074115
+ 1.609264254259424e-05 1.1999999668781061
+ 1.609288062985155e-05 1.1999999655242299
+ 1.609308771264719e-05 1.199999923851901
+ 1.6093303025399901e-05 1.199999868436012
+ 1.6093546136285511e-05 1.1999998262560381
+ 1.609367535103294e-05 1.199999651977766
+ 1.6093741121721501e-05 1.199999297411489
+ 1.609379912710786e-05 1.199998844044911
+ 1.609384443034638e-05 1.19999852587067
+ 1.6093912152391749e-05 1.199998011659998
+ 1.6093982045902111e-05 1.199998083543004
+ 1.6094062895638949e-05 1.1999991329418369
+ 1.6094087980890032e-05 1.1999996862289251
+ 1.6094107975562158e-05 1.1999998074282241
+ 1.609412651186222e-05 1.200000078237389
+ 1.6094151054526548e-05 1.20000261606874
+ 1.6094178492960371e-05 1.2000078626993469
+ 1.6094202899601521e-05 1.200010731937373
+ 1.6094223687759351e-05 1.2000101711807489
+ 1.609424086208317e-05 1.2000079919445661
+ 1.6094255582021701e-05 1.200005034621167
+ 1.6094271561296489e-05 1.2000019505098309
+ 1.6094288723818009e-05 1.1999997063135559
+ 1.6094315474026899e-05 1.199998030766295
+ 1.6094345155262761e-05 1.199997328970303
+ 1.609437290272103e-05 1.1999970821659629
+ 1.6094396988441281e-05 1.1999975640776681
+ 1.6094422349676251e-05 1.1999993227420429
+ 1.609445353148972e-05 1.200002505939435
+ 1.609448291122166e-05 1.200005266335799
+ 1.6094507029984742e-05 1.2000070549479189
+ 1.6094523532690041e-05 1.2000082916599051
+ 1.6094539118339579e-05 1.200009731023024
+ 1.609455398905355e-05 1.200011765480645
+ 1.6094568717907331e-05 1.200013277778182
+ 1.6094582052175011e-05 1.2000129924264911
+ 1.6094596281212501e-05 1.2000113644679551
+ 1.6094612119725921e-05 1.200008813885699
+ 1.6094638479753929e-05 1.2000030656420659
+ 1.609466629861408e-05 1.1999723928270449
+ 1.6094691524577569e-05 1.1999000803402839
+ 1.6094718087261791e-05 1.1997851679520419
+ 1.609475418135644e-05 1.199509983218904
+ 1.609477820733888e-05 1.199667959839305
+ 1.609479438924257e-05 1.2010122829206
+ 1.6094812320346471e-05 1.204933306622739
+ 1.6094833488088008e-05 1.2126424965435261
+ 1.6094850076231899e-05 1.215688714692539
+ 1.6094864123764099e-05 1.203901965895938
+ 1.60948803041827e-05 1.1602034607879841
+ 1.6094897327881029e-05 1.08422490157845
+ 1.6094914980659431e-05 0.98626966983773567
+ 1.60949362436989e-05 0.85848821051968849
+ 1.609495672714877e-05 0.73392886638639887
+ 1.6094971427612801e-05 0.64597778526757099
+ 1.6094982661666151e-05 0.58027882298984923
+ 1.609499517109948e-05 0.50914701527887041
+ 1.6095008240641358e-05 0.43762903273205922
+ 1.6095020986606981e-05 0.37133285300004648
+ 1.6095040596249789e-05 0.27834419042188979
+ 1.6095063680582181e-05 0.1870505939532966
+ 1.6095085963157282e-05 0.12013827113617589
+ 1.6095112836882291e-05 0.06558174342355888
+ 1.6095129055488488e-05 0.044319363903079549
+ 1.6095145700895939e-05 0.02925847900613289
+ 1.609516508763252e-05 0.01771820538575114
+ 1.609518631358889e-05 0.009986141955821936
+ 1.6095210508949621e-05 0.0049919527954538426
+ 1.6095238128071709e-05 0.0020864183820350642
+ 1.6095271211627721e-05 0.0005621884869013204
+ 1.609531184294465e-05 -6.3016657056115823e-05
+ 1.6095364916756031e-05 -0.00019492376168305111
+ 1.6095438418420489e-05 -0.0001211334461394476
+ 1.609553019845421e-05 -3.5399598357268482e-05
+ 1.6095625019045391e-05 -2.093851694056505e-06
+ 1.6095752587887481e-05 4.6942549876140044e-06
+ 1.6095915758984171e-05 2.1787402237383869e-06
+ 1.6096053874152931e-05 4.8327451533164694e-07
+ 1.6096178602619059e-05 3.6476383447674583e-08
+ 1.609629735507741e-05 6.1455876884139121e-09
+ 1.6096416184816109e-05 3.9840493759036309e-08
+ 1.6096546275986519e-05 5.9240214943411971e-08
+ 1.6096666434808681e-05 6.3946073470815583e-08
+ 1.6096792418403338e-05 6.5712955255838887e-08
+ 1.609691087094679e-05 6.8299964515120782e-08
+ 1.6097033038009759e-05 7.208434713983753e-08
+ 1.6097150821290361e-05 8.0261287158512451e-08
+ 1.6097271347439179e-05 1.073209126496221e-07
+ 1.6097368746440509e-05 2.3476297679861259e-07
+ 1.609742285980824e-05 5.4027023673577301e-07
+ 1.6097474003054409e-05 6.8447669439510648e-07
+ 1.6097542677956288e-05 3.3317366023364631e-07
+ 1.6097591685753139e-05 -1.3482001344880989e-07
+ 1.609762026325058e-05 -5.3621712222028099e-07
+ 1.6097645401852261e-05 -1.021284061775354e-06
+ 1.6097668210515771e-05 -1.529506773622389e-06
+ 1.6097689558737169e-05 -1.7696769377720221e-06
+ 1.6097717907371529e-05 -1.6394572090961021e-06
+ 1.6097737899391159e-05 -1.739250106029739e-06
+ 1.6097760880430021e-05 -6.5532141227301816e-07
+ 1.6097803820884198e-05 1.160031184263517e-06
+ 1.6097842659422239e-05 1.414983313066192e-06
+ 1.6097904755103341e-05 6.9678787815333616e-07
+ 1.6097968723315769e-05 1.721631575852433e-07
+ 1.6098047132686342e-05 3.0398915936066403e-08
+ 1.6098132328828431e-05 -1.7072565242563039e-08
+ 1.6098232232022279e-05 -4.2847218638477676e-09
+ 1.6098348328970259e-05 4.8386873782159102e-08
+ 1.609847446147239e-05 7.3626215211848207e-08
+ 1.6098644404701032e-05 6.998879285576123e-08
+ 1.6098888927465261e-05 6.1754095849205334e-08
+ 1.6099203550429119e-05 6.0761814113471285e-08
+ 1.6099557077435789e-05 6.1735876944010985e-08
+ 1.6099994665408248e-05 6.2030079231793321e-08
+ 1.6100518135561489e-05 6.2057608508717168e-08
+ 1.6101136059045209e-05 6.1591351855493418e-08
+ 1.610153228191232e-05 6.0289566826229176e-08
+ 1.6101875000987089e-05 6.304373261432601e-08
+ 1.610230793167828e-05 6.2224609193901499e-08
+ 1.610277242166129e-05 6.1726679220107845e-08
+ 1.6103321870134019e-05 6.1910221237682644e-08
+ 1.6103914008646301e-05 6.192231572037498e-08
+ 1.6104735480979589e-05 6.1919161192456952e-08
+ 1.610589110399675e-05 6.1921753213992055e-08
+ 1.610789776441762e-05 6.1921386415765817e-08
+ 1.6110944532128451e-05 6.192101214098324e-08
+ 1.6115944532128449e-05 6.1920982356650505e-08
+ 1.6120944532128449e-05 6.1920995085230094e-08
+ 1.612594453212845e-05 6.1920997549769638e-08
+ 1.6130944532128451e-05 6.1920997990614804e-08
+ 1.6135944532128459e-05 6.1920997955022307e-08
+ 1.6140944532128459e-05 6.1920998258937213e-08
+ 1.614594453212846e-05 6.1920998105190476e-08
+ 1.6150944532128461e-05 6.1920998112821276e-08
+ 1.6155944532128458e-05 6.1920998241362391e-08
+ 1.6160944532128459e-05 6.192099800860311e-08
+ 1.616594453212846e-05 6.1920998080491908e-08
+ 1.6170944532128461e-05 6.1920998190449596e-08
+ 1.6175944532128462e-05 6.1920998200282087e-08
+ 1.6180944532128459e-05 6.1920998253324878e-08
+ 1.618594453212846e-05 6.1920998272757151e-08
+ 1.6190944532128461e-05 6.1920998367154976e-08
+ 1.6195944532128461e-05 6.1920998174332928e-08
+ 1.6200944532128469e-05 6.1920997997771756e-08
+ 1.620594453212847e-05 6.1920998033386156e-08
+ 1.6210944532128471e-05 6.1920998082004683e-08
+ 1.6215944532128471e-05 6.1920998140806094e-08
+ 1.6220944532128469e-05 6.1920998215425368e-08
+ 1.622594453212847e-05 6.1920998227687666e-08
+ 1.623094453212847e-05 6.1920998265415625e-08
+ 1.6235944532128471e-05 6.1920998120547593e-08
+ 1.6240944532128469e-05 6.1920998200202572e-08
+ 1.6245944532128469e-05 6.1920997958270441e-08
+ 1.625094453212847e-05 6.1920998289762158e-08
+ 1.6255944532128471e-05 6.1920998318966941e-08
+ 1.6260944532128479e-05 6.1920998164501933e-08
+ 1.6265944532128479e-05 6.1920997918523274e-08
+ 1.627094453212848e-05 6.1920998217569751e-08
+ 1.6275944532128481e-05 6.1920998032082586e-08
+ 1.6280944532128478e-05 6.1920998088371617e-08
+ 1.6285944532128479e-05 6.1920998101725357e-08
+ 1.629094453212848e-05 6.1920998220030025e-08
+ 1.6295944532128481e-05 6.1920998050482471e-08
+ 1.6300944532128482e-05 6.1920998100485803e-08
+ 1.6305944532128479e-05 6.1920998113306004e-08
+ 1.631094453212848e-05 6.1920998137189673e-08
+ 1.6315944532128481e-05 6.1920998242717842e-08
+ 1.6320944532128481e-05 6.1920998010415403e-08
+ 1.6325944532128489e-05 6.1920998129073827e-08
+ 1.633094453212849e-05 6.1920997859046076e-08
+ 1.6335944532128491e-05 6.1920998219802755e-08
+ 1.6340944532128491e-05 6.1920998276417193e-08
+ 1.6345944532128489e-05 6.1920998066047416e-08
+ 1.635094453212849e-05 6.1920998085078142e-08
+ 1.635594453212849e-05 6.1920998206634186e-08
+ 1.6360944532128491e-05 6.1920998197731049e-08
+ 1.6365944532128489e-05 6.1920998390992296e-08
+ 1.6370944532128489e-05 6.1920998264729171e-08
+ 1.637594453212849e-05 6.1920998026809369e-08
+ 1.6380944532128491e-05 6.192099829964506e-08
+ 1.6385944532128499e-05 6.1920997990306537e-08
+ 1.6390944532128499e-05 6.1920997870542365e-08
+ 1.63959445321285e-05 6.1920997945233465e-08
+ 1.6400944532128501e-05 6.1920997706529271e-08
+ 1.6405944532128498e-05 6.192099716155886e-08
+ 1.6410944532128499e-05 6.1920993407525474e-08
+ 1.6413041328801909e-05 6.1920906516215871e-08
+ 1.6414862072496802e-05 6.1920906415342545e-08
+ 1.641677789094744e-05 6.1921195303207919e-08
+ 1.6418304201481351e-05 6.1921063037403843e-08
+ 1.641997956453363e-05 6.1920801538169446e-08
+ 1.6421008392575911e-05 6.192126749523857e-08
+ 1.642138681611927e-05 6.1921829260580718e-08
+ 1.6421939285985011e-05 6.1920916424036488e-08
+ 1.6422247083781921e-05 6.1925186393333255e-08
+ 1.6422492325179349e-05 6.1917757867741319e-08
+ 1.642269294879166e-05 6.1827333454110171e-08
+ 1.6422901511082371e-05 6.1857699124683015e-08
+ 1.6423144371619001e-05 6.1982124765030952e-08
+ 1.642330071249275e-05 6.1357196401982442e-08
+ 1.642336757206164e-05 5.7458482967782383e-08
+ 1.642342189831547e-05 5.5565523597379799e-08
+ 1.6423465464294382e-05 5.9457439066555513e-08
+ 1.642353001999413e-05 9.1109953129370295e-08
+ 1.642359588947213e-05 1.3060588824301329e-07
+ 1.6423661088451131e-05 1.719114058443267e-07
+ 1.642369056942192e-05 3.2944526459497998e-07
+ 1.6423711202506269e-05 6.4776749954260435e-07
+ 1.6423732889518061e-05 7.8520403484303107e-07
+ 1.642376033914174e-05 2.7240479867345082e-07
+ 1.6423783558174841e-05 -7.5155215026329383e-07
+ 1.6423804555767029e-05 -2.6207941011943192e-06
+ 1.6423823469776229e-05 -4.1761258185917838e-06
+ 1.642383862656171e-05 -4.9875406092886827e-06
+ 1.6423853063711869e-05 -4.7175601835638474e-06
+ 1.6423863148832731e-05 -2.5756954910719661e-06
+ 1.6423875726284029e-05 -6.6988999670683053e-07
+ 1.6423892296348289e-05 -4.9284791669702239e-07
+ 1.6423911075772671e-05 -1.57090135960662e-06
+ 1.642393541554222e-05 -2.6278996708129392e-06
+ 1.6423960355381741e-05 -3.2866372481582749e-06
+ 1.6423986304999829e-05 -3.3124028727347639e-06
+ 1.642400992721941e-05 -1.9727616331473482e-06
+ 1.6424032919082981e-05 -5.1954092625761901e-07
+ 1.6424059932773741e-05 -5.5993368406116693e-07
+ 1.6424090347801351e-05 -1.8937172584650699e-06
+ 1.6424118635595651e-05 -3.0550179038935039e-06
+ 1.642414055660491e-05 -3.7161697119606112e-06
+ 1.642416792991273e-05 -3.641875464545519e-06
+ 1.6424188509782329e-05 -7.5881705630445528e-07
+ 1.6424206051302401e-05 2.2651218127900048e-06
+ 1.6424223221559428e-05 -6.3648503738214993e-06
+ 1.642424102034359e-05 -5.3459893437427777e-05
+ 1.642426354985075e-05 -0.00014673891092681471
+ 1.6424284529312909e-05 -0.0001882329989122755
+ 1.6424297491036519e-05 -0.0001379660752532538
+ 1.6424310966053279e-05 -2.1127767530483451e-05
+ 1.6424326309398909e-05 0.0001119721868214861
+ 1.6424342420967609e-05 0.0001832804594635247
+ 1.6424365573987451e-05 0.00018573551191367849
+ 1.642438859746653e-05 0.0001477263953239317
+ 1.642442018036256e-05 9.617382737303963e-05
+ 1.642445085962015e-05 6.7195535397283809e-05
+ 1.6424487703118461e-05 5.6850242418421558e-05
+ 1.6424527070436379e-05 6.2658150671932933e-05
+ 1.642457819216081e-05 8.5111889767411692e-05
+ 1.6424642289650109e-05 -0.00016375257592194379
+ 1.6424690777588909e-05 -0.001834755149479683
+ 1.6424736929384239e-05 -0.0063474415773173472
+ 1.6424752045666549e-05 -0.0081406704164947007
+ 1.642476644784514e-05 -0.0083196173924832487
+ 1.6424775557645849e-05 -0.0064228371579437508
+ 1.642478567449416e-05 -0.0006690117561636566
+ 1.6424796256539528e-05 0.0117191969564649
+ 1.642480936379418e-05 0.039386978455163112
+ 1.6424821740511859e-05 0.079557180195509489
+ 1.642483889002238e-05 0.15581629204584529
+ 1.6424851001853049e-05 0.22076249021699509
+ 1.6424864736308679e-05 0.30065444109007328
+ 1.6424879449983809e-05 0.38904069879897091
+ 1.6424897049182549e-05 0.49407429351736509
+ 1.6424919764279439e-05 0.62377719653336583
+ 1.6424950032654539e-05 0.77964743170916539
+ 1.6424987072598161e-05 0.9342482679511348
+ 1.6425029790028889e-05 1.0577950782581349
+ 1.6425074250564071e-05 1.1335803364028669
+ 1.6425115219323851e-05 1.170238420629425
+ 1.642516796594218e-05 1.1919369395044119
+ 1.642521567825403e-05 1.198883164660429
+ 1.642528242646213e-05 1.2014191051213661
+ 1.6425356977757782e-05 1.2012952587545109
+ 1.6425477608202461e-05 1.2005300685647069
+ 1.6425609185593371e-05 1.2000973355666229
+ 1.642573846825949e-05 1.199982619456623
+ 1.6425861644955919e-05 1.1999781955905799
+ 1.6425981322601751e-05 1.1999902904849851
+ 1.6426109374072961e-05 1.19999783175695
+ 1.642622816966205e-05 1.200000020381796
+ 1.6426352246269511e-05 1.200000302887839
+ 1.6426469976198951e-05 1.2000001412067469
+ 1.6426591320681959e-05 1.2000000123535111
+ 1.6426708936379539e-05 1.1999999650573769
+ 1.6426829103700349e-05 1.1999999557784811
+ 1.6426947038156682e-05 1.1999999577306839
+ 1.6427066691921009e-05 1.1999999617390951
+ 1.6427139673363831e-05 1.199999973919011
+ 1.6427187527001991e-05 1.1999999941340329
+ 1.6427235658663469e-05 1.1999999907145691
+ 1.6427301863847179e-05 1.199999942398382
+ 1.642736109096741e-05 1.199999912014964
+ 1.642739065358738e-05 1.199999888265932
+ 1.642741433398152e-05 1.1999998443169799
+ 1.6427436005082662e-05 1.1999997778445299
+ 1.642745840205235e-05 1.199999693500974
+ 1.642748593076664e-05 1.1999996612918731
+ 1.6427505418476962e-05 1.1999998980800239
+ 1.6427530152974029e-05 1.2000001939556599
+ 1.642756814504801e-05 1.200000325569075
+ 1.6427619409165449e-05 1.2000001923258889
+ 1.6427673379875959e-05 1.20000000543579
+ 1.6427746170846079e-05 1.19999988358203
+ 1.6427825207987589e-05 1.19999987181422
+ 1.6427916557361601e-05 1.199999913940464
+ 1.642801462020631e-05 1.199999955310896
+ 1.6428126228265531e-05 1.1999999727148281
+ 1.642826783161874e-05 1.1999999703234081
+ 1.6428475678526e-05 1.199999962243085
+ 1.6428866334905011e-05 1.199999958784256
+ 1.642923924020766e-05 1.199999959769227
+ 1.64297908794332e-05 1.19999996050006
+ 1.6430379516532652e-05 1.199999960548757
+ 1.6430926080772648e-05 1.199999960444913
+ 1.6431415551593558e-05 1.1999999604619109
+ 1.6431767665864371e-05 1.1999999606221039
+ 1.6432172771022581e-05 1.1999999604480149
+ 1.6432636444662551e-05 1.199999960452697
+ 1.6433226722429612e-05 1.1999999604762339
+ 1.643389756909254e-05 1.1999999604821761
+ 1.6434908337861649e-05 1.19999996048195
+ 1.6436356001488359e-05 1.199999960481045
+ 1.6438892824441089e-05 1.1999999604809239
+ 1.6442827414885159e-05 1.199999960480937
+ 1.644782741488516e-05 1.1999999604808771
+ 1.645282741488516e-05 1.199999960480858
+ 1.6457827414885161e-05 1.199999960480862
+ 1.6462827414885159e-05 1.199999960480866
+ 1.6467827414885159e-05 1.199999960480868
+ 1.647282741488516e-05 1.199999960480868
+ 1.6477827414885161e-05 1.199999960480868
+ 1.6482827414885169e-05 1.199999960480868
+ 1.6487827414885169e-05 1.199999960480868
+ 1.649282741488517e-05 1.199999960480868
+ 1.6497827414885171e-05 1.199999960480868
+ 1.6502827414885168e-05 1.199999960480868
+ 1.6507827414885169e-05 1.199999960480868
+ 1.651282741488517e-05 1.199999960480868
+ 1.6517827414885171e-05 1.199999960480868
+ 1.6522827414885172e-05 1.199999960480868
+ 1.6527827414885169e-05 1.199999960480868
+ 1.653282741488517e-05 1.199999960480868
+ 1.6537827414885171e-05 1.199999960480868
+ 1.6542827414885171e-05 1.199999960480868
+ 1.6547827414885179e-05 1.199999960480868
+ 1.655282741488518e-05 1.199999960480868
+ 1.6557827414885181e-05 1.199999960480868
+ 1.6562827414885181e-05 1.199999960480868
+ 1.6567827414885179e-05 1.199999960480868
+ 1.657282741488518e-05 1.199999960480868
+ 1.657782741488518e-05 1.199999960480868
+ 1.6582827414885181e-05 1.199999960480868
+ 1.6587827414885179e-05 1.199999960480868
+ 1.6592827414885179e-05 1.199999960480868
+ 1.659782741488518e-05 1.199999960480868
+ 1.6602827414885181e-05 1.199999960480868
+ 1.6607827414885189e-05 1.199999960480868
+ 1.6612827414885189e-05 1.199999960480868
+ 1.661782741488519e-05 1.199999960480868
+ 1.6622827414885191e-05 1.199999960480868
+ 1.6627827414885188e-05 1.199999960480868
+ 1.6632827414885189e-05 1.199999960480868
+ 1.663782741488519e-05 1.199999960480868
+ 1.6642827414885191e-05 1.199999960480868
+ 1.6647827414885192e-05 1.199999960480868
+ 1.6652827414885189e-05 1.199999960480868
+ 1.665782741488519e-05 1.199999960480868
+ 1.6662827414885191e-05 1.199999960480868
+ 1.6667827414885191e-05 1.199999960480866
+ 1.6672827414885199e-05 1.199999960480866
+ 1.66778274148852e-05 1.1999999604808631
+ 1.6682827414885201e-05 1.1999999604808591
+ 1.6687827414885201e-05 1.19999996048085
+ 1.6692827414885199e-05 1.199999960480834
+ 1.66978274148852e-05 1.1999999604808029
+ 1.67028274148852e-05 1.1999999604807441
+ 1.6707827414885201e-05 1.19999996048063
+ 1.6712827414885199e-05 1.199999960480413
+ 1.6717827414885199e-05 1.1999999604800089
+ 1.67228274148852e-05 1.1999999604792899
+ 1.6727827414885201e-05 1.199999960478032
+ 1.6732827414885209e-05 1.1999999604756331
+ 1.6737827414885209e-05 1.1999999604684639
+ 1.6741311053700271e-05 1.199999960419007
+ 1.674311443946253e-05 1.199999960149233
+ 1.6745082522719781e-05 1.199999960156098
+ 1.6746681712655979e-05 1.199999960383545
+ 1.6748716558216211e-05 1.199999960455695
+ 1.6750249841691481e-05 1.199999960524599
+ 1.6750806403189969e-05 1.199999961339451
+ 1.6751307442545051e-05 1.199999962175778
+ 1.6751585192654269e-05 1.199999964855134
+ 1.6751887749668789e-05 1.1999999673002451
+ 1.6752118769981339e-05 1.1999999599086619
+ 1.6752336197205151e-05 1.1999999040726701
+ 1.675254821791613e-05 1.1999998551880351
+ 1.6752793437063469e-05 1.199999795467199
+ 1.6752895737378999e-05 1.1999994884864691
+ 1.6752954288183182e-05 1.199999020858542
+ 1.6753002662232651e-05 1.199998631241376
+ 1.675306353316232e-05 1.199998157687028
+ 1.67531304700976e-05 1.199997946274558
+ 1.675320519162563e-05 1.1999986012147621
+ 1.675323892488001e-05 1.199999257501263
+ 1.6753263010839209e-05 1.199999802941524
+ 1.675328080351938e-05 1.1999999364078759
+ 1.675329906387208e-05 1.199999972000652
+ 1.675332223290447e-05 1.200001943916186
+ 1.6753349109786808e-05 1.2000067957878779
+ 1.6753373758433979e-05 1.200010392686641
+ 1.6753395616870501e-05 1.2000104311863611
+ 1.6753413033746369e-05 1.200008547598697
+ 1.675343180149796e-05 1.200005089804649
+ 1.6753446638270619e-05 1.2000021935952541
+ 1.6753462750970491e-05 1.199999925509986
+ 1.6753490131632051e-05 1.1999980428057231
+ 1.6753519556539502e-05 1.199997325059291
+ 1.6753546474764051e-05 1.1999970678894729
+ 1.675357044497605e-05 1.1999974415182919
+ 1.6753595932229128e-05 1.199999055708094
+ 1.6753622301662959e-05 1.200001743396885
+ 1.6753652073906441e-05 1.2000046965791049
+ 1.67536786237884e-05 1.20000672397841
+ 1.6753696803775369e-05 1.20000802854262
+ 1.6753712545802659e-05 1.200009384942889
+ 1.6753727895330779e-05 1.2000113366197589
+ 1.675374174942165e-05 1.200013076172076
+ 1.675375704521028e-05 1.200013108140787
+ 1.6753769748720151e-05 1.200011797609277
+ 1.6753784104601171e-05 1.200009579764181
+ 1.6753809337388981e-05 1.2000048956832829
+ 1.6753831903991339e-05 1.199990521860915
+ 1.675385530430861e-05 1.1999406618923281
+ 1.6753881577230501e-05 1.199844861097022
+ 1.675391022451997e-05 1.199691978108572
+ 1.675395690305682e-05 1.1998847392677989
+ 1.6753975438122721e-05 1.201942697976115
+ 1.6753996165475989e-05 1.207344469411562
+ 1.6754019741265821e-05 1.214936538525522
+ 1.6754034866465491e-05 1.210111765826589
+ 1.6754048940924439e-05 1.184443538819469
+ 1.6754066207095561e-05 1.1205284732918099
+ 1.6754086719693871e-05 1.0141629183925649
+ 1.6754107505840421e-05 0.89114640594850025
+ 1.6754127953735531e-05 0.76656734437584795
+ 1.675414480239178e-05 0.66514169699208103
+ 1.6754156931407579e-05 0.59379640581157811
+ 1.675416845335088e-05 0.52778448192503857
+ 1.6754181675010541e-05 0.45464899524360491
+ 1.675419555672208e-05 0.38164245077697678
+ 1.6754210459006362e-05 0.30883409415572821
+ 1.6754230691785349e-05 0.22214319642562291
+ 1.6754254575405758e-05 0.1414974210877151
+ 1.6754276876877161e-05 0.087735380881104358
+ 1.6754292741497129e-05 0.060829134812819242
+ 1.6754308634665909e-05 0.041485041204822347
+ 1.6754326616145241e-05 0.02644803595837739
+ 1.6754347934326758e-05 0.01511091108499597
+ 1.6754369530609609e-05 0.0083394574656836286
+ 1.675439536896892e-05 0.003887739486013557
+ 1.6754423569019759e-05 0.0015265370101718121
+ 1.6754459091640269e-05 0.00029553835311900677
+ 1.6754501852396709e-05 -0.00013586011827452119
+ 1.675456048453496e-05 -0.0001834410163465627
+ 1.6754641834339158e-05 -9.0652813595243895e-05
+ 1.6754730352321101e-05 -2.2642014797484978e-05
+ 1.6754835557996561e-05 2.173393782720794e-06
+ 1.6754967348802372e-05 4.2541680731845096e-06
+ 1.6755129904174631e-05 1.4524439502763119e-06
+ 1.6755267964032411e-05 2.4702975225557182e-07
+ 1.6755392351670479e-05 7.4467534636306217e-09
+ 1.675551077020737e-05 1.8255663926199201e-08
+ 1.6755629308539071e-05 4.8623404254774131e-08
+ 1.675575767338839e-05 6.1647803395807456e-08
+ 1.675587764323431e-05 6.4525608652424744e-08
+ 1.6756002734235429e-05 6.6282640335334404e-08
+ 1.675612131318527e-05 6.9218745108611323e-08
+ 1.675624310952227e-05 7.3716566872037371e-08
+ 1.6756361071783949e-05 8.4707746995420545e-08
+ 1.67564814110551e-05 1.2733545658727201e-07
+ 1.6756557975340269e-05 3.0863653036362601e-07
+ 1.675660876443003e-05 5.9516466921694535e-07
+ 1.6756662348583329e-05 6.510630141069776e-07
+ 1.6756728183355489e-05 2.3924666727326528e-07
+ 1.6756763834560439e-05 -1.396374055241913e-07
+ 1.675679445586625e-05 -5.3453838525901435e-07
+ 1.6756819103877611e-05 -9.7422002778513987e-07
+ 1.6756842257245001e-05 -1.478156167754452e-06
+ 1.675686372089412e-05 -1.7524866953912329e-06
+ 1.6756892650980152e-05 -1.6242349801596351e-06
+ 1.6756913498829549e-05 -1.7262995633597549e-06
+ 1.6756936492744111e-05 -6.6873897783065502e-07
+ 1.6756977285229539e-05 1.1046016974759879e-06
+ 1.67570168390933e-05 1.4152102240491059e-06
+ 1.6757077010790108e-05 7.3110965681245501e-07
+ 1.6757141779376009e-05 1.8177529283137771e-07
+ 1.6757222579564269e-05 2.9482789665322581e-08
+ 1.675730781243331e-05 -1.7011582132329072e-08
+ 1.6757409072342198e-05 -5.2164104270817174e-09
+ 1.675752417249485e-05 4.7404941509205673e-08
+ 1.6757651197990611e-05 7.3639256943918274e-08
+ 1.675782025675434e-05 7.0149421932121e-08
+ 1.675806676673967e-05 6.1763308719773223e-08
+ 1.675837955834946e-05 6.075283786303412e-08
+ 1.6758734748564621e-05 6.173757137326312e-08
+ 1.6759170551950109e-05 6.2029501568130551e-08
+ 1.6759695770972141e-05 6.2057827258860912e-08
+ 1.676031177535873e-05 6.1589165235518371e-08
+ 1.676070776182503e-05 6.029015597955092e-08
+ 1.676105006624906e-05 6.3044529635398541e-08
+ 1.676148262985706e-05 6.2224101173639542e-08
+ 1.6761946907167979e-05 6.1726855593034313e-08
+ 1.676249604232277e-05 6.1910228572947256e-08
+ 1.6763088039608361e-05 6.192228851484656e-08
+ 1.6763908858353911e-05 6.1919153168608234e-08
+ 1.676506361408167e-05 6.1921752715463072e-08
+ 1.676706759908201e-05 6.1921388019960113e-08
+ 1.677011178898454e-05 6.1921012437949193e-08
+ 1.6775111788984541e-05 6.1920982319502154e-08
+ 1.6780111788984542e-05 6.192099480369368e-08
+ 1.6785111788984539e-05 6.1920997560992176e-08
+ 1.679011178898454e-05 6.1920997910490596e-08
+ 1.6795111788984541e-05 6.1920998216876839e-08
+ 1.6800111788984541e-05 6.1920998043325175e-08
+ 1.6805111788984549e-05 6.1920998279616344e-08
+ 1.681011178898455e-05 6.192099816548289e-08
+ 1.6815111788984551e-05 6.1920997995118372e-08
+ 1.6820111788984551e-05 6.1920997981268576e-08
+ 1.6825111788984549e-05 6.1920998310661491e-08
+ 1.683011178898455e-05 6.1920998090050013e-08
+ 1.683511178898455e-05 6.1920998154202145e-08
+ 1.6840111788984551e-05 6.1920998280862661e-08
+ 1.6845111788984549e-05 6.192099809071909e-08
+ 1.6850111788984549e-05 6.1920998053711718e-08
+ 1.685511178898455e-05 6.1920998221712457e-08
+ 1.6860111788984551e-05 6.1920997986278842e-08
+ 1.6865111788984559e-05 6.192099799077709e-08
+ 1.6870111788984559e-05 6.1920998099242941e-08
+ 1.687511178898456e-05 6.1920998145143299e-08
+ 1.6880111788984561e-05 6.1920998225832571e-08
+ 1.6885111788984558e-05 6.1920998278537582e-08
+ 1.6890111788984559e-05 6.1920998315938692e-08
+ 1.689511178898456e-05 6.1920998099079662e-08
+ 1.6900111788984561e-05 6.1920998204756274e-08
+ 1.6905111788984562e-05 6.1920997954259197e-08
+ 1.6910111788984559e-05 6.1920998000929984e-08
+ 1.691511178898456e-05 6.1920998124244164e-08
+ 1.6920111788984561e-05 6.1920998104328408e-08
+ 1.6925111788984561e-05 6.1920998244434076e-08
+ 1.6930111788984569e-05 6.1920998032278991e-08
+ 1.693511178898457e-05 6.1920998089328579e-08
+ 1.6940111788984571e-05 6.1920998067120726e-08
+ 1.6945111788984571e-05 6.1920998186618307e-08
+ 1.6950111788984569e-05 6.1920997960797907e-08
+ 1.695511178898457e-05 6.1920998044192642e-08
+ 1.696011178898457e-05 6.1920998085632511e-08
+ 1.6965111788984571e-05 6.1920998140844938e-08
+ 1.6970111788984569e-05 6.192099815627089e-08
+ 1.6975111788984569e-05 6.1920998024684692e-08
+ 1.698011178898457e-05 6.1920998078937444e-08
+ 1.6985111788984571e-05 6.1920998107388791e-08
+ 1.6990111788984579e-05 6.1920997946541019e-08
+ 1.6995111788984579e-05 6.1920998253846571e-08
+ 1.700011178898458e-05 6.1920998044940334e-08
+ 1.7005111788984581e-05 6.1920998131207384e-08
+ 1.7010111788984578e-05 6.1920998143842932e-08
+ 1.7015111788984579e-05 6.1920998180180222e-08
+ 1.702011178898458e-05 6.1920998355701846e-08
+ 1.7025111788984581e-05 6.1920998033644554e-08
+ 1.7030111788984582e-05 6.1920998119458825e-08
+ 1.7035111788984579e-05 6.1920998242052934e-08
+ 1.704011178898458e-05 6.1920998009903743e-08
+ 1.7045111788984581e-05 6.1920998068080308e-08
+ 1.7050111788984581e-05 6.192099793957019e-08
+ 1.7055111788984589e-05 6.1920997927438018e-08
+ 1.706011178898459e-05 6.1920997643295852e-08
+ 1.7065111788984591e-05 6.1920997462677511e-08
+ 1.7070111788984591e-05 6.1920993407815358e-08
+ 1.7072210510954272e-05 6.1920907349148287e-08
+ 1.707402931260896e-05 6.1920904579802164e-08
+ 1.7075949889029211e-05 6.192119549916375e-08
+ 1.7077473561731569e-05 6.1921064392744081e-08
+ 1.7079148365107411e-05 6.1920799664048288e-08
+ 1.7080178834715041e-05 6.1921266739081617e-08
+ 1.70805585291787e-05 6.1921819765889132e-08
+ 1.7081112929318069e-05 6.1920919474212825e-08
+ 1.7081421120947699e-05 6.1925166076147971e-08
+ 1.708166646228529e-05 6.1918003094538389e-08
+ 1.7081866828671021e-05 6.1828774885421147e-08
+ 1.7082075401728281e-05 6.185560869257084e-08
+ 1.7082318698690078e-05 6.1982847127660446e-08
+ 1.708247709594524e-05 6.1375010340464657e-08
+ 1.7082544420192311e-05 5.7466297839464872e-08
+ 1.7082598650612701e-05 5.5522027912538847e-08
+ 1.7082642264370861e-05 5.9488168361952111e-08
+ 1.7082706811941559e-05 9.1213694333447398e-08
+ 1.7082772656453619e-05 1.3067673799185739e-07
+ 1.7082837737614129e-05 1.7196204675952909e-07
+ 1.7082867188361759e-05 3.2911407215276659e-07
+ 1.7082887830873649e-05 6.4706907485938794e-07
+ 1.70829094996718e-05 7.8563378991293095e-07
+ 1.7082936932777009e-05 2.7412940218456481e-07
+ 1.7082960177274299e-05 -7.4779031316453379e-07
+ 1.708298117701015e-05 -2.6154891681421608e-06
+ 1.7083000072591241e-05 -4.172425631251166e-06
+ 1.708301524352266e-05 -4.9834517488473943e-06
+ 1.7083029647749939e-05 -4.7305464746250676e-06
+ 1.7083039718887981e-05 -2.5924493301159719e-06
+ 1.7083052289808191e-05 -6.7616760576706318e-07
+ 1.708306879080162e-05 -4.8634447567584037e-07
+ 1.7083087567082711e-05 -1.561769400306123e-06
+ 1.7083111867930029e-05 -2.6214296020466161e-06
+ 1.708313679293707e-05 -3.281644497204979e-06
+ 1.7083162725544769e-05 -3.3187421190863809e-06
+ 1.7083186466627751e-05 -1.9854623200330728e-06
+ 1.7083209432921579e-05 -5.2611132998033163e-07
+ 1.7083236372473819e-05 -5.5331833626693723e-07
+ 1.708326687044036e-05 -1.8855354244468571e-06
+ 1.7083295077628099e-05 -3.0456725106874671e-06
+ 1.7083317018941232e-05 -3.710154671612507e-06
+ 1.708334449944695e-05 -3.6526319283519301e-06
+ 1.7083365263201889e-05 -7.5336063063767856e-07
+ 1.7083382875114631e-05 2.2628774741049298e-06
+ 1.7083400049463339e-05 -6.6010725968866634e-06
+ 1.7083417852374432e-05 -5.4085625756691867e-05
+ 1.7083440347113921e-05 -0.00014726630193803811
+ 1.708346145240189e-05 -0.00018798925691777929
+ 1.708347440271353e-05 -0.00013647440053590249
+ 1.70834879189956e-05 -1.862608820004667e-05
+ 1.7083503338108249e-05 0.0001142074294251333
+ 1.7083519485648741e-05 0.0001839824783812878
+ 1.7083542876284029e-05 0.00018503828143665821
+ 1.708356586768657e-05 0.00014672522682677701
+ 1.7083597605253181e-05 9.5198209896330018e-05
+ 1.708362830830742e-05 6.674710762036301e-05
+ 1.7083665288072519e-05 5.6824754008117441e-05
+ 1.7083704783963211e-05 6.2977622355648221e-05
+ 1.7083756227967869e-05 8.5610819468636058e-05
+ 1.7083820676372029e-05 -0.0001872025126439945
+ 1.708386867133517e-05 -0.0019132776774765251
+ 1.7083915215746409e-05 -0.0065546436772834591
+ 1.708392968922641e-05 -0.008226793827947082
+ 1.7083944199797459e-05 -0.0081817114019571563
+ 1.7083953451918131e-05 -0.0059166007087406878
+ 1.7083963382661001e-05 0.00026670821838357608
+ 1.708397390125005e-05 0.013301394695291799
+ 1.7083986945558111e-05 0.041873897469956158
+ 1.708399952751637e-05 0.083846508796545483
+ 1.7084014582607489e-05 0.15114421914812801
+ 1.7084025968411558e-05 0.211685207933207
+ 1.7084039165998221e-05 0.28798275085082381
+ 1.7084053550960691e-05 0.37426914368990832
+ 1.708407059223043e-05 0.47633093942832633
+ 1.7084092522079321e-05 0.60275549563078357
+ 1.7084121619413201e-05 0.75571508885294403
+ 1.70841580042592e-05 0.91364663557810388
+ 1.7084199403377651e-05 1.0414935279477731
+ 1.7084252983445039e-05 1.1369604339010619
+ 1.7084296293878272e-05 1.1740438277311169
+ 1.708434930444956e-05 1.193812485386345
+ 1.708439772908963e-05 1.199774304371988
+ 1.70844642232934e-05 1.201599837361881
+ 1.708454079658388e-05 1.2012477651007001
+ 1.7084665529228412e-05 1.200439100173436
+ 1.7084798651040302e-05 1.2000574311955621
+ 1.7084927923643459e-05 1.199974130864349
+ 1.7085050590451899e-05 1.199978752502183
+ 1.708516990233238e-05 1.1999917182894779
+ 1.7085297401960101e-05 1.199998531414151
+ 1.7085416085911439e-05 1.2000002248413071
+ 1.7085539970139609e-05 1.200000315179067
+ 1.7085657739028309e-05 1.2000001213196649
+ 1.7085779022756869e-05 1.199999999470835
+ 1.7085896684762811e-05 1.199999960561378
+ 1.7086016815086689e-05 1.1999999551197129
+ 1.7086134775217769e-05 1.19999995803971
+ 1.7086254405844439e-05 1.1999999623817781
+ 1.708632160019665e-05 1.199999976454502
+ 1.7086368480661919e-05 1.199999995515564
+ 1.7086417516461192e-05 1.199999987649061
+ 1.708648248320444e-05 1.199999938670959
+ 1.7086532351706912e-05 1.1999999118604601
+ 1.708656003950886e-05 1.199999893908559
+ 1.708658534244081e-05 1.1999998593656329
+ 1.7086608269874989e-05 1.199999798194336
+ 1.708663108836382e-05 1.199999714428031
+ 1.7086659675692881e-05 1.199999654046092
+ 1.7086681803933781e-05 1.19999988148578
+ 1.7086706670109411e-05 1.2000001817171
+ 1.7086740763623949e-05 1.200000321568802
+ 1.7086794634531091e-05 1.200000198123667
+ 1.708684524487401e-05 1.200000018804565
+ 1.708691869226884e-05 1.1999998868813271
+ 1.708700173890682e-05 1.1999998708826589
+ 1.7087099141250071e-05 1.199999914778394
+ 1.708719456331249e-05 1.1999999550216189
+ 1.7087309537125831e-05 1.1999999728886079
+ 1.7087448156573318e-05 1.1999999703219359
+ 1.7087664222342981e-05 1.199999962044368
+ 1.7088064889609771e-05 1.199999958744598
+ 1.7088438513480349e-05 1.1999999597847779
+ 1.7088999983200421e-05 1.1999999605126661
+ 1.708959211491731e-05 1.199999960548902
+ 1.709013629670405e-05 1.1999999604389719
+ 1.7090658061103351e-05 1.19999996047971
+ 1.709102905612657e-05 1.1999999606091469
+ 1.7091447828996128e-05 1.199999960439271
+ 1.709192609438837e-05 1.1999999604558309
+ 1.70925253700302e-05 1.199999960478499
+ 1.7093245105387281e-05 1.1999999604826701
+ 1.7094329162242879e-05 1.199999960481734
+ 1.7095948086574172e-05 1.199999960480953
+ 1.709872313219555e-05 1.1999999604809359
+ 1.71031977572403e-05 1.1999999604809239
+ 1.7108197757240301e-05 1.19999996048087
+ 1.7113197757240308e-05 1.199999960480858
+ 1.7118197757240309e-05 1.1999999604808631
+ 1.712319775724031e-05 1.199999960480866
+ 1.7128197757240311e-05 1.199999960480868
+ 1.7133197757240312e-05 1.199999960480868
+ 1.7138197757240309e-05 1.199999960480868
+ 1.714319775724031e-05 1.1999999604808691
+ 1.7148197757240311e-05 1.199999960480868
+ 1.7153197757240311e-05 1.199999960480868
+ 1.7158197757240309e-05 1.199999960480868
+ 1.716319775724031e-05 1.199999960480868
+ 1.716819775724031e-05 1.199999960480868
+ 1.7173197757240311e-05 1.199999960480868
+ 1.7178197757240319e-05 1.199999960480868
+ 1.718319775724032e-05 1.199999960480868
+ 1.718819775724032e-05 1.199999960480868
+ 1.7193197757240321e-05 1.199999960480868
+ 1.7198197757240319e-05 1.199999960480868
+ 1.7203197757240319e-05 1.199999960480868
+ 1.720819775724032e-05 1.199999960480868
+ 1.7213197757240321e-05 1.199999960480868
+ 1.7218197757240318e-05 1.199999960480868
+ 1.7223197757240319e-05 1.199999960480868
+ 1.722819775724032e-05 1.199999960480868
+ 1.7233197757240321e-05 1.199999960480868
+ 1.7238197757240328e-05 1.199999960480868
+ 1.7243197757240329e-05 1.199999960480868
+ 1.724819775724033e-05 1.199999960480868
+ 1.7253197757240331e-05 1.199999960480868
+ 1.7258197757240332e-05 1.199999960480868
+ 1.7263197757240329e-05 1.199999960480868
+ 1.726819775724033e-05 1.199999960480868
+ 1.7273197757240331e-05 1.199999960480868
+ 1.7278197757240331e-05 1.199999960480868
+ 1.7283197757240329e-05 1.199999960480868
+ 1.728819775724033e-05 1.199999960480868
+ 1.729319775724033e-05 1.199999960480868
+ 1.7298197757240331e-05 1.199999960480868
+ 1.7303197757240339e-05 1.199999960480868
+ 1.730819775724034e-05 1.199999960480868
+ 1.731319775724034e-05 1.199999960480868
+ 1.7318197757240341e-05 1.199999960480868
+ 1.7323197757240339e-05 1.1999999604808671
+ 1.7328197757240339e-05 1.1999999604808671
+ 1.733319775724034e-05 1.1999999604808651
+ 1.7338197757240341e-05 1.199999960480862
+ 1.7343197757240338e-05 1.1999999604808571
+ 1.7348197757240339e-05 1.1999999604808469
+ 1.735319775724034e-05 1.1999999604808289
+ 1.7358197757240341e-05 1.199999960480792
+ 1.7363197757240348e-05 1.199999960480723
+ 1.7368197757240349e-05 1.19999996048059
+ 1.737319775724035e-05 1.199999960480338
+ 1.7378197757240351e-05 1.1999999604798719
+ 1.7383197757240352e-05 1.199999960479051
+ 1.7388197757240349e-05 1.199999960477605
+ 1.739319775724035e-05 1.19999996047468
+ 1.7398197757240351e-05 1.1999999604637941
+ 1.7400770809895292e-05 1.1999999603851479
+ 1.7402466380081659e-05 1.199999960116269
+ 1.74045551651903e-05 1.199999960188419
+ 1.7406072726370532e-05 1.199999960420187
+ 1.7407943224313661e-05 1.1999999604306899
+ 1.740918072461788e-05 1.1999999605201039
+ 1.740972771426565e-05 1.1999999610483281
+ 1.741037394114519e-05 1.1999999615458039
+ 1.7410701299742861e-05 1.1999999640724679
+ 1.7411004180231519e-05 1.199999966875172
+ 1.741124232668208e-05 1.19999996553169
+ 1.7411449448197978e-05 1.199999923880017
+ 1.7411664774751499e-05 1.199999868444799
+ 1.7411907895592161e-05 1.1999998262645919
+ 1.7412037144234339e-05 1.1999996520198239
+ 1.7412102923616561e-05 1.1999992974082581
+ 1.7412160925866269e-05 1.199998844024285
+ 1.7412206228315239e-05 1.199998525841161
+ 1.7412273950860202e-05 1.199998011633332
+ 1.7412343842719541e-05 1.199998083544028
+ 1.741242469439419e-05 1.199999132981393
+ 1.74124497796511e-05 1.1999996862629601
+ 1.7412469773930231e-05 1.1999998073961551
+ 1.741248831093146e-05 1.2000000783698559
+ 1.7412512853981059e-05 1.200002616494195
+ 1.741254028990886e-05 1.2000078628787001
+ 1.7412564697345412e-05 1.200010732040417
+ 1.741258548590464e-05 1.2000101710804809
+ 1.7412602660895071e-05 1.200007991604555
+ 1.7412617379699208e-05 1.200005034409926
+ 1.7412633358407819e-05 1.200001950412203
+ 1.741265052234697e-05 1.199999706112834
+ 1.74126772719293e-05 1.1999980307142279
+ 1.7412706953696239e-05 1.199997328938373
+ 1.7412734701962939e-05 1.1999970821678441
+ 1.7412758787967889e-05 1.199997564202002
+ 1.741278414944883e-05 1.1999993230371939
+ 1.7412815327475119e-05 1.200002505944245
+ 1.741284471071857e-05 1.2000052665918639
+ 1.7412868830593921e-05 1.200007055209831
+ 1.7412885333555621e-05 1.2000082919778381
+ 1.741290091941542e-05 1.2000097315052309
+ 1.7412915789175669e-05 1.2000117660198859
+ 1.7412930519715289e-05 1.2000132779698549
+ 1.741294385062283e-05 1.200012992262719
+ 1.7412958077816449e-05 1.2000113644012771
+ 1.741297392052652e-05 1.2000088131404369
+ 1.7413000284414921e-05 1.200003062290508
+ 1.741302810346228e-05 1.1999723761610781
+ 1.7413053336311531e-05 1.1999000276052589
+ 1.7413079894220231e-05 1.19978511616244
+ 1.7413116000627809e-05 1.1995097509551971
+ 1.741314001679436e-05 1.1996684527362611
+ 1.7413156197549619e-05 1.201013992396708
+ 1.7413174134012921e-05 1.2049383719552491
+ 1.7413195301244379e-05 1.212649006563864
+ 1.7413211884213362e-05 1.2156870450062141
+ 1.7413225930816259e-05 1.2038851369339469
+ 1.7413242118736529e-05 1.1601379194346331
+ 1.7413259146358809e-05 1.084114260321225
+ 1.7413276793771122e-05 0.98617393730280278
+ 1.741329806084738e-05 0.8583638755513272
+ 1.7413318544529459e-05 0.73380473172637217
+ 1.741333324316106e-05 0.64586740015233202
+ 1.741334447633046e-05 0.58017615071110817
+ 1.741335699772648e-05 0.508980897808751
+ 1.7413370072425081e-05 0.43744273161725361
+ 1.7413382804536588e-05 0.37122671949354352
+ 1.7413402468601188e-05 0.27801238766587788
+ 1.7413425519753769e-05 0.18690360934695621
+ 1.741344782424895e-05 0.1199755798520277
+ 1.7413474710664831e-05 0.065460718901676027
+ 1.7413490976660719e-05 0.044179306152126223
+ 1.7413507654085809e-05 0.029136632993988758
+ 1.7413527066653391e-05 0.01762786673000933
+ 1.7413548297286691e-05 0.0099311244888453387
+ 1.7413572521788601e-05 0.0049580633777712019
+ 1.7413600165009539e-05 0.0020687321741198368
+ 1.741363331005313e-05 0.00055373832878003262
+ 1.7413674014423549e-05 -6.5623341264207111e-05
+ 1.7413727233111818e-05 -0.00019479153796942561
+ 1.741380096059587e-05 -0.0001202399126595101
+ 1.7413892601934139e-05 -3.4998068894413902e-05
+ 1.7413987709038521e-05 -1.933313044315126e-06
+ 1.741411534870172e-05 4.6886378348992662e-06
+ 1.7414279238556068e-05 2.1546518560502089e-06
+ 1.7414417620981921e-05 4.7474849689559592e-07
+ 1.741454237956292e-05 3.5581947383586461e-08
+ 1.7414661055238791e-05 6.6845995165217636e-09
+ 1.7414779817880679e-05 4.0178442417177431e-08
+ 1.7414909786896931e-05 5.9322044017379582e-08
+ 1.741502992013425e-05 6.3966074629051462e-08
+ 1.7415155857672849e-05 6.5739866390738531e-08
+ 1.7415274317538159e-05 6.8342734165959953e-08
+ 1.7415396470098561e-05 7.2154760072194024e-08
+ 1.7415514263662659e-05 8.0438392182935679e-08
+ 1.7415634781906379e-05 1.0805999938042361e-07
+ 1.7415731043038338e-05 2.3752785246003159e-07
+ 1.741578496353518e-05 5.4210514028938836e-07
+ 1.741583614975331e-05 6.8363853927781372e-07
+ 1.7415904673132209e-05 3.30865810584356e-07
+ 1.7415953101828921e-05 -1.330791670367604e-07
+ 1.7415981540528399e-05 -5.3031476424144982e-07
+ 1.741600681030607e-05 -1.0129360352991229e-06
+ 1.7416029736319619e-05 -1.5219947575982161e-06
+ 1.7416051140371659e-05 -1.7683204317874549e-06
+ 1.7416079598796769e-05 -1.6374258682371099e-06
+ 1.7416099736455721e-05 -1.7368830668346951e-06
+ 1.7416122717917161e-05 -6.5605065079830365e-07
+ 1.7416165343703339e-05 1.1528736545166981e-06
+ 1.7416204289249031e-05 1.4148768457558989e-06
+ 1.7416266103726891e-05 7.0133068217895634e-07
+ 1.7416330206511481e-05 1.73322039252872e-07
+ 1.74164089167867e-05 3.0315076020371018e-08
+ 1.7416494098674421e-05 -1.70516152033085e-08
+ 1.7416594166673741e-05 -4.4133715203026366e-09
+ 1.7416710133411741e-05 4.8254038037909848e-08
+ 1.741683637662778e-05 7.3626511092772092e-08
+ 1.7417006201796319e-05 7.0010839810845386e-08
+ 1.7417250955796721e-05 6.1756112564894964e-08
+ 1.7417565403990851e-05 6.0760669739080968e-08
+ 1.7417919149167679e-05 6.1735823545472923e-08
+ 1.7418356589754511e-05 6.2030081224200274e-08
+ 1.741888031695801e-05 6.2057644370824901e-08
+ 1.741949792697485e-05 6.1590867416924512e-08
+ 1.7419894107526939e-05 6.0289708331325294e-08
+ 1.7420236742672909e-05 6.3044157602287494e-08
+ 1.7420669588756511e-05 6.2224301643555207e-08
+ 1.742113410705798e-05 6.1726722979922469e-08
+ 1.7421683569673679e-05 6.1910241266403817e-08
+ 1.7422275683126189e-05 6.1922303692327254e-08
+ 1.7423097119248359e-05 6.1919159313468598e-08
+ 1.7424252619456079e-05 6.1921753802573876e-08
+ 1.7426259119778449e-05 6.1921386504134753e-08
+ 1.7429305637279031e-05 6.1921012334938737e-08
+ 1.7434305637279031e-05 6.1920982291746089e-08
+ 1.7439305637279029e-05 6.1920995169957675e-08
+ 1.744430563727903e-05 6.1920997701135471e-08
+ 1.744930563727903e-05 6.1920997970831939e-08
+ 1.7454305637279031e-05 6.1920998159521684e-08
+ 1.7459305637279029e-05 6.1920998222729056e-08
+ 1.7464305637279029e-05 6.1920998280720849e-08
+ 1.746930563727903e-05 6.1920998106097172e-08
+ 1.7474305637279031e-05 6.192099818075365e-08
+ 1.7479305637279039e-05 6.1920998159523113e-08
+ 1.7484305637279039e-05 6.1920998090574446e-08
+ 1.748930563727904e-05 6.1920998106857092e-08
+ 1.7494305637279041e-05 6.1920997901801401e-08
+ 1.7499305637279038e-05 6.1920997958312832e-08
+ 1.7504305637279039e-05 6.192099797666212e-08
+ 1.750930563727904e-05 6.1920998315546635e-08
+ 1.7514305637279041e-05 6.1920998171839382e-08
+ 1.7519305637279042e-05 6.1920998189133479e-08
+ 1.7524305637279039e-05 6.1920998234071886e-08
+ 1.752930563727904e-05 6.19209982857268e-08
+ 1.7534305637279041e-05 6.1920998064695353e-08
+ 1.7539305637279041e-05 6.1920998147445125e-08
+ 1.7544305637279049e-05 6.1920998187247613e-08
+ 1.754930563727905e-05 6.192099826064458e-08
+ 1.7554305637279051e-05 6.1920998037172393e-08
+ 1.7559305637279051e-05 6.1920998129078975e-08
+ 1.7564305637279049e-05 6.1920998161884628e-08
+ 1.756930563727905e-05 6.1920998206277982e-08
+ 1.757430563727905e-05 6.192099799522445e-08
+ 1.7579305637279051e-05 6.1920998069526021e-08
+ 1.7584305637279049e-05 6.1920998142627572e-08
+ 1.7589305637279049e-05 6.1920998228194787e-08
+ 1.759430563727905e-05 6.1920998226913676e-08
+ 1.7599305637279051e-05 6.1920998013561813e-08
+ 1.7604305637279059e-05 6.1920998083076881e-08
+ 1.7609305637279059e-05 6.1920998149232166e-08
+ 1.761430563727906e-05 6.1920998269382108e-08
+ 1.7619305637279061e-05 6.1920998265393483e-08
+ 1.7624305637279058e-05 6.1920998374707452e-08
+ 1.7629305637279059e-05 6.1920998139357985e-08
+ 1.763430563727906e-05 6.1920998173979676e-08
+ 1.7639305637279061e-05 6.1920998009006417e-08
+ 1.7644305637279062e-05 6.1920998064563189e-08
+ 1.7649305637279059e-05 6.1920998087270858e-08
+ 1.765430563727906e-05 6.1920998160280016e-08
+ 1.7659305637279061e-05 6.1920998268068996e-08
+ 1.7664305637279061e-05 6.1920998243964847e-08
+ 1.7669305637279069e-05 6.1920998065237679e-08
+ 1.767430563727907e-05 6.1920998171505744e-08
+ 1.7679305637279071e-05 6.1920998201417879e-08
+ 1.7684305637279071e-05 6.1920998346214124e-08
+ 1.7689305637279069e-05 6.1920998279258989e-08
+ 1.769430563727907e-05 6.1920998143146988e-08
+ 1.769930563727907e-05 6.1920998181471642e-08
+ 1.7704305637279071e-05 6.192099794207075e-08
+ 1.7709305637279069e-05 6.1920997864275684e-08
+ 1.7714305637279069e-05 6.1920997777005138e-08
+ 1.771930563727907e-05 6.1920997625610149e-08
+ 1.7724305637279071e-05 6.192099745338331e-08
+ 1.7729305637279079e-05 6.1920993245549336e-08
+ 1.7731402577844979e-05 6.192090672149911e-08
+ 1.77332231752692e-05 6.192090592679112e-08
+ 1.7735139351321361e-05 6.1921195088729476e-08
+ 1.7736665461916241e-05 6.1921063947012884e-08
+ 1.7738340781241651e-05 6.1920800433916971e-08
+ 1.773936973701751e-05 6.1921268341130828e-08
+ 1.7739748256697058e-05 6.192182949866507e-08
+ 1.7740300869783961e-05 6.1920914491786503e-08
+ 1.7740608696528379e-05 6.1925187006244033e-08
+ 1.7740853945336379e-05 6.1917775717069919e-08
+ 1.7741054548877661e-05 6.1827439950462201e-08
+ 1.7741263112024181e-05 6.1857541753658298e-08
+ 1.7741506004668658e-05 6.1982183115068586e-08
+ 1.7741662500474251e-05 6.1358565030307299e-08
+ 1.7741729395186731e-05 5.7459123489520763e-08
+ 1.774178371445798e-05 5.5562308272098088e-08
+ 1.7741827283906119e-05 5.9459456988436981e-08
+ 1.7741891839179491e-05 9.1117129011184434e-08
+ 1.7741957706761411e-05 1.3061078361676589e-07
+ 1.7742022897628391e-05 1.719146822160803e-07
+ 1.774205237656809e-05 3.2942116106983032e-07
+ 1.7742073010314381e-05 6.4771721177895101e-07
+ 1.7742094695996759e-05 7.8523535721535342e-07
+ 1.774212214444789e-05 2.725291005911474e-07
+ 1.774214536530816e-05 -7.5128121329380507e-07
+ 1.7742166363063229e-05 -2.620413141389872e-06
+ 1.7742185275752691e-05 -4.1758606388442418e-06
+ 1.774220043355142e-05 -4.9872470904479464e-06
+ 1.774221486832889e-05 -4.7184950816831474e-06
+ 1.7742224952436911e-05 -2.5768988854137408e-06
+ 1.7742237529409299e-05 -6.7033934750665124e-07
+ 1.774225409449367e-05 -4.9237742727559032e-07
+ 1.774227287367223e-05 -1.5702441822290919e-06
+ 1.7742297210626451e-05 -2.6274335119072139e-06
+ 1.7742322149320011e-05 -3.2862765998237409e-06
+ 1.774234809766717e-05 -3.3128678835654539e-06
+ 1.774237172833912e-05 -1.9736931977620438e-06
+ 1.77423947182618e-05 -5.2002011395227394e-07
+ 1.7742421726501591e-05 -5.5944075413113925e-07
+ 1.7742452147581969e-05 -1.893110903989283e-06
+ 1.774248042944892e-05 -3.054327118097679e-06
+ 1.7742502351975319e-05 -3.715726127947452e-06
+ 1.7742529733180871e-05 -3.6426793545993912e-06
+ 1.7742550326793749e-05 -7.5839507717320643e-07
+ 1.7742567873492002e-05 2.264980123118554e-06
+ 1.7742585043968719e-05 -6.3821252545796337e-06
+ 1.7742602842986899e-05 -5.3505661428744779e-05
+ 1.7742625369909121e-05 -0.00014677753052597071
+ 1.7742646358617091e-05 -0.00018821599506161309
+ 1.7742659319485991e-05 -0.00013785762186044629
+ 1.7742672797445611e-05 -2.094535541102879e-05
+ 1.7742688146223771e-05 0.00011213575919828519
+ 1.7742704260306299e-05 0.000183332387970456
+ 1.7742727430461709e-05 0.00018568563279504601
+ 1.7742750451462729e-05 0.0001476541786896222
+ 1.7742782045577281e-05 9.610294084355276e-05
+ 1.774281272647642e-05 6.7162844868049143e-05
+ 1.7742849579787089e-05 5.6848141798808977e-05
+ 1.7742888956289091e-05 6.268088969568952e-05
+ 1.7742940101150522e-05 8.5149344010247095e-05
+ 1.7743004223769161e-05 -0.00016538341821338711
+ 1.774305267487808e-05 -0.0018402332789375379
+ 1.7743098853771749e-05 -0.006362101211833184
+ 1.7743113922951489e-05 -0.0081469078715541553
+ 1.774312833442221e-05 -0.0083109414410431834
+ 1.7743137428853429e-05 -0.0063996474543369054
+ 1.7743147547817429e-05 -0.0006154657132067874
+ 1.7743158135932171e-05 0.01182776794245234
+ 1.7743171233776761e-05 0.039546236908696381
+ 1.774318362991723e-05 0.079855770096752918
+ 1.774320062923688e-05 0.1554743391009793
+ 1.7743212688459221e-05 0.220100511849633
+ 1.7743226383318392e-05 0.29972901740308572
+ 1.7743241073556851e-05 0.3879675550343798
+ 1.774325863110832e-05 0.49278183114690149
+ 1.774328128945736e-05 0.62225460714160752
+ 1.7743311473348791e-05 0.77793088098650331
+ 1.7743348469485272e-05 0.93279839953159072
+ 1.7743391079822398e-05 1.0566372586277071
+ 1.7743436125226e-05 1.1337106028359381
+ 1.7743477253215151e-05 1.1704476386527001
+ 1.774353001999325e-05 1.1920469794321029
+ 1.7743577770499249e-05 1.198937674996041
+ 1.7743644485678071e-05 1.201430870114242
+ 1.7743719133341569e-05 1.201293331636005
+ 1.774383995210498e-05 1.200525086690754
+ 1.7743971601687661e-05 1.200095003459438
+ 1.7744100883745969e-05 1.1999820752391599
+ 1.7744224036666289e-05 1.199978202996608
+ 1.7744343697225629e-05 1.199990366493169
+ 1.7744471722764832e-05 1.199997872258584
+ 1.7744590513069281e-05 1.2000000330172389
+ 1.7744714580568228e-05 1.200000304040344
+ 1.7744832312265199e-05 1.2000001401965421
+ 1.774495365384801e-05 1.200000011622584
+ 1.774507127169145e-05 1.1999999647864079
+ 1.7745191437257899e-05 1.1999999557320289
+ 1.774530937290851e-05 1.1999999577445259
+ 1.7745429025563841e-05 1.1999999617697019
+ 1.7745501712063161e-05 1.1999999740312031
+ 1.774554951395048e-05 1.199999994194586
+ 1.7745597678186809e-05 1.199999990593388
+ 1.7745663822265691e-05 1.1999999422482761
+ 1.7745722652934519e-05 1.1999999120168789
+ 1.7745752141168358e-05 1.1999998885575269
+ 1.7745775885550378e-05 1.1999998450488241
+ 1.7745797606348119e-05 1.1999997788182979
+ 1.7745820015308532e-05 1.199999694524557
+ 1.7745847593749571e-05 1.1999996607395611
+ 1.77458671450865e-05 1.19999989661901
+ 1.7745891896903229e-05 1.20000019301105
+ 1.7745929625282912e-05 1.2000003254293059
+ 1.77459810399058e-05 1.2000001929851161
+ 1.7746034782327161e-05 1.200000006536371
+ 1.7746107540000189e-05 1.199999883925368
+ 1.7746186917657119e-05 1.1999998717220981
+ 1.774627862216885e-05 1.199999913922571
+ 1.7746376536354501e-05 1.19999995525639
+ 1.7746488300874411e-05 1.1999999727173101
+ 1.7746629682200261e-05 1.199999970332785
+ 1.7746837869550619e-05 1.199999962239934
+ 1.774722884579316e-05 1.1999999587817241
+ 1.7747601791369701e-05 1.1999999597688671
+ 1.7748153730742929e-05 1.1999999605004379
+ 1.77487424843547e-05 1.1999999605488501
+ 1.774928896534343e-05 1.1999999604447411
+ 1.774977938369344e-05 1.199999960462476
+ 1.775013200918518e-05 1.199999960621754
+ 1.775053745961468e-05 1.1999999604476941
+ 1.775100148905233e-05 1.199999960452786
+ 1.7751591975422729e-05 1.1999999604763081
+ 1.7752264178456572e-05 1.199999960482194
+ 1.775327694372768e-05 1.199999960481944
+ 1.775472924681108e-05 1.199999960481041
+ 1.7757272459110279e-05 1.1999999604809239
+ 1.776122103187762e-05 1.199999960480937
+ 1.7766221031877621e-05 1.1999999604808771
+ 1.7771221031877618e-05 1.199999960480858
+ 1.7776221031877619e-05 1.199999960480862
+ 1.778122103187762e-05 1.199999960480866
+ 1.7786221031877621e-05 1.199999960480868
+ 1.7791221031877622e-05 1.199999960480868
+ 1.7796221031877629e-05 1.199999960480868
+ 1.780122103187763e-05 1.199999960480868
+ 1.7806221031877631e-05 1.199999960480868
+ 1.7811221031877632e-05 1.199999960480868
+ 1.7816221031877629e-05 1.199999960480868
+ 1.782122103187763e-05 1.199999960480868
+ 1.7826221031877631e-05 1.199999960480868
+ 1.7831221031877631e-05 1.199999960480868
+ 1.7836221031877629e-05 1.199999960480868
+ 1.784122103187763e-05 1.199999960480868
+ 1.784622103187763e-05 1.199999960480868
+ 1.7851221031877631e-05 1.199999960480868
+ 1.7856221031877639e-05 1.199999960480868
+ 1.786122103187764e-05 1.199999960480868
+ 1.786622103187764e-05 1.199999960480868
+ 1.7871221031877641e-05 1.199999960480868
+ 1.7876221031877639e-05 1.199999960480868
+ 1.7881221031877639e-05 1.199999960480868
+ 1.788622103187764e-05 1.199999960480868
+ 1.7891221031877641e-05 1.199999960480868
+ 1.7896221031877638e-05 1.199999960480868
+ 1.7901221031877639e-05 1.199999960480868
+ 1.790622103187764e-05 1.199999960480868
+ 1.7911221031877641e-05 1.199999960480868
+ 1.7916221031877642e-05 1.199999960480868
+ 1.7921221031877649e-05 1.199999960480868
+ 1.792622103187765e-05 1.199999960480868
+ 1.7931221031877651e-05 1.199999960480868
+ 1.7936221031877652e-05 1.199999960480868
+ 1.7941221031877649e-05 1.199999960480868
+ 1.794622103187765e-05 1.199999960480868
+ 1.7951221031877651e-05 1.199999960480868
+ 1.7956221031877651e-05 1.199999960480868
+ 1.7961221031877649e-05 1.199999960480868
+ 1.796622103187765e-05 1.199999960480868
+ 1.797122103187765e-05 1.199999960480868
+ 1.7976221031877651e-05 1.199999960480868
+ 1.7981221031877659e-05 1.199999960480868
+ 1.798622103187766e-05 1.1999999604808671
+ 1.799122103187766e-05 1.199999960480866
+ 1.7996221031877661e-05 1.1999999604808631
+ 1.8001221031877659e-05 1.1999999604808591
+ 1.8006221031877659e-05 1.19999996048085
+ 1.801122103187766e-05 1.199999960480834
+ 1.8016221031877661e-05 1.1999999604808029
+ 1.8021221031877658e-05 1.199999960480743
+ 1.8026221031877659e-05 1.1999999604806291
+ 1.803122103187766e-05 1.199999960480411
+ 1.8036221031877661e-05 1.1999999604800049
+ 1.8041221031877662e-05 1.1999999604792839
+ 1.8046221031877669e-05 1.1999999604780209
+ 1.805122103187767e-05 1.19999996047561
+ 1.8056221031877671e-05 1.1999999604683691
+ 1.8059668876928299e-05 1.19999996041861
+ 1.8061468507114291e-05 1.199999960150042
+ 1.8063437304804259e-05 1.199999960155391
+ 1.806504216303522e-05 1.1999999603823901
+ 1.8067081498085341e-05 1.1999999604566829
+ 1.8068622390131888e-05 1.199999960525469
+ 1.806917773051027e-05 1.199999961353033
+ 1.806967571456789e-05 1.1999999622028319
+ 1.8069952338637941e-05 1.1999999648990289
+ 1.807025410122205e-05 1.199999967332072
+ 1.8070484323182459e-05 1.1999999595203319
+ 1.8070702016275601e-05 1.1999999032085049
+ 1.8070913687534979e-05 1.1999998546815249
+ 1.8071159258991689e-05 1.1999997936730069
+ 1.807126088619262e-05 1.199999478160644
+ 1.8071319071986999e-05 1.199999004189003
+ 1.8071367177704599e-05 1.1999986179007649
+ 1.807142984156596e-05 1.199998130538025
+ 1.807149756267307e-05 1.199997956982098
+ 1.8071572843625061e-05 1.1999986685780151
+ 1.8071603814212209e-05 1.1999992918819931
+ 1.8071628378125491e-05 1.1999998504843601
+ 1.8071645414091699e-05 1.199999913280277
+ 1.807166443685398e-05 1.2000000815586009
+ 1.8071687757249789e-05 1.2000023149379899
+ 1.8071714723721339e-05 1.200007383649063
+ 1.8071739086639001e-05 1.2000105693036009
+ 1.8071759920853651e-05 1.2000103107066651
+ 1.807177685586601e-05 1.200008369006057
+ 1.8071794658788839e-05 1.20000501017913
+ 1.807181169121327e-05 1.2000017899381561
+ 1.8071827217993838e-05 1.199999743022881
+ 1.8071858271554989e-05 1.19999784030499
+ 1.807188649624523e-05 1.1999972522907401
+ 1.807191482513656e-05 1.1999970700438309
+ 1.8071939129457811e-05 1.199997682363259
+ 1.8071964511413581e-05 1.199999584059632
+ 1.8071993217238371e-05 1.200002583234234
+ 1.8072025426444671e-05 1.2000055279333159
+ 1.8072050118887741e-05 1.200007300257097
+ 1.8072066726311111e-05 1.200008585614019
+ 1.8072082431887101e-05 1.200010178798717
+ 1.807209652726513e-05 1.2000122240240769
+ 1.8072114471888839e-05 1.2000133545948339
+ 1.807212596962256e-05 1.2000126175499619
+ 1.8072139630023739e-05 1.2000107925695289
+ 1.8072161716291521e-05 1.2000070839973329
+ 1.8072187690357999e-05 1.199997435432971
+ 1.8072213053690008e-05 1.199955441003133
+ 1.8072234187657841e-05 1.1998866932031189
+ 1.80722623402943e-05 1.199757898229407
+ 1.807230194786796e-05 1.199442708873226
+ 1.8072322341445361e-05 1.199882543363145
+ 1.8072338591446201e-05 1.2017756093545131
+ 1.807235963196798e-05 1.2074463639728861
+ 1.8072381643391259e-05 1.215135234901997
+ 1.8072396098206439e-05 1.2126886012896849
+ 1.807240980396279e-05 1.1914675951653639
+ 1.807242716780151e-05 1.1312170532291561
+ 1.807244755674582e-05 1.0279818991925149
+ 1.8072468955184841e-05 0.90222028670500509
+ 1.8072488799487901e-05 0.78122364994505222
+ 1.8072506270180711e-05 0.67575140366277342
+ 1.807251873078129e-05 0.60222275317241691
+ 1.807253004336319e-05 0.53716097161696841
+ 1.8072543574298771e-05 0.4619675601757805
+ 1.8072555779584771e-05 0.39715413828797419
+ 1.807257028296387e-05 0.32493439638949018
+ 1.8072590535693682e-05 0.23562121198048019
+ 1.80726140035464e-05 0.15278657944183471
+ 1.8072636177468109e-05 0.095863892341387189
+ 1.8072653710036941e-05 0.064200522476841007
+ 1.8072669331566039e-05 0.044153557239108701
+ 1.8072686690140489e-05 0.02867344453254643
+ 1.807270838709327e-05 0.016264966580252789
+ 1.8072729156438759e-05 0.0092237701155947222
+ 1.8072755049637301e-05 0.0043252393207293119
+ 1.8072782101254141e-05 0.0018019866360502121
+ 1.807281712348886e-05 0.00040185660281731258
+ 1.8072857875507129e-05 -0.00010194873608090779
+ 1.807291459230671e-05 -0.00019055026810216311
+ 1.8072990765565661e-05 -0.0001056907882398611
+ 1.807308148626152e-05 -2.816623193335954e-05
+ 1.8073180625913509e-05 3.8653801111726589e-07
+ 1.8073310962952119e-05 4.5344580230469598e-06
+ 1.8073486634640761e-05 1.755705389068585e-06
+ 1.8073629279323672e-05 3.4275545135123851e-07
+ 1.807375435756821e-05 2.348294257608702e-08
+ 1.807387169719697e-05 1.5591992206189831e-08
+ 1.8073989335177971e-05 4.5505227649603258e-08
+ 1.807411724732552e-05 6.0594684883905614e-08
+ 1.80742369720631e-05 6.4344561904575396e-08
+ 1.8074362130722449e-05 6.6256751810940561e-08
+ 1.8074480728960159e-05 6.9140444386269184e-08
+ 1.807460263151586e-05 7.3524884836466682e-08
+ 1.8074720605812431e-05 8.4131602836486528e-08
+ 1.8074840987834229e-05 1.2458592540007229e-07
+ 1.807491950978326e-05 2.9871158682176748e-07
+ 1.8074970570779969e-05 5.8758181561200226e-07
+ 1.8075023680555871e-05 6.5738494595357918e-07
+ 1.8075089747637621e-05 2.5512205975120809e-07
+ 1.8075125316637308e-05 -1.2179787688330781e-07
+ 1.8075156525110299e-05 -5.1611513741916334e-07
+ 1.8075181424537102e-05 -9.5128459611212252e-07
+ 1.8075204698868532e-05 -1.456839873305714e-06
+ 1.8075226226853571e-05 -1.750846417419453e-06
+ 1.8075251965578771e-05 -1.61940397515626e-06
+ 1.8075272943473259e-05 -1.797667032748159e-06
+ 1.8075295767339038e-05 -8.8758747744799041e-07
+ 1.807533158174621e-05 8.5121512230400606e-07
+ 1.8075371981321561e-05 1.4378405468863589e-06
+ 1.8075427400822821e-05 8.8860756058867059e-07
+ 1.8075490984512831e-05 2.5147906309364702e-07
+ 1.807557315057145e-05 3.6695894318979002e-08
+ 1.8075668928397871e-05 -1.7962344473613171e-08
+ 1.8075774385776829e-05 -1.075696644774876e-08
+ 1.8075888720902489e-05 4.2496123108369033e-08
+ 1.8076015899847951e-05 7.3107578761786611e-08
+ 1.8076182092461441e-05 7.0981141711345814e-08
+ 1.8076430479848411e-05 6.1941396963405182e-08
+ 1.8076741246547189e-05 6.0690944259953319e-08
+ 1.8077098930690391e-05 6.1720933399634098e-08
+ 1.8077533208224691e-05 6.2032072889941908e-08
+ 1.8078061187063881e-05 6.2058898068818384e-08
+ 1.8078675557063261e-05 6.1587182371487335e-08
+ 1.807907134914476e-05 6.0290253143939429e-08
+ 1.807941314516015e-05 6.3047565362505994e-08
+ 1.807984526436647e-05 6.2222011230116736e-08
+ 1.8080309770184021e-05 6.1727132353126854e-08
+ 1.808085907101759e-05 6.1910347046499003e-08
+ 1.8081450936668101e-05 6.1922219131862176e-08
+ 1.8082271668152039e-05 6.1919141887901157e-08
+ 1.80834258226425e-05 6.1921756352677816e-08
+ 1.8085429383371741e-05 6.1921388428507821e-08
+ 1.8088472543309871e-05 6.1921012543103913e-08
+ 1.8093472543309869e-05 6.1920982189977635e-08
+ 1.809847254330987e-05 6.1920995062790709e-08
+ 1.810347254330987e-05 6.1920997682840155e-08
+ 1.8108472543309871e-05 6.1920998007956546e-08
+ 1.8113472543309869e-05 6.1920998201989864e-08
+ 1.811847254330987e-05 6.1920998075979142e-08
+ 1.812347254330987e-05 6.1920998111998199e-08
+ 1.8128472543309871e-05 6.1920998140433214e-08
+ 1.8133472543309879e-05 6.192099827169468e-08
+ 1.8138472543309879e-05 6.1920998092181678e-08
+ 1.814347254330988e-05 6.1920997831009391e-08
+ 1.8148472543309881e-05 6.1920998202915592e-08
+ 1.8153472543309878e-05 6.1920998209823238e-08
+ 1.8158472543309879e-05 6.1920998030195409e-08
+ 1.816347254330988e-05 6.1920998086924925e-08
+ 1.8168472543309881e-05 6.1920998130147812e-08
+ 1.8173472543309882e-05 6.1920998233856236e-08
+ 1.8178472543309879e-05 6.1920997970883238e-08
+ 1.818347254330988e-05 6.1920998021026503e-08
+ 1.8188472543309881e-05 6.1920998398591836e-08
+ 1.8193472543309881e-05 6.1920997925049742e-08
+ 1.8198472543309889e-05 6.1920998205558493e-08
+ 1.820347254330989e-05 6.1920998302715078e-08
+ 1.8208472543309891e-05 6.1920998080558361e-08
+ 1.8213472543309891e-05 6.1920998098646061e-08
+ 1.8218472543309889e-05 6.1920998238041783e-08
+ 1.822347254330989e-05 6.1920998021804635e-08
+ 1.822847254330989e-05 6.1920998264066249e-08
+ 1.8233472543309891e-05 6.1920998067323431e-08
+ 1.8238472543309889e-05 6.1920998148455608e-08
+ 1.8243472543309889e-05 6.1920997930991017e-08
+ 1.824847254330989e-05 6.1920998305064629e-08
+ 1.8253472543309891e-05 6.1920998062222744e-08
+ 1.8258472543309899e-05 6.1920998137594952e-08
+ 1.8263472543309899e-05 6.1920998156910824e-08
+ 1.82684725433099e-05 6.1920998278360102e-08
+ 1.8273472543309901e-05 6.1920998025220057e-08
+ 1.8278472543309898e-05 6.1920998127915668e-08
+ 1.8283472543309899e-05 6.1920998173371599e-08
+ 1.82884725433099e-05 6.1920998240296426e-08
+ 1.8293472543309901e-05 6.1920998023492891e-08
+ 1.8298472543309902e-05 6.1920998103439315e-08
+ 1.8303472543309899e-05 6.1920998129723766e-08
+ 1.83084725433099e-05 6.1920997916833999e-08
+ 1.8313472543309901e-05 6.1920998274771448e-08
+ 1.8318472543309901e-05 6.1920998341252232e-08
+ 1.8323472543309909e-05 6.1920998137929649e-08
+ 1.832847254330991e-05 6.1920998114352619e-08
+ 1.8333472543309911e-05 6.1920998247834927e-08
+ 1.8338472543309911e-05 6.1920998083567313e-08
+ 1.8343472543309909e-05 6.1920998146403486e-08
+ 1.834847254330991e-05 6.1920998152205609e-08
+ 1.835347254330991e-05 6.1920998156517549e-08
+ 1.8358472543309911e-05 6.1920998290080563e-08
+ 1.8363472543309909e-05 6.1920998064328151e-08
+ 1.8368472543309909e-05 6.192099808829778e-08
+ 1.837347254330991e-05 6.1920997852347634e-08
+ 1.8378472543309911e-05 6.1920997683904399e-08
+ 1.8383472543309919e-05 6.1920997330858512e-08
+ 1.8388472543309919e-05 6.1920993439358945e-08
+ 1.839057182636963e-05 6.1920907474942857e-08
+ 1.839239006812647e-05 6.1920904363414812e-08
+ 1.839431202026916e-05 6.1921195259824903e-08
+ 1.8395834939149299e-05 6.1921065435476592e-08
+ 1.8397509589530279e-05 6.1920799268037635e-08
+ 1.8398540510492428e-05 6.1921266724147552e-08
+ 1.839892056917853e-05 6.1921815552078229e-08
+ 1.8399475537551941e-05 6.1920920187007435e-08
+ 1.8399783846582661e-05 6.1925162290255545e-08
+ 1.840002921736412e-05 6.1918069972591577e-08
+ 1.8400229513278689e-05 6.182919084796678e-08
+ 1.8400438089183091e-05 6.185501284757269e-08
+ 1.840068151606104e-05 6.1983040659357425e-08
+ 1.8400840505880339e-05 6.1379994167409976e-08
+ 1.8400907963311439e-05 5.7468295937982448e-08
+ 1.8400962164907742e-05 5.5509190714269002e-08
+ 1.8401005793117992e-05 5.9498580382101268e-08
+ 1.8401070337394721e-05 9.1246951154995717e-08
+ 1.8401136174787869e-05 1.306994925355237e-07
+ 1.8401201217937741e-05 1.719794926308484e-07
+ 1.840123065867294e-05 3.2901402578303277e-07
+ 1.8401251304161971e-05 6.4685523702232667e-07
+ 1.8401272967480812e-05 7.8576326389016767e-07
+ 1.8401300395443552e-05 2.7465651161584991e-07
+ 1.8401323647775361e-05 -7.466399853074149e-07
+ 1.8401344648118349e-05 -2.6138605083112761e-06
+ 1.8401363538021838e-05 -4.1712863750046117e-06
+ 1.8401378713315799e-05 -4.9821949340947406e-06
+ 1.840139310747622e-05 -4.734521234187882e-06
+ 1.8401403174368571e-05 -2.597593339896171e-06
+ 1.840141574333912e-05 -6.7810348025745168e-07
+ 1.8401432223232302e-05 -4.8436667569235446e-07
+ 1.8401450998661189e-05 -1.5589723811190561e-06
+ 1.8401475287667369e-05 -2.6194516319651302e-06
+ 1.8401500208597621e-05 -3.2801239535326411e-06
+ 1.8401526136268409e-05 -3.3206320983891022e-06
+ 1.8401549914353809e-05 -1.9892487700157612e-06
+ 1.8401572873412061e-05 -5.2808525586736264e-07
+ 1.840159979093956e-05 -5.513907482608614e-07
+ 1.8401630313807369e-05 -1.883133099481899e-06
+ 1.8401658497049561e-05 -3.0429176105188821e-06
+ 1.8401680444243189e-05 -3.7083756841325241e-06
+ 1.8401707956482411e-05 -3.6557537872517699e-06
+ 1.840172877361965e-05 -7.5174827721703572e-07
+ 1.8401746405721239e-05 2.2620667162466779e-06
+ 1.8401763581719331e-05 -6.6707860991024048e-06
+ 1.8401781386141069e-05 -5.4269828951022318e-05
+ 1.8401803870869141e-05 -0.00014742118630876289
+ 1.840182501301899e-05 -0.00018791281559387839
+ 1.840183796010127e-05 -0.00013603139194190471
+ 1.84018514889698e-05 -1.788609261657555e-05
+ 1.840186693102195e-05 0.00011486523204383091
+ 1.840188308982426e-05 0.00018418584898150279
+ 1.8401906551836009e-05 0.00018482654792881001
+ 1.8401929534543648e-05 0.00014642458164624029
+ 1.8401961318201379e-05 9.4908234137419868e-05
+ 1.8401992028837188e-05 6.6614464164308548e-05
+ 1.840202904961894e-05 5.6818637179851779e-05
+ 1.8402068584643421e-05 6.3075355760581966e-05
+ 1.8402120126059369e-05 8.5751399059258185e-05
+ 1.8402184680898471e-05 -0.00019460879010378779
+ 1.8402232535180931e-05 -0.0019379581250129781
+ 1.840227920452627e-05 -0.0066182199325537086
+ 1.8402293489852031e-05 -0.0082520620255042768
+ 1.8402308023818841e-05 -0.0081321635719286585
+ 1.8402317327874299e-05 -0.0057420362696876844
+ 1.840232719937768e-05 0.00057932350795640054
+ 1.8402337699524859e-05 0.013825327650306959
+ 1.840235072621593e-05 0.042695190180947293
+ 1.8402363379313399e-05 0.085275383133820645
+ 1.8402377856550449e-05 0.15013942936846281
+ 1.8402389064246631e-05 0.20961953987863061
+ 1.8402402137741039e-05 0.28508470920443429
+ 1.84024164364598e-05 0.37081620662321491
+ 1.840243336101197e-05 0.47225122855216561
+ 1.8402455102734789e-05 0.59785424877427829
+ 1.840248393668582e-05 0.7501184935381513
+ 1.8402520145451119e-05 0.90866668446458565
+ 1.8402561280114801e-05 1.0375853794962819
+ 1.840262285973714e-05 1.145122308532271
+ 1.8402669533155339e-05 1.1805347160215911
+ 1.840272161487732e-05 1.196337117369028
+ 1.840277231991569e-05 1.200890817178661
+ 1.8402838676249231e-05 1.2017526397891261
+ 1.8402921053964361e-05 1.20110908888051
+ 1.8403054275583549e-05 1.200292275283936
+ 1.840320509205918e-05 1.1999895430696501
+ 1.8403341106799829e-05 1.199962303096147
+ 1.8403476752202901e-05 1.1999818383385561
+ 1.840359968565733e-05 1.199994897290303
+ 1.8403723353117469e-05 1.199999683052412
+ 1.8403841449413151e-05 1.200000473349675
+ 1.84039618275606e-05 1.200000287494472
+ 1.8404079777558791e-05 1.200000072769809
+ 1.840419964885604e-05 1.199999976898696
+ 1.8404318044856681e-05 1.199999954294092
+ 1.840443760624696e-05 1.199999954984492
+ 1.840455615294098e-05 1.1999999593597459
+ 1.840466593055698e-05 1.1999999665906369
+ 1.8404720225509259e-05 1.199999991189481
+ 1.8404767901743802e-05 1.199999997033186
+ 1.8404839622022501e-05 1.1999999475819081
+ 1.8404905230615709e-05 1.199999911398232
+ 1.8404935270136879e-05 1.1999998814236941
+ 1.8404958300071941e-05 1.199999830570454
+ 1.8404979401515281e-05 1.1999997608806201
+ 1.8405001794564969e-05 1.1999996759266589
+ 1.8405028556047701e-05 1.199999675010204
+ 1.840504809880398e-05 1.199999936088318
+ 1.8405072357642899e-05 1.2000002155978711
+ 1.8405116337335559e-05 1.2000003235180741
+ 1.840516389216662e-05 1.2000001757699881
+ 1.840522364015786e-05 1.199999978992748
+ 1.8405295701795478e-05 1.199999877118435
+ 1.8405369834609491e-05 1.199999874403368
+ 1.840545816081323e-05 1.199999916867887
+ 1.8405557429879491e-05 1.1999999572808671
+ 1.8405669195409191e-05 1.199999972952128
+ 1.8405814445600301e-05 1.1999999698325241
+ 1.8406024162014332e-05 1.1999999619483379
+ 1.8406421263013632e-05 1.1999999588209189
+ 1.8406795317758719e-05 1.199999959822202
+ 1.8407354935712899e-05 1.199999960509458
+ 1.8407948276578919e-05 1.1999999605447389
+ 1.8408492649097902e-05 1.1999999604393901
+ 1.840900685101513e-05 1.1999999604759519
+ 1.8409373171174249e-05 1.199999960612445
+ 1.8409788442166071e-05 1.199999960440953
+ 1.841026290880239e-05 1.1999999604550791
+ 1.8410859763724162e-05 1.1999999604780121
+ 1.8411567674618999e-05 1.199999960482578
+ 1.84126337385803e-05 1.199999960481785
+ 1.841421044781577e-05 1.1999999604809699
+ 1.8416926394983739e-05 1.1999999604809339
+ 1.842126330339482e-05 1.1999999604809271
+ 1.842626330339482e-05 1.1999999604808711
+ 1.8431263303394821e-05 1.199999960480858
+ 1.8436263303394829e-05 1.199999960480862
+ 1.8441263303394829e-05 1.199999960480866
+ 1.844626330339483e-05 1.1999999604808671
+ 1.8451263303394831e-05 1.199999960480868
+ 1.8456263303394829e-05 1.199999960480868
+ 1.8461263303394829e-05 1.199999960480868
+ 1.846626330339483e-05 1.199999960480868
+ 1.8471263303394831e-05 1.199999960480868
+ 1.8476263303394828e-05 1.199999960480868
+ 1.8481263303394829e-05 1.199999960480868
+ 1.848626330339483e-05 1.199999960480868
+ 1.8491263303394831e-05 1.199999960480868
+ 1.8496263303394832e-05 1.199999960480868
+ 1.8501263303394839e-05 1.199999960480868
+ 1.850626330339484e-05 1.199999960480868
+ 1.8511263303394841e-05 1.199999960480868
+ 1.8516263303394841e-05 1.199999960480868
+ 1.8521263303394839e-05 1.199999960480868
+ 1.852626330339484e-05 1.199999960480868
+ 1.853126330339484e-05 1.199999960480868
+ 1.8536263303394841e-05 1.199999960480868
+ 1.8541263303394839e-05 1.199999960480868
+ 1.854626330339484e-05 1.199999960480868
+ 1.855126330339484e-05 1.199999960480868
+ 1.8556263303394841e-05 1.199999960480868
+ 1.8561263303394849e-05 1.199999960480868
+ 1.8566263303394849e-05 1.199999960480868
+ 1.857126330339485e-05 1.199999960480868
+ 1.8576263303394851e-05 1.199999960480868
+ 1.8581263303394848e-05 1.199999960480868
+ 1.8586263303394849e-05 1.199999960480868
+ 1.859126330339485e-05 1.199999960480868
+ 1.8596263303394851e-05 1.199999960480868
+ 1.8601263303394852e-05 1.199999960480868
+ 1.8606263303394849e-05 1.199999960480868
+ 1.861126330339485e-05 1.199999960480868
+ 1.8616263303394851e-05 1.199999960480868
+ 1.8621263303394851e-05 1.199999960480868
+ 1.8626263303394859e-05 1.199999960480868
+ 1.863126330339486e-05 1.199999960480868
+ 1.8636263303394861e-05 1.199999960480868
+ 1.8641263303394861e-05 1.199999960480868
+ 1.8646263303394859e-05 1.1999999604808671
+ 1.865126330339486e-05 1.199999960480866
+ 1.865626330339486e-05 1.1999999604808631
+ 1.8661263303394861e-05 1.199999960480858
+ 1.8666263303394859e-05 1.199999960480848
+ 1.8671263303394859e-05 1.19999996048083
+ 1.867626330339486e-05 1.1999999604807949
+ 1.8681263303394861e-05 1.199999960480729
+ 1.8686263303394869e-05 1.1999999604806
+ 1.8691263303394869e-05 1.199999960480358
+ 1.869626330339487e-05 1.1999999604799081
+ 1.8701263303394871e-05 1.1999999604791141
+ 1.8706263303394868e-05 1.1999999604777181
+ 1.8711263303394869e-05 1.199999960474941
+ 1.871626330339487e-05 1.1999999604652209
+ 1.8718998695684951e-05 1.199999960397623
+ 1.872071330220775e-05 1.1999999601330871
+ 1.8722759341635741e-05 1.19999996017112
+ 1.8724336025630859e-05 1.199999960397689
+ 1.8726288182865382e-05 1.1999999604482641
+ 1.8727624482031542e-05 1.199999960516938
+ 1.8728178078991411e-05 1.1999999611285179
+ 1.8728770721736619e-05 1.1999999617082959
+ 1.8729080516328749e-05 1.199999964260406
+ 1.8729385838823361e-05 1.1999999669483881
+ 1.8729623874384831e-05 1.199999964470488
+ 1.872983410235881e-05 1.199999918469379
+ 1.8730048940791719e-05 1.1999998644454599
+ 1.873029152997822e-05 1.19999981957883
+ 1.873040939897961e-05 1.199999621056475
+ 1.873047216996661e-05 1.199999258507269
+ 1.8730528793192819e-05 1.1999988132974719
+ 1.8730575344166679e-05 1.1999984882385999
+ 1.8730641261049e-05 1.1999979972191701
+ 1.8730711963900119e-05 1.199998115342567
+ 1.8730793308094829e-05 1.1999992151411889
+ 1.8730817802861368e-05 1.199999734750705
+ 1.8730837247598479e-05 1.1999997510110321
+ 1.873085738343855e-05 1.200000379411817
+ 1.873088284862804e-05 1.2000035064264629
+ 1.873090706181932e-05 1.2000083837903011
+ 1.8730933951259902e-05 1.2000109104996941
+ 1.8730955006710169e-05 1.20000976051301
+ 1.8730973019515209e-05 1.200007002919276
+ 1.8730985585741389e-05 1.200004326288548
+ 1.8731001373759329e-05 1.200001408579662
+ 1.8731022748517429e-05 1.199999033665917
+ 1.8731051210487291e-05 1.1999977083869
+ 1.873108273097776e-05 1.199997144680941
+ 1.873111226017422e-05 1.1999971912423979
+ 1.87311459816634e-05 1.1999989205231381
+ 1.8731172082652311e-05 1.200001543259366
+ 1.8731200778626812e-05 1.200004508703491
+ 1.8731226464188349e-05 1.2000065859105431
+ 1.873124476523719e-05 1.2000079242939601
+ 1.8731260515946849e-05 1.2000092599901779
+ 1.8731276137360391e-05 1.200011178737838
+ 1.873128989778165e-05 1.2000129988310331
+ 1.8731305481817939e-05 1.2000131863491701
+ 1.873131684533746e-05 1.20001210164864
+ 1.8731331194695029e-05 1.2000099645323199
+ 1.8731355821997051e-05 1.2000055894285619
+ 1.8731378381276091e-05 1.199993930430362
+ 1.87314019502862e-05 1.199948622885282
+ 1.8731424476591569e-05 1.199871263019348
+ 1.8731453185808549e-05 1.199732707631695
+ 1.8731495819503531e-05 1.199472837497731
+ 1.8731514660799571e-05 1.2003612734027469
+ 1.873153161754562e-05 1.2031607373860289
+ 1.873155569070918e-05 1.2110371494731209
+ 1.8731576500479828e-05 1.214726680745138
+ 1.8731591658394869e-05 1.200208823799179
+ 1.873160839044162e-05 1.1522829488490831
+ 1.8731625985881641e-05 1.071454324787714
+ 1.873164356839532e-05 0.9726679137605837
+ 1.8731665222823309e-05 0.84220243669652473
+ 1.8731685920341031e-05 0.71663560603820742
+ 1.873170037824578e-05 0.63052401114607948
+ 1.8731711571327571e-05 0.56542506987379204
+ 1.873172761766563e-05 0.47532156306815831
+ 1.8731739373713161e-05 0.41224158720864978
+ 1.873175252175954e-05 0.34547782313369041
+ 1.873177267349947e-05 0.25354592606378618
+ 1.8731795774317431e-05 0.16760739843515349
+ 1.873181793201893e-05 0.106396757187248
+ 1.8731841247232679e-05 0.062474539656214793
+ 1.8731858455172251e-05 0.041109863024641743
+ 1.873187623010369e-05 0.026255714571495409
+ 1.8731898285909999e-05 0.014641928584349539
+ 1.8731918880027959e-05 0.0082963344443557126
+ 1.873194534538386e-05 0.0037874792204624129
+ 1.8731972727679869e-05 0.0015316233416083609
+ 1.8732009117670319e-05 0.00028141684998184851
+ 1.8732051231602839e-05 -0.0001338529853062
+ 1.873211115722594e-05 -0.00018194920608953299
+ 1.8732191895233319e-05 -8.9871979736045487e-05
+ 1.8732281090353989e-05 -2.2084509316852701e-05
+ 1.873238597467144e-05 2.201156409131296e-06
+ 1.8732518742436511e-05 4.2175869048776778e-06
+ 1.8732680711170919e-05 1.4332278434549259e-06
+ 1.8732818534783749e-05 2.4248206207529551e-07
+ 1.8732942813561928e-05 7.2163192654913243e-09
+ 1.8733061245280669e-05 1.860228279105933e-08
+ 1.8733179816942679e-05 4.8807435527355293e-08
+ 1.8733308150800431e-05 6.1684308648497891e-08
+ 1.8733428137141701e-05 6.4521487152542725e-08
+ 1.8733553199569092e-05 6.6276196008963872e-08
+ 1.873367178717376e-05 6.9214809375257721e-08
+ 1.8733793566272941e-05 7.3713365999200226e-08
+ 1.8733911535567759e-05 8.4695453450571772e-08
+ 1.873403186540132e-05 1.272769429859695e-07
+ 1.8734108466103778e-05 3.0840993726724411e-07
+ 1.8734159258392641e-05 5.9498341336554299e-07
+ 1.8734212828972989e-05 6.5124944049529097e-07
+ 1.873427866758087e-05 2.3968662917601609e-07
+ 1.8734314303859849e-05 -1.3904853459637429e-07
+ 1.873434495094754e-05 -5.3397323923303021e-07
+ 1.8734369610690589e-05 -9.7355059651082378e-07
+ 1.8734392769427249e-05 -1.477582024964507e-06
+ 1.873441423470461e-05 -1.752459213068275e-06
+ 1.8734443174026889e-05 -1.6242447543718121e-06
+ 1.8734464035047841e-05 -1.7262171857768621e-06
+ 1.8734487029697181e-05 -6.6890572605478205e-07
+ 1.8734527792168559e-05 1.103886281959095e-06
+ 1.873456735637461e-05 1.415263822630546e-06
+ 1.8734627500148899e-05 7.3159953933295058e-07
+ 1.873469228028513e-05 1.8190500606420701e-07
+ 1.873477311166897e-05 2.9461651791010301e-08
+ 1.873485834561665e-05 -1.7016660656875411e-08
+ 1.8734959622614011e-05 -5.2293622936355521e-09
+ 1.873507471003344e-05 4.7393081520774791e-08
+ 1.8735201747355221e-05 7.363988769708382e-08
+ 1.8735370795979319e-05 7.015141644014306e-08
+ 1.8735617334565489e-05 6.1763317895401977e-08
+ 1.873593047459996e-05 6.0752508621116677e-08
+ 1.8736285885836808e-05 6.1737660257514524e-08
+ 1.8736722228652109e-05 6.2029600929571833e-08
+ 1.8737247943972811e-05 6.2057981617268282e-08
+ 1.8737862908988259e-05 6.1586588944650975e-08
+ 1.8738258744117429e-05 6.0291070488872857e-08
+ 1.873860067003817e-05 6.3047941943953297e-08
+ 1.8739032777167141e-05 6.2221521982290737e-08
+ 1.8739497608789861e-05 6.1727100227865124e-08
+ 1.874004726971328e-05 6.1910414838475581e-08
+ 1.8740639172702732e-05 6.1922200726867905e-08
+ 1.874146039603182e-05 6.1919142547655716e-08
+ 1.8742614899104891e-05 6.1921759053143234e-08
+ 1.8744620409288151e-05 6.1921387824733683e-08
+ 1.8747665056969441e-05 6.1921012610304635e-08
+ 1.8752665056969439e-05 6.1920982048955027e-08
+ 1.875766505696944e-05 6.1920995053391806e-08
+ 1.876266505696944e-05 6.1920997454887707e-08
+ 1.8767665056969441e-05 6.1920998123353999e-08
+ 1.8772665056969439e-05 6.1920998179063938e-08
+ 1.8777665056969439e-05 6.1920998027597096e-08
+ 1.878266505696944e-05 6.1920998066907657e-08
+ 1.8787665056969441e-05 6.1920998096324238e-08
+ 1.8792665056969449e-05 6.1920997982224612e-08
+ 1.8797665056969449e-05 6.1920997957746458e-08
+ 1.880266505696945e-05 6.192099804134808e-08
+ 1.8807665056969451e-05 6.1920998391459316e-08
+ 1.8812665056969448e-05 6.1920998154961893e-08
+ 1.8817665056969449e-05 6.1920998259937797e-08
+ 1.882266505696945e-05 6.1920998033799641e-08
+ 1.8827665056969451e-05 6.1920998051867449e-08
+ 1.8832665056969452e-05 6.1920998115244055e-08
+ 1.8837665056969449e-05 6.192099821905783e-08
+ 1.884266505696945e-05 6.1920998042710507e-08
+ 1.8847665056969451e-05 6.1920998090677612e-08
+ 1.8852665056969451e-05 6.192099812085635e-08
+ 1.8857665056969459e-05 6.1920998166093878e-08
+ 1.886266505696946e-05 6.1920998023207692e-08
+ 1.8867665056969461e-05 6.1920998090424494e-08
+ 1.8872665056969461e-05 6.1920998060482714e-08
+ 1.8877665056969459e-05 6.1920998165291249e-08
+ 1.888266505696946e-05 6.1920998241573011e-08
+ 1.888766505696946e-05 6.1920997988678235e-08
+ 1.8892665056969461e-05 6.1920998078708044e-08
+ 1.8897665056969459e-05 6.1920998141624923e-08
+ 1.8902665056969459e-05 6.1920998178839752e-08
+ 1.890766505696946e-05 6.1920998026533329e-08
+ 1.8912665056969461e-05 6.1920998023192419e-08
+ 1.8917665056969469e-05 6.1920998132389405e-08
+ 1.8922665056969469e-05 6.1920997906027606e-08
+ 1.892766505696947e-05 6.1920998225342139e-08
+ 1.8932665056969471e-05 6.1920998261467896e-08
+ 1.8937665056969468e-05 6.1920998061670571e-08
+ 1.8942665056969469e-05 6.1920998203295724e-08
+ 1.894766505696947e-05 6.1920998205711105e-08
+ 1.8952665056969471e-05 6.1920998287603508e-08
+ 1.8957665056969472e-05 6.1920998267913499e-08
+ 1.8962665056969469e-05 6.1920998149998439e-08
+ 1.896766505696947e-05 6.1920998212388001e-08
+ 1.8972665056969471e-05 6.1920998195082337e-08
+ 1.8977665056969471e-05 6.1920998324122565e-08
+ 1.8982665056969479e-05 6.1920998067456336e-08
+ 1.898766505696948e-05 6.192099814232485e-08
+ 1.8992665056969481e-05 6.1920998160555686e-08
+ 1.8997665056969481e-05 6.1920998134414714e-08
+ 1.9002665056969479e-05 6.1920998153336689e-08
+ 1.900766505696948e-05 6.1920998024801345e-08
+ 1.901266505696948e-05 6.1920998100223369e-08
+ 1.9017665056969481e-05 6.1920997968775502e-08
+ 1.9022665056969479e-05 6.1920998135328702e-08
+ 1.9027665056969479e-05 6.1920998135975425e-08
+ 1.903266505696948e-05 6.1920997976150499e-08
+ 1.9037665056969481e-05 6.1920997705650434e-08
+ 1.9042665056969489e-05 6.1920997141770159e-08
+ 1.9047665056969489e-05 6.1920993342801013e-08
+ 1.9049762706836009e-05 6.1920907158287504e-08
+ 1.9051582585920801e-05 6.1920905179106694e-08
+ 1.9053500519994231e-05 6.1921195633070567e-08
+ 1.9055025651676519e-05 6.1921063904210006e-08
+ 1.905670075998764e-05 6.1920800688831642e-08
+ 1.9057730333411481e-05 6.192126746227713e-08
+ 1.9058109324244071e-05 6.1921825254412848e-08
+ 1.9058662645777221e-05 6.1920916596811357e-08
+ 1.9058970616367712e-05 6.1925177485231612e-08
+ 1.905921590184433e-05 6.1917867022634606e-08
+ 1.9059416408470681e-05 6.1827971339412816e-08
+ 1.9059624975717921e-05 6.1856769186246457e-08
+ 1.905986802784551e-05 6.1982454030734483e-08
+ 1.906002528442318e-05 6.1365234061383957e-08
+ 1.906009235138791e-05 5.746213437206374e-08
+ 1.9060146635798241e-05 5.5546353963751219e-08
+ 1.9060190222592801e-05 5.9470074651401192e-08
+ 1.9060254775324482e-05 9.1153898572707018e-08
+ 1.9060320633632841e-05 1.3063587465205009e-07
+ 1.9060385782855389e-05 1.7193205207258351e-07
+ 1.9060415251238441e-05 3.2930082110771001e-07
+ 1.9060435888348921e-05 6.4746479913725941e-07
+ 1.9060457567402639e-05 7.8539165038665246e-07
+ 1.9060485009925729e-05 2.731527622561868e-07
+ 1.9060508239972071e-05 -7.4992123711230426e-07
+ 1.906052923852433e-05 -2.618498252662686e-06
+ 1.9060548144571329e-05 -4.174526454363107e-06
+ 1.9060563307468491e-05 -4.9857716225422793e-06
+ 1.906057773034131e-05 -4.7231885492423393e-06
+ 1.9060587809379679e-05 -2.5829467395592511e-06
+ 1.9060600383968819e-05 -6.7260146327642882e-07
+ 1.9060616924070749e-05 -4.9002102049906534e-07
+ 1.9060635702062341e-05 -1.566944491913003e-06
+ 1.9060660024915341e-05 -2.6250941014479421e-06
+ 1.906068495803993e-05 -3.2844688177685188e-06
+ 1.9060710900116728e-05 -3.315181852710024e-06
+ 1.9060734573468561e-05 -1.978329126399009e-06
+ 1.9060757553883641e-05 -5.2241132521442699e-07
+ 1.9060784535026848e-05 -5.5700570123725706e-07
+ 1.906081498630076e-05 -1.890107800415371e-06
+ 1.9060843238705729e-05 -3.0509017938658738e-06
+ 1.906086516871908e-05 -3.7135241594373682e-06
+ 1.906089258915002e-05 -3.6466447489154961e-06
+ 1.90609132505507e-05 -7.5632313316265724e-07
+ 1.9060930822824981e-05 2.2642166672849849e-06
+ 1.9060947994585349e-05 -6.4680013688621589e-06
+ 1.9060965794910511e-05 -5.3733073327595971e-05
+ 1.9060988309086269e-05 -0.00014696929522869099
+ 1.9061009343649999e-05 -0.00018812955570761229
+ 1.9061022300322951e-05 -0.00013731712845940791
+ 1.9061035793086491e-05 -2.0037508948204912e-05
+ 1.90610511691157e-05 0.0001129484508028748
+ 1.9061067295965871e-05 0.000183589094410193
+ 1.9061090551841981e-05 0.00018543513964484589
+ 1.9061113560838649e-05 0.00014729293366839979
+ 1.906114521092502e-05 9.5749554003155872e-05
+ 1.906117590021377e-05 6.7000125798866877e-05
+ 1.9061212802646631e-05 5.6838247692942539e-05
+ 1.9061252225300849e-05 6.2795348412305921e-05
+ 1.90613034861528e-05 8.5333406061060608e-05
+ 1.9061367734900151e-05 -0.0001736809088820262
+ 1.906141600476451e-05 -0.001868067915948459
+ 1.9061462322088679e-05 -0.0064361557978754227
+ 1.9061477157249909e-05 -0.0081781265835435719
+ 1.9061491611870861e-05 -0.0082646979272388062
+ 1.9061500761979981e-05 -0.006223624430367094
+ 1.906151081003086e-05 -0.00028882982212712083
+ 1.9061521371256609e-05 0.01237619585380049
+ 1.9061534447555269e-05 0.040413335290177807
+ 1.9061546911481681e-05 0.081337410710217509
+ 1.906156312485229e-05 0.1535687916336744
+ 1.906157489805358e-05 0.21644978874121229
+ 1.9061588377549271e-05 0.29463828850442209
+ 1.9061602941618809e-05 0.38207396349969458
+ 1.9061620268801981e-05 0.48566512278634438
+ 1.906164261644085e-05 0.61386298740763146
+ 1.906167232806116e-05 0.76839535108750778
+ 1.9061709076294899e-05 0.9246810511486806
+ 1.906175112178617e-05 1.0501675141839419
+ 1.9061799561118031e-05 1.134685021018125
+ 1.906184157274007e-05 1.171739327089661
+ 1.9061894458474352e-05 1.19270963226069
+ 1.9061942439198949e-05 1.1992591650302751
+ 1.9062009014762601e-05 1.2014988260317001
+ 1.9062084289215661e-05 1.201279617887546
+ 1.9062206386835941e-05 1.200494162769054
+ 1.9062338524012809e-05 1.2000809182160941
+ 1.9062467804456889e-05 1.1999789133234411
+ 1.9062590797868829e-05 1.1999783136719311
+ 1.9062710343414791e-05 1.1999908451159951
+ 1.9062838195389471e-05 1.199998117890444
+ 1.906295695013562e-05 1.2000001075326221
+ 1.906308095698566e-05 1.200000309864071
+ 1.9063198700582271e-05 1.2000001336982149
+ 1.9063320023011279e-05 1.200000007151099
+ 1.9063437655250369e-05 1.1999999631714851
+ 1.9063557809200391e-05 1.19999995547228
+ 1.9063675752836409e-05 1.1999999578389871
+ 1.9063795398164169e-05 1.199999961971461
+ 1.9063866174596671e-05 1.199999974796671
+ 1.906391364587314e-05 1.1999999946110871
+ 1.906396205144883e-05 1.199999989730463
+ 1.906402779306426e-05 1.199999941181747
+ 1.9064083861166738e-05 1.199999912009144
+ 1.9064112819537599e-05 1.199999890445024
+ 1.9064137020049741e-05 1.199999849900353
+ 1.9064159095286521e-05 1.199999785317343
+ 1.9064181605191269e-05 1.19999970130186
+ 1.9064209518214751e-05 1.199999657626309
+ 1.906422992694978e-05 1.1999998912768031
+ 1.9064254623151809e-05 1.20000018830469
+ 1.9064290998411829e-05 1.2000003243017301
+ 1.9064343204045532e-05 1.2000001956022519
+ 1.9064395799172519e-05 1.2000000115802281
+ 1.9064468584856849e-05 1.1999998853890921
+ 1.906454953943889e-05 1.1999998713544231
+ 1.9064650353274851e-05 1.199999916456437
+ 1.906474368087735e-05 1.199999955392024
+ 1.9064861650879891e-05 1.199999973124168
+ 1.9064998527753079e-05 1.1999999702005839
+ 1.906522041650794e-05 1.1999999618356449
+ 1.9065618468334408e-05 1.199999958759582
+ 1.9065996635136311e-05 1.1999999598108071
+ 1.9066556486769521e-05 1.199999960515274
+ 1.9067154858192529e-05 1.199999960547312
+ 1.906769738146397e-05 1.199999960436626
+ 1.906823319141785e-05 1.1999999604865479
+ 1.9068613216105821e-05 1.1999999606031651
+ 1.906903897053602e-05 1.1999999604366389
+ 1.9069524909632321e-05 1.199999960457226
+ 1.907012915409375e-05 1.1999999604793361
+ 1.9070871913260381e-05 1.19999996048281
+ 1.9071991361881459e-05 1.1999999604816409
+ 1.907369387696177e-05 1.1999999604809251
+ 1.9076583350551859e-05 1.1999999604809399
+ 1.9081341100248919e-05 1.199999960480916
+ 1.908634110024892e-05 1.1999999604808671
+ 1.9091341100248921e-05 1.199999960480858
+ 1.9096341100248918e-05 1.199999960480864
+ 1.9101341100248919e-05 1.1999999604808671
+ 1.910634110024892e-05 1.199999960480868
+ 1.9111341100248921e-05 1.199999960480868
+ 1.9116341100248928e-05 1.199999960480868
+ 1.9121341100248929e-05 1.199999960480868
+ 1.912634110024893e-05 1.199999960480868
+ 1.9131341100248931e-05 1.199999960480868
+ 1.9136341100248932e-05 1.199999960480868
+ 1.9141341100248929e-05 1.199999960480868
+ 1.914634110024893e-05 1.199999960480868
+ 1.9151341100248931e-05 1.199999960480868
+ 1.9156341100248931e-05 1.199999960480868
+ 1.9161341100248929e-05 1.199999960480868
+ 1.916634110024893e-05 1.199999960480868
+ 1.917134110024893e-05 1.199999960480868
+ 1.9176341100248931e-05 1.199999960480868
+ 1.9181341100248939e-05 1.199999960480868
+ 1.918634110024894e-05 1.199999960480868
+ 1.919134110024894e-05 1.199999960480868
+ 1.9196341100248941e-05 1.199999960480868
+ 1.9201341100248939e-05 1.199999960480868
+ 1.9206341100248939e-05 1.199999960480868
+ 1.921134110024894e-05 1.199999960480868
+ 1.9216341100248941e-05 1.199999960480868
+ 1.9221341100248938e-05 1.199999960480868
+ 1.9226341100248939e-05 1.199999960480868
+ 1.923134110024894e-05 1.199999960480868
+ 1.9236341100248941e-05 1.199999960480868
+ 1.9241341100248948e-05 1.199999960480868
+ 1.9246341100248949e-05 1.199999960480868
+ 1.925134110024895e-05 1.199999960480868
+ 1.9256341100248951e-05 1.199999960480868
+ 1.9261341100248952e-05 1.199999960480868
+ 1.9266341100248949e-05 1.199999960480868
+ 1.927134110024895e-05 1.199999960480868
+ 1.9276341100248951e-05 1.199999960480868
+ 1.9281341100248951e-05 1.199999960480868
+ 1.9286341100248949e-05 1.199999960480868
+ 1.929134110024895e-05 1.199999960480868
+ 1.929634110024895e-05 1.199999960480868
+ 1.9301341100248951e-05 1.1999999604808671
+ 1.9306341100248959e-05 1.1999999604808671
+ 1.931134110024896e-05 1.1999999604808651
+ 1.931634110024896e-05 1.199999960480862
+ 1.9321341100248961e-05 1.1999999604808571
+ 1.9326341100248959e-05 1.199999960480846
+ 1.9331341100248959e-05 1.199999960480826
+ 1.933634110024896e-05 1.1999999604807861
+ 1.9341341100248961e-05 1.199999960480711
+ 1.9346341100248958e-05 1.199999960480568
+ 1.9351341100248959e-05 1.199999960480296
+ 1.935634110024896e-05 1.1999999604797971
+ 1.9361341100248961e-05 1.199999960478918
+ 1.9366341100248962e-05 1.199999960477367
+ 1.9371341100248969e-05 1.199999960474101
+ 1.937634110024897e-05 1.199999960460137
+ 1.9378666860692361e-05 1.1999999603490299
+ 1.938038699297689e-05 1.1999999600820279
+ 1.9382541475345439e-05 1.1999999602379181
+ 1.9383970617686089e-05 1.199999960482113
+ 1.9385701649968969e-05 1.19999996037975
+ 1.9386844667605561e-05 1.1999999605864771
+ 1.9387334593165961e-05 1.199999961144627
+ 1.9387988229259491e-05 1.199999961666524
+ 1.9388320407714871e-05 1.199999964633683
+ 1.938859833482155e-05 1.199999967768332
+ 1.9388819522040692e-05 1.199999962169124
+ 1.938902936821686e-05 1.199999912674903
+ 1.9389244084385699e-05 1.199999861884824
+ 1.938948591797605e-05 1.1999998133681991
+ 1.9389597812849269e-05 1.199999588516891
+ 1.938965995516127e-05 1.199999197294179
+ 1.9389713372687711e-05 1.199998765535951
+ 1.938976202282966e-05 1.199998416862329
+ 1.9389826463109599e-05 1.199997967195747
+ 1.938989773193661e-05 1.199998180857909
+ 1.938998138868775e-05 1.199999402706569
+ 1.9390005036713009e-05 1.1999997904244399
+ 1.9390023737616371e-05 1.199999690369715
+ 1.939004964817035e-05 1.2000016219198759
+ 1.9390077661849491e-05 1.2000065021424009
+ 1.9390102650680239e-05 1.200010347113974
+ 1.9390124128421038e-05 1.2000105491206661
+ 1.9390141354989839e-05 1.2000087539674771
+ 1.9390159733878138e-05 1.2000053474867249
+ 1.9390174973207e-05 1.2000023576411121
+ 1.9390191152142311e-05 1.200000063162171
+ 1.9390218761548151e-05 1.199998119514972
+ 1.9390248356566021e-05 1.1999973469167819
+ 1.9390275588399109e-05 1.199997067308618
+ 1.939029956227607e-05 1.1999974707360099
+ 1.939032493136814e-05 1.1999991315655549
+ 1.9390351925049641e-05 1.200001899668236
+ 1.9390382135863099e-05 1.200004853284814
+ 1.939040864292469e-05 1.200006843817133
+ 1.9390426388078019e-05 1.200008137604174
+ 1.9390442108418101e-05 1.200009539738095
+ 1.9390457182071791e-05 1.2000115356545911
+ 1.9390471320456539e-05 1.2000131728713981
+ 1.939048641885322e-05 1.2000130097637669
+ 1.9390501497041691e-05 1.200011296868478
+ 1.9390515991171251e-05 1.2000089464070209
+ 1.9390542060074831e-05 1.200003461239437
+ 1.9390566484242431e-05 1.199980514979355
+ 1.9390591176567639e-05 1.199916173990544
+ 1.9390617870299821e-05 1.1998077988131659
+ 1.9390651230233929e-05 1.1995858753427371
+ 1.9390681157367299e-05 1.1996319544132319
+ 1.9390697986309469e-05 1.2009100244631581
+ 1.9390715619205721e-05 1.2045833574626481
+ 1.9390737405482382e-05 1.2123684974337039
+ 1.939075477475762e-05 1.215454820707768
+ 1.9390769035532401e-05 1.202991341479551
+ 1.9390785388858101e-05 1.1580246766288309
+ 1.9390802560478031e-05 1.0806852811819909
+ 1.9390820157025979e-05 0.9826624619944675
+ 1.9390841531783239e-05 0.8541027006629337
+ 1.9390862063570501e-05 0.72932126016827414
+ 1.9390876704207541e-05 0.64183182836758168
+ 1.9390887912916398e-05 0.57637589516756027
+ 1.9390900944653811e-05 0.50246307303928328
+ 1.9390914284842539e-05 0.4298076862905193
+ 1.939092658143243e-05 0.36620557659160291
+ 1.9390948454750741e-05 0.26411153086664008
+ 1.9390970350661631e-05 0.17987843140538501
+ 1.9390993506307231e-05 0.11280692149705571
+ 1.9391021344603108e-05 0.059615861409713991
+ 1.9391039595796681e-05 0.037981315714568843
+ 1.9391057647617699e-05 0.023939264437235399
+ 1.9391079919987421e-05 0.013179039294709011
+ 1.939110049101422e-05 0.0074306845243127737
+ 1.939112750518046e-05 0.0033012593478222709
+ 1.939115539773821e-05 0.001281985996222303
+ 1.939119317589709e-05 0.00017768120285260441
+ 1.9391236906165541e-05 -0.00015812768174804879
+ 1.9391300245674719e-05 -0.00017033879944701859
+ 1.9391386311866859e-05 -7.4328001160344496e-05
+ 1.939147430325902e-05 -1.6643308524729029e-05
+ 1.9391585781142279e-05 3.4349621118434852e-06
+ 1.9391721541876599e-05 3.788579388595821e-06
+ 1.9391867843087921e-05 1.176399501699677e-06
+ 1.939199945295854e-05 1.6856067826396071e-07
+ 1.9392122543212678e-05 -4.5524127352882711e-09
+ 1.939224224399036e-05 2.1010233940250709e-08
+ 1.9392361965196142e-05 5.1307741375918382e-08
+ 1.9392490823808229e-05 6.2489087517426748e-08
+ 1.9392611157450511e-05 6.4675061784066938e-08
+ 1.9392736112838131e-05 6.6341509041071799e-08
+ 1.9392854700930172e-05 6.9339076081498804e-08
+ 1.9392976329759169e-05 7.3974292103630522e-08
+ 1.9393094297380169e-05 8.5470285662599476e-08
+ 1.9393214561632251e-05 1.3103996336030549e-07
+ 1.939328877735416e-05 3.2183589733675549e-07
+ 1.939333925795232e-05 6.0508007271155433e-07
+ 1.939339352774295e-05 6.417426330664924e-07
+ 1.9393459119533989e-05 2.1709491651319131e-07
+ 1.9393495328297261e-05 -1.68345142137234e-07
+ 1.9393524830731011e-05 -5.6348405315025396e-07
+ 1.9393548965989592e-05 -1.0090924802053329e-06
+ 1.939357187127992e-05 -1.508665069803061e-06
+ 1.9393593247379161e-05 -1.7541409194149021e-06
+ 1.939362168843271e-05 -1.626685740693988e-06
+ 1.9393641842839981e-05 -1.7317949788589421e-06
+ 1.9393664825434009e-05 -6.5848600756697387e-07
+ 1.939370728446068e-05 1.144987190144241e-06
+ 1.9393746287728222e-05 1.4133190489473459e-06
+ 1.939380797835e-05 7.0420619772407881e-07
+ 1.9393872121202481e-05 1.7453077617963221e-07
+ 1.9393951108901651e-05 3.0406626062733208e-08
+ 1.9394036304231479e-05 -1.6956054765410249e-08
+ 1.93941365381579e-05 -4.5083008841069551e-09
+ 1.9394252385123791e-05 4.8130964476334018e-08
+ 1.939437872706362e-05 7.3623274016887003e-08
+ 1.9394548432734889e-05 7.0029977759647134e-08
+ 1.9394793395281769e-05 6.1757773769779665e-08
+ 1.9395107183000299e-05 6.0759905709441732e-08
+ 1.939546086600936e-05 6.1735695000654674e-08
+ 1.9395897418702101e-05 6.2029964510562472e-08
+ 1.9396420754233069e-05 6.2057460010296439e-08
+ 1.9397039466535021e-05 6.159381230723699e-08
+ 1.9397435823293501e-05 6.0288689064699912e-08
+ 1.9397778884017559e-05 6.3040133088731605e-08
+ 1.939821225197307e-05 6.2227327711714339e-08
+ 1.9398676104328539e-05 6.1726443468100819e-08
+ 1.939922493020946e-05 6.1910020861757526e-08
+ 1.9399817147772352e-05 6.1922406479085349e-08
+ 1.9400638073677209e-05 6.1919171324078616e-08
+ 1.940179382989234e-05 6.192174670258893e-08
+ 1.9403798395931941e-05 6.1921386296692202e-08
+ 1.9406844242207671e-05 6.1921012711755082e-08
+ 1.9411844242207668e-05 6.1920982240962838e-08
+ 1.9416844242207669e-05 6.192099503626034e-08
+ 1.942184424220767e-05 6.192099755677951e-08
+ 1.9426844242207671e-05 6.1920998171208515e-08
+ 1.9431844242207672e-05 6.1920998058250755e-08
+ 1.9436844242207679e-05 6.1920998191517678e-08
+ 1.944184424220768e-05 6.1920998233765008e-08
+ 1.9446844242207681e-05 6.1920997984978355e-08
+ 1.9451844242207681e-05 6.1920998365167162e-08
+ 1.9456844242207679e-05 6.1920997948640271e-08
+ 1.946184424220768e-05 6.1920998217206507e-08
+ 1.9466844242207681e-05 6.1920998303856085e-08
+ 1.9471844242207681e-05 6.1920998088717022e-08
+ 1.9476844242207679e-05 6.1920998147830644e-08
+ 1.948184424220768e-05 6.1920998171602081e-08
+ 1.948684424220768e-05 6.1920998230869757e-08
+ 1.9491844242207681e-05 6.1920998042168326e-08
+ 1.9496844242207689e-05 6.1920998151620309e-08
+ 1.9501844242207689e-05 6.1920998180837837e-08
+ 1.950684424220769e-05 6.1920997996894878e-08
+ 1.9511844242207691e-05 6.1920998061442309e-08
+ 1.9516844242207688e-05 6.1920998100716143e-08
+ 1.9521844242207689e-05 6.1920998123930219e-08
+ 1.952684424220769e-05 6.1920998162090721e-08
+ 1.9531844242207691e-05 6.1920998310391036e-08
+ 1.9536844242207692e-05 6.1920998103491407e-08
+ 1.9541844242207689e-05 6.1920998149524564e-08
+ 1.954684424220769e-05 6.1920997908664313e-08
+ 1.9551844242207691e-05 6.1920998234073858e-08
+ 1.9556844242207691e-05 6.1920998064863714e-08
+ 1.9561844242207699e-05 6.1920998098175455e-08
+ 1.95668442422077e-05 6.192099810264362e-08
+ 1.9571844242207701e-05 6.1920998156223734e-08
+ 1.9576844242207701e-05 6.1920998251327191e-08
+ 1.9581844242207699e-05 6.1920998055755529e-08
+ 1.95868442422077e-05 6.1920998129607418e-08
+ 1.95918442422077e-05 6.19209981187873e-08
+ 1.9596844242207701e-05 6.1920998024591334e-08
+ 1.9601844242207699e-05 6.1920998216739103e-08
+ 1.9606844242207699e-05 6.1920998380484191e-08
+ 1.96118442422077e-05 6.1920998142754786e-08
+ 1.9616844242207701e-05 6.1920998225954716e-08
+ 1.9621844242207709e-05 6.1920997966117486e-08
+ 1.9626844242207709e-05 6.1920998094968906e-08
+ 1.963184424220771e-05 6.1920998103141927e-08
+ 1.9636844242207711e-05 6.1920998178839474e-08
+ 1.9641844242207708e-05 6.1920998260987046e-08
+ 1.9646844242207709e-05 6.1920998034554598e-08
+ 1.965184424220771e-05 6.1920998123476011e-08
+ 1.9656844242207711e-05 6.1920998179084452e-08
+ 1.9661844242207712e-05 6.192099829276567e-08
+ 1.9666844242207709e-05 6.1920998104599406e-08
+ 1.967184424220771e-05 6.1920998210813473e-08
+ 1.9676844242207711e-05 6.1920998049877596e-08
+ 1.9681844242207711e-05 6.1920998170465601e-08
+ 1.9686844242207719e-05 6.1920997799238377e-08
+ 1.969184424220772e-05 6.1920998031042085e-08
+ 1.9696844242207721e-05 6.1920997694972287e-08
+ 1.9701844242207721e-05 6.1920997058528155e-08
+ 1.9706844242207719e-05 6.1920993338767694e-08
+ 1.970894200338543e-05 6.1920907224567436e-08
+ 1.9710761770125619e-05 6.1920905469028231e-08
+ 1.9712679979386231e-05 6.1921195204875547e-08
+ 1.971420495842382e-05 6.1921063918596888e-08
+ 1.9715880034287471e-05 6.1920800164968618e-08
+ 1.971690970284701e-05 6.1921268010413855e-08
+ 1.9717288767213599e-05 6.1921823667703006e-08
+ 1.9717842200301751e-05 6.192091725605387e-08
+ 1.9718150193640209e-05 6.1925178119603147e-08
+ 1.971839548489195e-05 6.1917879259832118e-08
+ 1.971859597660946e-05 6.1828056355019216e-08
+ 1.9718804544481621e-05 6.1856647679954811e-08
+ 1.9719047621820291e-05 6.1982495340575697e-08
+ 1.9719204997353679e-05 6.1366267550307695e-08
+ 1.971927209120454e-05 5.7462584504584279e-08
+ 1.9719326370079219e-05 5.5543845020168038e-08
+ 1.971936995963244e-05 5.9471841007477372e-08
+ 1.9719434511900329e-05 9.1159867902929284e-08
+ 1.9719500368763949e-05 1.306399584561802e-07
+ 1.9719565511203152e-05 1.719349585329176e-07
+ 1.9719594977848079e-05 3.2928169772069582e-07
+ 1.971961561550173e-05 6.4742449750695924e-07
+ 1.9719637293503711e-05 7.8541646557118041e-07
+ 1.9719664735074252e-05 2.7325228323664312e-07
+ 1.9719687966589338e-05 -7.497041494969715e-07
+ 1.9719708965265769e-05 -2.6181921785387769e-06
+ 1.971972787025006e-05 -4.1743130213683421e-06
+ 1.9719743033963901e-05 -4.9855356047271464e-06
+ 1.9719757454935188e-05 -4.7239382750766089e-06
+ 1.9719767533165441e-05 -2.5839137326016049e-06
+ 1.9719780107376509e-05 -6.7296355758534995e-07
+ 1.9719796643489981e-05 -4.8964524095127098e-07
+ 1.971981542129776e-05 -1.5664172127533771e-06
+ 1.9719839741901861e-05 -2.6247205628213211e-06
+ 1.97198646741652e-05 -3.2841805123455169e-06
+ 1.9719890615256628e-05 -3.3155484451410489e-06
+ 1.9719914295465471e-05 -1.9790635519635468e-06
+ 1.9719937274397721e-05 -5.2279111551145581e-07
+ 1.971996425125278e-05 -5.5662268945723339e-07
+ 1.9719994707321179e-05 -1.889634275279829e-06
+ 1.9720022955063991e-05 -3.0503610548844151e-06
+ 1.9720044886253501e-05 -3.713176171653834e-06
+ 1.9720072312886311e-05 -3.6472675885453409e-06
+ 1.97200929849344e-05 -7.5599902633447013e-07
+ 1.9720110561231121e-05 2.264086934219262e-06
+ 1.9720127733223339e-05 -6.4815920543509301e-06
+ 1.9720145533776891e-05 -5.3769046392963059e-05
+ 1.9720168045951101e-05 -0.00014699960974232741
+ 1.9720189087755528e-05 -0.00018811558539559919
+ 1.9720202043772522e-05 -0.00013723138704741571
+ 1.9720215538905399e-05 -1.9893680146757929e-05
+ 1.972023091928481e-05 0.0001130769920931003
+ 1.972024704819691e-05 0.00018362949775067779
+ 1.9720270317721211e-05 0.00018539511013495081
+ 1.972029332486614e-05 0.00014723542143749889
+ 1.9720324983841261e-05 9.5693477727118722e-05
+ 1.972035567449286e-05 6.6974344034016701e-05
+ 1.97203925847522e-05 5.6836766875119697e-05
+ 1.9720432014786521e-05 6.2813680699526432e-05
+ 1.9720483294143869e-05 8.5362186730192303e-05
+ 1.9720547563037041e-05 -0.00017502365063707699
+ 1.972059580450373e-05 -0.0018725660990967809
+ 1.9720642144306869e-05 -0.0064480502965013906
+ 1.972065694247239e-05 -0.0081830899719226614
+ 1.9720671403435968e-05 -0.0082568821102459583
+ 1.9720680564097371e-05 -0.0061938208882665949
+ 1.9720690599953249e-05 -0.0002345528253506415
+ 1.9720701156418229e-05 0.01246624672223965
+ 1.9720714229563792e-05 0.040556119142196402
+ 1.9720726704527731e-05 0.081580846486920516
+ 1.972074279606559e-05 0.15328966771630981
+ 1.972075452649278e-05 0.2159106387633162
+ 1.972076797421556e-05 0.29388624499443861
+ 1.972078251903293e-05 0.38119879253332672
+ 1.972079981290354e-05 0.48461233452640312
+ 1.9720822114112451e-05 0.61261653806218508
+ 1.972085175596305e-05 0.76697457939462121
+ 1.9720888465600669e-05 0.92345871443506333
+ 1.972093043174206e-05 1.049197035517474
+ 1.9720979404008301e-05 1.1348738045493449
+ 1.9721021549929911e-05 1.1719561306228981
+ 1.9721074453548818e-05 1.192817860702438
+ 1.9721122473060989e-05 1.199310688946126
+ 1.9721189034126971e-05 1.2015094293754811
+ 1.9721264420010359e-05 1.201277014360173
+ 1.9721386749398199e-05 1.200488958929363
+ 1.972151897435339e-05 1.200078612952612
+ 1.9721648254632879e-05 1.1999784165509351
+ 1.9721771219339801e-05 1.199978342631205
+ 1.9721890744188979e-05 1.1999909266581541
+ 1.972201856502102e-05 1.199998158258434
+ 1.972213731339642e-05 1.200000119432064
+ 1.9722261309400742e-05 1.200000310630011
+ 1.9722379055159452e-05 1.200000132569172
+ 1.972250037417735e-05 1.200000006409834
+ 1.9722618009012321e-05 1.1999999629107281
+ 1.9722738160888051e-05 1.1999999554331959
+ 1.9722856105961409e-05 1.1999999578562559
+ 1.972297574998564e-05 1.1999999620074091
+ 1.9723046194660131e-05 1.1999999749371371
+ 1.9723093609430961e-05 1.1999999946879261
+ 1.9723142062805131e-05 1.199999989565347
+ 1.972320773347903e-05 1.1999999409787201
+ 1.9723263285719419e-05 1.1999999120038289
+ 1.9723292142712529e-05 1.199999890770872
+ 1.972331643059556e-05 1.199999850760388
+ 1.9723338573678829e-05 1.19999978647752
+ 1.972336110540901e-05 1.1999997025014979
+ 1.972338907858656e-05 1.1999996571700839
+ 1.9723409639317879e-05 1.1999998903321829
+ 1.9723434336978619e-05 1.2000001875585189
+ 1.972347048420489e-05 1.2000003240745041
+ 1.9723522835879521e-05 1.200000195976296
+ 1.9723575235442871e-05 1.2000000123886789
+ 1.9723648050892768e-05 1.199999885600608
+ 1.97237292588269e-05 1.199999871297474
+ 1.9723829633080229e-05 1.199999916230823
+ 1.972392321653665e-05 1.1999999553333811
+ 1.9724040797961241e-05 1.1999999730930579
+ 1.9724177869959981e-05 1.199999970218828
+ 1.9724398954498299e-05 1.1999999618649231
+ 1.972479770835508e-05 1.1999999587565799
+ 1.9725175071429161e-05 1.1999999598070039
+ 1.9725735428617081e-05 1.1999999605150811
+ 1.972633274145838e-05 1.1999999605475451
+ 1.972687553407796e-05 1.199999960436906
+ 1.9727409606765341e-05 1.1999999604857261
+ 1.9727788488522751e-05 1.199999960603912
+ 1.9728213349594259e-05 1.199999960436932
+ 1.9728698301291589e-05 1.1999999604570519
+ 1.9729301900949861e-05 1.199999960479236
+ 1.9730041748676069e-05 1.1999999604827949
+ 1.9731156693383991e-05 1.199999960481652
+ 1.973284853112029e-05 1.1999999604809279
+ 1.9735725746411179e-05 1.1999999604809399
+ 1.9740445453697231e-05 1.1999999604809171
+ 1.9745445453697229e-05 1.199999960480866
+ 1.975044545369723e-05 1.199999960480858
+ 1.975544545369723e-05 1.1999999604808631
+ 1.9760445453697231e-05 1.1999999604808671
+ 1.9765445453697239e-05 1.199999960480868
+ 1.9770445453697239e-05 1.1999999604808691
+ 1.977544545369724e-05 1.199999960480868
+ 1.9780445453697241e-05 1.199999960480868
+ 1.9785445453697238e-05 1.199999960480868
+ 1.9790445453697239e-05 1.199999960480868
+ 1.979544545369724e-05 1.199999960480868
+ 1.9800445453697241e-05 1.199999960480868
+ 1.9805445453697238e-05 1.199999960480868
+ 1.9810445453697239e-05 1.199999960480868
+ 1.981544545369724e-05 1.199999960480868
+ 1.9820445453697241e-05 1.199999960480868
+ 1.9825445453697242e-05 1.199999960480868
+ 1.9830445453697249e-05 1.199999960480868
+ 1.983544545369725e-05 1.199999960480868
+ 1.9840445453697251e-05 1.199999960480868
+ 1.9845445453697251e-05 1.199999960480868
+ 1.9850445453697249e-05 1.199999960480868
+ 1.985544545369725e-05 1.199999960480868
+ 1.986044545369725e-05 1.199999960480868
+ 1.9865445453697251e-05 1.199999960480868
+ 1.9870445453697249e-05 1.199999960480868
+ 1.9875445453697249e-05 1.199999960480868
+ 1.988044545369725e-05 1.199999960480868
+ 1.9885445453697251e-05 1.199999960480868
+ 1.9890445453697259e-05 1.199999960480868
+ 1.9895445453697259e-05 1.199999960480868
+ 1.990044545369726e-05 1.199999960480868
+ 1.9905445453697261e-05 1.199999960480868
+ 1.9910445453697258e-05 1.199999960480868
+ 1.9915445453697259e-05 1.199999960480868
+ 1.992044545369726e-05 1.199999960480868
+ 1.9925445453697261e-05 1.199999960480868
+ 1.9930445453697262e-05 1.199999960480868
+ 1.9935445453697259e-05 1.199999960480868
+ 1.994044545369726e-05 1.199999960480868
+ 1.9945445453697261e-05 1.199999960480868
+ 1.9950445453697261e-05 1.199999960480868
+ 1.9955445453697269e-05 1.199999960480868
+ 1.996044545369727e-05 1.1999999604808671
+ 1.9965445453697271e-05 1.199999960480866
+ 1.9970445453697271e-05 1.1999999604808651
+ 1.9975445453697269e-05 1.199999960480862
+ 1.998044545369727e-05 1.1999999604808571
+ 1.998544545369727e-05 1.199999960480846
+ 1.9990445453697271e-05 1.199999960480826
+ 1.9995445453697269e-05 1.1999999604807869
+ 2.0000445453697269e-05 1.199999960480713
+ 2.000544545369727e-05 1.1999999604805709
+ 2.0010445453697271e-05 1.1999999604803011
+ 2.0015445453697279e-05 1.1999999604798059
+ 2.0020445453697279e-05 1.1999999604789371
+ 2.002544545369728e-05 1.199999960477397
+ 2.0030445453697281e-05 1.1999999604741789
+ 2.0035445453697278e-05 1.199999960460671
+ 2.0037797883674019e-05 1.199999960354581
+ 2.0039511711281732e-05 1.1999999600855971
+ 2.0041665434552011e-05 1.199999960230917
+ 2.0043099523780189e-05 1.199999960475399
+ 2.004484091982058e-05 1.1999999603849829
+ 2.0046000584732432e-05 1.199999960574339
+ 2.0046501691143101e-05 1.199999961121939
+ 2.004715422513568e-05 1.1999999616406991
+ 2.0047485666814941e-05 1.199999964512624
+ 2.0047768290864491e-05 1.1999999675930599
+ 2.0047992665543131e-05 1.199999963043535
+ 2.004820183705338e-05 1.1999999150783121
+ 2.004841695758312e-05 1.1999998632490589
+ 2.0048658591419009e-05 1.1999998165408801
+ 2.0048773149718491e-05 1.1999996056716351
+ 2.0048835778276429e-05 1.1999992298054649
+ 2.0048890703824341e-05 1.1999987912437959
+ 2.0048938112763261e-05 1.199998456746338
+ 2.004900319579058e-05 1.1999979834173391
+ 2.004907413299888e-05 1.1999981421970729
+ 2.0049156414905209e-05 1.199999291652728
+ 2.0049180518315049e-05 1.1999997691630571
+ 2.004919955143101e-05 1.1999997045145141
+ 2.0049221737834651e-05 1.200000791431711
+ 2.004924847818301e-05 1.200004641021817
+ 2.0049272120268431e-05 1.2000092396859421
+ 2.0049295514263902e-05 1.2000108804133589
+ 2.0049315045020349e-05 1.200009585699807
+ 2.004933216748792e-05 1.2000069190813201
+ 2.0049344345416351e-05 1.200004326444799
+ 2.0049359489829551e-05 1.200001512541641
+ 2.0049380752608811e-05 1.1999991152098191
+ 2.0049408651020159e-05 1.199997781830602
+ 2.0049439318671811e-05 1.1999972042095519
+ 2.0049469780851831e-05 1.199997178229665
+ 2.0049502898305309e-05 1.199998750292361
+ 2.004952930516852e-05 1.2000013444454889
+ 2.0049557625862231e-05 1.200004301769185
+ 2.004958315678328e-05 1.2000064165195219
+ 2.0049601896117082e-05 1.200007777974901
+ 2.00496176191374e-05 1.200009069707711
+ 2.0049633453355061e-05 1.2000109105954131
+ 2.0049647186387951e-05 1.2000128275845821
+ 2.0049663312328791e-05 1.200013247319536
+ 2.004967287191009e-05 1.200012446033468
+ 2.0049687588319839e-05 1.2000103839849481
+ 2.0049711698803139e-05 1.2000062466177139
+ 2.0049737647795961e-05 1.199993468595953
+ 2.0049761234669179e-05 1.199948618570595
+ 2.0049782714370532e-05 1.1998753248402501
+ 2.0049811828266742e-05 1.1997359157040739
+ 2.004985334421624e-05 1.1994543112199241
+ 2.0049872309361751e-05 1.200210961882475
+ 2.0049889023694889e-05 1.202754122969637
+ 2.0049913429258102e-05 1.210475505614101
+ 2.0049936550612901e-05 1.2139735291283109
+ 2.0049952424490821e-05 1.196347506158993
+ 2.0049971797478671e-05 1.134975812961418
+ 2.0049989579617018e-05 1.048397723945095
+ 2.0050006822764199e-05 0.94936787506108333
+ 2.0050029194479631e-05 0.81405336583052257
+ 2.0050050281083621e-05 0.68674215651666415
+ 2.0050064346484331e-05 0.60368645135865973
+ 2.0050075954644991e-05 0.53691729342632344
+ 2.0050090065078719e-05 0.45858618797331357
+ 2.005010236082794e-05 0.39346971433978462
+ 2.0050117150472611e-05 0.32018364612727779
+ 2.0050137575440531e-05 0.2309271593780203
+ 2.0050161191648252e-05 0.14882088891404849
+ 2.0050183433495609e-05 0.092946827721017047
+ 2.0050200346731951e-05 0.063053133884274234
+ 2.005021595851091e-05 0.043352883554581452
+ 2.005023346185804e-05 0.028033070326148692
+ 2.005025503467057e-05 0.015944135873331721
+ 2.0050276046190141e-05 0.0089722368248322491
+ 2.0050301923123339e-05 0.0042011662702981824
+ 2.0050329305739849e-05 0.0017217695216188379
+ 2.0050364460000749e-05 0.00037062390276410652
+ 2.005040577092988e-05 -0.0001125178556462296
+ 2.0050462996977532e-05 -0.00018886918240019151
+ 2.005054057599428e-05 -0.00010145473043763959
+ 2.005063062767591e-05 -2.656397844662326e-05
+ 2.0050731453756101e-05 9.5272503643182605e-07
+ 2.005086219634238e-05 4.468645449510294e-06
+ 2.0051042217777049e-05 1.645051949825643e-06
+ 2.0051186389231321e-05 3.09583240071354e-07
+ 2.0051311603788248e-05 2.153322341570995e-08
+ 2.0051428469582088e-05 1.8308294736180169e-08
+ 2.005154570109273e-05 4.694172301098589e-08
+ 2.005167293288468e-05 6.0915788478861593e-08
+ 2.0051792511044571e-05 6.4469238460852041e-08
+ 2.0051917422442599e-05 6.6438770668078222e-08
+ 2.0052036065770528e-05 6.9416411231675859e-08
+ 2.005215789353941e-05 7.4026506369514788e-08
+ 2.0052275926831389e-05 8.5597137910173102e-08
+ 2.0052396268469461e-05 1.3168612971424671e-07
+ 2.005247010702102e-05 3.243366646779842e-07
+ 2.0052520537184409e-05 6.0716358103045011e-07
+ 2.005257493930908e-05 6.4002552387694894e-07
+ 2.0052640490340639e-05 2.126698943820945e-07
+ 2.0052676790334049e-05 -1.7418214381433661e-07
+ 2.0052706084284429e-05 -5.6974613744957607e-07
+ 2.0052730121409079e-05 -1.0167672698386161e-06
+ 2.0052752976089039e-05 -1.515456079084198e-06
+ 2.0052774332888859e-05 -1.7545979393095839e-06
+ 2.005280266585545e-05 -1.627953643051186e-06
+ 2.0052822669497829e-05 -1.733280789332034e-06
+ 2.0052845657831522e-05 -6.5598044519018754e-07
+ 2.005288849582606e-05 1.1541813022567829e-06
+ 2.005292738066284e-05 1.4130903332160379e-06
+ 2.0052989410493179e-05 6.9815832769017628e-07
+ 2.0053053416231371e-05 1.7290050025342491e-07
+ 2.0053131971969231e-05 3.0566477898707648e-08
+ 2.0053217166592092e-05 -1.7008902984186999e-08
+ 2.00533171417794e-05 -4.3587672692728258e-09
+ 2.0053433168048671e-05 4.831356444514213e-08
+ 2.0053559342502572e-05 7.3626658141565508e-08
+ 2.0053729218410251e-05 7.0001192299776105e-08
+ 2.0053973839146499e-05 6.1755143687837673e-08
+ 2.0054288572453169e-05 6.0760868873104087e-08
+ 2.0054642292556799e-05 6.1735831807918739e-08
+ 2.0055080096047799e-05 6.2030149435997271e-08
+ 2.0055603907411e-05 6.2057712976174581e-08
+ 2.005622117137256e-05 6.1589855123562653e-08
+ 2.005661729846839e-05 6.0290079759195738e-08
+ 2.0056959793130351e-05 6.3045586226281319e-08
+ 2.005739246048378e-05 6.222321732724036e-08
+ 2.0057857230657191e-05 6.1726818287059131e-08
+ 2.0058406938037599e-05 6.1910318871432372e-08
+ 2.0058999018457061e-05 6.1922268787828239e-08
+ 2.0059820665186631e-05 6.1919155382314045e-08
+ 2.0060976102640241e-05 6.1921755784123415e-08
+ 2.0062983408764922e-05 6.1921386738823019e-08
+ 2.0066030265355371e-05 6.1921012106149487e-08
+ 2.0071030265355372e-05 6.1920982385216043e-08
+ 2.0076030265355379e-05 6.1920994931253877e-08
+ 2.008103026535538e-05 6.1920997754478244e-08
+ 2.0086030265355381e-05 6.1920998038563777e-08
+ 2.0091030265355382e-05 6.1920998009207349e-08
+ 2.0096030265355379e-05 6.1920998086545123e-08
+ 2.010103026535538e-05 6.192099809608417e-08
+ 2.0106030265355381e-05 6.1920998212679486e-08
+ 2.0111030265355381e-05 6.1920997992323256e-08
+ 2.0116030265355379e-05 6.1920998060104024e-08
+ 2.012103026535538e-05 6.1920998163975475e-08
+ 2.012603026535538e-05 6.192099798564415e-08
+ 2.0131030265355381e-05 6.1920998253407861e-08
+ 2.0136030265355389e-05 6.1920998026293142e-08
+ 2.014103026535539e-05 6.1920998094514658e-08
+ 2.014603026535539e-05 6.1920998141206714e-08
+ 2.0151030265355391e-05 6.1920998232446204e-08
+ 2.0156030265355389e-05 6.1920998051006453e-08
+ 2.0161030265355389e-05 6.1920998079248636e-08
+ 2.016603026535539e-05 6.1920998182727236e-08
+ 2.0171030265355391e-05 6.1920997952696328e-08
+ 2.0176030265355388e-05 6.192099823775996e-08
+ 2.0181030265355389e-05 6.1920998104739709e-08
+ 2.018603026535539e-05 6.1920998136287358e-08
+ 2.0191030265355391e-05 6.1920998117186421e-08
+ 2.0196030265355392e-05 6.1920998218525708e-08
+ 2.0201030265355399e-05 6.1920998045549457e-08
+ 2.02060302653554e-05 6.1920998118565708e-08
+ 2.0211030265355401e-05 6.1920998107114207e-08
+ 2.0216030265355402e-05 6.1920998193883838e-08
+ 2.0221030265355399e-05 6.1920998259287845e-08
+ 2.02260302653554e-05 6.1920998103078002e-08
+ 2.0231030265355401e-05 6.1920998155464713e-08
+ 2.0236030265355401e-05 6.1920997937992419e-08
+ 2.0241030265355399e-05 6.19209980206271e-08
+ 2.02460302653554e-05 6.1920998295924534e-08
+ 2.02510302653554e-05 6.1920998102524003e-08
+ 2.0256030265355401e-05 6.1920998201099315e-08
+ 2.0261030265355409e-05 6.1920998015620169e-08
+ 2.026603026535541e-05 6.1920997997544089e-08
+ 2.027103026535541e-05 6.1920998126166731e-08
+ 2.0276030265355411e-05 6.1920998139110625e-08
+ 2.0281030265355409e-05 6.1920998171357063e-08
+ 2.0286030265355409e-05 6.1920998289366196e-08
+ 2.029103026535541e-05 6.1920998060317145e-08
+ 2.0296030265355411e-05 6.1920998090367757e-08
+ 2.0301030265355408e-05 6.1920998217076844e-08
+ 2.0306030265355409e-05 6.1920998224398928e-08
+ 2.031103026535541e-05 6.1920998063735055e-08
+ 2.0316030265355411e-05 6.1920998173770485e-08
+ 2.0321030265355412e-05 6.192099821610817e-08
+ 2.0326030265355419e-05 6.1920998157499816e-08
+ 2.033103026535542e-05 6.1920998083832143e-08
+ 2.0336030265355421e-05 6.1920998122255516e-08
+ 2.0341030265355422e-05 6.1920998211888106e-08
+ 2.0346030265355419e-05 6.1920998154653468e-08
+ 2.035103026535542e-05 6.1920997988384791e-08
+ 2.0356030265355421e-05 6.1920997796973225e-08
+ 2.0361030265355421e-05 6.192099716433828e-08
+ 2.0366030265355419e-05 6.1920993289961325e-08
+ 2.0368126669773099e-05 6.1920906700663343e-08
+ 2.0369947813140148e-05 6.1920906454774576e-08
+ 2.037186265511579e-05 6.1921195252073877e-08
+ 2.0373389513026101e-05 6.1921063164859365e-08
+ 2.0375064996868568e-05 6.1920800945420064e-08
+ 2.037609347249402e-05 6.1921268523490219e-08
+ 2.037647163300695e-05 6.1921830665320103e-08
+ 2.037702371330336e-05 6.192091567586605e-08
+ 2.0377331432592019e-05 6.1925192045733005e-08
+ 2.037757665383651e-05 6.1917706831992995e-08
+ 2.037777733287514e-05 6.18270360974754e-08
+ 2.0377985892792631e-05 6.1858129760653297e-08
+ 2.0378228666227142e-05 6.1981971561671841e-08
+ 2.037838458372739e-05 6.1353420458691232e-08
+ 2.037845134715083e-05 5.7456704250881883e-08
+ 2.0378505692278671e-05 5.5574270960371923e-08
+ 2.0378549248887959e-05 5.9452165399148552e-08
+ 2.0378613805591949e-05 9.109087512504054e-08
+ 2.037867968026465e-05 1.3059287716469721e-07
+ 2.0378744900772558e-05 1.7190290134540419e-07
+ 2.037877438708782e-05 3.2951042834569861e-07
+ 2.037879501840309e-05 6.4790299265150368e-07
+ 2.0378816709012462e-05 7.8511934156018023e-07
+ 2.0378844161780219e-05 2.7206979787537211e-07
+ 2.037886737589483e-05 -7.5228209792790961e-07
+ 2.0378888373041272e-05 -2.621819583944241e-06
+ 2.0378907290600031e-05 -4.1768392373678227e-06
+ 2.0378922444659848e-05 -4.9883306767054354e-06
+ 2.0378936888204001e-05 -4.7150416975829252e-06
+ 2.0378946976058371e-05 -2.572455839992839e-06
+ 2.037895955480672e-05 -6.6868156042319838e-07
+ 2.0378976138292102e-05 -4.941171862959218e-07
+ 2.0378994918394249e-05 -1.5726715395633169e-06
+ 2.0379019265758669e-05 -2.6291557177597639e-06
+ 2.037904420874618e-05 -3.2876096969087051e-06
+ 2.0379070161824541e-05 -3.311143375433928e-06
+ 2.03790937613567e-05 -1.970238581465713e-06
+ 2.0379116758526928e-05 -5.1824531996369621e-07
+ 2.0379143786990871e-05 -5.612747639800769e-07
+ 2.037917418564957e-05 -1.8953642899825309e-06
+ 2.0379202489509351e-05 -3.0568929178253311e-06
+ 2.037922440638928e-05 -3.717372915004681e-06
+ 2.0379251758282671e-05 -3.63968632568363e-06
+ 2.0379272300724232e-05 -7.5996965159371552e-07
+ 2.0379289828154571e-05 2.2654854893836029e-06
+ 2.037930699788239e-05 -6.3180341015559918e-06
+ 2.0379324796081929e-05 -5.333582300162394e-05
+ 2.0379347332629969e-05 -0.0001466341757223161
+ 2.0379368286999431e-05 -0.00018827843082514059
+ 2.0379381251057399e-05 -0.00013825952490192049
+ 2.0379394718158291e-05 -2.1621747836459779e-05
+ 2.0379410046864091e-05 0.00011152875461671651
+ 2.0379426151712049e-05 0.00018313925122023011
+ 2.0379449258474531e-05 0.0001858698284801242
+ 2.0379472288775711e-05 0.00014792134626173879
+ 2.0379503841337971e-05 9.6365589420928531e-05
+ 2.0379534516223999e-05 6.7284053006939673e-05
+ 2.0379571333246351e-05 5.6856117269939608e-05
+ 2.0379610675841969e-05 6.2597002498342987e-05
+ 2.0379661735191649e-05 8.5009730435561711e-05
+ 2.0379725764985391e-05 -0.0001593957976259372
+ 2.037977435334677e-05 -0.0018201094051649
+ 2.037982043295345e-05 -0.0063081251849096392
+ 2.0379835676879681e-05 -0.00812386236415172
+ 2.0379850052908071e-05 -0.0083421351860524587
+ 2.0379859204768899e-05 -0.0064838035318485754
+ 2.037986931544934e-05 -0.00081075384207860779
+ 2.037987988113239e-05 0.011431002873898271
+ 2.0379893013959251e-05 0.038964316261420197
+ 2.0379905339228189e-05 0.078765442580250949
+ 2.0379924691072738e-05 0.16563286958380399
+ 2.037993812492799e-05 0.2388606227472056
+ 2.0379953698187069e-05 0.33038007558377108
+ 2.0379968540316209e-05 0.41963505518620908
+ 2.0379988131557541e-05 0.53536397481291131
+ 2.038001194134301e-05 0.66807296456291321
+ 2.0380045423917989e-05 0.83180355561973529
+ 2.0380083048373538e-05 0.97469432659225685
+ 2.0380130591839081e-05 1.092037705338067
+ 2.0380165824093631e-05 1.1419163532758889
+ 2.03802050896795e-05 1.172964049045355
+ 2.0380256621106399e-05 1.192168603617447
+ 2.0380305877733422e-05 1.198853065586754
+ 2.0380374915129549e-05 1.201309791334449
+ 2.0380453566067112e-05 1.2012045420365089
+ 2.0380579617085822e-05 1.200483287849569
+ 2.0380712823524719e-05 1.2000886839834739
+ 2.038084181876297e-05 1.1999851098084811
+ 2.038096424971017e-05 1.1999806462307681
+ 2.0381083469922499e-05 1.199991284178997
+ 2.0381210713106852e-05 1.1999980067666529
+ 2.0381329396702009e-05 1.199999996639372
+ 2.0381453168299202e-05 1.2000002640700189
+ 2.0381570974007051e-05 1.2000001230668651
+ 2.0381692206762291e-05 1.2000000078538831
+ 2.0381809900037999e-05 1.199999964977293
+ 2.038192999939237e-05 1.1999999564106101
+ 2.038204797924772e-05 1.199999958192854
+ 2.0382167592390939e-05 1.199999962523381
+ 2.0382231992990521e-05 1.1999999778745409
+ 2.0382278454050141e-05 1.1999999962612149
+ 2.0382328210549449e-05 1.1999999853911809
+ 2.038239257951067e-05 1.199999936133374
+ 2.038243649019989e-05 1.199999911570985
+ 2.0382463249442e-05 1.199999896250012
+ 2.0382489451011841e-05 1.19999986651608
+ 2.0382513128749912e-05 1.1999998082440271
+ 2.038253624887195e-05 1.199999724606132
+ 2.038256537011347e-05 1.1999996530115531
+ 2.0382589008811891e-05 1.199999874739776
+ 2.0382614207102078e-05 1.200000178897225
+ 2.038264679266035e-05 1.2000003194083819
+ 2.038269605551874e-05 1.2000002130865379
+ 2.038274790498215e-05 1.2000000274340969
+ 2.0382817667794938e-05 1.199999893962935
+ 2.0382907927770729e-05 1.199999870183069
+ 2.0382995181189181e-05 1.199999909570302
+ 2.038309743894153e-05 1.1999999537602271
+ 2.0383203639174209e-05 1.1999999720026631
+ 2.03833474537953e-05 1.1999999707104989
+ 2.0383546173320649e-05 1.199999962725022
+ 2.038394305408919e-05 1.199999958733706
+ 2.038430786460573e-05 1.1999999597027049
+ 2.038486389041951e-05 1.1999999604950271
+ 2.0385441844081859e-05 1.1999999605531679
+ 2.038599296892403e-05 1.1999999604489691
+ 2.0386468311643531e-05 1.1999999604528919
+ 2.0386813553533508e-05 1.19999996062667
+ 2.038721430656724e-05 1.1999999604534251
+ 2.038767348971319e-05 1.1999999604514131
+ 2.038826131588773e-05 1.199999960475076
+ 2.0388912603127991e-05 1.199999960481875
+ 2.038989505422079e-05 1.199999960482043
+ 2.0391276749864611e-05 1.1999999604810989
+ 2.039372441463494e-05 1.1999999604809179
+ 2.0397464558322679e-05 1.199999960480941
+ 2.040246455832268e-05 1.1999999604808811
+ 2.0407464558322681e-05 1.199999960480858
+ 2.0412464558322682e-05 1.1999999604808611
+ 2.0417464558322679e-05 1.199999960480866
+ 2.042246455832268e-05 1.199999960480868
+ 2.0427464558322681e-05 1.199999960480868
+ 2.0432464558322681e-05 1.199999960480868
+ 2.0437464558322679e-05 1.199999960480868
+ 2.044246455832268e-05 1.199999960480868
+ 2.044746455832268e-05 1.199999960480868
+ 2.0452464558322681e-05 1.199999960480868
+ 2.0457464558322689e-05 1.199999960480868
+ 2.046246455832269e-05 1.199999960480868
+ 2.046746455832269e-05 1.199999960480868
+ 2.0472464558322691e-05 1.199999960480868
+ 2.0477464558322689e-05 1.199999960480868
+ 2.0482464558322689e-05 1.199999960480868
+ 2.048746455832269e-05 1.199999960480868
+ 2.0492464558322691e-05 1.199999960480868
+ 2.0497464558322688e-05 1.199999960480868
+ 2.0502464558322689e-05 1.199999960480868
+ 2.050746455832269e-05 1.199999960480868
+ 2.0512464558322691e-05 1.199999960480868
+ 2.0517464558322698e-05 1.199999960480868
+ 2.0522464558322699e-05 1.199999960480868
+ 2.05274645583227e-05 1.199999960480868
+ 2.0532464558322701e-05 1.199999960480868
+ 2.0537464558322702e-05 1.199999960480868
+ 2.0542464558322699e-05 1.199999960480868
+ 2.05474645583227e-05 1.199999960480868
+ 2.0552464558322701e-05 1.199999960480868
+ 2.0557464558322701e-05 1.199999960480868
+ 2.0562464558322699e-05 1.199999960480868
+ 2.05674645583227e-05 1.199999960480868
+ 2.05724645583227e-05 1.199999960480868
+ 2.0577464558322701e-05 1.199999960480868
+ 2.0582464558322709e-05 1.199999960480868
+ 2.058746455832271e-05 1.199999960480868
+ 2.059246455832271e-05 1.199999960480868
+ 2.0597464558322711e-05 1.199999960480868
+ 2.0602464558322709e-05 1.199999960480868
+ 2.0607464558322709e-05 1.199999960480868
+ 2.061246455832271e-05 1.199999960480868
+ 2.0617464558322711e-05 1.199999960480868
+ 2.0622464558322708e-05 1.1999999604808671
+ 2.0627464558322709e-05 1.199999960480866
+ 2.063246455832271e-05 1.1999999604808631
+ 2.0637464558322711e-05 1.19999996048086
+ 2.0642464558322718e-05 1.1999999604808509
+ 2.0647464558322719e-05 1.199999960480836
+ 2.065246455832272e-05 1.1999999604808069
+ 2.0657464558322721e-05 1.199999960480751
+ 2.0662464558322722e-05 1.1999999604806431
+ 2.0667464558322719e-05 1.1999999604804381
+ 2.067246455832272e-05 1.199999960480056
+ 2.0677464558322721e-05 1.1999999604793721
+ 2.0682464558322721e-05 1.199999960478175
+ 2.0687464558322719e-05 1.1999999604759339
+ 2.069246455832272e-05 1.1999999604696681
+ 2.069654330993509e-05 1.1999999604217459
+ 2.0698404571012451e-05 1.199999960124621
+ 2.070037033013163e-05 1.1999999601797591
+ 2.0701849075208631e-05 1.199999960417454
+ 2.0703754657655439e-05 1.199999960426043
+ 2.0705031521498091e-05 1.1999999605098211
+ 2.0705602037667951e-05 1.199999961029409
+ 2.0706229499525379e-05 1.1999999615428121
+ 2.0706551379367672e-05 1.1999999639069281
+ 2.070686499565191e-05 1.199999966539997
+ 2.070711044006119e-05 1.1999999660788481
+ 2.070732080310163e-05 1.1999999262091161
+ 2.0707537080976071e-05 1.19999986946087
+ 2.0707781754178078e-05 1.1999998275170589
+ 2.0707914064473899e-05 1.199999655916421
+ 2.0707980642066709e-05 1.199999297111179
+ 2.0708038362968911e-05 1.1999988433293951
+ 2.0708083739171879e-05 1.199998524459708
+ 2.070815148129325e-05 1.199998012927908
+ 2.0708221336800741e-05 1.199998089928179
+ 2.070830245569129e-05 1.199999143213726
+ 2.0708327539143671e-05 1.1999996932137831
+ 2.070834748699842e-05 1.1999998012019271
+ 2.070836619126893e-05 1.20000010338422
+ 2.0708390834314459e-05 1.200002693933222
+ 2.0708417887233551e-05 1.200007890981456
+ 2.070844241999111e-05 1.2000107306930801
+ 2.0708463277001389e-05 1.2000101307899149
+ 2.0708480627986309e-05 1.2000078995710231
+ 2.0708495084145909e-05 1.2000049779860029
+ 2.0708510929502271e-05 1.2000019267055051
+ 2.0708528468425859e-05 1.199999658551641
+ 2.0708555087934641e-05 1.1999980212679719
+ 2.0708584928585361e-05 1.1999973238249231
+ 2.070861292463672e-05 1.1999970860723721
+ 2.0708637120791091e-05 1.199997605386611
+ 2.0708662532956251e-05 1.1999994135682019
+ 2.070869271213106e-05 1.2000025201324049
+ 2.070872311540087e-05 1.200005350461756
+ 2.07087475061633e-05 1.200007137049989
+ 2.070876406587576e-05 1.2000083906849239
+ 2.0708779708357801e-05 1.2000098818393441
+ 2.0708794292263491e-05 1.2000119292969951
+ 2.0708809653111099e-05 1.200013328544518
+ 2.0708822122523019e-05 1.200012923082449
+ 2.0708835893532538e-05 1.200011295765437
+ 2.0708853240546141e-05 1.200008488351737
+ 2.0708881431224222e-05 1.2000012613040889
+ 2.0708909174058629e-05 1.1999646052469941
+ 2.0708933819899271e-05 1.199888829355739
+ 2.0708960460514261e-05 1.1997685307406749
+ 2.0708999110790519e-05 1.1994582781385359
+ 2.0709020635263359e-05 1.199808915887641
+ 2.0709036732759759e-05 1.201502756140993
+ 2.0709056488784951e-05 1.2064808799721509
+ 2.0709077946097809e-05 1.214417185663059
+ 2.0709093100785281e-05 1.214466602111008
+ 2.070910688207731e-05 1.197412319179652
+ 2.0709124904220679e-05 1.139449284842261
+ 2.0709145175051289e-05 1.039492042220538
+ 2.070916421741228e-05 0.9285976929848101
+ 2.0709185347593171e-05 0.80006639155269799
+ 2.070920549716332e-05 0.67841677537487033
+ 2.0709219077858069e-05 0.59836093572164228
+ 2.0709230732384111e-05 0.53148034152354939
+ 2.0709244538048679e-05 0.45503612671388038
+ 2.0709257555019061e-05 0.38641152566381509
+ 2.0709272530223111e-05 0.31284719905946512
+ 2.07092928770744e-05 0.22506661686552351
+ 2.0709316772482981e-05 0.14363523582157661
+ 2.0709339015145391e-05 0.089336419797339209
+ 2.0709355191777199e-05 0.061539894023768492
+ 2.0709371000235481e-05 0.042074162593335032
+ 2.0709388834745829e-05 0.02694156378158824
+ 2.0709410228746759e-05 0.015372752092341589
+ 2.070943164174941e-05 0.0085362432675528573
+ 2.0709457486308979e-05 0.0039859403291308106
+ 2.070948542683556e-05 0.0015869963407844881
+ 2.0709520825076569e-05 0.00031875997686825789
+ 2.0709563121123649e-05 -0.00012892442937759271
+ 2.0709621291124641e-05 -0.0001853076015580592
+ 2.0709701416359481e-05 -9.407233206337978e-05
+ 2.07097903942036e-05 -2.386380831438965e-05
+ 2.0709894175904149e-05 1.8155875101167911e-06
+ 2.071002560215364e-05 4.3279993061271792e-06
+ 2.0710191550554691e-05 1.5155492793340819e-06
+ 2.0710330854701292e-05 2.6662538137927782e-07
+ 2.0710455439594641e-05 1.0858703734854691e-08
+ 2.0710573571949861e-05 1.777267006437605e-08
+ 2.0710691864697349e-05 4.8003693539381391e-08
+ 2.071082007754323e-05 6.1441426884766635e-08
+ 2.071093997569229e-05 6.4526101893728591e-08
+ 2.0711065067809101e-05 6.6336104071274367e-08
+ 2.0711183652650249e-05 6.9280704375316879e-08
+ 2.0711305470644672e-05 7.3811376098882744e-08
+ 2.0711423438843392e-05 8.4984000886572632e-08
+ 2.0711543787081149e-05 1.286732905570626e-07
+ 2.0711619473734921e-05 3.1348792878137422e-07
+ 2.0711670147486679e-05 5.9887022686391854e-07
+ 2.0711723978530929e-05 6.4773081559516329e-07
+ 2.07117897161801e-05 2.3112870278188969e-07
+ 2.0711825579757981e-05 -1.5016440290653629e-07
+ 2.07118557755668e-05 -5.4495820198733672e-07
+ 2.071188023066081e-05 -9.8673755502058733e-07
+ 2.0711903292922159e-05 -1.489164549670505e-06
+ 2.0711924724646339e-05 -1.7533150841144311e-06
+ 2.0711953480440841e-05 -1.6248006834384159e-06
+ 2.07119740790747e-05 -1.7283541987324681e-06
+ 2.0711997060771191e-05 -6.6555151435795137e-07
+ 2.071203843132492e-05 1.118699917477579e-06
+ 2.071207778515809e-05 1.4145835580179851e-06
+ 2.071213848646154e-05 7.2188592668073836e-07
+ 2.071220302578788e-05 1.7935689125456279e-07
+ 2.071228319509521e-05 2.9862825097434003e-08
+ 2.071236840227301e-05 -1.6967577668846131e-08
+ 2.0712469313022219e-05 -4.9832309528219373e-09
+ 2.071258466093336e-05 4.7638078547436121e-08
+ 2.0712711444760638e-05 7.3629597518116235e-08
+ 2.0712880698178611e-05 7.0111711726771987e-08
+ 2.0713126626370711e-05 6.1763412134421344e-08
+ 2.0713439200244139e-05 6.0754869593106702e-08
+ 2.0713793526369379e-05 6.1736915522656547e-08
+ 2.071422872816429e-05 6.2029324956393507e-08
+ 2.071475251131963e-05 6.2057473291355067e-08
+ 2.0715371185020211e-05 6.1594950223433018e-08
+ 2.0715767566215801e-05 6.0288239287496572e-08
+ 2.0716110750226951e-05 6.3037658467275693e-08
+ 2.0716544327705261e-05 6.2229217680872917e-08
+ 2.0717007631872498e-05 6.172632723393634e-08
+ 2.071755588774463e-05 6.1909868909710977e-08
+ 2.0718148119307622e-05 6.1922466735602494e-08
+ 2.071896842179914e-05 6.1919175846160741e-08
+ 2.0720123996828479e-05 6.192174229777575e-08
+ 2.0722126122225832e-05 6.1921386595292187e-08
+ 2.0725170442443751e-05 6.1921012600216896e-08
+ 2.0730170442443752e-05 6.1920982299621907e-08
+ 2.0735170442443749e-05 6.1920995031555495e-08
+ 2.074017044244375e-05 6.1920997721030382e-08
+ 2.0745170442443751e-05 6.1920997992373575e-08
+ 2.0750170442443751e-05 6.1920997985678005e-08
+ 2.0755170442443749e-05 6.1920998339640738e-08
+ 2.076017044244375e-05 6.1920998133780021e-08
+ 2.076517044244375e-05 6.1920998174903908e-08
+ 2.0770170442443751e-05 6.1920998228322967e-08
+ 2.0775170442443759e-05 6.1920998067025898e-08
+ 2.078017044244376e-05 6.1920998083085073e-08
+ 2.078517044244376e-05 6.1920998164425674e-08
+ 2.0790170442443761e-05 6.1920998221963973e-08
+ 2.0795170442443759e-05 6.1920998309702677e-08
+ 2.0800170442443759e-05 6.1920998130293157e-08
+ 2.080517044244376e-05 6.1920998136218669e-08
+ 2.0810170442443761e-05 6.192099820317223e-08
+ 2.0815170442443758e-05 6.1920998269147202e-08
+ 2.0820170442443759e-05 6.1920998015389009e-08
+ 2.082517044244376e-05 6.1920998360752346e-08
+ 2.0830170442443761e-05 6.1920998176367859e-08
+ 2.0835170442443762e-05 6.1920998253154466e-08
+ 2.0840170442443769e-05 6.1920998059962265e-08
+ 2.084517044244377e-05 6.1920998054970964e-08
+ 2.0850170442443771e-05 6.1920998170095606e-08
+ 2.0855170442443772e-05 6.1920998157268179e-08
+ 2.0860170442443769e-05 6.1920998248836477e-08
+ 2.086517044244377e-05 6.192099836392107e-08
+ 2.0870170442443771e-05 6.1920997862517866e-08
+ 2.0875170442443771e-05 6.1920998195075508e-08
+ 2.0880170442443769e-05 6.1920997994851173e-08
+ 2.088517044244377e-05 6.1920998088006943e-08
+ 2.089017044244377e-05 6.1920998097785026e-08
+ 2.0895170442443771e-05 6.192099817402306e-08
+ 2.0900170442443779e-05 6.1920997951563263e-08
+ 2.090517044244378e-05 6.1920998071819958e-08
+ 2.091017044244378e-05 6.1920998302232706e-08
+ 2.0915170442443781e-05 6.1920998166622228e-08
+ 2.0920170442443779e-05 6.1920997930618176e-08
+ 2.0925170442443779e-05 6.1920998283664646e-08
+ 2.093017044244378e-05 6.1920998099928813e-08
+ 2.0935170442443781e-05 6.1920998124689584e-08
+ 2.0940170442443778e-05 6.1920997871033604e-08
+ 2.0945170442443779e-05 6.1920997992511019e-08
+ 2.095017044244378e-05 6.192099824593167e-08
+ 2.0955170442443781e-05 6.1920998321195034e-08
+ 2.0960170442443782e-05 6.1920998196910605e-08
+ 2.0965170442443789e-05 6.1920997955841957e-08
+ 2.097017044244379e-05 6.192099799738445e-08
+ 2.0975170442443791e-05 6.1920998141030054e-08
+ 2.0980170442443792e-05 6.192099797065573e-08
+ 2.0985170442443789e-05 6.1920998133125636e-08
+ 2.099017044244379e-05 6.192099809624099e-08
+ 2.0995170442443791e-05 6.1920998074552288e-08
+ 2.1000170442443791e-05 6.1920998069990367e-08
+ 2.1005170442443789e-05 6.1920998016032052e-08
+ 2.101017044244379e-05 6.192099806548353e-08
+ 2.101517044244379e-05 6.1920997810269485e-08
+ 2.1020170442443791e-05 6.1920997448239835e-08
+ 2.1025170442443799e-05 6.1920993317158295e-08
+ 2.102727005824271e-05 6.1920907564675053e-08
+ 2.1029087969227549e-05 6.1920904169420762e-08
+ 2.103101073489886e-05 6.1921194984621609e-08
+ 2.1032533209835549e-05 6.1921065642375745e-08
+ 2.1034207771579e-05 6.1920798945182808e-08
+ 2.1035238954549891e-05 6.1921266481129591e-08
+ 2.1035619227945308e-05 6.1921814078651672e-08
+ 2.1036174534520659e-05 6.1920921958211349e-08
+ 2.103648291372831e-05 6.1925156831957101e-08
+ 2.1036728302038049e-05 6.1918109850503053e-08
+ 2.1036928557088889e-05 6.1829441247559913e-08
+ 2.1037137134616249e-05 6.1854658019913623e-08
+ 2.1037380639109759e-05 6.198315394001888e-08
+ 2.1037539978919141e-05 6.1382901758291144e-08
+ 2.1037607514861831e-05 5.7469427168940573e-08
+ 2.1037661699193491e-05 5.5501552713995053e-08
+ 2.1037705336080749e-05 5.9505058645482021e-08
+ 2.1037769878221939e-05 9.1267296198407007e-08
+ 2.103783571142489e-05 1.3071341092486741e-07
+ 2.1037900731272889e-05 1.719903924479248e-07
+ 2.1037930165822122e-05 3.28953940878338e-07
+ 2.1037950813125121e-05 6.4672624787745383e-07
+ 2.1037972473158131e-05 7.8584091991760948e-07
+ 2.1037999898003139e-05 2.749742409038001e-07
+ 2.1038023155070679e-05 -7.4594663873998292e-07
+ 2.103804415576935e-05 -2.6128774516097981e-06
+ 2.1038063042237169e-05 -4.1705977968304281e-06
+ 2.1038078220159459e-05 -4.9814376208694606e-06
+ 2.1038092608272749e-05 -4.7369134440602566e-06
+ 2.1038102672623659e-05 -2.6006937168136251e-06
+ 2.1038115240438219e-05 -6.7927396699866212e-07
+ 2.1038131707646861e-05 -4.8318148982676574e-07
+ 2.1038150482602569e-05 -1.5572896907149621e-06
+ 2.1038174764512111e-05 -2.618261478580366e-06
+ 2.103819968309184e-05 -3.2792103216114421e-06
+ 2.1038225607857121e-05 -3.32175740425627e-06
+ 2.1038249408332299e-05 -1.9915037630419778e-06
+ 2.103827236317147e-05 -5.292640859113776e-07
+ 2.1038299267603141e-05 -5.5025302434278143e-07
+ 2.103832980533581e-05 -1.881711012844192e-06
+ 2.103835797433892e-05 -3.0412841879148971e-06
+ 2.103837992499239e-05 -3.7073196190378812e-06
+ 2.1038407456070099e-05 -3.6575942404436981e-06
+ 2.10384283046819e-05 -7.5080190894142483e-07
+ 2.1038445948703909e-05 2.2615557741031821e-06
+ 2.1038463125772501e-05 -6.7122272724035973e-06
+ 2.1038480931160762e-05 -5.4379267034706449e-05
+ 2.103850340998867e-05 -0.0001475131355494236
+ 2.1038524573993429e-05 -0.00018786640221110309
+ 2.10385375191832e-05 -0.00013576740280580181
+ 2.1038551055621321e-05 -1.7445772462847569e-05
+ 2.103856651143937e-05 0.0001152559208912463
+ 2.1038582677076569e-05 0.00018430592713039541
+ 2.1038606181802509e-05 0.0001846993678456804
+ 2.1038629159506141e-05 0.00014624470406787311
+ 2.1038660970663941e-05 9.4735395489708372e-05
+ 2.103869168592905e-05 6.6535546127593329e-05
+ 2.103872873127326e-05 5.6815315876151249e-05
+ 2.103876828982665e-05 6.3134228744919039e-05
+ 2.1038819889665621e-05 8.5833271874502162e-05
+ 2.1038884508419091e-05 -0.0001991233444178927
+ 2.1038932280130459e-05 -0.0019529711450389381
+ 2.1038979025738958e-05 -0.006656455386395331
+ 2.1038993199723292e-05 -0.0082669098384904188
+ 2.1039007745531368e-05 -0.0081005166131518837
+ 2.1039017079901969e-05 -0.0056334696788978792
+ 2.1039026916971039e-05 0.00077268974668622534
+ 2.1039037407546139e-05 0.014150541513957541
+ 2.1039050423526041e-05 0.043203086313372413
+ 2.1039063122235411e-05 0.086165275987668474
+ 2.1039077263768991e-05 0.14962331326133421
+ 2.103908837215574e-05 0.20851754503884271
+ 2.10391013784345e-05 0.28353255656642729
+ 2.1039115627933951e-05 0.3689475509393203
+ 2.1039132492606872e-05 0.47006086339067649
+ 2.1039154131406009e-05 0.59520812091223962
+ 2.1039182826132929e-05 0.74710202609324661
+ 2.103921893511349e-05 0.90595179561989847
+ 2.103925993485652e-05 1.035463405185828
+ 2.10393206155404e-05 1.1430859594639959
+ 2.1039366457580829e-05 1.179032757611457
+ 2.1039418964952771e-05 1.195830297721802
+ 2.1039468938797261e-05 1.200674398981832
+ 2.103953535884257e-05 1.2017346024245941
+ 2.1039616004240851e-05 1.2011481167131171
+ 2.1039747159909961e-05 1.2003248636422961
+ 2.1039882518167698e-05 1.2000151000177071
+ 2.1040011641008099e-05 1.199967412210736
+ 2.1040133475239201e-05 1.1999805136824879
+ 2.1040252225536811e-05 1.1999935787482801
+ 2.1040378846567149e-05 1.199999292636089
+ 2.1040497377035159e-05 1.200000409787727
+ 2.104062095049804e-05 1.200000307836991
+ 2.1040738793723079e-05 1.2000000930111501
+ 2.1040859974310559e-05 1.1999999847349221
+ 2.1040977716008308e-05 1.1999999561683761
+ 2.1041097782621051e-05 1.1999999547965341
+ 2.104121578768421e-05 1.199999958584103
+ 2.1041335380852509e-05 1.199999963519732
+ 2.1041395061562881e-05 1.199999981416366
+ 2.1041440959759539e-05 1.199999997899589
+ 2.1041492696209681e-05 1.199999979669323
+ 2.104155622744952e-05 1.199999930365216
+ 2.104159100638875e-05 1.199999910003545
+ 2.104162198972863e-05 1.1999998958057509
+ 2.1041646339246871e-05 1.1999998657947559
+ 2.1041669334893111e-05 1.1999998064978881
+ 2.104169205837849e-05 1.199999723709096
+ 2.104172104069028e-05 1.1999996525301271
+ 2.1041744531114909e-05 1.199999872580501
+ 2.1041769672580201e-05 1.200000177143328
+ 2.1041802105547669e-05 1.2000003192647981
+ 2.104185124712056e-05 1.2000002149567861
+ 2.104190303529314e-05 1.2000000291562769
+ 2.1041972573881748e-05 1.199999894800625
+ 2.104206265182799e-05 1.1999998699879999
+ 2.1042149118556481e-05 1.199999908795494
+ 2.1042251782513902e-05 1.1999999533947701
+ 2.1042357226495241e-05 1.1999999718677969
+ 2.1042500982593761e-05 1.1999999708036351
+ 2.104269744902014e-05 1.199999962842782
+ 2.1043089989379309e-05 1.199999958742513
+ 2.1043454978749308e-05 1.199999959687766
+ 2.1044006713807231e-05 1.1999999604886871
+ 2.1044583738664232e-05 1.199999960553674
+ 2.1045136637382431e-05 1.199999960451599
+ 2.104560230742229e-05 1.1999999604464531
+ 2.1045943094565569e-05 1.199999960629418
+ 2.1046341370433431e-05 1.199999960457744
+ 2.1046798240488491e-05 1.1999999604505649
+ 2.104738485967421e-05 1.1999999604742191
+ 2.104802345407427e-05 1.1999999604816369
+ 2.104898767560806e-05 1.199999960482105
+ 2.1050327149295609e-05 1.1999999604811411
+ 2.1052718402907239e-05 1.199999960480914
+ 2.105633776924127e-05 1.1999999604809439
+ 2.1061337769241271e-05 1.1999999604808831
+ 2.1066337769241268e-05 1.1999999604808591
+ 2.1071337769241269e-05 1.1999999604808611
+ 2.107633776924127e-05 1.1999999604808651
+ 2.1081337769241271e-05 1.1999999604808671
+ 2.1086337769241272e-05 1.199999960480868
+ 2.1091337769241279e-05 1.199999960480868
+ 2.109633776924128e-05 1.199999960480868
+ 2.1101337769241281e-05 1.199999960480868
+ 2.1106337769241282e-05 1.199999960480868
+ 2.1111337769241279e-05 1.199999960480868
+ 2.111633776924128e-05 1.199999960480868
+ 2.1121337769241281e-05 1.199999960480868
+ 2.1126337769241281e-05 1.199999960480868
+ 2.1131337769241279e-05 1.199999960480868
+ 2.113633776924128e-05 1.199999960480868
+ 2.114133776924128e-05 1.199999960480868
+ 2.1146337769241281e-05 1.199999960480868
+ 2.1151337769241289e-05 1.199999960480868
+ 2.115633776924129e-05 1.199999960480868
+ 2.116133776924129e-05 1.199999960480868
+ 2.1166337769241291e-05 1.199999960480868
+ 2.1171337769241289e-05 1.199999960480868
+ 2.1176337769241289e-05 1.199999960480868
+ 2.118133776924129e-05 1.199999960480868
+ 2.1186337769241291e-05 1.199999960480868
+ 2.1191337769241288e-05 1.199999960480868
+ 2.1196337769241289e-05 1.199999960480868
+ 2.120133776924129e-05 1.199999960480868
+ 2.1206337769241291e-05 1.199999960480868
+ 2.1211337769241292e-05 1.199999960480868
+ 2.1216337769241299e-05 1.199999960480868
+ 2.12213377692413e-05 1.199999960480868
+ 2.1226337769241301e-05 1.199999960480868
+ 2.1231337769241301e-05 1.199999960480868
+ 2.1236337769241299e-05 1.199999960480868
+ 2.12413377692413e-05 1.199999960480868
+ 2.12463377692413e-05 1.199999960480868
+ 2.1251337769241301e-05 1.199999960480868
+ 2.1256337769241299e-05 1.199999960480868
+ 2.12613377692413e-05 1.199999960480868
+ 2.12663377692413e-05 1.199999960480868
+ 2.1271337769241301e-05 1.199999960480868
+ 2.1276337769241309e-05 1.199999960480868
+ 2.1281337769241309e-05 1.1999999604808671
+ 2.128633776924131e-05 1.199999960480866
+ 2.1291337769241311e-05 1.199999960480864
+ 2.1296337769241308e-05 1.19999996048086
+ 2.1301337769241309e-05 1.199999960480852
+ 2.130633776924131e-05 1.199999960480838
+ 2.1311337769241311e-05 1.1999999604808089
+ 2.1316337769241312e-05 1.199999960480755
+ 2.1321337769241309e-05 1.1999999604806511
+ 2.132633776924131e-05 1.1999999604804541
+ 2.1331337769241311e-05 1.1999999604800839
+ 2.1336337769241311e-05 1.199999960479422
+ 2.1341337769241319e-05 1.199999960478263
+ 2.134633776924132e-05 1.199999960476112
+ 2.1351337769241321e-05 1.199999960470328
+ 2.1356337769241321e-05 1.1999999604046461
+ 2.1358378486919189e-05 1.1999999600538329
+ 2.1360265034333431e-05 1.1999999602949341
+ 2.1361742282585289e-05 1.1999999604971749
+ 2.136343468711955e-05 1.199999960364555
+ 2.1364547730359191e-05 1.1999999606959739
+ 2.136497105199961e-05 1.199999961526979
+ 2.136554440742004e-05 1.199999962200289
+ 2.1365858612173018e-05 1.1999999658825731
+ 2.136611003903944e-05 1.1999999682680029
+ 2.136631420285047e-05 1.19999994698338
+ 2.1366530488949631e-05 1.199999889079687
+ 2.1366757842411691e-05 1.199999848409715
+ 2.136695293591932e-05 1.199999763157797
+ 2.136703853872335e-05 1.199999457284042
+ 2.1367100412292681e-05 1.1999990066302899
+ 2.1367146879780989e-05 1.1999986527612081
+ 2.1367209188451281e-05 1.199998165750038
+ 2.136727685752988e-05 1.199997969967215
+ 2.1367351957068081e-05 1.1999986505102891
+ 2.1367383754122599e-05 1.1999992761411069
+ 2.136740849289558e-05 1.199999834615757
+ 2.1367425796520629e-05 1.1999999231047771
+ 2.1367444484358008e-05 1.2000000183876081
+ 2.1367467781013961e-05 1.2000021175217139
+ 2.1367494815068619e-05 1.200007065784398
+ 2.1367519285652162e-05 1.2000104304097989
+ 2.1367540564382011e-05 1.200010323276326
+ 2.1367557692609599e-05 1.200008432057228
+ 2.136757591035584e-05 1.2000050503163331
+ 2.1367591122026942e-05 1.200002111161639
+ 2.1367607214557058e-05 1.1999998907459299
+ 2.1367634610822599e-05 1.199998048023188
+ 2.136766400925683e-05 1.199997338218614
+ 2.1367691054999609e-05 1.199997080387663
+ 2.1367715001771359e-05 1.199997467129412
+ 2.1367740416345748e-05 1.199999097208337
+ 2.136776697980263e-05 1.200001809833275
+ 2.1367796953070811e-05 1.2000047645801111
+ 2.1367823565113279e-05 1.200006780215412
+ 2.136784159521437e-05 1.2000080807509621
+ 2.1367857337875661e-05 1.2000094560765939
+ 2.1367872571270339e-05 1.2000114273972571
+ 2.1367886525509951e-05 1.200013123991728
+ 2.136790171503391e-05 1.200013073687902
+ 2.1367915155303369e-05 1.200011631354549
+ 2.1367929619898151e-05 1.2000093545227879
+ 2.1367955130889849e-05 1.200004444127905
+ 2.1367978060964941e-05 1.1999877458653501
+ 2.1368001656804189e-05 1.1999339455824349
+ 2.1368031310621331e-05 1.199820607717176
+ 2.1368059897018229e-05 1.1996515296631951
+ 2.136809737506082e-05 1.199658772285759
+ 2.1368114809192439e-05 1.201056286288976
+ 2.1368132963114649e-05 1.2049629470518399
+ 2.1368155451361459e-05 1.213075666423159
+ 2.1368172491590662e-05 1.21490067622007
+ 2.136818669364609e-05 1.2000198893707621
+ 2.1368205515300069e-05 1.1422602831073849
+ 2.1368223158044879e-05 1.0574381345988331
+ 2.1368240608460438e-05 0.95760892217155458
+ 2.136826239876451e-05 0.82576298886445298
+ 2.1368283546279161e-05 0.69779281931041981
+ 2.136829789163725e-05 0.61282361985367062
+ 2.1368309262927549e-05 0.54716048739001033
+ 2.136832410646769e-05 0.46441938739170952
+ 2.1368335110748869e-05 0.40571800618225801
+ 2.1368349138396409e-05 0.33511660757456257
+ 2.1368368781328089e-05 0.2467541973372222
+ 2.1368392265253821e-05 0.16116569679749701
+ 2.1368414226609179e-05 0.1022473475768476
+ 2.1368434472479311e-05 0.064455822631076853
+ 2.136845076615857e-05 0.043544268001363122
+ 2.1368468212431052e-05 0.028163439861273291
+ 2.1368490145898389e-05 0.015837125586506171
+ 2.1368510680430539e-05 0.0090260903442194503
+ 2.1368536803767269e-05 0.0041939801618632233
+ 2.1368563748395001e-05 0.001748044013652496
+ 2.1368599197715658e-05 0.00037378034331877889
+ 2.13686400749237e-05 -0.0001084046539619975
+ 2.136869764645919e-05 -0.00018888929105891891
+ 2.1368774550636641e-05 -0.0001024148596028883
+ 2.1368865062869339e-05 -2.6796661131419249e-05
+ 2.1368965055445089e-05 7.8432717407552945e-07
+ 2.1369095784867341e-05 4.4712868391996923e-06
+ 2.136927390171499e-05 1.6718656557714069e-06
+ 2.136941742250438e-05 3.1810152889958579e-07
+ 2.1369542570351191e-05 2.1928199351104299e-08
+ 2.1369659633151369e-05 1.7574644130420749e-08
+ 2.1369777033750621e-05 4.659473428751238e-08
+ 2.1369904528735019e-05 6.0880989307799823e-08
+ 2.1370024166407289e-05 6.4575210644052475e-08
+ 2.137014916925527e-05 6.6591503611199151e-08
+ 2.137026779528963e-05 6.9610247339539849e-08
+ 2.1370389649061589e-05 7.4364163890330888e-08
+ 2.1370507660204541e-05 8.6637161023577809e-08
+ 2.137062801919304e-05 1.3688384384050379e-07
+ 2.1370699124898572e-05 3.4276610295839151e-07
+ 2.1370749260368091e-05 6.2066639199155275e-07
+ 2.1370804789000951e-05 6.24155872489314e-07
+ 2.137087017173218e-05 1.7838628437711701e-07
+ 2.1370906956712e-05 -2.17351139087354e-07
+ 2.13709349150094e-05 -6.1804580091934284e-07
+ 2.1370958851834039e-05 -1.085097736502248e-06
+ 2.1370981579401521e-05 -1.576780524787884e-06
+ 2.1371002872704281e-05 -1.745248944088557e-06
+ 2.1371030131222159e-05 -1.6461962361684419e-06
+ 2.1371048447698719e-05 -1.7403809022927391e-06
+ 2.1371071881108941e-05 -6.0014450835722298e-07
+ 2.1371109927631799e-05 1.081663236637055e-06
+ 2.1371151372655431e-05 1.410079891497719e-06
+ 2.137120903231815e-05 7.5043378328534538e-07
+ 2.1371275995416421e-05 1.8077665880347979e-07
+ 2.137136467616907e-05 1.9230275443354021e-08
+ 2.1371447585012811e-05 -1.9295411843337551e-08
+ 2.1371547932148698e-05 -5.3834480230465421e-09
+ 2.1371663160242872e-05 4.829031381307999e-08
+ 2.137179111646949e-05 7.4094718454061129e-08
+ 2.137196324612459e-05 6.9986178318546075e-08
+ 2.1372215170831959e-05 6.1629461163299356e-08
+ 2.1372524704793779e-05 6.0786228860315965e-08
+ 2.1372883448198939e-05 6.1761311402830906e-08
+ 2.137331582349409e-05 6.2028484435760666e-08
+ 2.1373845623212841e-05 6.2058312139137714e-08
+ 2.137444952935979e-05 6.1566171666421391e-08
+ 2.1374844165365911e-05 6.0300108387865954e-08
+ 2.1375183451515221e-05 6.3061268426582843e-08
+ 2.1375612449080719e-05 6.2210762749984674e-08
+ 2.1376078750020621e-05 6.1728485257875456e-08
+ 2.137662943113274e-05 6.1911178116464583e-08
+ 2.1377220500788529e-05 6.1921775424872753e-08
+ 2.137804116907812e-05 6.1919069393896207e-08
+ 2.1379191827076359e-05 6.1921780289447529e-08
+ 2.1381194448832291e-05 6.1921392936621672e-08
+ 2.1384232349658658e-05 6.1921012873387695e-08
+ 2.1389232349658659e-05 6.192098196247295e-08
+ 2.139423234965866e-05 6.1920995030522816e-08
+ 2.1399232349658661e-05 6.1920997599214379e-08
+ 2.1404232349658668e-05 6.1920997782450144e-08
+ 2.1409232349658669e-05 6.1920998104339499e-08
+ 2.141423234965867e-05 6.1920998138460315e-08
+ 2.1419232349658671e-05 6.1920997932180423e-08
+ 2.1424232349658672e-05 6.192099806740464e-08
+ 2.1429232349658669e-05 6.1920998109781249e-08
+ 2.143423234965867e-05 6.1920997919770093e-08
+ 2.1439232349658671e-05 6.1920998244403993e-08
+ 2.1444232349658671e-05 6.19209980023323e-08
+ 2.1449232349658669e-05 6.1920998282135235e-08
+ 2.145423234965867e-05 6.1920998137637674e-08
+ 2.145923234965867e-05 6.1920998229496928e-08
+ 2.1464232349658671e-05 6.1920998037663461e-08
+ 2.1469232349658679e-05 6.1920998013003195e-08
+ 2.147423234965868e-05 6.1920998338318666e-08
+ 2.147923234965868e-05 6.1920998162947773e-08
+ 2.1484232349658681e-05 6.1920997965777495e-08
+ 2.1489232349658679e-05 6.1920998316337883e-08
+ 2.1494232349658679e-05 6.1920998064503261e-08
+ 2.149923234965868e-05 6.1920998136180632e-08
+ 2.1504232349658681e-05 6.1920998167186313e-08
+ 2.1509232349658678e-05 6.1920997979382935e-08
+ 2.1514232349658679e-05 6.1920998350147309e-08
+ 2.151923234965868e-05 6.1920998135754244e-08
+ 2.1524232349658681e-05 6.1920997935768918e-08
+ 2.1529232349658682e-05 6.1920998024063685e-08
+ 2.1534232349658689e-05 6.1920998058682067e-08
+ 2.153923234965869e-05 6.192099811053491e-08
+ 2.1544232349658691e-05 6.1920998117171955e-08
+ 2.1549232349658692e-05 6.1920998221492533e-08
+ 2.1554232349658689e-05 6.1920998225522147e-08
+ 2.155923234965869e-05 6.1920998337972441e-08
+ 2.1564232349658691e-05 6.1920998109874833e-08
+ 2.1569232349658691e-05 6.1920998196848057e-08
+ 2.1574232349658689e-05 6.1920998195136918e-08
+ 2.157923234965869e-05 6.1920998303908084e-08
+ 2.158423234965869e-05 6.1920998355981473e-08
+ 2.1589232349658691e-05 6.1920998134080003e-08
+ 2.1594232349658699e-05 6.1920998170117642e-08
+ 2.15992323496587e-05 6.1920998248009707e-08
+ 2.16042323496587e-05 6.1920998062550308e-08
+ 2.1609232349658701e-05 6.1920998085468968e-08
+ 2.1614232349658699e-05 6.1920998203016296e-08
+ 2.1619232349658699e-05 6.1920998181515106e-08
+ 2.16242323496587e-05 6.1920998340842559e-08
+ 2.1629232349658701e-05 6.1920998064607129e-08
+ 2.1634232349658698e-05 6.1920997993366232e-08
+ 2.1639232349658699e-05 6.1920998113674305e-08
+ 2.16442323496587e-05 6.192099821381586e-08
+ 2.1649232349658701e-05 6.1920998157450556e-08
+ 2.1654232349658702e-05 6.1920998170641638e-08
+ 2.1659232349658709e-05 6.1920998249402428e-08
+ 2.166423234965871e-05 6.1920998029967028e-08
+ 2.1669232349658711e-05 6.1920997892241483e-08
+ 2.1674232349658712e-05 6.1920997849435786e-08
+ 2.1679232349658709e-05 6.192099732108571e-08
+ 2.168423234965871e-05 6.1920993542505045e-08
+ 2.1686336025961781e-05 6.1920908531746598e-08
+ 2.1688149975999139e-05 6.1920901594826783e-08
+ 2.1690082529595141e-05 6.1921194907728937e-08
+ 2.1691599766936859e-05 6.1921068608010464e-08
+ 2.1693273367926861e-05 6.1920796400990443e-08
+ 2.1694307419385879e-05 6.1921263942696124e-08
+ 2.1694690238029499e-05 6.1921794036109502e-08
+ 2.1695249745056651e-05 6.1920927316935564e-08
+ 2.1695559013306919e-05 6.1925115843540313e-08
+ 2.1695804619537191e-05 6.1918578755952862e-08
+ 2.1696004428866789e-05 6.1832451712043969e-08
+ 2.1696213022010679e-05 6.1850456226308689e-08
+ 2.1696457506738389e-05 6.1984378455987272e-08
+ 2.169662103300622e-05 6.1415974332930731e-08
+ 2.1696689499234621e-05 5.7480076211800847e-08
+ 2.169674346453072e-05 5.5406704520436239e-08
+ 2.1696787213143169e-05 5.9601033748031398e-08
+ 2.1696851719807452e-05 9.1550263774834979e-08
+ 2.1696917503636919e-05 1.3090753548399619e-07
+ 2.169698219579545e-05 1.7215506016011641e-07
+ 2.169701154076483e-05 3.2817575532386741e-07
+ 2.1697032213074191e-05 6.4502379852241519e-07
+ 2.169705383087245e-05 7.8683775535617013e-07
+ 2.1697081213804019e-05 2.7914821263357618e-07
+ 2.1697104534033542e-05 -7.3685328037708353e-07
+ 2.1697125538717299e-05 -2.5998888822288162e-06
+ 2.1697144379442991e-05 -4.161442766966313e-06
+ 2.16971595923262e-05 -4.9714172738308426e-06
+ 2.1697173901310089e-05 -4.7682922420528906e-06
+ 2.169718393289727e-05 -2.6416262042407992e-06
+ 2.1697196486376159e-05 -6.948697815659479e-07
+ 2.1697212787817601e-05 -4.6785296361899749e-07
+ 2.1697231558410131e-05 -1.5351952829609091e-06
+ 2.1697255748415361e-05 -2.6026844019368448e-06
+ 2.1697283358902618e-05 -3.3110760825407931e-06
+ 2.1697308253666969e-05 -3.2928444759290331e-06
+ 2.169733229007712e-05 -1.8937875852177799e-06
+ 2.1697355749872871e-05 -4.8169648520549129e-07
+ 2.1697383137588e-05 -6.2317076217300336e-07
+ 2.169741321769099e-05 -1.9715610524615411e-06
+ 2.1697441932129169e-05 -3.1287544894284669e-06
+ 2.169746358603398e-05 -3.760806838637807e-06
+ 2.1697490075003889e-05 -3.5410858846398452e-06
+ 2.1697509643785658e-05 -7.0953669735382024e-07
+ 2.1697526746501729e-05 2.2916708862630038e-06
+ 2.1697543869896052e-05 -5.5386234221763703e-06
+ 2.169756157200877e-05 -5.1004007626290937e-05
+ 2.169758403039989e-05 -0.00014400303730366921
+ 2.1697604621857551e-05 -0.00018924137146218589
+ 2.169761769623123e-05 -0.00014410677569071079
+ 2.1697631068563982e-05 -3.1032335089817212e-05
+ 2.1697646141133371e-05 0.0001029703981845186
+ 2.16976621579392e-05 0.00018035743384668779
+ 2.1697684410114149e-05 0.00018824430281529821
+ 2.169770761815259e-05 0.00015145945970204829
+ 2.169773858488339e-05 9.996510641134772e-05
+ 2.169776920879108e-05 6.8953989818696545e-05
+ 2.1697805537716401e-05 5.7011514068262947e-05
+ 2.1697844464741579e-05 6.1544560776133014e-05
+ 2.1697894409750211e-05 8.2948965714302152e-05
+ 2.1697957087922091e-05 -8.9326356196327918e-05
+ 2.1698007737112981e-05 -0.0015780945579302421
+ 2.169805268520548e-05 -0.0056430647469364508
+ 2.169807044449091e-05 -0.0078373596495847943
+ 2.1698084094817449e-05 -0.0085838598761838747
+ 2.1698094186882761e-05 -0.0072846202248629758
+ 2.1698104065128749e-05 -0.002852357077933913
+ 2.169811431324345e-05 0.0071080882992065478
+ 2.169812587241741e-05 0.027601214664462619
+ 2.1698138558083841e-05 0.06355162866781558
+ 2.1698154162422419e-05 0.1269264235359833
+ 2.1698164656589471e-05 0.1796702266990142
+ 2.1698176226557589e-05 0.24425282098738471
+ 2.1698190816835919e-05 0.33056207385622632
+ 2.169820531671997e-05 0.41791246519333158
+ 2.169822555042391e-05 0.53744313160077417
+ 2.1698249666148081e-05 0.67160185314928567
+ 2.1698283900176149e-05 0.83796491080935809
+ 2.169832147250954e-05 0.97895412133419457
+ 2.1698369872965641e-05 1.096019032631673
+ 2.1698404633955619e-05 1.1437932563335429
+ 2.169844391497902e-05 1.173930590147465
+ 2.1698495345696001e-05 1.1924781342824311
+ 2.169854499434336e-05 1.1989704804021051
+ 2.1698614531297961e-05 1.2013142352687101
+ 2.1698694284344921e-05 1.2011803971686279
+ 2.1698822148292342e-05 1.2004618302623631
+ 2.169895596106386e-05 1.200081590821342
+ 2.1699084911514601e-05 1.1999844302925751
+ 2.1699207110580059e-05 1.199981193380137
+ 2.1699326176957389e-05 1.1999916708871941
+ 2.1699453174102221e-05 1.1999981368251
+ 2.1699571816709431e-05 1.2000000201899399
+ 2.1699695500542659e-05 1.200000258294351
+ 2.169981332789835e-05 1.2000001168315919
+ 2.1699934531077279e-05 1.200000005208693
+ 2.170005224714063e-05 1.199999964342132
+ 2.1700172328226859e-05 1.199999956442513
+ 2.1700290320991249e-05 1.1999999583307619
+ 2.1700409923328289e-05 1.199999962808834
+ 2.1700472245483179e-05 1.199999979209927
+ 2.170051842871856e-05 1.199999996915923
+ 2.1700568906131909e-05 1.199999983260525
+ 2.1700632863356019e-05 1.1999999338822691
+ 2.1700671590403531e-05 1.199999911215091
+ 2.1700700943915299e-05 1.199999897001939
+ 2.1700725649689421e-05 1.199999868992681
+ 2.1700748748258299e-05 1.1999998129605161
+ 2.170077160495676e-05 1.199999731698709
+ 2.170079759540433e-05 1.1999996473067149
+ 2.170082420738056e-05 1.1999998383130721
+ 2.1700849790138931e-05 1.2000001590469771
+ 2.1700878710419131e-05 1.20000031516897
+ 2.1700924523395471e-05 1.200000241511771
+ 2.1700975227475021e-05 1.200000054175925
+ 2.1701042793257379e-05 1.1999999057994339
+ 2.170112087330653e-05 1.1999998687793509
+ 2.1701202530189191e-05 1.1999998983530631
+ 2.170130482279725e-05 1.1999999456102011
+ 2.1701404648965161e-05 1.199999969094615
+ 2.170154039118433e-05 1.1999999721734069
+ 2.1701711643509601e-05 1.199999964806185
+ 2.1702029549004201e-05 1.199999959172497
+ 2.17024055826246e-05 1.1999999594358519
+ 2.1702882775010121e-05 1.1999999603404541
+ 2.170345221746865e-05 1.199999960552514
+ 2.1704100098882211e-05 1.199999960489619
+ 2.170451517312296e-05 1.199999960394863
+ 2.170485789161046e-05 1.1999999606194911
+ 2.1705281403254021e-05 1.1999999605065661
+ 2.170581393961867e-05 1.1999999604446341
+ 2.1706379023203531e-05 1.199999960467627
+ 2.170700172031115e-05 1.1999999604801459
+ 2.1707856814429228e-05 1.199999960482651
+ 2.170911375512451e-05 1.1999999604814291
+ 2.1711356241094948e-05 1.1999999604808771
+ 2.1714735006806258e-05 1.199999960480937
+ 2.1719735006806259e-05 1.1999999604808931
+ 2.172473500680626e-05 1.19999996048086
+ 2.1729735006806261e-05 1.19999996048086
+ 2.1734735006806268e-05 1.1999999604808651
+ 2.1739735006806269e-05 1.1999999604808671
+ 2.174473500680627e-05 1.199999960480868
+ 2.1749735006806271e-05 1.199999960480868
+ 2.1754735006806272e-05 1.199999960480868
+ 2.1759735006806269e-05 1.199999960480868
+ 2.176473500680627e-05 1.199999960480868
+ 2.1769735006806271e-05 1.199999960480868
+ 2.1774735006806271e-05 1.199999960480868
+ 2.1779735006806269e-05 1.199999960480868
+ 2.178473500680627e-05 1.199999960480868
+ 2.178973500680627e-05 1.199999960480868
+ 2.1794735006806271e-05 1.199999960480868
+ 2.1799735006806279e-05 1.199999960480868
+ 2.180473500680628e-05 1.199999960480868
+ 2.180973500680628e-05 1.199999960480868
+ 2.1814735006806281e-05 1.199999960480868
+ 2.1819735006806279e-05 1.199999960480868
+ 2.1824735006806279e-05 1.199999960480868
+ 2.182973500680628e-05 1.199999960480868
+ 2.1834735006806281e-05 1.199999960480868
+ 2.1839735006806278e-05 1.199999960480868
+ 2.1844735006806279e-05 1.199999960480868
+ 2.184973500680628e-05 1.199999960480868
+ 2.1854735006806281e-05 1.199999960480868
+ 2.1859735006806282e-05 1.199999960480868
+ 2.1864735006806289e-05 1.199999960480868
+ 2.186973500680629e-05 1.199999960480868
+ 2.1874735006806291e-05 1.199999960480868
+ 2.1879735006806292e-05 1.199999960480868
+ 2.1884735006806289e-05 1.199999960480868
+ 2.188973500680629e-05 1.199999960480868
+ 2.1894735006806291e-05 1.199999960480868
+ 2.1899735006806291e-05 1.199999960480868
+ 2.1904735006806289e-05 1.199999960480868
+ 2.190973500680629e-05 1.199999960480868
+ 2.191473500680629e-05 1.199999960480868
+ 2.1919735006806291e-05 1.199999960480868
+ 2.1924735006806299e-05 1.199999960480868
+ 2.19297350068063e-05 1.199999960480868
+ 2.19347350068063e-05 1.199999960480868
+ 2.1939735006806301e-05 1.1999999604808671
+ 2.1944735006806299e-05 1.1999999604808671
+ 2.1949735006806299e-05 1.199999960480864
+ 2.19547350068063e-05 1.19999996048086
+ 2.1959735006806301e-05 1.1999999604808529
+ 2.1964735006806298e-05 1.19999996048084
+ 2.1969735006806299e-05 1.199999960480814
+ 2.19747350068063e-05 1.199999960480765
+ 2.1979735006806301e-05 1.1999999604806699
+ 2.1984735006806302e-05 1.199999960480489
+ 2.1989735006806309e-05 1.1999999604801479
+ 2.199473500680631e-05 1.1999999604795351
+ 2.1999735006806311e-05 1.1999999604784619
+ 2.2004735006806312e-05 1.1999999604765079
+ 2.2009735006806309e-05 1.1999999604716749
+ 2.201473500680631e-05 1.199999960433078
+ 2.2016702321682741e-05 1.1999999601278479
+ 2.201863972401885e-05 1.1999999601797491
+ 2.2020076689836081e-05 1.1999999604297951
+ 2.2021964555412672e-05 1.1999999604128331
+ 2.202324807400613e-05 1.199999960512768
+ 2.2023819467392651e-05 1.1999999610289731
+ 2.2024446022732709e-05 1.1999999615445229
+ 2.202476763663412e-05 1.1999999639036321
+ 2.202508169407951e-05 1.1999999665257171
+ 2.2025327383341258e-05 1.199999966030465
+ 2.2025538094548011e-05 1.1999999260830361
+ 2.2025754572337499e-05 1.199999869525493
+ 2.2025999447373939e-05 1.199999827609995
+ 2.202613138984584e-05 1.1999996555282351
+ 2.2026197877505379e-05 1.1999992973459159
+ 2.202625564284278e-05 1.1999988445142931
+ 2.2026301051110258e-05 1.1999985263302051
+ 2.202636882593218e-05 1.1999980157279371
+ 2.2026438727007989e-05 1.199998093268716
+ 2.2026519902049e-05 1.1999991457424011
+ 2.2026544997789999e-05 1.199999694606749
+ 2.2026564949940259e-05 1.19999980019873
+ 2.2026583692135961e-05 1.200000106706592
+ 2.2026608363579479e-05 1.2000027035718861
+ 2.2026635398205051e-05 1.2000078917960539
+ 2.2026659939078911e-05 1.2000107208896751
+ 2.202668080350041e-05 1.2000101153668501
+ 2.2026698203249748e-05 1.200007873796995
+ 2.2026712598813049e-05 1.200004962573866
+ 2.2026728413087201e-05 1.2000019210943089
+ 2.2026746054997219e-05 1.199999647503764
+ 2.2026772650530059e-05 1.1999980202141549
+ 2.2026802540951699e-05 1.199997323571929
+ 2.2026830616892851e-05 1.199997088327706
+ 2.2026854857942669e-05 1.199997619705067
+ 2.202688028711419e-05 1.199999443545481
+ 2.2026910197114631e-05 1.200002529676212
+ 2.2026940912728271e-05 1.2000053799777
+ 2.2026965364168319e-05 1.2000071644616139
+ 2.2026981934083291e-05 1.200008423556105
+ 2.2026997591705188e-05 1.200009932199835
+ 2.2027012085554279e-05 1.200011981937557
+ 2.202702771137721e-05 1.2000133409797791
+ 2.2027039959055088e-05 1.2000128913347909
+ 2.2027053630649249e-05 1.200011251666532
+ 2.2027071574905949e-05 1.2000083376015831
+ 2.202709933752687e-05 1.2000010302937341
+ 2.2027127649856821e-05 1.1999622644765171
+ 2.202715195277627e-05 1.1998862710738589
+ 2.2027178749418121e-05 1.199763942423177
+ 2.2027217783032349e-05 1.1994505574490819
+ 2.2027238785339521e-05 1.199846780826479
+ 2.2027254949617249e-05 1.2016385900173929
+ 2.2027275316127871e-05 1.2069465954756089
+ 2.2027297014614459e-05 1.2148131762155661
+ 2.2027311811588002e-05 1.21372396277058
+ 2.2027325538609999e-05 1.194766204410038
+ 2.202734323257359e-05 1.135774716686361
+ 2.2027363724282539e-05 1.033411330843039
+ 2.2027383248769831e-05 0.91914461739635145
+ 2.2027404120037609e-05 0.79205752209444613
+ 2.2027423336547289e-05 0.67607902171023615
+ 2.202743651462118e-05 0.59840720952007731
+ 2.2027448091192898e-05 0.53196483337060652
+ 2.2027461756729208e-05 0.45625856486440108
+ 2.2027474772036719e-05 0.3875774212169979
+ 2.2027489665245449e-05 0.31429929811947188
+ 2.2027510025989769e-05 0.2262309075687805
+ 2.202753384725557e-05 0.14471398176735431
+ 2.202755608462459e-05 0.090095831686908795
+ 2.2027572399108439e-05 0.061888044848038427
+ 2.2027588172049711e-05 0.04235736791815331
+ 2.202760594040048e-05 0.027176663763836869
+ 2.2027627368533281e-05 0.01549794350016573
+ 2.2027648697673571e-05 0.0086299573791842072
+ 2.2027674542883949e-05 0.0040330080304399633
+ 2.2027702363716809e-05 0.0016159873604135969
+ 2.202773770150443e-05 0.00033001006606017002
+ 2.2027779782729471e-05 -0.00012549152961428099
+ 2.2027837734741031e-05 -0.0001861423335975071
+ 2.202791729473111e-05 -9.5692254427359556e-05
+ 2.2028006494538221e-05 -2.445131614912147e-05
+ 2.2028109615817511e-05 1.6364593775429251e-06
+ 2.2028240873476899e-05 4.3610027905774474e-06
+ 2.2028426891054979e-05 1.497319670340509e-06
+ 2.202857313072574e-05 2.6761790553957019e-07
+ 2.2028698518145289e-05 1.959496574578111e-08
+ 2.2028814729514471e-05 2.1961619043912831e-08
+ 2.2028931400143839e-05 4.8812398700792122e-08
+ 2.202905772021752e-05 6.1358677882958665e-08
+ 2.2029177098569359e-05 6.4725269376451871e-08
+ 2.2029301683497731e-05 6.6805167814190798e-08
+ 2.2029420388657691e-05 6.99543189820823e-08
+ 2.2029542119660969e-05 7.5042018680135247e-08
+ 2.2029660232743469e-05 8.8752567638827132e-08
+ 2.202978052459387e-05 1.4788014459630931e-07
+ 2.2029847114313329e-05 3.804069257704858e-07
+ 2.202989688269362e-05 6.4612840848915028e-07
+ 2.2029955100951621e-05 5.8494032716884497e-07
+ 2.2030020612391409e-05 1.023879468803612e-07
+ 2.2030057415401159e-05 -3.1265035383811088e-07
+ 2.2030083310920121e-05 -7.3757919402399036e-07
+ 2.2030106736125181e-05 -1.241074955700255e-06
+ 2.203012894210786e-05 -1.692443676679901e-06
+ 2.2030150477511349e-05 -1.698565676689828e-06
+ 2.2030175557115172e-05 -1.729926702613423e-06
+ 2.2030195258809431e-05 -1.559073398877486e-06
+ 2.20302192702233e-05 -2.39963934268214e-07
+ 2.2030260054019271e-05 1.2856576614311581e-06
+ 2.2030302751685329e-05 1.3321626448592071e-06
+ 2.2030363489757449e-05 5.8762531935991609e-07
+ 2.2030434901377641e-05 1.159658067439814e-07
+ 2.2030509186134599e-05 2.8280862919616609e-08
+ 2.2030595524608709e-05 -1.7385203473484358e-08
+ 2.2030698817967069e-05 2.3201210285285792e-09
+ 2.2030813868299249e-05 5.3304361510300973e-08
+ 2.2030945848063999e-05 7.4532966580651838e-08
+ 2.20311201724308e-05 6.8739558129305671e-08
+ 2.203138539909921e-05 6.1178816763610792e-08
+ 2.203169320838448e-05 6.0891396935661187e-08
+ 2.2032066033988721e-05 6.1831708707687193e-08
+ 2.2032500815567509e-05 6.2028988240128112e-08
+ 2.2033052873789159e-05 6.2056938104192859e-08
+ 2.203361948863097e-05 6.1448770658275277e-08
+ 2.2034024369097729e-05 6.0405383377658749e-08
+ 2.20343542393592e-05 6.3222321305516349e-08
+ 2.2034764398695562e-05 6.2052497764139333e-08
+ 2.203528794469508e-05 6.1741314086261992e-08
+ 2.203586058273606e-05 6.1922211140511901e-08
+ 2.2036470564600961e-05 6.1916713542388444e-08
+ 2.2037320157709181e-05 6.1919232322817433e-08
+ 2.2038524543574092e-05 6.1922108533726681e-08
+ 2.20406900546265e-05 6.1921350663550577e-08
+ 2.2043924373144471e-05 6.1920996309656413e-08
+ 2.2048924373144468e-05 6.1920983478848233e-08
+ 2.2053924373144469e-05 6.1920995325147822e-08
+ 2.205892437314447e-05 6.192099774761422e-08
+ 2.2063924373144471e-05 6.192099814364642e-08
+ 2.2068924373144472e-05 6.1920997904239334e-08
+ 2.2073924373144479e-05 6.1920998211764214e-08
+ 2.207892437314448e-05 6.1920998259186505e-08
+ 2.2083924373144481e-05 6.1920998114544777e-08
+ 2.2088924373144482e-05 6.1920998175698292e-08
+ 2.2093924373144479e-05 6.1920998166314014e-08
+ 2.209892437314448e-05 6.1920998308095074e-08
+ 2.2103924373144481e-05 6.1920998068959396e-08
+ 2.2108924373144481e-05 6.1920998101038519e-08
+ 2.2113924373144479e-05 6.1920998222246075e-08
+ 2.211892437314448e-05 6.1920997975714687e-08
+ 2.212392437314448e-05 6.192099803032085e-08
+ 2.2128924373144481e-05 6.1920998084263574e-08
+ 2.2133924373144489e-05 6.1920998192847255e-08
+ 2.213892437314449e-05 6.1920998213066355e-08
+ 2.214392437314449e-05 6.1920997982284897e-08
+ 2.2148924373144491e-05 6.1920998284488928e-08
+ 2.2153924373144489e-05 6.1920998107354354e-08
+ 2.2158924373144489e-05 6.1920998189005498e-08
+ 2.216392437314449e-05 6.1920998250257785e-08
+ 2.2168924373144491e-05 6.1920998310193903e-08
+ 2.2173924373144488e-05 6.1920998117388055e-08
+ 2.2178924373144489e-05 6.1920998117773825e-08
+ 2.218392437314449e-05 6.1920998200764618e-08
+ 2.2188924373144491e-05 6.1920998225199096e-08
+ 2.2193924373144492e-05 6.1920998301992321e-08
+ 2.2198924373144499e-05 6.1920998090058431e-08
+ 2.22039243731445e-05 6.1920998126834642e-08
+ 2.2208924373144501e-05 6.192099821500164e-08
+ 2.2213924373144502e-05 6.1920998306526171e-08
+ 2.2218924373144499e-05 6.1920998080054244e-08
+ 2.22239243731445e-05 6.1920998123007668e-08
+ 2.2228924373144501e-05 6.1920998164227878e-08
+ 2.2233924373144501e-05 6.1920998299451871e-08
+ 2.2238924373144499e-05 6.1920998298718684e-08
+ 2.22439243731445e-05 6.1920998119206674e-08
+ 2.22489243731445e-05 6.1920998136915817e-08
+ 2.2253924373144501e-05 6.1920998205479468e-08
+ 2.2258924373144509e-05 6.1920998261904674e-08
+ 2.226392437314451e-05 6.1920998356385971e-08
+ 2.226892437314451e-05 6.1920998164739684e-08
+ 2.2273924373144511e-05 6.1920998194355305e-08
+ 2.2278924373144509e-05 6.1920998273456734e-08
+ 2.2283924373144509e-05 6.1920998328139884e-08
+ 2.228892437314451e-05 6.1920998119840519e-08
+ 2.2293924373144511e-05 6.1920998253448638e-08
+ 2.2298924373144508e-05 6.1920998190486482e-08
+ 2.2303924373144509e-05 6.1920998085425571e-08
+ 2.230892437314451e-05 6.1920998297337332e-08
+ 2.2313924373144511e-05 6.1920998162153481e-08
+ 2.2318924373144512e-05 6.1920998169340913e-08
+ 2.2323924373144519e-05 6.1920998102556759e-08
+ 2.232892437314452e-05 6.1920997951163186e-08
+ 2.2333924373144521e-05 6.1920997941128691e-08
+ 2.2338924373144522e-05 6.1920997252818878e-08
+ 2.2343924373144519e-05 6.1920991775325119e-08
+ 2.2345931027840371e-05 6.1920869554311321e-08
+ 2.23477891219966e-05 6.1920997317262588e-08
+ 2.234941896193593e-05 6.1921191077396769e-08
+ 2.2351154947787369e-05 6.1920971093869677e-08
+ 2.2352930469380692e-05 6.1920896355140449e-08
+ 2.2353741162503232e-05 6.1921381456026043e-08
+ 2.2354075039728561e-05 6.1922324052572504e-08
+ 2.23545148829585e-05 6.1920928042122121e-08
+ 2.2354804257396781e-05 6.1925474458299345e-08
+ 2.2355031367546051e-05 6.189758261538268e-08
+ 2.2355234293029339e-05 6.1788536860250694e-08
+ 2.235543440510964e-05 6.1941620859801093e-08
+ 2.2355674978370419e-05 6.1914658846689541e-08
+ 2.2355776676619379e-05 6.0117829995142082e-08
+ 2.2355834005055852e-05 5.636179455765216e-08
+ 2.235588203224455e-05 5.5463236170590239e-08
+ 2.2355932752300679e-05 6.7561523112812027e-08
+ 2.2355994364432339e-05 1.0390405060006909e-07
+ 2.2356063643177819e-05 1.4013997027690389e-07
+ 2.2356112181737042e-05 1.9335791784418929e-07
+ 2.2356135739518351e-05 3.4075960011820839e-07
+ 2.2356157048294119e-05 6.4988153061656337e-07
+ 2.235617958275054e-05 7.7354205458316383e-07
+ 2.2356206226177639e-05 2.707060089837152e-07
+ 2.235622919960841e-05 -7.1817531991827636e-07
+ 2.235625003501508e-05 -2.5580120268343301e-06
+ 2.2356268761215879e-05 -4.1362764469977133e-06
+ 2.2356284189546889e-05 -4.9322152539840119e-06
+ 2.235629817610853e-05 -4.8876894787019226e-06
+ 2.235630808223252e-05 -2.7985013735306799e-06
+ 2.2356320590314889e-05 -7.4758151070236787e-07
+ 2.2356336236324059e-05 -4.0080228425057391e-07
+ 2.2356354987545331e-05 -1.4418919164551771e-06
+ 2.2356378804409939e-05 -2.5411203465683642e-06
+ 2.2356405924273968e-05 -3.2630775725758228e-06
+ 2.2356430772310699e-05 -3.3562565047302671e-06
+ 2.235645595940551e-05 -2.0263492311315179e-06
+ 2.2356479049092448e-05 -5.4804515588263045e-07
+ 2.235650565048223e-05 -5.4697773170036222e-07
+ 2.2356536579317919e-05 -1.8809265213748981e-06
+ 2.235656443686015e-05 -3.026755893561158e-06
+ 2.2356586301247339e-05 -3.6963755103650761e-06
+ 2.2356613919042309e-05 -3.6685347332159411e-06
+ 2.2356634893750221e-05 -7.5893989618351258e-07
+ 2.2356652594550001e-05 2.2550425783861201e-06
+ 2.2356669782151702e-05 -6.8304862634866839e-06
+ 2.235668760239896e-05 -5.4721634026471319e-05
+ 2.2356710063413409e-05 -0.00014779364681044159
+ 2.2356731291051139e-05 -0.00018770790306049879
+ 2.2356744229649371e-05 -0.0001349503631853643
+ 2.2356757789132331e-05 -1.6098910333660528e-05
+ 2.2356774983479111e-05 0.0001264763263546787
+ 2.2356790482044409e-05 0.00018607687708920069
+ 2.2356812984045651e-05 0.00018313034228189371
+ 2.2356836686387529e-05 0.00014383366601515549
+ 2.2356868011882671e-05 9.4073657435559923e-05
+ 2.2356899484892481e-05 6.6035424032815995e-05
+ 2.2356936032571159e-05 5.6945035749247703e-05
+ 2.2356976288076309e-05 6.3590711456523705e-05
+ 2.2357027574288809e-05 8.6146107574460649e-05
+ 2.2357093228698951e-05 -0.0002303154523429816
+ 2.2357140775218661e-05 -0.0020780723863622428
+ 2.2357188273020119e-05 -0.0069681414500656902
+ 2.2357201589947751e-05 -0.008369437605542332
+ 2.2357216159067729e-05 -0.0077646704250648466
+ 2.2357225713245942e-05 -0.0046052144528402712
+ 2.235723530271983e-05 0.0025680213923121738
+ 2.235724576550979e-05 0.017206213802034669
+ 2.2357258693438879e-05 0.047911184866137373
+ 2.235727186805121e-05 0.094618781322703932
+ 2.2357283722780129e-05 0.14882544818365301
+ 2.235729429963508e-05 0.20481199970058689
+ 2.2357307027593771e-05 0.27802953269082442
+ 2.235732098057103e-05 0.36159445431087611
+ 2.2357337732597639e-05 0.46215874924459638
+ 2.235735892106905e-05 0.58519341057823848
+ 2.2357387224323271e-05 0.73629946643256916
+ 2.2357422855155181e-05 0.89568691957887636
+ 2.235746347837755e-05 1.0276989023338921
+ 2.2357521104612619e-05 1.1356250785115929
+ 2.2357563979678171e-05 1.173304069324961
+ 2.2357611370467621e-05 1.1919578820577399
+ 2.2357662308506069e-05 1.199241138668512
+ 2.2357723179278471e-05 1.2013686620410899
+ 2.2357802257562201e-05 1.2012582086955219
+ 2.2357915968030908e-05 1.2005338612976271
+ 2.2358044126001151e-05 1.200102110466656
+ 2.2358172380804972e-05 1.199983149188586
+ 2.2358296043963969e-05 1.199977649443259
+ 2.2358416330725291e-05 1.1999899461704611
+ 2.2358545021708292e-05 1.199997728650674
+ 2.2358664105913171e-05 1.200000004275374
+ 2.235878835004652e-05 1.200000308125317
+ 2.235890609548371e-05 1.20000014609788
+ 2.2359027447399111e-05 1.2000000143414731
+ 2.2359145037705279e-05 1.199999965505953
+ 2.23592652072454e-05 1.1999999557327441
+ 2.2359383133468941e-05 1.1999999575988809
+ 2.2359502793710499e-05 1.1999999614072501
+ 2.235958143225515e-05 1.199999972175108
+ 2.2359630310931579e-05 1.1999999932621881
+ 2.235967803336237e-05 1.199999992539373
+ 2.2359745317998081e-05 1.1999999445225791
+ 2.2359810465127031e-05 1.1999999118529641
+ 2.2359841101807659e-05 1.199999883112792
+ 2.2359863849833572e-05 1.199999832020834
+ 2.235988480617417e-05 1.1999997617186611
+ 2.2359907133014271e-05 1.1999996762577549
+ 2.235993386138198e-05 1.199999674283126
+ 2.2359953375862919e-05 1.1999999347347921
+ 2.235997761187967e-05 1.200000214814724
+ 2.2360021404898181e-05 1.2000003239632919
+ 2.236006902110276e-05 1.200000176669981
+ 2.236012855656766e-05 1.199999979986454
+ 2.23602005759164e-05 1.199999877293165
+ 2.2360274785217712e-05 1.199999874182341
+ 2.2360363094082849e-05 1.1999999166101181
+ 2.2360462325127528e-05 1.1999999571545339
+ 2.236057397162072e-05 1.19999997294441
+ 2.2360719033213059e-05 1.199999969875871
+ 2.236092834111133e-05 1.1999999619767101
+ 2.236132449441362e-05 1.199999958818601
+ 2.236169689260198e-05 1.1999999598165081
+ 2.2362254351509839e-05 1.1999999605082929
+ 2.2362844361693469e-05 1.1999999605453
+ 2.2363389383066591e-05 1.1999999604407401
+ 2.2363895503021711e-05 1.1999999604716309
+ 2.236425697763802e-05 1.1999999606157361
+ 2.2364668642840499e-05 1.1999999604429969
+ 2.2365139236134588e-05 1.1999999604542859
+ 2.236573367053688e-05 1.1999999604774609
+ 2.236642903459584e-05 1.199999960482462
+ 2.2367476200860341e-05 1.1999999604818401
+ 2.236900868752917e-05 1.1999999604809919
+ 2.2371662919145399e-05 1.199999960480931
+ 2.237585873271225e-05 1.199999960480931
+ 2.2380858732712251e-05 1.1999999604808731
+ 2.2385858732712251e-05 1.199999960480858
+ 2.2390858732712249e-05 1.199999960480862
+ 2.239585873271225e-05 1.199999960480866
+ 2.240085873271225e-05 1.199999960480868
+ 2.2405858732712251e-05 1.199999960480868
+ 2.2410858732712249e-05 1.199999960480868
+ 2.2415858732712249e-05 1.199999960480868
+ 2.242085873271225e-05 1.199999960480868
+ 2.2425858732712251e-05 1.199999960480868
+ 2.2430858732712259e-05 1.199999960480868
+ 2.2435858732712259e-05 1.199999960480868
+ 2.244085873271226e-05 1.199999960480868
+ 2.2445858732712261e-05 1.199999960480868
+ 2.2450858732712258e-05 1.199999960480868
+ 2.2455858732712259e-05 1.199999960480868
+ 2.246085873271226e-05 1.199999960480868
+ 2.2465858732712261e-05 1.199999960480868
+ 2.2470858732712262e-05 1.199999960480868
+ 2.2475858732712259e-05 1.199999960480868
+ 2.248085873271226e-05 1.199999960480868
+ 2.2485858732712261e-05 1.199999960480868
+ 2.2490858732712261e-05 1.199999960480868
+ 2.2495858732712269e-05 1.199999960480868
+ 2.250085873271227e-05 1.199999960480868
+ 2.2505858732712271e-05 1.199999960480868
+ 2.2510858732712271e-05 1.199999960480868
+ 2.2515858732712269e-05 1.199999960480868
+ 2.252085873271227e-05 1.199999960480868
+ 2.252585873271227e-05 1.199999960480868
+ 2.2530858732712271e-05 1.199999960480868
+ 2.2535858732712269e-05 1.199999960480868
+ 2.2540858732712269e-05 1.199999960480868
+ 2.254585873271227e-05 1.199999960480868
+ 2.2550858732712271e-05 1.199999960480868
+ 2.2555858732712279e-05 1.199999960480868
+ 2.2560858732712279e-05 1.199999960480868
+ 2.256585873271228e-05 1.199999960480868
+ 2.2570858732712281e-05 1.199999960480868
+ 2.2575858732712278e-05 1.199999960480868
+ 2.2580858732712279e-05 1.199999960480868
+ 2.258585873271228e-05 1.199999960480868
+ 2.2590858732712281e-05 1.199999960480868
+ 2.2595858732712282e-05 1.1999999604808671
+ 2.2600858732712279e-05 1.1999999604808671
+ 2.260585873271228e-05 1.1999999604808651
+ 2.2610858732712281e-05 1.1999999604808631
+ 2.2615858732712281e-05 1.199999960480858
+ 2.2620858732712289e-05 1.1999999604808489
+ 2.262585873271229e-05 1.199999960480832
+ 2.2630858732712291e-05 1.199999960480798
+ 2.2635858732712291e-05 1.1999999604807341
+ 2.2640858732712289e-05 1.1999999604806111
+ 2.264585873271229e-05 1.199999960480377
+ 2.265085873271229e-05 1.1999999604799441
+ 2.2655858732712291e-05 1.1999999604791769
+ 2.2660858732712289e-05 1.19999996047783
+ 2.2665858732712289e-05 1.199999960475195
+ 2.267085873271229e-05 1.199999960466499
+ 2.2673801301111999e-05 1.19999996040753
+ 2.267554222436978e-05 1.199999960146338
+ 2.2677548585721029e-05 1.199999960158816
+ 2.267917090956039e-05 1.1999999603829421
+ 2.268119096018437e-05 1.199999960458467
+ 2.268269214507812e-05 1.199999960525544
+ 2.2683244094527969e-05 1.1999999613199139
+ 2.2683756532133701e-05 1.1999999621152659
+ 2.2684038501057701e-05 1.199999964812609
+ 2.2684339864532559e-05 1.199999967312495
+ 2.2684570777206269e-05 1.199999960390925
+ 2.2684787375434351e-05 1.1999999053187009
+ 2.268499977284321e-05 1.1999998559339351
+ 2.2685244323191778e-05 1.1999997981250961
+ 2.2685347732356941e-05 1.1999995042753531
+ 2.268540683791202e-05 1.1999990468459409
+ 2.268545569350033e-05 1.1999986509552221
+ 2.268551395518925e-05 1.1999981992127451
+ 2.268557982057994e-05 1.1999979342335709
+ 2.268565374085235e-05 1.1999985053683659
+ 2.2685694224705111e-05 1.1999992521236349
+ 2.268571600827814e-05 1.199999730145491
+ 2.26857355052205e-05 1.1999999465640281
+ 2.2685753539440631e-05 1.199999940966654
+ 2.2685776724364179e-05 1.200001788729222
+ 2.2685803764210269e-05 1.2000065560175399
+ 2.2685828218936491e-05 1.2000102917147231
+ 2.2685850256367361e-05 1.2000105012538811
+ 2.26858678852637e-05 1.2000086736828599
+ 2.2685887210299999e-05 1.2000051771387299
+ 2.2685901502916439e-05 1.200002355004151
+ 2.268591759462922e-05 1.200000023617191
+ 2.268594483919861e-05 1.199998076986909
+ 2.2685974200135859e-05 1.19999733639979
+ 2.2686000795891859e-05 1.1999970668798201
+ 2.2686024909548581e-05 1.1999973962851811
+ 2.2686050672774661e-05 1.199998965793911
+ 2.268607656607362e-05 1.200001585242888
+ 2.268610584065176e-05 1.20000452963993
+ 2.268613222987819e-05 1.200006586676031
+ 2.2686150799516032e-05 1.2000079048906089
+ 2.2686166537314971e-05 1.2000092187349281
+ 2.2686182131645671e-05 1.200011113492415
+ 2.2686195847543951e-05 1.200012948026308
+ 2.2686211512286661e-05 1.2000131763966879
+ 2.2686222445539411e-05 1.200012158876038
+ 2.268623684186698e-05 1.200010044159826
+ 2.2686261298016701e-05 1.2000057466266361
+ 2.268628398322975e-05 1.199994615913172
+ 2.268630769999175e-05 1.1999501345615671
+ 2.268632934563489e-05 1.1998767603709719
+ 2.2686358184029761e-05 1.199740198954856
+ 2.2686399813431669e-05 1.199448144319144
+ 2.2686419010977729e-05 1.200169063665526
+ 2.268643566969861e-05 1.202636946517146
+ 2.2686460309789979e-05 1.210356723210239
+ 2.2686483307021488e-05 1.214170916129089
+ 2.268649909168919e-05 1.197511213421528
+ 2.26865164436296e-05 1.14535103037063
+ 2.2686534483677179e-05 1.0603693128931
+ 2.2686551823558561e-05 0.96191724656874977
+ 2.2686573904633349e-05 0.82862721437660269
+ 2.2686594698231181e-05 0.70274199385594083
+ 2.2686608935925371e-05 0.6182639022040215
+ 2.2686620218407481e-05 0.5529571972679892
+ 2.2686635227834082e-05 0.46905526475722981
+ 2.268664599275468e-05 0.41140783730647501
+ 2.2686659903522959e-05 0.34096876488043548
+ 2.2686679535712489e-05 0.25183315223252328
+ 2.2686702939626611e-05 0.16530953267721021
+ 2.26867249267321e-05 0.1051458722646848
+ 2.2686747099875901e-05 0.063414112520969179
+ 2.2686763939557609e-05 0.042180183659568347
+ 2.2686781567062021e-05 0.02709090078417269
+ 2.2686803592161241e-05 0.01515283569350708
+ 2.2686824132273509e-05 0.0086145983838595199
+ 2.268685046326872e-05 0.0039617249148536588
+ 2.2686877625014372e-05 0.001625679545737327
+ 2.2686913615830361e-05 0.00032060108714991202
+ 2.2686955151510899e-05 -0.00012324105694519821
+ 2.268701404691174e-05 -0.0001852475911831024
+ 2.2687093020743551e-05 -9.538905905763105e-05
+ 2.2687182785557789e-05 -2.4106198671585689e-05
+ 2.2687285503221719e-05 1.6310616269001909e-06
+ 2.2687417433579949e-05 4.3407246576128611e-06
+ 2.2687603182380381e-05 1.4877819998559101e-06
+ 2.2687749321732919e-05 2.6561314980680449e-07
+ 2.2687874647841582e-05 1.957246551737014e-08
+ 2.268799085884886e-05 2.212370120384332e-08
+ 2.2688107544624068e-05 4.8880731178543352e-08
+ 2.2688233856144021e-05 6.1344494957263765e-08
+ 2.268835324541425e-05 6.463899360854537e-08
+ 2.2688477820823151e-05 6.6684535172990967e-08
+ 2.268859653113429e-05 6.9794257354841744e-08
+ 2.2688718255362881e-05 7.4744504773584351e-08
+ 2.2688836371514652e-05 8.7794855939212198e-08
+ 2.2688956657353131e-05 1.4284714519667809e-07
+ 2.268902510543729e-05 3.6337386084755591e-07
+ 2.2689074979977379e-05 6.3512660458835672e-07
+ 2.268913187696882e-05 6.0450464932891689e-07
+ 2.268919722980252e-05 1.385631679684293e-07
+ 2.2689234161942998e-05 -2.6720239932721198e-07
+ 2.2689260920840759e-05 -6.7889190002785915e-07
+ 2.2689284636667469e-05 -1.1668790029643151e-06
+ 2.2689307127689721e-05 -1.642005855592747e-06
+ 2.2689328459864761e-05 -1.7241778915702519e-06
+ 2.2689354496766251e-05 -1.6852965895093561e-06
+ 2.268937307496845e-05 -1.67401468083354e-06
+ 2.268939663375847e-05 -4.465702936343972e-07
+ 2.268943567489103e-05 1.17647381688681e-06
+ 2.26894776927185e-05 1.3829678399757401e-06
+ 2.2689536455030601e-05 6.8268471067799731e-07
+ 2.2689605342265018e-05 1.510904735246186e-07
+ 2.2689684275546811e-05 2.956770135949698e-08
+ 2.2689769106149609e-05 -1.6602077243341799e-08
+ 2.2689869155347621e-05 -3.3272692428499352e-09
+ 2.2689985121614988e-05 4.9430581300098423e-08
+ 2.2690112687286231e-05 7.3975949936351646e-08
+ 2.2690284560285659e-05 6.971842651744401e-08
+ 2.2690534734955169e-05 6.1593826603178613e-08
+ 2.2690848771476091e-05 6.0795531358123786e-08
+ 2.2691208016097139e-05 6.1764110386901474e-08
+ 2.269164666321146e-05 6.202953135082216e-08
+ 2.269217922661395e-05 6.2058930609612098e-08
+ 2.269277741122437e-05 6.1546127863336278e-08
+ 2.269317243178909e-05 6.0312048089227026e-08
+ 2.269350938132681e-05 6.3093965293625058e-08
+ 2.2693934724739251e-05 6.2183380508885573e-08
+ 2.2694408947046148e-05 6.1730437862925106e-08
+ 2.2694967757528001e-05 6.1913317286834914e-08
+ 2.2695558453284008e-05 6.1920885939889949e-08
+ 2.2696387633071469e-05 6.1919002264167071e-08
+ 2.2697539895981549e-05 6.1921846937535533e-08
+ 2.269957592132923e-05 6.1921390602897856e-08
+ 2.2702633447956781e-05 6.1921010380893086e-08
+ 2.2707633447956789e-05 6.1920982176803546e-08
+ 2.271263344795679e-05 6.1920995014956614e-08
+ 2.271763344795679e-05 6.1920997713497745e-08
+ 2.2722633447956791e-05 6.1920998156571759e-08
+ 2.2727633447956789e-05 6.1920998102357839e-08
+ 2.273263344795679e-05 6.1920998114930891e-08
+ 2.273763344795679e-05 6.1920998004056992e-08
+ 2.2742633447956791e-05 6.192099806237844e-08
+ 2.2747633447956789e-05 6.1920998377787727e-08
+ 2.2752633447956789e-05 6.1920998127945076e-08
+ 2.275763344795679e-05 6.1920997945981263e-08
+ 2.2762633447956791e-05 6.1920998048218801e-08
+ 2.2767633447956798e-05 6.1920998099132549e-08
+ 2.2772633447956799e-05 6.1920998143065051e-08
+ 2.27776334479568e-05 6.1920997917900916e-08
+ 2.2782633447956801e-05 6.1920998299069475e-08
+ 2.2787633447956802e-05 6.1920998050736938e-08
+ 2.2792633447956799e-05 6.1920998372149651e-08
+ 2.27976334479568e-05 6.1920998159807637e-08
+ 2.2802633447956801e-05 6.1920998216773673e-08
+ 2.2807633447956801e-05 6.192099808009371e-08
+ 2.2812633447956799e-05 6.1920998061904419e-08
+ 2.28176334479568e-05 6.1920998128052782e-08
+ 2.28226334479568e-05 6.1920997958913577e-08
+ 2.2827633447956801e-05 6.1920997964966514e-08
+ 2.2832633447956809e-05 6.1920998344837127e-08
+ 2.283763344795681e-05 6.1920998085233096e-08
+ 2.284263344795681e-05 6.1920998128976577e-08
+ 2.2847633447956811e-05 6.1920998253591429e-08
+ 2.2852633447956809e-05 6.192099803808531e-08
+ 2.2857633447956809e-05 6.1920998086250131e-08
+ 2.286263344795681e-05 6.1920998136798767e-08
+ 2.2867633447956811e-05 6.1920998146792592e-08
+ 2.2872633447956808e-05 6.1920998259242939e-08
+ 2.2877633447956809e-05 6.192099826186391e-08
+ 2.288263344795681e-05 6.1920998139800163e-08
+ 2.2887633447956811e-05 6.1920998207802151e-08
+ 2.2892633447956818e-05 6.1920997962034496e-08
+ 2.2897633447956819e-05 6.1920998030691784e-08
+ 2.290263344795682e-05 6.192099808460743e-08
+ 2.2907633447956821e-05 6.1920998103291322e-08
+ 2.2912633447956822e-05 6.1920998171637908e-08
+ 2.2917633447956819e-05 6.1920998232833762e-08
+ 2.292263344795682e-05 6.1920998048675207e-08
+ 2.2927633447956821e-05 6.1920998066822861e-08
+ 2.2932633447956821e-05 6.1920998181767469e-08
+ 2.2937633447956819e-05 6.1920997965217011e-08
+ 2.294263344795682e-05 6.192099827275232e-08
+ 2.294763344795682e-05 6.192099810742344e-08
+ 2.2952633447956821e-05 6.1920998192839923e-08
+ 2.2957633447956829e-05 6.1920997950009262e-08
+ 2.296263344795683e-05 6.1920998052799053e-08
+ 2.296763344795683e-05 6.1920998004620004e-08
+ 2.2972633447956831e-05 6.192099818322504e-08
+ 2.2977633447956829e-05 6.1920997960678357e-08
+ 2.2982633447956829e-05 6.1920998083752098e-08
+ 2.298763344795683e-05 6.1920998054179955e-08
+ 2.2992633447956831e-05 6.1920997750505488e-08
+ 2.2997633447956828e-05 6.1920997070637034e-08
+ 2.3002633447956829e-05 6.1920993509339271e-08
+ 2.300471863961737e-05 6.1920902795117243e-08
+ 2.3006545474688689e-05 6.1920914389815277e-08
+ 2.3008430739697641e-05 6.1921195385528629e-08
+ 2.3009969977635579e-05 6.1921054638874031e-08
+ 2.3011647340380871e-05 6.1920807457762059e-08
+ 2.3012669895446141e-05 6.1921274195099935e-08
+ 2.3013042691329731e-05 6.1921881166367934e-08
+ 2.3013584973212219e-05 6.1920898342086699e-08
+ 2.3013890580672869e-05 6.1925283702515985e-08
+ 2.3014135246740091e-05 6.1916464383277087e-08
+ 2.30143356695803e-05 6.1820205782767402e-08
+ 2.3014543576200799e-05 6.1868149100703105e-08
+ 2.301478478796701e-05 6.1978501719214794e-08
+ 2.3014932970842831e-05 6.127787636818639e-08
+ 2.301499797885631e-05 5.7423957895700312e-08
+ 2.301505265596338e-05 5.5730878716706101e-08
+ 2.3015096050804242e-05 5.9376772326321451e-08
+ 2.3015160614434939e-05 9.0788349865505387e-08
+ 2.301522658504539e-05 1.303879488829277e-07
+ 2.3015292142185049e-05 1.717876720372451e-07
+ 2.301532170790431e-05 3.3063724871932438e-07
+ 2.3015342310719981e-05 6.5019949512160461e-07
+ 2.3015364064148229e-05 7.8363376775460682e-07
+ 2.3015391569326909e-05 2.6634629095528872e-07
+ 2.301541470125783e-05 -7.6479485865707538e-07
+ 2.3015435689686239e-05 -2.6392342343337851e-06
+ 2.3015454666841759e-05 -4.1888463339186994e-06
+ 2.301546977487819e-05 -5.0017364711651627e-06
+ 2.3015484328695888e-05 -4.671805535078953e-06
+ 2.301549446457373e-05 -2.5173205005956681e-06
+ 2.3015507067095061e-05 -6.4841102550719939e-07
+ 2.301552388243847e-05 -5.1633207479956916e-07
+ 2.3015542771198059e-05 -1.6065181707625429e-06
+ 2.301556718947545e-05 -2.6513232242528591e-06
+ 2.3015592180521629e-05 -3.3051641674023121e-06
+ 2.3015615386999052e-05 -3.3430319736564902e-06
+ 2.301563961213292e-05 -2.0419861814499391e-06
+ 2.3015662450584709e-05 -5.5297536195541497e-07
+ 2.3015689047423651e-05 -5.0985961619876223e-07
+ 2.301571678201208e-05 -1.706695870982555e-06
+ 2.3015746389151212e-05 -2.9732160876766991e-06
+ 2.3015769785556359e-05 -3.694203848421133e-06
+ 2.301579817137059e-05 -3.7263808757070199e-06
+ 2.3015820652379181e-05 -6.1844709532527095e-07
+ 2.3015838842356541e-05 2.2150685393782528e-06
+ 2.3015856183262819e-05 -9.6627561586890863e-06
+ 2.3015874088557139e-05 -6.1858989376153937e-05
+ 2.3015896230208231e-05 -0.00015368680848383681
+ 2.3015918824803151e-05 -0.0001830624865784386
+ 2.3015932174589339e-05 -0.00011312987510219629
+ 2.3015946384066971e-05 1.7112938098530431e-05
+ 2.3015963864235221e-05 0.00014710607399587609
+ 2.3015980637286671e-05 0.00019144068013021839
+ 2.3016003557302938e-05 0.00017491699703145981
+ 2.301602852446207e-05 0.00013159641773674899
+ 2.3016060004158741e-05 8.5599374701356875e-05
+ 2.3016092787089248e-05 6.2188547788256509e-05
+ 2.3016129882680201e-05 5.7335298045250283e-05
+ 2.3016172482613469e-05 6.7794202350978254e-05
+ 2.3016226399868048e-05 8.4970673315213854e-05
+ 2.3016296055662808e-05 -0.00064736774287091207
+ 2.3016341100537678e-05 -0.0033303053604159072
+ 2.3016380872512041e-05 -0.0076174337198402654
+ 2.3016390099293151e-05 -0.0083215290125719463
+ 2.3016406016707659e-05 -0.0060601597089450076
+ 2.301641719263481e-05 0.0006849296074002381
+ 2.3016428085873151e-05 0.014162559269599849
+ 2.3016440185672771e-05 0.040084027281608939
+ 2.301645311191266e-05 0.082179182267512377
+ 2.3016471528048819e-05 0.16513977026380111
+ 2.3016484780759289e-05 0.23720288810845039
+ 2.3016500352483829e-05 0.32856858282580659
+ 2.301651504508898e-05 0.41689671222666108
+ 2.3016534628627699e-05 0.53265417793628811
+ 2.3016558165445339e-05 0.66410918371874406
+ 2.301659152577512e-05 0.82797340396806263
+ 2.3016628932002199e-05 0.97122616084589131
+ 2.301667612361898e-05 1.0893861950765349
+ 2.301671162586722e-05 1.1406313093395339
+ 2.3016750844418359e-05 1.1722761996416859
+ 2.3016802486203639e-05 1.1919560435729599
+ 2.3016851446395182e-05 1.198767795870334
+ 2.3016920200608059e-05 1.2013060411426739
+ 2.3016998080786809e-05 1.2012207479581769
+ 2.3017122996642951e-05 1.2004979141499541
+ 2.3017255836101188e-05 1.2000935958215311
+ 2.301738487510488e-05 1.1999856165252589
+ 2.3017507459161711e-05 1.199980288061439
+ 2.3017626778242368e-05 1.199991023187335
+ 2.3017754188166098e-05 1.199997917627923
+ 2.3017872897995771e-05 1.199999979917084
+ 2.3017996731357731e-05 1.2000002677190009
+ 2.301811452250559e-05 1.200000127238954
+ 2.3018235777042979e-05 1.2000000096535559
+ 2.3018353454818371e-05 1.1999999654195661
+ 2.3018473567389929e-05 1.1999999563947159
+ 2.301859153824431e-05 1.1999999581026981
+ 2.3018711159200541e-05 1.199999962343425
+ 2.3018777063721351e-05 1.1999999770323659
+ 2.3018823748966051e-05 1.199999995834403
+ 2.301887309675344e-05 1.1999999866211719
+ 2.301893778044792e-05 1.199999937486919
+ 2.3018984959037731e-05 1.1999999117368461
+ 2.3019012050120929e-05 1.1999998951171089
+ 2.3019037873205299e-05 1.1999998629344411
+ 2.3019061199212989e-05 1.199999803100352
+ 2.301908417754906e-05 1.199999719282302
+ 2.301911302250655e-05 1.199999653491026
+ 2.3019135828657411e-05 1.199999878456895
+ 2.3019160831781389e-05 1.200000180272528
+ 2.3019194220977521e-05 1.2000003205172589
+ 2.3019248722817849e-05 1.200000198093893
+ 2.3019298707832999e-05 1.2000000204253529
+ 2.3019372561017421e-05 1.199999886951985
+ 2.3019455873380031e-05 1.1999998708074231
+ 2.3019552852649481e-05 1.1999999146025759
+ 2.301964856149662e-05 1.1999999550051419
+ 2.3019763163661519e-05 1.1999999728608981
+ 2.30199020808567e-05 1.1999999703286259
+ 2.3020117562817059e-05 1.1999999620634121
+ 2.3020518752001319e-05 1.199999958742985
+ 2.3020891739484639e-05 1.1999999597825619
+ 2.3021453549249409e-05 1.199999960512673
+ 2.3022044836192929e-05 1.1999999605490581
+ 2.3022589236424048e-05 1.199999960439146
+ 2.302310994693544e-05 1.1999999604791669
+ 2.3023480289926268e-05 1.1999999606095879
+ 2.302389856493852e-05 1.199999960439498
+ 2.3024376282745449e-05 1.199999960455727
+ 2.3024975211917159e-05 1.1999999604784319
+ 2.3025693251059471e-05 1.199999960482657
+ 2.3026774729600269e-05 1.1999999604817411
+ 2.3028387578486941e-05 1.199999960480955
+ 2.303115414879608e-05 1.1999999604809359
+ 2.3035608781068731e-05 1.1999999604809239
+ 2.3040608781068731e-05 1.19999996048087
+ 2.3045608781068729e-05 1.199999960480858
+ 2.305060878106873e-05 1.1999999604808631
+ 2.305560878106873e-05 1.1999999604808671
+ 2.3060608781068731e-05 1.199999960480868
+ 2.3065608781068729e-05 1.199999960480868
+ 2.3070608781068729e-05 1.199999960480868
+ 2.307560878106873e-05 1.199999960480868
+ 2.3080608781068731e-05 1.199999960480868
+ 2.3085608781068738e-05 1.199999960480868
+ 2.3090608781068739e-05 1.199999960480868
+ 2.309560878106874e-05 1.199999960480868
+ 2.3100608781068741e-05 1.199999960480868
+ 2.3105608781068738e-05 1.199999960480868
+ 2.3110608781068739e-05 1.199999960480868
+ 2.311560878106874e-05 1.199999960480868
+ 2.3120608781068741e-05 1.199999960480868
+ 2.3125608781068742e-05 1.199999960480868
+ 2.3130608781068739e-05 1.199999960480868
+ 2.313560878106874e-05 1.199999960480868
+ 2.3140608781068741e-05 1.199999960480868
+ 2.3145608781068741e-05 1.199999960480868
+ 2.3150608781068749e-05 1.199999960480868
+ 2.315560878106875e-05 1.199999960480868
+ 2.316060878106875e-05 1.199999960480868
+ 2.3165608781068751e-05 1.199999960480868
+ 2.3170608781068749e-05 1.199999960480868
+ 2.3175608781068749e-05 1.199999960480868
+ 2.318060878106875e-05 1.199999960480868
+ 2.3185608781068751e-05 1.199999960480868
+ 2.3190608781068749e-05 1.199999960480868
+ 2.3195608781068749e-05 1.199999960480868
+ 2.320060878106875e-05 1.199999960480868
+ 2.3205608781068751e-05 1.199999960480868
+ 2.3210608781068758e-05 1.199999960480868
+ 2.3215608781068759e-05 1.199999960480868
+ 2.322060878106876e-05 1.199999960480868
+ 2.3225608781068761e-05 1.199999960480868
+ 2.3230608781068762e-05 1.199999960480868
+ 2.3235608781068759e-05 1.199999960480868
+ 2.324060878106876e-05 1.199999960480868
+ 2.3245608781068761e-05 1.199999960480868
+ 2.3250608781068761e-05 1.199999960480868
+ 2.3255608781068759e-05 1.1999999604808671
+ 2.326060878106876e-05 1.199999960480866
+ 2.326560878106876e-05 1.1999999604808651
+ 2.3270608781068761e-05 1.199999960480862
+ 2.3275608781068769e-05 1.1999999604808571
+ 2.328060878106877e-05 1.1999999604808469
+ 2.328560878106877e-05 1.1999999604808289
+ 2.3290608781068771e-05 1.199999960480792
+ 2.3295608781068769e-05 1.1999999604807241
+ 2.3300608781068769e-05 1.199999960480592
+ 2.330560878106877e-05 1.19999996048034
+ 2.3310608781068771e-05 1.199999960479877
+ 2.3315608781068768e-05 1.1999999604790601
+ 2.3320608781068769e-05 1.1999999604776219
+ 2.332560878106877e-05 1.1999999604747189
+ 2.3330608781068771e-05 1.1999999604640179
+ 2.333320376790295e-05 1.199999960387182
+ 2.333490168459324e-05 1.199999960118878
+ 2.3336984322522441e-05 1.1999999601855891
+ 2.3338510717758939e-05 1.1999999604164411
+ 2.3340393463363311e-05 1.199999960433717
+ 2.3341633817765202e-05 1.199999960518336
+ 2.3342181530625849e-05 1.19999996104763
+ 2.3342827943271679e-05 1.1999999615437491
+ 2.3343155243136651e-05 1.1999999640664369
+ 2.3343458455802601e-05 1.1999999668646231
+ 2.3343696813527069e-05 1.1999999655591
+ 2.334390407550822e-05 1.1999999239847321
+ 2.334411945299235e-05 1.1999998684785791
+ 2.334436261025257e-05 1.1999998262979941
+ 2.3344491987583721e-05 1.199999652183954
+ 2.3344557800152011e-05 1.199999297407353
+ 2.334461579112852e-05 1.199998843956964
+ 2.3344661090271859e-05 1.1999985257422801
+ 2.3344728815268029e-05 1.1999980115375579
+ 2.334479870073413e-05 1.1999980835370661
+ 2.3344879559448501e-05 1.199999133103568
+ 2.3344904644901862e-05 1.1999996863732461
+ 2.334492463788905e-05 1.1999998072929869
+ 2.3344943177097522e-05 1.2000000787934519
+ 2.3344967721401861e-05 1.200002617862542
+ 2.3344995149288121e-05 1.200007863463703
+ 2.3345019559289451e-05 1.2000107323824849
+ 2.334504034914112e-05 1.200010170765845
+ 2.3345057526277481e-05 1.200007990515024
+ 2.3345072241438611e-05 1.2000050337310411
+ 2.3345088218329971e-05 1.200001950096373
+ 2.3345105386827091e-05 1.1999997054651039
+ 2.3345132134395111e-05 1.199998030544603
+ 2.334516181786851e-05 1.199997328834004
+ 2.3345189568740921e-05 1.199997082172884
+ 2.334521365566628e-05 1.199997564602304
+ 2.3345239017942511e-05 1.1999993239887361
+ 2.3345270183775791e-05 1.2000025059613411
+ 2.3345299578337341e-05 1.200005267418462
+ 2.3345323701787832e-05 1.2000070560546241
+ 2.334534020557281e-05 1.200008293003288
+ 2.3345355792109971e-05 1.200009733060807
+ 2.3345370658794291e-05 1.2000117677587649
+ 2.3345385394787631e-05 1.200013278586834
+ 2.334539871488237e-05 1.2000129917315709
+ 2.3345412936142129e-05 1.200011364179135
+ 2.3345428792421581e-05 1.200008810722375
+ 2.334545516879209e-05 1.2000030514173079
+ 2.3345482988454211e-05 1.1999723221168499
+ 2.3345508243662499e-05 1.19989985648205
+ 2.334553478611911e-05 1.1997849479362239
+ 2.3345570932460459e-05 1.1995089978679041
+ 2.3345594916855641e-05 1.1996700607735149
+ 2.334561109387747e-05 1.201019559467666
+ 2.3345629047823119e-05 1.204954874345624
+ 2.334565021347466e-05 1.2126702025762821
+ 2.334566677961008e-05 1.215681519871586
+ 2.334568082318914e-05 1.2038301104754829
+ 2.3345697035727718e-05 1.159923316275647
+ 2.3345714076280369e-05 1.083751747715848
+ 2.3345731706163481e-05 0.98586017562068684
+ 2.3345752986527091e-05 0.8579560749383357
+ 2.3345773470958649e-05 0.73339768441704656
+ 2.334578816356769e-05 0.64550552234258951
+ 2.334579939387238e-05 0.57983936855210083
+ 2.3345811954998992e-05 0.50843334181726108
+ 2.334582504720841e-05 0.43682600034319408
+ 2.334583773478611e-05 0.37086861889117712
+ 2.3345857578682971e-05 0.27691100215587322
+ 2.334588052197381e-05 0.18640728354351491
+ 2.334590289848026e-05 0.11943213059656831
+ 2.3345929830487089e-05 0.065051918010959386
+ 2.334594625369567e-05 0.043711070527799531
+ 2.33459630376296e-05 0.028730910108118561
+ 2.334598253653731e-05 0.017327742462138369
+ 2.3346003783153159e-05 0.0097483869430412349
+ 2.3346028105807571e-05 0.0048456922815728861
+ 2.3346055830494409e-05 0.0020101755439719642
+ 2.334608918302053e-05 0.00052589399844755514
+ 2.334613013428968e-05 -7.4113729380581147e-05
+ 2.3346183843209282e-05 -0.0001942461332692672
+ 2.3346258336594172e-05 -0.0001172426199882739
+ 2.3346349528766719e-05 -3.3670110812495303e-05
+ 2.334644560669484e-05 -1.412999581289523e-06
+ 2.3346573500709829e-05 4.6663008619559988e-06
+ 2.3346739847286638e-05 2.0740106541524721e-06
+ 2.3346879136673731e-05 4.4673791002842572e-07
+ 2.3347003993820139e-05 3.2776017215082547e-08
+ 2.334712240584706e-05 8.5067998891203635e-09
+ 2.334724093906067e-05 4.1298523444349773e-08
+ 2.3347370493551249e-05 5.9590226903128239e-08
+ 2.3347490539989381e-05 6.4034426681440467e-08
+ 2.334761632170619e-05 6.5833361056040842e-08
+ 2.3347734806799641e-05 6.8490331647930266e-08
+ 2.334785691040205e-05 7.2399909335554789e-08
+ 2.3347974739022389e-05 8.1064749710364599e-08
+ 2.3348095230570429e-05 1.107149065253958e-07
+ 2.3348187715403931e-05 2.4744903611057672e-07
+ 2.3348240994116021e-05 5.4892679885283349e-07
+ 2.3348292366444501e-05 6.8047503770114196e-07
+ 2.334836037520813e-05 3.2169302791027898e-07
+ 2.334840660230927e-05 -1.2706673956299309e-07
+ 2.3348434499912379e-05 -5.0938445627584379e-07
+ 2.3348460269643339e-05 -9.8325087522648366e-07
+ 2.3348483638936019e-05 -1.494943710894384e-06
+ 2.3348505260263859e-05 -1.7626477275445139e-06
+ 2.3348534098830119e-05 -1.6310170079151411e-06
+ 2.3348554745264849e-05 -1.7283695506269379e-06
+ 2.3348577755754321e-05 -6.5702254169911087e-07
+ 2.3348619334565899e-05 1.129044858210206e-06
+ 2.3348658663740839e-05 1.414255975719019e-06
+ 2.3348719536159371e-05 7.1591650200330537e-07
+ 2.3348784127868651e-05 1.7681324269244889e-07
+ 2.3348863816970852e-05 2.9934202811803047e-08
+ 2.3348948972334799e-05 -1.7028087950834211e-08
+ 2.3349049555900398e-05 -4.8072713636621576e-09
+ 2.3349165123386521e-05 4.7861670074016581e-08
+ 2.3349291735252919e-05 7.363649201532625e-08
+ 2.3349461242866691e-05 7.0074670866942355e-08
+ 2.33497068410905e-05 6.175922365533378e-08
+ 2.3350020733078359e-05 6.0756639437737886e-08
+ 2.335037528050581e-05 6.1737418699326468e-08
+ 2.3350812287070531e-05 6.2029559940216016e-08
+ 2.3351337008732462e-05 6.2057865741952831e-08
+ 2.3351953175132709e-05 6.1588415229878381e-08
+ 2.3352349162315129e-05 6.0290506578292265e-08
+ 2.335269140011093e-05 6.3046429447039785e-08
+ 2.3353123822698719e-05 6.2222625963506797e-08
+ 2.335358855925228e-05 6.1726938867600569e-08
+ 2.335413817855846e-05 6.19103479607809e-08
+ 2.3354730175411129e-05 6.1922242108457667e-08
+ 2.3355551547310349e-05 6.1919150281955644e-08
+ 2.3356706515881591e-05 6.1921756459217025e-08
+ 2.3358712679278878e-05 6.1921387288016458e-08
+ 2.3361758300121841e-05 6.1921012607975851e-08
+ 2.3366758300121838e-05 6.1920982339455643e-08
+ 2.3371758300121839e-05 6.1920994940837552e-08
+ 2.337675830012184e-05 6.1920997753534954e-08
+ 2.3381758300121841e-05 6.1920997983694531e-08
+ 2.3386758300121848e-05 6.1920998304214605e-08
+ 2.3391758300121849e-05 6.1920998137522306e-08
+ 2.339675830012185e-05 6.1920998222495182e-08
+ 2.3401758300121851e-05 6.1920998000923367e-08
+ 2.3406758300121852e-05 6.1920998124478964e-08
+ 2.3411758300121849e-05 6.1920998142064745e-08
+ 2.341675830012185e-05 6.192099817134494e-08
+ 2.3421758300121851e-05 6.1920998009604793e-08
+ 2.3426758300121851e-05 6.1920998355430624e-08
+ 2.3431758300121849e-05 6.1920998151626609e-08
+ 2.343675830012185e-05 6.1920998133654052e-08
+ 2.344175830012185e-05 6.1920998242038085e-08
+ 2.3446758300121851e-05 6.1920998287415056e-08
+ 2.3451758300121859e-05 6.1920998347969322e-08
+ 2.345675830012186e-05 6.1920998144408498e-08
+ 2.346175830012186e-05 6.1920997993208948e-08
+ 2.3466758300121861e-05 6.1920998005713828e-08
+ 2.3471758300121859e-05 6.1920998094862325e-08
+ 2.3476758300121859e-05 6.1920998143878917e-08
+ 2.348175830012186e-05 6.1920998134117749e-08
+ 2.3486758300121861e-05 6.1920998007682478e-08
+ 2.3491758300121858e-05 6.1920997993661767e-08
+ 2.3496758300121859e-05 6.1920998369400791e-08
+ 2.350175830012186e-05 6.1920998104145925e-08
+ 2.3506758300121861e-05 6.1920998191031455e-08
+ 2.3511758300121868e-05 6.1920998305664301e-08
+ 2.3516758300121869e-05 6.1920998045049522e-08
+ 2.352175830012187e-05 6.1920998336940053e-08
+ 2.3526758300121871e-05 6.1920998237213915e-08
+ 2.3531758300121872e-05 6.1920998195273237e-08
+ 2.3536758300121869e-05 6.1920998034396719e-08
+ 2.354175830012187e-05 6.1920998145219678e-08
+ 2.3546758300121871e-05 6.1920998136026075e-08
+ 2.3551758300121871e-05 6.1920997960298145e-08
+ 2.3556758300121869e-05 6.192099801702897e-08
+ 2.356175830012187e-05 6.1920998122553063e-08
+ 2.356675830012187e-05 6.1920998094290869e-08
+ 2.3571758300121871e-05 6.1920998174455166e-08
+ 2.3576758300121879e-05 6.1920998283246582e-08
+ 2.358175830012188e-05 6.1920998008449784e-08
+ 2.358675830012188e-05 6.1920998128729799e-08
+ 2.3591758300121881e-05 6.1920998183934325e-08
+ 2.3596758300121879e-05 6.1920998177611753e-08
+ 2.3601758300121879e-05 6.1920998005390089e-08
+ 2.360675830012188e-05 6.1920998312885972e-08
+ 2.3611758300121881e-05 6.1920998013743012e-08
+ 2.3616758300121878e-05 6.1920998138266239e-08
+ 2.3621758300121879e-05 6.1920998216377883e-08
+ 2.362675830012188e-05 6.1920998254067329e-08
+ 2.3631758300121881e-05 6.1920998156550424e-08
+ 2.3636758300121888e-05 6.1920998174450083e-08
+ 2.3641758300121889e-05 6.1920998028276125e-08
+ 2.364675830012189e-05 6.1920997942688462e-08
+ 2.3651758300121891e-05 6.1920997849507519e-08
+ 2.3656758300121892e-05 6.1920997158055691e-08
+ 2.3661758300121889e-05 6.1920993475675945e-08
+ 2.366385569819168e-05 6.1920906999539408e-08
+ 2.3665675831769022e-05 6.1920905869616012e-08
+ 2.3667593142659248e-05 6.192119488280359e-08
+ 2.36691186205829e-05 6.1921064030448065e-08
+ 2.3670793802943139e-05 6.1920800484960116e-08
+ 2.3671823159384769e-05 6.192126769918936e-08
+ 2.3672201983481921e-05 6.192182683194702e-08
+ 2.3672755053054171e-05 6.192091626250209e-08
+ 2.367306297236117e-05 6.192518134638776e-08
+ 2.3673308244794159e-05 6.1917833627868733e-08
+ 2.3673508785441771e-05 6.182778463753965e-08
+ 2.3673717351255961e-05 6.1857039761468543e-08
+ 2.3673960346538849e-05 6.198235977260326e-08
+ 2.3674117333609639e-05 6.1362887339677303e-08
+ 2.36741843396133e-05 5.7461089020916691e-08
+ 2.3674238636481029e-05 5.55520292808212e-08
+ 2.3674282217071649e-05 5.94661807213405e-08
+ 2.3674346770787999e-05 9.1140581399717307e-08
+ 2.3674412632374671e-05 1.306267917979372e-07
+ 2.3674477796693819e-05 1.719256603840615e-07
+ 2.3674507268927249e-05 3.2934383351346978e-07
+ 2.3674527904824269e-05 6.4755526343772818e-07
+ 2.367454958624542e-05 7.8533580167091688e-07
+ 2.3674577030900899e-05 2.7292929479347228e-07
+ 2.36746002576521e-05 -7.5040862999133593e-07
+ 2.36746212559225e-05 -2.619185016467448e-06
+ 2.3674640164353711e-05 -4.1750052083891948e-06
+ 2.367465532542179e-05 -4.9863007308256698e-06
+ 2.3674669752558979e-05 -4.7215065910983934e-06
+ 2.367467983341089e-05 -2.5807781370472362e-06
+ 2.3674692408849749e-05 -6.7178950241137976e-07
+ 2.3674708957900691e-05 -4.9086427869246632e-07
+ 2.3674727736307851e-05 -1.568127005322251e-06
+ 2.367475206420725e-05 -2.625932301891774e-06
+ 2.3674776999292331e-05 -3.2851161376526081e-06
+ 2.367480294359485e-05 -3.3143565889685051e-06
+ 2.3674826601605669e-05 -1.9766756640273989e-06
+ 2.3674849585382511e-05 -5.2155722619430201e-07
+ 2.367487657618409e-05 -5.5787072070984947e-07
+ 2.3674907016675489e-05 -1.891176099141554e-06
+ 2.3674935279581549e-05 -3.05212109378741e-06
+ 2.3674957206936951e-05 -3.7143084492400959e-06
+ 2.3674984613393179e-05 -3.6452371653115632e-06
+ 2.367500525073211e-05 -7.5705679545112297e-07
+ 2.3675022813921379e-05 2.2645000290154322e-06
+ 2.3675039985187961e-05 -6.4373912589855836e-06
+ 2.3675057785020051e-05 -5.3652034311101053e-05
+ 2.3675080303719521e-05 -0.00014690098385233301
+ 2.3675101321958649e-05 -0.0001881607307655767
+ 2.3675114280117111e-05 -0.00013751004108822259
+ 2.3675127767570659e-05 -2.0361302086517409e-05
+ 2.36751431338395e-05 0.0001126588612306361
+ 2.3675159256086958e-05 0.00018349786982903911
+ 2.3675182481305629e-05 0.00018552491090445281
+ 2.3675205494521081e-05 0.00014742212603810741
+ 2.3675237124617999e-05 9.5875705703669641e-05
+ 2.367526781087244e-05 6.7058164736666549e-05
+ 2.3675304695730289e-05 5.6841668637190327e-05
+ 2.367534410183868e-05 6.2754277836388108e-05
+ 2.367539532116025e-05 8.5268222977148245e-05
+ 2.367545952471862e-05 -0.0001706865379873522
+ 2.3675507858831249e-05 -0.001858030466456963
+ 2.3675554126099369e-05 -0.0064095381170381866
+ 2.3675569044634682e-05 -0.0081669656394789056
+ 2.3675583484473058e-05 -0.0082817928942616834
+ 2.3675592610712621e-05 -0.0062895312010027996
+ 2.3675602686401849e-05 -0.00040914541175080459
+ 2.3675613258667629e-05 0.012176853547649351
+ 2.3675626341969249e-05 0.040096745758277652
+ 2.3675638781825391e-05 0.080799113366446199
+ 2.367565527291999e-05 0.15422492439347871
+ 2.3675667145475219e-05 0.21771111665895271
+ 2.36756806992776e-05 0.2963971406791705
+ 2.3675695307612962e-05 0.38411538816448337
+ 2.3675712713548399e-05 0.48812576443258571
+ 2.3675735169143589e-05 0.61677066009965453
+ 2.3675765044086939e-05 0.77170617108913053
+ 2.3675801880433629e-05 0.92751586951134335
+ 2.3675844115653819e-05 1.052422180485985
+ 2.3675891343231438e-05 1.1342921672351809
+ 2.3675933045743159e-05 1.1712609918502619
+ 2.3675985889559711e-05 1.192467839218067
+ 2.3676033785242899e-05 1.199143117758158
+ 2.3676100400890701e-05 1.201474633204509
+ 2.3676175436001509e-05 1.201285062418239
+ 2.3676297038479589e-05 1.200505634658827
+ 2.367642898752526e-05 1.200086064737959
+ 2.3676558268352579e-05 1.199980043234484
+ 2.3676681323243549e-05 1.199978259896366
+ 2.367680091313713e-05 1.199990666286888
+ 2.3676928831908429e-05 1.1999980279365829
+ 2.3677047600340411e-05 1.2000000806702771
+ 2.3677171630483501e-05 1.200000307966381
+ 2.3677289369473621e-05 1.2000001361530259
+ 2.3677410699238639e-05 1.2000000087964551
+ 2.36775283259247e-05 1.199999963757173
+ 2.36776484843302e-05 1.199999955562973
+ 2.3677766424889571e-05 1.199999957802264
+ 2.367788607302307e-05 1.199999961894237
+ 2.367795757193779e-05 1.199999974498783
+ 2.3678005167268359e-05 1.199999994448445
+ 2.3678053475036461e-05 1.199999990073719
+ 2.367811937015919e-05 1.199999941605145
+ 2.367817652396129e-05 1.199999912016444
+ 2.3678205693095941e-05 1.19999988973246
+ 2.3678229712084179e-05 1.199999848044045
+ 2.3678251646278942e-05 1.1999997828215789
+ 2.3678274113138118e-05 1.1999996987105701
+ 2.3678301897167129e-05 1.199999658707489
+ 2.3678321978605622e-05 1.199999893326833
+ 2.3678346682735721e-05 1.2000001900077131
+ 2.36783835628874e-05 1.200000324766674
+ 2.3678435458719081e-05 1.200000194700888
+ 2.367848848461066e-05 1.200000009743313
+ 2.3678561230365261e-05 1.1999998848825331
+ 2.3678641607757201e-05 1.199999871486048
+ 2.367874345543782e-05 1.1999999169947559
+ 2.367883619537567e-05 1.1999999555396299
+ 2.367895508262624e-05 1.199999973197714
+ 2.367909152667806e-05 1.1999999701554309
+ 2.3679315359116931e-05 1.199999961764779
+ 2.3679711766279831e-05 1.1999999587667149
+ 2.3680091879143312e-05 1.199999959820089
+ 2.3680650566888409e-05 1.19999996051581
+ 2.368125152425569e-05 1.19999996054674
+ 2.3681793423690971e-05 1.1999999604359151
+ 2.3682333744879289e-05 1.199999960488636
+ 2.368271677941658e-05 1.1999999606012191
+ 2.36831448980321e-05 1.1999999604359179
+ 2.36836334501902e-05 1.1999999604576761
+ 2.3684239413020119e-05 1.199999960479587
+ 2.3684989807118659e-05 1.1999999604828471
+ 2.3686121116112572e-05 1.1999999604816109
+ 2.3687851790020599e-05 1.1999999604809171
+ 2.3690770475285879e-05 1.199999960480941
+ 2.3695631189990949e-05 1.199999960480914
+ 2.370063118999095e-05 1.199999960480866
+ 2.3705631189990951e-05 1.199999960480858
+ 2.3710631189990951e-05 1.1999999604808631
+ 2.3715631189990959e-05 1.1999999604808671
+ 2.372063118999096e-05 1.199999960480868
+ 2.3725631189990961e-05 1.199999960480868
+ 2.3730631189990961e-05 1.199999960480868
+ 2.3735631189990959e-05 1.199999960480868
+ 2.374063118999096e-05 1.199999960480868
+ 2.374563118999096e-05 1.199999960480868
+ 2.3750631189990961e-05 1.199999960480868
+ 2.3755631189990959e-05 1.199999960480868
+ 2.3760631189990959e-05 1.199999960480868
+ 2.376563118999096e-05 1.199999960480868
+ 2.3770631189990961e-05 1.199999960480868
+ 2.3775631189990969e-05 1.199999960480868
+ 2.3780631189990969e-05 1.199999960480868
+ 2.378563118999097e-05 1.199999960480868
+ 2.3790631189990971e-05 1.199999960480868
+ 2.3795631189990968e-05 1.199999960480868
+ 2.3800631189990969e-05 1.199999960480868
+ 2.380563118999097e-05 1.199999960480868
+ 2.3810631189990971e-05 1.199999960480868
+ 2.3815631189990972e-05 1.199999960480868
+ 2.3820631189990969e-05 1.199999960480868
+ 2.382563118999097e-05 1.199999960480868
+ 2.3830631189990971e-05 1.199999960480868
+ 2.3835631189990971e-05 1.199999960480868
+ 2.3840631189990979e-05 1.199999960480868
+ 2.384563118999098e-05 1.199999960480868
+ 2.3850631189990981e-05 1.199999960480868
+ 2.3855631189990981e-05 1.199999960480868
+ 2.3860631189990979e-05 1.199999960480868
+ 2.386563118999098e-05 1.199999960480868
+ 2.387063118999098e-05 1.199999960480868
+ 2.3875631189990981e-05 1.199999960480868
+ 2.3880631189990979e-05 1.199999960480868
+ 2.3885631189990979e-05 1.199999960480868
+ 2.389063118999098e-05 1.199999960480868
+ 2.3895631189990981e-05 1.199999960480868
+ 2.3900631189990989e-05 1.199999960480868
+ 2.3905631189990989e-05 1.199999960480868
+ 2.391063118999099e-05 1.199999960480868
+ 2.3915631189990991e-05 1.1999999604808671
+ 2.3920631189990988e-05 1.199999960480866
+ 2.3925631189990989e-05 1.1999999604808651
+ 2.393063118999099e-05 1.199999960480862
+ 2.3935631189990991e-05 1.199999960480856
+ 2.3940631189990992e-05 1.1999999604808449
+ 2.3945631189990989e-05 1.199999960480824
+ 2.395063118999099e-05 1.1999999604807841
+ 2.3955631189990991e-05 1.199999960480707
+ 2.3960631189990991e-05 1.19999996048056
+ 2.3965631189990999e-05 1.1999999604802809
+ 2.3970631189991e-05 1.1999999604797711
+ 2.3975631189991001e-05 1.199999960478872
+ 2.3980631189991001e-05 1.1999999604772831
+ 2.3985631189990999e-05 1.1999999604738889
+ 2.3990631189991e-05 1.199999960458606
+ 2.3992892347040281e-05 1.1999999603329039
+ 2.3994631640228461e-05 1.19999996007472
+ 2.3996769828071609e-05 1.1999999602565461
+ 2.3998208322411641e-05 1.199999960495179
+ 2.399991670962748e-05 1.1999999603719169
+ 2.4001006602802729e-05 1.1999999606231391
+ 2.4001463443558042e-05 1.1999999612173351
+ 2.4002120724107311e-05 1.19999996174567
+ 2.400245532815127e-05 1.1999999650110591
+ 2.4002719860346549e-05 1.199999968254448
+ 2.4002932275081222e-05 1.199999958850172
+ 2.4003143848907829e-05 1.1999999053990571
+ 2.4003355996933111e-05 1.1999998579406581
+ 2.4003600137710218e-05 1.199999802257393
+ 2.400370519763615e-05 1.1999995247405739
+ 2.4003765046045561e-05 1.199999081329771
+ 2.4003814678812059e-05 1.199998677073054
+ 2.4003870072094108e-05 1.199998253195603
+ 2.400393496403378e-05 1.199997931073755
+ 2.4004008057985641e-05 1.1999984042616161
+ 2.400405985830121e-05 1.199999298276001
+ 2.400407899039663e-05 1.1999996914009881
+ 2.400410019885537e-05 1.1999999148608
+ 2.40041190605086e-05 1.2000000504519499
+ 2.4004142324148041e-05 1.200002173253427
+ 2.4004169175331109e-05 1.200007156271073
+ 2.4004193625394739e-05 1.200010512649345
+ 2.4004214820137521e-05 1.200010374623556
+ 2.4004231909315349e-05 1.200008460769987
+ 2.4004250052936781e-05 1.200005065754145
+ 2.4004265304022979e-05 1.200002106952248
+ 2.4004281387269309e-05 1.199999882651156
+ 2.400430876532297e-05 1.1999980379481301
+ 2.4004338143338819e-05 1.199997328024091
+ 2.4004365192523621e-05 1.1999970714029871
+ 2.4004389134272381e-05 1.19999746083937
+ 2.4004414538476559e-05 1.1999990937010649
+ 2.4004441111563112e-05 1.2000018094604921
+ 2.400447109419203e-05 1.2000047653253449
+ 2.400449771014204e-05 1.2000067809254371
+ 2.4004515728154731e-05 1.2000080813817049
+ 2.400453147101337e-05 1.200009458208354
+ 2.400454669582978e-05 1.2000114308088621
+ 2.4004560658965911e-05 1.20001312488101
+ 2.4004575841704299e-05 1.200013069289031
+ 2.400458933938309e-05 1.2000116169406521
+ 2.4004603814610161e-05 1.2000093354525461
+ 2.4004629343968248e-05 1.200004406882377
+ 2.4004652312320939e-05 1.1999875118268659
+ 2.4004675932460481e-05 1.199933378043796
+ 2.4004705420009291e-05 1.1998204772700209
+ 2.4004734184434699e-05 1.199649921987455
+ 2.400477150650463e-05 1.199660214016973
+ 2.4004788933761791e-05 1.201061054547947
+ 2.4004807096993452e-05 1.2049758940390289
+ 2.4004829570023711e-05 1.213086839044599
+ 2.4004846584089919e-05 1.2149048940088469
+ 2.4004860778890161e-05 1.2000344738825299
+ 2.400487959710457e-05 1.142292788897616
+ 2.4004897240928479e-05 1.0574695052666581
+ 2.40049146930914e-05 0.95763103733620625
+ 2.4004936480351869e-05 0.82580282411909645
+ 2.4004957628906311e-05 0.69782532838325972
+ 2.400497197534666e-05 0.61284896904284514
+ 2.4004983346518399e-05 0.54718586694919236
+ 2.400499819214919e-05 0.46443232983108929
+ 2.400500919440924e-05 0.40574092821014912
+ 2.400502322121348e-05 0.33514193011505727
+ 2.4005042864030022e-05 0.24677638806026239
+ 2.400506634735953e-05 0.16118448931728691
+ 2.4005088308852968e-05 0.102260408155637
+ 2.4005108563018291e-05 0.06445182319659841
+ 2.4005124859144411e-05 0.043538588290103937
+ 2.4005142306206669e-05 0.028158923842686701
+ 2.4005164240092949e-05 0.01583421779343808
+ 2.4005184774606001e-05 0.0090243505129109589
+ 2.400521089881308e-05 0.0041929930354761237
+ 2.400523784429454e-05 0.001747525058002233
+ 2.400527329585972e-05 0.00037355220269481908
+ 2.400531417572926e-05 -0.0001084697397361765
+ 2.400537175269865e-05 -0.00018887560960534751
+ 2.4005448665259758e-05 -0.0001023856385470715
+ 2.4005539174876131e-05 -2.6784927715219739e-05
+ 2.4005639176535709e-05 7.8791399502912624e-07
+ 2.4005769908486101e-05 4.470731207781036e-06
+ 2.4005948048298819e-05 1.671125573195129e-06
+ 2.4006091570594e-05 3.1791356223320508e-07
+ 2.400621671802447e-05 2.1916651745802939e-08
+ 2.4006333780575841e-05 1.7559413603902239e-08
+ 2.4006451182394251e-05 4.6566892794400968e-08
+ 2.4006578684111701e-05 6.0834524699791842e-08
+ 2.4006698323512978e-05 6.4420788358260993e-08
+ 2.400682332988362e-05 6.6363658028421199e-08
+ 2.4006941955876641e-05 6.9307692641940524e-08
+ 2.4007063811010579e-05 7.3830260985426838e-08
+ 2.4007181821399708e-05 8.5017509875390373e-08
+ 2.4007302177885838e-05 1.2884311735229031e-07
+ 2.4007377747338129e-05 3.1414168074052918e-07
+ 2.4007428399000101e-05 5.99451506046792e-07
+ 2.4007482254856321e-05 6.4746760261219936e-07
+ 2.400754797529082e-05 2.301879786669057e-07
+ 2.400758384152601e-05 -1.5131020725931991e-07
+ 2.400761400131291e-05 -5.4622293402280015e-07
+ 2.400763844007048e-05 -9.883377304490598e-07
+ 2.400766149354347e-05 -1.4907022541356579e-06
+ 2.4007682920294482e-05 -1.753636013368401e-06
+ 2.400771165342436e-05 -1.625180945654206e-06
+ 2.400773221946968e-05 -1.728900662142703e-06
+ 2.4007755198859061e-05 -6.6527285860781985e-07
+ 2.4007796644691809e-05 1.12065969136928e-06
+ 2.4007835970291569e-05 1.414687016811863e-06
+ 2.4007896737868859e-05 7.2081247580396988e-07
+ 2.400796124177839e-05 1.7911686680844969e-07
+ 2.400804131057619e-05 2.9922918720986308e-08
+ 2.4008126507710369e-05 -1.6988030219451641e-08
+ 2.400822735881685e-05 -4.9697781314493353e-09
+ 2.4008342737663169e-05 4.7666240055864597e-08
+ 2.4008469477184861e-05 7.3629590650904202e-08
+ 2.4008638748654299e-05 7.0108545045383588e-08
+ 2.4008884567714728e-05 6.1763993402354134e-08
+ 2.400919829008697e-05 6.0754131540434537e-08
+ 2.4009553085788391e-05 6.1736912730500686e-08
+ 2.4009989970342881e-05 6.2029614761068351e-08
+ 2.4010514982985569e-05 6.2057918918153598e-08
+ 2.4011130894819399e-05 6.1588011846865614e-08
+ 2.4011526848488478e-05 6.0290598235720274e-08
+ 2.401186900710428e-05 6.3046950334593194e-08
+ 2.4012301350742191e-05 6.2222253212294876e-08
+ 2.4012766141603921e-05 6.1726983623225467e-08
+ 2.4013315805430369e-05 6.1910371604773265e-08
+ 2.4013907780877461e-05 6.1922229464592146e-08
+ 2.4014729159373421e-05 6.1919147913261994e-08
+ 2.401588403882439e-05 6.1921757678464876e-08
+ 2.4017890215289871e-05 6.1921387401700574e-08
+ 2.402093572339548e-05 6.1921012465003651e-08
+ 2.402593572339548e-05 6.1920982394918659e-08
+ 2.4030935723395481e-05 6.1920995138141463e-08
+ 2.4035935723395479e-05 6.1920997606707285e-08
+ 2.4040935723395479e-05 6.1920998047048414e-08
+ 2.404593572339548e-05 6.1920997986987266e-08
+ 2.4050935723395481e-05 6.192099802508968e-08
+ 2.4055935723395489e-05 6.1920998121880056e-08
+ 2.4060935723395489e-05 6.19209981747185e-08
+ 2.406593572339549e-05 6.1920998012370925e-08
+ 2.4070935723395491e-05 6.1920998083300511e-08
+ 2.4075935723395488e-05 6.1920998111280312e-08
+ 2.4080935723395489e-05 6.1920997961031358e-08
+ 2.408593572339549e-05 6.1920998228254582e-08
+ 2.4090935723395491e-05 6.1920998042664012e-08
+ 2.4095935723395492e-05 6.1920998108609127e-08
+ 2.4100935723395489e-05 6.1920998167986507e-08
+ 2.410593572339549e-05 6.1920998188536016e-08
+ 2.4110935723395491e-05 6.1920998226646834e-08
+ 2.4115935723395491e-05 6.1920998114809845e-08
+ 2.4120935723395499e-05 6.1920998148900235e-08
+ 2.41259357233955e-05 6.1920998176042413e-08
+ 2.4130935723395501e-05 6.1920998222364355e-08
+ 2.4135935723395501e-05 6.1920998284825253e-08
+ 2.4140935723395499e-05 6.1920998115253823e-08
+ 2.41459357233955e-05 6.1920998169986326e-08
+ 2.41509357233955e-05 6.1920998226007351e-08
+ 2.4155935723395501e-05 6.1920997987001705e-08
+ 2.4160935723395499e-05 6.1920998071077799e-08
+ 2.4165935723395499e-05 6.1920998148639666e-08
+ 2.41709357233955e-05 6.1920997938770379e-08
+ 2.4175935723395501e-05 6.1920997944651858e-08
+ 2.4180935723395509e-05 6.1920998289994615e-08
+ 2.4185935723395509e-05 6.192099813464831e-08
+ 2.419093572339551e-05 6.1920997899936856e-08
+ 2.4195935723395511e-05 6.1920998181088784e-08
+ 2.4200935723395508e-05 6.1920998256568048e-08
+ 2.4205935723395509e-05 6.1920998055251795e-08
+ 2.421093572339551e-05 6.1920998101895981e-08
+ 2.4215935723395511e-05 6.192099819473009e-08
+ 2.4220935723395512e-05 6.1920997964367384e-08
+ 2.4225935723395509e-05 6.1920997987714047e-08
+ 2.423093572339551e-05 6.1920998099752895e-08
+ 2.4235935723395511e-05 6.1920998114762491e-08
+ 2.4240935723395511e-05 6.1920998189944937e-08
+ 2.4245935723395519e-05 6.1920998259050609e-08
+ 2.425093572339552e-05 6.1920998037350469e-08
+ 2.4255935723395521e-05 6.1920998359866628e-08
+ 2.4260935723395521e-05 6.1920998119014212e-08
+ 2.4265935723395519e-05 6.192099823482331e-08
+ 2.427093572339552e-05 6.1920998346918763e-08
+ 2.427593572339552e-05 6.1920998141844622e-08
+ 2.4280935723395521e-05 6.1920998039978865e-08
+ 2.4285935723395519e-05 6.1920998093500098e-08
+ 2.4290935723395519e-05 6.1920997911092413e-08
+ 2.429593572339552e-05 6.1920998216961727e-08
+ 2.4300935723395521e-05 6.1920997917277169e-08
+ 2.4305935723395529e-05 6.1920997957583775e-08
+ 2.4310935723395529e-05 6.1920997957677994e-08
+ 2.431593572339553e-05 6.192099731338859e-08
+ 2.4320935723395531e-05 6.1920993234315681e-08
+ 2.4323033274281819e-05 6.1920906615897117e-08
+ 2.4324853253326659e-05 6.1920905822572067e-08
+ 2.432677094255887e-05 6.1921194960243048e-08
+ 2.4328296210166219e-05 6.1921064006791467e-08
+ 2.4329971347465431e-05 6.1920800337591828e-08
+ 2.4331000835896769e-05 6.1921267999608084e-08
+ 2.433137976125872e-05 6.192182501896441e-08
+ 2.433193298369095e-05 6.1920918095978729e-08
+ 2.4332240934093962e-05 6.1925177706083621e-08
+ 2.4332486214439489e-05 6.191785419508381e-08
+ 2.433268673438798e-05 6.1827899304524472e-08
+ 2.4332895301074498e-05 6.1856874391805614e-08
+ 2.433313833082784e-05 6.1982417875041927e-08
+ 2.433329548154505e-05 6.1364311076764673e-08
+ 2.4333362524572521e-05 5.7461729186350092e-08
+ 2.4333416813889839e-05 5.554858968222103e-08
+ 2.4333460398239802e-05 5.9468525995525902e-08
+ 2.4333524951369021e-05 9.1148626228669803e-08
+ 2.4333590810964119e-05 1.306322813203109e-07
+ 2.4333655966161369e-05 1.7192951092860071e-07
+ 2.4333685436071189e-05 3.2931776781196852e-07
+ 2.433370607270217e-05 6.4750046774143128e-07
+ 2.4333727752688271e-05 7.8536965134198145e-07
+ 2.4333755196053129e-05 2.7306465367032491e-07
+ 2.4333778424799719e-05 -7.5011341322774744e-07
+ 2.4333799423241342e-05 -2.6187691004082368e-06
+ 2.433381833022933e-05 -4.1747153194133074e-06
+ 2.433383349240605e-05 -4.9859801093889287e-06
+ 2.433384791695778e-05 -4.7225258490833889e-06
+ 2.4333857996709591e-05 -2.5820920410749218e-06
+ 2.4333870571632259e-05 -6.7228114098928026e-07
+ 2.4333887115259031e-05 -4.9035286198709768e-07
+ 2.4333905893411441e-05 -1.5674102877420021e-06
+ 2.433393021825032e-05 -2.6254243610329539e-06
+ 2.433395515214267e-05 -3.2847238222943392e-06
+ 2.4333981095092892e-05 -3.3148573405812459e-06
+ 2.433400476239593e-05 -1.9776788678934891e-06
+ 2.4334027744129061e-05 -5.2207525995848616e-07
+ 2.4334054729069551e-05 -5.5734539970767251e-07
+ 2.4334085176101511e-05 -1.890527542482188e-06
+ 2.4334113432635072e-05 -3.0513809735937938e-06
+ 2.4334135361604881e-05 -3.7138324433261559e-06
+ 2.433416277654247e-05 -3.6460920973977088e-06
+ 2.433418342849624e-05 -7.5661088956289711e-07
+ 2.433420099720278e-05 2.2643295676172188e-06
+ 2.4334218168764221e-05 -6.4559669902381166e-06
+ 2.4334235968891909e-05 -5.3701215433916413e-05
+ 2.433425848484357e-05 -0.0001469424440991744
+ 2.433427951299199e-05 -0.00018814186034562131
+ 2.433429247024764e-05 -0.00013739300605198609
+ 2.4334305960919179e-05 -2.0164834125189101e-05
+ 2.4334321333104881e-05 0.0001128346106039242
+ 2.433433745813865e-05 0.00018355326627335919
+ 2.4334360701948139e-05 0.0001854704973589658
+ 2.4334383712595482e-05 0.00014734378245597119
+ 2.433441535481788e-05 9.5799175447167545e-05
+ 2.4334446042907871e-05 6.7022948814552272e-05
+ 2.4334482938422411e-05 5.6839578529454102e-05
+ 2.4334522354559009e-05 6.2779165284807206e-05
+ 2.4334573599058568e-05 8.5307837882411363e-05
+ 2.4334637830009181e-05 -0.0001724987495633122
+ 2.4334686125085449e-05 -0.0018641062262529731
+ 2.4334732422635421e-05 -0.0064256623425321679
+ 2.4334747290567938e-05 -0.0081737352776531588
+ 2.4334761739458441e-05 -0.0082715020235895314
+ 2.4334770880199739e-05 -0.0062497360505162766
+ 2.433478093908874e-05 -0.00033644951054952562
+ 2.4334791504603061e-05 0.012297252968255731
+ 2.4334804583671411e-05 0.040288046149248642
+ 2.43348170380053e-05 0.0811241394057481
+ 2.4334833360007339e-05 0.153822185200193
+ 2.4334845171763441e-05 0.2169378380032983
+ 2.4334858680012909e-05 0.29531892389296732
+ 2.4334873261333729e-05 0.3828648147675372
+ 2.433489061885587e-05 0.48661758989717879
+ 2.4334913008373251e-05 0.61498940766307542
+ 2.4334942783176141e-05 0.76967856396025469
+ 2.433497956585813e-05 0.92578200372706065
+ 2.4335021684079211e-05 1.0510424986630711
+ 2.4335069648949219e-05 1.134525173002122
+ 2.4335111540212759e-05 1.1715496390583089
+ 2.433516440971037e-05 1.1926142494013821
+ 2.4335212356647481e-05 1.199213545806961
+ 2.4335278946696799e-05 1.2014893658218739
+ 2.4335354125170949e-05 1.2012818270119989
+ 2.433547602368015e-05 1.2004987138180729
+ 2.4335608085304461e-05 1.200082949126317
+ 2.4335737365891808e-05 1.199979355742296
+ 2.4335860383997598e-05 1.199978290641756
+ 2.433597994735405e-05 1.1999907740118749
+ 2.4336107826142721e-05 1.1999980823651979
+ 2.4336226586379829e-05 1.2000000969816551
+ 2.4336350602574928e-05 1.2000003091464411
+ 2.4336468344317459e-05 1.2000001346778619
+ 2.4336589669687752e-05 1.2000000078019639
+ 2.433670729969536e-05 1.199999963402016
+ 2.4336827455432659e-05 1.1999999555074961
+ 2.433694539783269e-05 1.1999999578241931
+ 2.433706504428506e-05 1.1999999619404911
+ 2.4337136108929501e-05 1.1999999746765491
+ 2.433718362953461e-05 1.199999994545442
+ 2.4337231995084091e-05 1.199999989870012
+ 2.433729779810558e-05 1.199999941353681
+ 2.433735430543803e-05 1.19999991201274
+ 2.4337383349490739e-05 1.199999890161171
+ 2.4337407476189991e-05 1.199999849157001
+ 2.433742949408531e-05 1.1999997843165551
+ 2.4337451986089311e-05 1.1999997002644951
+ 2.4337479847317358e-05 1.1999996580432879
+ 2.4337500124921482e-05 1.19999989209661
+ 2.4337524822438029e-05 1.2000001889716689
+ 2.433756139783977e-05 1.200000324492335
+ 2.4337613478479331e-05 1.2000001952565871
+ 2.4337666244734489e-05 1.200000010859398
+ 2.4337739010343579e-05 1.199999885194388
+ 2.4337819738463081e-05 1.1999998714057269
+ 2.4337920952441489e-05 1.199999916663556
+ 2.4338014050293101e-05 1.199999955447594
+ 2.4338132374744561e-05 1.1999999731525841
+ 2.4338269079880661e-05 1.1999999701834709
+ 2.4338491712346899e-05 1.199999961808538
+ 2.4338889126553009e-05 1.199999958762332
+ 2.4339268037425011e-05 1.199999959814344
+ 2.4339827434499439e-05 1.1999999605154681
+ 2.4340426791027101e-05 1.1999999605470939
+ 2.434096907085506e-05 1.1999999604363589
+ 2.4341506555618289e-05 1.1999999604873299
+ 2.4341887690755402e-05 1.199999960602443
+ 2.4342314315538391e-05 1.199999960436364
+ 2.434280121658608e-05 1.199999960457393
+ 2.4343406091685521e-05 1.19999996047943
+ 2.4344151672743629e-05 1.199999960482824
+ 2.43452754967446e-05 1.19999996048163
+ 2.43469883926257e-05 1.1999999604809219
+ 2.4349888616961861e-05 1.199999960480941
+ 2.4354684156133301e-05 1.1999999604809151
+ 2.4359684156133301e-05 1.199999960480866
+ 2.4364684156133299e-05 1.199999960480858
+ 2.43696841561333e-05 1.199999960480864
+ 2.43746841561333e-05 1.1999999604808671
+ 2.4379684156133301e-05 1.199999960480868
+ 2.4384684156133299e-05 1.199999960480868
+ 2.4389684156133299e-05 1.199999960480868
+ 2.43946841561333e-05 1.199999960480868
+ 2.4399684156133301e-05 1.199999960480868
+ 2.4404684156133309e-05 1.199999960480868
+ 2.4409684156133309e-05 1.199999960480868
+ 2.441468415613331e-05 1.199999960480868
+ 2.4419684156133311e-05 1.199999960480868
+ 2.4424684156133308e-05 1.199999960480868
+ 2.4429684156133309e-05 1.199999960480868
+ 2.443468415613331e-05 1.199999960480868
+ 2.4439684156133311e-05 1.199999960480868
+ 2.4444684156133312e-05 1.199999960480868
+ 2.4449684156133309e-05 1.199999960480868
+ 2.445468415613331e-05 1.199999960480868
+ 2.4459684156133311e-05 1.199999960480868
+ 2.4464684156133311e-05 1.199999960480868
+ 2.4469684156133319e-05 1.199999960480868
+ 2.447468415613332e-05 1.199999960480868
+ 2.4479684156133321e-05 1.199999960480868
+ 2.4484684156133321e-05 1.199999960480868
+ 2.4489684156133319e-05 1.199999960480868
+ 2.449468415613332e-05 1.199999960480868
+ 2.449968415613332e-05 1.199999960480868
+ 2.4504684156133321e-05 1.199999960480868
+ 2.4509684156133319e-05 1.199999960480868
+ 2.4514684156133319e-05 1.199999960480868
+ 2.451968415613332e-05 1.199999960480868
+ 2.4524684156133321e-05 1.199999960480868
+ 2.4529684156133329e-05 1.199999960480868
+ 2.4534684156133329e-05 1.199999960480868
+ 2.453968415613333e-05 1.199999960480868
+ 2.4544684156133331e-05 1.199999960480868
+ 2.4549684156133328e-05 1.199999960480868
+ 2.4554684156133329e-05 1.199999960480868
+ 2.455968415613333e-05 1.199999960480868
+ 2.4564684156133331e-05 1.199999960480868
+ 2.4569684156133332e-05 1.199999960480868
+ 2.4574684156133329e-05 1.1999999604808671
+ 2.457968415613333e-05 1.199999960480866
+ 2.4584684156133331e-05 1.1999999604808651
+ 2.4589684156133331e-05 1.199999960480862
+ 2.4594684156133339e-05 1.199999960480856
+ 2.459968415613334e-05 1.1999999604808449
+ 2.4604684156133341e-05 1.1999999604808249
+ 2.4609684156133341e-05 1.1999999604807861
+ 2.4614684156133339e-05 1.1999999604807099
+ 2.461968415613334e-05 1.1999999604805649
+ 2.462468415613334e-05 1.19999996048029
+ 2.4629684156133341e-05 1.1999999604797871
+ 2.4634684156133339e-05 1.1999999604789009
+ 2.4639684156133339e-05 1.1999999604773359
+ 2.464468415613334e-05 1.1999999604740239
+ 2.4649684156133341e-05 1.1999999604595959
+ 2.4651985247933431e-05 1.199999960343358
+ 2.4653711965424949e-05 1.199999960078967
+ 2.4655863650166269e-05 1.199999960244752
+ 2.465729094836782e-05 1.1999999604877749
+ 2.465901361919849e-05 1.199999960375659
+ 2.4660139340999691e-05 1.199999960598978
+ 2.4660617914057521e-05 1.199999961169129
+ 2.4661272477364409e-05 1.199999961693992
+ 2.4661605373316519e-05 1.199999964761076
+ 2.46618786186935e-05 1.199999967942369
+ 2.4662096669583381e-05 1.199999961152036
+ 2.4662307177648449e-05 1.199999910176117
+ 2.4662521261066339e-05 1.1999998604989059
+ 2.4662763586479971e-05 1.1999998098204789
+ 2.4662872923687261e-05 1.1999995687678739
+ 2.466293441049052e-05 1.1999991605752081
+ 2.466298639011771e-05 1.1999987370027769
+ 2.4663036760568369e-05 1.1999983683288911
+ 2.4663100879641952e-05 1.1999979506642089
+ 2.4663172601735721e-05 1.199998235649073
+ 2.4663244228065202e-05 1.1999993256470209
+ 2.46632665456776e-05 1.199999763755923
+ 2.4663286003049518e-05 1.199999760226478
+ 2.4663307125228611e-05 1.2000005201834361
+ 2.466333256011544e-05 1.2000037926857541
+ 2.4663356025928761e-05 1.2000085443446209
+ 2.4663382558037688e-05 1.2000109032860891
+ 2.4663403600099631e-05 1.2000096748603399
+ 2.4663421573565039e-05 1.2000068883180139
+ 2.4663434147780938e-05 1.200004212157971
+ 2.466344986258149e-05 1.2000013312014739
+ 2.4663471577280651e-05 1.1999989638818609
+ 2.466350041081027e-05 1.1999976702454289
+ 2.466353183894257e-05 1.199997131894615
+ 2.4663561170688359e-05 1.1999972083786661
+ 2.4663594015481108e-05 1.1999989273612039
+ 2.466362002415369e-05 1.200001543113016
+ 2.4663648688182642e-05 1.2000045008315501
+ 2.466367442366578e-05 1.2000065774208479
+ 2.466369277570186e-05 1.20000791450004
+ 2.466370852683918e-05 1.2000092452156159
+ 2.4663724161745202e-05 1.2000111574741099
+ 2.466373791212787e-05 1.2000129849811201
+ 2.4663753530921878e-05 1.2000131895274551
+ 2.466376473687181e-05 1.20001213001832
+ 2.4663779102621709e-05 1.2000100007291099
+ 2.466380365946462e-05 1.2000056555116181
+ 2.4663826260996212e-05 1.199994211174233
+ 2.4663849881889071e-05 1.199949247021957
+ 2.4663872001156789e-05 1.19987368387301
+ 2.4663900787001221e-05 1.199735926147957
+ 2.4663942972246441e-05 1.1994600074684361
+ 2.466396195642752e-05 1.2002721984573259
+ 2.4663978771653232e-05 1.202921178071841
+ 2.4664003071897212e-05 1.21072181742698
+ 2.46640263111532e-05 1.213593936655958
+ 2.4664042286336951e-05 1.19438715391599
+ 2.4664061396653071e-05 1.132359712556203
+ 2.4664079943894159e-05 1.0410614325167791
+ 2.4664097484440919e-05 0.93967221712995774
+ 2.466411978257221e-05 0.80459447088884517
+ 2.466414125899026e-05 0.67517024886225907
+ 2.4664155264072801e-05 0.59276879526970017
+ 2.4664167335681529e-05 0.52369563543207165
+ 2.4664181115792611e-05 0.44771810372760767
+ 2.4664197268596769e-05 0.36374673069403529
+ 2.4664212661826289e-05 0.29035180891072759
+ 2.4664232444244652e-05 0.20845110435396089
+ 2.4664256207619149e-05 0.13175622732004999
+ 2.4664279102537461e-05 0.079927042660815337
+ 2.4664293993278201e-05 0.056452383656108142
+ 2.4664310105046849e-05 0.038189129958594727
+ 2.466432866461518e-05 0.02390634155953892
+ 2.4664349736217769e-05 0.01369812258226522
+ 2.466437219680713e-05 0.0073368432944124267
+ 2.4664398221610201e-05 0.0033644185611043198
+ 2.4664427762732519e-05 0.0012205143263733041
+ 2.4664464215671968e-05 0.00017652132943912121
+ 2.4664509509182759e-05 -0.00016659154892242699
+ 2.4664571100335371e-05 -0.0001709862439009924
+ 2.4664659535455861e-05 -7.2242740201011477e-05
+ 2.4664746193955949e-05 -1.6261959412859219e-05
+ 2.4664860269396341e-05 3.7090054214993222e-06
+ 2.4664995548627649e-05 3.7684282308554651e-06
+ 2.466513835483603e-05 1.155335567058244e-06
+ 2.466526851306346e-05 1.587991204509803e-07
+ 2.4665391400277689e-05 -7.9838370090520028e-09
+ 2.46655114323747e-05 2.050950532393007e-08
+ 2.4665631427641159e-05 5.1484398905102159e-08
+ 2.466576045821175e-05 6.2621980339680339e-08
+ 2.466588086641448e-05 6.4711494762747618e-08
+ 2.4666005822432591e-05 6.6341539167935711e-08
+ 2.4666124401279341e-05 6.9333341736861988e-08
+ 2.4666246007965071e-05 7.3967129722879551e-08
+ 2.4666363967785399e-05 8.545039416638083e-08
+ 2.4666484224035628e-05 1.309407282192216e-07
+ 2.4666558497046371e-05 3.214672495970171e-07
+ 2.4666608984690438e-05 6.04801639442536e-07
+ 2.4666663235651679e-05 6.4200641189453765e-07
+ 2.4666728833486168e-05 2.177202350884187e-07
+ 2.4666765010204341e-05 -1.6737356404821839e-07
+ 2.4666794556762081e-05 -5.6251098637205684e-07
+ 2.4666818712849381e-05 -1.007943395748824e-06
+ 2.4666841628069141e-05 -1.5076946821732099e-06
+ 2.46668630067512e-05 -1.7540441641929471e-06
+ 2.4666891462872489e-05 -1.626563262737303e-06
+ 2.4666911637154459e-05 -1.7316217173528279e-06
+ 2.4666934619250648e-05 -6.5875967915358063e-07
+ 2.4666977031669979e-05 1.1438862783528999e-06
+ 2.4667016049906141e-05 1.413351123742634e-06
+ 2.4667077698590281e-05 7.0493632785893458e-07
+ 2.4667141859176251e-05 1.747263297489292e-07
+ 2.466722089596676e-05 3.0388388902843622e-08
+ 2.4667306090732021e-05 -1.69536827687629e-08
+ 2.4667406352813488e-05 -4.5280054899253374e-09
+ 2.466752217881697e-05 4.8109809981689117e-08
+ 2.4667648539136029e-05 7.3623281359040363e-08
+ 2.4667818225366669e-05 7.0033458230096602e-08
+ 2.4668063226529811e-05 6.1758065305528464e-08
+ 2.4668376980413579e-05 6.0759728157272368e-08
+ 2.46687306974009e-05 6.1735689404116694e-08
+ 2.4669167218497401e-05 6.2029964712126812e-08
+ 2.4669690591195981e-05 6.2057464285091239e-08
+ 2.467030926161804e-05 6.1593758894258857e-08
+ 2.4670705612740749e-05 6.0288701996018001e-08
+ 2.467104866346025e-05 6.3040166097462993e-08
+ 2.4671482022141899e-05 6.2227306294274218e-08
+ 2.467194587241536e-05 6.1726448516770186e-08
+ 2.4672494694040842e-05 6.1910019925675833e-08
+ 2.4673086908179339e-05 6.1922406774857992e-08
+ 2.4673907822407829e-05 6.1919170892190677e-08
+ 2.467506355981434e-05 6.1921746800574257e-08
+ 2.4677068078129249e-05 6.1921386158894818e-08
+ 2.4680113874024801e-05 6.1921012658765852e-08
+ 2.4685113874024801e-05 6.1920982324583386e-08
+ 2.4690113874024799e-05 6.1920994918330629e-08
+ 2.46951138740248e-05 6.1920997571237992e-08
+ 2.47001138740248e-05 6.1920998018787662e-08
+ 2.4705113874024801e-05 6.192099808102534e-08
+ 2.4710113874024809e-05 6.1920998053066517e-08
+ 2.471511387402481e-05 6.1920998156353542e-08
+ 2.472011387402481e-05 6.1920998169400444e-08
+ 2.4725113874024811e-05 6.1920998247530498e-08
+ 2.4730113874024809e-05 6.1920998108668552e-08
+ 2.4735113874024809e-05 6.1920998162237245e-08
+ 2.474011387402481e-05 6.1920998153476859e-08
+ 2.4745113874024811e-05 6.1920998278344432e-08
+ 2.4750113874024808e-05 6.1920998030195542e-08
+ 2.4755113874024809e-05 6.1920998139617667e-08
+ 2.476011387402481e-05 6.1920998133400312e-08
+ 2.4765113874024811e-05 6.1920998000643939e-08
+ 2.4770113874024818e-05 6.192099805523369e-08
+ 2.4775113874024819e-05 6.1920998091933669e-08
+ 2.478011387402482e-05 6.1920998146839337e-08
+ 2.4785113874024821e-05 6.1920997920496583e-08
+ 2.4790113874024822e-05 6.1920998002920618e-08
+ 2.4795113874024819e-05 6.1920998326675999e-08
+ 2.480011387402482e-05 6.1920998116229141e-08
+ 2.4805113874024821e-05 6.192099788831072e-08
+ 2.4810113874024821e-05 6.1920998225465276e-08
+ 2.4815113874024819e-05 6.1920998048692438e-08
+ 2.482011387402482e-05 6.1920998076065658e-08
+ 2.482511387402482e-05 6.1920998113293603e-08
+ 2.4830113874024821e-05 6.1920998233565347e-08
+ 2.4835113874024829e-05 6.1920997975985698e-08
+ 2.484011387402483e-05 6.1920998072069674e-08
+ 2.484511387402483e-05 6.1920998115566179e-08
+ 2.4850113874024831e-05 6.1920998129787651e-08
+ 2.4855113874024829e-05 6.192099829232835e-08
+ 2.4860113874024829e-05 6.1920998025198524e-08
+ 2.486511387402483e-05 6.1920998077587498e-08
+ 2.4870113874024831e-05 6.1920998162827283e-08
+ 2.4875113874024828e-05 6.1920998204921088e-08
+ 2.4880113874024829e-05 6.1920998220022494e-08
+ 2.488511387402483e-05 6.1920998049730292e-08
+ 2.4890113874024831e-05 6.1920998156132175e-08
+ 2.4895113874024838e-05 6.1920998126904827e-08
+ 2.4900113874024839e-05 6.192099801040058e-08
+ 2.490511387402484e-05 6.192099806183475e-08
+ 2.4910113874024841e-05 6.1920998089175359e-08
+ 2.4915113874024842e-05 6.1920998128388882e-08
+ 2.4920113874024839e-05 6.1920998233289121e-08
+ 2.492511387402484e-05 6.1920998005622745e-08
+ 2.4930113874024841e-05 6.1920998156857659e-08
+ 2.4935113874024841e-05 6.1920998239856313e-08
+ 2.4940113874024839e-05 6.1920998258987545e-08
+ 2.494511387402484e-05 6.1920998062924948e-08
+ 2.495011387402484e-05 6.1920998090418592e-08
+ 2.4955113874024841e-05 6.1920998120899641e-08
+ 2.4960113874024849e-05 6.1920998113947049e-08
+ 2.496511387402485e-05 6.1920997771092954e-08
+ 2.497011387402485e-05 6.1920997546643133e-08
+ 2.4975113874024851e-05 6.1920997198104812e-08
+ 2.4980113874024849e-05 6.1920993448366677e-08
+ 2.4982211396917511e-05 6.1920906944290811e-08
+ 2.4984031404262512e-05 6.1920905751059815e-08
+ 2.4985949024209358e-05 6.1921195159645284e-08
+ 2.4987474330314352e-05 6.1921064195306617e-08
+ 2.4989149475846391e-05 6.1920799987554748e-08
+ 2.499017894016507e-05 6.1921267668062699e-08
+ 2.4990557846989891e-05 6.1921825238588671e-08
+ 2.4991111041403139e-05 6.1920918041224904e-08
+ 2.499141898610284e-05 6.1925177922840451e-08
+ 2.499166426499821e-05 6.1917851309831286e-08
+ 2.4991864788727799e-05 6.1827877727836651e-08
+ 2.499207335525542e-05 6.1856904999440901e-08
+ 2.499231637868664e-05 6.1982407962259378e-08
+ 2.4992473499438579e-05 6.1364053129301988e-08
+ 2.4992540535688469e-05 5.7461607417194318e-08
+ 2.4992594826391631e-05 5.5549217249016102e-08
+ 2.4992638410051481e-05 5.9468091838866318e-08
+ 2.4992702963290809e-05 9.1147147478764812e-08
+ 2.4992768823250418e-05 1.306312737665877e-07
+ 2.4992833980128358e-05 1.7192879477058499e-07
+ 2.4992863450467071e-05 3.2932254989428518e-07
+ 2.4992884086963001e-05 6.475105330544021e-07
+ 2.4992905767212451e-05 7.8536344150460249e-07
+ 2.4992933210814631e-05 2.7303979448887047e-07
+ 2.4992956439194761e-05 -7.5016763966521919e-07
+ 2.4992977437605071e-05 -2.6188455171168351e-06
+ 2.499299634485755e-05 -4.1747685611180188e-06
+ 2.4993011506828909e-05 -4.9860393144024443e-06
+ 2.4993025931859151e-05 -4.7223378635891617e-06
+ 2.4993036011814871e-05 -2.5818498161399178e-06
+ 2.4993048586833741e-05 -6.721908058798633e-07
+ 2.4993065131461831e-05 -4.9044755389466862e-07
+ 2.499308390966359e-05 -1.567542678679294e-06
+ 2.4993108235069219e-05 -2.6255179988213399e-06
+ 2.4993133169180469e-05 -3.2847961167686462e-06
+ 2.4993159112380578e-05 -3.3147649094951171e-06
+ 2.4993182777965451e-05 -1.9774938066393569e-06
+ 2.4993205760074882e-05 -5.2197967671330572e-07
+ 2.4993232746096829e-05 -5.5744224288461842e-07
+ 2.4993263191921351e-05 -1.8906471204338079e-06
+ 2.4993291449630671e-05 -3.05151746024836e-06
+ 2.4993313378302931e-05 -3.7139202344890032e-06
+ 2.499334079167583e-05 -3.6459345595593549e-06
+ 2.4993361440936099e-05 -7.5669310870466606e-07
+ 2.499337900862561e-05 2.264361327893853e-06
+ 2.4993396180131628e-05 -6.4525390361229106e-06
+ 2.4993413980204039e-05 -5.3692140472868547e-05
+ 2.4993436496662179e-05 -0.0001469347945197474
+ 2.499345752298257e-05 -0.0001881453536370895
+ 2.4993470480404509e-05 -0.00013741461090708789
+ 2.499348397048119e-05 -2.0201095359221711e-05
+ 2.4993499341573579e-05 0.0001128021814307801
+ 2.499351546609159e-05 0.00018354305218994181
+ 2.4993538706467251e-05 0.00018548055343342771
+ 2.4993561717586649e-05 0.00014735825276530841
+ 2.4993593357570291e-05 9.5813303740704001e-05
+ 2.499362404532021e-05 6.70294485511444e-05
+ 2.4993660938866191e-05 5.6839960956559581e-05
+ 2.4993700353149301e-05 6.2774564271995441e-05
+ 2.4993751592996901e-05 8.5300541027206095e-05
+ 2.499381581888557e-05 -0.00017216319267453971
+ 2.4993864121154392e-05 -0.0018629814465077269
+ 2.4993910413094291e-05 -0.0064226801484149713
+ 2.499392529036325e-05 -0.0081724852006492283
+ 2.4993939737602079e-05 -0.0082734202684534366
+ 2.499394887567107e-05 -0.0062571260468210557
+ 2.4993958937653889e-05 -0.00034993802120477328
+ 2.499396950440215e-05 0.01227490274402139
+ 2.499398258425553e-05 0.040252554159658997
+ 2.49939950358879e-05 0.081063781299654025
+ 2.4994011388963389e-05 0.15389544057416821
+ 2.4994023211820359e-05 0.2170787030556616
+ 2.4994036728368219e-05 0.29551535509174298
+ 2.4994051314638562e-05 0.38309284668071703
+ 2.4994068680949028e-05 0.48689241069416178
+ 2.4994091082528189e-05 0.61531420296044126
+ 2.4994120875570859e-05 0.77004842938052731
+ 2.4994157668111262e-05 0.92609880779238685
+ 2.4994199807484091e-05 1.051294433653261
+ 2.4994247636755979e-05 1.1344809147088371
+ 2.499428949347024e-05 1.1714959978428161
+ 2.499434235828132e-05 1.192587157524833
+ 2.4994390295682659e-05 1.1992005512546049
+ 2.499445689015351e-05 1.201486659017601
+ 2.4994532041741249e-05 1.201282439887229
+ 2.4994653884589109e-05 1.200500000407287
+ 2.499478592506874e-05 1.200083525818449
+ 2.4994915205697839e-05 1.199979482190866
+ 2.4995038230713151e-05 1.1999782845301981
+ 2.499515779905382e-05 1.199990753947848
+ 2.4995285685349011e-05 1.1999980722841379
+ 2.4995404447124101e-05 1.200000093973947
+ 2.4995528465936569e-05 1.2000003089352771
+ 2.4995646207161241e-05 1.200000134953453
+ 2.4995767533355751e-05 1.200000007986409
+ 2.4995885162739229e-05 1.1999999634676179
+ 2.4996005318977151e-05 1.1999999555176331
+ 2.4996123261031399e-05 1.199999957820064
+ 2.499624290779899e-05 1.1999999619318149
+ 2.4996314053561059e-05 1.1999999746430521
+ 2.4996361588088551e-05 1.19999999452715
+ 2.4996409942617259e-05 1.199999989908652
+ 2.4996475762882171e-05 1.19999994140134
+ 2.4996532392361631e-05 1.1999999120135849
+ 2.499656146014042e-05 1.199999890081173
+ 2.4996585566404839e-05 1.1999998489484469
+ 2.4996607568422448e-05 1.199999784036105
+ 2.4996630055563809e-05 1.199999699973378
+ 2.49966579022936e-05 1.199999658164089
+ 2.499667814313235e-05 1.1999998923269819
+ 2.4996702841458061e-05 1.200000189162417
+ 2.4996739473507021e-05 1.2000003245447799
+ 2.4996791519296431e-05 1.2000001951559189
+ 2.4996844333898929e-05 1.200000010653576
+ 2.4996917094842859e-05 1.1999998851378
+ 2.499699775826445e-05 1.199999871420462
+ 2.4997099087844099e-05 1.199999916723689
+ 2.499719211986742e-05 1.1999999554640219
+ 2.4997310546851511e-05 1.1999999731608071
+ 2.4997447203381231e-05 1.1999999701784401
+ 2.499767005273822e-05 1.1999999618006301
+ 2.4998067282988941e-05 1.1999999587631289
+ 2.4998446410991842e-05 1.199999959815379
+ 2.4999005677720629e-05 1.1999999605155269
+ 2.4999605322588789e-05 1.19999996054703
+ 2.5000147532500459e-05 1.199999960436279
+ 2.5000685517786031e-05 1.199999960487562
+ 2.5001066986396088e-05 1.199999960602228
+ 2.5001493872990921e-05 1.199999960436283
+ 2.5001981063407132e-05 1.1999999604574429
+ 2.5002586128666289e-05 1.199999960479458
+ 2.5003332555941851e-05 1.1999999604828291
+ 2.5004457693909831e-05 1.199999960481626
+ 2.500617370885832e-05 1.1999999604809211
+ 2.5009077167621022e-05 1.1999999604809419
+ 2.501388409966764e-05 1.1999999604809151
+ 2.5018884099667641e-05 1.199999960480866
+ 2.5023884099667649e-05 1.199999960480858
+ 2.5028884099667649e-05 1.199999960480864
+ 2.503388409966765e-05 1.1999999604808671
+ 2.5038884099667651e-05 1.199999960480868
+ 2.5043884099667648e-05 1.199999960480868
+ 2.5048884099667649e-05 1.199999960480868
+ 2.505388409966765e-05 1.1999999604808691
+ 2.5058884099667651e-05 1.199999960480868
+ 2.5063884099667652e-05 1.199999960480868
+ 2.5068884099667649e-05 1.199999960480868
+ 2.507388409966765e-05 1.199999960480868
+ 2.5078884099667651e-05 1.199999960480868
+ 2.5083884099667651e-05 1.199999960480868
+ 2.5088884099667659e-05 1.199999960480868
+ 2.509388409966766e-05 1.199999960480868
+ 2.5098884099667661e-05 1.199999960480868
+ 2.5103884099667661e-05 1.199999960480868
+ 2.5108884099667659e-05 1.199999960480868
+ 2.511388409966766e-05 1.199999960480868
+ 2.511888409966766e-05 1.199999960480868
+ 2.5123884099667661e-05 1.199999960480868
+ 2.5128884099667659e-05 1.199999960480868
+ 2.5133884099667659e-05 1.199999960480868
+ 2.513888409966766e-05 1.199999960480868
+ 2.5143884099667661e-05 1.199999960480868
+ 2.5148884099667669e-05 1.199999960480868
+ 2.5153884099667669e-05 1.199999960480868
+ 2.515888409966767e-05 1.199999960480868
+ 2.5163884099667671e-05 1.199999960480868
+ 2.5168884099667668e-05 1.199999960480868
+ 2.5173884099667669e-05 1.199999960480868
+ 2.517888409966767e-05 1.199999960480868
+ 2.5183884099667671e-05 1.199999960480868
+ 2.5188884099667672e-05 1.199999960480868
+ 2.5193884099667669e-05 1.199999960480868
+ 2.519888409966767e-05 1.199999960480868
+ 2.5203884099667671e-05 1.199999960480868
+ 2.5208884099667671e-05 1.199999960480868
+ 2.5213884099667679e-05 1.199999960480868
+ 2.521888409966768e-05 1.199999960480868
+ 2.5223884099667681e-05 1.199999960480868
+ 2.5228884099667681e-05 1.199999960480868
+ 2.5233884099667679e-05 1.1999999604808671
+ 2.523888409966768e-05 1.199999960480866
+ 2.524388409966768e-05 1.1999999604808651
+ 2.5248884099667681e-05 1.199999960480862
+ 2.5253884099667679e-05 1.199999960480856
+ 2.5258884099667679e-05 1.1999999604808449
+ 2.526388409966768e-05 1.1999999604808249
+ 2.5268884099667681e-05 1.1999999604807861
+ 2.5273884099667689e-05 1.199999960480709
+ 2.5278884099667689e-05 1.199999960480564
+ 2.528388409966769e-05 1.199999960480288
+ 2.5288884099667691e-05 1.199999960479784
+ 2.5293884099667688e-05 1.199999960478896
+ 2.5298884099667689e-05 1.199999960477327
+ 2.530388409966769e-05 1.1999999604739999
+ 2.5308884099667691e-05 1.199999960459428
+ 2.5311177976763459e-05 1.1999999603415921
+ 2.5312906779061951e-05 1.199999960078129
+ 2.5315056902635819e-05 1.1999999602468161
+ 2.531648599862065e-05 1.199999960489244
+ 2.5318205672629349e-05 1.199999960374823
+ 2.531932513908e-05 1.199999960603092
+ 2.5319799868090639e-05 1.1999999611770691
+ 2.5320455077965438e-05 1.199999961702459
+ 2.5320788311116018e-05 1.199999964803671
+ 2.532105999250936e-05 1.1999999679995701
+ 2.5321277015426409e-05 1.199999960788978
+ 2.5321487720184091e-05 1.1999999093537519
+ 2.532170154278778e-05 1.1999998600528201
+ 2.5321944094651581e-05 1.1999998085992889
+ 2.5322052640656529e-05 1.1999995618325321
+ 2.5322113880937509e-05 1.1999991478106531
+ 2.53221654192282e-05 1.199998727289413
+ 2.532221646885194e-05 1.199998350757348
+ 2.5322280576786979e-05 1.199997945715465
+ 2.5322352478923669e-05 1.199998257710045
+ 2.5322421797206069e-05 1.199999331999837
+ 2.5322443718607171e-05 1.199999761688447
+ 2.5322463276906599e-05 1.1999997730783889
+ 2.5322484208390281e-05 1.2000004721152751
+ 2.5322509378569631e-05 1.2000036322613841
+ 2.532253304619423e-05 1.200008425894274
+ 2.5322559711009541e-05 1.2000108964560301
+ 2.5322580846851539e-05 1.200009727169457
+ 2.5322598839389991e-05 1.2000069794714501
+ 2.5322611388963429e-05 1.200004310107829
+ 2.5322627167021129e-05 1.200001393383034
+ 2.532264829568638e-05 1.199999039092311
+ 2.5322676421055889e-05 1.199997720709884
+ 2.5322707801626191e-05 1.199997156638646
+ 2.532273756440928e-05 1.1999971831158709
+ 2.5322772025875872e-05 1.199998919892967
+ 2.5322798221227779e-05 1.200001549237514
+ 2.5322826955018351e-05 1.2000045213215531
+ 2.5322852601944811e-05 1.200006598368123
+ 2.5322870855677798e-05 1.200007937019812
+ 2.532288660560694e-05 1.2000092765099339
+ 2.5322902212905621e-05 1.200011200148726
+ 2.53229159835641e-05 1.200013013348836
+ 2.5322931535353289e-05 1.200013185697048
+ 2.5322943047127719e-05 1.200012077349059
+ 2.532295738481214e-05 1.2000099324256761
+ 2.5322982074955421e-05 1.200005529072657
+ 2.5323004602523489e-05 1.1999936615194311
+ 2.5323028129231801e-05 1.1999480163410139
+ 2.5323051024741769e-05 1.1998689620284251
+ 2.5323079677666349e-05 1.199729585231837
+ 2.532312271877642e-05 1.199488012648481
+ 2.5323141437160281e-05 1.2004515636622879
+ 2.5323158542628741e-05 1.203399299431497
+ 2.532318242933028e-05 1.211353540380349
+ 2.5323202679484589e-05 1.2147452639145859
+ 2.5323217701209319e-05 1.2001222442662149
+ 2.5323234557300531e-05 1.151443021572673
+ 2.532325219213427e-05 1.0700349976424599
+ 2.5323269657831249e-05 0.97170894558201359
+ 2.5323291384277771e-05 0.84075579568620817
+ 2.532331206300798e-05 0.71532234659200022
+ 2.5323326499134079e-05 0.62937167145415018
+ 2.5323337690493059e-05 0.56431182186626172
+ 2.5323353664493919e-05 0.47465411017646653
+ 2.5323365338935599e-05 0.41202912775813733
+ 2.532337851638448e-05 0.34513419269316592
+ 2.5323398635420309e-05 0.25338614385226688
+ 2.532342174132375e-05 0.1674662804812633
+ 2.5323443894763579e-05 0.1063053096433506
+ 2.5323467129301699e-05 0.062538728972054286
+ 2.5323484314040859e-05 0.041180521116025007
+ 2.5323502079876021e-05 0.02631022424130924
+ 2.5323524132866271e-05 0.01467557276111211
+ 2.5323544724061049e-05 0.0083171055036899404
+ 2.5323571179639832e-05 0.0037989367950231928
+ 2.5323598547836821e-05 0.001537748988030269
+ 2.532363491029372e-05 0.00028397010336917659
+ 2.5323676986102818e-05 -0.0001331821999003797
+ 2.532373684141977e-05 -0.00018218058426832081
+ 2.5323817461369739e-05 -9.0236803620894786e-05
+ 2.5323906688078849e-05 -2.2217461503863931e-05
+ 2.5324011406444809e-05 2.1635352937081392e-06
+ 2.5324144084935548e-05 4.2257588535667438e-06
+ 2.5324306486018151e-05 1.439764126715637e-06
+ 2.53244444721702e-05 2.4452859662355921e-07
+ 2.5324568780669909e-05 7.6014752417869765e-09
+ 2.53246871775256e-05 1.8567168924446439e-08
+ 2.5324805717963319e-05 4.8746966269955901e-08
+ 2.5324934035102199e-05 6.1663939264909798e-08
+ 2.5325054011911879e-05 6.4525682471923668e-08
+ 2.532517907589058e-05 6.6288487864327253e-08
+ 2.5325297663727579e-05 6.9230432845695731e-08
+ 2.5325419446300151e-05 7.3738999756625606e-08
+ 2.532553741594689e-05 8.4770574984789821e-08
+ 2.5325657747420469e-05 1.276390077960842e-07
+ 2.5325734105395971e-05 3.0972501935715959e-07
+ 2.5325784865209509e-05 5.9599676110462571e-07
+ 2.5325838501824329e-05 6.5036775691581846e-07
+ 2.5325904312809161e-05 2.3750202938799149e-07
+ 2.5325940004311469e-05 -1.4185340958464119e-07
+ 2.5325970537562649e-05 -5.3672435850851235e-07
+ 2.5325995145964632e-05 -9.7685343119369872e-07
+ 2.5326018280607589e-05 -1.480500524627478e-06
+ 2.5326039737286959e-05 -1.752703411009002e-06
+ 2.5326068630553851e-05 -1.6243690524248459e-06
+ 2.5326089425241149e-05 -1.726790203322366e-06
+ 2.5326112415646031e-05 -6.6812549704617861e-07
+ 2.5326153329417401e-05 1.107590314402279e-06
+ 2.5326192840052301e-05 1.415109754813485e-06
+ 2.5326253122678929e-05 7.2920421093781028e-07
+ 2.5326317841054519e-05 1.812880725465762e-07
+ 2.532639850604165e-05 2.956932641264601e-08
+ 2.5326483731534549e-05 -1.7003497784066539e-08
+ 2.5326584917251581e-05 -5.1707605019964494e-09
+ 2.532670006805684e-05 4.7451736496910438e-08
+ 2.532682704092645e-05 7.3636954861571042e-08
+ 2.5326996136579579e-05 7.0142080729292475e-08
+ 2.5327242515957138e-05 6.1763589632175564e-08
+ 2.532755557312394e-05 6.0752996927861688e-08
+ 2.532791073736095e-05 6.1737444004314774e-08
+ 2.53283468812922e-05 6.2029546940585911e-08
+ 2.5328872175996009e-05 6.2057881070124843e-08
+ 2.5329487923234721e-05 6.1588346308067385e-08
+ 2.5329883867498899e-05 6.0290446909573846e-08
+ 2.5330226055332391e-05 6.3045798948502137e-08
+ 2.533065847008396e-05 6.2223141840934187e-08
+ 2.533112297577862e-05 6.1726936286528363e-08
+ 2.5331672335591659e-05 6.1910300595838887e-08
+ 2.5332264306445292e-05 6.192225680321263e-08
+ 2.533308532757444e-05 6.1919149268844483e-08
+ 2.5334240048004659e-05 6.1921754970116785e-08
+ 2.5336244811655929e-05 6.1921387794602418e-08
+ 2.5339289362075739e-05 6.1921012565912764e-08
+ 2.534428936207574e-05 6.1920982196306533e-08
+ 2.5349289362075741e-05 6.1920994872488491e-08
+ 2.5354289362075742e-05 6.1920997858936544e-08
+ 2.5359289362075739e-05 6.1920998065247578e-08
+ 2.536428936207574e-05 6.1920998055497514e-08
+ 2.5369289362075741e-05 6.1920998156078574e-08
+ 2.5374289362075741e-05 6.1920998237122872e-08
+ 2.5379289362075739e-05 6.1920998018799216e-08
+ 2.538428936207574e-05 6.1920998063753267e-08
+ 2.538928936207574e-05 6.1920998183692748e-08
+ 2.5394289362075741e-05 6.1920998239322246e-08
+ 2.5399289362075749e-05 6.1920998032805144e-08
+ 2.5404289362075749e-05 6.1920998106605947e-08
+ 2.540928936207575e-05 6.1920998155203642e-08
+ 2.5414289362075751e-05 6.1920998176263846e-08
+ 2.5419289362075749e-05 6.1920997947567822e-08
+ 2.5424289362075749e-05 6.1920998341299877e-08
+ 2.542928936207575e-05 6.1920998106083275e-08
+ 2.5434289362075751e-05 6.1920998152973351e-08
+ 2.5439289362075748e-05 6.1920997959815071e-08
+ 2.5444289362075749e-05 6.1920998258658486e-08
+ 2.544928936207575e-05 6.1920998334578724e-08
+ 2.5454289362075751e-05 6.1920998105498862e-08
+ 2.5459289362075752e-05 6.1920998146911123e-08
+ 2.5464289362075759e-05 6.1920997960085817e-08
+ 2.546928936207576e-05 6.1920998089180124e-08
+ 2.5474289362075761e-05 6.1920998073304463e-08
+ 2.5479289362075761e-05 6.1920998118566304e-08
+ 2.5484289362075759e-05 6.1920998238194263e-08
+ 2.548928936207576e-05 6.1920998018133621e-08
+ 2.549428936207576e-05 6.1920998065866296e-08
+ 2.5499289362075761e-05 6.1920998152300754e-08
+ 2.5504289362075759e-05 6.192099815752438e-08
+ 2.5509289362075759e-05 6.1920998222486778e-08
+ 2.551428936207576e-05 6.1920998048599185e-08
+ 2.5519289362075761e-05 6.1920998115947106e-08
+ 2.5524289362075769e-05 6.1920998153155609e-08
+ 2.5529289362075769e-05 6.1920998245009728e-08
+ 2.553428936207577e-05 6.192099805475951e-08
+ 2.5539289362075771e-05 6.1920998079835391e-08
+ 2.5544289362075768e-05 6.1920998115974264e-08
+ 2.5549289362075769e-05 6.1920998190501596e-08
+ 2.555428936207577e-05 6.1920998217110011e-08
+ 2.5559289362075771e-05 6.1920998053118861e-08
+ 2.5564289362075772e-05 6.1920998114418053e-08
+ 2.5569289362075769e-05 6.1920998184585084e-08
+ 2.557428936207577e-05 6.1920997970095537e-08
+ 2.5579289362075771e-05 6.1920998025881299e-08
+ 2.5584289362075771e-05 6.1920998049858803e-08
+ 2.5589289362075779e-05 6.1920997993577712e-08
+ 2.559428936207578e-05 6.1920998097393352e-08
+ 2.5599289362075781e-05 6.192099792039478e-08
+ 2.5604289362075781e-05 6.1920998231958777e-08
+ 2.5609289362075779e-05 6.1920998031889317e-08
+ 2.561428936207578e-05 6.1920998098602174e-08
+ 2.561928936207578e-05 6.1920998102312297e-08
+ 2.5624289362075781e-05 6.1920997955760536e-08
+ 2.5629289362075779e-05 6.1920997816530104e-08
+ 2.5634289362075779e-05 6.192099716216396e-08
+ 2.563928936207578e-05 6.1920993421609475e-08
+ 2.564138738218713e-05 6.1920906948436812e-08
+ 2.5643206888051539e-05 6.1920905181885637e-08
+ 2.5645125736676211e-05 6.1921195024792795e-08
+ 2.564665036171676e-05 6.19210641429313e-08
+ 2.5648325362827991e-05 6.1920800556846902e-08
+ 2.564935525079542e-05 6.1921267423466503e-08
+ 2.5649734485774621e-05 6.1921822396412392e-08
+ 2.565028817873942e-05 6.1920918975065838e-08
+ 2.5650596225174751e-05 6.1925174101498889e-08
+ 2.565084152988325e-05 6.1917914118862047e-08
+ 2.5651041987237599e-05 6.1828246619792373e-08
+ 2.5651250556544918e-05 6.1856367778770948e-08
+ 2.5651493692715129e-05 6.198259034948524e-08
+ 2.565165134447514e-05 6.1368651002526663e-08
+ 2.5651718500708561e-05 5.7463627325057802e-08
+ 2.5651772766642921e-05 5.5537985987148068e-08
+ 2.5651816362650171e-05 5.9476049444007142e-08
+ 2.5651880913773671e-05 9.1173977981707774e-08
+ 2.5651946767288089e-05 1.306495922749282e-07
+ 2.5652011893693141e-05 1.7194190913140229e-07
+ 2.5652041356211249e-05 3.2923698595216209e-07
+ 2.5652061995144239e-05 6.4733005605095348e-07
+ 2.565208367068819e-05 7.8547448306281534e-07
+ 2.5652111110020301e-05 2.7348546157797139e-07
+ 2.5652134344980169e-05 -7.4919543642520485e-07
+ 2.565215534394434e-05 -2.6174745238073092e-06
+ 2.5652174246434631e-05 -4.1738123310436278e-06
+ 2.565218941206237e-05 -4.9849825054172993e-06
+ 2.565220382858273e-05 -4.7256943364024051e-06
+ 2.565221390492394e-05 -2.586179944046533e-06
+ 2.5652226478254192e-05 -6.738131537575134e-07
+ 2.565224300502965e-05 -4.887664624662247e-07
+ 2.5652261782417691e-05 -1.565182339545827e-06
+ 2.5652286097762371e-05 -2.623845726395679e-06
+ 2.5652311028038818e-05 -3.2835056307681389e-06
+ 2.565233696684157e-05 -3.3164035144591829e-06
+ 2.5652360663148521e-05 -1.980776754614488e-06
+ 2.5652383638647422e-05 -5.2367812250240129e-07
+ 2.5652410605505049e-05 -5.557322568054315e-07
+ 2.5652441072768801e-05 -1.8885321269391599e-06
+ 2.5652469309642391e-05 -3.0491017447609999e-06
+ 2.5652491243564338e-05 -3.7123653740078509e-06
+ 2.565251868464955e-05 -3.6487147581389662e-06
+ 2.5652539381436489e-05 -7.5524748272436232e-07
+ 2.565255696708462e-05 2.2637750661459762e-06
+ 2.565257413964746e-05 -6.5132765509810986e-06
+ 2.5652591940756131e-05 -5.3852893862939211e-05
+ 2.565261444828055e-05 -0.0001470702468567734
+ 2.565263550694798e-05 -0.00018808270838077681
+ 2.5652648461444241e-05 -0.00013703128154542559
+ 2.565266196212879e-05 -1.9558208488343189e-05
+ 2.5652677352689899e-05 0.0001133765813167778
+ 2.5652693486452878e-05 0.00018372345174291061
+ 2.565271678788325e-05 0.0001853013773162009
+ 2.565273979076221e-05 0.00014710097814229779
+ 2.565277147049244e-05 9.5562588838644976e-05
+ 2.5652802164358749e-05 6.6914208186658048e-05
+ 2.5652839092920049e-05 5.6833406379585591e-05
+ 2.5652878540241059e-05 6.2856653054087406e-05
+ 2.5652929862899412e-05 8.5428884937483964e-05
+ 2.5652994178956418e-05 -0.0001781861101130894
+ 2.565304235452701e-05 -0.001883153205581163
+ 2.5653088747346169e-05 -0.0064759587608521048
+ 2.5653103459327111e-05 -0.0081946730419818065
+ 2.5653117934535361e-05 -0.0082381052897320031
+ 2.565312711968062e-05 -0.0061230218553384704
+ 2.5653137127295579e-05 -0.0001059310094302303
+ 2.5653147673009861e-05 0.01267994433457512
+ 2.5653160738702571e-05 0.04089439550421798
+ 2.565317324025895e-05 0.082159204133684757
+ 2.5653189051141871e-05 0.1526675222977775
+ 2.5653200684887152e-05 0.2147020773803282
+ 2.5653214061325048e-05 0.29219975405017851
+ 2.5653228562171309e-05 0.37923063138744029
+ 2.5653245782185331e-05 0.48224980205065737
+ 2.5653267978626888e-05 0.60981390617627174
+ 2.5653297464240499e-05 0.76377727023302722
+ 2.5653334085190728e-05 0.920694671343527
+ 2.565337587722797e-05 1.0470063152466209
+ 2.5653426080648391e-05 1.135347018820984
+ 2.56534685339137e-05 1.1724722901674161
+ 2.5653521477024682e-05 1.193072275168807
+ 2.5653569589917519e-05 1.1994308675342791
+ 2.5653636124226729e-05 1.2015338131424831
+ 2.5653711782857931e-05 1.201270489698572
+ 2.565383468082443e-05 1.200476562503151
+ 2.5653967120400019e-05 1.200073191845757
+ 2.565409640022002e-05 1.1999772706366101
+ 2.5654219294641621e-05 1.199978422302207
+ 2.5654338768855099e-05 1.199991121831226
+ 2.5654466513555791e-05 1.1999982533702269
+ 2.5654585246393559e-05 1.200000147100174
+ 2.5654709215915859e-05 1.200000312231625
+ 2.5654826967000698e-05 1.200000129843918
+ 2.5654948277697978e-05 1.200000004656407
+ 2.565506591889823e-05 1.1999999623012609
+ 2.5655186065707622e-05 1.199999955344943
+ 2.5655304014303699e-05 1.1999999578988341
+ 2.565542365515223e-05 1.199999962095339
+ 2.565549330201868e-05 1.1999999752850159
+ 2.5655540582210269e-05 1.1999999948783979
+ 2.5655589158508259e-05 1.199999989147482
+ 2.5655654657592839e-05 1.199999940467275
+ 2.5655708923048771e-05 1.199999911985592
+ 2.565573752346793e-05 1.199999891549131
+ 2.565576203268784e-05 1.199999852845941
+ 2.565578434745598e-05 1.199999789301212
+ 2.5655806937154131e-05 1.1999997054076901
+ 2.5655835057191609e-05 1.1999996561781141
+ 2.5655855988682761e-05 1.199999888070294
+ 2.565588070249131e-05 1.2000001858660081
+ 2.5655916313132539e-05 1.200000323497773
+ 2.5655969024529351e-05 1.2000001967656251
+ 2.5656020961474232e-05 1.200000014230046
+ 2.56560938766875e-05 1.1999998860513781
+ 2.565617565513077e-05 1.1999998711705311
+ 2.5656275069072049e-05 1.199999915745698
+ 2.5656369224663399e-05 1.199999955214764
+ 2.5656485960051601e-05 1.199999973025645
+ 2.565662348375883e-05 1.1999999702564841
+ 2.5656842860136032e-05 1.1999999619268691
+ 2.5657243153432439e-05 1.1999999587500969
+ 2.5657618813036361e-05 1.1999999597990321
+ 2.5658180298736242e-05 1.199999960514744
+ 2.5658775389497629e-05 1.199999960548036
+ 2.5659318772865871e-05 1.1999999604374749
+ 2.5659849424894239e-05 1.199999960484079
+ 2.5660226083879379e-05 1.1999999606053779
+ 2.566064921521566e-05 1.1999999604375391
+ 2.566113225471877e-05 1.199999960456712
+ 2.5661734613563469e-05 1.199999960479037
+ 2.566246877521119e-05 1.199999960482764
+ 2.5663574954769919e-05 1.1999999604816749
+ 2.5665246035943699e-05 1.1999999604809339
+ 2.56680941822904e-05 1.199999960480939
+ 2.5672743209911e-05 1.1999999604809179
+ 2.5677743209911001e-05 1.199999960480868
+ 2.5682743209910998e-05 1.199999960480858
+ 2.5687743209910999e-05 1.1999999604808631
+ 2.5692743209911e-05 1.199999960480866
+ 2.5697743209911001e-05 1.199999960480868
+ 2.5702743209911002e-05 1.199999960480868
+ 2.5707743209910999e-05 1.199999960480868
+ 2.5712743209911e-05 1.1999999604808691
+ 2.5717743209911001e-05 1.199999960480868
+ 2.5722743209911001e-05 1.199999960480868
+ 2.5727743209911009e-05 1.199999960480868
+ 2.573274320991101e-05 1.199999960480868
+ 2.5737743209911011e-05 1.199999960480868
+ 2.5742743209911011e-05 1.199999960480868
+ 2.5747743209911009e-05 1.199999960480868
+ 2.575274320991101e-05 1.199999960480868
+ 2.575774320991101e-05 1.199999960480868
+ 2.5762743209911011e-05 1.199999960480868
+ 2.5767743209911009e-05 1.199999960480868
+ 2.5772743209911009e-05 1.199999960480868
+ 2.577774320991101e-05 1.199999960480868
+ 2.5782743209911011e-05 1.199999960480868
+ 2.5787743209911019e-05 1.199999960480868
+ 2.5792743209911019e-05 1.199999960480868
+ 2.579774320991102e-05 1.199999960480868
+ 2.5802743209911021e-05 1.199999960480868
+ 2.5807743209911018e-05 1.199999960480868
+ 2.5812743209911019e-05 1.199999960480868
+ 2.581774320991102e-05 1.199999960480868
+ 2.5822743209911021e-05 1.199999960480868
+ 2.5827743209911022e-05 1.199999960480868
+ 2.5832743209911019e-05 1.199999960480868
+ 2.583774320991102e-05 1.199999960480868
+ 2.5842743209911021e-05 1.199999960480868
+ 2.5847743209911021e-05 1.199999960480868
+ 2.5852743209911029e-05 1.199999960480868
+ 2.585774320991103e-05 1.199999960480868
+ 2.5862743209911031e-05 1.199999960480868
+ 2.5867743209911031e-05 1.199999960480868
+ 2.5872743209911029e-05 1.199999960480868
+ 2.587774320991103e-05 1.199999960480868
+ 2.588274320991103e-05 1.199999960480868
+ 2.5887743209911031e-05 1.199999960480868
+ 2.5892743209911029e-05 1.199999960480868
+ 2.5897743209911029e-05 1.1999999604808671
+ 2.590274320991103e-05 1.1999999604808651
+ 2.5907743209911031e-05 1.1999999604808631
+ 2.5912743209911039e-05 1.1999999604808571
+ 2.5917743209911039e-05 1.199999960480846
+ 2.592274320991104e-05 1.1999999604808269
+ 2.5927743209911041e-05 1.1999999604807889
+ 2.5932743209911038e-05 1.1999999604807161
+ 2.5937743209911039e-05 1.199999960480576
+ 2.594274320991104e-05 1.199999960480312
+ 2.5947743209911041e-05 1.199999960479825
+ 2.5952743209911042e-05 1.19999996047897
+ 2.5957743209911039e-05 1.199999960477458
+ 2.596274320991104e-05 1.199999960474329
+ 2.5967743209911041e-05 1.19999996046166
+ 2.597015186419726e-05 1.199999960364637
+ 2.5971854528093511e-05 1.1999999600936211
+ 2.5973997183484881e-05 1.1999999602174729
+ 2.5975447050176769e-05 1.1999999604600049
+ 2.5977216285642949e-05 1.199999960397564
+ 2.597840592150493e-05 1.199999960552796
+ 2.5978927058849389e-05 1.199999961085582
+ 2.5979576727992711e-05 1.1999999615985519
+ 2.5979906615689111e-05 1.199999964308639
+ 2.5980197867877301e-05 1.199999967276286
+ 2.5980428147052559e-05 1.199999964323772
+ 2.5980636140092499e-05 1.199999919164263
+ 2.598085154486117e-05 1.1999998656421009
+ 2.5981093435379578e-05 1.1999998214487451
+ 2.598121303135699e-05 1.1999996311375589
+ 2.5981276114214271e-05 1.1999992786581739
+ 2.598133389791906e-05 1.199998830724647
+ 2.59813799128879e-05 1.1999985108078259
+ 2.59814465988407e-05 1.1999980077800081
+ 2.5981517123389151e-05 1.1999980988869321
+ 2.5981597933289779e-05 1.199999167488315
+ 2.5981622716706021e-05 1.199999706957974
+ 2.5981642481361668e-05 1.199999784823168
+ 2.5981661611490339e-05 1.200000185253026
+ 2.598168644128213e-05 1.2000029382979629
+ 2.5981712292264709e-05 1.200008020359024
+ 2.598173722539354e-05 1.2000107989224711
+ 2.5981758286532921e-05 1.2000100722593421
+ 2.598177620481032e-05 1.200007661538973
+ 2.5981790194693821e-05 1.2000047830404701
+ 2.5981805869834701e-05 1.2000017880139919
+ 2.5981824391536651e-05 1.1999994784147441
+ 2.5981850880201889e-05 1.199997950368505
+ 2.59818812333528e-05 1.199997279997046
+ 2.5981910289362701e-05 1.1999970926548691
+ 2.5981935410777239e-05 1.1999978003615961
+ 2.598196137446055e-05 1.199999852154797
+ 2.598198910126184e-05 1.200002782804042
+ 2.5982019046811369e-05 1.2000055280912221
+ 2.5982042820143251e-05 1.2000072389751659
+ 2.5982059316603139e-05 1.200008491793243
+ 2.598207508160733e-05 1.2000100373909339
+ 2.5982089451031841e-05 1.2000120919600481
+ 2.5982107679588641e-05 1.2000133441217711
+ 2.5982119654111559e-05 1.200012614636534
+ 2.5982133332764571e-05 1.200010795287078
+ 2.5982154590000882e-05 1.200007232023262
+ 2.598218102169075e-05 1.199997735505157
+ 2.5982206577569899e-05 1.19995608317147
+ 2.5982227720788071e-05 1.199887656492113
+ 2.598225585328005e-05 1.199759345024519
+ 2.5982295221460701e-05 1.19944475067409
+ 2.5982315747698871e-05 1.199861274097541
+ 2.598233196678332e-05 1.201705504808003
+ 2.5982352682158139e-05 1.207201854745938
+ 2.5982374524943139e-05 1.2149945313422501
+ 2.5982389134719628e-05 1.2132449343932861
+ 2.5982402841707129e-05 1.193192772312567
+ 2.5982420362368151e-05 1.1336138392535231
+ 2.5982440794290028e-05 1.0308730827778669
+ 2.5982462505975588e-05 0.90353168387082983
+ 2.5982482185417499e-05 0.78353639656171015
+ 2.5982499734123731e-05 0.67754062712726892
+ 2.5982512242422131e-05 0.60368813098903851
+ 2.5982523511618729e-05 0.53883127682752952
+ 2.59825371213252e-05 0.46314145181490801
+ 2.598254900014854e-05 0.39995839277592332
+ 2.5982563424732169e-05 0.32789412858816303
+ 2.598258354802591e-05 0.2386492860232671
+ 2.5982606987278931e-05 0.1551585944235592
+ 2.598262911403879e-05 0.097632809617620567
+ 2.5982647057614489e-05 0.064824787351548036
+ 2.5982662717693839e-05 0.044551227883842463
+ 2.5982680011848239e-05 0.028986090683131391
+ 2.5982701783593009e-05 0.016413363374344701
+ 2.5982722423954411e-05 0.0093452342220259211
+ 2.5982748333722029e-05 0.0043838139220660141
+ 2.5982775215394451e-05 0.0018412893618808351
+ 2.5982810186557159e-05 0.00041698196772612539
+ 2.5982850664111501e-05 -9.6573483924537309e-05
+ 2.5982907158177501e-05 -0.00019125595637313109
+ 2.5982982662011139e-05 -0.00010771118111869791
+ 2.5983073728700901e-05 -2.8939032168574931e-05
+ 2.598317207460354e-05 9.9777761585109583e-08
+ 2.5983302250979011e-05 4.5624225415001468e-06
+ 2.5983475919390291e-05 1.8085574596320671e-06
+ 2.5983617855818681e-05 3.590888298723576e-07
+ 2.5983742866545159e-05 2.457153261455332e-08
+ 2.5983860422524379e-05 1.430343822228157e-08
+ 2.5983978246472659e-05 4.480596388348944e-08
+ 2.59841064726014e-05 6.0436474168478676e-08
+ 2.598422626494625e-05 6.42828099773797e-08
+ 2.5984351538077199e-05 6.6165539985226128e-08
+ 2.5984470115959179e-05 6.9003371066006758e-08
+ 2.5984592053269241e-05 7.3282928737293554e-08
+ 2.5984710000579611e-05 8.3445603396022374e-08
+ 2.5984830401361539e-05 1.213639279871097e-07
+ 2.598491149598934e-05 2.8691827966327802e-07
+ 2.5984962935788311e-05 5.7845918479838849e-07
+ 2.598501554052981e-05 6.6394969738433937e-07
+ 2.5985081946961359e-05 2.7285998826696338e-07
+ 2.5985118525819899e-05 -1.101959948364603e-07
+ 2.598514952748288e-05 -4.9945932175894721e-07
+ 2.598517428758473e-05 -9.2720959773111963e-07
+ 2.598519751979434e-05 -1.430408850559533e-06
+ 2.5985219138710598e-05 -1.7485925325209311e-06
+ 2.5985243835876369e-05 -1.6165458517788111e-06
+ 2.5985265561864931e-05 -1.806929212011945e-06
+ 2.5985288639329498e-05 -9.6783939259391815e-07
+ 2.5985321391152979e-05 7.0212584988812249e-07
+ 2.5985363021630469e-05 1.4411503912049441e-06
+ 2.5985415548847441e-05 9.6323255490282158e-07
+ 2.5985479670949431e-05 2.836929847875185e-07
+ 2.5985559076051031e-05 4.5448908064869551e-08
+ 2.5985653069711041e-05 -1.371130374989088e-08
+ 2.5985752389746981e-05 -1.5208853400781319e-08
+ 2.598586976962449e-05 3.8103315613618902e-08
+ 2.598599072526646e-05 7.13733378674159e-08
+ 2.598615540084592e-05 7.198668216604488e-08
+ 2.5986383101559629e-05 6.2705625487355503e-08
+ 2.598670216637916e-05 6.0583995088089365e-08
+ 2.5987039940254168e-05 6.1608398926840953e-08
+ 2.5987478150491539e-05 6.2032904503739447e-08
+ 2.5987977940486509e-05 6.2052226534905864e-08
+ 2.5988662764692421e-05 6.1685570802321019e-08
+ 2.5989093097202319e-05 6.0325932779781865e-08
+ 2.598945781886809e-05 6.3018065322340545e-08
+ 2.5989901816583779e-05 6.220463880740556e-08
+ 2.5990402236946089e-05 6.1716888383667173e-08
+ 2.5991014058043381e-05 6.1916410595454674e-08
+ 2.5991607686452759e-05 6.1921888907662488e-08
+ 2.5992517334299051e-05 6.1919282850059082e-08
+ 2.599372313564979e-05 6.1921904512216744e-08
+ 2.599607564356317e-05 6.1921301912995726e-08
+ 2.599936066965418e-05 6.1920994540361089e-08
+ 2.600436066965418e-05 6.1920985088006142e-08
+ 2.6009360669654181e-05 6.1920995701596024e-08
+ 2.6014360669654179e-05 6.1920997898248018e-08
+ 2.6019360669654179e-05 6.1920998022584752e-08
+ 2.602436066965418e-05 6.1920998262860471e-08
+ 2.6029360669654181e-05 6.192099833797072e-08
+ 2.6034360669654189e-05 6.1920998176823774e-08
+ 2.6039360669654189e-05 6.1920998227152884e-08
+ 2.604436066965419e-05 6.192099803427382e-08
+ 2.6049360669654191e-05 6.1920998094353033e-08
+ 2.6054360669654188e-05 6.1920998141784271e-08
+ 2.6059360669654189e-05 6.1920998191029655e-08
+ 2.606436066965419e-05 6.1920998026706917e-08
+ 2.6069360669654191e-05 6.192099807416841e-08
+ 2.6074360669654192e-05 6.1920998070494511e-08
+ 2.6079360669654189e-05 6.1920998201969152e-08
+ 2.608436066965419e-05 6.1920998229674064e-08
+ 2.6089360669654191e-05 6.1920998046173667e-08
+ 2.6094360669654191e-05 6.1920998107700658e-08
+ 2.6099360669654199e-05 6.1920998186025305e-08
+ 2.61043606696542e-05 6.1920998188228848e-08
+ 2.6109360669654201e-05 6.1920998260243483e-08
+ 2.6114360669654201e-05 6.1920998062386579e-08
+ 2.6119360669654199e-05 6.1920998171125135e-08
+ 2.61243606696542e-05 6.1920998168718688e-08
+ 2.61293606696542e-05 6.1920998262792655e-08
+ 2.6134360669654201e-05 6.1920998292992556e-08
+ 2.6139360669654199e-05 6.1920998376958323e-08
+ 2.6144360669654199e-05 6.1920998122209406e-08
+ 2.61493606696542e-05 6.1920998207243599e-08
+ 2.6154360669654201e-05 6.1920998035206046e-08
+ 2.6159360669654209e-05 6.1920998069490644e-08
+ 2.6164360669654209e-05 6.19209981217683e-08
+ 2.616936066965421e-05 6.1920998221208301e-08
+ 2.6174360669654211e-05 6.1920997993218993e-08
+ 2.6179360669654208e-05 6.1920998270793728e-08
+ 2.6184360669654209e-05 6.1920998115448455e-08
+ 2.618936066965421e-05 6.1920998146263196e-08
+ 2.6194360669654211e-05 6.1920998189766067e-08
+ 2.6199360669654212e-05 6.1920998281955849e-08
+ 2.6204360669654209e-05 6.1920998087486561e-08
+ 2.620936066965421e-05 6.1920998104442453e-08
+ 2.6214360669654211e-05 6.192099821345198e-08
+ 2.6219360669654211e-05 6.1920998220763251e-08
+ 2.6224360669654219e-05 6.192099833182592e-08
+ 2.622936066965422e-05 6.1920998097759244e-08
+ 2.6234360669654221e-05 6.1920998219247618e-08
+ 2.6239360669654221e-05 6.1920997977495375e-08
+ 2.6244360669654219e-05 6.1920998268875252e-08
+ 2.624936066965422e-05 6.1920998161092136e-08
+ 2.625436066965422e-05 6.1920998191522337e-08
+ 2.6259360669654221e-05 6.1920998254339875e-08
+ 2.6264360669654219e-05 6.1920998217457864e-08
+ 2.6269360669654219e-05 6.192099816868347e-08
+ 2.627436066965422e-05 6.1920997886152851e-08
+ 2.6279360669654221e-05 6.1920997868493432e-08
+ 2.6284360669654229e-05 6.192099796142904e-08
+ 2.6289360669654229e-05 6.1920997591644008e-08
+ 2.629436066965423e-05 6.1920997303133972e-08
+ 2.6299360669654231e-05 6.1920989681961475e-08
+ 2.630132636135096e-05 6.1920843515805586e-08
+ 2.630323853480447e-05 6.1921073067159246e-08
+ 2.63047075861224e-05 6.1921187214768651e-08
+ 2.6306667575238889e-05 6.1920881491378577e-08
+ 2.630800433736187e-05 6.1920978596321772e-08
+ 2.6308571933646289e-05 6.1921475874848958e-08
+ 2.6309165706486339e-05 6.1921126228956999e-08
+ 2.630947283027629e-05 6.1923394311596413e-08
+ 2.6309784454816451e-05 6.1922292249403019e-08
+ 2.6310025954744071e-05 6.1915704739829488e-08
+ 2.631023039468931e-05 6.1812785931970169e-08
+ 2.6310438241312279e-05 6.1882163623300768e-08
+ 2.6310678011482279e-05 6.1969591084913813e-08
+ 2.631081208673006e-05 6.1090703292613695e-08
+ 2.631087370271719e-05 5.7267304457261952e-08
+ 2.6310928412630941e-05 5.5925455120521548e-08
+ 2.631097249812446e-05 5.9976001552610777e-08
+ 2.6311036247850969e-05 9.1503785161086474e-08
+ 2.6311102924592029e-05 1.308774584023919e-07
+ 2.6311167720188289e-05 1.7305854923107889e-07
+ 2.631119686647201e-05 3.349429335694835e-07
+ 2.6311217465910831e-05 6.5670238603427865e-07
+ 2.6311239517624531e-05 7.7687012387242272e-07
+ 2.63112671210391e-05 2.4774843904415872e-07
+ 2.63112899889957e-05 -8.0178489700068128e-07
+ 2.63113109257941e-05 -2.687080442496463e-06
+ 2.631133006829881e-05 -4.2202398386320896e-06
+ 2.631134505772583e-05 -5.0366368239449894e-06
+ 2.6311359930636551e-05 -4.5468520681488032e-06
+ 2.631137021413547e-05 -2.363397619920461e-06
+ 2.6311382898986781e-05 -5.9447847817121823e-07
+ 2.631140039649287e-05 -5.8335456947082469e-07
+ 2.631142027500358e-05 -1.7255048977565971e-06
+ 2.6311444510845829e-05 -2.72043326200178e-06
+ 2.6311469762982399e-05 -3.3629586150830289e-06
+ 2.63114920038102e-05 -3.292322316136135e-06
+ 2.631151543855605e-05 -1.9285601684857471e-06
+ 2.6311538700329271e-05 -4.8691084595252434e-07
+ 2.6311566042060059e-05 -5.7072526658107419e-07
+ 2.6311596387588582e-05 -1.9173974335112191e-06
+ 2.631162483428896e-05 -3.078014795675272e-06
+ 2.6311646706519041e-05 -3.728847457509497e-06
+ 2.631167388333208e-05 -3.6202387424281919e-06
+ 2.6311694100440399e-05 -7.7013761372982181e-07
+ 2.6311711506110701e-05 2.2675007902165749e-06
+ 2.6311728676559019e-05 -5.9208969380903031e-06
+ 2.6311746473635051e-05 -5.2283114831266702e-05
+ 2.631176895804476e-05 -0.00014536034730928699
+ 2.6311789747766979e-05 -0.0001887210917501552
+ 2.6311802762814731e-05 -0.00014095777634876079
+ 2.6311816182263142e-05 -2.599412754865952e-05
+ 2.6311831385275398e-05 0.000107557169249015
+ 2.631184744203837e-05 0.0001818579463415881
+ 2.631187014277447e-05 0.0001870120226582948
+ 2.631189324780914e-05 0.00014960278174590969
+ 2.6311924527605951e-05 9.8053220709702472e-05
+ 2.6311955173779731e-05 6.8064404608194853e-05
+ 2.631199175879475e-05 5.6919734330338488e-05
+ 2.6312030897754859e-05 6.2084696673402694e-05
+ 2.631208142127416e-05 8.4073143401068898e-05
+ 2.631214488274149e-05 -0.00012455873673165009
+ 2.631219439727222e-05 -0.001702678255310627
+ 2.63122399161289e-05 -0.0059882625824000642
+ 2.6312256277490421e-05 -0.0079847354558873936
+ 2.631227037341827e-05 -0.0084882599771405991
+ 2.631227991789047e-05 -0.0069190501663292103
+ 2.631228994959468e-05 -0.001871057562154454
+ 2.631230037483651e-05 0.0092321898937415599
+ 2.6312312311097951e-05 0.032105710319923493
+ 2.6312325008600051e-05 0.070276367965545497
+ 2.631234179445827e-05 0.14160487678573949
+ 2.6312352527700368e-05 0.19742146316030329
+ 2.6312364878894221e-05 0.26783068187713738
+ 2.6312379415396709e-05 0.35458342277334948
+ 2.631239511472288e-05 0.44895764805374389
+ 2.6312416351966401e-05 0.57291156933419085
+ 2.6312442984264909e-05 0.71693085473562668
+ 2.631247868161019e-05 0.88068726404171238
+ 2.6312518000634978e-05 1.014073645738772
+ 2.6312572623063382e-05 1.124825142130808
+ 2.6312611070662171e-05 1.164136951762023
+ 2.6312654724072919e-05 1.186336025621211
+ 2.6312705501077651e-05 1.197053388161385
+ 2.631276183035391e-05 1.200700164795568
+ 2.631283715966396e-05 1.201348425068268
+ 2.6312935910434159e-05 1.200789241861423
+ 2.6313069280227599e-05 1.200207487921908
+ 2.631320231017432e-05 1.200005597455166
+ 2.6313328662331261e-05 1.199976922935075
+ 2.6313449251252559e-05 1.1999866892202711
+ 2.631357902805194e-05 1.1999960710961459
+ 2.6313697607369969e-05 1.19999949363886
+ 2.6313822302337401e-05 1.200000269208227
+ 2.6313939669451909e-05 1.2000001905346069
+ 2.6314061337405999e-05 1.200000044690064
+ 2.6314178724881089e-05 1.1999999765009339
+ 2.6314299121154091e-05 1.1999999574831419
+ 2.6314416924692259e-05 1.1999999569870199
+ 2.631453671963608e-05 1.1999999602855409
+ 2.6314633042326891e-05 1.199999968482629
+ 2.63146851516953e-05 1.1999999919741211
+ 2.6314732772856729e-05 1.1999999954108169
+ 2.6314802615113561e-05 1.1999999465757989
+ 2.6314870906631909e-05 1.1999999113045501
+ 2.6314901869388929e-05 1.199999878600378
+ 2.6314924371283489e-05 1.1999998227855591
+ 2.6314945083066601e-05 1.1999997500048329
+ 2.6314967592565731e-05 1.19999966347978
+ 2.6314993822444101e-05 1.1999996905278041
+ 2.631501372839322e-05 1.1999999690050791
+ 2.6315037946887119e-05 1.200000234668849
+ 2.6315086383874911e-05 1.200000315726593
+ 2.6315131376984302e-05 1.2000001602432691
+ 2.6315195891518831e-05 1.1999999578596541
+ 2.631526763832893e-05 1.199999872168235
+ 2.6315340373416519e-05 1.199999877107198
+ 2.6315429274273989e-05 1.1999999214547219
+ 2.6315528552313568e-05 1.1999999597597639
+ 2.631564309736742e-05 1.1999999733282081
+ 2.6315791873317438e-05 1.199999969114925
+ 2.6316011845294311e-05 1.1999999613925949
+ 2.63164205318425e-05 1.1999999588690029
+ 2.6316796718598389e-05 1.1999999599058879
+ 2.6317368631763311e-05 1.1999999605270231
+ 2.6317969201244999e-05 1.1999999605391221
+ 2.6318514248936472e-05 1.199999960429371
+ 2.631910292659549e-05 1.1999999605057781
+ 2.6319522779298251e-05 1.19999996058169
+ 2.63199770761321e-05 1.19999996043163
+ 2.6320505854524371e-05 1.1999999604623159
+ 2.63211268152902e-05 1.199999960481712
+ 2.6321973052896299e-05 1.1999999604830029
+ 2.6323232120021279e-05 1.199999960481325
+ 2.6325321301547281e-05 1.19999996048087
+ 2.632858426820662e-05 1.1999999604809459
+ 2.6333584268206621e-05 1.1999999604808971
+ 2.6338584268206622e-05 1.19999996048086
+ 2.6343584268206619e-05 1.19999996048086
+ 2.634858426820662e-05 1.1999999604808651
+ 2.6353584268206621e-05 1.1999999604808671
+ 2.6358584268206621e-05 1.199999960480868
+ 2.6363584268206629e-05 1.199999960480868
+ 2.636858426820663e-05 1.199999960480868
+ 2.6373584268206631e-05 1.199999960480868
+ 2.6378584268206631e-05 1.199999960480868
+ 2.6383584268206629e-05 1.199999960480868
+ 2.638858426820663e-05 1.199999960480868
+ 2.639358426820663e-05 1.199999960480868
+ 2.6398584268206631e-05 1.199999960480868
+ 2.6403584268206629e-05 1.199999960480868
+ 2.6408584268206629e-05 1.199999960480868
+ 2.641358426820663e-05 1.199999960480868
+ 2.6418584268206631e-05 1.199999960480868
+ 2.6423584268206639e-05 1.199999960480868
+ 2.6428584268206639e-05 1.199999960480868
+ 2.643358426820664e-05 1.199999960480868
+ 2.6438584268206641e-05 1.199999960480868
+ 2.6443584268206638e-05 1.199999960480868
+ 2.6448584268206639e-05 1.199999960480868
+ 2.645358426820664e-05 1.199999960480868
+ 2.6458584268206641e-05 1.199999960480868
+ 2.6463584268206642e-05 1.199999960480868
+ 2.6468584268206639e-05 1.199999960480868
+ 2.647358426820664e-05 1.199999960480868
+ 2.6478584268206641e-05 1.199999960480868
+ 2.6483584268206641e-05 1.199999960480868
+ 2.6488584268206649e-05 1.199999960480868
+ 2.649358426820665e-05 1.199999960480868
+ 2.6498584268206651e-05 1.199999960480868
+ 2.6503584268206651e-05 1.199999960480868
+ 2.6508584268206649e-05 1.199999960480868
+ 2.651358426820665e-05 1.199999960480868
+ 2.651858426820665e-05 1.199999960480868
+ 2.6523584268206651e-05 1.199999960480868
+ 2.6528584268206649e-05 1.199999960480868
+ 2.6533584268206649e-05 1.199999960480868
+ 2.653858426820665e-05 1.199999960480868
+ 2.6543584268206651e-05 1.199999960480868
+ 2.6548584268206659e-05 1.199999960480868
+ 2.6553584268206659e-05 1.1999999604808671
+ 2.655858426820666e-05 1.199999960480866
+ 2.6563584268206661e-05 1.199999960480864
+ 2.6568584268206658e-05 1.1999999604808611
+ 2.6573584268206659e-05 1.199999960480854
+ 2.657858426820666e-05 1.1999999604808409
+ 2.6583584268206661e-05 1.1999999604808169
+ 2.6588584268206662e-05 1.199999960480769
+ 2.6593584268206659e-05 1.199999960480679
+ 2.659858426820666e-05 1.1999999604805049
+ 2.6603584268206661e-05 1.199999960480179
+ 2.6608584268206661e-05 1.199999960479589
+ 2.6613584268206669e-05 1.199999960478555
+ 2.661858426820667e-05 1.1999999604766871
+ 2.6623584268206671e-05 1.1999999604722309
+ 2.6628584268206671e-05 1.1999999604415761
+ 2.6630583549260868e-05 1.1999999601765849
+ 2.6632482661140031e-05 1.199999960135155
+ 2.663404894561731e-05 1.1999999603784419
+ 2.6636187861718481e-05 1.1999999604544269
+ 2.6637854938596049e-05 1.199999960533219
+ 2.6638404971707439e-05 1.1999999615304151
+ 2.6638861737181769e-05 1.199999962597146
+ 2.663913613044517e-05 1.199999965434511
+ 2.6639418993354101e-05 1.199999967706058
+ 2.6639637278756391e-05 1.199999953478883
+ 2.6639856739481401e-05 1.1999998937196259
+ 2.6640074732836899e-05 1.1999998494729689
+ 2.6640280824464901e-05 1.199999778906816
+ 2.6640371743340611e-05 1.199999498526128
+ 2.6640434574314501e-05 1.199999061950616
+ 2.664048207865484e-05 1.1999986867520731
+ 2.6640538621588529e-05 1.199998245873972
+ 2.6640603956031419e-05 1.1999979373034639
+ 2.6640677186851088e-05 1.199998440622573
+ 2.6640724431250501e-05 1.1999992724437749
+ 2.6640744286135459e-05 1.199999691135389
+ 2.6640765200166471e-05 1.19999993709699
+ 2.664078360601963e-05 1.1999999804277091
+ 2.6640806816552769e-05 1.2000019221483409
+ 2.6640833857633901e-05 1.2000067737320019
+ 2.6640858594275899e-05 1.2000103816862051
+ 2.6640880440070079e-05 1.2000104193286869
+ 2.664089782763e-05 1.2000085380723651
+ 2.664091650153177e-05 1.2000050903058099
+ 2.664093146813146e-05 1.200002175668025
+ 2.6640947606591179e-05 1.199999916009074
+ 2.664097504364756e-05 1.19999804097777
+ 2.6641004515489278e-05 1.199997323511359
+ 2.664103154015459e-05 1.1999970680336589
+ 2.66410554969902e-05 1.1999974556351649
+ 2.664108092823143e-05 1.1999990863951471
+ 2.6641107465158128e-05 1.20000179754901
+ 2.6641137407271499e-05 1.200004753133147
+ 2.664116400924838e-05 1.2000067709647699
+ 2.6641182057471561e-05 1.200008072216884
+ 2.6641197800251009e-05 1.2000094451950689
+ 2.664121304956187e-05 1.2000114141842531
+ 2.6641226989463021e-05 1.2000131167866701
+ 2.6641242191065771e-05 1.200013077566944
+ 2.6641255534762439e-05 1.2000116529135989
+ 2.6641269981811729e-05 1.200009384254267
+ 2.6641295456982361e-05 1.200004507183172
+ 2.6641318321013399e-05 1.199988161747483
+ 2.6641341875821829e-05 1.199934959127779
+ 2.6641371843572688e-05 1.199820777334855
+ 2.664140010764452e-05 1.199654301578811
+ 2.6641437828460669e-05 1.1996550339552809
+ 2.6641455269904209e-05 1.2010429163462659
+ 2.66414733936987e-05 1.204926772811532
+ 2.6641495907038041e-05 1.213039193179388
+ 2.664151301371339e-05 1.2149009926354331
+ 2.6641527233587051e-05 1.2000334009131159
+ 2.664154606903217e-05 1.1422588661146349
+ 2.6641563685920862e-05 1.0575833497009961
+ 2.664158112204518e-05 0.95785662120337733
+ 2.664160292303259e-05 0.82595586633956453
+ 2.664162405515834e-05 0.69807487438015181
+ 2.6641638399398349e-05 0.61310502356208318
+ 2.6641649764699359e-05 0.5474686146573029
+ 2.6641664625995371e-05 0.46461766099188828
+ 2.6641675607206161e-05 0.40602794633079609
+ 2.6641689623530781e-05 0.33545866707148869
+ 2.6641709265220941e-05 0.24705274771017691
+ 2.6641732741111291e-05 0.1614186845431142
+ 2.6641754704621559e-05 0.1024225546904305
+ 2.6641775062371059e-05 0.06440117038206368
+ 2.664179138903125e-05 0.043467217582906698
+ 2.6641808845982811e-05 0.028102226165296961
+ 2.6641830785082619e-05 0.01579774376672697
+ 2.66418513194361e-05 0.0090025077973943449
+ 2.6641877454558409e-05 0.0041806050344068328
+ 2.6641904410842981e-05 0.0017410065867397889
+ 2.664193989058872e-05 0.00037068668094485298
+ 2.6641980804005149e-05 -0.0001092874500698029
+ 2.6642038449288339e-05 -0.00018870178220211061
+ 2.664211546725934e-05 -0.000102017476039825
+ 2.664220593449633e-05 -2.6641279296306631e-05
+ 2.6642306068674481e-05 8.3452994707182068e-07
+ 2.664243685057306e-05 4.4643506784721946e-06
+ 2.6642615352270072e-05 1.6615317795135739e-06
+ 2.6642759002441559e-05 3.1508555540771118e-07
+ 2.6642884159978748e-05 2.1760951593166009e-08
+ 2.6643001181859429e-05 1.7801711237983459e-08
+ 2.6643118548880411e-05 4.6698807991524137e-08
+ 2.6643245990756331e-05 6.0873087248756414e-08
+ 2.6643365617471051e-05 6.4468483130271454e-08
+ 2.6643490601749661e-05 6.6434512093233303e-08
+ 2.6643609231736771e-05 6.9404541343808947e-08
+ 2.6643731080044131e-05 7.4001105879648056e-08
+ 2.6643849095718631e-05 8.5526911681762595e-08
+ 2.6643969449263801e-05 1.313371477322516e-07
+ 2.664404349639188e-05 3.2310136061760421e-07
+ 2.6644093956380861e-05 6.0622894620019897e-07
+ 2.664414829700764e-05 6.4084951212617752e-07
+ 2.6644213869301e-05 2.1467261639636151e-07
+ 2.6644250118306659e-05 -1.714827931347371e-07
+ 2.664427951268778e-05 -5.6689635215395261e-07
+ 2.6644303596963959e-05 -1.0133058333547391e-06
+ 2.6644326475585811e-05 -1.512428665035366e-06
+ 2.6644347840775692e-05 -1.7544016024962939e-06
+ 2.6644376221914781e-05 -1.627411345879908e-06
+ 2.664439629214594e-05 -1.7326574826770159e-06
+ 2.6644419277430609e-05 -6.5710321625280402e-07
+ 2.6644461948777859e-05 1.150158774811985e-06
+ 2.6644500885248769e-05 1.413197333066505e-06
+ 2.6644562766140679e-05 7.0081969473697383e-07
+ 2.6644626831853761e-05 1.736267549869552e-07
+ 2.6644705572759559e-05 3.0505979826382058e-08
+ 2.6644790764992919e-05 -1.6988701673353101e-08
+ 2.6644890849311939e-05 -4.4289064031807322e-09
+ 2.6645006796625122e-05 4.8232395851686568e-08
+ 2.664513304056784e-05 7.3625379852742397e-08
+ 2.6645302839721551e-05 7.0014369756880553e-08
+ 2.6645547599822e-05 6.1756490526686931e-08
+ 2.6645861349707491e-05 6.0760732211479567e-08
+ 2.6646214742612031e-05 6.173561508775273e-08
+ 2.6646651136041782e-05 6.2029923111824091e-08
+ 2.664717400613568e-05 6.2057356848188372e-08
+ 2.6647793506548569e-05 6.159546223023929e-08
+ 2.6648189987535561e-05 6.0288197298569549e-08
+ 2.6648533309108961e-05 6.3038152975932059e-08
+ 2.6648966970029171e-05 6.2228773353077814e-08
+ 2.6649430560910112e-05 6.1726290189776103e-08
+ 2.6649979155370579e-05 6.1909921382377693e-08
+ 2.665057144411647e-05 6.1922455992849616e-08
+ 2.6651392252205299e-05 6.1919178159741358e-08
+ 2.6652548268995422e-05 6.1921744151728153e-08
+ 2.6654552419578569e-05 6.1921386055656774e-08
+ 2.6657598402121771e-05 6.1921012488500543e-08
+ 2.6662598402121769e-05 6.1920982366949181e-08
+ 2.666759840212177e-05 6.1920995018620257e-08
+ 2.667259840212177e-05 6.1920997734221081e-08
+ 2.6677598402121771e-05 6.1920997912974189e-08
+ 2.6682598402121779e-05 6.1920998128963805e-08
+ 2.668759840212178e-05 6.1920997916445714e-08
+ 2.669259840212178e-05 6.1920998223993239e-08
+ 2.6697598402121781e-05 6.1920998009905516e-08
+ 2.6702598402121779e-05 6.1920998133902404e-08
+ 2.6707598402121779e-05 6.1920998152251322e-08
+ 2.671259840212178e-05 6.1920998179258173e-08
+ 2.6717598402121781e-05 6.192099801155416e-08
+ 2.6722598402121778e-05 6.1920998071260864e-08
+ 2.6727598402121779e-05 6.1920998112269924e-08
+ 2.673259840212178e-05 6.1920997968529412e-08
+ 2.6737598402121781e-05 6.1920998245398675e-08
+ 2.6742598402121788e-05 6.1920998018424073e-08
+ 2.6747598402121789e-05 6.192099833322449e-08
+ 2.675259840212179e-05 6.1920998209677588e-08
+ 2.6757598402121791e-05 6.1920997964368787e-08
+ 2.6762598402121792e-05 6.1920998271235244e-08
+ 2.6767598402121789e-05 6.1920998103969359e-08
+ 2.677259840212179e-05 6.1920998155262736e-08
+ 2.6777598402121791e-05 6.1920997906652822e-08
+ 2.6782598402121791e-05 6.1920998216065752e-08
+ 2.6787598402121789e-05 6.1920998101431674e-08
+ 2.679259840212179e-05 6.1920998123177948e-08
+ 2.679759840212179e-05 6.192099821299989e-08
+ 2.6802598402121791e-05 6.1920998250771021e-08
+ 2.6807598402121799e-05 6.1920998052937013e-08
+ 2.68125984021218e-05 6.1920998052856042e-08
+ 2.68175984021218e-05 6.1920998394077574e-08
+ 2.6822598402121801e-05 6.1920998242634542e-08
+ 2.6827598402121799e-05 6.1920998006297354e-08
+ 2.6832598402121799e-05 6.1920998044479204e-08
+ 2.68375984021218e-05 6.1920998173409609e-08
+ 2.6842598402121801e-05 6.192099820433064e-08
+ 2.6847598402121798e-05 6.1920997977428499e-08
+ 2.6852598402121799e-05 6.1920998280490734e-08
+ 2.68575984021218e-05 6.1920998095013812e-08
+ 2.6862598402121801e-05 6.1920998115541099e-08
+ 2.6867598402121808e-05 6.1920998187898664e-08
+ 2.6872598402121809e-05 6.1920998252455822e-08
+ 2.687759840212181e-05 6.1920998115459202e-08
+ 2.6882598402121811e-05 6.1920998127754401e-08
+ 2.6887598402121812e-05 6.1920998167238074e-08
+ 2.6892598402121809e-05 6.1920997964890877e-08
+ 2.689759840212181e-05 6.1920998309834602e-08
+ 2.6902598402121811e-05 6.1920998082059846e-08
+ 2.6907598402121811e-05 6.192099813159645e-08
+ 2.6912598402121809e-05 6.1920998082215435e-08
+ 2.691759840212181e-05 6.1920998253680632e-08
+ 2.692259840212181e-05 6.1920998131675158e-08
+ 2.6927598402121811e-05 6.192099803547703e-08
+ 2.6932598402121819e-05 6.1920998129632591e-08
+ 2.693759840212182e-05 6.1920997905899518e-08
+ 2.694259840212182e-05 6.1920997964950235e-08
+ 2.6947598402121821e-05 6.192099785278244e-08
+ 2.6952598402121819e-05 6.1920997253486976e-08
+ 2.6957598402121819e-05 6.1920993414233022e-08
+ 2.6959696721708911e-05 6.1920907211940345e-08
+ 2.6961515926544279e-05 6.1920905244217825e-08
+ 2.6963435513363019e-05 6.1921194826321488e-08
+ 2.6964959730734098e-05 6.1921064473388724e-08
+ 2.6966634646586469e-05 6.1920800009340581e-08
+ 2.6967664785073942e-05 6.1921267022853377e-08
+ 2.69680442166499e-05 6.1921822085650231e-08
+ 2.6968598210876661e-05 6.1920918188574438e-08
+ 2.6968906319039251e-05 6.1925170281555725e-08
+ 2.696915163934907e-05 6.1917951723974962e-08
+ 2.6969352057498279e-05 6.1828473054572478e-08
+ 2.6969560628430078e-05 6.1856043174729323e-08
+ 2.696980383297536e-05 6.1982702760926474e-08
+ 2.6969961803426259e-05 6.1371383753782654e-08
+ 2.697002903154575e-05 5.7464788812019958e-08
+ 2.6970083282402168e-05 5.553118604666543e-08
+ 2.6970126885938471e-05 5.9481096938811117e-08
+ 2.6970191435624979e-05 9.1190665179525829e-08
+ 2.697025728528438e-05 1.3066099721244671e-07
+ 2.697032239269935e-05 1.7195027341485711e-07
+ 2.6970351850298399e-05 3.2918484514365879e-07
+ 2.6970372490738691e-05 6.4721957361844722e-07
+ 2.6970394163418841e-05 7.855420957321512e-07
+ 2.697042160012206e-05 2.7375812763441912e-07
+ 2.697044483911581e-05 -7.4860049806926847e-07
+ 2.6970465838410788e-05 -2.6166344572250228e-06
+ 2.6970484737980161e-05 -4.173225891533453e-06
+ 2.6970499905852361e-05 -4.9843345706017692e-06
+ 2.6970514317163308e-05 -4.7277493736866777e-06
+ 2.6970524391296571e-05 -2.5888336860253209e-06
+ 2.6970536963600541e-05 -6.7480865099660543e-07
+ 2.6970553479451789e-05 -4.8773909746595902e-07
+ 2.697057225635843e-05 -1.5637367743914799e-06
+ 2.6970596565553882e-05 -2.6228222743251851e-06
+ 2.6970621493559139e-05 -3.282716794208598e-06
+ 2.6970647429713791e-05 -3.317398505150019e-06
+ 2.697067114493553e-05 -1.98277015771083e-06
+ 2.697069411648458e-05 -5.2471197723239743e-07
+ 2.6970721071718229e-05 -5.5470138351579351e-07
+ 2.6970751552029619e-05 -1.8872540083531629e-06
+ 2.6970779776265881e-05 -3.0476400998611908e-06
+ 2.697080171334744e-05 -3.711423606746527e-06
+ 2.697082917122388e-05 -3.6503886012169572e-06
+ 2.6970849896626191e-05 -7.5438041356949236e-07
+ 2.6970867493100429e-05 2.263396151288471e-06
+ 2.6970884666378769e-05 -6.5501155516880596e-06
+ 2.6970902468171981e-05 -5.3950348930331477e-05
+ 2.6970924970319059e-05 -0.0001471523103559457
+ 2.697094604856181e-05 -0.00018804394379405131
+ 2.6970959001305011e-05 -0.0001367982530862121
+ 2.6970972508493319e-05 -1.916789347899615e-05
+ 2.697098791096277e-05 0.0001137247513903674
+ 2.6971004050442839e-05 0.00018383226350547689
+ 2.6971027389123789e-05 0.00018519167471686961
+ 2.6971050387132739e-05 0.00014694402667580079
+ 2.697108209105114e-05 9.5410136564457533e-05
+ 2.697111278872122e-05 6.6844239772955043e-05
+ 2.6971149738659941e-05 5.6829662462134473e-05
+ 2.6971189206223049e-05 6.2907029031375962e-05
+ 2.6971240579506112e-05 8.5505697073068513e-05
+ 2.6971304950747031e-05 -0.00018192019936749251
+ 2.6971353050250859e-05 -0.0018956407524396289
+ 2.6971399505787701e-05 -0.0065087121463067018
+ 2.6971414117703789e-05 -0.0082081458384039505
+ 2.6971428608491241e-05 -0.0082152643003391857
+ 2.697143782188158e-05 -0.0060383421242544031
+ 2.6971447797010399e-05 4.7349259928013077e-05
+ 2.6971458330860599e-05 0.01293515554124269
+ 2.697147138771473e-05 0.041297388029211783
+ 2.6971483921748251e-05 0.082851152622422292
+ 2.6971499411999178e-05 0.15199349721304309
+ 2.6971510938391879e-05 0.21337935647670481
+ 2.6971524236631949e-05 0.29035240890555081
+ 2.697153868787497e-05 0.37706491480401277
+ 2.6971555828458749e-05 0.47965911795216037
+ 2.6971577909003509e-05 0.6067313164383501
+ 2.6971607223997131e-05 0.76025732064558182
+ 2.6971643744184379e-05 0.91762954849054523
+ 2.697168535159202e-05 1.044583196869314
+ 2.6971736967513711e-05 1.1359525724148749
+ 2.697177976999523e-05 1.1730909345321761
+ 2.6971832754414871e-05 1.1933715789145669
+ 2.6971880981765671e-05 1.199570701829493
+ 2.6971947495880349e-05 1.201561547976453
+ 2.6972023495178912e-05 1.201262093491287
+ 2.697214710308636e-05 1.2004616942677619
+ 2.697227980932354e-05 1.200066814103151
+ 2.6972409088348902e-05 1.1999759615731731
+ 2.6972531895196109e-05 1.199978536186957
+ 2.6972651306414188e-05 1.199991357394435
+ 2.697277895650045e-05 1.1999983655890201
+ 2.6972897670108441e-05 1.200000179104145
+ 2.6973021606774039e-05 1.200000313768455
+ 2.6973139364559509e-05 1.200000126515133
+ 2.697326066494527e-05 1.200000002575456
+ 2.6973378314094851e-05 1.19999996159068
+ 2.6973498454612991e-05 1.19999995524748
+ 2.6973616407605958e-05 1.199999957952411
+ 2.6973736044528431e-05 1.1999999622050721
+ 2.6973804725387669e-05 1.1999999757266819
+ 2.6973851845382089e-05 1.1999999951200291
+ 2.6973900586895318e-05 1.1999999885986581
+ 2.6973965876787979e-05 1.199999939801778
+ 2.6974018492952208e-05 1.1999999119522671
+ 2.697404675621631e-05 1.199999892476989
+ 2.6974071556875181e-05 1.199999855398699
+ 2.6974094097116471e-05 1.199999792777477
+ 2.6974116767789959e-05 1.1999997089577921
+ 2.6974145069413232e-05 1.1999996551777261
+ 2.6974166461143009e-05 1.1999998853885261
+ 2.6974191217303211e-05 1.200000184029625
+ 2.697422620458126e-05 1.2000003227545279
+ 2.697427936480947e-05 1.200000197498206
+ 2.6974330760055111e-05 1.200000016239805
+ 2.6974403846423079e-05 1.199999886481256
+ 2.69744862235054e-05 1.1999998710379649
+ 2.697458466998461e-05 1.1999999152699889
+ 2.6974679421806409e-05 1.199999955110485
+ 2.6974795308542242e-05 1.1999999729588151
+ 2.6974933328035439e-05 1.1999999702908271
+ 2.6975151058112801e-05 1.199999961985966
+ 2.6975551458678569e-05 1.1999999587474031
+ 2.6975926114726369e-05 1.199999959791777
+ 2.697648750554583e-05 1.199999960513622
+ 2.6977081104979249e-05 1.1999999605484779
+ 2.6977624863258141e-05 1.199999960438261
+ 2.697815075654239e-05 1.1999999604817739
+ 2.6978524354433881e-05 1.199999960607403
+ 2.6978945119833461e-05 1.199999960438435
+ 2.6979425566234721e-05 1.199999960456239
+ 2.69800262418615e-05 1.199999960478753
+ 2.6980752628646681e-05 1.1999999604827161
+ 2.6981846853730361e-05 1.1999999604817071
+ 2.6983489727444258e-05 1.1999999604809439
+ 2.6986298303729841e-05 1.199999960480937
+ 2.6990852411258252e-05 1.1999999604809211
+ 2.6995852411258249e-05 1.199999960480868
+ 2.700085241125825e-05 1.199999960480858
+ 2.7005852411258251e-05 1.1999999604808631
+ 2.7010852411258251e-05 1.1999999604808671
+ 2.7015852411258249e-05 1.199999960480868
+ 2.702085241125825e-05 1.199999960480868
+ 2.702585241125825e-05 1.199999960480868
+ 2.7030852411258251e-05 1.199999960480868
+ 2.7035852411258259e-05 1.199999960480868
+ 2.704085241125826e-05 1.199999960480868
+ 2.704585241125826e-05 1.199999960480868
+ 2.7050852411258261e-05 1.199999960480868
+ 2.7055852411258259e-05 1.199999960480868
+ 2.7060852411258259e-05 1.199999960480868
+ 2.706585241125826e-05 1.199999960480868
+ 2.7070852411258261e-05 1.199999960480868
+ 2.7075852411258258e-05 1.199999960480868
+ 2.7080852411258259e-05 1.199999960480868
+ 2.708585241125826e-05 1.199999960480868
+ 2.7090852411258261e-05 1.199999960480868
+ 2.7095852411258262e-05 1.199999960480868
+ 2.7100852411258269e-05 1.199999960480868
+ 2.710585241125827e-05 1.199999960480868
+ 2.7110852411258271e-05 1.199999960480868
+ 2.7115852411258271e-05 1.199999960480868
+ 2.7120852411258269e-05 1.199999960480868
+ 2.712585241125827e-05 1.199999960480868
+ 2.7130852411258271e-05 1.199999960480868
+ 2.7135852411258271e-05 1.199999960480868
+ 2.7140852411258269e-05 1.199999960480868
+ 2.714585241125827e-05 1.199999960480868
+ 2.715085241125827e-05 1.199999960480868
+ 2.7155852411258271e-05 1.199999960480868
+ 2.7160852411258279e-05 1.199999960480868
+ 2.7165852411258279e-05 1.199999960480868
+ 2.717085241125828e-05 1.199999960480868
+ 2.7175852411258281e-05 1.199999960480868
+ 2.7180852411258278e-05 1.199999960480868
+ 2.7185852411258279e-05 1.199999960480868
+ 2.719085241125828e-05 1.199999960480868
+ 2.7195852411258281e-05 1.199999960480868
+ 2.7200852411258282e-05 1.199999960480868
+ 2.7205852411258279e-05 1.199999960480868
+ 2.721085241125828e-05 1.199999960480868
+ 2.7215852411258281e-05 1.1999999604808671
+ 2.7220852411258281e-05 1.1999999604808651
+ 2.7225852411258289e-05 1.199999960480862
+ 2.723085241125829e-05 1.1999999604808571
+ 2.7235852411258291e-05 1.1999999604808469
+ 2.7240852411258291e-05 1.199999960480828
+ 2.7245852411258289e-05 1.1999999604807901
+ 2.725085241125829e-05 1.1999999604807201
+ 2.725585241125829e-05 1.199999960480584
+ 2.7260852411258291e-05 1.199999960480326
+ 2.7265852411258289e-05 1.1999999604798499
+ 2.7270852411258289e-05 1.1999999604790139
+ 2.727585241125829e-05 1.199999960477538
+ 2.7280852411258291e-05 1.1999999604745231
+ 2.7285852411258299e-05 1.199999960462875
+ 2.7288345575923462e-05 1.1999999603765039
+ 2.7290035161581239e-05 1.199999960105943
+ 2.7292147002940449e-05 1.1999999602004441
+ 2.7293631166285301e-05 1.1999999604360989
+ 2.7295454660053169e-05 1.199999960417435
+ 2.7296677268733348e-05 1.1999999605297831
+ 2.7297218304334241e-05 1.1999999610556591
+ 2.7297864920075139e-05 1.19999996155816
+ 2.7298192880289179e-05 1.1999999641240049
+ 2.729849305534948e-05 1.199999966964983
+ 2.7298729399851999e-05 1.19999996529356
+ 2.729893639820539e-05 1.1999999228884151
+ 2.729915167840406e-05 1.199999867899195
+ 2.729939445853257e-05 1.199999825428631
+ 2.7299521771392322e-05 1.1999996484182449
+ 2.7299587010290539e-05 1.19999929506368
+ 2.7299645048282679e-05 1.199998842583986
+ 2.7299690461726521e-05 1.199998524307897
+ 2.7299758027227462e-05 1.199998011562839
+ 2.7299828037226009e-05 1.1999980855540771
+ 2.7299908843764458e-05 1.199999136828205
+ 2.72999338870779e-05 1.199999688466439
+ 2.7299953857450041e-05 1.199999805067012
+ 2.729997245496643e-05 1.2000000888174001
+ 2.7299997021435281e-05 1.200002648196931
+ 2.7300024268442049e-05 1.200007875412793
+ 2.7300048733733611e-05 1.2000107387877199
+ 2.7300069551726811e-05 1.200010163078493
+ 2.7300086775732172e-05 1.200007966277864
+ 2.730010141546144e-05 1.200005018110625
+ 2.7300117355302809e-05 1.200001942269882
+ 2.7300134621211412e-05 1.1999996909728601
+ 2.730016132729905e-05 1.1999980265809771
+ 2.73001910478454e-05 1.1999973264724231
+ 2.730021885733492e-05 1.199997082329423
+ 2.7300242966201852e-05 1.1999975737131909
+ 2.730026834762619e-05 1.1999993456006921
+ 2.730029924706642e-05 1.2000025071948339
+ 2.7300328894664151e-05 1.200005286559902
+ 2.7300353094295511e-05 1.20000707533899
+ 2.7300369615245379e-05 1.200008316362714
+ 2.730038521672027e-05 1.2000097685333919
+ 2.7300400013909471e-05 1.2000118071247241
+ 2.7300414879999519e-05 1.2000132921513109
+ 2.7300427965561521e-05 1.200012978587649
+ 2.7300442058291271e-05 1.2000113562916039
+ 2.7300458235245141e-05 1.2000087501913019
+ 2.7300487429735611e-05 1.2000015007322551
+ 2.7300514101080649e-05 1.199968113641035
+ 2.7300539225945568e-05 1.1998929416855419
+ 2.7300565758731479e-05 1.199775099947203
+ 2.730060372572869e-05 1.199473438500523
+ 2.730062611883868e-05 1.199757909892448
+ 2.7300642119654258e-05 1.20131069959198
+ 2.7300661073281189e-05 1.2058464354608609
+ 2.7300682298788689e-05 1.2137552936029681
+ 2.730069800013011e-05 1.2151733449145841
+ 2.7300711884001691e-05 1.20045983330872
+ 2.7300730364832659e-05 1.1437851220163699
+ 2.730074838790159e-05 1.057099318968302
+ 2.730076608111391e-05 0.95568614480438829
+ 2.7300787645772961e-05 0.82506996717555059
+ 2.7300809002278968e-05 0.69583764427778905
+ 2.730082339094758e-05 0.61066347005174582
+ 2.7300834830333541e-05 0.54466988424524754
+ 2.730084953209687e-05 0.46280694785556081
+ 2.7300860759968781e-05 0.40301332585680127
+ 2.7300874908332349e-05 0.33203044075011012
+ 2.730089456226984e-05 0.24406566368072069
+ 2.7300918132601189e-05 0.15885012666376361
+ 2.730094007147096e-05 0.10065196509595779
+ 2.730095931750931e-05 0.06491645247454457
+ 2.7300975308657041e-05 0.044224716923368441
+ 2.7300992658074699e-05 0.028707539669373259
+ 2.7301014539318519e-05 0.016188955192623259
+ 2.7301035077640691e-05 0.0092363299825546398
+ 2.730106109658721e-05 0.004313562215865996
+ 2.7301087941073929e-05 0.0018109315586898799
+ 2.73011231225072e-05 0.00040161274956366269
+ 2.7301163684484039e-05 -0.0001003580342856002
+ 2.730122060965175e-05 -0.0001904494631160778
+ 2.7301296523712951e-05 -0.0001059298395616215
+ 2.7301387452366829e-05 -2.8186370716768041e-05
+ 2.7301486216837359e-05 3.2380291184909801e-07
+ 2.7301616510662801e-05 4.5291618088568163e-06
+ 2.7301791313463599e-05 1.763514250066556e-06
+ 2.730193366516257e-05 3.4557119954145332e-07
+ 2.7302058716969919e-05 2.3592899839107822e-08
+ 2.7302176147676229e-05 1.5322079005694889e-08
+ 2.7302293861822429e-05 4.5374636025504517e-08
+ 2.7302421893853041e-05 6.0567229596916148e-08
+ 2.7302541644880518e-05 6.4318120844687453e-08
+ 2.730266684520778e-05 6.6212891139622886e-08
+ 2.730278543534199e-05 6.9079226848066783e-08
+ 2.730290734994341e-05 7.341955810138941e-08
+ 2.7303025313988752e-05 8.3831643540485961e-08
+ 2.7303145702599121e-05 1.2316879209495149e-07
+ 2.730322531648405e-05 2.9353182904079641e-07
+ 2.7303276535695882e-05 5.8356613663789373e-07
+ 2.7303329414884069e-05 6.6039064893993046e-07
+ 2.7303395622635491e-05 2.631080090896711e-07
+ 2.7303431655667779e-05 -1.166298316734775e-07
+ 2.730346276162258e-05 -5.0855494979087598e-07
+ 2.7303487594735929e-05 -9.4032923535705984e-07
+ 2.730351084934648e-05 -1.4449051183465699e-06
+ 2.7303532417384692e-05 -1.750142635177256e-06
+ 2.7303557647847149e-05 -1.617766447134445e-06
+ 2.73035789391432e-05 -1.803884067908832e-06
+ 2.730360185094274e-05 -9.284384568997161e-07
+ 2.730363618808254e-05 7.7993965778345826e-07
+ 2.7303677124113422e-05 1.4396655729812849e-06
+ 2.7303731153803171e-05 9.256783696942898e-07
+ 2.730379491772887e-05 2.6768757301104469e-07
+ 2.7303875617042698e-05 4.1258731205662752e-08
+ 2.7303976911139429e-05 -1.897283389351213e-08
+ 2.7304076434377119e-05 -1.352177110250171e-08
+ 2.7304195553699351e-05 4.2071255877860578e-08
+ 2.7304317755265932e-05 7.2588924441247763e-08
+ 2.730448829807784e-05 7.1187617059441836e-08
+ 2.730472794002717e-05 6.214370804697068e-08
+ 2.7305045606655839e-05 6.0670436774920672e-08
+ 2.730539530885832e-05 6.169350770655982e-08
+ 2.73058355639986e-05 6.2034962768593005e-08
+ 2.730635427266754e-05 6.2058515646860997e-08
+ 2.730698023216387e-05 6.160423589290925e-08
+ 2.7307377633941792e-05 6.0285620624168321e-08
+ 2.7307722393926089e-05 6.3034576416247547e-08
+ 2.7308157422606939e-05 6.2231129335117284e-08
+ 2.7308621531103541e-05 6.1725644629629221e-08
+ 2.7309170995167731e-05 6.1909840872838208e-08
+ 2.73097637792727e-05 6.1922572553353522e-08
+ 2.7310586620303299e-05 6.1919211103706503e-08
+ 2.731174558359217e-05 6.1921742403254368e-08
+ 2.731375808992086e-05 6.1921381769363105e-08
+ 2.731681245383603e-05 6.1921011609455071e-08
+ 2.7321812453836031e-05 6.192098259488007e-08
+ 2.7326812453836032e-05 6.1920995164440843e-08
+ 2.7331812453836029e-05 6.1920997577071746e-08
+ 2.733681245383603e-05 6.1920997920579155e-08
+ 2.7341812453836031e-05 6.1920998205857509e-08
+ 2.7346812453836031e-05 6.1920998053491754e-08
+ 2.7351812453836029e-05 6.1920998083878875e-08
+ 2.735681245383603e-05 6.1920998145964246e-08
+ 2.7361812453836031e-05 6.1920998199677292e-08
+ 2.7366812453836031e-05 6.1920998300504587e-08
+ 2.7371812453836039e-05 6.1920998021419023e-08
+ 2.737681245383604e-05 6.1920998386373253e-08
+ 2.738181245383604e-05 6.1920997952112617e-08
+ 2.7386812453836041e-05 6.1920998240750449e-08
+ 2.7391812453836039e-05 6.1920998066110731e-08
+ 2.7396812453836039e-05 6.1920998124512197e-08
+ 2.740181245383604e-05 6.1920998145277898e-08
+ 2.7406812453836041e-05 6.192099793619115e-08
+ 2.7411812453836038e-05 6.1920998021678665e-08
+ 2.7416812453836039e-05 6.192099810726834e-08
+ 2.742181245383604e-05 6.192099816932208e-08
+ 2.7426812453836041e-05 6.1920998207511248e-08
+ 2.7431812453836048e-05 6.1920997978757348e-08
+ 2.7436812453836049e-05 6.1920998061694421e-08
+ 2.744181245383605e-05 6.1920998072085265e-08
+ 2.7446812453836051e-05 6.1920998169520735e-08
+ 2.7451812453836052e-05 6.1920997961416189e-08
+ 2.7456812453836049e-05 6.1920998289328411e-08
+ 2.746181245383605e-05 6.1920998078275527e-08
+ 2.7466812453836051e-05 6.1920998120158368e-08
+ 2.7471812453836051e-05 6.1920998209523627e-08
+ 2.7476812453836049e-05 6.192099825193941e-08
+ 2.748181245383605e-05 6.192099807143976e-08
+ 2.748681245383605e-05 6.1920998052593383e-08
+ 2.7491812453836051e-05 6.1920998183041631e-08
+ 2.7496812453836059e-05 6.1920997918188352e-08
+ 2.750181245383606e-05 6.1920998254746504e-08
+ 2.750681245383606e-05 6.192099808758479e-08
+ 2.7511812453836061e-05 6.1920998132714308e-08
+ 2.7516812453836059e-05 6.1920997952442272e-08
+ 2.7521812453836059e-05 6.1920998018939347e-08
+ 2.752681245383606e-05 6.1920998335568601e-08
+ 2.7531812453836061e-05 6.1920998127014002e-08
+ 2.7536812453836058e-05 6.1920998163599671e-08
+ 2.7541812453836059e-05 6.192099823758383e-08
+ 2.754681245383606e-05 6.1920998071287334e-08
+ 2.7551812453836061e-05 6.1920998106813338e-08
+ 2.7556812453836068e-05 6.1920998082150346e-08
+ 2.7561812453836069e-05 6.1920998168358871e-08
+ 2.756681245383607e-05 6.1920998124868348e-08
+ 2.7571812453836071e-05 6.1920998134997261e-08
+ 2.7576812453836072e-05 6.1920998276083436e-08
+ 2.7581812453836069e-05 6.1920998119221881e-08
+ 2.758681245383607e-05 6.1920998174260944e-08
+ 2.7591812453836071e-05 6.1920998173189447e-08
+ 2.7596812453836071e-05 6.1920997921783768e-08
+ 2.7601812453836069e-05 6.1920997983431925e-08
+ 2.760681245383607e-05 6.1920997763116657e-08
+ 2.761181245383607e-05 6.1920997321886302e-08
+ 2.7616812453836071e-05 6.1920993119662016e-08
+ 2.7618904691257329e-05 6.1920904938731779e-08
+ 2.7620730166261861e-05 6.1920910400234853e-08
+ 2.7622634487008131e-05 6.1921194603202302e-08
+ 2.762416737863161e-05 6.1921059867327583e-08
+ 2.7625844295468219e-05 6.1920803608669659e-08
+ 2.762686863478705e-05 6.1921271266304438e-08
+ 2.76272439115731e-05 6.1921855189188601e-08
+ 2.762779193044729e-05 6.192090589651852e-08
+ 2.7628098852867539e-05 6.1925235855687003e-08
+ 2.7628343864435201e-05 6.1917130586861715e-08
+ 2.762854508450179e-05 6.182386663021602e-08
+ 2.7628753572625281e-05 6.1862854140195364e-08
+ 2.7628995471946069e-05 6.198014949308198e-08
+ 2.7629146910872721e-05 6.1311093189061002e-08
+ 2.762921264950632e-05 5.7434793633703307e-08
+ 2.7629267177002391e-05 5.5662947541478682e-08
+ 2.7629310643463331e-05 5.9416146802686247e-08
+ 2.7629375197495139e-05 9.0931782859128961e-08
+ 2.762944112828669e-05 1.30484784085262e-07
+ 2.762950652596704e-05 1.7184871199052279e-07
+ 2.762953605246091e-05 3.301462151123881e-07
+ 2.762955666815571e-05 6.4918722941650432e-07
+ 2.762957839410544e-05 7.8429257924899267e-07
+ 2.76296058753938e-05 2.68890572105836e-07
+ 2.7629629043213629e-05 -7.5918462477261548e-07
+ 2.7629650035619051e-05 -2.6314506564000362e-06
+ 2.7629668986331381e-05 -4.1835129756115756e-06
+ 2.7629684114983801e-05 -4.9957384363697159e-06
+ 2.762969861895852e-05 -4.6912839183784024e-06
+ 2.7629708732920641e-05 -2.54204049706228e-06
+ 2.7629721324359702e-05 -6.5741539526320786e-07
+ 2.7629738034861452e-05 -5.0620722072350913e-07
+ 2.7629756822374691e-05 -1.589351209525371e-06
+ 2.7629781242081172e-05 -2.6410260818708882e-06
+ 2.7629806219213459e-05 -3.2968465003781499e-06
+ 2.7629832207593981e-05 -3.298765115769135e-06
+ 2.762985559932268e-05 -1.9454524934609331e-06
+ 2.762987865222793e-05 -5.0569742823365369e-07
+ 2.7629905826482259e-05 -5.7490055015123506e-07
+ 2.762993606625987e-05 -1.9118890849417991e-06
+ 2.762996452883019e-05 -3.0756131797743239e-06
+ 2.7629986403834941e-05 -3.7293209880792221e-06
+ 2.763001354398789e-05 -3.617254858877862e-06
+ 2.7630033702328961e-05 -7.7212474833418009e-07
+ 2.7630051086269331e-05 2.2674040636779928e-06
+ 2.763006825635789e-05 -5.8563317925984113e-06
+ 2.7630086052946759e-05 -5.2109764880977042e-05
+ 2.7630108504163941e-05 -0.00014506764542409359
+ 2.763012927716005e-05 -0.00018880921166110771
+ 2.7630142307513231e-05 -0.00014145215750551449
+ 2.7630155723480861e-05 -2.6756219447891061e-05
+ 2.7630170905283471e-05 0.00010685727095062431
+ 2.7630186956027751e-05 0.00018163111476453289
+ 2.7630209586510492e-05 0.00018720346092068369
+ 2.7630232707363861e-05 0.00014988782655092289
+ 2.7630263938523609e-05 9.8345342028061561e-05
+ 2.7630294581628799e-05 6.8199343526210247e-05
+ 2.7630331126454348e-05 5.6932567757480017e-05
+ 2.763037023288784e-05 6.2000272416477643e-05
+ 2.7630420665978781e-05 8.3905803877765004e-05
+ 2.7630484008439849e-05 -0.0001188245205948993
+ 2.7630533689395009e-05 -0.001682626278443479
+ 2.763057911305003e-05 -0.0059328046879999754
+ 2.7630595684284049e-05 -0.007960673156300618
+ 2.7630609718829731e-05 -0.0085077868794419496
+ 2.763061934172075e-05 -0.0069848859385275609
+ 2.7630629353896131e-05 -0.0020400586448371429
+ 2.7630639752795781e-05 0.0088737622511988919
+ 2.7630651625899379e-05 0.031345230665465948
+ 2.7630664318439209e-05 0.069140906790503512
+ 2.7630680892275289e-05 0.1390577271005019
+ 2.763069157704057e-05 0.19431937077854769
+ 2.763070378937303e-05 0.26370802289321837
+ 2.7630718321714141e-05 0.35032538469727842
+ 2.7630733805654659e-05 0.44345718354692443
+ 2.7630754853989419e-05 0.56659589316096048
+ 2.7630781040251051e-05 0.70896505598340565
+ 2.7630816505817461e-05 0.87341557985969398
+ 2.7630855495811918e-05 1.008158512856639
+ 2.7630908766381491e-05 1.119820944141616
+ 2.7630945025796981e-05 1.1594101167404141
+ 2.76309869163583e-05 1.1832304397060021
+ 2.763103776312822e-05 1.195838717414254
+ 2.7631092097723979e-05 1.200262980504802
+ 2.7631165987717661e-05 1.2013549482674351
+ 2.7631258846998059e-05 1.200904938394161
+ 2.7631408538384261e-05 1.2002404141009619
+ 2.763154795622161e-05 1.200014815580166
+ 2.7631689063037041e-05 1.1999766207300611
+ 2.76318167649311e-05 1.199986222580532
+ 2.76319425690408e-05 1.1999956607183799
+ 2.7632062229047601e-05 1.19999939493841
+ 2.7632182675453021e-05 1.2000002480736061
+ 2.7632300923838981e-05 1.2000001980214059
+ 2.7632420552807469e-05 1.2000000528768779
+ 2.763253910040445e-05 1.19999997927973
+ 2.7632658555836782e-05 1.1999999581274099
+ 2.763277724521111e-05 1.19999995697527
+ 2.7632896460412951e-05 1.1999999605711691
+ 2.7632978638926931e-05 1.199999970766952
+ 2.7633028076218421e-05 1.1999999923148441
+ 2.7633075434708631e-05 1.1999999937293451
+ 2.7633143575924649e-05 1.199999946405037
+ 2.763321385308926e-05 1.199999911781868
+ 2.763324532795766e-05 1.199999878299824
+ 2.7633268007659008e-05 1.199999820014211
+ 2.7633288692305699e-05 1.19999974542298
+ 2.763331133976367e-05 1.1999996577140939
+ 2.763333737485441e-05 1.1999997005399381
+ 2.763335760498027e-05 1.1999999877426359
+ 2.7633381927744789e-05 1.200000245406257
+ 2.763343057327381e-05 1.200000311542325
+ 2.7633475417515459e-05 1.200000152798522
+ 2.7633540725962359e-05 1.1999999519712941
+ 2.7633613404182131e-05 1.1999998705943919
+ 2.7633685736592629e-05 1.199999878265096
+ 2.7633774776273619e-05 1.1999999231283309
+ 2.763387411499926e-05 1.1999999605994689
+ 2.7633989653468341e-05 1.199999973401835
+ 2.7634140023567079e-05 1.19999996883922
+ 2.7634364270827922e-05 1.1999999612004191
+ 2.7634773415557879e-05 1.199999958900231
+ 2.7635155028665529e-05 1.1999999599383511
+ 2.76357300807085e-05 1.1999999605306559
+ 2.7636277184049779e-05 1.199999960536551
+ 2.76368338686673e-05 1.1999999604298051
+ 2.7637419744478819e-05 1.199999960497391
+ 2.7637827296432009e-05 1.1999999605900289
+ 2.76382727439383e-05 1.199999960432075
+ 2.7638780590482299e-05 1.1999999604605509
+ 2.763940101052591e-05 1.1999999604811791
+ 2.764020721738267e-05 1.1999999604830101
+ 2.764142985079279e-05 1.1999999604814089
+ 2.7643373618650831e-05 1.19999996048088
+ 2.7646521522470831e-05 1.1999999604809459
+ 2.7651521522470839e-05 1.199999960480902
+ 2.765652152247084e-05 1.199999960480862
+ 2.766152152247084e-05 1.19999996048086
+ 2.7666521522470841e-05 1.199999960480864
+ 2.7671521522470839e-05 1.199999960480868
+ 2.7676521522470839e-05 1.199999960480868
+ 2.768152152247084e-05 1.199999960480868
+ 2.7686521522470841e-05 1.199999960480868
+ 2.7691521522470838e-05 1.1999999604808691
+ 2.7696521522470839e-05 1.199999960480868
+ 2.770152152247084e-05 1.199999960480868
+ 2.7706521522470841e-05 1.199999960480868
+ 2.7711521522470842e-05 1.199999960480868
+ 2.7716521522470849e-05 1.199999960480868
+ 2.772152152247085e-05 1.199999960480868
+ 2.7726521522470851e-05 1.199999960480868
+ 2.7731521522470852e-05 1.199999960480868
+ 2.7736521522470849e-05 1.199999960480868
+ 2.774152152247085e-05 1.199999960480868
+ 2.7746521522470851e-05 1.199999960480868
+ 2.7751521522470851e-05 1.199999960480868
+ 2.7756521522470849e-05 1.199999960480868
+ 2.776152152247085e-05 1.199999960480868
+ 2.776652152247085e-05 1.199999960480868
+ 2.7771521522470851e-05 1.199999960480868
+ 2.7776521522470859e-05 1.199999960480868
+ 2.778152152247086e-05 1.199999960480868
+ 2.778652152247086e-05 1.199999960480868
+ 2.7791521522470861e-05 1.199999960480868
+ 2.7796521522470859e-05 1.199999960480868
+ 2.7801521522470859e-05 1.199999960480868
+ 2.780652152247086e-05 1.199999960480868
+ 2.7811521522470861e-05 1.199999960480868
+ 2.7816521522470858e-05 1.199999960480868
+ 2.7821521522470859e-05 1.199999960480868
+ 2.782652152247086e-05 1.199999960480868
+ 2.7831521522470861e-05 1.199999960480868
+ 2.7836521522470862e-05 1.199999960480868
+ 2.7841521522470869e-05 1.199999960480868
+ 2.784652152247087e-05 1.199999960480868
+ 2.7851521522470871e-05 1.199999960480868
+ 2.7856521522470871e-05 1.199999960480868
+ 2.7861521522470869e-05 1.199999960480868
+ 2.786652152247087e-05 1.199999960480868
+ 2.7871521522470871e-05 1.1999999604808671
+ 2.7876521522470871e-05 1.199999960480866
+ 2.7881521522470869e-05 1.1999999604808651
+ 2.788652152247087e-05 1.1999999604808611
+ 2.789152152247087e-05 1.199999960480854
+ 2.7896521522470871e-05 1.1999999604808429
+ 2.7901521522470879e-05 1.1999999604808189
+ 2.7906521522470879e-05 1.1999999604807741
+ 2.791152152247088e-05 1.1999999604806879
+ 2.7916521522470881e-05 1.1999999604805229
+ 2.7921521522470878e-05 1.1999999604802121
+ 2.7926521522470879e-05 1.1999999604796501
+ 2.793152152247088e-05 1.19999996047866
+ 2.7936521522470881e-05 1.1999999604768889
+ 2.7941521522470878e-05 1.1999999604728251
+ 2.7946521522470879e-05 1.1999999604489049
+ 2.79485795281005e-05 1.1999999602346481
+ 2.795041850167784e-05 1.1999999600947631
+ 2.795219357057187e-05 1.1999999603322
+ 2.7953791061319959e-05 1.1999999604920411
+ 2.7955488778761049e-05 1.1999999604005309
+ 2.7956492832258399e-05 1.199999960843962
+ 2.795685486582886e-05 1.1999999620765811
+ 2.7957363959250569e-05 1.199999962884855
+ 2.7957666024358999e-05 1.199999967195589
+ 2.7957908082481491e-05 1.1999999648268
+ 2.7958109554415479e-05 1.1999999188981061
+ 2.7958321196857989e-05 1.1999998664179381
+ 2.7958564388290689e-05 1.199999824338748
+ 2.795868720198749e-05 1.199999639416677
+ 2.7958751215833309e-05 1.199999286419382
+ 2.7958809138172289e-05 1.1999988371390879
+ 2.79588549470323e-05 1.1999985183649391
+ 2.795892203481894e-05 1.1999980122042271
+ 2.7958992391003659e-05 1.1999980964481749
+ 2.7959073248123541e-05 1.1999991564416921
+ 2.7959098157138401e-05 1.1999997002149609
+ 2.7959118017311951e-05 1.199999792771725
+ 2.795913694343419e-05 1.2000001438567609
+ 2.795916167591043e-05 1.2000028144799799
+ 2.7959188094510051e-05 1.2000079493563169
+ 2.7959212832579009e-05 1.2000107614004309
+ 2.795923379413236e-05 1.200010100955077
+ 2.7959251394919711e-05 1.200007788504994
+ 2.7959265600788431e-05 1.200004891809596
+ 2.7959281341648811e-05 1.200001869451754
+ 2.7959299337051021e-05 1.199999578642313
+ 2.795932585863428e-05 1.199997992009374
+ 2.7959355919154939e-05 1.1999973058732689
+ 2.7959384334509941e-05 1.199997087555714
+ 2.795940881221783e-05 1.1999976771146721
+ 2.795943435670314e-05 1.199999575009141
+ 2.7959463290195139e-05 1.200002590244083
+ 2.7959495296939399e-05 1.2000055175908919
+ 2.795951988194685e-05 1.200007287054996
+ 2.795953645991819e-05 1.200008570708575
+ 2.7959552163919589e-05 1.200010160313135
+ 2.7959566287865641e-05 1.2000122081683251
+ 2.7959584265980721e-05 1.2000133514850251
+ 2.7959595820947299e-05 1.2000126141444261
+ 2.795960947920144e-05 1.200010789991548
+ 2.7959631458455909e-05 1.200007100201038
+ 2.795965749114984e-05 1.1999974632127259
+ 2.7959682864279782e-05 1.199955524971559
+ 2.795970399552831e-05 1.199886832416093
+ 2.795973214651508e-05 1.199758105347515
+ 2.7959771724216131e-05 1.199442963889799
+ 2.7959792136479499e-05 1.199879635003031
+ 2.79598083822979e-05 1.201766071918172
+ 2.7959829377801749e-05 1.2074127562302299
+ 2.7959851365263269e-05 1.215117794968229
+ 2.795986584066592e-05 1.21276932017587
+ 2.7959879545737401e-05 1.191713289315923
+ 2.7959896930456449e-05 1.131559206750546
+ 2.795991732428428e-05 1.0283992470033381
+ 2.7959938765051031e-05 0.90242527303057374
+ 2.7959958585946251e-05 0.78157073678132938
+ 2.795997606934277e-05 0.67601416573962891
+ 2.7959988537487491e-05 0.60243489802792194
+ 2.7959999843599629e-05 0.53740384997922475
+ 2.7960013385843269e-05 0.46213908367553608
+ 2.796002554128301e-05 0.3975745403219092
+ 2.7960040033158849e-05 0.32537626572863693
+ 2.7960060267047659e-05 0.23607056618256411
+ 2.796008373007783e-05 0.15313975473347921
+ 2.7960105896715831e-05 0.096127357679719916
+ 2.796012348893543e-05 0.06429676848424154
+ 2.7960139116301751e-05 0.044215071121174933
+ 2.7960156465240188e-05 0.028721515454763969
+ 2.7960178173152318e-05 0.01628807454814513
+ 2.7960198923065259e-05 0.0092424668010048696
+ 2.796022481824765e-05 0.0043343371384816139
+ 2.7960251843985909e-05 0.001808033963991512
+ 2.7960286857660591e-05 0.00040419677830829651
+ 2.796032756750389e-05 -0.0001011277112596603
+ 2.7960384248846371e-05 -0.00019066304337467981
+ 2.796046031837785e-05 -0.00010600406462262271
+ 2.7960551091330559e-05 -2.82859214358876e-05
+ 2.796065010776822e-05 3.4274196253630869e-07
+ 2.7960780418609751e-05 4.5389353815072696e-06
+ 2.796095577771221e-05 1.7639001111445581e-06
+ 2.7961098313187729e-05 3.4526319968389352e-07
+ 2.7961223381316051e-05 2.3645194552229e-08
+ 2.79613407544474e-05 1.539661994813652e-08
+ 2.7961458420975471e-05 4.5403409898760178e-08
+ 2.7961586380449431e-05 6.0576747670415655e-08
+ 2.796170611533349e-05 6.4357190126052174e-08
+ 2.796183129105683e-05 6.6276801101043167e-08
+ 2.7961949886148009e-05 6.9164176108655494e-08
+ 2.7962071793833541e-05 7.3563090156713236e-08
+ 2.7962189764072339e-05 8.4243832675528041e-08
+ 2.796231014927828e-05 1.2511897869864381e-07
+ 2.7962388278922409e-05 3.0065988068370941e-07
+ 2.796243928626675e-05 5.8908154570769409e-07
+ 2.7962492489002881e-05 6.5614822297808596e-07
+ 2.7962558508032649e-05 2.519785364778279e-07
+ 2.7962593901225861e-05 -1.23872460450121e-07
+ 2.796262514615784e-05 -5.1913495525598701e-07
+ 2.7962650069515871e-05 -9.5563595743004254e-07
+ 2.796267335056206e-05 -1.461488144492454e-06
+ 2.7962694863687928e-05 -1.750926855374232e-06
+ 2.7962720821413179e-05 -1.620114606531492e-06
+ 2.796274168719796e-05 -1.794090343356364e-06
+ 2.796276449024037e-05 -8.6928094575116862e-07
+ 2.7962800928416651e-05 8.807092572862783e-07
+ 2.7962841129937082e-05 1.436780594090441e-06
+ 2.7962897135352539e-05 8.7243379917395188e-07
+ 2.7962960681431051e-05 2.4440018552447579e-07
+ 2.796304356700641e-05 3.457388950507587e-08
+ 2.7963137252728398e-05 -1.7785496420834631e-08
+ 2.796324543779708e-05 -9.4794560786005529e-09
+ 2.7963357830012931e-05 4.2865419735299691e-08
+ 2.7963487355558961e-05 7.3385595318210207e-08
+ 2.7963651990166171e-05 7.0857680847301737e-08
+ 2.7963905119269498e-05 6.182473224815063e-08
+ 2.7964212413396861e-05 6.0703434193580523e-08
+ 2.7964574260605399e-05 6.1736598248596801e-08
+ 2.7965005465064681e-05 6.2031740405852282e-08
+ 2.7965538381995311e-05 6.2058832033973181e-08
+ 2.7966145758969621e-05 6.1575104256312395e-08
+ 2.7966540749792799e-05 6.0294704188780334e-08
+ 2.796688068217032e-05 6.3058343977474481e-08
+ 2.7967310759764952e-05 6.2213807734103701e-08
+ 2.7967776436018691e-05 6.172814255431875e-08
+ 2.7968326633823861e-05 6.1910898396168365e-08
+ 2.7968917953855961e-05 6.1921916420141739e-08
+ 2.7969738579512351e-05 6.1919095151195911e-08
+ 2.7970890326760811e-05 6.1921772326511809e-08
+ 2.7972893051050308e-05 6.1921391824468682e-08
+ 2.7975932504904111e-05 6.1921012650683715e-08
+ 2.7980932504904111e-05 6.1920981954431245e-08
+ 2.7985932504904109e-05 6.1920995044241653e-08
+ 2.799093250490411e-05 6.1920997596608071e-08
+ 2.799593250490411e-05 6.192099814656376e-08
+ 2.8000932504904111e-05 6.1920998075044547e-08
+ 2.8005932504904119e-05 6.1920998126978201e-08
+ 2.801093250490412e-05 6.19209982401332e-08
+ 2.801593250490412e-05 6.1920998257715725e-08
+ 2.8020932504904121e-05 6.1920998161192721e-08
+ 2.8025932504904119e-05 6.1920997945367932e-08
+ 2.8030932504904119e-05 6.1920997989080589e-08
+ 2.803593250490412e-05 6.1920998274904009e-08
+ 2.8040932504904121e-05 6.1920998104870205e-08
+ 2.8045932504904118e-05 6.1920998145988254e-08
+ 2.8050932504904119e-05 6.1920997966794517e-08
+ 2.805593250490412e-05 6.1920998220678693e-08
+ 2.8060932504904121e-05 6.1920998285029097e-08
+ 2.8065932504904122e-05 6.1920998108902121e-08
+ 2.8070932504904129e-05 6.1920998173465289e-08
+ 2.807593250490413e-05 6.1920997979113116e-08
+ 2.8080932504904131e-05 6.192099799465486e-08
+ 2.8085932504904132e-05 6.1920998074261491e-08
+ 2.8090932504904129e-05 6.1920998160033397e-08
+ 2.809593250490413e-05 6.1920998184099655e-08
+ 2.8100932504904131e-05 6.1920998045411575e-08
+ 2.8105932504904131e-05 6.1920998087119928e-08
+ 2.8110932504904129e-05 6.192099808739929e-08
+ 2.811593250490413e-05 6.1920998220913943e-08
+ 2.812093250490413e-05 6.1920998249578174e-08
+ 2.8125932504904131e-05 6.1920998016290225e-08
+ 2.8130932504904139e-05 6.1920998064239953e-08
+ 2.8135932504904139e-05 6.1920998151974845e-08
+ 2.814093250490414e-05 6.1920998241983557e-08
+ 2.8145932504904141e-05 6.1920997969542795e-08
+ 2.8150932504904139e-05 6.1920998053261294e-08
+ 2.8155932504904139e-05 6.192099816744618e-08
+ 2.816093250490414e-05 6.1920998198149404e-08
+ 2.8165932504904141e-05 6.1920998256936322e-08
+ 2.8170932504904138e-05 6.1920998074382762e-08
+ 2.8175932504904139e-05 6.1920998051211395e-08
+ 2.818093250490414e-05 6.19209984650878e-08
+ 2.8185932504904141e-05 6.1920998228772993e-08
+ 2.8190932504904142e-05 6.192099802412217e-08
+ 2.8195932504904149e-05 6.1920998104184055e-08
+ 2.820093250490415e-05 6.1920998179469587e-08
+ 2.8205932504904151e-05 6.1920998213641716e-08
+ 2.8210932504904151e-05 6.1920998257084077e-08
+ 2.8215932504904149e-05 6.192099804160219e-08
+ 2.822093250490415e-05 6.1920998410032922e-08
+ 2.822593250490415e-05 6.1920997878112894e-08
+ 2.8230932504904151e-05 6.1920998217100085e-08
+ 2.8235932504904149e-05 6.1920998151893265e-08
+ 2.8240932504904149e-05 6.192099803403366e-08
+ 2.824593250490415e-05 6.1920998248191912e-08
+ 2.8250932504904151e-05 6.1920998016017256e-08
+ 2.8255932504904159e-05 6.1920997733417604e-08
+ 2.8260932504904159e-05 6.1920998106501418e-08
+ 2.826593250490416e-05 6.1920997602943878e-08
+ 2.8270932504904161e-05 6.1920997148223544e-08
+ 2.8275932504904158e-05 6.1920993443445468e-08
+ 2.8278033841651852e-05 6.1920908101635642e-08
+ 2.827985005705823e-05 6.1920902876930713e-08
+ 2.828177700258662e-05 6.1921194540541875e-08
+ 2.8283297217818591e-05 6.1921067317001823e-08
+ 2.8284971345618071e-05 6.1920798232997744e-08
+ 2.8286003817562829e-05 6.1921265674027961e-08
+ 2.8286385186352459e-05 6.1921805123669878e-08
+ 2.828694225656795e-05 6.1920923279285319e-08
+ 2.828725100525016e-05 6.1925139578238154e-08
+ 2.828749648501761e-05 6.1918313167736118e-08
+ 2.8287696539475649e-05 6.183072202734367e-08
+ 2.8287905124597721e-05 6.1852852987559919e-08
+ 2.8288149037169529e-05 6.1983708086354778e-08
+ 2.8288310170235939e-05 6.1397448047162121e-08
+ 2.8288378106672461e-05 5.7474626746109458e-08
+ 2.8288432199893551e-05 5.5461685502610372e-08
+ 2.8288475882861381e-05 5.9542006348626572e-08
+ 2.8288540411957609e-05 9.1379613069056148e-08
+ 2.8288606223851091e-05 1.307903558823144e-07
+ 2.8288671114406229e-05 1.7205318260025359e-07
+ 2.8288700514099979e-05 3.2863430131808971e-07
+ 2.828872117135592e-05 6.4603358345191304e-07
+ 2.8288742813970301e-05 7.862525403025699e-07
+ 2.8288770221907369e-05 2.7667704628421872e-07
+ 2.8288793504522009e-05 -7.4223241051603418e-07
+ 2.828881450699748e-05 -2.6075933579740279e-06
+ 2.8288833374942359e-05 -4.1668865930870663e-06
+ 2.828884856705378e-05 -4.9773611831977647e-06
+ 2.8288862922765738e-05 -4.7497384650400203e-06
+ 2.82888729735851e-05 -2.61736217598853e-06
+ 2.8288885535341691e-05 -6.8558965124845455e-07
+ 2.8288901934652379e-05 -4.7686308297542933e-07
+ 2.8288920707380549e-05 -1.5482621544968401e-06
+ 2.8288944951436829e-05 -2.6118877416692702e-06
+ 2.828896985872322e-05 -3.274335642320799e-06
+ 2.828899576865527e-05 -3.3276516020207251e-06
+ 2.82890196908862e-05 -2.0033123402757332e-06
+ 2.828904262476757e-05 -5.354743723907922e-07
+ 2.8289069460859671e-05 -5.4441960458042699e-07
+ 2.828910007689443e-05 -1.874372145833788e-06
+ 2.8289128171566991e-05 -3.0328204607372351e-06
+ 2.828915013978705e-05 -3.7018319958965361e-06
+ 2.82891777687341e-05 -3.6670049818088499e-06
+ 2.828919877839546e-05 -7.4599997965782121e-07
+ 2.828921648360261e-05 2.2585526941881349e-06
+ 2.8289233667289819e-05 -6.9283079011501273e-06
+ 2.8289251478507631e-05 -5.49491051524979e-05
+ 2.828927392717519e-05 -0.00014799105133914619
+ 2.8289295204428441e-05 -0.00018761277027450789
+ 2.8289308140078279e-05 -0.0001343835046996476
+ 2.8289321717026801e-05 -1.514529993782014e-05
+ 2.828933890949062e-05 0.00012707929019887369
+ 2.8289354438658971e-05 0.00018628729619074531
+ 2.828937694156845e-05 0.00018293987780147259
+ 2.828940067163215e-05 0.00014353423717607279
+ 2.8289431999504399e-05 9.3856140663777708e-05
+ 2.828946351018688e-05 6.5926768092575049e-05
+ 2.8289500063672389e-05 5.6946342518530337e-05
+ 2.8289540377326199e-05 6.3679433308400402e-05
+ 2.8289591715328939e-05 8.6239997029335231e-05
+ 2.828965748763244e-05 -0.00023736005060514889
+ 2.8289704940364501e-05 -0.002102017520593258
+ 2.828975256387089e-05 -0.007021768728996053
+ 2.8289765736840011e-05 -0.0083836616392972199
+ 2.828978029887154e-05 -0.0076932813590343497
+ 2.828978988711778e-05 -0.0044018908940027524
+ 2.8289799500527492e-05 0.002986122135223417
+ 2.8289810007255541e-05 0.018004497646622829
+ 2.8289822909145641e-05 0.049111738644727877
+ 2.8289836229198489e-05 0.096876701535077783
+ 2.8289847741818089e-05 0.14985249566500469
+ 2.8289858292526081e-05 0.20581798041795529
+ 2.8289871049205139e-05 0.279275542787703
+ 2.8289884975127569e-05 0.36270723185999448
+ 2.8289901829794141e-05 0.46386507449315478
+ 2.8289923057113549e-05 0.58703105271965306
+ 2.8289951536026231e-05 0.73880142827501172
+ 2.8289987198305009e-05 0.8977680127943114
+ 2.829002796442904e-05 1.029454694903891
+ 2.829008611477308e-05 1.1371382021053209
+ 2.8290129588153019e-05 1.174495845531526
+ 2.8290177498311729e-05 1.192648162864071
+ 2.8290228493736361e-05 1.1995075715951871
+ 2.8290290021875509e-05 1.2014367953866321
+ 2.8290369709054829e-05 1.201238364112627
+ 2.8290485822687122e-05 1.200498077487596
+ 2.8290614940412019e-05 1.2000865836105581
+ 2.8290743262418109e-05 1.1999801543970789
+ 2.8290866650640431e-05 1.19997807940465
+ 2.829098672417223e-05 1.199990572264009
+ 2.829111510391827e-05 1.199998005841689
+ 2.8291234115514011e-05 1.2000000784031311
+ 2.8291358252885969e-05 1.20000030923446
+ 2.829147601566772e-05 1.2000001370941831
+ 2.8291597336109071e-05 1.2000000091535019
+ 2.8291714950459238e-05 1.1999999638262819
+ 2.8291835101261869e-05 1.1999999555423291
+ 2.829195304059171e-05 1.1999999577463689
+ 2.8292072688282069e-05 1.1999999616591179
+ 2.8292148070528121e-05 1.1999999731487769
+ 2.8292196351113452e-05 1.19999999372622
+ 2.8292244258073301e-05 1.1999999916143911
+ 2.8292310948543741e-05 1.1999999434797279
+ 2.8292373122961371e-05 1.199999911972754
+ 2.8292403227413969e-05 1.1999998859233389
+ 2.8292426441308419e-05 1.199999838575798
+ 2.8292447751383489e-05 1.199999770258342
+ 2.8292470083918141e-05 1.199999685453091
+ 2.82924972294224e-05 1.1999996664501451
+ 2.829251667225513e-05 1.199999914339595
+ 2.829254111366495e-05 1.200000203042437
+ 2.8292581645358931e-05 1.2000003258579599
+ 2.8292631554227592e-05 1.2000001849789099
+ 2.829268774580474e-05 1.1999999942521089
+ 2.8292760786658352e-05 1.1999998802842931
+ 2.829283691388551e-05 1.199999872817795
+ 2.829292543731918e-05 1.1999999145519959
+ 2.8293024727057849e-05 1.199999956029137
+ 2.8293135322780801e-05 1.199999972751181
+ 2.8293279093615519e-05 1.1999999701752799
+ 2.829348519933254e-05 1.1999999622047171
+ 2.829387576677139e-05 1.199999958803567
+ 2.8294248100386851e-05 1.1999999597813269
+ 2.8294799810312249e-05 1.199999960500215
+ 2.8295387905020719e-05 1.1999999605475311
+ 2.8295934710245821e-05 1.199999960444855
+ 2.829642289108425e-05 1.1999999604611551
+ 2.8296774328215461e-05 1.1999999606226019
+ 2.8297178980636901e-05 1.199999960448471
+ 2.829764218396672e-05 1.199999960452574
+ 2.829823219115821e-05 1.1999999604761309
+ 2.829890120191171e-05 1.1999999604821501
+ 2.8299909280540851e-05 1.1999999604819589
+ 2.83013506834141e-05 1.1999999604810501
+ 2.8303878928979619e-05 1.1999999604809231
+ 2.8307794726844631e-05 1.199999960480937
+ 2.8312794726844632e-05 1.1999999604808771
+ 2.8317794726844629e-05 1.199999960480858
+ 2.832279472684463e-05 1.199999960480862
+ 2.8327794726844631e-05 1.199999960480866
+ 2.8332794726844631e-05 1.199999960480868
+ 2.8337794726844639e-05 1.199999960480868
+ 2.834279472684464e-05 1.199999960480868
+ 2.8347794726844641e-05 1.199999960480868
+ 2.8352794726844641e-05 1.199999960480868
+ 2.8357794726844639e-05 1.199999960480868
+ 2.836279472684464e-05 1.199999960480868
+ 2.836779472684464e-05 1.199999960480868
+ 2.8372794726844641e-05 1.199999960480868
+ 2.8377794726844639e-05 1.199999960480868
+ 2.8382794726844639e-05 1.199999960480868
+ 2.838779472684464e-05 1.199999960480868
+ 2.8392794726844641e-05 1.199999960480868
+ 2.8397794726844649e-05 1.199999960480868
+ 2.8402794726844649e-05 1.199999960480868
+ 2.840779472684465e-05 1.199999960480868
+ 2.8412794726844651e-05 1.199999960480868
+ 2.8417794726844648e-05 1.199999960480868
+ 2.8422794726844649e-05 1.199999960480868
+ 2.842779472684465e-05 1.199999960480868
+ 2.8432794726844651e-05 1.199999960480868
+ 2.8437794726844652e-05 1.199999960480868
+ 2.8442794726844649e-05 1.199999960480868
+ 2.844779472684465e-05 1.199999960480868
+ 2.8452794726844651e-05 1.199999960480868
+ 2.8457794726844651e-05 1.199999960480868
+ 2.8462794726844659e-05 1.199999960480868
+ 2.846779472684466e-05 1.199999960480868
+ 2.847279472684466e-05 1.199999960480868
+ 2.8477794726844661e-05 1.199999960480868
+ 2.8482794726844659e-05 1.199999960480868
+ 2.848779472684466e-05 1.199999960480868
+ 2.849279472684466e-05 1.199999960480868
+ 2.8497794726844661e-05 1.199999960480868
+ 2.8502794726844659e-05 1.199999960480868
+ 2.8507794726844659e-05 1.199999960480868
+ 2.851279472684466e-05 1.199999960480868
+ 2.8517794726844661e-05 1.199999960480868
+ 2.8522794726844668e-05 1.199999960480868
+ 2.8527794726844669e-05 1.199999960480868
+ 2.853279472684467e-05 1.1999999604808671
+ 2.8537794726844671e-05 1.1999999604808651
+ 2.8542794726844672e-05 1.1999999604808631
+ 2.8547794726844669e-05 1.1999999604808591
+ 2.855279472684467e-05 1.19999996048085
+ 2.8557794726844671e-05 1.199999960480834
+ 2.8562794726844671e-05 1.1999999604808029
+ 2.8567794726844669e-05 1.1999999604807441
+ 2.857279472684467e-05 1.1999999604806311
+ 2.8577794726844671e-05 1.199999960480415
+ 2.8582794726844671e-05 1.1999999604800129
+ 2.8587794726844679e-05 1.1999999604792979
+ 2.859279472684468e-05 1.199999960478046
+ 2.859779472684468e-05 1.199999960475663
+ 2.8602794726844681e-05 1.1999999604685889
+ 2.8606327819656281e-05 1.1999999604195
+ 2.8608136320350402e-05 1.1999999601479461
+ 2.8610103651718009e-05 1.199999960157232
+ 2.8611694486431299e-05 1.1999999603853491
+ 2.861372218229692e-05 1.199999960454152
+ 2.8615242788579591e-05 1.1999999605232949
+ 2.8615801172899192e-05 1.1999999613180381
+ 2.8616307337984101e-05 1.199999962132783
+ 2.8616586974559729e-05 1.1999999647861479
+ 2.8616890747587769e-05 1.1999999672489581
+ 2.8617123022084301e-05 1.1999999605010221
+ 2.861733999574592e-05 1.19999990545901
+ 2.8617552520059189e-05 1.199999856007538
+ 2.8617797237036381e-05 1.1999997982450961
+ 2.8617900671464531e-05 1.199999504328823
+ 2.8617959787367371e-05 1.199999047008085
+ 2.8618008652083969e-05 1.199998651606309
+ 2.8618066995772688e-05 1.1999981997108069
+ 2.8618132912288441e-05 1.1999979361340429
+ 2.8618206871085691e-05 1.199998508786442
+ 2.8618247199495749e-05 1.19999925281675
+ 2.8618269045199842e-05 1.199999731995258
+ 2.8618288507361921e-05 1.199999946331509
+ 2.8618306549512079e-05 1.1999999406114921
+ 2.86183297417652e-05 1.2000017887819741
+ 2.8618356778171981e-05 1.2000065514418781
+ 2.8618381232214101e-05 1.20001028459499
+ 2.861840326591101e-05 1.200010495411433
+ 2.8618420892528241e-05 1.200008670474729
+ 2.8618440212288001e-05 1.200005176984164
+ 2.8618454509709531e-05 1.200002355329036
+ 2.861847060149554e-05 1.2000000250320491
+ 2.861849784793032e-05 1.199998078848153
+ 2.8618527209718369e-05 1.199997337951759
+ 2.8618553808113791e-05 1.199997068027304
+ 2.861857792076324e-05 1.199997397332234
+ 2.8618603682421708e-05 1.1999989668106179
+ 2.8618629578794581e-05 1.2000015864769611
+ 2.8618658856847439e-05 1.2000045308439891
+ 2.8618685247129089e-05 1.200006587646824
+ 2.86187038147611e-05 1.200007905769547
+ 2.8618719552572761e-05 1.2000092198369849
+ 2.861873514568324e-05 1.2000111149587771
+ 2.8618748861926201e-05 1.200012948963906
+ 2.8618764524353042e-05 1.200013176180273
+ 2.8618775467374579e-05 1.200012157114478
+ 2.8618789862062799e-05 1.2000100420039681
+ 2.861881432309535e-05 1.2000057426556701
+ 2.8618837004653551e-05 1.199994600001304
+ 2.86188607174428e-05 1.1999501000444299
+ 2.861888236795931e-05 1.1998766918327011
+ 2.8618911211937742e-05 1.1997400660948641
+ 2.8618952851095341e-05 1.199448378905333
+ 2.8618972041713339e-05 1.2001713619407499
+ 2.861898870377134e-05 1.202643400904837
+ 2.861901333427538e-05 1.210364565767146
+ 2.8619036337157941e-05 1.214159678547911
+ 2.8619052126368599e-05 1.197444497155876
+ 2.8619069502356851e-05 1.1451300182480471
+ 2.8619087555463518e-05 1.060013271197533
+ 2.8619104881226091e-05 0.96160632328347373
+ 2.8619126978565529e-05 0.82820970463930099
+ 2.8619147772425239e-05 0.70233098218538903
+ 2.861916200328015e-05 0.61790325133816648
+ 2.861917328988646e-05 0.55258225266756722
+ 2.8619188272816681e-05 0.46884081403948519
+ 2.86191990617608e-05 0.41107643163264229
+ 2.861921298158254e-05 0.34061662740452392
+ 2.8619232615055661e-05 0.25152451887442367
+ 2.861925602489284e-05 0.1650536966340764
+ 2.861927800945062e-05 0.10496883547792039
+ 2.8619300060393109e-05 0.063485843234577219
+ 2.8619316866136419e-05 0.042269317283898829
+ 2.861933448200387e-05 0.027160504236485739
+ 2.8619356501860169e-05 0.0151967786188571
+ 2.8619377040916821e-05 0.0086411623537895384
+ 2.8619403358647981e-05 0.0039766056960145188
+ 2.8619430505342781e-05 0.0016335342906196139
+ 2.8619466460749741e-05 0.00032396655957808588
+ 2.8619507952029229e-05 -0.00012232462448930769
+ 2.8619566759867219e-05 -0.00018550545946969919
+ 2.8619645594277641e-05 -9.5846889112835077e-05
+ 2.8619735405719121e-05 -2.4278045325741909e-05
+ 2.8619837949160331e-05 1.5805101141350579e-06
+ 2.8619969808859031e-05 4.3502755271264556e-06
+ 2.862015506793469e-05 1.4995500675998781e-06
+ 2.86203010409862e-05 2.6884367949418488e-07
+ 2.862042635599967e-05 1.9691858250896221e-08
+ 2.862054262148497e-05 2.1835714636238481e-08
+ 2.8620659353077861e-05 4.8739522163222982e-08
+ 2.8620785738748588e-05 6.1318277376733778e-08
+ 2.862090514382161e-05 6.4642246807250665e-08
+ 2.8621029745707189e-05 6.6688787302159778e-08
+ 2.862114845066796e-05 6.9796171644782639e-08
+ 2.8621270182786421e-05 7.4745239709067247e-08
+ 2.8621388292350749e-05 8.7799466809755517e-08
+ 2.8621508582826429e-05 1.4286979493120719e-07
+ 2.862157702442711e-05 3.6345514124183087e-07
+ 2.8621626900602569e-05 6.3517004778979443e-07
+ 2.8621683807121742e-05 6.043536724889149e-07
+ 2.8621749162298561e-05 1.38322110305292e-07
+ 2.8621786093537489e-05 -2.6747293750360372e-07
+ 2.8621812847404849e-05 -6.7923087312933448e-07
+ 2.862183656152758e-05 -1.1673058581720039e-06
+ 2.862185905096981e-05 -1.64228877033337e-06
+ 2.862188038406464e-05 -1.723956718438769e-06
+ 2.8621906414552599e-05 -1.685498117571901e-06
+ 2.8621924998405511e-05 -1.6733699742288e-06
+ 2.8621948558808099e-05 -4.4540278022464979e-07
+ 2.862198761051329e-05 1.177142451902178e-06
+ 2.8622029631891699e-05 1.38268031792745e-06
+ 2.8622088406312349e-05 6.8210545342951218e-07
+ 2.862215730839353e-05 1.5085754596503801e-07
+ 2.862223621546446e-05 2.9570867856914491e-08
+ 2.86223210489805e-05 -1.6597615688656851e-08
+ 2.8622421112872239e-05 -3.2967003461360472e-09
+ 2.862253707517802e-05 4.9450658574359258e-08
+ 2.862266466167393e-05 7.3978795009361608e-08
+ 2.8622836545644e-05 6.9713412262380985e-08
+ 2.8623086785177731e-05 6.1591720421199696e-08
+ 2.8623400415438769e-05 6.0796201117162297e-08
+ 2.862375951765228e-05 6.1764382974163929e-08
+ 2.8624197574095819e-05 6.2029432449335042e-08
+ 2.8624729739574499e-05 6.2058830490947806e-08
+ 2.8625328651595211e-05 6.1548555869818839e-08
+ 2.862572355050004e-05 6.031033860187919e-08
+ 2.8626060755379189e-05 6.3090088683912407e-08
+ 2.8626486540681631e-05 6.2186780246729219e-08
+ 2.8626959711057529e-05 6.1730205865307749e-08
+ 2.862751743167894e-05 6.1913048232051487e-08
+ 2.8628108158154759e-05 6.1920995902347981e-08
+ 2.862893616537116e-05 6.1919009427366364e-08
+ 2.8630088130196759e-05 6.1921838979605248e-08
+ 2.863211950751698e-05 6.1921391345714226e-08
+ 2.863517419440973e-05 6.1921010571925539e-08
+ 2.8640174194409731e-05 6.1920982089413913e-08
+ 2.8645174194409739e-05 6.1920995190005925e-08
+ 2.8650174194409739e-05 6.1920997690628901e-08
+ 2.865517419440974e-05 6.1920998179140423e-08
+ 2.8660174194409741e-05 6.1920997857632709e-08
+ 2.8665174194409738e-05 6.1920998162140114e-08
+ 2.8670174194409739e-05 6.1920997949059407e-08
+ 2.867517419440974e-05 6.1920998238088688e-08
+ 2.8680174194409741e-05 6.1920998318886472e-08
+ 2.8685174194409742e-05 6.1920998197968787e-08
+ 2.8690174194409739e-05 6.1920997991292126e-08
+ 2.869517419440974e-05 6.1920998258116769e-08
+ 2.8700174194409741e-05 6.1920998044596028e-08
+ 2.8705174194409741e-05 6.1920998136992738e-08
+ 2.8710174194409749e-05 6.1920997947607447e-08
+ 2.871517419440975e-05 6.1920997952665729e-08
+ 2.8720174194409751e-05 6.1920998063855189e-08
+ 2.8725174194409751e-05 6.1920998116169505e-08
+ 2.8730174194409749e-05 6.1920998151566218e-08
+ 2.873517419440975e-05 6.1920998196932932e-08
+ 2.874017419440975e-05 6.1920998049301958e-08
+ 2.8745174194409751e-05 6.1920998113294953e-08
+ 2.8750174194409749e-05 6.1920998169577037e-08
+ 2.8755174194409749e-05 6.1920998170766297e-08
+ 2.876017419440975e-05 6.1920998286757467e-08
+ 2.8765174194409751e-05 6.1920998047439955e-08
+ 2.8770174194409759e-05 6.1920998337743107e-08
+ 2.8775174194409759e-05 6.1920998175704711e-08
+ 2.878017419440976e-05 6.192099820642882e-08
+ 2.8785174194409761e-05 6.1920998286584024e-08
+ 2.8790174194409758e-05 6.1920998125932288e-08
+ 2.8795174194409759e-05 6.1920998166504372e-08
+ 2.880017419440976e-05 6.1920998182137582e-08
+ 2.8805174194409761e-05 6.1920998011068929e-08
+ 2.8810174194409762e-05 6.1920998077115079e-08
+ 2.8815174194409759e-05 6.1920998157473095e-08
+ 2.882017419440976e-05 6.1920998203897872e-08
+ 2.8825174194409761e-05 6.1920997969190111e-08
+ 2.8830174194409761e-05 6.1920998085444139e-08
+ 2.8835174194409769e-05 6.1920998093279644e-08
+ 2.884017419440977e-05 6.1920998127144154e-08
+ 2.8845174194409771e-05 6.1920998006947293e-08
+ 2.8850174194409771e-05 6.1920998021088071e-08
+ 2.8855174194409769e-05 6.1920998057564976e-08
+ 2.886017419440977e-05 6.1920998092193192e-08
+ 2.886517419440977e-05 6.1920998209956686e-08
+ 2.8870174194409771e-05 6.1920998225642267e-08
+ 2.8875174194409769e-05 6.1920998044961523e-08
+ 2.8880174194409769e-05 6.1920998073055687e-08
+ 2.888517419440977e-05 6.1920998071520665e-08
+ 2.8890174194409771e-05 6.1920998301406412e-08
+ 2.8895174194409779e-05 6.1920998245261945e-08
+ 2.8900174194409779e-05 6.1920997986661556e-08
+ 2.890517419440978e-05 6.1920998092348331e-08
+ 2.8910174194409781e-05 6.1920998124802412e-08
+ 2.8915174194409778e-05 6.1920998109616898e-08
+ 2.8920174194409779e-05 6.1920997873497054e-08
+ 2.892517419440978e-05 6.1920997890228734e-08
+ 2.8930174194409781e-05 6.1920997224124406e-08
+ 2.8935174194409782e-05 6.1920993202499032e-08
+ 2.8937261842048268e-05 6.1920903900492143e-08
+ 2.893908837491067e-05 6.1920912856270014e-08
+ 2.8940980378281531e-05 6.1921195045915507e-08
+ 2.8942517458021031e-05 6.1921056667265114e-08
+ 2.8944194689654182e-05 6.1920806767965241e-08
+ 2.8945217793723501e-05 6.1921272317454975e-08
+ 2.8945591408265938e-05 6.1921871256916116e-08
+ 2.8946135644075081e-05 6.1920901915899691e-08
+ 2.8946441702559748e-05 6.1925267510155248e-08
+ 2.8946686488309521e-05 6.1916694759349009e-08
+ 2.8946887179524879e-05 6.1821432332306696e-08
+ 2.894709528491474e-05 6.1866353933562911e-08
+ 2.894733671755409e-05 6.1979079623501413e-08
+ 2.894748598597211e-05 6.1289256122972696e-08
+ 2.8947551238759329e-05 5.7428086098456771e-08
+ 2.8947605868734901e-05 5.5708803060307078e-08
+ 2.8947649286113209e-05 5.9387009407932438e-08
+ 2.8947713848579229e-05 9.0829976406904535e-08
+ 2.8947779805714551e-05 1.3041600988972799e-07
+ 2.894784531692309e-05 1.718029547925897e-07
+ 2.894787487190606e-05 3.3048106327279598e-07
+ 2.894789547858169e-05 6.49882916711476e-07
+ 2.8947917223225682e-05 7.8384344891507635e-07
+ 2.8947944721115291e-05 2.671429523695949e-07
+ 2.8947967864245349e-05 -7.6304309839771733e-07
+ 2.8947988853986392e-05 -2.6368128401560259e-06
+ 2.89480078229361e-05 -4.1871906480455258e-06
+ 2.8948022937358889e-05 -4.9998727975124063e-06
+ 2.8948037475621938e-05 -4.6778787645650813e-06
+ 2.8948047604626351e-05 -2.525009469485944e-06
+ 2.8948060203635728e-05 -6.5120150325319642e-07
+ 2.8948076986234111e-05 -5.1316085784005743e-07
+ 2.8948095824787881e-05 -1.6004829728284139e-06
+ 2.8948120255602051e-05 -2.6480026980400309e-06
+ 2.8948145245507209e-05 -3.3024267326238672e-06
+ 2.8948168513440409e-05 -3.344707532670428e-06
+ 2.8948192782868179e-05 -2.0453507278690872e-06
+ 2.8948215613857089e-05 -5.5507800538996056e-07
+ 2.8948242188354571e-05 -5.0870115445931976e-07
+ 2.8948269903032139e-05 -1.7033580537294339e-06
+ 2.8948299512702469e-05 -2.9708335446415399e-06
+ 2.8948322932280941e-05 -3.693203232203306e-06
+ 2.894835134084692e-05 -3.7283404342237551e-06
+ 2.894837385966405e-05 -6.1671635037707003e-07
+ 2.894839206325598e-05 2.2123947304056118e-06
+ 2.894840941125888e-05 -9.7353015883129143e-06
+ 2.8948427322286959e-05 -6.2042880585437481e-05
+ 2.8948449457163431e-05 -0.00015383364461293031
+ 2.8948472084261959e-05 -0.00018290350307532231
+ 2.8948485449220649e-05 -0.0001125131904856751
+ 2.8948499661827089e-05 1.7849338783137701e-05
+ 2.8948517165135509e-05 0.00014760012665170641
+ 2.8948533967068371e-05 0.00019151717153640511
+ 2.8948556948567578e-05 0.00017465041293026761
+ 2.8948581929938161e-05 0.0001312489810664389
+ 2.894861344224909e-05 8.5336914645765306e-05
+ 2.894864622159303e-05 6.2095678323944019e-05
+ 2.8948683372643441e-05 5.7358073169233641e-05
+ 2.8948726013718099e-05 6.7933987096730866e-05
+ 2.8948780059343879e-05 8.4664038491722953e-05
+ 2.894884967040075e-05 -0.00066103073565464696
+ 2.8948894640946199e-05 -0.00336255895959146
+ 2.894893362512939e-05 -0.0076025287390576587
+ 2.894894276630975e-05 -0.00834316556529607
+ 2.8948958917508391e-05 -0.006185863011192505
+ 2.894897019709332e-05 0.0005164115640705865
+ 2.89489811192696e-05 0.013915549702442159
+ 2.8948993172840648e-05 0.039561622076068691
+ 2.8949006097601021e-05 0.081426371474099035
+ 2.8949024293111739e-05 0.16303876630379399
+ 2.8949037299550659e-05 0.23351488172897061
+ 2.8949052991860469e-05 0.32542073813530281
+ 2.894906745631012e-05 0.41238321312491311
+ 2.8949087032270249e-05 0.52824908315235641
+ 2.8949110170232969e-05 0.65790306150837374
+ 2.8949143399796971e-05 0.82222693762883059
+ 2.8949180503180199e-05 0.9660634945956712
+ 2.8949227231042989e-05 1.085506034794903
+ 2.8949263145061609e-05 1.1387859342048221
+ 2.8949302288316269e-05 1.171280584843456
+ 2.8949354116026639e-05 1.19165718633982
+ 2.8949402648115279e-05 1.1986453997053521
+ 2.8949471032440341e-05 1.201300501117301
+ 2.89495478288179e-05 1.201243267168308
+ 2.8949671219354559e-05 1.200518489308289
+ 2.8949803569310282e-05 1.2001005860590981
+ 2.8949932671941099e-05 1.199986365994532
+ 2.8950055462439782e-05 1.199979793099883
+ 2.8950174913076311e-05 1.19999065633534
+ 2.8950302546392099e-05 1.199997791173947
+ 2.895042129030902e-05 1.1999999557714549
+ 2.8950545206502621e-05 1.2000002726730059
+ 2.895066297775914e-05 1.2000001330861989
+ 2.8950784261756271e-05 1.2000000121994649
+ 2.895090191863905e-05 1.199999966052739
+ 2.89510220491482e-05 1.199999956376496
+ 2.895114000789241e-05 1.1999999579775431
+ 2.8951259639525962e-05 1.1999999620979549
+ 2.8951327808482108e-05 1.199999975882458
+ 2.895137484881229e-05 1.199999995216996
+ 2.8951423694746671e-05 1.19999998821623
+ 2.8951488869048349e-05 1.199999939343382
+ 2.8951540493495969e-05 1.1999999119171201
+ 2.89515685492901e-05 1.199999893007847
+ 2.8951593526345769e-05 1.199999856877026
+ 2.8951616203876618e-05 1.199999794784042
+ 2.8951638926299828e-05 1.1999997109784359
+ 2.8951667331078781e-05 1.1999996547301961
+ 2.8951688985830341e-05 1.199999883948538
+ 2.8951713776115261e-05 1.200000183119369
+ 2.895174843033408e-05 1.2000003223188129
+ 2.8951801845838589e-05 1.2000001977818879
+ 2.8951852949786079e-05 1.200000017234788
+ 2.8951926154925641e-05 1.1999998866587229
+ 2.8952008809126869e-05 1.199999870975222
+ 2.8952106819223639e-05 1.19999991506147
+ 2.8952201847235791e-05 1.1999999550701059
+ 2.895231735210543e-05 1.199999972929453
+ 2.8952455612030681e-05 1.1999999703049029
+ 2.8952672629080841e-05 1.1999999620112181
+ 2.8953073064656039e-05 1.1999999587463079
+ 2.8953447179461919e-05 1.199999959788637
+ 2.895400844218552e-05 1.1999999605131511
+ 2.8954601201243239e-05 1.199999960548684
+ 2.895514515453469e-05 1.1999999604386471
+ 2.8955668687772979e-05 1.199999960480608
+ 2.895604078745733e-05 1.199999960608402
+ 2.8956460401434179e-05 1.1999999604389071
+ 2.8956939589329259e-05 1.1999999604560061
+ 2.8957539453718381e-05 1.1999999604786089
+ 2.8958262020590781e-05 1.1999999604826901
+ 2.8959350396802189e-05 1.199999960481722
+ 2.8960979493585779e-05 1.199999960480949
+ 2.8963768759629099e-05 1.199999960480937
+ 2.8968277006194801e-05 1.1999999604809231
+ 2.8973277006194799e-05 1.1999999604808691
+ 2.89782770061948e-05 1.199999960480858
+ 2.89832770061948e-05 1.1999999604808631
+ 2.8988277006194801e-05 1.1999999604808671
+ 2.8993277006194799e-05 1.199999960480868
+ 2.8998277006194799e-05 1.199999960480868
+ 2.90032770061948e-05 1.199999960480868
+ 2.9008277006194801e-05 1.199999960480868
+ 2.9013277006194809e-05 1.199999960480868
+ 2.9018277006194809e-05 1.199999960480868
+ 2.902327700619481e-05 1.199999960480868
+ 2.9028277006194811e-05 1.199999960480868
+ 2.9033277006194808e-05 1.199999960480868
+ 2.9038277006194809e-05 1.199999960480868
+ 2.904327700619481e-05 1.199999960480868
+ 2.9048277006194811e-05 1.199999960480868
+ 2.9053277006194812e-05 1.199999960480868
+ 2.9058277006194809e-05 1.199999960480868
+ 2.906327700619481e-05 1.199999960480868
+ 2.9068277006194811e-05 1.199999960480868
+ 2.9073277006194811e-05 1.199999960480868
+ 2.9078277006194819e-05 1.199999960480868
+ 2.908327700619482e-05 1.199999960480868
+ 2.9088277006194821e-05 1.199999960480868
+ 2.9093277006194821e-05 1.199999960480868
+ 2.9098277006194819e-05 1.199999960480868
+ 2.910327700619482e-05 1.199999960480868
+ 2.910827700619482e-05 1.199999960480868
+ 2.9113277006194821e-05 1.199999960480868
+ 2.9118277006194819e-05 1.199999960480868
+ 2.9123277006194819e-05 1.199999960480868
+ 2.912827700619482e-05 1.199999960480868
+ 2.9133277006194821e-05 1.199999960480868
+ 2.9138277006194829e-05 1.199999960480868
+ 2.9143277006194829e-05 1.199999960480868
+ 2.914827700619483e-05 1.199999960480868
+ 2.9153277006194831e-05 1.199999960480868
+ 2.9158277006194828e-05 1.199999960480868
+ 2.9163277006194829e-05 1.199999960480868
+ 2.916827700619483e-05 1.199999960480868
+ 2.9173277006194831e-05 1.199999960480868
+ 2.9178277006194832e-05 1.199999960480868
+ 2.9183277006194829e-05 1.199999960480868
+ 2.918827700619483e-05 1.1999999604808671
+ 2.9193277006194831e-05 1.1999999604808671
+ 2.9198277006194831e-05 1.1999999604808651
+ 2.9203277006194839e-05 1.199999960480862
+ 2.920827700619484e-05 1.1999999604808571
+ 2.9213277006194841e-05 1.1999999604808469
+ 2.9218277006194841e-05 1.199999960480828
+ 2.9223277006194839e-05 1.199999960480792
+ 2.922827700619484e-05 1.1999999604807221
+ 2.923327700619484e-05 1.1999999604805871
+ 2.9238277006194841e-05 1.1999999604803331
+ 2.9243277006194839e-05 1.199999960479863
+ 2.9248277006194839e-05 1.1999999604790359
+ 2.925327700619484e-05 1.1999999604775771
+ 2.9258277006194841e-05 1.199999960474615
+ 2.9263277006194849e-05 1.1999999604634191
+ 2.9265815525867769e-05 1.199999960381668
+ 2.9267507632631361e-05 1.199999960111968
+ 2.926960609089097e-05 1.1999999601932589
+ 2.9271109438789961e-05 1.1999999604265179
+ 2.927296019685787e-05 1.1999999604254621
+ 2.927419226727675e-05 1.199999960523515
+ 2.9274737499816409e-05 1.199999961050221
+ 2.9275383682207479e-05 1.1999999615497881
+ 2.9275711222207921e-05 1.199999964087201
+ 2.9276013299968151e-05 1.199999966901182
+ 2.927625092239361e-05 1.199999965464728
+ 2.927645779578231e-05 1.1999999236185599
+ 2.9276673033426759e-05 1.199999868341624
+ 2.9276916062183851e-05 1.1999998261374789
+ 2.9277044928123489e-05 1.199999651400341
+ 2.927711061013696e-05 1.1999992973087239
+ 2.9277168630470899e-05 1.1999988440363469
+ 2.9277213947644209e-05 1.199998525851959
+ 2.927728165251532e-05 1.199998011762492
+ 2.9277351564829672e-05 1.1999980837033959
+ 2.9277432400894029e-05 1.1999991330730819
+ 2.927745748254143e-05 1.1999996862485089
+ 2.9277477477150921e-05 1.1999998073932401
+ 2.927749601505484e-05 1.2000000784528559
+ 2.9277520557728478e-05 1.200002616606938
+ 2.9277547992495491e-05 1.2000078628228259
+ 2.9277572400074541e-05 1.2000107319832769
+ 2.927759318872302e-05 1.200010171021515
+ 2.927761036367964e-05 1.200007991568508
+ 2.9277625082600279e-05 1.2000050343710751
+ 2.9277641061399681e-05 1.2000019503710291
+ 2.9277658225165529e-05 1.1999997061025141
+ 2.9277684974760608e-05 1.1999980307089979
+ 2.92777146564183e-05 1.1999973289413839
+ 2.9277742404592922e-05 1.1999970821702131
+ 2.927776649056071e-05 1.1999975641904079
+ 2.9277791852009532e-05 1.1999993230045169
+ 2.9277823030498291e-05 1.2000025059463659
+ 2.9277852413318971e-05 1.2000052665632011
+ 2.9277876533063289e-05 1.200007055180353
+ 2.92778930359945e-05 1.200008291941437
+ 2.9277908621828122e-05 1.2000097314486839
+ 2.927792349170393e-05 1.2000117659563261
+ 2.9277938222037388e-05 1.200013277948256
+ 2.9277951553355331e-05 1.2000129922841689
+ 2.9277965780774101e-05 1.200011364410785
+ 2.9277981622971541e-05 1.2000088132328479
+ 2.9278007986389239e-05 1.200003062700264
+ 2.9278035805414799e-05 1.1999723781874969
+ 2.927806103742467e-05 1.1999000340231549
+ 2.9278087595915449e-05 1.199785122459798
+ 2.9278123700823469e-05 1.199509779216142
+ 2.9278147718183239e-05 1.199668392657846
+ 2.9278163899078181e-05 1.201013784088655
+ 2.9278181834888241e-05 1.204937754689386
+ 2.9278203002181102e-05 1.21264821329642
+ 2.9278219585780491e-05 1.2156872491844279
+ 2.9278233632496609e-05 1.20388718958119
+ 2.927824981950124e-05 1.1601459156949701
+ 2.927826684664417e-05 1.0841277606884061
+ 2.927828449471084e-05 0.9861856192607843
+ 2.9278305761294081e-05 0.85837904998371906
+ 2.927832624494791e-05 0.73381988097145501
+ 2.927834094380326e-05 0.645880870688744
+ 2.9278352177080219e-05 0.58018868184378281
+ 2.9278364697012302e-05 0.50900119354033779
+ 2.9278377771076851e-05 0.43746551407821738
+ 2.9278390504872081e-05 0.37123975162706602
+ 2.9278410162284609e-05 0.2780529851973067
+ 2.927843321747918e-05 0.18692165903579161
+ 2.9278455519298371e-05 0.1199955121171635
+ 2.9278482404134949e-05 0.065475581336113642
+ 2.927849866433294e-05 0.04419646929461548
+ 2.9278515337838629e-05 0.029151552146969309
+ 2.9278534747241059e-05 0.01763892288649338
+ 2.9278555977298701e-05 0.0099378575205180935
+ 2.9278580198224239e-05 0.0049622093470339862
+ 2.927860783848544e-05 0.0020708952242573311
+ 2.9278640975980131e-05 0.00055477080760009032
+ 2.927868167137889e-05 -6.5305581667518065e-05
+ 2.927873487227061e-05 -0.0001948085126550704
+ 2.9278808572002302e-05 -0.0001203494861395408
+ 2.9278900230225492e-05 -3.50471664211052e-05
+ 2.9278995302127821e-05 -1.9528634146774248e-06
+ 2.9279122932983141e-05 4.6893526864232971e-06
+ 2.9279286734376259e-05 2.1576046298380892e-06
+ 2.9279425083974278e-05 4.75789568104815e-07
+ 2.9279549838884989e-05 3.5690162309781313e-08
+ 2.9279668524015099e-05 6.6184246913968797e-09
+ 2.9279787294907919e-05 4.013717780866539e-08
+ 2.9279917278910671e-05 5.9312117455144812e-08
+ 2.9280037415286101e-05 6.3963829036441241e-08
+ 2.928016335846889e-05 6.5736924226372074e-08
+ 2.9280281817432428e-05 6.8337962755446392e-08
+ 2.9280403971768771e-05 7.2146829709939096e-08
+ 2.928052176407024e-05 8.0418399095028035e-08
+ 2.9280642283285281e-05 1.07976293588406e-07
+ 2.9280738671318591e-05 2.3721488006249119e-07
+ 2.9280792613358449e-05 5.4189602108558878e-07
+ 2.9280843794544769e-05 6.8373385564687377e-07
+ 2.928091233490612e-05 3.3113175686919402e-07
+ 2.9280960829831911e-05 -1.3327465387612061e-07
+ 2.9280989284475879e-05 -5.3098069007930274e-07
+ 2.9281014539255701e-05 -1.013878619910172e-06
+ 2.92810374518716e-05 -1.5228450224527871e-06
+ 2.9281058849507098e-05 -1.768478295251514e-06
+ 2.9281087295592809e-05 -1.637649526121817e-06
+ 2.9281107416861409e-05 -1.7371503298436829e-06
+ 2.9281130398096509e-05 -6.5597775472158814e-07
+ 2.9281173059015709e-05 1.153673144550164e-06
+ 2.9281211992444639e-05 1.4148899178402619e-06
+ 2.9281273838370639e-05 7.0082620177851285e-07
+ 2.9281337925894671e-05 1.731946535634636e-07
+ 2.9281416602692061e-05 3.0325182816135608e-08
+ 2.9281501786003282e-05 -1.7053604633100319e-08
+ 2.928160183577384e-05 -4.3992222563190527e-09
+ 2.928171781684875e-05 4.826855956387863e-08
+ 2.9281844047677332e-05 7.3626419361906578e-08
+ 2.9282013885554319e-05 7.0008438572308638e-08
+ 2.928225861318233e-05 6.17559159094663e-08
+ 2.92825730745499e-05 6.0760794411359795e-08
+ 2.9282926791532379e-05 6.1735823051660815e-08
+ 2.9283364238884379e-05 6.2030080913290875e-08
+ 2.9283887928585581e-05 6.2057637043024554e-08
+ 2.9284505593130899e-05 6.1590969146397408e-08
+ 2.9284901781338621e-05 6.0289674078986009e-08
+ 2.9285244432774299e-05 6.3044051346347092e-08
+ 2.9285677296566469e-05 6.2224381583013738e-08
+ 2.9286141802237789e-05 6.1726713094979206e-08
+ 2.9286691254397561e-05 6.1910234468024367e-08
+ 2.928728337238556e-05 6.1922307406131445e-08
+ 2.9288104806077111e-05 6.1919159984876609e-08
+ 2.9289260325120801e-05 6.1921753365794614e-08
+ 2.929126681910564e-05 6.1921386795557511e-08
+ 2.9294313358743661e-05 6.1921012088685679e-08
+ 2.9299313358743669e-05 6.1920982271255449e-08
+ 2.930431335874367e-05 6.1920995188066762e-08
+ 2.9309313358743671e-05 6.1920997739186652e-08
+ 2.9314313358743671e-05 6.1920998001078017e-08
+ 2.9319313358743669e-05 6.1920998049475044e-08
+ 2.932431335874367e-05 6.1920998103899598e-08
+ 2.932931335874367e-05 6.1920998149532558e-08
+ 2.9334313358743671e-05 6.1920998305807119e-08
+ 2.9339313358743669e-05 6.1920998081658392e-08
+ 2.9344313358743669e-05 6.1920998170473343e-08
+ 2.934931335874367e-05 6.1920997912222765e-08
+ 2.9354313358743671e-05 6.1920998193702361e-08
+ 2.9359313358743679e-05 6.1920998062587895e-08
+ 2.9364313358743679e-05 6.19209980990432e-08
+ 2.936931335874368e-05 6.1920998160000032e-08
+ 2.9374313358743681e-05 6.1920998210487338e-08
+ 2.9379313358743678e-05 6.1920998025255712e-08
+ 2.9384313358743679e-05 6.1920998286060862e-08
+ 2.938931335874368e-05 6.1920998130422409e-08
+ 2.9394313358743681e-05 6.1920998211567292e-08
+ 2.9399313358743682e-05 6.1920998263538203e-08
+ 2.9404313358743679e-05 6.1920998053228075e-08
+ 2.940931335874368e-05 6.1920998107774972e-08
+ 2.9414313358743681e-05 6.1920998190063826e-08
+ 2.9419313358743681e-05 6.1920998204681444e-08
+ 2.9424313358743689e-05 6.1920998268507547e-08
+ 2.942931335874369e-05 6.1920998070160581e-08
+ 2.9434313358743691e-05 6.1920998140792382e-08
+ 2.9439313358743691e-05 6.1920998171515075e-08
+ 2.9444313358743689e-05 6.1920998257635072e-08
+ 2.944931335874369e-05 6.1920998331279001e-08
+ 2.945431335874369e-05 6.192099813061593e-08
+ 2.9459313358743691e-05 6.1920998192870059e-08
+ 2.9464313358743689e-05 6.192099817055405e-08
+ 2.9469313358743689e-05 6.1920998047840734e-08
+ 2.947431335874369e-05 6.1920998067374068e-08
+ 2.9479313358743691e-05 6.1920998150337438e-08
+ 2.9484313358743699e-05 6.1920998237421358e-08
+ 2.9489313358743699e-05 6.192099829350067e-08
+ 2.94943133587437e-05 6.1920998319552545e-08
+ 2.9499313358743701e-05 6.1920998160209646e-08
+ 2.9504313358743698e-05 6.1920998187900345e-08
+ 2.9509313358743699e-05 6.1920998223723949e-08
+ 2.95143133587437e-05 6.1920998013111523e-08
+ 2.9519313358743701e-05 6.1920998366061112e-08
+ 2.9524313358743702e-05 6.192099817916406e-08
+ 2.9529313358743699e-05 6.1920998168613259e-08
+ 2.95343133587437e-05 6.1920998038240674e-08
+ 2.9539313358743701e-05 6.1920998091817281e-08
+ 2.9544313358743701e-05 6.1920998151543943e-08
+ 2.9549313358743709e-05 6.1920998009895219e-08
+ 2.955431335874371e-05 6.1920998072067398e-08
+ 2.9559313358743711e-05 6.1920998145098618e-08
+ 2.9564313358743711e-05 6.192099829151807e-08
+ 2.9569313358743709e-05 6.1920998073258631e-08
+ 2.957431335874371e-05 6.1920997926616594e-08
+ 2.957931335874371e-05 6.1920998129478418e-08
+ 2.9584313358743711e-05 6.1920997726221754e-08
+ 2.9589313358743709e-05 6.1920997355908651e-08
+ 2.9594313358743709e-05 6.1920993155085648e-08
+ 2.9596410295330669e-05 6.1920906575484473e-08
+ 2.9598230896796549e-05 6.1920906176851419e-08
+ 2.9600147062965671e-05 6.192119526498565e-08
+ 2.9601673179082651e-05 6.1921063327314038e-08
+ 2.9603348499613351e-05 6.1920801077978682e-08
+ 2.960437745186971e-05 6.1921268027449117e-08
+ 2.9604755968893899e-05 6.1921827971296331e-08
+ 2.9605308578018439e-05 6.1920916298552209e-08
+ 2.960561640396137e-05 6.1925187799974692e-08
+ 2.9605861652564361e-05 6.1917773332590249e-08
+ 2.9606062256658739e-05 6.1827437035627118e-08
+ 2.9606270819781738e-05 6.1857548037958629e-08
+ 2.960651371153739e-05 6.1982178367030919e-08
+ 2.9606670203062041e-05 6.1358531435132703e-08
+ 2.960673709680375e-05 5.7459106250645413e-08
+ 2.9606791416268488e-05 5.5562389986188992e-08
+ 2.9606834985620479e-05 5.9459399248856137e-08
+ 2.9606899540906062e-05 9.1116932426187089e-08
+ 2.9606965408540339e-05 1.3061065058170941e-07
+ 2.9607030599633151e-05 1.7191458997548571e-07
+ 2.960706007862952e-05 3.2942182889736519e-07
+ 2.9607080712357421e-05 6.4771860531970359e-07
+ 2.960710239807662e-05 7.8523448816356881e-07
+ 2.9607129846560329e-05 2.7252565525912838e-07
+ 2.9607153067369899e-05 -7.5128872361278183e-07
+ 2.9607174065120471e-05 -2.6204237095918959e-06
+ 2.9607192977846559e-05 -4.1758679995925781e-06
+ 2.960720813561717e-05 -4.9872552370460098e-06
+ 2.9607222570460441e-05 -4.7184691583256892e-06
+ 2.9607232654596529e-05 -2.5768655070687009e-06
+ 2.9607245231582179e-05 -6.7032688012465567e-07
+ 2.9607261796804639e-05 -4.923904697660876e-07
+ 2.9607280575989979e-05 -1.5702624081267049e-06
+ 2.9607304913022239e-05 -2.627446439647262e-06
+ 2.960732985174741e-05 -3.286286601983538e-06
+ 2.9607355800129728e-05 -3.3128550030067208e-06
+ 2.960737943056704e-05 -1.9736673951008768e-06
+ 2.960740242054334e-05 -5.2000683422919665e-07
+ 2.9607429428934059e-05 -5.5945439009049768e-07
+ 2.9607459849846749e-05 -1.89312768110266e-06
+ 2.960748813187783e-05 -3.054346240432502e-06
+ 2.9607510054362261e-05 -3.715738410821827e-06
+ 2.960753743534917e-05 -3.642657124146575e-06
+ 2.9607558028581991e-05 -7.5840673465532259e-07
+ 2.960757557513702e-05 2.2649841046603298e-06
+ 2.960759274560749e-05 -6.3816469332643741e-06
+ 2.9607610544619049e-05 -5.3504394263742132e-05
+ 2.9607633071612751e-05 -0.00014677646139092909
+ 2.9607654060064819e-05 -0.00018821646761425949
+ 2.9607667020957331e-05 -0.00013786062604824109
+ 2.9607680498835311e-05 -2.0950407160088428e-05
+ 2.9607695847462831e-05 0.0001121312304614642
+ 2.9607711961475509e-05 0.00018333095142653261
+ 2.9607735131155971e-05 0.000185687016192592
+ 2.9607758152225319e-05 0.00014765618032155811
+ 2.960778974602905e-05 9.6104904523359628e-05
+ 2.9607820426882541e-05 6.7163750224685591e-05
+ 2.9607857279921191e-05 5.6848199468373752e-05
+ 2.9607896656168449e-05 6.2680258799522139e-05
+ 2.9607947800388371e-05 8.5148308773806279e-05
+ 2.9608011922310109e-05 -0.00016533809193524561
+ 2.9608060374437161e-05 -0.0018400810555838671
+ 2.9608106552577151e-05 -0.0063616942136756963
+ 2.9608121623061061e-05 -0.0081467349331814879
+ 2.960813603427715e-05 -0.008311184397504584
+ 2.9608145129132821e-05 -0.0064002946817965541
+ 2.9608155248039418e-05 -0.00061695750133894942
+ 2.9608165835985859e-05 0.011824745344668521
+ 2.9608178934090799e-05 0.03954180297077358
+ 2.9608191329690228e-05 0.079847455005499363
+ 2.960820833314886e-05 0.1554836591443377
+ 2.960822039381113e-05 0.22011858510984769
+ 2.9608234089751559e-05 0.29975428634005052
+ 2.9608248780633811e-05 0.38799688478598537
+ 2.9608266339318149e-05 0.49281712995870941
+ 2.960828899922e-05 0.62229622031466603
+ 2.9608319185417831e-05 0.77797781520121512
+ 2.9608356182760459e-05 0.9328381061430906
+ 2.9608398795998969e-05 1.056668945203596
+ 2.960844382531569e-05 1.1337068710962219
+ 2.9608484948956319e-05 1.170441832796618
+ 2.9608537715176159e-05 1.192043936213923
+ 2.960858546462824e-05 1.1989361722346581
+ 2.96086521806777e-05 1.201430546593095
+ 2.9608726825648589e-05 1.201293386268016
+ 2.9608847639107161e-05 1.2005252250673111
+ 2.9608979286657549e-05 1.2000950679891229
+ 2.9609108568730799e-05 1.199982090216746
+ 2.96092317223194e-05 1.1999782027486661
+ 2.960935138335935e-05 1.1999903643772309
+ 2.9609479409627191e-05 1.1999978711372401
+ 2.9609598200080329e-05 1.200000032668789
+ 2.9609722267834971e-05 1.200000304009196
+ 2.9609839999482272e-05 1.200000140224752
+ 2.9609961341146371e-05 1.2000000116428451
+ 2.9610078958929509e-05 1.199999964793891
+ 2.961019912454515e-05 1.1999999557333001
+ 2.9610317060162229e-05 1.199999957744136
+ 2.961043671284865e-05 1.199999961768845
+ 2.961050940759766e-05 1.1999999740280449
+ 2.9610557210930201e-05 1.1999999941928789
+ 2.961060537423953e-05 1.1999999905968179
+ 2.9610671520031611e-05 1.199999942252526
+ 2.9610730361894921e-05 1.199999912016835
+ 2.9610759852234501e-05 1.1999998885493679
+ 2.9610783594805039e-05 1.1999998450282869
+ 2.9610805314195631e-05 1.199999778790948
+ 2.9610827722808002e-05 1.1999996944958371
+ 2.961085529985078e-05 1.1999996607547569
+ 2.9610874847526781e-05 1.199999896641323
+ 2.961089959983174e-05 1.200000193032694
+ 2.9610937334157539e-05 1.200000325433429
+ 2.9610988745572649e-05 1.2000001929722759
+ 2.9611042492984021e-05 1.2000000065134351
+ 2.961111525108828e-05 1.1999998839182291
+ 2.9611194621666718e-05 1.1999998717238129
+ 2.96112863187625e-05 1.199999913922829
+ 2.961138423608822e-05 1.199999955257538
+ 2.9611495997342609e-05 1.1999999727172941
+ 2.9611637383301302e-05 1.1999999703326061
+ 2.9611845563467252e-05 1.1999999622399991
+ 2.9612236532856961e-05 1.199999958781774
+ 2.961260947762278e-05 1.199999959768874
+ 2.9613161410577018e-05 1.1999999605004299
+ 2.9613750161764419e-05 1.1999999605488481
+ 2.9614296644470799e-05 1.199999960444744
+ 2.9614787042628221e-05 1.199999960462464
+ 2.961513965719158e-05 1.1999999606217611
+ 2.9615545100218571e-05 1.199999960447701
+ 2.9616009122018939e-05 1.199999960452784
+ 2.9616599603901959e-05 1.199999960476307
+ 2.9617271777978599e-05 1.1999999604821929
+ 2.961828450060029e-05 1.199999960481944
+ 2.961973670456707e-05 1.199999960481041
+ 2.9622279780294e-05 1.1999999604809239
+ 2.962622805396095e-05 1.199999960480937
+ 2.9631228053960951e-05 1.1999999604808771
+ 2.9636228053960951e-05 1.199999960480858
+ 2.9641228053960949e-05 1.199999960480862
+ 2.964622805396095e-05 1.199999960480866
+ 2.965122805396095e-05 1.199999960480868
+ 2.9656228053960951e-05 1.199999960480868
+ 2.9661228053960949e-05 1.199999960480868
+ 2.9666228053960949e-05 1.199999960480868
+ 2.967122805396095e-05 1.199999960480868
+ 2.9676228053960951e-05 1.199999960480868
+ 2.9681228053960959e-05 1.199999960480868
+ 2.9686228053960959e-05 1.199999960480868
+ 2.969122805396096e-05 1.199999960480868
+ 2.9696228053960961e-05 1.199999960480868
+ 2.9701228053960958e-05 1.199999960480868
+ 2.9706228053960959e-05 1.199999960480868
+ 2.971122805396096e-05 1.199999960480868
+ 2.9716228053960961e-05 1.199999960480868
+ 2.9721228053960962e-05 1.199999960480868
+ 2.9726228053960959e-05 1.199999960480868
+ 2.973122805396096e-05 1.199999960480868
+ 2.9736228053960961e-05 1.199999960480868
+ 2.9741228053960961e-05 1.199999960480868
+ 2.9746228053960969e-05 1.199999960480868
+ 2.975122805396097e-05 1.199999960480868
+ 2.9756228053960971e-05 1.199999960480868
+ 2.9761228053960971e-05 1.199999960480868
+ 2.9766228053960969e-05 1.199999960480868
+ 2.977122805396097e-05 1.199999960480868
+ 2.977622805396097e-05 1.199999960480868
+ 2.9781228053960971e-05 1.199999960480868
+ 2.9786228053960969e-05 1.199999960480868
+ 2.9791228053960969e-05 1.199999960480868
+ 2.979622805396097e-05 1.199999960480868
+ 2.9801228053960971e-05 1.199999960480868
+ 2.9806228053960979e-05 1.199999960480868
+ 2.9811228053960979e-05 1.199999960480868
+ 2.981622805396098e-05 1.199999960480868
+ 2.9821228053960981e-05 1.199999960480868
+ 2.9826228053960978e-05 1.199999960480868
+ 2.9831228053960979e-05 1.199999960480868
+ 2.983622805396098e-05 1.199999960480868
+ 2.9841228053960981e-05 1.199999960480868
+ 2.9846228053960982e-05 1.199999960480868
+ 2.9851228053960979e-05 1.1999999604808671
+ 2.985622805396098e-05 1.199999960480866
+ 2.9861228053960981e-05 1.1999999604808631
+ 2.9866228053960981e-05 1.1999999604808591
+ 2.9871228053960989e-05 1.19999996048085
+ 2.987622805396099e-05 1.199999960480834
+ 2.9881228053960991e-05 1.1999999604808029
+ 2.9886228053960991e-05 1.199999960480743
+ 2.9891228053960989e-05 1.1999999604806291
+ 2.989622805396099e-05 1.199999960480411
+ 2.990122805396099e-05 1.1999999604800049
+ 2.9906228053960991e-05 1.1999999604792839
+ 2.9911228053960989e-05 1.1999999604780209
+ 2.9916228053960989e-05 1.1999999604756111
+ 2.992122805396099e-05 1.1999999604683711
+ 2.9924676655456428e-05 1.1999999604186189
+ 2.9926476365496058e-05 1.199999960150026
+ 2.992844514646339e-05 1.199999960155405
+ 2.9930049888548048e-05 1.1999999603824141
+ 2.993208913498184e-05 1.1999999604566629
+ 2.9933629879397399e-05 1.199999960525451
+ 2.9934185244790439e-05 1.1999999613527621
+ 2.9934683287838801e-05 1.199999962202297
+ 2.993495993367495e-05 1.1999999648981541
+ 2.993526171230403e-05 1.199999967331443
+ 2.9935491950193331e-05 1.199999959528151
+ 2.9935709638177879e-05 1.199999903225571
+ 2.9935921316619781e-05 1.1999998546914949
+ 2.9936166880820099e-05 1.19999979370891
+ 2.9936268521060889e-05 1.199999478367983
+ 2.993632671414984e-05 1.199999004520774
+ 2.9936374824869929e-05 1.199998618169529
+ 2.993643745155191e-05 1.199998131080158
+ 2.9936505155993918e-05 1.1999979567326049
+ 2.993658042518941e-05 1.1999986671655121
+ 2.9936611435029688e-05 1.1999992908365871
+ 2.9936636003354419e-05 1.1999998496361439
+ 2.9936653050222859e-05 1.1999999139235431
+ 2.9936672050461132e-05 1.2000000781688001
+ 2.9936695364225479e-05 1.200002304432044
+ 2.993672231683569e-05 1.2000073664786
+ 2.9936746682995591e-05 1.2000105645043739
+ 2.9936767547078381e-05 1.200010315070565
+ 2.993678449465351e-05 1.2000083757653319
+ 2.9936802329937541e-05 1.2000050138975349
+ 2.9936819401997381e-05 1.200001787089952
+ 2.993683489603684e-05 1.199999744131804
+ 2.993686588411574e-05 1.1999978427667961
+ 2.9936894147279241e-05 1.199997252743576
+ 2.9936922466795949e-05 1.199997069839595
+ 2.9936946765098201e-05 1.199997680137695
+ 2.993697214498492e-05 1.199999579473664
+ 2.9937000879985031e-05 1.200002580798013
+ 2.9937033045714719e-05 1.2000055230687121
+ 2.993705773563131e-05 1.2000072959931121
+ 2.9937074343354991e-05 1.200008580475652
+ 2.9937090048100088e-05 1.2000101707959809
+ 2.9937104155035181e-05 1.200012216457526
+ 2.993712211816413e-05 1.20001335508264
+ 2.9937133645813869e-05 1.200012618513004
+ 2.9937147304592601e-05 1.200010794274555
+ 2.993716933575846e-05 1.2000070953652049
+ 2.9937195336673741e-05 1.199997462456365
+ 2.993722071617459e-05 1.199955494947786
+ 2.9937241850445081e-05 1.19988677479825
+ 2.9937269999651351e-05 1.199758031098024
+ 2.9937309588556141e-05 1.199442868900201
+ 2.9937329993945301e-05 1.19988072296736
+ 2.993734624131138e-05 1.2017696366084589
+ 2.9937367253594352e-05 1.2074252992678911
+ 2.9937389249964761e-05 1.215124377274895
+ 2.993740371765497e-05 1.212739358345126
+ 2.9937417422946409e-05 1.191621926415001
+ 2.993743479984121e-05 1.131432024628179
+ 2.993745519180213e-05 1.0282443077637009
+ 2.9937476616744679e-05 0.90234976779985476
+ 2.9937496446343308e-05 0.78144239140749638
+ 2.993751392507333e-05 0.6759168224560349
+ 2.9937526390445729e-05 0.60235617845859801
+ 2.9937537698960858e-05 0.53731371304370446
+ 2.9937551237014241e-05 0.46207539461327463
+ 2.9937563410919699e-05 0.39741864303566671
+ 2.993757790703092e-05 0.32521253684752521
+ 2.993759814789528e-05 0.2359040535667862
+ 2.993762161269986e-05 0.15300889536907661
+ 2.993764378201331e-05 0.096029767740825445
+ 2.9937661352061411e-05 0.064261270023099254
+ 2.9937676977263112e-05 0.044192399687467653
+ 2.9937694329766532e-05 0.028703786912301459
+ 2.9937716033611199e-05 0.016279566065907629
+ 2.9937736790711299e-05 0.0092355723448774071
+ 2.993776268513648e-05 0.0043309859578550929
+ 2.9937789720432469e-05 0.0018058037986487809
+ 2.993782473723173e-05 0.00040333436400638828
+ 2.9937865462632629e-05 -0.0001014307463455804
+ 2.993792215699669e-05 -0.00019062164645820021
+ 2.9937998264753119e-05 -0.0001058886454584312
+ 2.9938089018480511e-05 -2.8241782112333179e-05
+ 2.993818808016017e-05 3.5889243978248698e-07
+ 2.9938318400455229e-05 4.537285903893762e-06
+ 2.9938493874051911e-05 1.7608829219099501e-06
+ 2.993863644894834e-05 3.4434191913167582e-07
+ 2.993876152069232e-05 2.358538846518935e-08
+ 2.9938878881757129e-05 1.5465727699349471e-08
+ 2.9938996538129489e-05 4.5437251380530037e-08
+ 2.9939124481205142e-05 6.0579454138110941e-08
+ 2.99392442125991e-05 6.4339042723274933e-08
+ 2.9939369382512281e-05 6.624867493506063e-08
+ 2.993948797872728e-05 6.9128139248431253e-08
+ 2.9939609884693548e-05 7.3502877811066589e-08
+ 2.993972785632471e-05 8.4068693336346667e-08
+ 2.9939848240196899e-05 1.2428768364655401e-07
+ 2.9939926987142299e-05 2.9762403941829841e-07
+ 2.9939978080590009e-05 5.8674118194172045e-07
+ 2.9940031141493601e-05 6.5802460139539802e-07
+ 2.9940097237224658e-05 2.5680595782427818e-07
+ 2.9940132900969589e-05 -1.206771648199509e-07
+ 2.9940164090517119e-05 -5.1448717812894105e-07
+ 2.994018897729402e-05 -9.489369501326763e-07
+ 2.9940212248097429e-05 -1.4543087567606911e-06
+ 2.99402337843444e-05 -1.750721427194611e-06
+ 2.9940259410724541e-05 -1.61900753497644e-06
+ 2.9940280451230532e-05 -1.79927784961191e-06
+ 2.9940303289651499e-05 -8.9682268345472217e-07
+ 2.9940338780874981e-05 8.3576726180253718e-07
+ 2.994037928977783e-05 1.4382953945275081e-06
+ 2.9940434405828391e-05 8.9685742628760705e-07
+ 2.994049801820448e-05 2.55092219430628e-07
+ 2.9940579836635999e-05 3.7749964736821367e-08
+ 2.9940676755922909e-05 -1.8109990155607819e-08
+ 2.994078085046595e-05 -1.138948343794309e-08
+ 2.994089621433328e-05 4.234865594312909e-08
+ 2.9941022233210709e-05 7.2976425184790069e-08
+ 2.9941189303633509e-05 7.1036267311945563e-08
+ 2.9941435486996962e-05 6.1994725582689372e-08
+ 2.9941747769560519e-05 6.0685398278533039e-08
+ 2.9942103404159349e-05 6.1713941129398448e-08
+ 2.994253891231951e-05 6.2032267242311468e-08
+ 2.9943064383174049e-05 6.2058856562849734e-08
+ 2.994368232692537e-05 6.1593241901542351e-08
+ 2.9944078588257199e-05 6.0288287538355757e-08
+ 2.9944421356805241e-05 6.3042095956930367e-08
+ 2.9944854511428901e-05 6.2226042299906756e-08
+ 2.9945318507905179e-05 6.1726611359915111e-08
+ 2.9945867451684829e-05 6.1910085217559321e-08
+ 2.9946459604077931e-05 6.1922367909097418e-08
+ 2.9947280525446479e-05 6.1919166757924069e-08
+ 2.9948436000302362e-05 6.1921748845928048e-08
+ 2.9950440519094069e-05 6.1921386717215327e-08
+ 2.9953485968069371e-05 6.1921012169410884e-08
+ 2.9958485968069371e-05 6.1920982304804267e-08
+ 2.9963485968069379e-05 6.1920994996195112e-08
+ 2.996848596806938e-05 6.1920997650130747e-08
+ 2.9973485968069381e-05 6.1920997958376055e-08
+ 2.9978485968069381e-05 6.1920997978488257e-08
+ 2.9983485968069379e-05 6.1920998284334596e-08
+ 2.998848596806938e-05 6.1920998335136694e-08
+ 2.999348596806938e-05 6.1920998170376212e-08
+ 2.9998485968069381e-05 6.1920998168166502e-08
+ 3.0003485968069379e-05 6.1920998259265848e-08
+ 3.0008485968069379e-05 6.1920998126458864e-08
+ 3.001348596806938e-05 6.192099815098379e-08
+ 3.0018485968069381e-05 6.1920998228472098e-08
+ 3.0023485968069389e-05 6.1920997987153629e-08
+ 3.0028485968069389e-05 6.1920998298886701e-08
+ 3.003348596806939e-05 6.1920998104236214e-08
+ 3.0038485968069391e-05 6.1920998116870822e-08
+ 3.0043485968069388e-05 6.1920998280531682e-08
+ 3.0048485968069389e-05 6.1920998012136693e-08
+ 3.005348596806939e-05 6.1920998078752235e-08
+ 3.0058485968069391e-05 6.1920998145360391e-08
+ 3.0063485968069392e-05 6.1920998179537429e-08
+ 3.0068485968069389e-05 6.1920998280272345e-08
+ 3.007348596806939e-05 6.1920998298158412e-08
+ 3.0078485968069391e-05 6.1920998116752555e-08
+ 3.0083485968069391e-05 6.1920998211803773e-08
+ 3.0088485968069399e-05 6.192099824829476e-08
+ 3.00934859680694e-05 6.1920998008086182e-08
+ 3.0098485968069401e-05 6.1920998341085022e-08
+ 3.0103485968069401e-05 6.1920998175994132e-08
+ 3.0108485968069399e-05 6.1920998212884336e-08
+ 3.01134859680694e-05 6.1920998223206994e-08
+ 3.01184859680694e-05 6.1920998328612211e-08
+ 3.0123485968069401e-05 6.1920998047280117e-08
+ 3.0128485968069399e-05 6.1920998221096294e-08
+ 3.0133485968069399e-05 6.1920997996901257e-08
+ 3.01384859680694e-05 6.1920998296053839e-08
+ 3.0143485968069401e-05 6.1920998069368857e-08
+ 3.0148485968069409e-05 6.1920998184972562e-08
+ 3.0153485968069409e-05 6.1920997958187815e-08
+ 3.015848596806941e-05 6.1920998035092636e-08
+ 3.0163485968069411e-05 6.1920998305861144e-08
+ 3.0168485968069408e-05 6.192099814479366e-08
+ 3.0173485968069409e-05 6.1920997932663695e-08
+ 3.017848596806941e-05 6.1920998258075317e-08
+ 3.0183485968069411e-05 6.1920998286174669e-08
+ 3.0188485968069412e-05 6.1920998284080777e-08
+ 3.0193485968069409e-05 6.1920998345937475e-08
+ 3.019848596806941e-05 6.1920998161532394e-08
+ 3.0203485968069411e-05 6.1920998112948252e-08
+ 3.0208485968069411e-05 6.1920998228690738e-08
+ 3.0213485968069419e-05 6.192099811078129e-08
+ 3.021848596806942e-05 6.1920998132971608e-08
+ 3.0223485968069421e-05 6.1920998162754782e-08
+ 3.0228485968069421e-05 6.1920998143275936e-08
+ 3.0233485968069419e-05 6.1920997952483631e-08
+ 3.023848596806942e-05 6.1920997879448572e-08
+ 3.024348596806942e-05 6.1920997743050314e-08
+ 3.0248485968069421e-05 6.1920997124935617e-08
+ 3.0253485968069419e-05 6.1920993410609918e-08
+ 3.0255584045488049e-05 6.1920906943690754e-08
+ 3.025740349367844e-05 6.1920905507263007e-08
+ 3.025932248368057e-05 6.1921194904689955e-08
+ 3.0260847030549241e-05 6.1921064146474333e-08
+ 3.0262522015239299e-05 6.1920799621940282e-08
+ 3.0263551951418999e-05 6.1921267956589623e-08
+ 3.0263931224083601e-05 6.1921821746443817e-08
+ 3.0264484974645421e-05 6.1920919145285328e-08
+ 3.0264793032867229e-05 6.1925172113460721e-08
+ 3.0265038340557911e-05 6.1917921841845734e-08
+ 3.0265238790364021e-05 6.1828292770728054e-08
+ 3.026544735998481e-05 6.1856305163270222e-08
+ 3.0265690509212952e-05 6.1982613900242438e-08
+ 3.0265848222030479e-05 6.1369174984697355e-08
+ 3.0265915392043601e-05 5.746384682074235e-08
+ 3.0265969655101309e-05 5.5536684990467192e-08
+ 3.0266013252544141e-05 5.9476999600990523e-08
+ 3.0266077803401831e-05 9.1177144817466074e-08
+ 3.026614365617686e-05 1.3065176223803601e-07
+ 3.0266208778984591e-05 1.7194348004973911e-07
+ 3.0266238240573168e-05 3.292270398947498e-07
+ 3.026625887979232e-05 6.4730901937348195e-07
+ 3.026628055479002e-05 7.8548737732555064e-07
+ 3.026630799362234e-05 2.7353738894635481e-07
+ 3.0266331229349309e-05 -7.4908212351856893e-07
+ 3.0266352228376851e-05 -2.6173145683496639e-06
+ 3.0266371130314439e-05 -4.173700830609747e-06
+ 3.0266386296376581e-05 -4.9848578527259406e-06
+ 3.0266400711888772e-05 -4.7260890404537721e-06
+ 3.0266410787800698e-05 -2.5866888540265259e-06
+ 3.0266423360928432e-05 -6.7400255354064384e-07
+ 3.0266439885600779e-05 -4.8856724227160317e-07
+ 3.0266458662883581e-05 -1.564903828802509e-06
+ 3.026648297703552e-05 -2.6236493244003501e-06
+ 3.0266507906871269e-05 -3.2833542556791971e-06
+ 3.0266533845157849e-05 -3.316595954316729e-06
+ 3.0266557545104701e-05 -1.9811618067781191e-06
+ 3.0266580519835901e-05 -5.2387759613049836e-07
+ 3.0266607484445449e-05 -5.5553247789275365e-07
+ 3.0266637954229982e-05 -1.8882847701225309e-06
+ 3.0266666188659679e-05 -3.0488189855479991e-06
+ 3.0266688123194251e-05 -3.7121832456759381e-06
+ 3.0266715567527871e-05 -3.6490390728619229e-06
+ 3.0266736269861131e-05 -7.5507882922339811e-07
+ 3.026675385760685e-05 2.2637032873624769e-06
+ 3.026677103030336e-05 -6.5204034114323443e-06
+ 3.0266788831540749e-05 -5.3871749126408041e-05
+ 3.026681133802246e-05 -0.00014708612754182169
+ 3.0266832400479489e-05 -0.00018807525509932611
+ 3.0266845354635401e-05 -0.0001369862332363276
+ 3.026685885657403e-05 -1.948272396783174e-05
+ 3.0266874249432919e-05 0.00011344394861922259
+ 3.0266890384295419e-05 0.0001837445375900341
+ 3.0266913692919011e-05 0.000185280215845812
+ 3.0266936694848311e-05 0.00014707066919770551
+ 3.0266968379253011e-05 9.553311938571275e-05
+ 3.0266999073849619e-05 6.6900676805876981e-05
+ 3.0267036006538171e-05 5.6832668345836303e-05
+ 3.026707545776301e-05 6.2866363608282092e-05
+ 3.0267126790191298e-05 8.5443807435558493e-05
+ 3.026719111689451e-05 -0.00017890364911017141
+ 3.0267239277703791e-05 -0.001885553939715884
+ 3.026728568256541e-05 -0.0064822697844909962
+ 3.0267300375175799e-05 -0.0081972795548975793
+ 3.0267314853481439e-05 -0.0082337726215567595
+ 3.0267324044109999e-05 -0.0061068404314625051
+ 3.0267334045410568e-05 -7.6594544793564745e-05
+ 3.026734458877552e-05 0.01272874393579638
+ 3.0267357652772659e-05 0.040971535431658782
+ 3.0267370160479281e-05 0.082291408896562002
+ 3.0267385908869259e-05 0.1525330307596586
+ 3.0267397521434092e-05 0.21443938327073331
+ 3.0267410882360291e-05 0.291833016947455
+ 3.026742537348637e-05 0.37880155329501508
+ 3.0267442577604119e-05 0.48173574236098737
+ 3.0267464751137101e-05 0.60920303714158874
+ 3.026749420282899e-05 0.76307995592687872
+ 3.026753080408608e-05 0.92008934100559792
+ 3.026757255896506e-05 1.046527251450599
+ 3.026762303719812e-05 1.135459644998601
+ 3.0267665558629551e-05 1.1725904387524699
+ 3.0267718510144479e-05 1.193129893235171
+ 3.0267766644662629e-05 1.1994579116731561
+ 3.0267833174206039e-05 1.2015392312714679
+ 3.026790889674358e-05 1.2012689335913651
+ 3.0268031927990602e-05 1.200473723789262
+ 3.0268164417734841e-05 1.20007196395656
+ 3.0268293697427329e-05 1.1999770153637559
+ 3.0268416575395011e-05 1.199978442559368
+ 3.026853603776421e-05 1.199991166691101
+ 3.0268663764667669e-05 1.19999827494836
+ 3.0268782493881332e-05 1.2000001533069851
+ 3.026890645721878e-05 1.2000003125562599
+ 3.0269024209557151e-05 1.2000001292132041
+ 3.0269145518312519e-05 1.200000004257276
+ 3.0269263161004799e-05 1.199999962163925
+ 3.0269383306630449e-05 1.199999955325652
+ 3.026950125605198e-05 1.1999999579088581
+ 3.0269620896160279e-05 1.1999999621159301
+ 3.0269690359179749e-05 1.1999999753672921
+ 3.026973760863875e-05 1.199999994923447
+ 3.0269786214944281e-05 1.1999999890467949
+ 3.026985167431745e-05 1.199999940344616
+ 3.026990563373887e-05 1.199999911980234
+ 3.0269934172325339e-05 1.19999989172712
+ 3.0269958734938791e-05 1.1999998533296661
+ 3.0269981091071259e-05 1.199999789958238
+ 3.0270003695252461e-05 1.1999997060810801
+ 3.027003184954762e-05 1.1999996559707291
+ 3.027005286762803e-05 1.1999998875535669
+ 3.02700775876173e-05 1.200000185497738
+ 3.0270113077239839e-05 1.2000003233595999
+ 3.0270165873054729e-05 1.2000001969244489
+ 3.027021770519294e-05 1.2000000146320731
+ 3.0270290648849101e-05 1.19999988614321
+ 3.0270372549747521e-05 1.199999871143427
+ 3.0270471762613891e-05 1.199999915645626
+ 3.027056604040779e-05 1.199999955191726
+ 3.0270682599124861e-05 1.1999999730116531
+ 3.0270820222220028e-05 1.1999999702639501
+ 3.0271039249875962e-05 1.199999961939453
+ 3.0271439780909859e-05 1.19999995874897
+ 3.0271815130949581e-05 1.19999995979744
+ 3.027237678255584e-05 1.1999999605146341
+ 3.0272971460816441e-05 1.1999999605481331
+ 3.027351495410816e-05 1.1999999604376019
+ 3.0274044844640139e-05 1.199999960483711
+ 3.027442101232436e-05 1.199999960605703
+ 3.027484376265302e-05 1.199999960437679
+ 3.0275326382145402e-05 1.1999999604566369
+ 3.0275928468876649e-05 1.1999999604789919
+ 3.0276661375169481e-05 1.199999960482756
+ 3.0277765623149089e-05 1.1999999604816809
+ 3.0279432137233379e-05 1.1999999604809359
+ 3.0282273885893382e-05 1.199999960480939
+ 3.0286907459657901e-05 1.1999999604809199
+ 3.0291907459657899e-05 1.199999960480868
+ 3.0296907459657899e-05 1.199999960480858
+ 3.03019074596579e-05 1.1999999604808631
+ 3.0306907459657901e-05 1.1999999604808671
+ 3.0311907459657909e-05 1.199999960480868
+ 3.0316907459657909e-05 1.199999960480868
+ 3.032190745965791e-05 1.199999960480868
+ 3.0326907459657911e-05 1.199999960480868
+ 3.0331907459657908e-05 1.199999960480868
+ 3.0336907459657909e-05 1.199999960480868
+ 3.034190745965791e-05 1.199999960480868
+ 3.0346907459657911e-05 1.199999960480868
+ 3.0351907459657912e-05 1.199999960480868
+ 3.0356907459657909e-05 1.199999960480868
+ 3.036190745965791e-05 1.199999960480868
+ 3.0366907459657911e-05 1.199999960480868
+ 3.0371907459657911e-05 1.199999960480868
+ 3.0376907459657919e-05 1.199999960480868
+ 3.038190745965792e-05 1.199999960480868
+ 3.0386907459657921e-05 1.199999960480868
+ 3.0391907459657921e-05 1.199999960480868
+ 3.0396907459657919e-05 1.199999960480868
+ 3.040190745965792e-05 1.199999960480868
+ 3.040690745965792e-05 1.199999960480868
+ 3.0411907459657921e-05 1.199999960480868
+ 3.0416907459657919e-05 1.199999960480868
+ 3.0421907459657919e-05 1.199999960480868
+ 3.042690745965792e-05 1.199999960480868
+ 3.0431907459657921e-05 1.199999960480868
+ 3.0436907459657929e-05 1.199999960480868
+ 3.0441907459657929e-05 1.199999960480868
+ 3.044690745965793e-05 1.199999960480868
+ 3.0451907459657931e-05 1.199999960480868
+ 3.0456907459657928e-05 1.199999960480868
+ 3.0461907459657929e-05 1.199999960480868
+ 3.046690745965793e-05 1.199999960480868
+ 3.0471907459657931e-05 1.199999960480868
+ 3.0476907459657932e-05 1.199999960480868
+ 3.0481907459657929e-05 1.199999960480868
+ 3.048690745965793e-05 1.199999960480868
+ 3.0491907459657931e-05 1.199999960480868
+ 3.0496907459657931e-05 1.199999960480868
+ 3.0501907459657939e-05 1.199999960480868
+ 3.050690745965794e-05 1.199999960480868
+ 3.0511907459657941e-05 1.1999999604808671
+ 3.0516907459657941e-05 1.1999999604808651
+ 3.0521907459657942e-05 1.199999960480862
+ 3.0526907459657933e-05 1.1999999604808571
+ 3.053190745965793e-05 1.199999960480846
+ 3.0536907459657928e-05 1.1999999604808269
+ 3.0541907459657932e-05 1.1999999604807889
+ 3.0546907459657922e-05 1.199999960480717
+ 3.055190745965792e-05 1.199999960480578
+ 3.0556907459657917e-05 1.199999960480314
+ 3.0561907459657908e-05 1.199999960479829
+ 3.0566907459657912e-05 1.1999999604789779
+ 3.0571907459657909e-05 1.1999999604774709
+ 3.0576907459657907e-05 1.199999960474361
+ 3.0581907459657898e-05 1.199999960461865
+ 3.0584329138816371e-05 1.199999960366694
+ 3.0586029542245943e-05 1.199999960095524
+ 3.0588168289221099e-05 1.199999960214609
+ 3.05896227136013e-05 1.199999960456309
+ 3.0591399457390138e-05 1.1999999604006399
+ 3.059259507420021e-05 1.199999960548557
+ 3.0593120100932553e-05 1.199999961079139
+ 3.0593769106675208e-05 1.1999999615908969
+ 3.059409865634023e-05 1.199999964270928
+ 3.0594391615857593e-05 1.199999967214971
+ 3.0594623066059432e-05 1.1999999645351069
+ 3.0594830841209693e-05 1.1999999199220781
+ 3.0595046247565911e-05 1.199999866096924
+ 3.0595288267626201e-05 1.199999822297787
+ 3.0595409386288569e-05 1.199999634899904
+ 3.0595472827524551e-05 1.1999992828621171
+ 3.0595530758353969e-05 1.199998833772655
+ 3.0595576641199438e-05 1.1999985144144421
+ 3.0595643526731382e-05 1.199998009007363
+ 3.0595713954516893e-05 1.19999809567038
+ 3.059579473262485e-05 1.199999159602168
+ 3.0595819575765538e-05 1.1999997021921549
+ 3.0595839393852881e-05 1.199999790175249
+ 3.0595858379445642e-05 1.2000001585014619
+ 3.0595883130391483e-05 1.2000028585116249
+ 3.0595909314280869e-05 1.200007976181485
+ 3.0595934129186798e-05 1.2000107830727369
+ 3.0595955127563548e-05 1.2000101001142729
+ 3.0595972804329978e-05 1.200007758884069
+ 3.0595986951241952e-05 1.2000048644767629
+ 3.0596002673368332e-05 1.2000018470701099
+ 3.0596020793958897e-05 1.1999995508225261
+ 3.0596047297554162e-05 1.199997979064918
+ 3.0596077421963863e-05 1.199997297572243
+ 3.0596105977044289e-05 1.1999970867625309
+ 3.0596130574062708e-05 1.199997701657576
+ 3.0596156188047111e-05 1.1999996320352819
+ 3.0596184795844991e-05 1.2000026243529971
+ 3.0596217309458083e-05 1.200005578877049
+ 3.0596241897151577e-05 1.2000073400294891
+ 3.0596258478288513e-05 1.2000086355156629
+ 3.0596274188809098e-05 1.200010261263865
+ 3.0596288172195738e-05 1.200012301928878
+ 3.059630591327332e-05 1.200013344458368
+ 3.0596317090679617e-05 1.2000126026523039
+ 3.0596330787140907e-05 1.2000107669888169
+ 3.0596353461641259e-05 1.200006954422036
+ 3.05963791693912e-05 1.199997097006235
+ 3.0596404341811792e-05 1.199954773890727
+ 3.0596425481332489e-05 1.199885658369334
+ 3.0596453687352778e-05 1.199756150466915
+ 3.0596493517284883e-05 1.1994409368344161
+ 3.059651376108923e-05 1.199906049213463
+ 3.0596530044785593e-05 1.201852018250346
+ 3.0596551453922887e-05 1.207719032712804
+ 3.0596573669596733e-05 1.215252276662792
+ 3.0596588196588763e-05 1.2117206502965669
+ 3.0596602028290497e-05 1.1883886247519759
+ 3.0596619202948447e-05 1.126813314780015
+ 3.0596639639513349e-05 1.0221171170461121
+ 3.0596660597884367e-05 0.89849407500358791
+ 3.0596680752334809e-05 0.77562361684250192
+ 3.0596697980952871e-05 0.67172442762493245
+ 3.0596710304760732e-05 0.5990900458970414
+ 3.059672171830881e-05 0.5335431120171289
+ 3.0596735088859991e-05 0.45936706455456938
+ 3.0596748050044071e-05 0.39079777683524503
+ 3.0596762757317441e-05 0.31812793054788868
+ 3.059678317382623e-05 0.22923064247598879
+ 3.0596806803662138e-05 0.14750981692083021
+ 3.0596829047499891e-05 0.092027621436436127
+ 3.0596845736473113e-05 0.062728086719730305
+ 3.0596861412445541e-05 0.043054403108588331
+ 3.0596879008955707e-05 0.027765029747156691
+ 3.0596900529849993e-05 0.015807409879975389
+ 3.0596921646710268e-05 0.0088645981738434999
+ 3.0596947503740787e-05 0.0041495712497629303
+ 3.0596975026685668e-05 0.001688674913875554
+ 3.0597010227060483e-05 0.00035812563106979721
+ 3.0597051779939662e-05 -0.00011663316618823829
+ 3.0597109215392818e-05 -0.00018806639070650811
+ 3.0597187404226298e-05 -9.9681857946699385e-05
+ 3.0597277179827707e-05 -2.591330601562367e-05
+ 3.0597378717086722e-05 1.1715405008837669e-06
+ 3.0597509613357947e-05 4.4373879705279347e-06
+ 3.0597691472422451e-05 1.5994145410720101e-06
+ 3.0597836274430258e-05 2.9639731981456188e-07
+ 3.059796154201391e-05 2.0873385368245299e-08
+ 3.0598078208888788e-05 1.943014999546677e-08
+ 3.0598195271217599e-05 4.7518599020255567e-08
+ 3.059832222910712e-05 6.1042028579339084e-08
+ 3.0598441747588237e-05 6.4513885755835647e-08
+ 3.0598566561383421e-05 6.6503702090865594e-08
+ 3.05986852233694e-05 6.9517506410941445e-08
+ 3.0598807022267468e-05 7.4216078656283642e-08
+ 3.0598925079401063e-05 8.6165486160634088e-08
+ 3.0599045405298807e-05 1.345151028796109e-07
+ 3.0599117682934201e-05 3.3438560821830561e-07
+ 3.0599167927055619e-05 6.1463643851322049e-07
+ 3.0599222906934911e-05 6.3201069161701816e-07
+ 3.0599288336836933e-05 1.9469668409460591e-07
+ 3.0599324956135483e-05 -1.9721115309582521e-07
+ 3.0599353487305002e-05 -5.9492800085242849e-07
+ 3.0599377472420152e-05 -1.052709253375727e-06
+ 3.0599400264603779e-05 -1.5485855745394789e-06
+ 3.0599421578012662e-05 -1.7514863630291509e-06
+ 3.0599449348506683e-05 -1.6360206995108131e-06
+ 3.0599468493230968e-05 -1.7373883042769459e-06
+ 3.0599491628906913e-05 -6.2994778359305033e-07
+ 3.0599529874289732e-05 1.0717369828162941e-06
+ 3.0599570906424487e-05 1.413831662516641e-06
+ 3.059962876828687e-05 7.568314485533618e-07
+ 3.0599695207516408e-05 1.8509464697538209e-07
+ 3.0599783688317802e-05 1.982704296596925e-08
+ 3.0599866911856818e-05 -1.9208697219681889e-08
+ 3.0599967715963979e-05 -5.6218737858535027e-09
+ 3.060008268340673e-05 4.793782027223824e-08
+ 3.0600210705991993e-05 7.4043462235777304e-08
+ 3.0600382194275772e-05 7.0051531532524826e-08
+ 3.0600633853030798e-05 6.1649405982234346e-08
+ 3.0600946645238291e-05 6.0777588502608854e-08
+ 3.0601307032533167e-05 6.1758704099444569e-08
+ 3.0601744374306999e-05 6.2029458560781934e-08
+ 3.0602278104661617e-05 6.2059259936785921e-08
+ 3.0602875340112693e-05 6.1545092742655806e-08
+ 3.0603270353669429e-05 6.0312630217894077e-08
+ 3.0603607112516928e-05 6.3094741828255693e-08
+ 3.0604032249176921e-05 6.2182682324167271e-08
+ 3.0604506555622481e-05 6.1730522741633327e-08
+ 3.060506542567054e-05 6.1913366190627012e-08
+ 3.0605656063964049e-05 6.1920859951078617e-08
+ 3.0606485196728577e-05 6.1918996700557947e-08
+ 3.0607637193928657e-05 6.1921849071576215e-08
+ 3.0609672973422097e-05 6.192139106833313e-08
+ 3.0612730004805768e-05 6.192101025302715e-08
+ 3.0617730004805772e-05 6.192098202604002e-08
+ 3.0622730004805763e-05 6.1920995143886675e-08
+ 3.062773000480576e-05 6.192099769633732e-08
+ 3.0632730004805758e-05 6.192099812208378e-08
+ 3.0637730004805762e-05 6.1920998015874544e-08
+ 3.0642730004805752e-05 6.1920998104641241e-08
+ 3.064773000480575e-05 6.192099817189129e-08
+ 3.0652730004805747e-05 6.1920998249075804e-08
+ 3.0657730004805738e-05 6.1920998083533206e-08
+ 3.0662730004805742e-05 6.1920998124691821e-08
+ 3.066773000480574e-05 6.1920998138426196e-08
+ 3.0672730004805737e-05 6.1920998214969135e-08
+ 3.0677730004805728e-05 6.1920998027033978e-08
+ 3.0682730004805732e-05 6.1920998116935832e-08
+ 3.0687730004805729e-05 6.192099813040531e-08
+ 3.0692730004805733e-05 6.1920997906913099e-08
+ 3.0697730004805717e-05 6.1920998254133384e-08
+ 3.0702730004805721e-05 6.1920998077681029e-08
+ 3.0707730004805719e-05 6.1920998113620386e-08
+ 3.0712730004805723e-05 6.192099812797725e-08
+ 3.0717730004805707e-05 6.1920998149590778e-08
+ 3.0722730004805711e-05 6.1920998028294945e-08
+ 3.0727730004805708e-05 6.1920998012476632e-08
+ 3.0732730004805713e-05 6.1920998133795745e-08
+ 3.0737730004805703e-05 6.1920998132800176e-08
+ 3.0742730004805701e-05 6.1920998272521795e-08
+ 3.0747730004805698e-05 6.1920998014108891e-08
+ 3.0752730004805702e-05 6.1920998108051382e-08
+ 3.0757730004805693e-05 6.192099813769019e-08
+ 3.076273000480569e-05 6.1920997974551036e-08
+ 3.0767730004805688e-05 6.1920998052640181e-08
+ 3.0772730004805692e-05 6.192099804843551e-08
+ 3.0777730004805683e-05 6.1920998110146783e-08
+ 3.078273000480568e-05 6.1920998158737093e-08
+ 3.0787730004805677e-05 6.1920998260671486e-08
+ 3.0792730004805668e-05 6.1920998083964002e-08
+ 3.0797730004805672e-05 6.1920998123992357e-08
+ 3.080273000480567e-05 6.1920998173996537e-08
+ 3.0807730004805667e-05 6.1920997987432342e-08
+ 3.0812730004805658e-05 6.1920998251573942e-08
+ 3.0817730004805662e-05 6.1920998124758776e-08
+ 3.0822730004805659e-05 6.1920998135208715e-08
+ 3.0827730004805657e-05 6.1920997934460966e-08
+ 3.0832730004805647e-05 6.1920998242313146e-08
+ 3.0837730004805652e-05 6.1920998062053377e-08
+ 3.0842730004805649e-05 6.1920998133628694e-08
+ 3.0847730004805653e-05 6.1920998129148551e-08
+ 3.0852730004805637e-05 6.1920998199460346e-08
+ 3.0857730004805641e-05 6.1920998070343818e-08
+ 3.0862730004805639e-05 6.1920998054388259e-08
+ 3.0867730004805643e-05 6.1920998051274645e-08
+ 3.0872730004805627e-05 6.1920997940046169e-08
+ 3.0877730004805631e-05 6.1920998294436416e-08
+ 3.0882730004805628e-05 6.1920998202976353e-08
+ 3.0887730004805632e-05 6.1920998092992791e-08
+ 3.0892730004805623e-05 6.1920998033094591e-08
+ 3.089773000480562e-05 6.1920998057369775e-08
+ 3.0902730004805618e-05 6.1920997686704147e-08
+ 3.0907730004805622e-05 6.1920997368493205e-08
+ 3.0912730004805613e-05 6.1920993282764284e-08
+ 3.0914815728051292e-05 6.192090305713246e-08
+ 3.0916642498273002e-05 6.1920914090546652e-08
+ 3.0918529228753937e-05 6.1921195289409845e-08
+ 3.0920067992939033e-05 6.1921055703986238e-08
+ 3.0921745323309612e-05 6.1920807479109963e-08
+ 3.0922768006652719e-05 6.1921273663778124e-08
+ 3.0923140982252323e-05 6.1921879519983562e-08
+ 3.0923683685140438e-05 6.1920899260398343e-08
+ 3.0923989389354362e-05 6.1925277361531389e-08
+ 3.0924234081250257e-05 6.1916517157920538e-08
+ 3.0924434562825527e-05 6.1820473000799628e-08
+ 3.0924642513347882e-05 6.1867756919649277e-08
+ 3.0924883772330733e-05 6.1978630603289022e-08
+ 3.0925032191141177e-05 6.1280375843740054e-08
+ 3.0925097252455173e-05 5.7424903205766357e-08
+ 3.0925151919590202e-05 5.5726135685086613e-08
+ 3.0925195319203593e-05 5.9378727988845322e-08
+ 3.0925259882777658e-05 9.0796824748552184e-08
+ 3.0925325850440217e-05 1.3039365682887779e-07
+ 3.092539139825855e-05 1.7179052754576819e-07
+ 3.0925420961859148e-05 3.30603968662012e-07
+ 3.092544156547517e-05 6.5013256121807656e-07
+ 3.0925463317028548e-05 7.8367841557095903e-07
+ 3.0925490820685228e-05 2.6651474326031622e-07
+ 3.0925513954981973e-05 -7.6442501805627925e-07
+ 3.0925534943693698e-05 -2.6387237494816131e-06
+ 3.0925553919122328e-05 -4.1884975596691314e-06
+ 3.0925569028506063e-05 -5.0013431300936491e-06
+ 3.0925583579033587e-05 -4.6730883460124218e-06
+ 3.0925593713454261e-05 -2.518942933957785e-06
+ 3.0925606315227218e-05 -6.489984261882651e-07
+ 3.0925623123647651e-05 -5.1566038027618266e-07
+ 3.0925642001809312e-05 -1.6052445738724709e-06
+ 3.0925666422697848e-05 -2.650621355868272e-06
+ 3.0925691413415189e-05 -3.304584775718425e-06
+ 3.0925714632792348e-05 -3.343391250104309e-06
+ 3.0925738867268258e-05 -2.042711508037442e-06
+ 3.0925761704054343e-05 -5.534281550246434e-07
+ 3.0925788296074663e-05 -5.0960366752588805e-07
+ 3.0925816026356208e-05 -1.705968520071248e-06
+ 3.0925845634043718e-05 -2.97269716560022e-06
+ 3.0925869035502068e-05 -3.6939852458981288e-06
+ 3.0925897426312712e-05 -3.7268110159723759e-06
+ 3.0925919915613451e-05 -6.1806730757413095e-07
+ 3.0925938108578699e-05 2.214486884095179e-06
+ 3.0925955451031009e-05 -9.6786310707231724e-06
+ 3.0925973357573991e-05 -6.1899244693554262e-05
+ 3.0925995497736937e-05 -0.00015371897055985591
+ 3.0926018099455902e-05 -0.00018302783870213039
+ 3.0926031452562433e-05 -0.00011299497194530641
+ 3.0926045662716692e-05 1.7274232523948298e-05
+ 3.0926063147929602e-05 0.00014721442360996471
+ 3.0926079927276279e-05 0.00019145764278779331
+ 3.0926102860724402e-05 0.0001748588056090134
+ 3.0926127830952958e-05 0.0001315205003966324
+ 3.0926159317795483e-05 8.5541904931157894e-05
+ 3.092619209989599e-05 6.2168196041524518e-05
+ 3.0926229207616627e-05 5.7340207395214788e-05
+ 3.0926271816488773e-05 6.7824641614491727e-05
+ 3.0926325761769653e-05 8.4905711623694611e-05
+ 3.0926395407723038e-05 -0.00065032906941957702
+ 3.092644043619312e-05 -0.003337302766510055
+ 3.0926480034526487e-05 -0.0076144346113469824
+ 3.0926489242615558e-05 -0.0083269416083889547
+ 3.0926505211080288e-05 -0.0060890042904962714
+ 3.0926516409608633e-05 0.00064576039549529981
+ 3.0926527308987817e-05 0.01410449479726472
+ 3.0926539398049713e-05 0.03996176895152919
+ 3.0926552323793067e-05 0.082002796479363524
+ 3.0926570688504837e-05 0.16464870366241979
+ 3.0926583883830372e-05 0.23634184667550959
+ 3.0926599482784067e-05 0.32782918323303611
+ 3.0926614122073102e-05 0.41583861681706341
+ 3.0926633703161609e-05 0.53161809682793615
+ 3.092665714647471e-05 0.66265314173066936
+ 3.0926690476105418e-05 0.82662747404362724
+ 3.0926727811702909e-05 0.97002195873415431
+ 3.0926774890897239e-05 1.088477877833723
+ 3.092681048761346e-05 1.140195429217808
+ 3.0926849688812923e-05 1.172041650920024
+ 3.092690137189258e-05 1.191884744588751
+ 3.0926950230814242e-05 1.1987388299820601
+ 3.0927018894105807e-05 1.2013047423874399
+ 3.0927096515388791e-05 1.201226148765723
+ 3.0927221060348558e-05 1.200502822143632
+ 3.0927353780183009e-05 1.2000952552625459
+ 3.0927482833903288e-05 1.1999857917438499
+ 3.0927605467861188e-05 1.1999801691292631
+ 3.0927724818911092e-05 1.199990935635896
+ 3.0927852282754852e-05 1.1999978875484349
+ 3.0927971000902741e-05 1.199999974213791
+ 3.092809485418012e-05 1.200000268918423
+ 3.0928212640533917e-05 1.2000001286368149
+ 3.0928333902114243e-05 1.2000000102600319
+ 3.0928451574850903e-05 1.19999996556968
+ 3.0928571691716122e-05 1.1999999563899431
+ 3.0928689659655413e-05 1.1999999580724821
+ 3.0928809283156032e-05 1.1999999622829609
+ 3.09288757182803e-05 1.1999999767483041
+ 3.092892248444388e-05 1.199999995683606
+ 3.0928971702136553e-05 1.199999987027996
+ 3.0929036500071813e-05 1.1999999379525821
+ 3.0929084779620391e-05 1.1999999117867259
+ 3.0929112118652187e-05 1.199999894646439
+ 3.0929137723539307e-05 1.199999861513767
+ 3.0929160883326438e-05 1.1999998011370661
+ 3.0929183794506539e-05 1.1999997173453429
+ 3.0929212535407888e-05 1.1999996536744959
+ 3.0929235065783063e-05 1.199999879625387
+ 3.0929260009864667e-05 1.2000001807847449
+ 3.0929293672477417e-05 1.200000320933583
+ 3.0929347920937789e-05 1.200000198166264
+ 3.0929398149448213e-05 1.2000000198437331
+ 3.0929471830763352e-05 1.1999998869531441
+ 3.0929555073930167e-05 1.1999998708305151
+ 3.0929652168511572e-05 1.199999914645689
+ 3.0929747796714133e-05 1.1999999550060421
+ 3.0929862500846373e-05 1.1999999728685671
+ 3.0930001325917542e-05 1.199999970328125
+ 3.0930216949010233e-05 1.1999999620591379
+ 3.0930617912099103e-05 1.199999958743484
+ 3.0930991054557793e-05 1.199999959782992
+ 3.093155266581389e-05 1.1999999605125931
+ 3.0932144119933877e-05 1.1999999605490299
+ 3.0932688466756811e-05 1.1999999604391489
+ 3.0933209139178073e-05 1.199999960479154
+ 3.093357945472703e-05 1.199999960609605
+ 3.0933997708584969e-05 1.1999999604395051
+ 3.0934475405650799e-05 1.199999960455723
+ 3.0935074319764997e-05 1.1999999604784299
+ 3.093579230027953e-05 1.199999960482657
+ 3.0936873685794403e-05 1.199999960481742
+ 3.0938486321348319e-05 1.199999960480955
+ 3.0941252578389133e-05 1.1999999604809359
+ 3.0945706498744669e-05 1.1999999604809239
+ 3.0950706498744673e-05 1.19999996048087
+ 3.0955706498744657e-05 1.199999960480858
+ 3.0960706498744661e-05 1.1999999604808631
+ 3.0965706498744658e-05 1.199999960480866
+ 3.0970706498744663e-05 1.199999960480868
+ 3.0975706498744653e-05 1.199999960480868
+ 3.0980706498744651e-05 1.199999960480868
+ 3.0985706498744648e-05 1.199999960480868
+ 3.0990706498744652e-05 1.199999960480868
+ 3.0995706498744643e-05 1.199999960480868
+ 3.100070649874464e-05 1.199999960480868
+ 3.1005706498744638e-05 1.199999960480868
+ 3.1010706498744642e-05 1.199999960480868
+ 3.1015706498744632e-05 1.199999960480868
+ 3.102070649874463e-05 1.199999960480868
+ 3.1025706498744627e-05 1.199999960480868
+ 3.1030706498744618e-05 1.199999960480868
+ 3.1035706498744622e-05 1.199999960480868
+ 3.1040706498744619e-05 1.199999960480868
+ 3.1045706498744617e-05 1.199999960480868
+ 3.1050706498744608e-05 1.199999960480868
+ 3.1055706498744612e-05 1.199999960480868
+ 3.1060706498744609e-05 1.199999960480868
+ 3.1065706498744613e-05 1.199999960480868
+ 3.1070706498744597e-05 1.199999960480868
+ 3.1075706498744601e-05 1.199999960480868
+ 3.1080706498744599e-05 1.199999960480868
+ 3.1085706498744603e-05 1.199999960480868
+ 3.1090706498744587e-05 1.199999960480868
+ 3.1095706498744591e-05 1.199999960480868
+ 3.1100706498744588e-05 1.199999960480868
+ 3.1105706498744593e-05 1.199999960480868
+ 3.1110706498744583e-05 1.199999960480868
+ 3.1115706498744581e-05 1.199999960480868
+ 3.1120706498744578e-05 1.199999960480868
+ 3.1125706498744582e-05 1.199999960480868
+ 3.1130706498744573e-05 1.199999960480868
+ 3.113570649874457e-05 1.199999960480868
+ 3.1140706498744568e-05 1.199999960480868
+ 3.1145706498744572e-05 1.199999960480868
+ 3.1150706498744563e-05 1.199999960480868
+ 3.115570649874456e-05 1.199999960480868
+ 3.1160706498744557e-05 1.199999960480868
+ 3.1165706498744548e-05 1.1999999604808671
+ 3.1170706498744552e-05 1.1999999604808671
+ 3.117570649874455e-05 1.1999999604808651
+ 3.1180706498744547e-05 1.199999960480862
+ 3.1185706498744538e-05 1.1999999604808571
+ 3.1190706498744542e-05 1.1999999604808469
+ 3.1195706498744539e-05 1.1999999604808289
+ 3.1200706498744537e-05 1.1999999604807929
+ 3.1205706498744527e-05 1.1999999604807241
+ 3.1210706498744531e-05 1.199999960480592
+ 3.1215706498744529e-05 1.1999999604803411
+ 3.1220706498744533e-05 1.199999960479877
+ 3.1225706498744517e-05 1.199999960479061
+ 3.1230706498744521e-05 1.1999999604776219
+ 3.1235706498744519e-05 1.1999999604747209
+ 3.1240706498744523e-05 1.199999960464025
+ 3.1243302269933759e-05 1.1999999603872531
+ 3.1245000272360757e-05 1.1999999601189679
+ 3.1247082691302293e-05 1.19999996018549
+ 3.124860939949925e-05 1.1999999604163121
+ 3.1250492577067887e-05 1.199999960433821
+ 3.125173303057474e-05 1.1999999605182781
+ 3.1252280764000419e-05 1.199999961047616
+ 3.1252927182896362e-05 1.199999961543688
+ 3.1253254480580143e-05 1.199999964066278
+ 3.1253557702723128e-05 1.199999966864334
+ 3.1253796066271639e-05 1.1999999655598219
+ 3.1254003332033613e-05 1.1999999239874619
+ 3.1254218710820548e-05 1.1999998684794291
+ 3.1254461869073771e-05 1.1999998262988201
+ 3.1254591249705543e-05 1.199999652187983
+ 3.1254657063118252e-05 1.199999297406857
+ 3.125471505377974e-05 1.199998843954756
+ 3.1254760352849587e-05 1.1999985257391621
+ 3.1254828077885697e-05 1.199998011534805
+ 3.1254897963191579e-05 1.199998083537237
+ 3.125497882209805e-05 1.199999133107772
+ 3.1255003907549033e-05 1.1999996863768041
+ 3.1255023900494829e-05 1.1999998072896061
+ 3.1255042439777541e-05 1.2000000788074869
+ 3.1255066984121942e-05 1.2000026179075101
+ 3.1255094411742867e-05 1.2000078634827001
+ 3.1255118821828297e-05 1.2000107323935381
+ 3.1255139611722368e-05 1.2000101707554329
+ 3.1255156788928918e-05 1.2000079904793131
+ 3.1255171503971382e-05 1.2000050337087249
+ 3.1255187480803653e-05 1.200001950085914
+ 3.1255204649449552e-05 1.199999705443864
+ 3.1255231396952053e-05 1.199998030539009
+ 3.1255261080481268e-05 1.1999973288305701
+ 3.1255288831439063e-05 1.199997082173047
+ 3.1255312918394658e-05 1.1999975646154251
+ 3.1255338280697031e-05 1.199999324019926
+ 3.1255369446131333e-05 1.200002505961957
+ 3.1255398841063622e-05 1.2000052674455839
+ 3.1255422964630982e-05 1.2000070560823251
+ 3.1255439468442849e-05 1.20000829303691
+ 3.1255455055002182e-05 1.200009733111812
+ 3.1255469921585698e-05 1.20001176781576
+ 3.1255484657758192e-05 1.200013278607035
+ 3.1255497977499207e-05 1.2000129917140949
+ 3.1255512198564857e-05 1.200011364171675
+ 3.1255528055289882e-05 1.200008810642762
+ 3.125555443207026e-05 1.2000030510593169
+ 3.1255582251752832e-05 1.199972320338029
+ 3.1255607507697812e-05 1.199899850846724
+ 3.1255634049646708e-05 1.199784942391837
+ 3.125567019730258e-05 1.1995089730836519
+ 3.1255694180653591e-05 1.199670113952747
+ 3.1255710357552292e-05 1.201019743316561
+ 3.1255728312076038e-05 1.2049554195010641
+ 3.1255749477677529e-05 1.2126709024366999
+ 3.1255766043257519e-05 1.215681335109428
+ 3.1255780086736789e-05 1.2038282874791999
+ 3.125579630009332e-05 1.1599161986986839
+ 3.1255813341076968e-05 1.0837397183137789
+ 3.1255830970379778e-05 0.98584976143113501
+ 3.1255852251185888e-05 0.85794253173387669
+ 3.1255872735642033e-05 0.73338416876942891
+ 3.1255887428050727e-05 0.6454935087022351
+ 3.1255898658261187e-05 0.57982818303313166
+ 3.1255911220720418e-05 0.50841508514610623
+ 3.1255924313527259e-05 0.43680536727286068
+ 3.1255936999649553e-05 0.37085646314441179
+ 3.1255956849553907e-05 0.27687408030167387
+ 3.1255979789287963e-05 0.18639042646511311
+ 3.1256002168189158e-05 0.1194138241426065
+ 3.1256029101815942e-05 0.065038029054160326
+ 3.1256045530292292e-05 0.043695288354718517
+ 3.125606231780274e-05 0.028717277788109591
+ 3.1256081819620598e-05 0.017317676455761408
+ 3.1256103066784613e-05 0.0097422591473605453
+ 3.1256127392767119e-05 0.0048419292591623548
+ 3.1256155120224303e-05 0.0020082170007106851
+ 3.1256188479796109e-05 0.00052496627653086817
+ 3.1256229439460127e-05 -7.4393939484959762e-05
+ 3.1256283165064178e-05 -0.00019422500683512011
+ 3.1256357684564171e-05 -0.0001171413378958956
+ 3.125644886197908e-05 -3.3625733138441209e-05
+ 3.1256544972987128e-05 -1.395897654824215e-06
+ 3.1256672876046941e-05 4.6654528746546823e-06
+ 3.1256839306912531e-05 2.071290188822513e-06
+ 3.1256978627242313e-05 4.4580707242886079e-07
+ 3.1257103487654788e-05 3.2686326399038549e-08
+ 3.1257221890604471e-05 8.5687330050927638e-09
+ 3.1257340415943808e-05 4.1336009436736858e-08
+ 3.1257469956294267e-05 5.9599121590523477e-08
+ 3.1257589999771589e-05 6.4036779453026637e-08
+ 3.1257715776186127e-05 6.5836612365901681e-08
+ 3.1257834262150413e-05 6.8495434125214887e-08
+ 3.1257956364090083e-05 7.2408448486842053e-08
+ 3.1258074193910528e-05 8.1086844205602114e-08
+ 3.1258194684551782e-05 1.108097117318628e-07
+ 3.1258287042919583e-05 2.478029261169121e-07
+ 3.1258340300118757e-05 5.4917623978577421e-07
+ 3.1258391679980948e-05 6.8035702374701459e-07
+ 3.1258459671226502e-05 3.2134133292012131e-07
+ 3.1258505816556267e-05 -1.2685880998047299e-07
+ 3.125853369363159e-05 -5.0864667627034052e-07
+ 3.12585594820672e-05 -9.8220392844817906e-07
+ 3.1258582867800037e-05 -1.4939808306731319e-06
+ 3.1258604497335642e-05 -1.7624242902333581e-06
+ 3.1258633349004242e-05 -1.630813006719681e-06
+ 3.125865401315224e-05 -1.72806613663125e-06
+ 3.1258677025380939e-05 -6.5701142885804297e-07
+ 3.1258718569365168e-05 1.128254469101966e-06
+ 3.1258757912095637e-05 1.4142275223008689e-06
+ 3.1258818753003958e-05 7.1638511484049474e-07
+ 3.125888336220789e-05 1.7691804336437771e-07
+ 3.1258963083030837e-05 2.991898335496342e-08
+ 3.1259048237916848e-05 -1.7028510511018649e-08
+ 3.1259148837514592e-05 -4.8194268078487864e-09
+ 3.1259264392733869e-05 4.7850018167583451e-08
+ 3.125939101672948e-05 7.3637059563097182e-08
+ 3.1259560515873211e-05 7.0076535039036169e-08
+ 3.1259806143790942e-05 6.1759207781521289e-08
+ 3.1260120018139072e-05 6.0756567381903661e-08
+ 3.1260474593971438e-05 6.1737448765570139e-08
+ 3.1260911587569003e-05 6.2029560571535771e-08
+ 3.1261436345701898e-05 6.2057872095456918e-08
+ 3.1262052454430048e-05 6.1588310756494662e-08
+ 3.1262448434005451e-05 6.0290541360377853e-08
+ 3.1262790655654317e-05 6.3046527251291303e-08
+ 3.126322306055105e-05 6.2222553688204734e-08
+ 3.126368780796188e-05 6.172694732166284e-08
+ 3.1264237435771447e-05 6.1910352797541695e-08
+ 3.1264829427947281e-05 6.1922240658679409e-08
+ 3.1265650799816889e-05 6.1919149400608148e-08
+ 3.1266805748042908e-05 6.1921756772335645e-08
+ 3.1268811907896308e-05 6.1921387233366077e-08
+ 3.1271857499318188e-05 6.1921012712449066e-08
+ 3.1276857499318192e-05 6.1920982509661051e-08
+ 3.1281857499318189e-05 6.1920994846185299e-08
+ 3.1286857499318193e-05 6.192099769098574e-08
+ 3.1291857499318177e-05 6.192099798391701e-08
+ 3.1296857499318181e-05 6.1920998003349852e-08
+ 3.1301857499318179e-05 6.1920998321294759e-08
+ 3.1306857499318183e-05 6.192099817739261e-08
+ 3.1311857499318167e-05 6.1920998153036442e-08
+ 3.1316857499318171e-05 6.1920998250137639e-08
+ 3.1321857499318168e-05 6.1920998077988396e-08
+ 3.1326857499318173e-05 6.1920998090572288e-08
+ 3.1331857499318163e-05 6.1920998166162369e-08
+ 3.1336857499318161e-05 6.1920998260021574e-08
+ 3.1341857499318158e-05 6.1920998003524049e-08
+ 3.1346857499318162e-05 6.1920998158591284e-08
+ 3.1351857499318153e-05 6.1920998147820201e-08
+ 3.135685749931815e-05 6.1920998214339949e-08
+ 3.1361857499318148e-05 6.19209980434168e-08
+ 3.1366857499318152e-05 6.1920998071767125e-08
+ 3.1371857499318143e-05 6.1920998126890679e-08
+ 3.137685749931814e-05 6.1920998187426681e-08
+ 3.1381857499318137e-05 6.1920998267900304e-08
+ 3.1386857499318128e-05 6.1920998039037269e-08
+ 3.1391857499318132e-05 6.1920998123926884e-08
+ 3.139685749931813e-05 6.1920997896659329e-08
+ 3.1401857499318127e-05 6.1920998184481693e-08
+ 3.1406857499318118e-05 6.1920998067233156e-08
+ 3.1411857499318122e-05 6.1920998085931699e-08
+ 3.1416857499318119e-05 6.1920998169347345e-08
+ 3.1421857499318117e-05 6.1920997964683102e-08
+ 3.1426857499318107e-05 6.1920998253107588e-08
+ 3.1431857499318111e-05 6.192099806198715e-08
+ 3.1436857499318109e-05 6.1920998163595939e-08
+ 3.1441857499318113e-05 6.1920998132607384e-08
+ 3.1446857499318097e-05 6.1920998261536545e-08
+ 3.1451857499318101e-05 6.1920998330401978e-08
+ 3.1456857499318099e-05 6.1920998136025823e-08
+ 3.1461857499318103e-05 6.1920998147214414e-08
+ 3.1466857499318093e-05 6.1920998222919678e-08
+ 3.1471857499318091e-05 6.1920998037442729e-08
+ 3.1476857499318088e-05 6.1920998104265489e-08
+ 3.1481857499318092e-05 6.1920997937123191e-08
+ 3.1486857499318083e-05 6.1920998210063293e-08
+ 3.149185749931808e-05 6.1920998199919464e-08
+ 3.1496857499318078e-05 6.1920998318681636e-08
+ 3.1501857499318082e-05 6.1920998092970027e-08
+ 3.1506857499318073e-05 6.1920998223473134e-08
+ 3.151185749931807e-05 6.1920998223098044e-08
+ 3.1516857499318067e-05 6.1920998268433418e-08
+ 3.1521857499318058e-05 6.1920997878868024e-08
+ 3.1526857499318062e-05 6.1920998092078472e-08
+ 3.153185749931806e-05 6.1920998088767685e-08
+ 3.1536857499318057e-05 6.1920998101303627e-08
+ 3.1541857499318048e-05 6.1920998217266461e-08
+ 3.1546857499318052e-05 6.1920998143768247e-08
+ 3.1551857499318049e-05 6.1920998155237881e-08
+ 3.1556857499318047e-05 6.1920997953209008e-08
+ 3.1561857499318037e-05 6.1920997870439225e-08
+ 3.1566857499318042e-05 6.1920997360166778e-08
+ 3.1571857499318039e-05 6.1920993533385716e-08
+ 3.1573954910554883e-05 6.192090676840794e-08
+ 3.1575775030810453e-05 6.1920906358246622e-08
+ 3.1577692374313772e-05 6.1921195022181869e-08
+ 3.1579217834096542e-05 6.1921063665647518e-08
+ 3.1580893012560762e-05 6.1920800377883214e-08
+ 3.1581922380409202e-05 6.1921267474962255e-08
+ 3.1582301213239142e-05 6.1921826584185224e-08
+ 3.1582854295974643e-05 6.1920917044574995e-08
+ 3.1583162217957497e-05 6.1925181928220488e-08
+ 3.1583407491071843e-05 6.1917835363744954e-08
+ 3.1583608029929959e-05 6.1827793547546786e-08
+ 3.1583816595819643e-05 6.1857026770884246e-08
+ 3.1584059594068769e-05 6.1982364786792112e-08
+ 3.158421659524793e-05 6.1363007142633073e-08
+ 3.1584283604444468e-05 5.746114430654137e-08
+ 3.1584337900662963e-05 5.5551738273555407e-08
+ 3.1584381481576737e-05 5.9466379651941741e-08
+ 3.1584446035243802e-05 9.1141272384859243e-08
+ 3.1584511896658662e-05 1.3062726339715559e-07
+ 3.1584577060196849e-05 1.7192598865191619e-07
+ 3.1584606532231708e-05 3.2934158920816428e-07
+ 3.1584627168191663e-05 6.4755055004448208e-07
+ 3.1584648849489397e-05 7.8533871341516511e-07
+ 3.1584676294034129e-05 2.7294092729029739e-07
+ 3.1584699520956698e-05 -7.5038326546790673e-07
+ 3.158472051924188e-05 -2.6191492939381839e-06
+ 3.1584739427549139e-05 -4.1749803130147586e-06
+ 3.1584754588712378e-05 -4.9862732042358112e-06
+ 3.1584769015627532e-05 -4.7215941358880626e-06
+ 3.1584779096384928e-05 -2.5808909742008542e-06
+ 3.1584791671779423e-05 -6.7183172137181639e-07
+ 3.1584808220364449e-05 -4.9082034638957759e-07
+ 3.1584826998749647e-05 -1.568065456579099e-06
+ 3.1584851326386137e-05 -2.6258886745446722e-06
+ 3.1584876261368209e-05 -3.285082424196038e-06
+ 3.1584902205554271e-05 -3.3143996542151e-06
+ 3.1584925864362372e-05 -1.9767619466583332e-06
+ 3.158494884796297e-05 -5.2160176106243876e-07
+ 3.1584975838260371e-05 -5.5782548556319135e-07
+ 3.1585006279314068e-05 -1.891120275415566e-06
+ 3.1585034541671949e-05 -3.0520573990408072e-06
+ 3.1585056469166403e-05 -3.714267492455918e-06
+ 3.1585083876352332e-05 -3.6453108053790758e-06
+ 3.158510451495007e-05 -7.5701836285610724e-07
+ 3.1585122078614453e-05 2.2644855439446271e-06
+ 3.1585139249905833e-05 -6.438989169370159e-06
+ 3.1585157049762907e-05 -5.3656265281365318e-05
+ 3.1585179568225689e-05 -0.00014690455100424069
+ 3.1585200587317559e-05 -0.00018815911333491811
+ 3.1585213545398199e-05 -0.0001374999776472621
+ 3.1585227033128032e-05 -2.0344404719294381e-05
+ 3.1585242399905097e-05 0.0001126739809391233
+ 3.1585258522391411e-05 0.0001835026395823462
+ 3.158528174920764e-05 0.00018552023793286839
+ 3.158530476220121e-05 0.00014741539367392259
+ 3.1585336393340568e-05 9.5869125469118168e-05
+ 3.1585367079752198e-05 6.7055136014411174e-05
+ 3.1585403965525707e-05 5.6841487132169617e-05
+ 3.1585443372495222e-05 6.2756414314728244e-05
+ 3.158549459397964e-05 8.527163771033093e-05
+ 3.158555879989062e-05 -0.00017084183317788091
+ 3.1585607130639549e-05 -0.0018585512434805089
+ 3.1585653400501087e-05 -0.0064109216383858494
+ 3.1585668314682678e-05 -0.0081675475149771519
+ 3.1585682755309493e-05 -0.0082809176393360134
+ 3.1585691882798473e-05 -0.0062861320997832006
+ 3.1585701957039177e-05 -0.00040293027800255221
+ 3.1585712528717977e-05 0.01218714166359088
+ 3.1585725611657467e-05 0.040113102678127843
+ 3.1585738052743483e-05 0.080826875326537082
+ 3.1585754529223948e-05 0.1541897220993653
+ 3.1585766396486553e-05 0.2176436354066027
+ 3.1585779946313673e-05 0.2963030568618279
+ 3.1585794552306412e-05 0.38400637005304772
+ 3.1585811954000647e-05 0.48799419424484658
+ 3.1585834403842397e-05 0.6166153805248179
+ 3.1585864270045827e-05 0.77152949764070256
+ 3.1585901101752978e-05 0.92736506715319678
+ 3.1585943326676528e-05 1.052302101134027
+ 3.1585990617921077e-05 1.1343115495890219
+ 3.1586032336822177e-05 1.171285627455718
+ 3.1586085182873422e-05 1.192480395528682
+ 3.1586133082927218e-05 1.199149177563849
+ 3.1586199696212012e-05 1.2014759067488301
+ 3.1586274743433278e-05 1.20128479231704
+ 3.1586396370836827e-05 1.2005050442228851
+ 3.1586528329373142e-05 1.2000857976373469
+ 3.158665761017811e-05 1.1999799838766589
+ 3.1586780661968018e-05 1.1999782623127251
+ 3.1586900249624358e-05 1.199990675457222
+ 3.1587028165023232e-05 1.1999980325993731
+ 3.1587146932763768e-05 1.2000000820746419
+ 3.1587270961729699e-05 1.200000308071336
+ 3.1587388700951432e-05 1.2000001360278849
+ 3.158751003034529e-05 1.200000008711388
+ 3.1587627657311251e-05 1.1999999637266541
+ 3.1587747815491518e-05 1.199999955558148
+ 3.1587865756206052e-05 1.199999957804107
+ 3.1587985404197538e-05 1.199999961898143
+ 3.1588056866270973e-05 1.199999974513716
+ 3.1588104455244303e-05 1.199999994456586
+ 3.1588152767799228e-05 1.199999990056736
+ 3.158821865512925e-05 1.19999994158416
+ 3.15882757547955e-05 1.199999912016207
+ 3.1588304913501521e-05 1.1999998897688671
+ 3.1588328941468312e-05 1.199999848138118
+ 3.1588350882640912e-05 1.199999782947784
+ 3.1588373351548953e-05 1.199999698841949
+ 3.1588401142086748e-05 1.199999658649477
+ 3.158842124010671e-05 1.1999998932228131
+ 3.1588445943456488e-05 1.2000001899184269
+ 3.1588482797618727e-05 1.200000324744027
+ 3.158853470895687e-05 1.2000001947496091
+ 3.158858771275079e-05 1.200000009839314
+ 3.1588660459697698e-05 1.1999998849098279
+ 3.158874086723713e-05 1.1999998714790989
+ 3.1588842659761369e-05 1.1999999169657789
+ 3.1588935430567963e-05 1.19999995553143
+ 3.1589054268761467e-05 1.199999973193782
+ 3.1589190735023382e-05 1.199999970157916
+ 3.1589414461953519e-05 1.199999961768627
+ 3.15898109566354e-05 1.1999999587663319
+ 3.1590190963747467e-05 1.1999999598195821
+ 3.1590749712731187e-05 1.1999999605157781
+ 3.1591350528812271e-05 1.199999960546771
+ 3.159189246105039e-05 1.199999960435955
+ 3.1592432526305189e-05 1.1999999604885201
+ 3.1592815388504578e-05 1.1999999606013301
+ 3.1593243371325412e-05 1.199999960435957
+ 3.1593731773386069e-05 1.1999999604576499
+ 3.1594337637068541e-05 1.199999960479573
+ 3.1595087595127398e-05 1.199999960482844
+ 3.1596218224867681e-05 1.1999999604816129
+ 3.1597947284397939e-05 1.1999999604809179
+ 3.160086429075921e-05 1.1999999604809419
+ 3.1605719063124968e-05 1.199999960480914
+ 3.1610719063124972e-05 1.1999999604808651
+ 3.1615719063124969e-05 1.199999960480858
+ 3.1620719063124967e-05 1.199999960480864
+ 3.1625719063124957e-05 1.1999999604808671
+ 3.1630719063124962e-05 1.199999960480868
+ 3.1635719063124959e-05 1.199999960480868
+ 3.1640719063124963e-05 1.199999960480868
+ 3.1645719063124947e-05 1.199999960480868
+ 3.1650719063124951e-05 1.199999960480868
+ 3.1655719063124949e-05 1.199999960480868
+ 3.1660719063124953e-05 1.199999960480868
+ 3.1665719063124937e-05 1.199999960480868
+ 3.1670719063124941e-05 1.199999960480868
+ 3.1675719063124938e-05 1.199999960480868
+ 3.1680719063124942e-05 1.199999960480868
+ 3.1685719063124933e-05 1.199999960480868
+ 3.169071906312493e-05 1.199999960480868
+ 3.1695719063124928e-05 1.199999960480868
+ 3.1700719063124932e-05 1.199999960480868
+ 3.1705719063124923e-05 1.199999960480868
+ 3.171071906312492e-05 1.199999960480868
+ 3.1715719063124918e-05 1.199999960480868
+ 3.1720719063124908e-05 1.199999960480868
+ 3.1725719063124912e-05 1.199999960480868
+ 3.173071906312491e-05 1.199999960480868
+ 3.1735719063124907e-05 1.199999960480868
+ 3.1740719063124898e-05 1.199999960480868
+ 3.1745719063124902e-05 1.199999960480868
+ 3.1750719063124899e-05 1.199999960480868
+ 3.1755719063124897e-05 1.199999960480868
+ 3.1760719063124887e-05 1.199999960480868
+ 3.1765719063124892e-05 1.199999960480868
+ 3.1770719063124889e-05 1.199999960480868
+ 3.1775719063124893e-05 1.199999960480868
+ 3.1780719063124877e-05 1.199999960480868
+ 3.1785719063124881e-05 1.199999960480868
+ 3.1790719063124879e-05 1.199999960480868
+ 3.1795719063124883e-05 1.199999960480868
+ 3.1800719063124867e-05 1.199999960480868
+ 3.1805719063124871e-05 1.199999960480868
+ 3.1810719063124868e-05 1.199999960480868
+ 3.1815719063124873e-05 1.199999960480868
+ 3.1820719063124863e-05 1.199999960480868
+ 3.1825719063124861e-05 1.1999999604808671
+ 3.1830719063124858e-05 1.1999999604808671
+ 3.1835719063124862e-05 1.1999999604808651
+ 3.1840719063124853e-05 1.199999960480862
+ 3.184571906312485e-05 1.199999960480856
+ 3.1850719063124848e-05 1.1999999604808449
+ 3.1855719063124852e-05 1.1999999604808249
+ 3.1860719063124842e-05 1.1999999604807841
+ 3.186571906312484e-05 1.199999960480707
+ 3.1870719063124837e-05 1.19999996048056
+ 3.1875719063124828e-05 1.199999960480282
+ 3.1880719063124832e-05 1.199999960479772
+ 3.188571906312483e-05 1.1999999604788749
+ 3.1890719063124827e-05 1.199999960477288
+ 3.1895719063124818e-05 1.1999999604739009
+ 3.1900719063124822e-05 1.1999999604586999
+ 3.1902983729050612e-05 1.199999960333898
+ 3.1904721796273133e-05 1.19999996007504
+ 3.1906861713293171e-05 1.1999999602554781
+ 3.1908299099743501e-05 1.1999999604946039
+ 3.1910008525203531e-05 1.1999999603721569
+ 3.1911101672077353e-05 1.199999960620882
+ 3.1911560454356447e-05 1.1999999612126859
+ 3.1912217587915522e-05 1.1999999617406589
+ 3.1912552058811787e-05 1.1999999649878059
+ 3.1912817356763783e-05 1.1999999682279461
+ 3.1913030256384689e-05 1.199999959081951
+ 3.1913241740900163e-05 1.19999990583792
+ 3.1913454111930958e-05 1.199999858172508
+ 3.191369803340265e-05 1.1999998030018511
+ 3.1913803454044707e-05 1.1999995291867389
+ 3.1913863472692047e-05 1.199999089129371
+ 3.1913913297632797e-05 1.199998682977794
+ 3.1913968103643018e-05 1.199998265145086
+ 3.1914032829227733e-05 1.1999979315257641
+ 3.1914105756549832e-05 1.1999983839095509
+ 3.1914160471306632e-05 1.1999993152137349
+ 3.191418004385639e-05 1.199999712298321
+ 3.1914200783692948e-05 1.1999998866655039
+ 3.1914219987864981e-05 1.2000001105550691
+ 3.1914243447685073e-05 1.200002405680582
+ 3.191427051228669e-05 1.2000075302535389
+ 3.1914294862658717e-05 1.2000106218088751
+ 3.1914315665888041e-05 1.200010273970584
+ 3.1914332545667198e-05 1.2000082844143509
+ 3.1914349978122783e-05 1.200004941597355
+ 3.1914366457289447e-05 1.200001816212793
+ 3.1914382700971343e-05 1.199999694625695
+ 3.1914410402520819e-05 1.199997965753137
+ 3.1914440049619993e-05 1.199997294208625
+ 3.1914468041133797e-05 1.1999970750925519
+ 3.1914492215155732e-05 1.1999976068415781
+ 3.1914517604011592e-05 1.1999994221208561
+ 3.1914547682507222e-05 1.200002523022522
+ 3.1914578168892062e-05 1.2000053600450109
+ 3.1914602586615358e-05 1.20000714636718
+ 3.1914619153524098e-05 1.200008400465344
+ 3.1914634799609518e-05 1.2000098939713
+ 3.1914649363817858e-05 1.2000119408028049
+ 3.1914664776364917e-05 1.2000133335210359
+ 3.1914677197763523e-05 1.2000129204724219
+ 3.191469094592071e-05 1.200011291703952
+ 3.1914708411180228e-05 1.2000084633479879
+ 3.1914736510182547e-05 1.200001232463668
+ 3.1914764357864647e-05 1.1999642299638831
+ 3.1914788951080769e-05 1.1998884046484919
+ 3.1914815610384128e-05 1.1997678085067061
+ 3.1914854326624513e-05 1.19945689966382
+ 3.1914875763669828e-05 1.1998147516294659
+ 3.1914891871834997e-05 1.201524089925518
+ 3.1914911721392257e-05 1.2065530801449
+ 3.1914933212248112e-05 1.2144840450166721
+ 3.1914948308783008e-05 1.2143649840246149
+ 3.1914962080040837e-05 1.197027591929344
+ 3.1914980050530178e-05 1.1389120794277341
+ 3.1915000649017673e-05 1.0370362601851899
+ 3.1915019936962517e-05 0.92450234627930017
+ 3.191504099120397e-05 0.79637645284622993
+ 3.191506074973232e-05 0.67710697346213555
+ 3.1915074152464573e-05 0.59810987784450886
+ 3.1915085784937071e-05 0.5313592925868551
+ 3.1915099518842733e-05 0.45530763067220448
+ 3.191511261579042e-05 0.38626021709420683
+ 3.1915127581020139e-05 0.31275664577176437
+ 3.1915147927994468e-05 0.22499057847470899
+ 3.191517182684535e-05 0.14356910237184339
+ 3.1915194067076897e-05 0.089295504223022654
+ 3.1915210225241988e-05 0.061537492005541893
+ 3.1915226040478593e-05 0.0420656031963106
+ 3.1915243882375729e-05 0.026930581114088071
+ 3.1915265273061623e-05 0.01536751708259027
+ 3.1915286692580647e-05 0.0085315182320821192
+ 3.1915312534074638e-05 0.0039839299213556192
+ 3.1915340482032788e-05 0.001585614618577975
+ 3.1915375879975672e-05 0.00031829761073413969
+ 3.1915418188108723e-05 -0.00012907742379671239
+ 3.1915476364638723e-05 -0.00018526654029199239
+ 3.1915556518814663e-05 -9.3997805237172854e-05
+ 3.1915645485679679e-05 -2.3838334366249109e-05
+ 3.1915749311168982e-05 1.824641586817607e-06
+ 3.1915880758513873e-05 4.3267069000587558e-06
+ 3.1916046614167567e-05 1.514148643493277e-06
+ 3.1916185882703717e-05 2.6616946932839948e-07
+ 3.1916310461059649e-05 1.076661020754407e-08
+ 3.1916428601201721e-05 1.777045496071383e-08
+ 3.1916546901217527e-05 4.8007278532755789e-08
+ 3.1916675119523021e-05 6.1435342690822632e-08
+ 3.1916795020212163e-05 6.448914492868946e-08
+ 3.1916920112882523e-05 6.627889689751852e-08
+ 3.191703869764379e-05 6.9205406586244136e-08
+ 3.1917160515216502e-05 7.3682152919743202e-08
+ 3.1917278483151252e-05 8.460228949270249e-08
+ 3.1917398830509078e-05 1.2682909806391749e-07
+ 3.1917475740307628e-05 3.0681419580310879e-07
+ 3.1917526575461762e-05 5.9376970504307559e-07
+ 3.19175800661055e-05 6.5232693863554828e-07
+ 3.1917645937957988e-05 2.4227963253554422e-07
+ 3.1917681504695043e-05 -1.3570315825510639e-07
+ 3.1917712288810521e-05 -5.307672251521596e-07
+ 3.1917737010089981e-05 -9.6975368530657472e-07
+ 3.191776019748964e-05 -1.4742634599909249e-06
+ 3.1917781672757771e-05 -1.7522185354300191e-06
+ 3.191781066500582e-05 -1.6241913429797141e-06
+ 3.1917831602541223e-05 -1.7255837725815669e-06
+ 3.1917854602712029e-05 -6.6976167570208149e-07
+ 3.1917895192267068e-05 1.099680618534618e-06
+ 3.1917934818224653e-05 1.415463441746695e-06
+ 3.1917994802805757e-05 7.3433673176758057e-07
+ 3.1918059654277539e-05 1.8260846964170999e-07
+ 3.1918140671757942e-05 2.9337882864161561e-08
+ 3.1918225914400538e-05 -1.7038157850983579e-08
+ 3.1918327290995339e-05 -5.2988867944970208e-09
+ 3.1918442307109167e-05 4.732733556751972e-08
+ 3.1918569414931183e-05 7.3643881794172506e-08
+ 3.1918738411249838e-05 7.0162150571264634e-08
+ 3.191898512690174e-05 6.1762979177211613e-08
+ 3.1919298022886443e-05 6.0752144148189387e-08
+ 3.1919653530905449e-05 6.1737837732250015e-08
+ 3.1920089586867322e-05 6.2029574437437298e-08
+ 3.1920615345398387e-05 6.2057961523112609e-08
+ 3.1921230329460028e-05 6.1586879774530916e-08
+ 3.1921626172874133e-05 6.0290956011011871e-08
+ 3.1921968136767167e-05 6.3047302514681378e-08
+ 3.1922400300231002e-05 6.2222014371326787e-08
+ 3.1922864995035252e-05 6.1727064090037446e-08
+ 3.1923414514789618e-05 6.1910378324000331e-08
+ 3.1924006422475353e-05 6.1922215577393842e-08
+ 3.1924827495284108e-05 6.1919144676176376e-08
+ 3.1925981961881183e-05 6.1921757378971602e-08
+ 3.1927986883094689e-05 6.192138764907922e-08
+ 3.193103117259361e-05 6.1921012548769942e-08
+ 3.1936031172593607e-05 6.1920982302438001e-08
+ 3.1941031172593598e-05 6.192099482905967e-08
+ 3.1946031172593602e-05 6.1920997645930059e-08
+ 3.1951031172593599e-05 6.1920997909366795e-08
+ 3.1956031172593597e-05 6.1920998235810884e-08
+ 3.1961031172593587e-05 6.1920998074440149e-08
+ 3.1966031172593592e-05 6.1920998155591027e-08
+ 3.1971031172593589e-05 6.1920998225880243e-08
+ 3.1976031172593593e-05 6.1920998262920226e-08
+ 3.1981031172593577e-05 6.1920998109098659e-08
+ 3.1986031172593581e-05 6.192099812895065e-08
+ 3.1991031172593579e-05 6.1920998211805494e-08
+ 3.1995515586296789e-05 6.1920997984883064e-08
+ 3.1999999999999999e-05 6.1920998381178255e-08
+ )
.control
set num_threads=1
set numdgt=15
set wr_singlescale
set wr_vecnames
save v(fout) v(pad_c2p) v(temp_pad) v(xpad.net1) v(xpad.net2) i(vpad33) i(vpad12) i(vreplay)
tran 2n 32u
wrdata reduction.dat v(fout) v(pad_c2p) v(temp_pad) v(xpad.net1) v(xpad.net2) i(vpad33) i(vpad12) i(vreplay)
quit
.endc
.end
