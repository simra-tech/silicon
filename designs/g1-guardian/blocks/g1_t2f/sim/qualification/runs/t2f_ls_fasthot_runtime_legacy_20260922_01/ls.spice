* ngspice translation of raw_pex.spice
* Source SHA256 866801c8bfdc8d517af8e2896ea39bca00f85f930d02f7ccaa83df38a81a220d
.SUBCKT g1_ls_up in out vdd vdda vss
XM1 n_4 in vss vss sg13_lv_nmos L=0.13U W=1U AS=0.34P AD=0.34P PS=2.68U PD=2.68U rfmode=0
XM2 n_3 n_4 vss vss sg13_hv_nmos L=0.45U W=3.8U AS=1.292P AD=1.292P PS=8.28U PD=8.28U rfmode=0
XM3 n_5 in vss vss sg13_hv_nmos L=0.45U W=3.8U AS=1.292P AD=1.292P PS=8.28U PD=8.28U rfmode=0
XM4 out n_5 vss vss sg13_hv_nmos L=0.45U W=1.9U AS=0.646P AD=0.646P PS=4.48U PD=4.48U rfmode=0
XM5 n_4 in vdd vdd sg13_lv_pmos L=0.13U W=2U AS=0.68P AD=0.68P PS=4.68U PD=4.68U rfmode=0
XM6 out n_5 vdda vdda sg13_hv_pmos L=0.45U W=3.9U AS=1.326P AD=1.326P PS=8.48U PD=8.48U rfmode=0
XM7 n_3 n_5 vdda vdda sg13_hv_pmos L=0.45U W=0.3U AS=0.102P AD=0.102P PS=1.28U PD=1.28U rfmode=0
XM8 n_5 n_3 vdda vdda sg13_hv_pmos L=0.45U W=0.3U AS=0.102P AD=0.102P PS=1.28U PD=1.28U rfmode=0
Cext_1 n_3 n_4 1.20585e-16
Cext_2 n_3 n_5 5.20224e-16
Cext_3 n_3 in 3.17187e-17
Cext_4 n_3 out 7.0479e-17
Cext_5 n_3 vdda 7.00154e-17
Cext_6 n_3 vss 3.38549e-16
Cext_7 n_3 vss 3.94361e-16
Cext_8 n_4 n_5 2.34274e-16
Cext_9 n_4 in 3.88706e-16
Cext_10 n_4 out 4.18793e-18
Cext_11 n_4 vdd 2.10387e-16
Cext_12 n_4 vdda 2.44212e-17
Cext_13 n_4 vss 4.31201e-16
Cext_14 n_4 vss 1.26833f
Cext_15 n_5 in 1.01229e-16
Cext_16 n_5 out 2.92627e-16
Cext_17 n_5 vdd 1.53624e-19
Cext_18 n_5 vdda 4.80472e-16
Cext_19 n_5 vss 6.75817e-16
Cext_20 n_5 vss 1.77214f
Cext_21 in vdd 3.2872e-17
Cext_22 in vdda 1.16906e-18
Cext_23 in vss 3.4392e-16
Cext_24 out vdda 2.39298e-16
Cext_25 out vss 9.85541e-17
Cext_26 vdd vdda 1.83974e-17
Cext_27 vdda vss 1.23264e-17
Cext_28 vss in 1.84407f
Cext_29 vss out 6.2379e-16
Cext_30 vss vdd 3.32051e-16
Cext_31 vss vdda 1.0366f
Cext_32 vss vss 1.33616f
.ENDS g1_ls_up
