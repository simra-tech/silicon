* G1_T2F joint C-PEX: T=100.0 C, VDDA=3.3 V, VDD=1.2 V, HBT=bcs, MOS=ff, R=bcs, C=bcs, mismatch=True, seed=52016
.lib /foss/pdks/ihp-sg13g2/libs.tech/ngspice/models/cornerHBT.lib hbt_bcs_mismatch
.lib /foss/pdks/ihp-sg13g2/libs.tech/ngspice/models/cornerMOShv.lib mos_ff_mismatch
.lib /foss/pdks/ihp-sg13g2/libs.tech/ngspice/models/cornerMOSlv.lib mos_ff_mismatch
.lib /foss/pdks/ihp-sg13g2/libs.tech/ngspice/models/cornerRES.lib res_bcs_mismatch
.lib /foss/pdks/ihp-sg13g2/libs.tech/ngspice/models/cornerCAP.lib cap_bcs_mismatch
.include bgr.spice
.include t2f.spice
.option seed=52016
.option gmin=1e-15 abstol=1e-13 reltol=1e-4 vntol=1e-6 method=gear
.temp 100.0
.global sub!
Vsub sub! 0 dc 0
Vdd vdd 0 dc 3.3
Vdd12 vdd12 0 dc 1.2
Vr4 r4 0 dc 0
Ven en 0 pwl(0 0 1u 0 1.01u 3.3)
Vmode mode 0 dc 0
Xbgr vdd 0 r4 vref iptat pbias pcasc vbe dvbe g1_bgr
Vload iptat 0 dc 1.0
Xt2f vdd vdd12 0 pbias pcasc vref en mode fout g1_t2f
* TEMP_OUT pad stand-in: ~50 fF of core wiring plus the IO cell input
Cout fout 0 50f
.control
set num_threads=1
set filetype=ascii
set numdgt=15
set wr_singlescale
set wr_vecnames
op
print @n.xbgr.xr1.nr1[nsmm_rsh]
print @n.xbgr.xr1.nr1[nsmm_w]
print @n.xbgr.xr1.nr1[nsmm_l]
print @n.xbgr.xr2.nr1[nsmm_rsh]
print @n.xbgr.xr2.nr1[nsmm_w]
print @n.xbgr.xr2.nr1[nsmm_l]
print @n.xbgr.xr3.nr1[nsmm_rsh]
print @n.xbgr.xr3.nr1[nsmm_w]
print @n.xbgr.xr3.nr1[nsmm_l]
print @n.xbgr.xr4.nr1[nsmm_rsh]
print @n.xbgr.xr4.nr1[nsmm_w]
print @n.xbgr.xr4.nr1[nsmm_l]
print @n.xbgr.xr5.nr1[nsmm_rsh]
print @n.xbgr.xr5.nr1[nsmm_w]
print @n.xbgr.xr5.nr1[nsmm_l]
print @n.xbgr.xr6.nr1[nsmm_rsh]
print @n.xbgr.xr6.nr1[nsmm_w]
print @n.xbgr.xr6.nr1[nsmm_l]
print @n.xbgr.xr7.nr1[nsmm_rsh]
print @n.xbgr.xr7.nr1[nsmm_w]
print @n.xbgr.xr7.nr1[nsmm_l]
print @n.xbgr.xr8.nr1[nsmm_rsh]
print @n.xbgr.xr8.nr1[nsmm_w]
print @n.xbgr.xr8.nr1[nsmm_l]
print @n.xbgr.xr9.nr1[nsmm_rsh]
print @n.xbgr.xr9.nr1[nsmm_w]
print @n.xbgr.xr9.nr1[nsmm_l]
print @n.xbgr.xr10.nr1[nsmm_rsh]
print @n.xbgr.xr10.nr1[nsmm_w]
print @n.xbgr.xr10.nr1[nsmm_l]
print @n.xbgr.xr11.nr1[nsmm_rsh]
print @n.xbgr.xr11.nr1[nsmm_w]
print @n.xbgr.xr11.nr1[nsmm_l]
print @n.xbgr.xr12.nr1[nsmm_rsh]
print @n.xbgr.xr12.nr1[nsmm_w]
print @n.xbgr.xr12.nr1[nsmm_l]
print @n.xbgr.xr13.nr1[nsmm_rsh]
print @n.xbgr.xr13.nr1[nsmm_w]
print @n.xbgr.xr13.nr1[nsmm_l]
print @n.xbgr.xr14.nr1[nsmm_rsh]
print @n.xbgr.xr14.nr1[nsmm_w]
print @n.xbgr.xr14.nr1[nsmm_l]
print @n.xbgr.xr15.nr1[nsmm_rsh]
print @n.xbgr.xr15.nr1[nsmm_w]
print @n.xbgr.xr15.nr1[nsmm_l]
print @n.xbgr.xr16.nr1[nsmm_rsh]
print @n.xbgr.xr16.nr1[nsmm_w]
print @n.xbgr.xr16.nr1[nsmm_l]
print @n.xbgr.xr17.nr1[nsmm_rsh]
print @n.xbgr.xr17.nr1[nsmm_w]
print @n.xbgr.xr17.nr1[nsmm_l]
print @n.xbgr.xr18.nr1[nsmm_rsh]
print @n.xbgr.xr18.nr1[nsmm_w]
print @n.xbgr.xr18.nr1[nsmm_l]
print @n.xbgr.xr19.nr1[nsmm_rsh]
print @n.xbgr.xr19.nr1[nsmm_w]
print @n.xbgr.xr19.nr1[nsmm_l]
print @n.xbgr.xr20.nr1[nsmm_rsh]
print @n.xbgr.xr20.nr1[nsmm_w]
print @n.xbgr.xr20.nr1[nsmm_l]
print @n.xbgr.xr21.nr1[nsmm_rsh]
print @n.xbgr.xr21.nr1[nsmm_w]
print @n.xbgr.xr21.nr1[nsmm_l]
print @n.xbgr.xr22.nr1[nsmm_rsh]
print @n.xbgr.xr22.nr1[nsmm_w]
print @n.xbgr.xr22.nr1[nsmm_l]
print @n.xbgr.xr23.nr1[nsmm_rsh]
print @n.xbgr.xr23.nr1[nsmm_w]
print @n.xbgr.xr23.nr1[nsmm_l]
print @n.xbgr.xr24.nr1[nsmm_rsh]
print @n.xbgr.xr24.nr1[nsmm_w]
print @n.xbgr.xr24.nr1[nsmm_l]
print @n.xbgr.xr25.nr1[nsmm_rsh]
print @n.xbgr.xr25.nr1[nsmm_w]
print @n.xbgr.xr25.nr1[nsmm_l]
print @n.xbgr.xr26.nr1[nsmm_rsh]
print @n.xbgr.xr26.nr1[nsmm_w]
print @n.xbgr.xr26.nr1[nsmm_l]
print @n.xbgr.xm27.nsg13_hv_pmos[w]
print @n.xbgr.xm27.nsg13_hv_pmos[l]
print @n.xbgr.xm27.nsg13_hv_pmos[delvto]
print @n.xbgr.xm27.nsg13_hv_pmos[factuo]
print @n.xbgr.xm28.nsg13_hv_pmos[w]
print @n.xbgr.xm28.nsg13_hv_pmos[l]
print @n.xbgr.xm28.nsg13_hv_pmos[delvto]
print @n.xbgr.xm28.nsg13_hv_pmos[factuo]
print @n.xbgr.xm29.nsg13_hv_nmos[w]
print @n.xbgr.xm29.nsg13_hv_nmos[l]
print @n.xbgr.xm29.nsg13_hv_nmos[delvto]
print @n.xbgr.xm29.nsg13_hv_nmos[factuo]
print @n.xbgr.xm30.nsg13_hv_nmos[w]
print @n.xbgr.xm30.nsg13_hv_nmos[l]
print @n.xbgr.xm30.nsg13_hv_nmos[delvto]
print @n.xbgr.xm30.nsg13_hv_nmos[factuo]
print @n.xbgr.xm31.nsg13_hv_nmos[w]
print @n.xbgr.xm31.nsg13_hv_nmos[l]
print @n.xbgr.xm31.nsg13_hv_nmos[delvto]
print @n.xbgr.xm31.nsg13_hv_nmos[factuo]
print @n.xbgr.xm32.nsg13_hv_nmos[w]
print @n.xbgr.xm32.nsg13_hv_nmos[l]
print @n.xbgr.xm32.nsg13_hv_nmos[delvto]
print @n.xbgr.xm32.nsg13_hv_nmos[factuo]
print @n.xbgr.xm33.nsg13_hv_nmos[w]
print @n.xbgr.xm33.nsg13_hv_nmos[l]
print @n.xbgr.xm33.nsg13_hv_nmos[delvto]
print @n.xbgr.xm33.nsg13_hv_nmos[factuo]
print @n.xbgr.xm34.nsg13_hv_nmos[w]
print @n.xbgr.xm34.nsg13_hv_nmos[l]
print @n.xbgr.xm34.nsg13_hv_nmos[delvto]
print @n.xbgr.xm34.nsg13_hv_nmos[factuo]
print @n.xbgr.xm35.nsg13_hv_nmos[w]
print @n.xbgr.xm35.nsg13_hv_nmos[l]
print @n.xbgr.xm35.nsg13_hv_nmos[delvto]
print @n.xbgr.xm35.nsg13_hv_nmos[factuo]
print @n.xbgr.xm36.nsg13_hv_nmos[w]
print @n.xbgr.xm36.nsg13_hv_nmos[l]
print @n.xbgr.xm36.nsg13_hv_nmos[delvto]
print @n.xbgr.xm36.nsg13_hv_nmos[factuo]
print @n.xbgr.xm37.nsg13_hv_nmos[w]
print @n.xbgr.xm37.nsg13_hv_nmos[l]
print @n.xbgr.xm37.nsg13_hv_nmos[delvto]
print @n.xbgr.xm37.nsg13_hv_nmos[factuo]
print @n.xbgr.xm38.nsg13_hv_pmos[w]
print @n.xbgr.xm38.nsg13_hv_pmos[l]
print @n.xbgr.xm38.nsg13_hv_pmos[delvto]
print @n.xbgr.xm38.nsg13_hv_pmos[factuo]
print @n.xbgr.xm39.nsg13_hv_pmos[w]
print @n.xbgr.xm39.nsg13_hv_pmos[l]
print @n.xbgr.xm39.nsg13_hv_pmos[delvto]
print @n.xbgr.xm39.nsg13_hv_pmos[factuo]
print @n.xbgr.xm40.nsg13_hv_pmos[w]
print @n.xbgr.xm40.nsg13_hv_pmos[l]
print @n.xbgr.xm40.nsg13_hv_pmos[delvto]
print @n.xbgr.xm40.nsg13_hv_pmos[factuo]
print @n.xbgr.xm41.nsg13_hv_pmos[w]
print @n.xbgr.xm41.nsg13_hv_pmos[l]
print @n.xbgr.xm41.nsg13_hv_pmos[delvto]
print @n.xbgr.xm41.nsg13_hv_pmos[factuo]
print @n.xbgr.xm42.nsg13_hv_pmos[w]
print @n.xbgr.xm42.nsg13_hv_pmos[l]
print @n.xbgr.xm42.nsg13_hv_pmos[delvto]
print @n.xbgr.xm42.nsg13_hv_pmos[factuo]
print @n.xbgr.xm43.nsg13_hv_pmos[w]
print @n.xbgr.xm43.nsg13_hv_pmos[l]
print @n.xbgr.xm43.nsg13_hv_pmos[delvto]
print @n.xbgr.xm43.nsg13_hv_pmos[factuo]
print @n.xbgr.xm44.nsg13_hv_pmos[w]
print @n.xbgr.xm44.nsg13_hv_pmos[l]
print @n.xbgr.xm44.nsg13_hv_pmos[delvto]
print @n.xbgr.xm44.nsg13_hv_pmos[factuo]
print @n.xbgr.xm45.nsg13_hv_pmos[w]
print @n.xbgr.xm45.nsg13_hv_pmos[l]
print @n.xbgr.xm45.nsg13_hv_pmos[delvto]
print @n.xbgr.xm45.nsg13_hv_pmos[factuo]
print @n.xbgr.xm46.nsg13_hv_pmos[w]
print @n.xbgr.xm46.nsg13_hv_pmos[l]
print @n.xbgr.xm46.nsg13_hv_pmos[delvto]
print @n.xbgr.xm46.nsg13_hv_pmos[factuo]
print @n.xbgr.xm47.nsg13_hv_pmos[w]
print @n.xbgr.xm47.nsg13_hv_pmos[l]
print @n.xbgr.xm47.nsg13_hv_pmos[delvto]
print @n.xbgr.xm47.nsg13_hv_pmos[factuo]
print @n.xbgr.xm48.nsg13_hv_pmos[w]
print @n.xbgr.xm48.nsg13_hv_pmos[l]
print @n.xbgr.xm48.nsg13_hv_pmos[delvto]
print @n.xbgr.xm48.nsg13_hv_pmos[factuo]
print @n.xbgr.xm49.nsg13_hv_pmos[w]
print @n.xbgr.xm49.nsg13_hv_pmos[l]
print @n.xbgr.xm49.nsg13_hv_pmos[delvto]
print @n.xbgr.xm49.nsg13_hv_pmos[factuo]
print @n.xbgr.xm50.nsg13_hv_pmos[w]
print @n.xbgr.xm50.nsg13_hv_pmos[l]
print @n.xbgr.xm50.nsg13_hv_pmos[delvto]
print @n.xbgr.xm50.nsg13_hv_pmos[factuo]
print @n.xbgr.xm51.nsg13_hv_pmos[w]
print @n.xbgr.xm51.nsg13_hv_pmos[l]
print @n.xbgr.xm51.nsg13_hv_pmos[delvto]
print @n.xbgr.xm51.nsg13_hv_pmos[factuo]
print @n.xbgr.xm52.nsg13_hv_pmos[w]
print @n.xbgr.xm52.nsg13_hv_pmos[l]
print @n.xbgr.xm52.nsg13_hv_pmos[delvto]
print @n.xbgr.xm52.nsg13_hv_pmos[factuo]
print @n.xbgr.xm53.nsg13_hv_pmos[w]
print @n.xbgr.xm53.nsg13_hv_pmos[l]
print @n.xbgr.xm53.nsg13_hv_pmos[delvto]
print @n.xbgr.xm53.nsg13_hv_pmos[factuo]
print @n.xbgr.xm54.nsg13_hv_pmos[w]
print @n.xbgr.xm54.nsg13_hv_pmos[l]
print @n.xbgr.xm54.nsg13_hv_pmos[delvto]
print @n.xbgr.xm54.nsg13_hv_pmos[factuo]
print @q.xbgr.xq55.qnpn13g2[area]
print @q.xbgr.xq56.qnpn13g2[area]
print @q.xbgr.xq57.qnpn13g2[area]
print @q.xbgr.xq58.qnpn13g2[area]
print @q.xbgr.xq59.qnpn13g2[area]
print @q.xbgr.xq60.qnpn13g2[area]
print @q.xbgr.xq61.qnpn13g2[area]
print @q.xbgr.xq62.qnpn13g2[area]
print @q.xbgr.xq63.qnpn13g2[area]
print @q.xbgr.xq64.qnpn13g2[area]
print @q.xbgr.xq65.qnpn13g2[area]
print @q.xbgr.xq66.qnpn13g2[area]
print @q.xbgr.xq67.qnpn13g2[area]
print @q.xbgr.xq68.qnpn13g2[area]
print @q.xbgr.xq69.qnpn13g2[area]
print @q.xbgr.xq70.qnpn13g2[area]
print @q.xbgr.xq71.qnpn13g2[area]
print @q.xbgr.xq72.qnpn13g2[area]
print @q.xbgr.xq73.qnpn13g2[area]
print @q.xbgr.xq74.qnpn13g2[area]
print @q.xbgr.xq75.qnpn13g2[area]
print @q.xbgr.xq76.qnpn13g2[area]
print @n.xbgr.xr77.nr1[nsmm_rsh]
print @n.xbgr.xr77.nr1[nsmm_w]
print @n.xbgr.xr77.nr1[nsmm_l]
print @n.xbgr.xr78.nr1[nsmm_rsh]
print @n.xbgr.xr78.nr1[nsmm_w]
print @n.xbgr.xr78.nr1[nsmm_l]
print @n.xbgr.xr79.nr1[nsmm_rsh]
print @n.xbgr.xr79.nr1[nsmm_w]
print @n.xbgr.xr79.nr1[nsmm_l]
print @n.xbgr.xr80.nr1[nsmm_rsh]
print @n.xbgr.xr80.nr1[nsmm_w]
print @n.xbgr.xr80.nr1[nsmm_l]
print @n.xbgr.xr81.nr1[nsmm_rsh]
print @n.xbgr.xr81.nr1[nsmm_w]
print @n.xbgr.xr81.nr1[nsmm_l]
print @n.xbgr.xr82.nr1[nsmm_rsh]
print @n.xbgr.xr82.nr1[nsmm_w]
print @n.xbgr.xr82.nr1[nsmm_l]
print @n.xbgr.xr83.nr1[nsmm_rsh]
print @n.xbgr.xr83.nr1[nsmm_w]
print @n.xbgr.xr83.nr1[nsmm_l]
print @n.xbgr.xr84.nr1[nsmm_rsh]
print @n.xbgr.xr84.nr1[nsmm_w]
print @n.xbgr.xr84.nr1[nsmm_l]
print @n.xbgr.xr85.nr1[nsmm_rsh]
print @n.xbgr.xr85.nr1[nsmm_w]
print @n.xbgr.xr85.nr1[nsmm_l]
print @n.xbgr.xr86.nr1[nsmm_rsh]
print @n.xbgr.xr86.nr1[nsmm_w]
print @n.xbgr.xr86.nr1[nsmm_l]
print @n.xt2f.xm1.nsg13_hv_nmos[w]
print @n.xt2f.xm1.nsg13_hv_nmos[l]
print @n.xt2f.xm1.nsg13_hv_nmos[delvto]
print @n.xt2f.xm1.nsg13_hv_nmos[factuo]
print @n.xt2f.xm2.nsg13_hv_nmos[w]
print @n.xt2f.xm2.nsg13_hv_nmos[l]
print @n.xt2f.xm2.nsg13_hv_nmos[delvto]
print @n.xt2f.xm2.nsg13_hv_nmos[factuo]
print @n.xt2f.xr3.nr1[nsmm_rsh]
print @n.xt2f.xr3.nr1[nsmm_w]
print @n.xt2f.xr3.nr1[nsmm_l]
print @n.xt2f.xr4.nr1[nsmm_rsh]
print @n.xt2f.xr4.nr1[nsmm_w]
print @n.xt2f.xr4.nr1[nsmm_l]
print @n.xt2f.xr5.nr1[nsmm_rsh]
print @n.xt2f.xr5.nr1[nsmm_w]
print @n.xt2f.xr5.nr1[nsmm_l]
print @n.xt2f.xr6.nr1[nsmm_rsh]
print @n.xt2f.xr6.nr1[nsmm_w]
print @n.xt2f.xr6.nr1[nsmm_l]
print @n.xt2f.xr7.nr1[nsmm_rsh]
print @n.xt2f.xr7.nr1[nsmm_w]
print @n.xt2f.xr7.nr1[nsmm_l]
print @n.xt2f.xr8.nr1[nsmm_rsh]
print @n.xt2f.xr8.nr1[nsmm_w]
print @n.xt2f.xr8.nr1[nsmm_l]
print @n.xt2f.xr9.nr1[nsmm_rsh]
print @n.xt2f.xr9.nr1[nsmm_w]
print @n.xt2f.xr9.nr1[nsmm_l]
print @n.xt2f.xr10.nr1[nsmm_rsh]
print @n.xt2f.xr10.nr1[nsmm_w]
print @n.xt2f.xr10.nr1[nsmm_l]
print @n.xt2f.xr11.nr1[nsmm_rsh]
print @n.xt2f.xr11.nr1[nsmm_w]
print @n.xt2f.xr11.nr1[nsmm_l]
print @n.xt2f.xr12.nr1[nsmm_rsh]
print @n.xt2f.xr12.nr1[nsmm_w]
print @n.xt2f.xr12.nr1[nsmm_l]
print @n.xt2f.xm13.nsg13_hv_nmos[w]
print @n.xt2f.xm13.nsg13_hv_nmos[l]
print @n.xt2f.xm13.nsg13_hv_nmos[delvto]
print @n.xt2f.xm13.nsg13_hv_nmos[factuo]
print @n.xt2f.xm14.nsg13_hv_nmos[w]
print @n.xt2f.xm14.nsg13_hv_nmos[l]
print @n.xt2f.xm14.nsg13_hv_nmos[delvto]
print @n.xt2f.xm14.nsg13_hv_nmos[factuo]
print @n.xt2f.xm15.nsg13_lv_pmos[w]
print @n.xt2f.xm15.nsg13_lv_pmos[l]
print @n.xt2f.xm15.nsg13_lv_pmos[delvto]
print @n.xt2f.xm15.nsg13_lv_pmos[factuo]
print @n.xt2f.xm16.nsg13_lv_nmos[w]
print @n.xt2f.xm16.nsg13_lv_nmos[l]
print @n.xt2f.xm16.nsg13_lv_nmos[delvto]
print @n.xt2f.xm16.nsg13_lv_nmos[factuo]
print @n.xt2f.xm17.nsg13_lv_nmos[w]
print @n.xt2f.xm17.nsg13_lv_nmos[l]
print @n.xt2f.xm17.nsg13_lv_nmos[delvto]
print @n.xt2f.xm17.nsg13_lv_nmos[factuo]
print @n.xt2f.xm18.nsg13_lv_pmos[w]
print @n.xt2f.xm18.nsg13_lv_pmos[l]
print @n.xt2f.xm18.nsg13_lv_pmos[delvto]
print @n.xt2f.xm18.nsg13_lv_pmos[factuo]
print @n.xt2f.xm19.nsg13_lv_pmos[w]
print @n.xt2f.xm19.nsg13_lv_pmos[l]
print @n.xt2f.xm19.nsg13_lv_pmos[delvto]
print @n.xt2f.xm19.nsg13_lv_pmos[factuo]
print @n.xt2f.xm20.nsg13_hv_pmos[w]
print @n.xt2f.xm20.nsg13_hv_pmos[l]
print @n.xt2f.xm20.nsg13_hv_pmos[delvto]
print @n.xt2f.xm20.nsg13_hv_pmos[factuo]
print @n.xt2f.xm21.nsg13_hv_pmos[w]
print @n.xt2f.xm21.nsg13_hv_pmos[l]
print @n.xt2f.xm21.nsg13_hv_pmos[delvto]
print @n.xt2f.xm21.nsg13_hv_pmos[factuo]
print @n.xt2f.xm22.nsg13_hv_pmos[w]
print @n.xt2f.xm22.nsg13_hv_pmos[l]
print @n.xt2f.xm22.nsg13_hv_pmos[delvto]
print @n.xt2f.xm22.nsg13_hv_pmos[factuo]
print @n.xt2f.xm23.nsg13_hv_nmos[w]
print @n.xt2f.xm23.nsg13_hv_nmos[l]
print @n.xt2f.xm23.nsg13_hv_nmos[delvto]
print @n.xt2f.xm23.nsg13_hv_nmos[factuo]
print @n.xt2f.xm24.nsg13_hv_nmos[w]
print @n.xt2f.xm24.nsg13_hv_nmos[l]
print @n.xt2f.xm24.nsg13_hv_nmos[delvto]
print @n.xt2f.xm24.nsg13_hv_nmos[factuo]
print @n.xt2f.xm25.nsg13_hv_nmos[w]
print @n.xt2f.xm25.nsg13_hv_nmos[l]
print @n.xt2f.xm25.nsg13_hv_nmos[delvto]
print @n.xt2f.xm25.nsg13_hv_nmos[factuo]
print @n.xt2f.xm26.nsg13_hv_pmos[w]
print @n.xt2f.xm26.nsg13_hv_pmos[l]
print @n.xt2f.xm26.nsg13_hv_pmos[delvto]
print @n.xt2f.xm26.nsg13_hv_pmos[factuo]
print @n.xt2f.xm27.nsg13_hv_pmos[w]
print @n.xt2f.xm27.nsg13_hv_pmos[l]
print @n.xt2f.xm27.nsg13_hv_pmos[delvto]
print @n.xt2f.xm27.nsg13_hv_pmos[factuo]
print @n.xt2f.xm28.nsg13_hv_pmos[w]
print @n.xt2f.xm28.nsg13_hv_pmos[l]
print @n.xt2f.xm28.nsg13_hv_pmos[delvto]
print @n.xt2f.xm28.nsg13_hv_pmos[factuo]
print @n.xt2f.xm29.nsg13_hv_pmos[w]
print @n.xt2f.xm29.nsg13_hv_pmos[l]
print @n.xt2f.xm29.nsg13_hv_pmos[delvto]
print @n.xt2f.xm29.nsg13_hv_pmos[factuo]
print @n.xt2f.xm30.nsg13_hv_pmos[w]
print @n.xt2f.xm30.nsg13_hv_pmos[l]
print @n.xt2f.xm30.nsg13_hv_pmos[delvto]
print @n.xt2f.xm30.nsg13_hv_pmos[factuo]
print @n.xt2f.xm31.nsg13_hv_pmos[w]
print @n.xt2f.xm31.nsg13_hv_pmos[l]
print @n.xt2f.xm31.nsg13_hv_pmos[delvto]
print @n.xt2f.xm31.nsg13_hv_pmos[factuo]
print @n.xt2f.xm32.nsg13_hv_pmos[w]
print @n.xt2f.xm32.nsg13_hv_pmos[l]
print @n.xt2f.xm32.nsg13_hv_pmos[delvto]
print @n.xt2f.xm32.nsg13_hv_pmos[factuo]
print @n.xt2f.xm33.nsg13_hv_pmos[w]
print @n.xt2f.xm33.nsg13_hv_pmos[l]
print @n.xt2f.xm33.nsg13_hv_pmos[delvto]
print @n.xt2f.xm33.nsg13_hv_pmos[factuo]
print @n.xt2f.xm34.nsg13_hv_pmos[w]
print @n.xt2f.xm34.nsg13_hv_pmos[l]
print @n.xt2f.xm34.nsg13_hv_pmos[delvto]
print @n.xt2f.xm34.nsg13_hv_pmos[factuo]
print @n.xt2f.xm35.nsg13_hv_pmos[w]
print @n.xt2f.xm35.nsg13_hv_pmos[l]
print @n.xt2f.xm35.nsg13_hv_pmos[delvto]
print @n.xt2f.xm35.nsg13_hv_pmos[factuo]
print @n.xt2f.xm36.nsg13_hv_nmos[w]
print @n.xt2f.xm36.nsg13_hv_nmos[l]
print @n.xt2f.xm36.nsg13_hv_nmos[delvto]
print @n.xt2f.xm36.nsg13_hv_nmos[factuo]
print @n.xt2f.xm37.nsg13_hv_nmos[w]
print @n.xt2f.xm37.nsg13_hv_nmos[l]
print @n.xt2f.xm37.nsg13_hv_nmos[delvto]
print @n.xt2f.xm37.nsg13_hv_nmos[factuo]
print @n.xt2f.xm38.nsg13_hv_nmos[w]
print @n.xt2f.xm38.nsg13_hv_nmos[l]
print @n.xt2f.xm38.nsg13_hv_nmos[delvto]
print @n.xt2f.xm38.nsg13_hv_nmos[factuo]
print @n.xt2f.xm39.nsg13_hv_nmos[w]
print @n.xt2f.xm39.nsg13_hv_nmos[l]
print @n.xt2f.xm39.nsg13_hv_nmos[delvto]
print @n.xt2f.xm39.nsg13_hv_nmos[factuo]
print @q.xt2f.xq40.qnpn13g2[area]
print @q.xt2f.xq41.qnpn13g2[area]
print @q.xt2f.xq42.qnpn13g2[area]
print @q.xt2f.xq43.qnpn13g2[area]
print @q.xt2f.xq44.qnpn13g2[area]
print @q.xt2f.xq45.qnpn13g2[area]
print @n.xt2f.xm46.nsg13_hv_pmos[w]
print @n.xt2f.xm46.nsg13_hv_pmos[l]
print @n.xt2f.xm46.nsg13_hv_pmos[delvto]
print @n.xt2f.xm46.nsg13_hv_pmos[factuo]
print @n.xt2f.xm47.nsg13_hv_pmos[w]
print @n.xt2f.xm47.nsg13_hv_pmos[l]
print @n.xt2f.xm47.nsg13_hv_pmos[delvto]
print @n.xt2f.xm47.nsg13_hv_pmos[factuo]
print @n.xt2f.xm48.nsg13_hv_pmos[w]
print @n.xt2f.xm48.nsg13_hv_pmos[l]
print @n.xt2f.xm48.nsg13_hv_pmos[delvto]
print @n.xt2f.xm48.nsg13_hv_pmos[factuo]
print @n.xt2f.xm49.nsg13_hv_pmos[w]
print @n.xt2f.xm49.nsg13_hv_pmos[l]
print @n.xt2f.xm49.nsg13_hv_pmos[delvto]
print @n.xt2f.xm49.nsg13_hv_pmos[factuo]
print @n.xt2f.xm50.nsg13_hv_nmos[w]
print @n.xt2f.xm50.nsg13_hv_nmos[l]
print @n.xt2f.xm50.nsg13_hv_nmos[delvto]
print @n.xt2f.xm50.nsg13_hv_nmos[factuo]
print @n.xt2f.xm51.nsg13_hv_nmos[w]
print @n.xt2f.xm51.nsg13_hv_nmos[l]
print @n.xt2f.xm51.nsg13_hv_nmos[delvto]
print @n.xt2f.xm51.nsg13_hv_nmos[factuo]
print @n.xt2f.xm52.nsg13_hv_nmos[w]
print @n.xt2f.xm52.nsg13_hv_nmos[l]
print @n.xt2f.xm52.nsg13_hv_nmos[delvto]
print @n.xt2f.xm52.nsg13_hv_nmos[factuo]
print @n.xt2f.xm53.nsg13_hv_nmos[w]
print @n.xt2f.xm53.nsg13_hv_nmos[l]
print @n.xt2f.xm53.nsg13_hv_nmos[delvto]
print @n.xt2f.xm53.nsg13_hv_nmos[factuo]
print @n.xt2f.xm54.nsg13_hv_nmos[w]
print @n.xt2f.xm54.nsg13_hv_nmos[l]
print @n.xt2f.xm54.nsg13_hv_nmos[delvto]
print @n.xt2f.xm54.nsg13_hv_nmos[factuo]
print @n.xt2f.xm55.nsg13_hv_nmos[w]
print @n.xt2f.xm55.nsg13_hv_nmos[l]
print @n.xt2f.xm55.nsg13_hv_nmos[delvto]
print @n.xt2f.xm55.nsg13_hv_nmos[factuo]
print @n.xt2f.xm56.nsg13_hv_nmos[w]
print @n.xt2f.xm56.nsg13_hv_nmos[l]
print @n.xt2f.xm56.nsg13_hv_nmos[delvto]
print @n.xt2f.xm56.nsg13_hv_nmos[factuo]
print @n.xt2f.xm57.nsg13_hv_nmos[w]
print @n.xt2f.xm57.nsg13_hv_nmos[l]
print @n.xt2f.xm57.nsg13_hv_nmos[delvto]
print @n.xt2f.xm57.nsg13_hv_nmos[factuo]
print @n.xt2f.xm58.nsg13_hv_nmos[w]
print @n.xt2f.xm58.nsg13_hv_nmos[l]
print @n.xt2f.xm58.nsg13_hv_nmos[delvto]
print @n.xt2f.xm58.nsg13_hv_nmos[factuo]
print @n.xt2f.xm59.nsg13_hv_nmos[w]
print @n.xt2f.xm59.nsg13_hv_nmos[l]
print @n.xt2f.xm59.nsg13_hv_nmos[delvto]
print @n.xt2f.xm59.nsg13_hv_nmos[factuo]
print @n.xt2f.xm60.nsg13_hv_nmos[w]
print @n.xt2f.xm60.nsg13_hv_nmos[l]
print @n.xt2f.xm60.nsg13_hv_nmos[delvto]
print @n.xt2f.xm60.nsg13_hv_nmos[factuo]
print @n.xt2f.xm61.nsg13_hv_nmos[w]
print @n.xt2f.xm61.nsg13_hv_nmos[l]
print @n.xt2f.xm61.nsg13_hv_nmos[delvto]
print @n.xt2f.xm61.nsg13_hv_nmos[factuo]
print @n.xt2f.xm62.nsg13_hv_nmos[w]
print @n.xt2f.xm62.nsg13_hv_nmos[l]
print @n.xt2f.xm62.nsg13_hv_nmos[delvto]
print @n.xt2f.xm62.nsg13_hv_nmos[factuo]
print @n.xt2f.xm63.nsg13_hv_nmos[w]
print @n.xt2f.xm63.nsg13_hv_nmos[l]
print @n.xt2f.xm63.nsg13_hv_nmos[delvto]
print @n.xt2f.xm63.nsg13_hv_nmos[factuo]
print @n.xt2f.xm64.nsg13_hv_nmos[w]
print @n.xt2f.xm64.nsg13_hv_nmos[l]
print @n.xt2f.xm64.nsg13_hv_nmos[delvto]
print @n.xt2f.xm64.nsg13_hv_nmos[factuo]
print @n.xt2f.xm65.nsg13_hv_nmos[w]
print @n.xt2f.xm65.nsg13_hv_nmos[l]
print @n.xt2f.xm65.nsg13_hv_nmos[delvto]
print @n.xt2f.xm65.nsg13_hv_nmos[factuo]
print @n.xt2f.xm66.nsg13_hv_nmos[w]
print @n.xt2f.xm66.nsg13_hv_nmos[l]
print @n.xt2f.xm66.nsg13_hv_nmos[delvto]
print @n.xt2f.xm66.nsg13_hv_nmos[factuo]
print @n.xt2f.xm67.nsg13_hv_nmos[w]
print @n.xt2f.xm67.nsg13_hv_nmos[l]
print @n.xt2f.xm67.nsg13_hv_nmos[delvto]
print @n.xt2f.xm67.nsg13_hv_nmos[factuo]
print @n.xt2f.xm68.nsg13_hv_nmos[w]
print @n.xt2f.xm68.nsg13_hv_nmos[l]
print @n.xt2f.xm68.nsg13_hv_nmos[delvto]
print @n.xt2f.xm68.nsg13_hv_nmos[factuo]
print @n.xt2f.xm69.nsg13_hv_nmos[w]
print @n.xt2f.xm69.nsg13_hv_nmos[l]
print @n.xt2f.xm69.nsg13_hv_nmos[delvto]
print @n.xt2f.xm69.nsg13_hv_nmos[factuo]
print @n.xt2f.xm70.nsg13_hv_nmos[w]
print @n.xt2f.xm70.nsg13_hv_nmos[l]
print @n.xt2f.xm70.nsg13_hv_nmos[delvto]
print @n.xt2f.xm70.nsg13_hv_nmos[factuo]
print @n.xt2f.xm71.nsg13_hv_nmos[w]
print @n.xt2f.xm71.nsg13_hv_nmos[l]
print @n.xt2f.xm71.nsg13_hv_nmos[delvto]
print @n.xt2f.xm71.nsg13_hv_nmos[factuo]
print @n.xt2f.xm72.nsg13_hv_nmos[w]
print @n.xt2f.xm72.nsg13_hv_nmos[l]
print @n.xt2f.xm72.nsg13_hv_nmos[delvto]
print @n.xt2f.xm72.nsg13_hv_nmos[factuo]
print @n.xt2f.xm73.nsg13_hv_nmos[w]
print @n.xt2f.xm73.nsg13_hv_nmos[l]
print @n.xt2f.xm73.nsg13_hv_nmos[delvto]
print @n.xt2f.xm73.nsg13_hv_nmos[factuo]
print @n.xt2f.xm74.nsg13_hv_nmos[w]
print @n.xt2f.xm74.nsg13_hv_nmos[l]
print @n.xt2f.xm74.nsg13_hv_nmos[delvto]
print @n.xt2f.xm74.nsg13_hv_nmos[factuo]
print @n.xt2f.xm75.nsg13_hv_nmos[w]
print @n.xt2f.xm75.nsg13_hv_nmos[l]
print @n.xt2f.xm75.nsg13_hv_nmos[delvto]
print @n.xt2f.xm75.nsg13_hv_nmos[factuo]
print @n.xt2f.xm76.nsg13_hv_nmos[w]
print @n.xt2f.xm76.nsg13_hv_nmos[l]
print @n.xt2f.xm76.nsg13_hv_nmos[delvto]
print @n.xt2f.xm76.nsg13_hv_nmos[factuo]
print @n.xt2f.xm77.nsg13_hv_pmos[w]
print @n.xt2f.xm77.nsg13_hv_pmos[l]
print @n.xt2f.xm77.nsg13_hv_pmos[delvto]
print @n.xt2f.xm77.nsg13_hv_pmos[factuo]
print @n.xt2f.xm78.nsg13_hv_pmos[w]
print @n.xt2f.xm78.nsg13_hv_pmos[l]
print @n.xt2f.xm78.nsg13_hv_pmos[delvto]
print @n.xt2f.xm78.nsg13_hv_pmos[factuo]
print @n.xt2f.xm79.nsg13_hv_pmos[w]
print @n.xt2f.xm79.nsg13_hv_pmos[l]
print @n.xt2f.xm79.nsg13_hv_pmos[delvto]
print @n.xt2f.xm79.nsg13_hv_pmos[factuo]
print @n.xt2f.xm80.nsg13_hv_pmos[w]
print @n.xt2f.xm80.nsg13_hv_pmos[l]
print @n.xt2f.xm80.nsg13_hv_pmos[delvto]
print @n.xt2f.xm80.nsg13_hv_pmos[factuo]
print @n.xt2f.xm81.nsg13_hv_pmos[w]
print @n.xt2f.xm81.nsg13_hv_pmos[l]
print @n.xt2f.xm81.nsg13_hv_pmos[delvto]
print @n.xt2f.xm81.nsg13_hv_pmos[factuo]
print @n.xt2f.xm82.nsg13_hv_pmos[w]
print @n.xt2f.xm82.nsg13_hv_pmos[l]
print @n.xt2f.xm82.nsg13_hv_pmos[delvto]
print @n.xt2f.xm82.nsg13_hv_pmos[factuo]
print @n.xt2f.xm83.nsg13_hv_pmos[w]
print @n.xt2f.xm83.nsg13_hv_pmos[l]
print @n.xt2f.xm83.nsg13_hv_pmos[delvto]
print @n.xt2f.xm83.nsg13_hv_pmos[factuo]
print @n.xt2f.xm84.nsg13_hv_pmos[w]
print @n.xt2f.xm84.nsg13_hv_pmos[l]
print @n.xt2f.xm84.nsg13_hv_pmos[delvto]
print @n.xt2f.xm84.nsg13_hv_pmos[factuo]
print @n.xt2f.xm85.nsg13_hv_pmos[w]
print @n.xt2f.xm85.nsg13_hv_pmos[l]
print @n.xt2f.xm85.nsg13_hv_pmos[delvto]
print @n.xt2f.xm85.nsg13_hv_pmos[factuo]
print @n.xt2f.xm86.nsg13_hv_pmos[w]
print @n.xt2f.xm86.nsg13_hv_pmos[l]
print @n.xt2f.xm86.nsg13_hv_pmos[delvto]
print @n.xt2f.xm86.nsg13_hv_pmos[factuo]
print @n.xt2f.xm87.nsg13_hv_pmos[w]
print @n.xt2f.xm87.nsg13_hv_pmos[l]
print @n.xt2f.xm87.nsg13_hv_pmos[delvto]
print @n.xt2f.xm87.nsg13_hv_pmos[factuo]
print @n.xt2f.xm88.nsg13_hv_pmos[w]
print @n.xt2f.xm88.nsg13_hv_pmos[l]
print @n.xt2f.xm88.nsg13_hv_pmos[delvto]
print @n.xt2f.xm88.nsg13_hv_pmos[factuo]
print @n.xt2f.xm89.nsg13_hv_pmos[w]
print @n.xt2f.xm89.nsg13_hv_pmos[l]
print @n.xt2f.xm89.nsg13_hv_pmos[delvto]
print @n.xt2f.xm89.nsg13_hv_pmos[factuo]
print @n.xt2f.xm90.nsg13_hv_pmos[w]
print @n.xt2f.xm90.nsg13_hv_pmos[l]
print @n.xt2f.xm90.nsg13_hv_pmos[delvto]
print @n.xt2f.xm90.nsg13_hv_pmos[factuo]
print @n.xt2f.xm91.nsg13_lv_pmos[w]
print @n.xt2f.xm91.nsg13_lv_pmos[l]
print @n.xt2f.xm91.nsg13_lv_pmos[delvto]
print @n.xt2f.xm91.nsg13_lv_pmos[factuo]
print @c.xt2f.xc1.c1[scale]
print @c.xt2f.xc2.c1[scale]
tran 5n 32u
print @n.xbgr.xr1.nr1[nsmm_rsh]
print @n.xbgr.xr1.nr1[nsmm_w]
print @n.xbgr.xr1.nr1[nsmm_l]
print @n.xbgr.xr2.nr1[nsmm_rsh]
print @n.xbgr.xr2.nr1[nsmm_w]
print @n.xbgr.xr2.nr1[nsmm_l]
print @n.xbgr.xr3.nr1[nsmm_rsh]
print @n.xbgr.xr3.nr1[nsmm_w]
print @n.xbgr.xr3.nr1[nsmm_l]
print @n.xbgr.xr4.nr1[nsmm_rsh]
print @n.xbgr.xr4.nr1[nsmm_w]
print @n.xbgr.xr4.nr1[nsmm_l]
print @n.xbgr.xr5.nr1[nsmm_rsh]
print @n.xbgr.xr5.nr1[nsmm_w]
print @n.xbgr.xr5.nr1[nsmm_l]
print @n.xbgr.xr6.nr1[nsmm_rsh]
print @n.xbgr.xr6.nr1[nsmm_w]
print @n.xbgr.xr6.nr1[nsmm_l]
print @n.xbgr.xr7.nr1[nsmm_rsh]
print @n.xbgr.xr7.nr1[nsmm_w]
print @n.xbgr.xr7.nr1[nsmm_l]
print @n.xbgr.xr8.nr1[nsmm_rsh]
print @n.xbgr.xr8.nr1[nsmm_w]
print @n.xbgr.xr8.nr1[nsmm_l]
print @n.xbgr.xr9.nr1[nsmm_rsh]
print @n.xbgr.xr9.nr1[nsmm_w]
print @n.xbgr.xr9.nr1[nsmm_l]
print @n.xbgr.xr10.nr1[nsmm_rsh]
print @n.xbgr.xr10.nr1[nsmm_w]
print @n.xbgr.xr10.nr1[nsmm_l]
print @n.xbgr.xr11.nr1[nsmm_rsh]
print @n.xbgr.xr11.nr1[nsmm_w]
print @n.xbgr.xr11.nr1[nsmm_l]
print @n.xbgr.xr12.nr1[nsmm_rsh]
print @n.xbgr.xr12.nr1[nsmm_w]
print @n.xbgr.xr12.nr1[nsmm_l]
print @n.xbgr.xr13.nr1[nsmm_rsh]
print @n.xbgr.xr13.nr1[nsmm_w]
print @n.xbgr.xr13.nr1[nsmm_l]
print @n.xbgr.xr14.nr1[nsmm_rsh]
print @n.xbgr.xr14.nr1[nsmm_w]
print @n.xbgr.xr14.nr1[nsmm_l]
print @n.xbgr.xr15.nr1[nsmm_rsh]
print @n.xbgr.xr15.nr1[nsmm_w]
print @n.xbgr.xr15.nr1[nsmm_l]
print @n.xbgr.xr16.nr1[nsmm_rsh]
print @n.xbgr.xr16.nr1[nsmm_w]
print @n.xbgr.xr16.nr1[nsmm_l]
print @n.xbgr.xr17.nr1[nsmm_rsh]
print @n.xbgr.xr17.nr1[nsmm_w]
print @n.xbgr.xr17.nr1[nsmm_l]
print @n.xbgr.xr18.nr1[nsmm_rsh]
print @n.xbgr.xr18.nr1[nsmm_w]
print @n.xbgr.xr18.nr1[nsmm_l]
print @n.xbgr.xr19.nr1[nsmm_rsh]
print @n.xbgr.xr19.nr1[nsmm_w]
print @n.xbgr.xr19.nr1[nsmm_l]
print @n.xbgr.xr20.nr1[nsmm_rsh]
print @n.xbgr.xr20.nr1[nsmm_w]
print @n.xbgr.xr20.nr1[nsmm_l]
print @n.xbgr.xr21.nr1[nsmm_rsh]
print @n.xbgr.xr21.nr1[nsmm_w]
print @n.xbgr.xr21.nr1[nsmm_l]
print @n.xbgr.xr22.nr1[nsmm_rsh]
print @n.xbgr.xr22.nr1[nsmm_w]
print @n.xbgr.xr22.nr1[nsmm_l]
print @n.xbgr.xr23.nr1[nsmm_rsh]
print @n.xbgr.xr23.nr1[nsmm_w]
print @n.xbgr.xr23.nr1[nsmm_l]
print @n.xbgr.xr24.nr1[nsmm_rsh]
print @n.xbgr.xr24.nr1[nsmm_w]
print @n.xbgr.xr24.nr1[nsmm_l]
print @n.xbgr.xr25.nr1[nsmm_rsh]
print @n.xbgr.xr25.nr1[nsmm_w]
print @n.xbgr.xr25.nr1[nsmm_l]
print @n.xbgr.xr26.nr1[nsmm_rsh]
print @n.xbgr.xr26.nr1[nsmm_w]
print @n.xbgr.xr26.nr1[nsmm_l]
print @n.xbgr.xm27.nsg13_hv_pmos[w]
print @n.xbgr.xm27.nsg13_hv_pmos[l]
print @n.xbgr.xm27.nsg13_hv_pmos[delvto]
print @n.xbgr.xm27.nsg13_hv_pmos[factuo]
print @n.xbgr.xm28.nsg13_hv_pmos[w]
print @n.xbgr.xm28.nsg13_hv_pmos[l]
print @n.xbgr.xm28.nsg13_hv_pmos[delvto]
print @n.xbgr.xm28.nsg13_hv_pmos[factuo]
print @n.xbgr.xm29.nsg13_hv_nmos[w]
print @n.xbgr.xm29.nsg13_hv_nmos[l]
print @n.xbgr.xm29.nsg13_hv_nmos[delvto]
print @n.xbgr.xm29.nsg13_hv_nmos[factuo]
print @n.xbgr.xm30.nsg13_hv_nmos[w]
print @n.xbgr.xm30.nsg13_hv_nmos[l]
print @n.xbgr.xm30.nsg13_hv_nmos[delvto]
print @n.xbgr.xm30.nsg13_hv_nmos[factuo]
print @n.xbgr.xm31.nsg13_hv_nmos[w]
print @n.xbgr.xm31.nsg13_hv_nmos[l]
print @n.xbgr.xm31.nsg13_hv_nmos[delvto]
print @n.xbgr.xm31.nsg13_hv_nmos[factuo]
print @n.xbgr.xm32.nsg13_hv_nmos[w]
print @n.xbgr.xm32.nsg13_hv_nmos[l]
print @n.xbgr.xm32.nsg13_hv_nmos[delvto]
print @n.xbgr.xm32.nsg13_hv_nmos[factuo]
print @n.xbgr.xm33.nsg13_hv_nmos[w]
print @n.xbgr.xm33.nsg13_hv_nmos[l]
print @n.xbgr.xm33.nsg13_hv_nmos[delvto]
print @n.xbgr.xm33.nsg13_hv_nmos[factuo]
print @n.xbgr.xm34.nsg13_hv_nmos[w]
print @n.xbgr.xm34.nsg13_hv_nmos[l]
print @n.xbgr.xm34.nsg13_hv_nmos[delvto]
print @n.xbgr.xm34.nsg13_hv_nmos[factuo]
print @n.xbgr.xm35.nsg13_hv_nmos[w]
print @n.xbgr.xm35.nsg13_hv_nmos[l]
print @n.xbgr.xm35.nsg13_hv_nmos[delvto]
print @n.xbgr.xm35.nsg13_hv_nmos[factuo]
print @n.xbgr.xm36.nsg13_hv_nmos[w]
print @n.xbgr.xm36.nsg13_hv_nmos[l]
print @n.xbgr.xm36.nsg13_hv_nmos[delvto]
print @n.xbgr.xm36.nsg13_hv_nmos[factuo]
print @n.xbgr.xm37.nsg13_hv_nmos[w]
print @n.xbgr.xm37.nsg13_hv_nmos[l]
print @n.xbgr.xm37.nsg13_hv_nmos[delvto]
print @n.xbgr.xm37.nsg13_hv_nmos[factuo]
print @n.xbgr.xm38.nsg13_hv_pmos[w]
print @n.xbgr.xm38.nsg13_hv_pmos[l]
print @n.xbgr.xm38.nsg13_hv_pmos[delvto]
print @n.xbgr.xm38.nsg13_hv_pmos[factuo]
print @n.xbgr.xm39.nsg13_hv_pmos[w]
print @n.xbgr.xm39.nsg13_hv_pmos[l]
print @n.xbgr.xm39.nsg13_hv_pmos[delvto]
print @n.xbgr.xm39.nsg13_hv_pmos[factuo]
print @n.xbgr.xm40.nsg13_hv_pmos[w]
print @n.xbgr.xm40.nsg13_hv_pmos[l]
print @n.xbgr.xm40.nsg13_hv_pmos[delvto]
print @n.xbgr.xm40.nsg13_hv_pmos[factuo]
print @n.xbgr.xm41.nsg13_hv_pmos[w]
print @n.xbgr.xm41.nsg13_hv_pmos[l]
print @n.xbgr.xm41.nsg13_hv_pmos[delvto]
print @n.xbgr.xm41.nsg13_hv_pmos[factuo]
print @n.xbgr.xm42.nsg13_hv_pmos[w]
print @n.xbgr.xm42.nsg13_hv_pmos[l]
print @n.xbgr.xm42.nsg13_hv_pmos[delvto]
print @n.xbgr.xm42.nsg13_hv_pmos[factuo]
print @n.xbgr.xm43.nsg13_hv_pmos[w]
print @n.xbgr.xm43.nsg13_hv_pmos[l]
print @n.xbgr.xm43.nsg13_hv_pmos[delvto]
print @n.xbgr.xm43.nsg13_hv_pmos[factuo]
print @n.xbgr.xm44.nsg13_hv_pmos[w]
print @n.xbgr.xm44.nsg13_hv_pmos[l]
print @n.xbgr.xm44.nsg13_hv_pmos[delvto]
print @n.xbgr.xm44.nsg13_hv_pmos[factuo]
print @n.xbgr.xm45.nsg13_hv_pmos[w]
print @n.xbgr.xm45.nsg13_hv_pmos[l]
print @n.xbgr.xm45.nsg13_hv_pmos[delvto]
print @n.xbgr.xm45.nsg13_hv_pmos[factuo]
print @n.xbgr.xm46.nsg13_hv_pmos[w]
print @n.xbgr.xm46.nsg13_hv_pmos[l]
print @n.xbgr.xm46.nsg13_hv_pmos[delvto]
print @n.xbgr.xm46.nsg13_hv_pmos[factuo]
print @n.xbgr.xm47.nsg13_hv_pmos[w]
print @n.xbgr.xm47.nsg13_hv_pmos[l]
print @n.xbgr.xm47.nsg13_hv_pmos[delvto]
print @n.xbgr.xm47.nsg13_hv_pmos[factuo]
print @n.xbgr.xm48.nsg13_hv_pmos[w]
print @n.xbgr.xm48.nsg13_hv_pmos[l]
print @n.xbgr.xm48.nsg13_hv_pmos[delvto]
print @n.xbgr.xm48.nsg13_hv_pmos[factuo]
print @n.xbgr.xm49.nsg13_hv_pmos[w]
print @n.xbgr.xm49.nsg13_hv_pmos[l]
print @n.xbgr.xm49.nsg13_hv_pmos[delvto]
print @n.xbgr.xm49.nsg13_hv_pmos[factuo]
print @n.xbgr.xm50.nsg13_hv_pmos[w]
print @n.xbgr.xm50.nsg13_hv_pmos[l]
print @n.xbgr.xm50.nsg13_hv_pmos[delvto]
print @n.xbgr.xm50.nsg13_hv_pmos[factuo]
print @n.xbgr.xm51.nsg13_hv_pmos[w]
print @n.xbgr.xm51.nsg13_hv_pmos[l]
print @n.xbgr.xm51.nsg13_hv_pmos[delvto]
print @n.xbgr.xm51.nsg13_hv_pmos[factuo]
print @n.xbgr.xm52.nsg13_hv_pmos[w]
print @n.xbgr.xm52.nsg13_hv_pmos[l]
print @n.xbgr.xm52.nsg13_hv_pmos[delvto]
print @n.xbgr.xm52.nsg13_hv_pmos[factuo]
print @n.xbgr.xm53.nsg13_hv_pmos[w]
print @n.xbgr.xm53.nsg13_hv_pmos[l]
print @n.xbgr.xm53.nsg13_hv_pmos[delvto]
print @n.xbgr.xm53.nsg13_hv_pmos[factuo]
print @n.xbgr.xm54.nsg13_hv_pmos[w]
print @n.xbgr.xm54.nsg13_hv_pmos[l]
print @n.xbgr.xm54.nsg13_hv_pmos[delvto]
print @n.xbgr.xm54.nsg13_hv_pmos[factuo]
print @q.xbgr.xq55.qnpn13g2[area]
print @q.xbgr.xq56.qnpn13g2[area]
print @q.xbgr.xq57.qnpn13g2[area]
print @q.xbgr.xq58.qnpn13g2[area]
print @q.xbgr.xq59.qnpn13g2[area]
print @q.xbgr.xq60.qnpn13g2[area]
print @q.xbgr.xq61.qnpn13g2[area]
print @q.xbgr.xq62.qnpn13g2[area]
print @q.xbgr.xq63.qnpn13g2[area]
print @q.xbgr.xq64.qnpn13g2[area]
print @q.xbgr.xq65.qnpn13g2[area]
print @q.xbgr.xq66.qnpn13g2[area]
print @q.xbgr.xq67.qnpn13g2[area]
print @q.xbgr.xq68.qnpn13g2[area]
print @q.xbgr.xq69.qnpn13g2[area]
print @q.xbgr.xq70.qnpn13g2[area]
print @q.xbgr.xq71.qnpn13g2[area]
print @q.xbgr.xq72.qnpn13g2[area]
print @q.xbgr.xq73.qnpn13g2[area]
print @q.xbgr.xq74.qnpn13g2[area]
print @q.xbgr.xq75.qnpn13g2[area]
print @q.xbgr.xq76.qnpn13g2[area]
print @n.xbgr.xr77.nr1[nsmm_rsh]
print @n.xbgr.xr77.nr1[nsmm_w]
print @n.xbgr.xr77.nr1[nsmm_l]
print @n.xbgr.xr78.nr1[nsmm_rsh]
print @n.xbgr.xr78.nr1[nsmm_w]
print @n.xbgr.xr78.nr1[nsmm_l]
print @n.xbgr.xr79.nr1[nsmm_rsh]
print @n.xbgr.xr79.nr1[nsmm_w]
print @n.xbgr.xr79.nr1[nsmm_l]
print @n.xbgr.xr80.nr1[nsmm_rsh]
print @n.xbgr.xr80.nr1[nsmm_w]
print @n.xbgr.xr80.nr1[nsmm_l]
print @n.xbgr.xr81.nr1[nsmm_rsh]
print @n.xbgr.xr81.nr1[nsmm_w]
print @n.xbgr.xr81.nr1[nsmm_l]
print @n.xbgr.xr82.nr1[nsmm_rsh]
print @n.xbgr.xr82.nr1[nsmm_w]
print @n.xbgr.xr82.nr1[nsmm_l]
print @n.xbgr.xr83.nr1[nsmm_rsh]
print @n.xbgr.xr83.nr1[nsmm_w]
print @n.xbgr.xr83.nr1[nsmm_l]
print @n.xbgr.xr84.nr1[nsmm_rsh]
print @n.xbgr.xr84.nr1[nsmm_w]
print @n.xbgr.xr84.nr1[nsmm_l]
print @n.xbgr.xr85.nr1[nsmm_rsh]
print @n.xbgr.xr85.nr1[nsmm_w]
print @n.xbgr.xr85.nr1[nsmm_l]
print @n.xbgr.xr86.nr1[nsmm_rsh]
print @n.xbgr.xr86.nr1[nsmm_w]
print @n.xbgr.xr86.nr1[nsmm_l]
print @n.xt2f.xm1.nsg13_hv_nmos[w]
print @n.xt2f.xm1.nsg13_hv_nmos[l]
print @n.xt2f.xm1.nsg13_hv_nmos[delvto]
print @n.xt2f.xm1.nsg13_hv_nmos[factuo]
print @n.xt2f.xm2.nsg13_hv_nmos[w]
print @n.xt2f.xm2.nsg13_hv_nmos[l]
print @n.xt2f.xm2.nsg13_hv_nmos[delvto]
print @n.xt2f.xm2.nsg13_hv_nmos[factuo]
print @n.xt2f.xr3.nr1[nsmm_rsh]
print @n.xt2f.xr3.nr1[nsmm_w]
print @n.xt2f.xr3.nr1[nsmm_l]
print @n.xt2f.xr4.nr1[nsmm_rsh]
print @n.xt2f.xr4.nr1[nsmm_w]
print @n.xt2f.xr4.nr1[nsmm_l]
print @n.xt2f.xr5.nr1[nsmm_rsh]
print @n.xt2f.xr5.nr1[nsmm_w]
print @n.xt2f.xr5.nr1[nsmm_l]
print @n.xt2f.xr6.nr1[nsmm_rsh]
print @n.xt2f.xr6.nr1[nsmm_w]
print @n.xt2f.xr6.nr1[nsmm_l]
print @n.xt2f.xr7.nr1[nsmm_rsh]
print @n.xt2f.xr7.nr1[nsmm_w]
print @n.xt2f.xr7.nr1[nsmm_l]
print @n.xt2f.xr8.nr1[nsmm_rsh]
print @n.xt2f.xr8.nr1[nsmm_w]
print @n.xt2f.xr8.nr1[nsmm_l]
print @n.xt2f.xr9.nr1[nsmm_rsh]
print @n.xt2f.xr9.nr1[nsmm_w]
print @n.xt2f.xr9.nr1[nsmm_l]
print @n.xt2f.xr10.nr1[nsmm_rsh]
print @n.xt2f.xr10.nr1[nsmm_w]
print @n.xt2f.xr10.nr1[nsmm_l]
print @n.xt2f.xr11.nr1[nsmm_rsh]
print @n.xt2f.xr11.nr1[nsmm_w]
print @n.xt2f.xr11.nr1[nsmm_l]
print @n.xt2f.xr12.nr1[nsmm_rsh]
print @n.xt2f.xr12.nr1[nsmm_w]
print @n.xt2f.xr12.nr1[nsmm_l]
print @n.xt2f.xm13.nsg13_hv_nmos[w]
print @n.xt2f.xm13.nsg13_hv_nmos[l]
print @n.xt2f.xm13.nsg13_hv_nmos[delvto]
print @n.xt2f.xm13.nsg13_hv_nmos[factuo]
print @n.xt2f.xm14.nsg13_hv_nmos[w]
print @n.xt2f.xm14.nsg13_hv_nmos[l]
print @n.xt2f.xm14.nsg13_hv_nmos[delvto]
print @n.xt2f.xm14.nsg13_hv_nmos[factuo]
print @n.xt2f.xm15.nsg13_lv_pmos[w]
print @n.xt2f.xm15.nsg13_lv_pmos[l]
print @n.xt2f.xm15.nsg13_lv_pmos[delvto]
print @n.xt2f.xm15.nsg13_lv_pmos[factuo]
print @n.xt2f.xm16.nsg13_lv_nmos[w]
print @n.xt2f.xm16.nsg13_lv_nmos[l]
print @n.xt2f.xm16.nsg13_lv_nmos[delvto]
print @n.xt2f.xm16.nsg13_lv_nmos[factuo]
print @n.xt2f.xm17.nsg13_lv_nmos[w]
print @n.xt2f.xm17.nsg13_lv_nmos[l]
print @n.xt2f.xm17.nsg13_lv_nmos[delvto]
print @n.xt2f.xm17.nsg13_lv_nmos[factuo]
print @n.xt2f.xm18.nsg13_lv_pmos[w]
print @n.xt2f.xm18.nsg13_lv_pmos[l]
print @n.xt2f.xm18.nsg13_lv_pmos[delvto]
print @n.xt2f.xm18.nsg13_lv_pmos[factuo]
print @n.xt2f.xm19.nsg13_lv_pmos[w]
print @n.xt2f.xm19.nsg13_lv_pmos[l]
print @n.xt2f.xm19.nsg13_lv_pmos[delvto]
print @n.xt2f.xm19.nsg13_lv_pmos[factuo]
print @n.xt2f.xm20.nsg13_hv_pmos[w]
print @n.xt2f.xm20.nsg13_hv_pmos[l]
print @n.xt2f.xm20.nsg13_hv_pmos[delvto]
print @n.xt2f.xm20.nsg13_hv_pmos[factuo]
print @n.xt2f.xm21.nsg13_hv_pmos[w]
print @n.xt2f.xm21.nsg13_hv_pmos[l]
print @n.xt2f.xm21.nsg13_hv_pmos[delvto]
print @n.xt2f.xm21.nsg13_hv_pmos[factuo]
print @n.xt2f.xm22.nsg13_hv_pmos[w]
print @n.xt2f.xm22.nsg13_hv_pmos[l]
print @n.xt2f.xm22.nsg13_hv_pmos[delvto]
print @n.xt2f.xm22.nsg13_hv_pmos[factuo]
print @n.xt2f.xm23.nsg13_hv_nmos[w]
print @n.xt2f.xm23.nsg13_hv_nmos[l]
print @n.xt2f.xm23.nsg13_hv_nmos[delvto]
print @n.xt2f.xm23.nsg13_hv_nmos[factuo]
print @n.xt2f.xm24.nsg13_hv_nmos[w]
print @n.xt2f.xm24.nsg13_hv_nmos[l]
print @n.xt2f.xm24.nsg13_hv_nmos[delvto]
print @n.xt2f.xm24.nsg13_hv_nmos[factuo]
print @n.xt2f.xm25.nsg13_hv_nmos[w]
print @n.xt2f.xm25.nsg13_hv_nmos[l]
print @n.xt2f.xm25.nsg13_hv_nmos[delvto]
print @n.xt2f.xm25.nsg13_hv_nmos[factuo]
print @n.xt2f.xm26.nsg13_hv_pmos[w]
print @n.xt2f.xm26.nsg13_hv_pmos[l]
print @n.xt2f.xm26.nsg13_hv_pmos[delvto]
print @n.xt2f.xm26.nsg13_hv_pmos[factuo]
print @n.xt2f.xm27.nsg13_hv_pmos[w]
print @n.xt2f.xm27.nsg13_hv_pmos[l]
print @n.xt2f.xm27.nsg13_hv_pmos[delvto]
print @n.xt2f.xm27.nsg13_hv_pmos[factuo]
print @n.xt2f.xm28.nsg13_hv_pmos[w]
print @n.xt2f.xm28.nsg13_hv_pmos[l]
print @n.xt2f.xm28.nsg13_hv_pmos[delvto]
print @n.xt2f.xm28.nsg13_hv_pmos[factuo]
print @n.xt2f.xm29.nsg13_hv_pmos[w]
print @n.xt2f.xm29.nsg13_hv_pmos[l]
print @n.xt2f.xm29.nsg13_hv_pmos[delvto]
print @n.xt2f.xm29.nsg13_hv_pmos[factuo]
print @n.xt2f.xm30.nsg13_hv_pmos[w]
print @n.xt2f.xm30.nsg13_hv_pmos[l]
print @n.xt2f.xm30.nsg13_hv_pmos[delvto]
print @n.xt2f.xm30.nsg13_hv_pmos[factuo]
print @n.xt2f.xm31.nsg13_hv_pmos[w]
print @n.xt2f.xm31.nsg13_hv_pmos[l]
print @n.xt2f.xm31.nsg13_hv_pmos[delvto]
print @n.xt2f.xm31.nsg13_hv_pmos[factuo]
print @n.xt2f.xm32.nsg13_hv_pmos[w]
print @n.xt2f.xm32.nsg13_hv_pmos[l]
print @n.xt2f.xm32.nsg13_hv_pmos[delvto]
print @n.xt2f.xm32.nsg13_hv_pmos[factuo]
print @n.xt2f.xm33.nsg13_hv_pmos[w]
print @n.xt2f.xm33.nsg13_hv_pmos[l]
print @n.xt2f.xm33.nsg13_hv_pmos[delvto]
print @n.xt2f.xm33.nsg13_hv_pmos[factuo]
print @n.xt2f.xm34.nsg13_hv_pmos[w]
print @n.xt2f.xm34.nsg13_hv_pmos[l]
print @n.xt2f.xm34.nsg13_hv_pmos[delvto]
print @n.xt2f.xm34.nsg13_hv_pmos[factuo]
print @n.xt2f.xm35.nsg13_hv_pmos[w]
print @n.xt2f.xm35.nsg13_hv_pmos[l]
print @n.xt2f.xm35.nsg13_hv_pmos[delvto]
print @n.xt2f.xm35.nsg13_hv_pmos[factuo]
print @n.xt2f.xm36.nsg13_hv_nmos[w]
print @n.xt2f.xm36.nsg13_hv_nmos[l]
print @n.xt2f.xm36.nsg13_hv_nmos[delvto]
print @n.xt2f.xm36.nsg13_hv_nmos[factuo]
print @n.xt2f.xm37.nsg13_hv_nmos[w]
print @n.xt2f.xm37.nsg13_hv_nmos[l]
print @n.xt2f.xm37.nsg13_hv_nmos[delvto]
print @n.xt2f.xm37.nsg13_hv_nmos[factuo]
print @n.xt2f.xm38.nsg13_hv_nmos[w]
print @n.xt2f.xm38.nsg13_hv_nmos[l]
print @n.xt2f.xm38.nsg13_hv_nmos[delvto]
print @n.xt2f.xm38.nsg13_hv_nmos[factuo]
print @n.xt2f.xm39.nsg13_hv_nmos[w]
print @n.xt2f.xm39.nsg13_hv_nmos[l]
print @n.xt2f.xm39.nsg13_hv_nmos[delvto]
print @n.xt2f.xm39.nsg13_hv_nmos[factuo]
print @q.xt2f.xq40.qnpn13g2[area]
print @q.xt2f.xq41.qnpn13g2[area]
print @q.xt2f.xq42.qnpn13g2[area]
print @q.xt2f.xq43.qnpn13g2[area]
print @q.xt2f.xq44.qnpn13g2[area]
print @q.xt2f.xq45.qnpn13g2[area]
print @n.xt2f.xm46.nsg13_hv_pmos[w]
print @n.xt2f.xm46.nsg13_hv_pmos[l]
print @n.xt2f.xm46.nsg13_hv_pmos[delvto]
print @n.xt2f.xm46.nsg13_hv_pmos[factuo]
print @n.xt2f.xm47.nsg13_hv_pmos[w]
print @n.xt2f.xm47.nsg13_hv_pmos[l]
print @n.xt2f.xm47.nsg13_hv_pmos[delvto]
print @n.xt2f.xm47.nsg13_hv_pmos[factuo]
print @n.xt2f.xm48.nsg13_hv_pmos[w]
print @n.xt2f.xm48.nsg13_hv_pmos[l]
print @n.xt2f.xm48.nsg13_hv_pmos[delvto]
print @n.xt2f.xm48.nsg13_hv_pmos[factuo]
print @n.xt2f.xm49.nsg13_hv_pmos[w]
print @n.xt2f.xm49.nsg13_hv_pmos[l]
print @n.xt2f.xm49.nsg13_hv_pmos[delvto]
print @n.xt2f.xm49.nsg13_hv_pmos[factuo]
print @n.xt2f.xm50.nsg13_hv_nmos[w]
print @n.xt2f.xm50.nsg13_hv_nmos[l]
print @n.xt2f.xm50.nsg13_hv_nmos[delvto]
print @n.xt2f.xm50.nsg13_hv_nmos[factuo]
print @n.xt2f.xm51.nsg13_hv_nmos[w]
print @n.xt2f.xm51.nsg13_hv_nmos[l]
print @n.xt2f.xm51.nsg13_hv_nmos[delvto]
print @n.xt2f.xm51.nsg13_hv_nmos[factuo]
print @n.xt2f.xm52.nsg13_hv_nmos[w]
print @n.xt2f.xm52.nsg13_hv_nmos[l]
print @n.xt2f.xm52.nsg13_hv_nmos[delvto]
print @n.xt2f.xm52.nsg13_hv_nmos[factuo]
print @n.xt2f.xm53.nsg13_hv_nmos[w]
print @n.xt2f.xm53.nsg13_hv_nmos[l]
print @n.xt2f.xm53.nsg13_hv_nmos[delvto]
print @n.xt2f.xm53.nsg13_hv_nmos[factuo]
print @n.xt2f.xm54.nsg13_hv_nmos[w]
print @n.xt2f.xm54.nsg13_hv_nmos[l]
print @n.xt2f.xm54.nsg13_hv_nmos[delvto]
print @n.xt2f.xm54.nsg13_hv_nmos[factuo]
print @n.xt2f.xm55.nsg13_hv_nmos[w]
print @n.xt2f.xm55.nsg13_hv_nmos[l]
print @n.xt2f.xm55.nsg13_hv_nmos[delvto]
print @n.xt2f.xm55.nsg13_hv_nmos[factuo]
print @n.xt2f.xm56.nsg13_hv_nmos[w]
print @n.xt2f.xm56.nsg13_hv_nmos[l]
print @n.xt2f.xm56.nsg13_hv_nmos[delvto]
print @n.xt2f.xm56.nsg13_hv_nmos[factuo]
print @n.xt2f.xm57.nsg13_hv_nmos[w]
print @n.xt2f.xm57.nsg13_hv_nmos[l]
print @n.xt2f.xm57.nsg13_hv_nmos[delvto]
print @n.xt2f.xm57.nsg13_hv_nmos[factuo]
print @n.xt2f.xm58.nsg13_hv_nmos[w]
print @n.xt2f.xm58.nsg13_hv_nmos[l]
print @n.xt2f.xm58.nsg13_hv_nmos[delvto]
print @n.xt2f.xm58.nsg13_hv_nmos[factuo]
print @n.xt2f.xm59.nsg13_hv_nmos[w]
print @n.xt2f.xm59.nsg13_hv_nmos[l]
print @n.xt2f.xm59.nsg13_hv_nmos[delvto]
print @n.xt2f.xm59.nsg13_hv_nmos[factuo]
print @n.xt2f.xm60.nsg13_hv_nmos[w]
print @n.xt2f.xm60.nsg13_hv_nmos[l]
print @n.xt2f.xm60.nsg13_hv_nmos[delvto]
print @n.xt2f.xm60.nsg13_hv_nmos[factuo]
print @n.xt2f.xm61.nsg13_hv_nmos[w]
print @n.xt2f.xm61.nsg13_hv_nmos[l]
print @n.xt2f.xm61.nsg13_hv_nmos[delvto]
print @n.xt2f.xm61.nsg13_hv_nmos[factuo]
print @n.xt2f.xm62.nsg13_hv_nmos[w]
print @n.xt2f.xm62.nsg13_hv_nmos[l]
print @n.xt2f.xm62.nsg13_hv_nmos[delvto]
print @n.xt2f.xm62.nsg13_hv_nmos[factuo]
print @n.xt2f.xm63.nsg13_hv_nmos[w]
print @n.xt2f.xm63.nsg13_hv_nmos[l]
print @n.xt2f.xm63.nsg13_hv_nmos[delvto]
print @n.xt2f.xm63.nsg13_hv_nmos[factuo]
print @n.xt2f.xm64.nsg13_hv_nmos[w]
print @n.xt2f.xm64.nsg13_hv_nmos[l]
print @n.xt2f.xm64.nsg13_hv_nmos[delvto]
print @n.xt2f.xm64.nsg13_hv_nmos[factuo]
print @n.xt2f.xm65.nsg13_hv_nmos[w]
print @n.xt2f.xm65.nsg13_hv_nmos[l]
print @n.xt2f.xm65.nsg13_hv_nmos[delvto]
print @n.xt2f.xm65.nsg13_hv_nmos[factuo]
print @n.xt2f.xm66.nsg13_hv_nmos[w]
print @n.xt2f.xm66.nsg13_hv_nmos[l]
print @n.xt2f.xm66.nsg13_hv_nmos[delvto]
print @n.xt2f.xm66.nsg13_hv_nmos[factuo]
print @n.xt2f.xm67.nsg13_hv_nmos[w]
print @n.xt2f.xm67.nsg13_hv_nmos[l]
print @n.xt2f.xm67.nsg13_hv_nmos[delvto]
print @n.xt2f.xm67.nsg13_hv_nmos[factuo]
print @n.xt2f.xm68.nsg13_hv_nmos[w]
print @n.xt2f.xm68.nsg13_hv_nmos[l]
print @n.xt2f.xm68.nsg13_hv_nmos[delvto]
print @n.xt2f.xm68.nsg13_hv_nmos[factuo]
print @n.xt2f.xm69.nsg13_hv_nmos[w]
print @n.xt2f.xm69.nsg13_hv_nmos[l]
print @n.xt2f.xm69.nsg13_hv_nmos[delvto]
print @n.xt2f.xm69.nsg13_hv_nmos[factuo]
print @n.xt2f.xm70.nsg13_hv_nmos[w]
print @n.xt2f.xm70.nsg13_hv_nmos[l]
print @n.xt2f.xm70.nsg13_hv_nmos[delvto]
print @n.xt2f.xm70.nsg13_hv_nmos[factuo]
print @n.xt2f.xm71.nsg13_hv_nmos[w]
print @n.xt2f.xm71.nsg13_hv_nmos[l]
print @n.xt2f.xm71.nsg13_hv_nmos[delvto]
print @n.xt2f.xm71.nsg13_hv_nmos[factuo]
print @n.xt2f.xm72.nsg13_hv_nmos[w]
print @n.xt2f.xm72.nsg13_hv_nmos[l]
print @n.xt2f.xm72.nsg13_hv_nmos[delvto]
print @n.xt2f.xm72.nsg13_hv_nmos[factuo]
print @n.xt2f.xm73.nsg13_hv_nmos[w]
print @n.xt2f.xm73.nsg13_hv_nmos[l]
print @n.xt2f.xm73.nsg13_hv_nmos[delvto]
print @n.xt2f.xm73.nsg13_hv_nmos[factuo]
print @n.xt2f.xm74.nsg13_hv_nmos[w]
print @n.xt2f.xm74.nsg13_hv_nmos[l]
print @n.xt2f.xm74.nsg13_hv_nmos[delvto]
print @n.xt2f.xm74.nsg13_hv_nmos[factuo]
print @n.xt2f.xm75.nsg13_hv_nmos[w]
print @n.xt2f.xm75.nsg13_hv_nmos[l]
print @n.xt2f.xm75.nsg13_hv_nmos[delvto]
print @n.xt2f.xm75.nsg13_hv_nmos[factuo]
print @n.xt2f.xm76.nsg13_hv_nmos[w]
print @n.xt2f.xm76.nsg13_hv_nmos[l]
print @n.xt2f.xm76.nsg13_hv_nmos[delvto]
print @n.xt2f.xm76.nsg13_hv_nmos[factuo]
print @n.xt2f.xm77.nsg13_hv_pmos[w]
print @n.xt2f.xm77.nsg13_hv_pmos[l]
print @n.xt2f.xm77.nsg13_hv_pmos[delvto]
print @n.xt2f.xm77.nsg13_hv_pmos[factuo]
print @n.xt2f.xm78.nsg13_hv_pmos[w]
print @n.xt2f.xm78.nsg13_hv_pmos[l]
print @n.xt2f.xm78.nsg13_hv_pmos[delvto]
print @n.xt2f.xm78.nsg13_hv_pmos[factuo]
print @n.xt2f.xm79.nsg13_hv_pmos[w]
print @n.xt2f.xm79.nsg13_hv_pmos[l]
print @n.xt2f.xm79.nsg13_hv_pmos[delvto]
print @n.xt2f.xm79.nsg13_hv_pmos[factuo]
print @n.xt2f.xm80.nsg13_hv_pmos[w]
print @n.xt2f.xm80.nsg13_hv_pmos[l]
print @n.xt2f.xm80.nsg13_hv_pmos[delvto]
print @n.xt2f.xm80.nsg13_hv_pmos[factuo]
print @n.xt2f.xm81.nsg13_hv_pmos[w]
print @n.xt2f.xm81.nsg13_hv_pmos[l]
print @n.xt2f.xm81.nsg13_hv_pmos[delvto]
print @n.xt2f.xm81.nsg13_hv_pmos[factuo]
print @n.xt2f.xm82.nsg13_hv_pmos[w]
print @n.xt2f.xm82.nsg13_hv_pmos[l]
print @n.xt2f.xm82.nsg13_hv_pmos[delvto]
print @n.xt2f.xm82.nsg13_hv_pmos[factuo]
print @n.xt2f.xm83.nsg13_hv_pmos[w]
print @n.xt2f.xm83.nsg13_hv_pmos[l]
print @n.xt2f.xm83.nsg13_hv_pmos[delvto]
print @n.xt2f.xm83.nsg13_hv_pmos[factuo]
print @n.xt2f.xm84.nsg13_hv_pmos[w]
print @n.xt2f.xm84.nsg13_hv_pmos[l]
print @n.xt2f.xm84.nsg13_hv_pmos[delvto]
print @n.xt2f.xm84.nsg13_hv_pmos[factuo]
print @n.xt2f.xm85.nsg13_hv_pmos[w]
print @n.xt2f.xm85.nsg13_hv_pmos[l]
print @n.xt2f.xm85.nsg13_hv_pmos[delvto]
print @n.xt2f.xm85.nsg13_hv_pmos[factuo]
print @n.xt2f.xm86.nsg13_hv_pmos[w]
print @n.xt2f.xm86.nsg13_hv_pmos[l]
print @n.xt2f.xm86.nsg13_hv_pmos[delvto]
print @n.xt2f.xm86.nsg13_hv_pmos[factuo]
print @n.xt2f.xm87.nsg13_hv_pmos[w]
print @n.xt2f.xm87.nsg13_hv_pmos[l]
print @n.xt2f.xm87.nsg13_hv_pmos[delvto]
print @n.xt2f.xm87.nsg13_hv_pmos[factuo]
print @n.xt2f.xm88.nsg13_hv_pmos[w]
print @n.xt2f.xm88.nsg13_hv_pmos[l]
print @n.xt2f.xm88.nsg13_hv_pmos[delvto]
print @n.xt2f.xm88.nsg13_hv_pmos[factuo]
print @n.xt2f.xm89.nsg13_hv_pmos[w]
print @n.xt2f.xm89.nsg13_hv_pmos[l]
print @n.xt2f.xm89.nsg13_hv_pmos[delvto]
print @n.xt2f.xm89.nsg13_hv_pmos[factuo]
print @n.xt2f.xm90.nsg13_hv_pmos[w]
print @n.xt2f.xm90.nsg13_hv_pmos[l]
print @n.xt2f.xm90.nsg13_hv_pmos[delvto]
print @n.xt2f.xm90.nsg13_hv_pmos[factuo]
print @n.xt2f.xm91.nsg13_lv_pmos[w]
print @n.xt2f.xm91.nsg13_lv_pmos[l]
print @n.xt2f.xm91.nsg13_lv_pmos[delvto]
print @n.xt2f.xm91.nsg13_lv_pmos[factuo]
print @c.xt2f.xc1.c1[scale]
print @c.xt2f.xc2.c1[scale]

meas tran t_a when v(fout)=0.6 rise=8
meas tran t_b when v(fout)=0.6 rise=24
let freq = (24-8)/(t_b-t_a)
print freq
meas tran i33_avg avg i(vdd) from=t_a to=t_b
meas tran i12_avg avg i(vdd12) from=t_a to=t_b
meas tran vref_avg avg v(vref) from=t_a to=t_b
meas tran vth_avg avg v(xt2f.vth) from=t_a to=t_b
meas tran cap1_max max v(xt2f.cap1) from=t_a to=t_b
meas tran fout_hi max v(fout) from=t_a to=t_b
meas tran fout_lo min v(fout) from=t_a to=t_b
meas tran t_half_a trig v(fout) val=0.6 rise=8 targ v(fout) val=0.6 fall=8

wrdata ptat_T100.dat v(fout) v(vref) i(vdd) i(vdd12) v(xt2f.cap1) v(xt2f.cap2) v(xt2f.ca1) v(xt2f.tail1) v(xt2f.cb1) v(xt2f.ca2) v(xt2f.tail2) v(xt2f.cb2)
quit
.endc

.end
