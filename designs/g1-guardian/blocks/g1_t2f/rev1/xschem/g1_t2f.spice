** sch_path: /work/designs/g1-guardian/blocks/g1_t2f/xschem/g1_t2f.sch
.subckt g1_t2f vdd vdd12 vss pbias pcasc vref en mode fout
*.iopin vdd
*.iopin vdd12
*.iopin vss
*.ipin pbias
*.ipin pcasc
*.ipin vref
*.ipin en
*.ipin mode
*.opin fout
XMPO do pbias vdd vdd sg13_hv_pmos w=10u l=4u ng=1 m=1 mm_ok=1
XMCO isrc pcasc do do sg13_hv_pmos w=10u l=4u ng=1 m=1 mm_ok=1
XMPR dr pbias vdd vdd sg13_hv_pmos w=10u l=4u ng=1 m=2 mm_ok=1
XMCR vr pcasc dr dr sg13_hv_pmos w=10u l=4u ng=1 m=2 mm_ok=1
XRREF vr vss sub! rppd w=0.5u l=245u m=1 b=0 mm_ok=1
XMPB db pbias vdd vdd sg13_hv_pmos w=10u l=4u ng=1 m=1 mm_ok=1
XMCB nbias pcasc db db sg13_hv_pmos w=10u l=4u ng=1 m=1 mm_ok=1
XMNB nbias nbias vss vss sg13_hv_nmos w=10u l=2u ng=1 m=1 mm_ok=1
XMX1 vref moden vth vss sg13_hv_nmos w=4u l=0.5u ng=1 m=1 mm_ok=1
XMX2 vr mode vth vss sg13_hv_nmos w=4u l=0.5u ng=1 m=1 mm_ok=1
XIMN moden mode vss vss sg13_hv_nmos w=1u l=0.5u ng=1 m=1 mm_ok=1
XIMP moden mode vdd vdd sg13_hv_pmos w=2u l=0.5u ng=1 m=1 mm_ok=1
XQA1 oa1 vth tail1 vss npn13G2 Nx=1 mm_ok=1
XQB1 ob1 cap1 tail1 vss npn13G2 Nx=1 mm_ok=1
XMLA1 oa1 oa1 vdd vdd sg13_hv_pmos w=4u l=1u ng=1 m=1 mm_ok=1
XMLB1 ob1 oa1 vdd vdd sg13_hv_pmos w=4u l=1u ng=1 m=1 mm_ok=1
XMT1 tail1 nbias vss vss sg13_hv_nmos w=20u l=2u ng=1 m=1 mm_ok=1
XIC1AN c1 ob1 vss vss sg13_hv_nmos w=1u l=0.5u ng=1 m=1 mm_ok=1
XIC1AP c1 ob1 vdd vdd sg13_hv_pmos w=2u l=0.5u ng=1 m=1 mm_ok=1
XIC1BN sn c1 vss vss sg13_hv_nmos w=2u l=0.5u ng=1 m=1 mm_ok=1
XIC1BP sn c1 vdd vdd sg13_hv_pmos w=4u l=0.5u ng=1 m=1 mm_ok=1
XQA2 oa2 vth tail2 vss npn13G2 Nx=1 mm_ok=1
XQB2 ob2 cap2 tail2 vss npn13G2 Nx=1 mm_ok=1
XMLA2 oa2 oa2 vdd vdd sg13_hv_pmos w=4u l=1u ng=1 m=1 mm_ok=1
XMLB2 ob2 oa2 vdd vdd sg13_hv_pmos w=4u l=1u ng=1 m=1 mm_ok=1
XMT2 tail2 nbias vss vss sg13_hv_nmos w=20u l=2u ng=1 m=1 mm_ok=1
XIC2AN c2 ob2 vss vss sg13_hv_nmos w=1u l=0.5u ng=1 m=1 mm_ok=1
XIC2AP c2 ob2 vdd vdd sg13_hv_pmos w=2u l=0.5u ng=1 m=1 mm_ok=1
XIC2BN rn c2 vss vss sg13_hv_nmos w=2u l=0.5u ng=1 m=1 mm_ok=1
XIC2BP rn c2 vdd vdd sg13_hv_pmos w=4u l=0.5u ng=1 m=1 mm_ok=1
XNQPA q sn vdd vdd sg13_hv_pmos w=2u l=0.5u ng=1 m=1 mm_ok=1
XNQPB q qn vdd vdd sg13_hv_pmos w=2u l=0.5u ng=1 m=1 mm_ok=1
XNQNA q sn NQ_i vss sg13_hv_nmos w=2u l=0.5u ng=1 m=1 mm_ok=1
XNQNB NQ_i qn vss vss sg13_hv_nmos w=2u l=0.5u ng=1 m=1 mm_ok=1
XNQNPA qn rn vdd vdd sg13_hv_pmos w=2u l=0.5u ng=1 m=1 mm_ok=1
XNQNPB qn q vdd vdd sg13_hv_pmos w=2u l=0.5u ng=1 m=1 mm_ok=1
XNQNPC qn en vdd vdd sg13_hv_pmos w=2u l=0.5u ng=1 m=1 mm_ok=1
XNQNNA qn rn NQN_i vss sg13_hv_nmos w=3u l=0.5u ng=1 m=1 mm_ok=1
XNQNNB NQN_i q NQN_j vss sg13_hv_nmos w=3u l=0.5u ng=1 m=1 mm_ok=1
XNQNNC NQN_j en vss vss sg13_hv_nmos w=3u l=0.5u ng=1 m=1 mm_ok=1
XND1PA d1g qn vdd vdd sg13_hv_pmos w=2u l=0.5u ng=1 m=1 mm_ok=1
XND1PB d1g en vdd vdd sg13_hv_pmos w=2u l=0.5u ng=1 m=1 mm_ok=1
XND1NA d1g qn ND1_i vss sg13_hv_nmos w=2u l=0.5u ng=1 m=1 mm_ok=1
XND1NB ND1_i en vss vss sg13_hv_nmos w=2u l=0.5u ng=1 m=1 mm_ok=1
XND2PA d2g q vdd vdd sg13_hv_pmos w=2u l=0.5u ng=1 m=1 mm_ok=1
XND2PB d2g en vdd vdd sg13_hv_pmos w=2u l=0.5u ng=1 m=1 mm_ok=1
XND2NA d2g q ND2_i vss sg13_hv_nmos w=2u l=0.5u ng=1 m=1 mm_ok=1
XND2NB ND2_i en vss vss sg13_hv_nmos w=2u l=0.5u ng=1 m=1 mm_ok=1
XSW1 cap1 d1g isrc vdd sg13_hv_pmos w=4u l=0.5u ng=1 m=1 mm_ok=1
XD1 cap1 d1g vss vss sg13_hv_nmos w=4u l=0.5u ng=1 m=1 mm_ok=1
XSW2 cap2 d2g isrc vdd sg13_hv_pmos w=4u l=0.5u ng=1 m=1 mm_ok=1
XD2 cap2 d2g vss vss sg13_hv_nmos w=4u l=0.5u ng=1 m=1 mm_ok=1
XC1 cap1 vss cap_cmim w=28u l=28u m=1 mm_ok=1
XC2 cap2 vss cap_cmim w=28u l=28u m=1 mm_ok=1
XIAN a d2g vss vss sg13_hv_nmos w=1u l=0.5u ng=1 m=1 mm_ok=1
XIAP a d2g vdd vdd sg13_hv_pmos w=2u l=0.5u ng=1 m=1 mm_ok=1
XMLSA lsa a vss vss sg13_hv_nmos w=2u l=0.5u ng=1 m=1 mm_ok=1
XMLSB lsb d2g vss vss sg13_hv_nmos w=2u l=0.5u ng=1 m=1 mm_ok=1
XMLPA lsa lsb vdd12 vdd12 sg13_lv_pmos w=0.5u l=0.3u ng=1 m=1 mm_ok=1
XMLPB lsb lsa vdd12 vdd12 sg13_lv_pmos w=0.5u l=0.3u ng=1 m=1 mm_ok=1
XIO1N fon lsb vss vss sg13_lv_nmos w=0.5u l=0.13u ng=1 m=1 mm_ok=1
XIO1P fon lsb vdd12 vdd12 sg13_lv_pmos w=1u l=0.13u ng=1 m=1 mm_ok=1
XIO2N fout fon vss vss sg13_lv_nmos w=1u l=0.13u ng=1 m=1 mm_ok=1
XIO2P fout fon vdd12 vdd12 sg13_lv_pmos w=2u l=0.13u ng=1 m=1 mm_ok=1
.ends
