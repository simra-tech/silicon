* G1_T2F LVS reference, generated by make_lvs_cdl.py from xschem/g1_t2f.spice (frozen schematic)
.subckt g1_t2f vdd vdd12 vss pbias pcasc vref en mode fout
MMPO do pbias vdd vdd sg13_hv_pmos w=10u l=4u ng=1 m=1
MMCO isrc pcasc do do sg13_hv_pmos w=10u l=4u ng=1 m=1
MMPR dr pbias vdd vdd sg13_hv_pmos w=10u l=4u ng=1 m=2
MMCR vr pcasc dr dr sg13_hv_pmos w=10u l=4u ng=1 m=2
RRREF vr vss vss rppd w=0.5u l=245u m=1 b=0
MMPB db pbias vdd vdd sg13_hv_pmos w=10u l=4u ng=1 m=1
MMCB nbias pcasc db db sg13_hv_pmos w=10u l=4u ng=1 m=1
MMNB nbias nbias vss vss sg13_hv_nmos w=10u l=2u ng=1 m=1
MMX1 vref moden vth vss sg13_hv_nmos w=4u l=0.5u ng=1 m=1
MMX2 vr mode vth vss sg13_hv_nmos w=4u l=0.5u ng=1 m=1
MIMN moden mode vss vss sg13_hv_nmos w=1u l=0.5u ng=1 m=1
MIMP moden mode vdd vdd sg13_hv_pmos w=2u l=0.5u ng=1 m=1
QQA1 oa1 vth tail1 vss npn13G2 le=900n we=70n Nx=1
QQB1 ob1 cap1 tail1 vss npn13G2 le=900n we=70n Nx=1
MMLA1 oa1 oa1 vdd vdd sg13_hv_pmos w=4u l=1u ng=1 m=1
MMLB1 ob1 oa1 vdd vdd sg13_hv_pmos w=4u l=1u ng=1 m=1
MMT1 tail1 nbias vss vss sg13_hv_nmos w=20u l=2u ng=1 m=1
MIC1AN c1 ob1 vss vss sg13_hv_nmos w=1u l=0.5u ng=1 m=1
MIC1AP c1 ob1 vdd vdd sg13_hv_pmos w=2u l=0.5u ng=1 m=1
MIC1BN sn c1 vss vss sg13_hv_nmos w=2u l=0.5u ng=1 m=1
MIC1BP sn c1 vdd vdd sg13_hv_pmos w=4u l=0.5u ng=1 m=1
QQA2 oa2 vth tail2 vss npn13G2 le=900n we=70n Nx=1
QQB2 ob2 cap2 tail2 vss npn13G2 le=900n we=70n Nx=1
MMLA2 oa2 oa2 vdd vdd sg13_hv_pmos w=4u l=1u ng=1 m=1
MMLB2 ob2 oa2 vdd vdd sg13_hv_pmos w=4u l=1u ng=1 m=1
MMT2 tail2 nbias vss vss sg13_hv_nmos w=20u l=2u ng=1 m=1
MIC2AN c2 ob2 vss vss sg13_hv_nmos w=1u l=0.5u ng=1 m=1
MIC2AP c2 ob2 vdd vdd sg13_hv_pmos w=2u l=0.5u ng=1 m=1
MIC2BN rn c2 vss vss sg13_hv_nmos w=2u l=0.5u ng=1 m=1
MIC2BP rn c2 vdd vdd sg13_hv_pmos w=4u l=0.5u ng=1 m=1
MNQPA q sn vdd vdd sg13_hv_pmos w=2u l=0.5u ng=1 m=1
MNQPB q qn vdd vdd sg13_hv_pmos w=2u l=0.5u ng=1 m=1
MNQNA q sn NQ_i vss sg13_hv_nmos w=2u l=0.5u ng=1 m=1
MNQNB NQ_i qn vss vss sg13_hv_nmos w=2u l=0.5u ng=1 m=1
MNQNPA qn rn vdd vdd sg13_hv_pmos w=2u l=0.5u ng=1 m=1
MNQNPB qn q vdd vdd sg13_hv_pmos w=2u l=0.5u ng=1 m=1
MNQNPC qn en vdd vdd sg13_hv_pmos w=2u l=0.5u ng=1 m=1
MNQNNA qn rn NQN_i vss sg13_hv_nmos w=3u l=0.5u ng=1 m=1
MNQNNB NQN_i q NQN_j vss sg13_hv_nmos w=3u l=0.5u ng=1 m=1
MNQNNC NQN_j en vss vss sg13_hv_nmos w=3u l=0.5u ng=1 m=1
MND1PA d1g qn vdd vdd sg13_hv_pmos w=2u l=0.5u ng=1 m=1
MND1PB d1g en vdd vdd sg13_hv_pmos w=2u l=0.5u ng=1 m=1
MND1NA d1g qn ND1_i vss sg13_hv_nmos w=2u l=0.5u ng=1 m=1
MND1NB ND1_i en vss vss sg13_hv_nmos w=2u l=0.5u ng=1 m=1
MND2PA d2g q vdd vdd sg13_hv_pmos w=2u l=0.5u ng=1 m=1
MND2PB d2g en vdd vdd sg13_hv_pmos w=2u l=0.5u ng=1 m=1
MND2NA d2g q ND2_i vss sg13_hv_nmos w=2u l=0.5u ng=1 m=1
MND2NB ND2_i en vss vss sg13_hv_nmos w=2u l=0.5u ng=1 m=1
MSW1 cap1 d1g isrc vdd sg13_hv_pmos w=4u l=0.5u ng=1 m=1
MD1 cap1 d1g vss vss sg13_hv_nmos w=4u l=0.5u ng=1 m=1
MSW2 cap2 d2g isrc vdd sg13_hv_pmos w=4u l=0.5u ng=1 m=1
MD2 cap2 d2g vss vss sg13_hv_nmos w=4u l=0.5u ng=1 m=1
CC1 cap1 vss cap_cmim w=28u l=28u m=1
CC2 cap2 vss cap_cmim w=28u l=28u m=1
MIAN a d2g vss vss sg13_hv_nmos w=1u l=0.5u ng=1 m=1
MIAP a d2g vdd vdd sg13_hv_pmos w=2u l=0.5u ng=1 m=1
MMLSA lsa a vss vss sg13_hv_nmos w=2u l=0.5u ng=1 m=1
MMLSB lsb d2g vss vss sg13_hv_nmos w=2u l=0.5u ng=1 m=1
MMLPA lsa lsb vdd12 vdd12 sg13_lv_pmos w=0.5u l=0.3u ng=1 m=1
MMLPB lsb lsa vdd12 vdd12 sg13_lv_pmos w=0.5u l=0.3u ng=1 m=1
MIO1N fon lsb vss vss sg13_lv_nmos w=0.5u l=0.13u ng=1 m=1
MIO1P fon lsb vdd12 vdd12 sg13_lv_pmos w=1u l=0.13u ng=1 m=1
MIO2N fout fon vss vss sg13_lv_nmos w=1u l=0.13u ng=1 m=1
MIO2P fout fon vdd12 vdd12 sg13_lv_pmos w=2u l=0.13u ng=1 m=1
QQD1 vss vss vss vss npn13G2 le=900n we=70n Nx=1
QQD2 vss vss vss vss npn13G2 le=900n we=70n Nx=1
.ends
