* Extracted by KLayout with SG13G2 LVS runset on : 19/09/2026 09:02

.SUBCKT g1_t2f a c1 c2 cap1 cap2 d1g d2g db do dr en fon fout isrc lsa lsb mode
+ moden nbias oa1 oa2 ob1 ob2 pbias pcasc q qn rn sn tail1 tail2 vdd vdd12 vr
+ vref vss vth
M$1 vdd12 fon fout vdd12 sg13_lv_pmos L=0.13u W=2u AS=0.68p AD=0.68p PS=4.68u
+ PD=4.68u rfmode=0
M$2 vss fon fout vss sg13_lv_nmos L=0.13u W=1u AS=0.34p AD=0.34p PS=2.68u
+ PD=2.68u rfmode=0
M$3 vdd12 lsb fon vdd12 sg13_lv_pmos L=0.13u W=1u AS=0.34p AD=0.34p PS=2.68u
+ PD=2.68u rfmode=0
M$4 vss lsb fon vss sg13_lv_nmos L=0.13u W=0.5u AS=0.17p AD=0.17p PS=1.68u
+ PD=1.68u rfmode=0
M$5 lsa lsb vdd12 vdd12 sg13_lv_pmos L=0.3u W=0.5u AS=0.17p AD=0.095p PS=1.68u
+ PD=0.88u rfmode=0
M$6 vdd12 lsa lsb vdd12 sg13_lv_pmos L=0.3u W=0.5u AS=0.095p AD=0.17p PS=0.88u
+ PD=1.68u rfmode=0
M$7 vdd en qn vdd sg13_hv_pmos L=0.5u W=2u AS=0.68p AD=0.38p PS=4.68u PD=2.38u
+ rfmode=0
M$8 qn q vdd vdd sg13_hv_pmos L=0.5u W=2u AS=0.38p AD=0.38p PS=2.38u PD=2.38u
+ rfmode=0
M$9 vdd rn qn vdd sg13_hv_pmos L=0.5u W=2u AS=0.38p AD=0.68p PS=2.38u PD=4.68u
+ rfmode=0
M$10 vss en \$I182 vss sg13_hv_nmos L=0.5u W=3u AS=1.02p AD=0.57p PS=6.68u
+ PD=3.38u rfmode=0
M$11 \$I182 q \$I183 vss sg13_hv_nmos L=0.5u W=3u AS=0.57p AD=0.57p PS=3.38u
+ PD=3.38u rfmode=0
M$12 \$I183 rn qn vss sg13_hv_nmos L=0.5u W=3u AS=0.57p AD=1.02p PS=3.38u
+ PD=6.68u rfmode=0
M$13 vdd en d2g vdd sg13_hv_pmos L=0.5u W=2u AS=0.68p AD=0.38p PS=4.68u
+ PD=2.38u rfmode=0
M$14 d2g q vdd vdd sg13_hv_pmos L=0.5u W=2u AS=0.38p AD=0.68p PS=2.38u PD=4.68u
+ rfmode=0
M$15 vdd qn q vdd sg13_hv_pmos L=0.5u W=2u AS=0.68p AD=0.38p PS=4.68u PD=2.38u
+ rfmode=0
M$16 q sn vdd vdd sg13_hv_pmos L=0.5u W=2u AS=0.38p AD=0.68p PS=2.38u PD=4.68u
+ rfmode=0
M$17 vdd en d1g vdd sg13_hv_pmos L=0.5u W=2u AS=0.68p AD=0.38p PS=4.68u
+ PD=2.38u rfmode=0
M$18 d1g qn vdd vdd sg13_hv_pmos L=0.5u W=2u AS=0.38p AD=0.68p PS=2.38u
+ PD=4.68u rfmode=0
M$19 vss en \$I171 vss sg13_hv_nmos L=0.5u W=2u AS=0.68p AD=0.38p PS=4.68u
+ PD=2.38u rfmode=0
M$20 \$I171 qn d1g vss sg13_hv_nmos L=0.5u W=2u AS=0.38p AD=0.68p PS=2.38u
+ PD=4.68u rfmode=0
M$21 lsa a vss vss sg13_hv_nmos L=0.5u W=2u AS=0.68p AD=0.38p PS=4.68u PD=2.38u
+ rfmode=0
M$22 vss d2g lsb vss sg13_hv_nmos L=0.5u W=2u AS=0.38p AD=0.68p PS=2.38u
+ PD=4.68u rfmode=0
M$23 vss en \$I170 vss sg13_hv_nmos L=0.5u W=2u AS=0.68p AD=0.38p PS=4.68u
+ PD=2.38u rfmode=0
M$24 \$I170 q d2g vss sg13_hv_nmos L=0.5u W=2u AS=0.38p AD=0.68p PS=2.38u
+ PD=4.68u rfmode=0
M$25 vss qn \$I169 vss sg13_hv_nmos L=0.5u W=2u AS=0.68p AD=0.38p PS=4.68u
+ PD=2.38u rfmode=0
M$26 \$I169 sn q vss sg13_hv_nmos L=0.5u W=2u AS=0.38p AD=0.68p PS=2.38u
+ PD=4.68u rfmode=0
M$27 vss c1 sn vss sg13_hv_nmos L=0.5u W=2u AS=0.68p AD=0.68p PS=4.68u PD=4.68u
+ rfmode=0
M$28 vss c2 rn vss sg13_hv_nmos L=0.5u W=2u AS=0.68p AD=0.68p PS=4.68u PD=4.68u
+ rfmode=0
M$29 vdd pbias dr vdd sg13_hv_pmos L=4u W=20u AS=5.3p AD=5.3p PS=31.06u
+ PD=31.06u rfmode=0
M$31 vr pcasc dr dr sg13_hv_pmos L=4u W=20u AS=5.3p AD=5.3p PS=31.06u PD=31.06u
+ rfmode=0
M$33 vdd pbias do vdd sg13_hv_pmos L=4u W=10u AS=3.4p AD=3.4p PS=20.68u
+ PD=20.68u rfmode=0
M$34 vdd pbias db vdd sg13_hv_pmos L=4u W=10u AS=3.4p AD=3.4p PS=20.68u
+ PD=20.68u rfmode=0
M$35 do pcasc isrc do sg13_hv_pmos L=4u W=10u AS=3.4p AD=3.4p PS=20.68u
+ PD=20.68u rfmode=0
M$36 db pcasc nbias db sg13_hv_pmos L=4u W=10u AS=3.4p AD=3.4p PS=20.68u
+ PD=20.68u rfmode=0
M$37 vdd oa1 oa1 vdd sg13_hv_pmos L=1u W=4u AS=1.36p AD=1.36p PS=8.68u PD=8.68u
+ rfmode=0
M$38 vdd oa2 ob2 vdd sg13_hv_pmos L=1u W=4u AS=1.36p AD=1.36p PS=8.68u PD=8.68u
+ rfmode=0
M$39 vdd oa1 ob1 vdd sg13_hv_pmos L=1u W=4u AS=1.36p AD=1.36p PS=8.68u PD=8.68u
+ rfmode=0
M$40 vdd oa2 oa2 vdd sg13_hv_pmos L=1u W=4u AS=1.36p AD=1.36p PS=8.68u PD=8.68u
+ rfmode=0
M$41 vss nbias nbias vss sg13_hv_nmos L=2u W=10u AS=3.4p AD=3.4p PS=20.68u
+ PD=20.68u rfmode=0
M$42 vss nbias tail1 vss sg13_hv_nmos L=2u W=20u AS=5.3p AD=5.3p PS=31.06u
+ PD=31.06u rfmode=0
M$44 vss nbias tail2 vss sg13_hv_nmos L=2u W=20u AS=5.3p AD=5.3p PS=31.06u
+ PD=31.06u rfmode=0
Q$46 vss vss vss vss npn13G2 we=70n le=900n Nx=1 m=2
Q$48 oa1 vth tail1 vss npn13G2 we=70n le=900n Nx=1 m=1
Q$49 ob1 cap1 tail1 vss npn13G2 we=70n le=900n Nx=1 m=1
Q$50 oa2 vth tail2 vss npn13G2 we=70n le=900n Nx=1 m=1
Q$51 ob2 cap2 tail2 vss npn13G2 we=70n le=900n Nx=1 m=1
M$52 vdd ob1 c1 vdd sg13_hv_pmos L=0.5u W=2u AS=0.68p AD=0.68p PS=4.68u
+ PD=4.68u rfmode=0
M$53 vdd mode moden vdd sg13_hv_pmos L=0.5u W=2u AS=0.68p AD=0.68p PS=4.68u
+ PD=4.68u rfmode=0
M$54 vdd d2g a vdd sg13_hv_pmos L=0.5u W=2u AS=0.68p AD=0.68p PS=4.68u PD=4.68u
+ rfmode=0
M$55 vdd ob2 c2 vdd sg13_hv_pmos L=0.5u W=2u AS=0.68p AD=0.68p PS=4.68u
+ PD=4.68u rfmode=0
M$56 vss mode moden vss sg13_hv_nmos L=0.5u W=1u AS=0.34p AD=0.34p PS=2.68u
+ PD=2.68u rfmode=0
M$57 vss ob2 c2 vss sg13_hv_nmos L=0.5u W=1u AS=0.34p AD=0.34p PS=2.68u
+ PD=2.68u rfmode=0
M$58 vss d2g a vss sg13_hv_nmos L=0.5u W=1u AS=0.34p AD=0.34p PS=2.68u PD=2.68u
+ rfmode=0
M$59 vss ob1 c1 vss sg13_hv_nmos L=0.5u W=1u AS=0.34p AD=0.34p PS=2.68u
+ PD=2.68u rfmode=0
M$60 vref moden vth vss sg13_hv_nmos L=0.5u W=4u AS=1.36p AD=0.76p PS=8.68u
+ PD=4.38u rfmode=0
M$61 vth mode vr vss sg13_hv_nmos L=0.5u W=4u AS=0.76p AD=1.36p PS=4.38u
+ PD=8.68u rfmode=0
M$62 vdd c1 sn vdd sg13_hv_pmos L=0.5u W=4u AS=1.36p AD=1.36p PS=8.68u PD=8.68u
+ rfmode=0
M$63 vdd c2 rn vdd sg13_hv_pmos L=0.5u W=4u AS=1.36p AD=1.36p PS=8.68u PD=8.68u
+ rfmode=0
M$64 isrc d2g cap2 vdd sg13_hv_pmos L=0.5u W=4u AS=1.36p AD=1.36p PS=8.68u
+ PD=8.68u rfmode=0
M$65 isrc d1g cap1 vdd sg13_hv_pmos L=0.5u W=4u AS=1.36p AD=1.36p PS=8.68u
+ PD=8.68u rfmode=0
M$66 vss d1g cap1 vss sg13_hv_nmos L=0.5u W=4u AS=1.36p AD=1.36p PS=8.68u
+ PD=8.68u rfmode=0
M$67 vss d2g cap2 vss sg13_hv_nmos L=0.5u W=4u AS=1.36p AD=1.36p PS=8.68u
+ PD=8.68u rfmode=0
R$74 vss vr vss rppd w=0.5u l=245u ps=0u b=0 m=1
C$78 cap1 vss cap_cmim w=28u l=28u A=784p P=112u m=1
C$79 cap2 vss cap_cmim w=28u l=28u A=784p P=112u m=1
.ENDS g1_t2f
