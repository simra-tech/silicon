* G1_T2F post-layout netlist: kpex 2.5D extraction (--mode CC --blackbox true) of layout/g1_t2f.gds,
* reformatted for ngspice by sim/postlayout/make_pex_netlist.py (see its docstring; no circuit content changed).
.subckt g1_t2f vdd vdd12 vss pbias pcasc vref en mode fout
XM1 fout fon vdd12 vdd12 sg13_lv_pmos l=0.13u w=2u as=0.68p ad=0.68p ps=4.68u pd=4.68u rfmode=0
XM2 fout fon vss vss sg13_lv_nmos l=0.13u w=1u as=0.34p ad=0.34p ps=2.68u pd=2.68u rfmode=0
XM3 fon lsb vdd12 vdd12 sg13_lv_pmos l=0.13u w=1u as=0.34p ad=0.34p ps=2.68u pd=2.68u rfmode=0
XM4 fon lsb vss vss sg13_lv_nmos l=0.13u w=0.5u as=0.17p ad=0.17p ps=1.68u pd=1.68u rfmode=0
XM5 vdd12 lsb lsa vdd12 sg13_lv_pmos l=0.3u w=0.5u as=0.17p ad=0.095p ps=1.68u pd=0.88u rfmode=0
XM6 lsb lsa vdd12 vdd12 sg13_lv_pmos l=0.3u w=0.5u as=0.095p ad=0.17p ps=0.88u pd=1.68u rfmode=0
XM7 qn en vdd vdd sg13_hv_pmos l=0.5u w=2u as=0.68p ad=0.38p ps=4.68u pd=2.38u rfmode=0
XM8 vdd q qn vdd sg13_hv_pmos l=0.5u w=2u as=0.38p ad=0.38p ps=2.38u pd=2.38u rfmode=0
XM9 qn rn vdd vdd sg13_hv_pmos l=0.5u w=2u as=0.38p ad=0.68p ps=2.38u pd=4.68u rfmode=0
XM10 nI182 en vss vss sg13_hv_nmos l=0.5u w=3u as=1.02p ad=0.57p ps=6.68u pd=3.38u rfmode=0
XM11 nI183 q nI182 vss sg13_hv_nmos l=0.5u w=3u as=0.57p ad=0.57p ps=3.38u pd=3.38u rfmode=0
XM12 qn rn nI183 vss sg13_hv_nmos l=0.5u w=3u as=0.57p ad=1.02p ps=3.38u pd=6.68u rfmode=0
XM13 d2g en vdd vdd sg13_hv_pmos l=0.5u w=2u as=0.68p ad=0.38p ps=4.68u pd=2.38u rfmode=0
XM14 vdd q d2g vdd sg13_hv_pmos l=0.5u w=2u as=0.38p ad=0.68p ps=2.38u pd=4.68u rfmode=0
XM15 q qn vdd vdd sg13_hv_pmos l=0.5u w=2u as=0.68p ad=0.38p ps=4.68u pd=2.38u rfmode=0
XM16 vdd sn q vdd sg13_hv_pmos l=0.5u w=2u as=0.38p ad=0.68p ps=2.38u pd=4.68u rfmode=0
XM17 d1g en vdd vdd sg13_hv_pmos l=0.5u w=2u as=0.68p ad=0.38p ps=4.68u pd=2.38u rfmode=0
XM18 vdd qn d1g vdd sg13_hv_pmos l=0.5u w=2u as=0.38p ad=0.68p ps=2.38u pd=4.68u rfmode=0
XM19 nI171 en vss vss sg13_hv_nmos l=0.5u w=2u as=0.68p ad=0.38p ps=4.68u pd=2.38u rfmode=0
XM20 d1g qn nI171 vss sg13_hv_nmos l=0.5u w=2u as=0.38p ad=0.68p ps=2.38u pd=4.68u rfmode=0
XM21 vss a lsa vss sg13_hv_nmos l=0.5u w=2u as=0.68p ad=0.38p ps=4.68u pd=2.38u rfmode=0
XM22 lsb d2g vss vss sg13_hv_nmos l=0.5u w=2u as=0.38p ad=0.68p ps=2.38u pd=4.68u rfmode=0
XM23 nI170 en vss vss sg13_hv_nmos l=0.5u w=2u as=0.68p ad=0.38p ps=4.68u pd=2.38u rfmode=0
XM24 d2g q nI170 vss sg13_hv_nmos l=0.5u w=2u as=0.38p ad=0.68p ps=2.38u pd=4.68u rfmode=0
XM25 nI169 qn vss vss sg13_hv_nmos l=0.5u w=2u as=0.68p ad=0.38p ps=4.68u pd=2.38u rfmode=0
XM26 q sn nI169 vss sg13_hv_nmos l=0.5u w=2u as=0.38p ad=0.68p ps=2.38u pd=4.68u rfmode=0
XM27 sn c1 vss vss sg13_hv_nmos l=0.5u w=2u as=0.68p ad=0.68p ps=4.68u pd=4.68u rfmode=0
XM28 rn c2 vss vss sg13_hv_nmos l=0.5u w=2u as=0.68p ad=0.68p ps=4.68u pd=4.68u rfmode=0
XM29 dr pbias vdd vdd sg13_hv_pmos l=4u w=10u as=3.4p ad=1.9p ps=20.68u pd=10.38u rfmode=0
XM30 vdd pbias dr vdd sg13_hv_pmos l=4u w=10u as=1.9p ad=3.4p ps=10.38u pd=20.68u rfmode=0
XM31 dr pcasc vr dr sg13_hv_pmos l=4u w=10u as=3.4p ad=1.9p ps=20.68u pd=10.38u rfmode=0
XM32 vr pcasc dr dr sg13_hv_pmos l=4u w=10u as=1.9p ad=3.4p ps=10.38u pd=20.68u rfmode=0
XM33 do pbias vdd vdd sg13_hv_pmos l=4u w=10u as=3.4p ad=3.4p ps=20.68u pd=20.68u rfmode=0
XM34 db pbias vdd vdd sg13_hv_pmos l=4u w=10u as=3.4p ad=3.4p ps=20.68u pd=20.68u rfmode=0
XM35 isrc pcasc do do sg13_hv_pmos l=4u w=10u as=3.4p ad=3.4p ps=20.68u pd=20.68u rfmode=0
XM36 nbias pcasc db db sg13_hv_pmos l=4u w=10u as=3.4p ad=3.4p ps=20.68u pd=20.68u rfmode=0
XM37 oa1 oa1 vdd vdd sg13_hv_pmos l=1u w=4u as=1.36p ad=1.36p ps=8.68u pd=8.68u rfmode=0
XM38 ob2 oa2 vdd vdd sg13_hv_pmos l=1u w=4u as=1.36p ad=1.36p ps=8.68u pd=8.68u rfmode=0
XM39 ob1 oa1 vdd vdd sg13_hv_pmos l=1u w=4u as=1.36p ad=1.36p ps=8.68u pd=8.68u rfmode=0
XM40 oa2 oa2 vdd vdd sg13_hv_pmos l=1u w=4u as=1.36p ad=1.36p ps=8.68u pd=8.68u rfmode=0
XM41 nbias nbias vss vss sg13_hv_nmos l=2u w=10u as=3.4p ad=3.4p ps=20.68u pd=20.68u rfmode=0
XM42 tail1 nbias vss vss sg13_hv_nmos l=2u w=10u as=3.4p ad=1.9p ps=20.68u pd=10.38u rfmode=0
XM43 vss nbias tail1 vss sg13_hv_nmos l=2u w=10u as=1.9p ad=3.4p ps=10.38u pd=20.68u rfmode=0
XM44 tail2 nbias vss vss sg13_hv_nmos l=2u w=10u as=3.4p ad=1.9p ps=20.68u pd=10.38u rfmode=0
XM45 vss nbias tail2 vss sg13_hv_nmos l=2u w=10u as=1.9p ad=3.4p ps=10.38u pd=20.68u rfmode=0
XQ46 vss vss vss vss npn13G2 we=0.07u le=0.9u Nx=1 m=1
XQ47 vss vss vss vss npn13G2 we=0.07u le=0.9u Nx=1 m=1
XQ48 oa1 vth tail1 vss npn13G2 we=0.07u le=0.9u Nx=1 m=1
XQ49 ob1 cap1 tail1 vss npn13G2 we=0.07u le=0.9u Nx=1 m=1
XQ50 oa2 vth tail2 vss npn13G2 we=0.07u le=0.9u Nx=1 m=1
XQ51 ob2 cap2 tail2 vss npn13G2 we=0.07u le=0.9u Nx=1 m=1
XM52 c1 ob1 vdd vdd sg13_hv_pmos l=0.5u w=2u as=0.68p ad=0.68p ps=4.68u pd=4.68u rfmode=0
XM53 moden mode vdd vdd sg13_hv_pmos l=0.5u w=2u as=0.68p ad=0.68p ps=4.68u pd=4.68u rfmode=0
XM54 a d2g vdd vdd sg13_hv_pmos l=0.5u w=2u as=0.68p ad=0.68p ps=4.68u pd=4.68u rfmode=0
XM55 c2 ob2 vdd vdd sg13_hv_pmos l=0.5u w=2u as=0.68p ad=0.68p ps=4.68u pd=4.68u rfmode=0
XM56 moden mode vss vss sg13_hv_nmos l=0.5u w=1u as=0.34p ad=0.34p ps=2.68u pd=2.68u rfmode=0
XM57 c2 ob2 vss vss sg13_hv_nmos l=0.5u w=1u as=0.34p ad=0.34p ps=2.68u pd=2.68u rfmode=0
XM58 a d2g vss vss sg13_hv_nmos l=0.5u w=1u as=0.34p ad=0.34p ps=2.68u pd=2.68u rfmode=0
XM59 c1 ob1 vss vss sg13_hv_nmos l=0.5u w=1u as=0.34p ad=0.34p ps=2.68u pd=2.68u rfmode=0
XM60 vth moden vref vss sg13_hv_nmos l=0.5u w=4u as=1.36p ad=0.76p ps=8.68u pd=4.38u rfmode=0
XM61 vr mode vth vss sg13_hv_nmos l=0.5u w=4u as=0.76p ad=1.36p ps=4.38u pd=8.68u rfmode=0
XM62 sn c1 vdd vdd sg13_hv_pmos l=0.5u w=4u as=1.36p ad=1.36p ps=8.68u pd=8.68u rfmode=0
XM63 rn c2 vdd vdd sg13_hv_pmos l=0.5u w=4u as=1.36p ad=1.36p ps=8.68u pd=8.68u rfmode=0
XM64 cap2 d2g isrc vdd sg13_hv_pmos l=0.5u w=4u as=1.36p ad=1.36p ps=8.68u pd=8.68u rfmode=0
XM65 cap1 d1g isrc vdd sg13_hv_pmos l=0.5u w=4u as=1.36p ad=1.36p ps=8.68u pd=8.68u rfmode=0
XM66 cap1 d1g vss vss sg13_hv_nmos l=0.5u w=4u as=1.36p ad=1.36p ps=8.68u pd=8.68u rfmode=0
XM67 cap2 d2g vss vss sg13_hv_nmos l=0.5u w=4u as=1.36p ad=1.36p ps=8.68u pd=8.68u rfmode=0
XR68 vr n7 vss rppd w=0.5u l=24.5u b=0 m=1
XR69 vss n15 vss rppd w=0.5u l=24.5u b=0 m=1
XR70 n8 n7 vss rppd w=0.5u l=24.5u b=0 m=1
XR71 n8 n9 vss rppd w=0.5u l=24.5u b=0 m=1
XR72 n10 n9 vss rppd w=0.5u l=24.5u b=0 m=1
XR73 n10 n11 vss rppd w=0.5u l=24.5u b=0 m=1
XR74 n12 n11 vss rppd w=0.5u l=24.5u b=0 m=1
XR75 n12 n13 vss rppd w=0.5u l=24.5u b=0 m=1
XR76 n14 n13 vss rppd w=0.5u l=24.5u b=0 m=1
XR77 n14 n15 vss rppd w=0.5u l=24.5u b=0 m=1
XC1 cap1 vss cap_cmim w=28u l=28u m=1
XC2 cap2 vss cap_cmim w=28u l=28u m=1
Cext_1 n10 n12 0.016f
Cext_2 n10 n8 0.016f
Cext_3 n10 vr 0.001f
Cext_4 n10 vss 0.058f
Cext_5 n10 vss 0.307f
Cext_6 n11 n13 0.016f
Cext_7 n11 n9 0.016f
Cext_8 n11 mode 0.001f
Cext_9 n11 vr 0f
Cext_10 n11 vss 0.007f
Cext_11 n11 vss 0.341f
Cext_12 n12 n14 0.016f
Cext_13 n12 vr 0f
Cext_14 n12 vss 0.058f
Cext_15 n12 vss 0.307f
Cext_16 n13 n15 0.016f
Cext_17 n13 mode 0.001f
Cext_18 n13 vss 0.007f
Cext_19 n13 vss 0.341f
Cext_20 n14 vss 0.075f
Cext_21 n14 vss 0.307f
Cext_22 n15 mode 0.001f
Cext_23 n15 vss 0.009f
Cext_24 n15 vss 0.354f
Cext_25 n7 n9 0.016f
Cext_26 n7 cap2 0.001f
Cext_27 n7 mode 0.001f
Cext_28 n7 vr 0.037f
Cext_29 n7 vss 0.008f
Cext_30 n7 vss 0.354f
Cext_31 n8 vr 0.02f
Cext_32 n8 vss 0.058f
Cext_33 n8 vss 0.307f
Cext_34 n9 mode 0.001f
Cext_35 n9 vr 0.002f
Cext_36 n9 vss 0.007f
Cext_37 n9 vss 0.341f
Cext_38 nI169 q 0.12f
Cext_39 nI169 qn 0.056f
Cext_40 nI169 sn 0.056f
Cext_41 nI169 vss 0.091f
Cext_42 nI169 vss 0.035f
Cext_43 nI170 d2g 0.12f
Cext_44 nI170 en 0.056f
Cext_45 nI170 q 0.056f
Cext_46 nI170 vss 0.091f
Cext_47 nI170 vss 0.035f
Cext_48 nI171 d1g 0.12f
Cext_49 nI171 en 0.056f
Cext_50 nI171 qn 0.056f
Cext_51 nI171 vss 0.091f
Cext_52 nI171 vss 0.035f
Cext_53 nI182 nI183 0.13f
Cext_54 nI182 en 0.083f
Cext_55 nI182 q 0.083f
Cext_56 nI182 qn 0.046f
Cext_57 nI182 vss 0.134f
Cext_58 nI182 vss 0.047f
Cext_59 nI183 d2g 0.001f
Cext_60 nI183 q 0.101f
Cext_61 nI183 qn 0.134f
Cext_62 nI183 rn 0.101f
Cext_63 nI183 vss 0.004f
Cext_64 nI183 vss 0.047f
Cext_65 a c2 0.03f
Cext_66 a d2g 2.212f
Cext_67 a en 0.001f
Cext_68 a lsa 1.195f
Cext_69 a lsb 0.012f
Cext_70 a ob2 0.045f
Cext_71 a q 0.006f
Cext_72 a qn 0.084f
Cext_73 a rn 0.297f
Cext_74 a vdd 0.111f
Cext_75 a vss 0.227f
Cext_76 c1 d1g 0.03f
Cext_77 c1 en 0.078f
Cext_78 c1 oa1 0.002f
Cext_79 c1 ob1 1.846f
Cext_80 c1 q 0.002f
Cext_81 c1 qn 0f
Cext_82 c1 sn 1.722f
Cext_83 c1 vdd 0.308f
Cext_84 c1 vss 0.339f
Cext_85 c2 d2g 0.261f
Cext_86 c2 en 0.012f
Cext_87 c2 lsa 0.137f
Cext_88 c2 lsb 0.069f
Cext_89 c2 oa2 0.004f
Cext_90 c2 ob2 1.904f
Cext_91 c2 rn 1.658f
Cext_92 c2 vdd 0.378f
Cext_93 c2 vdd12 0.001f
Cext_94 c2 vss 0.335f
Cext_95 cap1 cap2 1.801f
Cext_96 cap1 d1g 2.598f
Cext_97 cap1 isrc 0.633f
Cext_98 cap1 nbias 0.44f
Cext_99 cap1 ob1 0.017f
Cext_100 cap1 tail1 0.476f
Cext_101 cap1 vdd 0.061f
Cext_102 cap1 vss 9.41f
Cext_103 cap1 vth 0.103f
Cext_104 cap2 d2g 2.729f
Cext_105 cap2 do 0.023f
Cext_106 cap2 isrc 1.159f
Cext_107 cap2 mode 0.063f
Cext_108 cap2 moden 0.037f
Cext_109 cap2 nbias 0.548f
Cext_110 cap2 ob2 0.017f
Cext_111 cap2 tail2 0.479f
Cext_112 cap2 vdd 0.064f
Cext_113 cap2 vr 0.032f
Cext_114 cap2 vref 0.091f
Cext_115 cap2 vss 8.584f
Cext_116 cap2 vth 0.154f
Cext_117 d1g d2g 0.051f
Cext_118 d1g en 2.107f
Cext_119 d1g isrc 1.287f
Cext_120 d1g nbias 0.063f
Cext_121 d1g oa1 0.132f
Cext_122 d1g ob1 0.036f
Cext_123 d1g q 0.006f
Cext_124 d1g qn 1.919f
Cext_125 d1g sn 0.12f
Cext_126 d1g tail1 0.039f
Cext_127 d1g vdd 0.4f
Cext_128 d1g vss 0.699f
Cext_129 d1g vth 0.324f
Cext_130 d2g do 0.152f
Cext_131 d2g en 2.639f
Cext_132 d2g fon 0.001f
Cext_133 d2g fout 0f
Cext_134 d2g isrc 1.278f
Cext_135 d2g lsa 0.266f
Cext_136 d2g lsb 0.777f
Cext_137 d2g moden 0.008f
Cext_138 d2g nbias 0.017f
Cext_139 d2g oa1 0.023f
Cext_140 d2g oa2 0.053f
Cext_141 d2g ob1 0.151f
Cext_142 d2g ob2 0.632f
Cext_143 d2g pbias 0.075f
Cext_144 d2g pcasc 0.188f
Cext_145 d2g q 1.756f
Cext_146 d2g qn 0.142f
Cext_147 d2g rn 0.328f
Cext_148 d2g sn 0.028f
Cext_149 d2g vdd 0.846f
Cext_150 d2g vref 0f
Cext_151 d2g vss 0.523f
Cext_152 d2g vth 0.029f
Cext_153 db dr 0.021f
Cext_154 db nbias 0.118f
Cext_155 db pbias 0.621f
Cext_156 db pcasc 0.697f
Cext_157 db vdd 0.132f
Cext_158 db vr 0.096f
Cext_159 db vref 0.002f
Cext_160 do dr 0.025f
Cext_161 do isrc 0.128f
Cext_162 do nbias 0.005f
Cext_163 do pbias 0.679f
Cext_164 do pcasc 0.715f
Cext_165 do vdd 0.531f
Cext_166 do vth 0.003f
Cext_167 dr nbias 0.041f
Cext_168 dr pbias 1.03f
Cext_169 dr pcasc 1.187f
Cext_170 dr vdd 0.232f
Cext_171 dr vr 0.21f
Cext_172 dr vref 0.004f
Cext_173 en fon 0.001f
Cext_174 en fout 0.964f
Cext_175 en lsa 0.001f
Cext_176 en lsb 0.001f
Cext_177 en oa1 0.001f
Cext_178 en ob1 0.155f
Cext_179 en ob2 0.015f
Cext_180 en q 0.615f
Cext_181 en qn 3.81f
Cext_182 en rn 0.009f
Cext_183 en sn 0.725f
Cext_184 en vdd 6.446f
Cext_185 en vdd12 0.01f
Cext_186 en vss 0.757f
Cext_187 fon fout 0.216f
Cext_188 fon lsa 0.001f
Cext_189 fon lsb 0.28f
Cext_190 fon vdd12 0.198f
Cext_191 fon vss 0.128f
Cext_192 fout lsb 0.007f
Cext_193 fout vdd 0.491f
Cext_194 fout vdd12 1.481f
Cext_195 fout vss 0.168f
Cext_196 isrc nbias 4.302f
Cext_197 isrc pbias 0f
Cext_198 isrc pcasc 0.567f
Cext_199 isrc vdd 0.128f
Cext_200 isrc vr 0.135f
Cext_201 isrc vss 0.088f
Cext_202 isrc vth 0.338f
Cext_203 lsa lsb 2.913f
Cext_204 lsa oa2 0f
Cext_205 lsa ob2 0.524f
Cext_206 lsa rn 0.149f
Cext_207 lsa sn 0.002f
Cext_208 lsa vdd 0.064f
Cext_209 lsa vdd12 0.062f
Cext_210 lsa vss 0.287f
Cext_211 lsb ob2 0.163f
Cext_212 lsb rn 0.603f
Cext_213 lsb vdd 0.017f
Cext_214 lsb vdd12 0.127f
Cext_215 lsb vss 0.415f
Cext_216 mode moden 2.689f
Cext_217 mode vdd 0.056f
Cext_218 mode vr 1.182f
Cext_219 mode vref 0.004f
Cext_220 mode vss 0.51f
Cext_221 mode vth 1.038f
Cext_222 moden vdd 0.09f
Cext_223 moden vr 0.047f
Cext_224 moden vref 1.038f
Cext_225 moden vss 0.227f
Cext_226 moden vth 1.04f
Cext_227 nbias pcasc 0.661f
Cext_228 nbias tail1 0.944f
Cext_229 nbias tail2 0.944f
Cext_230 nbias vdd 0.038f
Cext_231 nbias vr 2.042f
Cext_232 nbias vref 0.099f
Cext_233 nbias vss 3.279f
Cext_234 nbias vth 1.876f
Cext_235 oa1 oa2 0.012f
Cext_236 oa1 ob1 0.249f
Cext_237 oa1 q 0.003f
Cext_238 oa1 tail1 0.441f
Cext_239 oa1 vdd 0.501f
Cext_240 oa1 vss 0.212f
Cext_241 oa1 vth 0.017f
Cext_242 oa2 ob1 0.008f
Cext_243 oa2 ob2 0.31f
Cext_244 oa2 rn 0.002f
Cext_245 oa2 tail2 0.441f
Cext_246 oa2 vdd 0.478f
Cext_247 oa2 vss 0.224f
Cext_248 oa2 vth 0.017f
Cext_249 ob1 ob2 0.07f
Cext_250 ob1 q 0.283f
Cext_251 ob1 qn 0.188f
Cext_252 ob1 rn 0.002f
Cext_253 ob1 sn 0.267f
Cext_254 ob1 tail1 0.437f
Cext_255 ob1 vdd 0.275f
Cext_256 ob1 vss 0.281f
Cext_257 ob2 qn 0.012f
Cext_258 ob2 rn 0.064f
Cext_259 ob2 tail2 0.437f
Cext_260 ob2 vdd 0.302f
Cext_261 ob2 vss 0.208f
Cext_262 pbias pcasc 0.777f
Cext_263 pbias vdd 2.501f
Cext_264 pbias vss 0.06f
Cext_265 pcasc vdd 0.231f
Cext_266 pcasc vr 1.021f
Cext_267 pcasc vref 0.002f
Cext_268 pcasc vss 0.057f
Cext_269 pcasc vth 0.001f
Cext_270 q qn 3.357f
Cext_271 q rn 0.672f
Cext_272 q sn 2.151f
Cext_273 q vdd 0.369f
Cext_274 q vss 0.323f
Cext_275 qn rn 0.322f
Cext_276 qn sn 1.179f
Cext_277 qn vdd 0.556f
Cext_278 qn vss 0.293f
Cext_279 rn sn 0f
Cext_280 rn vdd 0.259f
Cext_281 rn vdd12 0.024f
Cext_282 rn vss 0.289f
Cext_283 sn vdd 0.472f
Cext_284 sn vss 0.319f
Cext_285 tail1 tail2 0.014f
Cext_286 tail1 vdd 0f
Cext_287 tail1 vss 0.622f
Cext_288 tail1 vth 0.476f
Cext_289 tail2 vdd 0f
Cext_290 tail2 vss 0.609f
Cext_291 tail2 vth 0.476f
Cext_292 vdd vdd12 0.319f
Cext_293 vdd vr 0.167f
Cext_294 vdd vref 0.553f
Cext_295 vdd vss 6.33f
Cext_296 vdd vth 0.297f
Cext_297 vdd12 vss 0.103f
Cext_298 vr vref 0.658f
Cext_299 vr vss 0.157f
Cext_300 vr vth 0.713f
Cext_301 vref vss 0.075f
Cext_302 vref vth 0.876f
Cext_303 vss vth 0.508f
Cext_304 vss a 0.967f
Cext_305 vss c1 1.699f
Cext_306 vss c2 1.804f
Cext_307 vss cap1 9.203f
Cext_308 vss cap2 10.099f
Cext_309 vss d1g 4.104f
Cext_310 vss d2g 6.358f
Cext_311 vss db 1.584f
Cext_312 vss do 1.579f
Cext_313 vss dr 1.078f
Cext_314 vss en 4.875f
Cext_315 vss fon 0.787f
Cext_316 vss fout 1.906f
Cext_317 vss isrc 2.018f
Cext_318 vss lsa 1.074f
Cext_319 vss lsb 1.609f
Cext_320 vss mode 4.116f
Cext_321 vss moden 1.68f
Cext_322 vss nbias 16.651f
Cext_323 vss oa1 2.913f
Cext_324 vss oa2 3.012f
Cext_325 vss ob1 2.314f
Cext_326 vss ob2 2.007f
Cext_327 vss pbias 21.172f
Cext_328 vss pcasc 21.717f
Cext_329 vss q 1.926f
Cext_330 vss qn 2.156f
Cext_331 vss rn 1.747f
Cext_332 vss sn 1.35f
Cext_333 vss tail1 1.045f
Cext_334 vss tail2 1.057f
Cext_335 vss vdd 38.578f
Cext_336 vss vdd12 3.284f
Cext_337 vss vr 5.791f
Cext_338 vss vref 2.419f
Cext_340 vss vth 3.837f
.ends g1_t2f
