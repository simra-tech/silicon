** sch_path: characterisation/xschem/ihp_sg13g2_inv.sch
.subckt ihp_sg13g2_inv in out vdd vss
*.PININFO in:I out:O vdd:B vss:B
XM2 out in vdd vdd sg13_lv_pmos w=1.414u l=0.13u ng=1 m=1 mm_ok=1
XM1 out in vss vss sg13_lv_nmos w=1.0u l=0.13u ng=1 m=1 mm_ok=1
.ends
