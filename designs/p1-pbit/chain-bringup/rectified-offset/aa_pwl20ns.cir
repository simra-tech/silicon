* P1_NOISE_AMP alone: does the differential output carry a DC mean?
.lib $PDK_ROOT/libs.tech/ngspice/models/cornerHBT.lib hbt_typ
.lib $PDK_ROOT/libs.tech/ngspice/models/cornerRES.lib res_typ
.lib $PDK_ROOT/libs.tech/ngspice/models/cornerCAP.lib cap_typ
.lib $PDK_ROOT/libs.tech/ngspice/models/cornerMOShv.lib mos_tt
.lib $PDK_ROOT/libs.tech/ngspice/models/cornerMOSlv.lib mos_tt
.lib $PDK_ROOT/libs.tech/ngspice/models/cornerDIO.lib dio_tt
.include ./p1_noise_amp_export.spice
.option temp = 27.0
.options rshunt = 1e12
VCC_HBT VCC_HBT 0 DC 2.500
VSS VSS 0 DC 0.000
.include ./pwl20ns.inc
VRAW_N RAW_NOISE_N 0 DC 1.440
XAMP NOISE_AMP_P NOISE_AMP_N RAW_NOISE_P RAW_NOISE_N VCC_HBT VSS p1_noise_amp
.control
pre_osdi $PDK_ROOT/libs.tech/ngspice/osdi/psp103.osdi
pre_osdi $PDK_ROOT/libs.tech/ngspice/osdi/psp103_nqs.osdi
tran 2p 20n 0 2p
let ampdiff = v(NOISE_AMP_P) - v(NOISE_AMP_N)
let indiff = v(RAW_NOISE_P) - v(RAW_NOISE_N)
meas tran in_avg  AVG indiff  from=2n to=20n
meas tran amp_avg AVG ampdiff from=2n to=20n
meas tran amp_max MAX ampdiff from=2n to=20n
meas tran amp_min MIN ampdiff from=2n to=20n
meas tran cm_avg  AVG v(NOISE_AMP_P) from=2n to=20n
.endc
.end
