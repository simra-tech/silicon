* 180ns High-Statistics Sampling Phase Sweep (N = 650 bits): COLD: -40C, FF, VDD=1.32V (Vtrip=0.656V)
.lib $PDK_ROOT/libs.tech/ngspice/models/cornerHBT.lib hbt_typ
.lib $PDK_ROOT/libs.tech/ngspice/models/cornerRES.lib res_typ
.lib $PDK_ROOT/libs.tech/ngspice/models/cornerCAP.lib cap_typ
.lib $PDK_ROOT/libs.tech/ngspice/models/cornerMOShv.lib mos_ff
.lib $PDK_ROOT/libs.tech/ngspice/models/cornerMOSlv.lib mos_ff
.lib $PDK_ROOT/libs.tech/ngspice/models/cornerDIO.lib dio_tt

.include ./cace_ihp_sg13g2_demo/xschem/simulations/p1_noise_amp.spice

.subckt p1_comp_cand2_180n PBIT_OUT PBIT_RAW CLK_OUT_DIV IN_P IN_N CLK_P CLK_N TRIM_P TRIM_N VCC_HBT VDD VSS
XRC1 VCC_HBT c_n sub! rppd w=1.0u l=0.838u m=1 b=0 mm_ok=1
XRC2 VCC_HBT c_p sub! rppd w=1.0u l=0.838u m=1 b=0 mm_ok=1
XQ1 c_n IN_P e_track sub! npn13G2 Nx=1 mm_ok=1
XQ2 c_p IN_N e_track sub! npn13G2 Nx=1 mm_ok=1
XQ3 c_n ef_p e_latch sub! npn13G2 Nx=1 mm_ok=1
XQ4 c_p ef_n e_latch sub! npn13G2 Nx=1 mm_ok=1
I_PTAT_TAIL e_tail VSS DC 1.958m
XQCLK_TRACK e_track CLK_P e_tail sub! npn13G2 Nx=1 mm_ok=1
XQCLK_LATCH e_latch CLK_N e_tail sub! npn13G2 Nx=1 mm_ok=1
XQEF1 VCC_HBT c_p ef_p sub! npn13G2 Nx=1 mm_ok=1
XQEF2 VCC_HBT c_n ef_n sub! npn13G2 Nx=1 mm_ok=1
XR1_P ef_p g_p sub! rppd w=1.0u l=22.0u m=1 b=0 mm_ok=1
XR2_P g_p VSS sub! rppd w=1.0u l=14.5u m=1 b=0 mm_ok=1
XR1_N ef_n g_n sub! rppd w=1.0u l=22.0u m=1 b=0 mm_ok=1
XR2_N g_n VSS sub! rppd w=1.0u l=14.5u m=1 b=0 mm_ok=1
XM1 cml_out_n g_p e_cmos VSS sg13_lv_nmos w=6.0u l=0.13u ng=1 m=1 mm_ok=1
XM2 cml_out_p g_n e_cmos VSS sg13_lv_nmos w=6.0u l=0.13u ng=1 m=1 mm_ok=1
XMTAIL e_cmos VDD VSS VSS sg13_lv_nmos w=8.0u l=0.50u ng=1 m=1 mm_ok=1
XM3 cml_out_n cml_out_n VDD VDD sg13_lv_pmos w=8.0u l=0.13u ng=1 m=1 mm_ok=1
XM4 cml_out_p cml_out_n VDD VDD sg13_lv_pmos w=8.0u l=0.13u ng=1 m=1 mm_ok=1
XCDAMP1 cml_out_p VSS cap_cmim w=5.0u l=5.0u m=1 mm_ok=1
XCDAMP2 cml_out_n VSS cap_cmim w=5.0u l=5.0u m=1 mm_ok=1
XRFB raw_inv cml_out_p sub! rppd w=1.0u l=18.05u m=1 b=0 mm_ok=1
XM5 raw_inv cml_out_p VDD VDD sg13_lv_pmos w=2.83u l=0.13u ng=1 m=1 mm_ok=1
XM6 raw_inv cml_out_p VSS VSS sg13_lv_nmos w=2.0u l=0.13u ng=1 m=1 mm_ok=1
XM7 PBIT_RAW raw_inv VDD VDD sg13_lv_pmos w=2.83u l=0.13u ng=1 m=1 mm_ok=1
XM8 PBIT_RAW raw_inv VSS VSS sg13_lv_nmos w=2.0u l=0.13u ng=1 m=1 mm_ok=1
XM9 PBIT_OUT PBIT_RAW VDD VDD sg13_lv_pmos w=2.83u l=0.13u ng=1 m=1 mm_ok=1
XM10 PBIT_OUT PBIT_RAW VSS VSS sg13_lv_nmos w=2.0u l=0.13u ng=1 m=1 mm_ok=1
XQDAC_P c_p TRIM_P e_dac_p sub! npn13G2 Nx=1 mm_ok=1
XRDAC_P e_dac_p VSS sub! rppd w=1.0u l=3.0u m=1 b=0 mm_ok=1
XQDAC_N c_n TRIM_N e_dac_n sub! npn13G2 Nx=1 mm_ok=1
XRDAC_N e_dac_n VSS sub! rppd w=1.0u l=3.0u m=1 b=0 mm_ok=1
XTAP1 VSS sub! ptap1
.ends

.option temp = -40
.options reltol=1e-4 abstol=1e-12 vntol=1e-6 chgtol=1e-15 method=gear rshunt=1e12

VCC_HBT VCC 0 DC 2.75
VDD VDD 0 DC 1.32
VSS VSS 0 DC 0.000

VCM_CT v_cm 0 DC 1.440
VNOISE_SRC noise_src 0 DC 0.0 PWL(0.0000n -0.444058m 0.0050n -0.532854m 0.0100n -0.343053m 0.0150n 2.163373m 0.0200n -0.393202m 0.0250n -4.614544m 0.0300n 1.024139m 0.0350n -0.823881m 0.0400n -0.668623m 0.0450n 0.357134m 0.0500n 0.715 ... [PWL truncated for publication: 36,000 points at 5 ps, seed 42, sigma 3.0818 mV; regenerate with the sweep script] )
E_NOISE_P RAW_NOISE_P v_cm noise_src 0 +0.5
E_NOISE_N RAW_NOISE_N v_cm noise_src 0 -0.5

VCLK_P CLK_P 0 PULSE(1.32 0.0 0 20p 20p 80p 200p)
VCLK_N CLK_N 0 PULSE(0.0 1.32 0 20p 20p 80p 200p)
VTRIM_P TRIM_P 0 DC 0.800
VTRIM_N TRIM_N 0 DC 0.800

XAMP NOISE_AMP_P NOISE_AMP_N RAW_NOISE_P RAW_NOISE_N VCC VSS p1_noise_amp

XCAC1 NOISE_AMP_P in_p cap_cmim w=36.5u l=36.5u m=1
XCAC2 NOISE_AMP_N in_n cap_cmim w=36.5u l=36.5u m=1

* Optimal R_bias = 13.02 kOhm (L = 50 um)
XRBIAS1 VCC in_p sub! rppd w=1.0u l=10.547u m=1 b=0 mm_ok=1
XRBIAS2 in_p VSS sub! rppd w=1.0u l=14.353u m=1 b=0 mm_ok=1
XRBIAS3 VCC in_n sub! rppd w=1.0u l=10.547u m=1 b=0 mm_ok=1
XRBIAS4 in_n VSS sub! rppd w=1.0u l=14.353u m=1 b=0 mm_ok=1

XCOMP PBIT_OUT PBIT_RAW CLK_OUT_DIV in_p in_n CLK_P CLK_N TRIM_P TRIM_N VCC VDD VSS p1_comp_cand2_180n

.control
pre_osdi $PDK_ROOT/libs.tech/ngspice/osdi/psp103.osdi
pre_osdi $PDK_ROOT/libs.tech/ngspice/osdi/psp103_nqs.osdi
set filetype=ascii

save v(PBIT_OUT) v(CLK_P) v(xcomp.cml_out_p)
tran 2p 180n 0 2p

linearize v(PBIT_OUT) v(CLK_P) v(xcomp.cml_out_p)
write ./raw_180ns_-40c.raw v(PBIT_OUT) v(CLK_P) v(xcomp.cml_out_p)
.endc
.end
