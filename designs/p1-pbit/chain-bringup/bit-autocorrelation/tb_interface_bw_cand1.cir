* CML-to-CMOS candidate 1: resistive load in place of the current mirror
.lib $PDK_ROOT/libs.tech/ngspice/models/cornerHBT.lib hbt_typ
.lib $PDK_ROOT/libs.tech/ngspice/models/cornerRES.lib res_typ
.lib $PDK_ROOT/libs.tech/ngspice/models/cornerCAP.lib cap_typ
.lib $PDK_ROOT/libs.tech/ngspice/models/cornerMOShv.lib mos_tt
.lib $PDK_ROOT/libs.tech/ngspice/models/cornerMOSlv.lib mos_tt
.lib $PDK_ROOT/libs.tech/ngspice/models/cornerDIO.lib dio_tt
.include ./p1_comparator_cand1.spice
.option temp = 27.0
.options rshunt = 1e12
VCC_HBT VCC_HBT 0 DC 2.500
VDD VDD 0 DC 1.200
VSS VSS 0 DC 0.000
VCLK_P CLK_P 0 DC 1.20
VCLK_N CLK_N 0 DC 0.0
VAMP_P raw_amp_p 0 DC 2.1386 AC 0.5
VAMP_N raw_amp_n 0 DC 2.1386 AC -0.5
RROUT1 raw_amp_p IN_P 120
RROUT2 raw_amp_n IN_N 120
VTRIM_P TRIM_P 0 DC 1.440
VTRIM_N TRIM_N 0 DC 1.440
XCOMP PBIT_OUT PBIT_RAW CLK_OUT_DIV IN_P IN_N CLK_P CLK_N TRIM_P TRIM_N VCC_HBT VDD VSS p1_comparator
.control
pre_osdi $PDK_ROOT/libs.tech/ngspice/osdi/psp103.osdi
pre_osdi $PDK_ROOT/libs.tech/ngspice/osdi/psp103_nqs.osdi
ac dec 20 1e5 5e10
let cml = v(xcomp.cml_out_p) - v(xcomp.cml_out_n)
let cml_db = db(cml)
let col = v(xcomp.c_p) - v(xcomp.c_n)
let col_db = db(col)
meas ac cml_lo FIND cml_db at=1e6
meas ac col_lo FIND col_db at=1e6
meas ac cml_bw WHEN cml_db=1.006 FALL=1
meas ac col_bw WHEN col_db=9.323 FALL=1
.endc
.end
