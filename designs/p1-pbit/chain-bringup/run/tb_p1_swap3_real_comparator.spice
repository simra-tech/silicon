* Stage 2 Swap 3: 28 dB Preamp + 100-Tone Incommensurate Physical Noise (2.5 GHz Nyquist)
.lib $PDK_ROOT/ihp-sg13g2/libs.tech/ngspice/models/cornerHBT.lib hbt_typ
.lib $PDK_ROOT/ihp-sg13g2/libs.tech/ngspice/models/cornerMOSlv.lib mos_tt

.subckt p1_noise_gen RAW_NOISE_P RAW_NOISE_N VCC VSS
XQ1 RAW_NOISE_N b1_q1 e VSS npn13G2 Nx=1
XQ2 RAW_NOISE_P b2_q2 e VSS npn13G2 Nx=1
RC1 VCC RAW_NOISE_N 1.0k m=1
RC2 VCC RAW_NOISE_P 1.0k m=1
R_TAIL e VSS 316
C_TAIL_GEN e VSS 50f

VBM b_cm VSS DC 0.872

* 100-Tone Incommensurate Physical Noise Source evaluated with 64-bit IEEE double precision
V_NOISE_P b2_src b_cm DC 0 PWL ( 0.0000n 0.001424 0.0100n 0.001341 0.0200n 0.001261 0.0300n 0.001185 0.0400n 0.001114 0.0500n 0.001047 0.0600n 0.000983 0.0700n 0.000922 0.0800n 0.000863 0.0900n 0.000805 0.1000n 0.000747 0.1100n 0.000688 0.1200n 0.000627 0.1300n 0.000561 0.1400n 0.000491
+ 0.1500n 0.000415 0.1600n 0.000331 0.1700n 0.000240 0.1800n 0.000141 0.1900n 0.000032 0.2000n -0.000086 0.2100n -0.000213 0.2200n -0.000349 0.2300n -0.000493 0.2400n -0.000645 0.2500n -0.000803 0.2600n -0.000967 0.2700n -0.001135 0.2800n -0.001305 0.2900n -0.001476
+ 0.3000n -0.001645 0.3100n -0.001811 0.3200n -0.001973 0.3300n -0.002127 0.3400n -0.002273 0.3500n -0.002408 0.3600n -0.002530 0.3700n -0.002640 0.3800n -0.002734 0.3900n -0.002812 0.4000n -0.002874 0.4100n -0.002919 0.4200n -0.002946 0.4300n -0.002957 0.4400n -0.002950
+ 0.4500n -0.002928 0.4600n -0.002890 0.4700n -0.002839 0.4800n -0.002776 0.4900n -0.002702 0.5000n -0.002619 0.5100n -0.002531 0.5200n -0.002437 0.5300n -0.002342 0.5400n -0.002247 0.5500n -0.002154 0.5600n -0.002066 0.5700n -0.001985 0.5800n -0.001912 0.5900n -0.001850
+ 0.6000n -0.001799 0.6100n -0.001762 0.6200n -0.001739 0.6300n -0.001731 0.6400n -0.001738 0.6500n -0.001761 0.6600n -0.001799 0.6700n -0.001851 0.6800n -0.001916 0.6900n -0.001994 0.7000n -0.002082 0.7100n -0.002180 0.7200n -0.002284 0.7300n -0.002394 0.7400n -0.002505
+ 0.7500n -0.002617 0.7600n -0.002726 0.7700n -0.002829 0.7800n -0.002925 0.7900n -0.003010 0.8000n -0.003083 0.8100n -0.003141 0.8200n -0.003182 0.8300n -0.003203 0.8400n -0.003205 0.8500n -0.003185 0.8600n -0.003142 0.8700n -0.003075 0.8800n -0.002985 0.8900n -0.002872
+ 0.9000n -0.002736 0.9100n -0.002578 0.9200n -0.002398 0.9300n -0.002199 0.9400n -0.001983 0.9500n -0.001750 0.9600n -0.001505 0.9700n -0.001249 0.9800n -0.000986 0.9900n -0.000717 1.0000n -0.000447 1.0100n -0.000178 1.0200n 0.000087 1.0300n 0.000344 1.0400n 0.000591
+ 1.0500n 0.000824 1.0600n 0.001042 1.0700n 0.001242 1.0800n 0.001421 1.0900n 0.001578 1.1000n 0.001711 1.1100n 0.001819 1.1200n 0.001902 1.1300n 0.001958 1.1400n 0.001988 1.1500n 0.001991 1.1600n 0.001970 1.1700n 0.001924 1.1800n 0.001856 1.1900n 0.001767
+ 1.2000n 0.001659 1.2100n 0.001535 1.2200n 0.001397 1.2300n 0.001248 1.2400n 0.001092 1.2500n 0.000930 1.2600n 0.000766 1.2700n 0.000604 1.2800n 0.000446 1.2900n 0.000295 1.3000n 0.000154 1.3100n 0.000026 1.3200n -0.000087 1.3300n -0.000183 1.3400n -0.000261
+ 1.3500n -0.000318 1.3600n -0.000354 1.3700n -0.000369 1.3800n -0.000361 1.3900n -0.000332 1.4000n -0.000282 1.4100n -0.000212 1.4200n -0.000123 1.4300n -0.000017 1.4400n 0.000103 1.4500n 0.000236 1.4600n 0.000380 1.4700n 0.000530 1.4800n 0.000684 1.4900n 0.000840
+ 1.5000n 0.000993 1.5100n 0.001142 1.5200n 0.001282 1.5300n 0.001412 1.5400n 0.001528 1.5500n 0.001628 1.5600n 0.001710 1.5700n 0.001771 1.5800n 0.001811 1.5900n 0.001829 1.6000n 0.001823 1.6100n 0.001793 1.6200n 0.001740 1.6300n 0.001664 1.6400n 0.001567
+ 1.6500n 0.001449 1.6600n 0.001313 1.6700n 0.001160 1.6800n 0.000994 1.6900n 0.000816 1.7000n 0.000631 1.7100n 0.000441 1.7200n 0.000249 1.7300n 0.000060 1.7400n -0.000125 1.7500n -0.000301 1.7600n -0.000466 1.7700n -0.000616 1.7800n -0.000750 1.7900n -0.000864
+ 1.8000n -0.000957 1.8100n -0.001026 1.8200n -0.001072 1.8300n -0.001092 1.8400n -0.001088 1.8500n -0.001059 1.8600n -0.001005 1.8700n -0.000929 1.8800n -0.000830 1.8900n -0.000713 1.9000n -0.000578 1.9100n -0.000429 1.9200n -0.000269 1.9300n -0.000100 1.9400n 0.000073
+ 1.9500n 0.000248 1.9600n 0.000420 1.9700n 0.000586 1.9800n 0.000743 1.9900n 0.000887 2.0000n 0.001016 2.0100n 0.001125 2.0200n 0.001214 2.0300n 0.001280 2.0400n 0.001321 2.0500n 0.001335 2.0600n 0.001323 2.0700n 0.001283 2.0800n 0.001217 2.0900n 0.001124
+ 2.1000n 0.001006 2.1100n 0.000865 2.1200n 0.000702 2.1300n 0.000520 2.1400n 0.000322 2.1500n 0.000111 2.1600n -0.000110 2.1700n -0.000337 2.1800n -0.000567 2.1900n -0.000795 2.2000n -0.001019 2.2100n -0.001234 2.2200n -0.001437 2.2300n -0.001624 2.2400n -0.001794
+ 2.2500n -0.001942 2.2600n -0.002067 2.2700n -0.002166 2.2800n -0.002237 2.2900n -0.002281 2.3000n -0.002296 2.3100n -0.002281 2.3200n -0.002238 2.3300n -0.002166 2.3400n -0.002067 2.3500n -0.001942 2.3600n -0.001794 2.3700n -0.001625 2.3800n -0.001437 2.3900n -0.001233
+ 2.4000n -0.001016 2.4100n -0.000790 2.4200n -0.000557 2.4300n -0.000322 2.4400n -0.000088 2.4500n 0.000142 2.4600n 0.000365 2.4700n 0.000578 2.4800n 0.000777 2.4900n 0.000961 2.5000n 0.001126 2.5100n 0.001271 2.5200n 0.001394 2.5300n 0.001493 2.5400n 0.001568
+ 2.5500n 0.001617 2.5600n 0.001641 2.5700n 0.001640 2.5800n 0.001613 2.5900n 0.001562 2.6000n 0.001488 2.6100n 0.001391 2.6200n 0.001274 2.6300n 0.001138 2.6400n 0.000985 2.6500n 0.000818 2.6600n 0.000638 2.6700n 0.000449 2.6800n 0.000252 2.6900n 0.000050
+ 2.7000n -0.000155 2.7100n -0.000360 2.7200n -0.000562 2.7300n -0.000760 2.7400n -0.000951 2.7500n -0.001133 2.7600n -0.001304 2.7700n -0.001462 2.7800n -0.001607 2.7900n -0.001736 2.8000n -0.001848 2.8100n -0.001942 2.8200n -0.002018 2.8300n -0.002075 2.8400n -0.002112
+ 2.8500n -0.002129 2.8600n -0.002127 2.8700n -0.002105 2.8800n -0.002065 2.8900n -0.002005 2.9000n -0.001928 2.9100n -0.001834 2.9200n -0.001725 2.9300n -0.001601 2.9400n -0.001464 2.9500n -0.001315 2.9600n -0.001156 2.9700n -0.000988 2.9800n -0.000814 2.9900n -0.000635
+ 3.0000n -0.000453 3.0100n -0.000269 3.0200n -0.000086 3.0300n 0.000095 3.0400n 0.000271 3.0500n 0.000442 3.0600n 0.000605 3.0700n 0.000760 3.0800n 0.000903 3.0900n 0.001036 3.1000n 0.001155 3.1100n 0.001261 3.1200n 0.001352 3.1300n 0.001428 3.1400n 0.001489
+ 3.1500n 0.001534 3.1600n 0.001564 3.1700n 0.001579 3.1800n 0.001579 3.1900n 0.001565 3.2000n 0.001538 3.2100n 0.001500 3.2200n 0.001450 3.2300n 0.001392 3.2400n 0.001326 3.2500n 0.001254 3.2600n 0.001177 3.2700n 0.001098 3.2800n 0.001017 3.2900n 0.000938
+ 3.3000n 0.000860 3.3100n 0.000786 3.3200n 0.000717 3.3300n 0.000655 3.3400n 0.000599 3.3500n 0.000552 3.3600n 0.000513 3.3700n 0.000484 3.3800n 0.000463 3.3900n 0.000452 3.4000n 0.000448 3.4100n 0.000453 3.4200n 0.000465 3.4300n 0.000482 3.4400n 0.000504
+ 3.4500n 0.000530 3.4600n 0.000557 3.4700n 0.000583 3.4800n 0.000608 3.4900n 0.000630 3.5000n 0.000646 3.5100n 0.000655 3.5200n 0.000656 3.5300n 0.000647 3.5400n 0.000628 3.5500n 0.000596 3.5600n 0.000552 3.5700n 0.000495 3.5800n 0.000425 3.5900n 0.000342
+ 3.6000n 0.000248 3.6100n 0.000142 3.6200n 0.000026 3.6300n -0.000099 3.6400n -0.000231 3.6500n -0.000367 3.6600n -0.000505 3.6700n -0.000644 3.6800n -0.000779 3.6900n -0.000910 3.7000n -0.001033 3.7100n -0.001145 3.7200n -0.001243 3.7300n -0.001326 3.7400n -0.001391
+ 3.7500n -0.001436 3.7600n -0.001459 3.7700n -0.001459 3.7800n -0.001435 3.7900n -0.001386 3.8000n -0.001311 3.8100n -0.001212 3.8200n -0.001088 3.8300n -0.000941 3.8400n -0.000773 3.8500n -0.000584 3.8600n -0.000378 3.8700n -0.000156 3.8800n 0.000077 3.8900n 0.000320
+ 3.9000n 0.000568 3.9100n 0.000819 3.9200n 0.001068 3.9300n 0.001312 3.9400n 0.001548 3.9500n 0.001773 3.9600n 0.001982 3.9700n 0.002174 3.9800n 0.002345 3.9900n 0.002494 4.0000n 0.002617 4.0100n 0.002714 4.0200n 0.002784 4.0300n 0.002825 4.0400n 0.002838
+ 4.0500n 0.002822 4.0600n 0.002779 4.0700n 0.002709 4.0800n 0.002614 4.0900n 0.002496 4.1000n 0.002356 4.1100n 0.002197 4.1200n 0.002022 4.1300n 0.001833 4.1400n 0.001633 4.1500n 0.001425 4.1600n 0.001211 4.1700n 0.000995 4.1800n 0.000779 4.1900n 0.000565
+ 4.2000n 0.000355 4.2100n 0.000152 4.2200n -0.000042 4.2300n -0.000227 4.2400n -0.000402 4.2500n -0.000565 4.2600n -0.000716 4.2700n -0.000855 4.2800n -0.000982 4.2900n -0.001097 4.3000n -0.001202 4.3100n -0.001297 4.3200n -0.001382 4.3300n -0.001460 4.3400n -0.001530
+ 4.3500n -0.001595 4.3600n -0.001655 4.3700n -0.001711 4.3800n -0.001764 4.3900n -0.001814 4.4000n -0.001864 4.4100n -0.001911 4.4200n -0.001958 4.4300n -0.002003 4.4400n -0.002047 4.4500n -0.002088 4.4600n -0.002126 4.4700n -0.002159 4.4800n -0.002188 4.4900n -0.002209
+ 4.5000n -0.002222 4.5100n -0.002226 4.5200n -0.002218 4.5300n -0.002198 4.5400n -0.002163 4.5500n -0.002113 4.5600n -0.002047 4.5700n -0.001964 4.5800n -0.001862 4.5900n -0.001743 4.6000n -0.001606 4.6100n -0.001452 4.6200n -0.001281 4.6300n -0.001094 4.6400n -0.000894
+ 4.6500n -0.000682 4.6600n -0.000460 4.6700n -0.000231 4.6800n 0.000003 4.6900n 0.000238 4.7000n 0.000471 4.7100n 0.000699 4.7200n 0.000919 4.7300n 0.001127 4.7400n 0.001321 4.7500n 0.001496 4.7600n 0.001651 4.7700n 0.001783 4.7800n 0.001890 4.7900n 0.001969
+ 4.8000n 0.002020 4.8100n 0.002042 4.8200n 0.002034 4.8300n 0.001997 4.8400n 0.001930 4.8500n 0.001836 4.8600n 0.001715 4.8700n 0.001571 4.8800n 0.001404 4.8900n 0.001219 4.9000n 0.001019 4.9100n 0.000806 4.9200n 0.000584 4.9300n 0.000359 4.9400n 0.000132
+ 4.9500n -0.000092 4.9600n -0.000309 4.9700n -0.000515 4.9800n -0.000708 4.9900n -0.000884 5.0000n -0.001041 5.0100n -0.001176 5.0200n -0.001287 5.0300n -0.001373 5.0400n -0.001433 5.0500n -0.001466 5.0600n -0.001473 5.0700n -0.001455 5.0800n -0.001411 5.0900n -0.001344
+ 5.1000n -0.001256 5.1100n -0.001148 5.1200n -0.001023 5.1300n -0.000883 5.1400n -0.000733 5.1500n -0.000573 5.1600n -0.000408 5.1700n -0.000240 5.1800n -0.000073 5.1900n 0.000093 5.2000n 0.000253 5.2100n 0.000406 5.2200n 0.000550 5.2300n 0.000683 5.2400n 0.000805
+ 5.2500n 0.000914 5.2600n 0.001011 5.2700n 0.001095 5.2800n 0.001167 5.2900n 0.001227 5.3000n 0.001277 5.3100n 0.001317 5.3200n 0.001349 5.3300n 0.001375 5.3400n 0.001396 5.3500n 0.001414 5.3600n 0.001432 5.3700n 0.001450 5.3800n 0.001470 5.3900n 0.001494
+ 5.4000n 0.001523 5.4100n 0.001557 5.4200n 0.001598 5.4300n 0.001645 5.4400n 0.001699 5.4500n 0.001759 5.4600n 0.001824 5.4700n 0.001894 5.4800n 0.001967 5.4900n 0.002041 5.5000n 0.002115 5.5100n 0.002186 5.5200n 0.002253 5.5300n 0.002314 5.5400n 0.002366
+ 5.5500n 0.002407 5.5600n 0.002435 5.5700n 0.002448 5.5800n 0.002445 5.5900n 0.002425 5.6000n 0.002385 5.6100n 0.002327 5.6200n 0.002249 5.6300n 0.002153 5.6400n 0.002037 5.6500n 0.001904 5.6600n 0.001756 5.6700n 0.001593 5.6800n 0.001419 5.6900n 0.001235
+ 5.7000n 0.001045 5.7100n 0.000853 5.7200n 0.000660 5.7300n 0.000471 5.7400n 0.000289 5.7500n 0.000117 5.7600n -0.000042 5.7700n -0.000184 5.7800n -0.000306 5.7900n -0.000407 5.8000n -0.000484 5.8100n -0.000536 5.8200n -0.000561 5.8300n -0.000560 5.8400n -0.000531
+ 5.8500n -0.000475 5.8600n -0.000394 5.8700n -0.000288 5.8800n -0.000161 5.8900n -0.000013 5.9000n 0.000151 5.9100n 0.000329 5.9200n 0.000517 5.9300n 0.000712 5.9400n 0.000909 5.9500n 0.001104 5.9600n 0.001294 5.9700n 0.001475 5.9800n 0.001643 5.9900n 0.001795
+ 6.0000n 0.001927 6.0100n 0.002037 6.0200n 0.002122 6.0300n 0.002181 6.0400n 0.002213 6.0500n 0.002216 6.0600n 0.002190 6.0700n 0.002136 6.0800n 0.002054 6.0900n 0.001946 6.1000n 0.001814 6.1100n 0.001659 6.1200n 0.001485 6.1300n 0.001293 6.1400n 0.001088
+ 6.1500n 0.000873 6.1600n 0.000651 6.1700n 0.000425 6.1800n 0.000200 6.1900n -0.000023 6.2000n -0.000238 6.2100n -0.000445 6.2200n -0.000639 6.2300n -0.000819 6.2400n -0.000984 6.2500n -0.001130 6.2600n -0.001259 6.2700n -0.001368 6.2800n -0.001457 6.2900n -0.001528
+ 6.3000n -0.001581 6.3100n -0.001616 6.3200n -0.001636 6.3300n -0.001641 6.3400n -0.001634 6.3500n -0.001616 6.3600n -0.001590 6.3700n -0.001558 6.3800n -0.001522 6.3900n -0.001484 6.4000n -0.001446 6.4100n -0.001410 6.4200n -0.001377 6.4300n -0.001349 6.4400n -0.001326
+ 6.4500n -0.001309 6.4600n -0.001298 6.4700n -0.001293 6.4800n -0.001294 6.4900n -0.001300 6.5000n -0.001311 6.5100n -0.001324 6.5200n -0.001338 6.5300n -0.001352 6.5400n -0.001364 6.5500n -0.001372 6.5600n -0.001375 6.5700n -0.001371 6.5800n -0.001357 6.5900n -0.001334
+ 6.6000n -0.001299 6.6100n -0.001252 6.6200n -0.001192 6.6300n -0.001119 6.6400n -0.001032 6.6500n -0.000934 6.6600n -0.000823 6.6700n -0.000702 6.6800n -0.000572 6.6900n -0.000435 6.7000n -0.000292 6.7100n -0.000148 6.7200n -0.000003 6.7300n 0.000139 6.7400n 0.000275
+ 6.7500n 0.000403 6.7600n 0.000521 6.7700n 0.000624 6.7800n 0.000712 6.7900n 0.000782 6.8000n 0.000832 6.8100n 0.000862 6.8200n 0.000869 6.8300n 0.000853 6.8400n 0.000815 6.8500n 0.000755 6.8600n 0.000673 6.8700n 0.000571 6.8800n 0.000451 6.8900n 0.000316
+ 6.9000n 0.000167 6.9100n 0.000009 6.9200n -0.000157 6.9300n -0.000326 6.9400n -0.000495 6.9500n -0.000659 6.9600n -0.000816 6.9700n -0.000962 6.9800n -0.001093 6.9900n -0.001207 7.0000n -0.001300 7.0100n -0.001370 7.0200n -0.001415 7.0300n -0.001434 7.0400n -0.001425
+ 7.0500n -0.001389 7.0600n -0.001325 7.0700n -0.001234 7.0800n -0.001117 7.0900n -0.000976 7.1000n -0.000815 7.1100n -0.000634 7.1200n -0.000438 7.1300n -0.000230 7.1400n -0.000014 7.1500n 0.000205 7.1600n 0.000425 7.1700n 0.000641 7.1800n 0.000848 7.1900n 0.001042
+ 7.2000n 0.001221 7.2100n 0.001380 7.2200n 0.001516 7.2300n 0.001628 7.2400n 0.001711 7.2500n 0.001766 7.2600n 0.001791 7.2700n 0.001785 7.2800n 0.001748 7.2900n 0.001682 7.3000n 0.001586 7.3100n 0.001465 7.3200n 0.001318 7.3300n 0.001150 7.3400n 0.000962
+ 7.3500n 0.000760 7.3600n 0.000546 7.3700n 0.000324 7.3800n 0.000099 7.3900n -0.000127 7.4000n -0.000348 7.4100n -0.000561 7.4200n -0.000763 7.4300n -0.000950 7.4400n -0.001120 7.4500n -0.001269 7.4600n -0.001396 7.4700n -0.001499 7.4800n -0.001577 7.4900n -0.001629
+ 7.5000n -0.001656 7.5100n -0.001657 7.5200n -0.001634 7.5300n -0.001587 7.5400n -0.001520 7.5500n -0.001433 7.5600n -0.001330 7.5700n -0.001212 7.5800n -0.001084 7.5900n -0.000948 7.6000n -0.000807 7.6100n -0.000664 7.6200n -0.000523 7.6300n -0.000386 7.6400n -0.000256
+ 7.6500n -0.000135 7.6600n -0.000026 7.6700n 0.000069 7.6800n 0.000149 7.6900n 0.000212 7.7000n 0.000259 7.7100n 0.000287 7.7200n 0.000298 7.7300n 0.000292 7.7400n 0.000269 7.7500n 0.000230 7.7600n 0.000177 7.7700n 0.000111 7.7800n 0.000034 7.7900n -0.000052
+ 7.8000n -0.000146 7.8100n -0.000245 7.8200n -0.000348 7.8300n -0.000452 7.8400n -0.000555 7.8500n -0.000655 7.8600n -0.000752 7.8700n -0.000843 7.8800n -0.000927 7.8900n -0.001004 7.9000n -0.001071 7.9100n -0.001130 7.9200n -0.001179 7.9300n -0.001218 7.9400n -0.001248
+ 7.9500n -0.001268 7.9600n -0.001280 7.9700n -0.001283 7.9800n -0.001279 7.9900n -0.001268 8.0000n -0.001251 8.0100n -0.001229 8.0200n -0.001204 8.0300n -0.001174 8.0400n -0.001143 8.0500n -0.001109 8.0600n -0.001075 8.0700n -0.001039 8.0800n -0.001003 8.0900n -0.000967
+ 8.1000n -0.000930 8.1100n -0.000893 8.1200n -0.000856 8.1300n -0.000818 8.1400n -0.000778 8.1500n -0.000737 8.1600n -0.000694 8.1700n -0.000648 8.1800n -0.000599 8.1900n -0.000546 8.2000n -0.000489 8.2100n -0.000428 8.2200n -0.000361 8.2300n -0.000291 8.2400n -0.000215
+ 8.2500n -0.000134 8.2600n -0.000050 8.2700n 0.000039 8.2800n 0.000131 8.2900n 0.000226 8.3000n 0.000323 8.3100n 0.000420 8.3200n 0.000518 8.3300n 0.000613 8.3400n 0.000707 8.3500n 0.000797 8.3600n 0.000881 8.3700n 0.000960 8.3800n 0.001032 8.3900n 0.001097
+ 8.4000n 0.001152 8.4100n 0.001199 8.4200n 0.001236 8.4300n 0.001263 8.4400n 0.001280 8.4500n 0.001288 8.4600n 0.001286 8.4700n 0.001276 8.4800n 0.001258 8.4900n 0.001234 8.5000n 0.001204 8.5100n 0.001171 8.5200n 0.001135 8.5300n 0.001098 8.5400n 0.001062
+ 8.5500n 0.001029 8.5600n 0.001000 8.5700n 0.000977 8.5800n 0.000961 8.5900n 0.000954 8.6000n 0.000956 8.6100n 0.000970 8.6200n 0.000995 8.6300n 0.001033 8.6400n 0.001083 8.6500n 0.001145 8.6600n 0.001219 8.6700n 0.001305 8.6800n 0.001401 8.6900n 0.001507
+ 8.7000n 0.001620 8.7100n 0.001739 8.7200n 0.001863 8.7300n 0.001989 8.7400n 0.002114 8.7500n 0.002237 8.7600n 0.002356 8.7700n 0.002467 8.7800n 0.002569 8.7900n 0.002659 8.8000n 0.002734 8.8100n 0.002794 8.8200n 0.002836 8.8300n 0.002859 8.8400n 0.002861
+ 8.8500n 0.002841 8.8600n 0.002799 8.8700n 0.002733 8.8800n 0.002645 8.8900n 0.002534 8.9000n 0.002401 8.9100n 0.002247 8.9200n 0.002072 8.9300n 0.001879 8.9400n 0.001669 8.9500n 0.001444 8.9600n 0.001206 8.9700n 0.000957 8.9800n 0.000701 8.9900n 0.000438
+ 9.0000n 0.000172 9.0100n -0.000094 9.0200n -0.000359 9.0300n -0.000619 9.0400n -0.000873 9.0500n -0.001117 9.0600n -0.001351 9.0700n -0.001572 9.0800n -0.001779 9.0900n -0.001970 9.1000n -0.002143 9.1100n -0.002298 9.1200n -0.002435 9.1300n -0.002551 9.1400n -0.002648
+ 9.1500n -0.002726 9.1600n -0.002783 9.1700n -0.002821 9.1800n -0.002840 9.1900n -0.002841 9.2000n -0.002825 9.2100n -0.002792 9.2200n -0.002744 9.2300n -0.002683 9.2400n -0.002608 9.2500n -0.002523 9.2600n -0.002427 9.2700n -0.002324 9.2800n -0.002213 9.2900n -0.002097
+ 9.3000n -0.001977 9.3100n -0.001854 9.3200n -0.001730 9.3300n -0.001607 9.3400n -0.001485 9.3500n -0.001366 9.3600n -0.001252 9.3700n -0.001142 9.3800n -0.001039 9.3900n -0.000943 9.4000n -0.000856 9.4100n -0.000777 9.4200n -0.000708 9.4300n -0.000649 9.4400n -0.000600
+ 9.4500n -0.000563 9.4600n -0.000536 9.4700n -0.000521 9.4800n -0.000516 9.4900n -0.000522 9.5000n -0.000538 9.5100n -0.000564 9.5200n -0.000598 9.5300n -0.000640 9.5400n -0.000689 9.5500n -0.000743 9.5600n -0.000801 9.5700n -0.000862 9.5800n -0.000924 9.5900n -0.000985
+ 9.6000n -0.001044 9.6100n -0.001099 9.6200n -0.001147 9.6300n -0.001188 9.6400n -0.001219 9.6500n -0.001240 9.6600n -0.001248 9.6700n -0.001241 9.6800n -0.001220 9.6900n -0.001182 9.7000n -0.001128 9.7100n -0.001056 9.7200n -0.000966 9.7300n -0.000859 9.7400n -0.000735
+ 9.7500n -0.000595 9.7600n -0.000439 9.7700n -0.000269 9.7800n -0.000087 9.7900n 0.000106 9.8000n 0.000307 9.8100n 0.000514 9.8200n 0.000724 9.8300n 0.000934 9.8400n 0.001142 9.8500n 0.001345 9.8600n 0.001539 9.8700n 0.001721 9.8800n 0.001890 9.8900n 0.002041
+ 9.9000n 0.002173 9.9100n 0.002283 9.9200n 0.002369 9.9300n 0.002430 9.9400n 0.002464 9.9500n 0.002471 9.9600n 0.002449 9.9700n 0.002399 9.9800n 0.002322 9.9900n 0.002218 10.0000n 0.002088 10.0100n 0.001934 10.0200n 0.001759 10.0300n 0.001564 10.0400n 0.001354
+ 10.0500n 0.001130 10.0600n 0.000896 10.0700n 0.000655 10.0800n 0.000412 10.0900n 0.000170 10.1000n -0.000068 10.1100n -0.000299 10.1200n -0.000518 10.1300n -0.000722 10.1400n -0.000909 10.1500n -0.001077 10.1600n -0.001223 10.1700n -0.001345 10.1800n -0.001442 10.1900n -0.001514
+ 10.2000n -0.001560 10.2100n -0.001580 10.2200n -0.001574 10.2300n -0.001545 10.2400n -0.001493 10.2500n -0.001421 10.2600n -0.001331 10.2700n -0.001225 10.2800n -0.001106 10.2900n -0.000978 10.3000n -0.000844 10.3100n -0.000707 10.3200n -0.000570 10.3300n -0.000437 10.3400n -0.000311
+ 10.3500n -0.000195 10.3600n -0.000091 10.3700n -0.000001 10.3800n 0.000071 10.3900n 0.000126 10.4000n 0.000161 10.4100n 0.000175 10.4200n 0.000169 10.4300n 0.000143 10.4400n 0.000097 10.4500n 0.000033 10.4600n -0.000048 10.4700n -0.000145 10.4800n -0.000254 10.4900n -0.000373
+ 10.5000n -0.000500 10.5100n -0.000632 10.5200n -0.000764 10.5300n -0.000896 10.5400n -0.001022 10.5500n -0.001140 10.5600n -0.001248 10.5700n -0.001342 10.5800n -0.001420 10.5900n -0.001480 10.6000n -0.001520 10.6100n -0.001538 10.6200n -0.001534 10.6300n -0.001506 10.6400n -0.001455
+ 10.6500n -0.001380 10.6600n -0.001283 10.6700n -0.001165 10.6800n -0.001026 10.6900n -0.000869 10.7000n -0.000695 10.7100n -0.000508 10.7200n -0.000309 10.7300n -0.000102 10.7400n 0.000111 10.7500n 0.000327 10.7600n 0.000542 10.7700n 0.000754 10.7800n 0.000960 10.7900n 0.001156
+ 10.8000n 0.001342 10.8100n 0.001513 10.8200n 0.001669 10.8300n 0.001807 10.8400n 0.001926 10.8500n 0.002024 10.8600n 0.002101 10.8700n 0.002157 10.8800n 0.002190 10.8900n 0.002202 10.9000n 0.002192 10.9100n 0.002161 10.9200n 0.002110 10.9300n 0.002040 10.9400n 0.001953
+ 10.9500n 0.001850 10.9600n 0.001732 10.9700n 0.001601 10.9800n 0.001460 10.9900n 0.001308 11.0000n 0.001149 11.0100n 0.000984 11.0200n 0.000814 11.0300n 0.000641 11.0400n 0.000467 11.0500n 0.000292 11.0600n 0.000117 11.0700n -0.000056 11.0800n -0.000226 11.0900n -0.000393
+ 11.1000n -0.000556 11.1100n -0.000715 11.1200n -0.000869 11.1300n -0.001019 11.1400n -0.001163 11.1500n -0.001302 11.1600n -0.001435 11.1700n -0.001563 11.1800n -0.001685 11.1900n -0.001802 11.2000n -0.001914 11.2100n -0.002019 11.2200n -0.002118 11.2300n -0.002212 11.2400n -0.002299
+ 11.2500n -0.002380 11.2600n -0.002453 11.2700n -0.002520 11.2800n -0.002579 11.2900n -0.002631 11.3000n -0.002674 11.3100n -0.002709 11.3200n -0.002734 11.3300n -0.002751 11.3400n -0.002758 11.3500n -0.002756 11.3600n -0.002744 11.3700n -0.002722 11.3800n -0.002690 11.3900n -0.002648
+ 11.4000n -0.002596 11.4100n -0.002536 11.4200n -0.002466 11.4300n -0.002387 11.4400n -0.002301 11.4500n -0.002206 11.4600n -0.002105 11.4700n -0.001998 11.4800n -0.001884 11.4900n -0.001766 11.5000n -0.001644 11.5100n -0.001518 11.5200n -0.001389 11.5300n -0.001258 11.5400n -0.001126
+ 11.5500n -0.000992 11.5600n -0.000858 11.5700n -0.000724 11.5800n -0.000590 11.5900n -0.000457 11.6000n -0.000326 11.6100n -0.000195 11.6200n -0.000066 11.6300n 0.000062 11.6400n 0.000187 11.6500n 0.000311 11.6600n 0.000432 11.6700n 0.000551 11.6800n 0.000667 11.6900n 0.000780
+ 11.7000n 0.000890 11.7100n 0.000996 11.7200n 0.001097 11.7300n 0.001194 11.7400n 0.001285 11.7500n 0.001370 11.7600n 0.001447 11.7700n 0.001517 11.7800n 0.001578 11.7900n 0.001629 11.8000n 0.001669 11.8100n 0.001697 11.8200n 0.001713 11.8300n 0.001716 11.8400n 0.001705
+ 11.8500n 0.001678 11.8600n 0.001637 11.8700n 0.001580 11.8800n 0.001507 11.8900n 0.001420 11.9000n 0.001317 11.9100n 0.001199 11.9200n 0.001068 11.9300n 0.000925 11.9400n 0.000770 11.9500n 0.000606 11.9600n 0.000435 11.9700n 0.000258 11.9800n 0.000078 11.9900n -0.000104
+ 12.0000n -0.000283 12.0100n -0.000458 12.0200n -0.000626 12.0300n -0.000785 12.0400n -0.000932 12.0500n -0.001064 12.0600n -0.001179 12.0700n -0.001275 12.0800n -0.001351 12.0900n -0.001405 12.1000n -0.001436 12.1100n -0.001443 12.1200n -0.001425 12.1300n -0.001383 12.1400n -0.001318
+ 12.1500n -0.001230 12.1600n -0.001120 12.1700n -0.000990 12.1800n -0.000842 12.1900n -0.000680 12.2000n -0.000504 12.2100n -0.000319 12.2200n -0.000127 12.2300n 0.000067 12.2400n 0.000262 12.2500n 0.000453 12.2600n 0.000637 12.2700n 0.000812 12.2800n 0.000973 12.2900n 0.001119
+ 12.3000n 0.001247 12.3100n 0.001355 12.3200n 0.001442 12.3300n 0.001507 12.3400n 0.001548 12.3500n 0.001566 12.3600n 0.001561 12.3700n 0.001534 12.3800n 0.001487 12.3900n 0.001421 12.4000n 0.001339 12.4100n 0.001243 12.4200n 0.001137 12.4300n 0.001022 12.4400n 0.000904
+ 12.4500n 0.000785 12.4600n 0.000669 12.4700n 0.000559 12.4800n 0.000460 12.4900n 0.000373 12.5000n 0.000302 12.5100n 0.000250 12.5200n 0.000218 12.5300n 0.000209 12.5400n 0.000223 12.5500n 0.000261 12.5600n 0.000324 12.5700n 0.000410 12.5800n 0.000518 12.5900n 0.000648
+ 12.6000n 0.000796 12.6100n 0.000960 12.6200n 0.001137 12.6300n 0.001324 12.6400n 0.001516 12.6500n 0.001710 12.6600n 0.001902 12.6700n 0.002087 12.6800n 0.002261 12.6900n 0.002421 12.7000n 0.002562 12.7100n 0.002681 12.7200n 0.002775 12.7300n 0.002841 12.7400n 0.002877
+ 12.7500n 0.002882 12.7600n 0.002854 12.7700n 0.002794 12.7800n 0.002701 12.7900n 0.002577 12.8000n 0.002423 12.8100n 0.002242 12.8200n 0.002036 12.8300n 0.001809 12.8400n 0.001565 12.8500n 0.001308 12.8600n 0.001043 12.8700n 0.000774 12.8800n 0.000506 12.8900n 0.000244
+ 12.9000n -0.000007 12.9100n -0.000242 12.9200n -0.000458 12.9300n -0.000650 12.9400n -0.000815 12.9500n -0.000949 12.9600n -0.001050 12.9700n -0.001118 12.9800n -0.001149 12.9900n -0.001145 13.0000n -0.001104 13.0100n -0.001030 13.0200n -0.000922 13.0300n -0.000784 13.0400n -0.000618
+ 13.0500n -0.000428 13.0600n -0.000217 13.0700n 0.000009 13.0800n 0.000246 13.0900n 0.000490 13.1000n 0.000736 13.1100n 0.000978 13.1200n 0.001212 13.1300n 0.001433 13.1400n 0.001636 13.1500n 0.001819 13.1600n 0.001977 13.1700n 0.002107 13.1800n 0.002207 13.1900n 0.002276
+ 13.2000n 0.002312 13.2100n 0.002314 13.2200n 0.002283 13.2300n 0.002221 13.2400n 0.002128 13.2500n 0.002006 13.2600n 0.001860 13.2700n 0.001690 13.2800n 0.001502 13.2900n 0.001300 13.3000n 0.001087 13.3100n 0.000868 13.3200n 0.000647 13.3300n 0.000429 13.3400n 0.000218
+ 13.3500n 0.000019 13.3600n -0.000166 13.3700n -0.000333 13.3800n -0.000478 13.3900n -0.000600 13.4000n -0.000696 13.4100n -0.000766 13.4200n -0.000807 13.4300n -0.000822 13.4400n -0.000809 13.4500n -0.000770 13.4600n -0.000706 13.4700n -0.000621 13.4800n -0.000516 13.4900n -0.000394
+ 13.5000n -0.000259 13.5100n -0.000114 13.5200n 0.000037 13.5300n 0.000191 13.5400n 0.000342 13.5500n 0.000489 13.5600n 0.000626 13.5700n 0.000752 13.5800n 0.000863 13.5900n 0.000955 13.6000n 0.001029 13.6100n 0.001080 13.6200n 0.001109 13.6300n 0.001115 13.6400n 0.001098
+ 13.6500n 0.001057 13.6600n 0.000994 13.6700n 0.000911 13.6800n 0.000809 13.6900n 0.000690 13.7000n 0.000557 13.7100n 0.000413 13.7200n 0.000260 13.7300n 0.000103 13.7400n -0.000055 13.7500n -0.000212 13.7600n -0.000364 13.7700n -0.000508 13.7800n -0.000642 13.7900n -0.000761
+ 13.8000n -0.000866 13.8100n -0.000952 13.8200n -0.001020 13.8300n -0.001067 13.8400n -0.001094 13.8500n -0.001101 13.8600n -0.001087 13.8700n -0.001053 13.8800n -0.001001 13.8900n -0.000933 13.9000n -0.000850 13.9100n -0.000754 13.9200n -0.000649 13.9300n -0.000536 13.9400n -0.000419
+ 13.9500n -0.000301 13.9600n -0.000184 13.9700n -0.000071 13.9800n 0.000034 13.9900n 0.000130 14.0000n 0.000214 14.0100n 0.000284 14.0200n 0.000338 14.0300n 0.000375 14.0400n 0.000394 14.0500n 0.000394 14.0600n 0.000375 14.0700n 0.000338 14.0800n 0.000281 14.0900n 0.000208
+ 14.1000n 0.000117 14.1100n 0.000013 14.1200n -0.000105 14.1300n -0.000234 14.1400n -0.000371 14.1500n -0.000515 14.1600n -0.000663 14.1700n -0.000813 14.1800n -0.000962 14.1900n -0.001108 14.2000n -0.001249 14.2100n -0.001383 14.2200n -0.001508 14.2300n -0.001623 14.2400n -0.001726
+ 14.2500n -0.001816 14.2600n -0.001893 14.2700n -0.001956 14.2800n -0.002005 14.2900n -0.002040 14.3000n -0.002062 14.3100n -0.002072 14.3200n -0.002069 14.3300n -0.002057 14.3400n -0.002035 14.3500n -0.002005 14.3600n -0.001969 14.3700n -0.001929 14.3800n -0.001885 14.3900n -0.001840
+ 14.4000n -0.001795 14.4100n -0.001751 14.4200n -0.001710 14.4300n -0.001672 14.4400n -0.001639 14.4500n -0.001612 14.4600n -0.001591 14.4700n -0.001575 14.4800n -0.001567 14.4900n -0.001564 14.5000n -0.001567 14.5100n -0.001575 14.5200n -0.001588 14.5300n -0.001604 14.5400n -0.001623
+ 14.5500n -0.001643 14.5600n -0.001663 14.5700n -0.001682 14.5800n -0.001699 14.5900n -0.001713 14.6000n -0.001721 14.6100n -0.001724 14.6200n -0.001719 14.6300n -0.001706 14.6400n -0.001685 14.6500n -0.001654 14.6600n -0.001614 14.6700n -0.001564 14.6800n -0.001504 14.6900n -0.001433
+ 14.7000n -0.001354 14.7100n -0.001266 14.7200n -0.001169 14.7300n -0.001066 14.7400n -0.000956 14.7500n -0.000841 14.7600n -0.000723 14.7700n -0.000603 14.7800n -0.000482 14.7900n -0.000361 14.8000n -0.000243 14.8100n -0.000128 14.8200n -0.000019 14.8300n 0.000084 14.8400n 0.000180
+ 14.8500n 0.000267 14.8600n 0.000344 14.8700n 0.000410 14.8800n 0.000466 14.8900n 0.000510 14.9000n 0.000542 14.9100n 0.000562 14.9200n 0.000570 14.9300n 0.000567 14.9400n 0.000552 14.9500n 0.000528 14.9600n 0.000494 14.9700n 0.000451 14.9800n 0.000402 14.9900n 0.000346
+ 15.0000n 0.000286 15.0100n 0.000223 15.0200n 0.000158 15.0300n 0.000094 15.0400n 0.000031 15.0500n -0.000029 15.0600n -0.000084 15.0700n -0.000133 15.0800n -0.000174 15.0900n -0.000207 15.1000n -0.000230 15.1100n -0.000242 15.1200n -0.000242 15.1300n -0.000230 15.1400n -0.000205
+ 15.1500n -0.000168 15.1600n -0.000117 15.1700n -0.000053 15.1800n 0.000022 15.1900n 0.000110 15.2000n 0.000208 15.2100n 0.000317 15.2200n 0.000433 15.2300n 0.000557 15.2400n 0.000687 15.2500n 0.000821 15.2600n 0.000957 15.2700n 0.001093 15.2800n 0.001228 15.2900n 0.001359
+ 15.3000n 0.001485 15.3100n 0.001604 15.3200n 0.001714 15.3300n 0.001813 15.3400n 0.001900 15.3500n 0.001973 15.3600n 0.002031 15.3700n 0.002074 15.3800n 0.002099 15.3900n 0.002108 15.4000n 0.002100 15.4100n 0.002074 15.4200n 0.002032 15.4300n 0.001973 15.4400n 0.001900
+ 15.4500n 0.001812 15.4600n 0.001711 15.4700n 0.001600 15.4800n 0.001480 15.4900n 0.001353 15.5000n 0.001221 15.5100n 0.001087 15.5200n 0.000952 15.5300n 0.000821 15.5400n 0.000694 15.5500n 0.000574 15.5600n 0.000463 15.5700n 0.000364 15.5800n 0.000278 15.5900n 0.000207
+ 15.6000n 0.000151 15.6100n 0.000113 15.6200n 0.000093 15.6300n 0.000090 15.6400n 0.000105 15.6500n 0.000138 15.6600n 0.000187 15.6700n 0.000251 15.6800n 0.000329 15.6900n 0.000418 15.7000n 0.000517 15.7100n 0.000623 15.7200n 0.000733 15.7300n 0.000845 15.7400n 0.000955
+ 15.7500n 0.001060 15.7600n 0.001158 15.7700n 0.001245 15.7800n 0.001318 15.7900n 0.001376 15.8000n 0.001415 15.8100n 0.001434 15.8200n 0.001431 15.8300n 0.001405 15.8400n 0.001355 15.8500n 0.001280 15.8600n 0.001182 15.8700n 0.001061 15.8800n 0.000918 15.8900n 0.000755
+ 15.9000n 0.000574 15.9100n 0.000378 15.9200n 0.000170 15.9300n -0.000047 15.9400n -0.000268 15.9500n -0.000489 15.9600n -0.000707 15.9700n -0.000917 15.9800n -0.001114 15.9900n -0.001295 16.0000n -0.001456 16.0100n -0.001593 16.0200n -0.001703 16.0300n -0.001782 16.0400n -0.001828
+ 16.0500n -0.001840 16.0600n -0.001815 16.0700n -0.001754 16.0800n -0.001655 16.0900n -0.001521 16.1000n -0.001352 16.1100n -0.001151 16.1200n -0.000919 16.1300n -0.000661 16.1400n -0.000380 16.1500n -0.000081 16.1600n 0.000232 16.1700n 0.000553 16.1800n 0.000877 16.1900n 0.001199
+ 16.2000n 0.001513 16.2100n 0.001814 16.2200n 0.002095 16.2300n 0.002352 16.2400n 0.002581 16.2500n 0.002777 16.2600n 0.002936 16.2700n 0.003055 16.2800n 0.003132 16.2900n 0.003166 16.3000n 0.003154 16.3100n 0.003098 16.3200n 0.002998 16.3300n 0.002855 16.3400n 0.002672
+ 16.3500n 0.002452 16.3600n 0.002198 16.3700n 0.001915 16.3800n 0.001608 16.3900n 0.001281 16.4000n 0.000942 16.4100n 0.000595 16.4200n 0.000246 16.4300n -0.000098 16.4400n -0.000431 16.4500n -0.000749 16.4600n -0.001045 16.4700n -0.001314 16.4800n -0.001552 16.4900n -0.001756
+ 16.5000n -0.001921 16.5100n -0.002047 16.5200n -0.002130 16.5300n -0.002170 16.5400n -0.002167 16.5500n -0.002123 16.5600n -0.002037 16.5700n -0.001913 16.5800n -0.001753 16.5900n -0.001561 16.6000n -0.001342 16.6100n -0.001099 16.6200n -0.000837 16.6300n -0.000563 16.6400n -0.000280
+ 16.6500n 0.000005 16.6600n 0.000288 16.6700n 0.000563 16.6800n 0.000826 16.6900n 0.001072 16.7000n 0.001297 16.7100n 0.001498 16.7200n 0.001672 16.7300n 0.001817 16.7400n 0.001931 16.7500n 0.002014 16.7600n 0.002066 16.7700n 0.002087 16.7800n 0.002079 16.7900n 0.002042
+ 16.8000n 0.001981 16.8100n 0.001898 16.8200n 0.001795 16.8300n 0.001678 16.8400n 0.001549 16.8500n 0.001414 16.8600n 0.001275 16.8700n 0.001137 16.8800n 0.001003 16.8900n 0.000878 16.9000n 0.000765 16.9100n 0.000666 16.9200n 0.000584 16.9300n 0.000521 16.9400n 0.000477
+ 16.9500n 0.000454 16.9600n 0.000451 16.9700n 0.000468 16.9800n 0.000504 16.9900n 0.000557 17.0000n 0.000624 17.0100n 0.000703 17.0200n 0.000791 17.0300n 0.000884 17.0400n 0.000978 17.0500n 0.001070 17.0600n 0.001155 17.0700n 0.001231 17.0800n 0.001293 17.0900n 0.001337
+ 17.1000n 0.001361 17.1100n 0.001362 17.1200n 0.001338 17.1300n 0.001287 17.1400n 0.001208 17.1500n 0.001101 17.1600n 0.000966 17.1700n 0.000803 17.1800n 0.000614 17.1900n 0.000402 17.2000n 0.000169 17.2100n -0.000082 17.2200n -0.000346 17.2300n -0.000621 17.2400n -0.000901
+ 17.2500n -0.001182 17.2600n -0.001460 17.2700n -0.001728 17.2800n -0.001984 17.2900n -0.002221 17.3000n -0.002437 17.3100n -0.002627 17.3200n -0.002788 17.3300n -0.002917 17.3400n -0.003013 17.3500n -0.003073 17.3600n -0.003096 17.3700n -0.003083 17.3800n -0.003034 17.3900n -0.002951
+ 17.4000n -0.002835 17.4100n -0.002689 17.4200n -0.002516 17.4300n -0.002321 17.4400n -0.002107 17.4500n -0.001879 17.4600n -0.001641 17.4700n -0.001400 17.4800n -0.001159 17.4900n -0.000925 17.5000n -0.000701 17.5100n -0.000493 17.5200n -0.000306 17.5300n -0.000142 17.5400n -0.000006
+ 17.5500n 0.000100 17.5600n 0.000173 17.5700n 0.000213 17.5800n 0.000218 17.5900n 0.000188 17.6000n 0.000125 17.6100n 0.000028 17.6200n -0.000098 17.6300n -0.000253 17.6400n -0.000431 17.6500n -0.000630 17.6600n -0.000845 17.6700n -0.001071 17.6800n -0.001303 17.6900n -0.001536
+ 17.7000n -0.001766 17.7100n -0.001986 17.7200n -0.002192 17.7300n -0.002379 17.7400n -0.002542 17.7500n -0.002678 17.7600n -0.002784 17.7700n -0.002855 17.7800n -0.002891 17.7900n -0.002889 17.8000n -0.002849 17.8100n -0.002770 17.8200n -0.002653 17.8300n -0.002500 17.8400n -0.002311
+ 17.8500n -0.002091 17.8600n -0.001841 17.8700n -0.001566 17.8800n -0.001270 17.8900n -0.000957 17.9000n -0.000632 17.9100n -0.000301 17.9200n 0.000033 17.9300n 0.000363 17.9400n 0.000685 17.9500n 0.000994 17.9600n 0.001285 17.9700n 0.001555 17.9800n 0.001799 17.9900n 0.002015
+ 18.0000n 0.002199 18.0100n 0.002349 18.0200n 0.002464 18.0300n 0.002543 18.0400n 0.002585 18.0500n 0.002591 18.0600n 0.002562 18.0700n 0.002499 18.0800n 0.002404 18.0900n 0.002281 18.1000n 0.002131 18.1100n 0.001958 18.1200n 0.001765 18.1300n 0.001558 18.1400n 0.001338
+ 18.1500n 0.001111 18.1600n 0.000881 18.1700n 0.000651 18.1800n 0.000425 18.1900n 0.000207 18.2000n 0.000001 18.2100n -0.000192 18.2200n -0.000367 18.2300n -0.000524 18.2400n -0.000659 18.2500n -0.000772 18.2600n -0.000863 18.2700n -0.000929 18.2800n -0.000973 18.2900n -0.000993
+ 18.3000n -0.000991 18.3100n -0.000968 18.3200n -0.000925 18.3300n -0.000865 18.3400n -0.000789 18.3500n -0.000701 18.3600n -0.000601 18.3700n -0.000494 18.3800n -0.000381 18.3900n -0.000264 18.4000n -0.000148 18.4100n -0.000033 18.4200n 0.000078 18.4300n 0.000182 18.4400n 0.000278
+ 18.4500n 0.000365 18.4600n 0.000441 18.4700n 0.000505 18.4800n 0.000555 18.4900n 0.000593 18.5000n 0.000617 18.5100n 0.000628 18.5200n 0.000625 18.5300n 0.000611 18.5400n 0.000585 18.5500n 0.000548 18.5600n 0.000502 18.5700n 0.000448 18.5800n 0.000388 18.5900n 0.000322
+ 18.6000n 0.000254 18.6100n 0.000184 18.6200n 0.000114 18.6300n 0.000045 18.6400n -0.000020 18.6500n -0.000081 18.6600n -0.000137 18.6700n -0.000185 18.6800n -0.000226 18.6900n -0.000258 18.7000n -0.000281 18.7100n -0.000294 18.7200n -0.000297 18.7300n -0.000290 18.7400n -0.000272
+ 18.7500n -0.000245 18.7600n -0.000209 18.7700n -0.000164 18.7800n -0.000110 18.7900n -0.000050 18.8000n 0.000017 18.8100n 0.000090 18.8200n 0.000166 18.8300n 0.000246 18.8400n 0.000327 18.8500n 0.000409 18.8600n 0.000490 18.8700n 0.000569 18.8800n 0.000645 18.8900n 0.000716
+ 18.9000n 0.000782 18.9100n 0.000842 18.9200n 0.000894 18.9300n 0.000937 18.9400n 0.000971 18.9500n 0.000995 18.9600n 0.001008 18.9700n 0.001010 18.9800n 0.001001 18.9900n 0.000980 19.0000n 0.000947 19.0100n 0.000902 19.0200n 0.000846 19.0300n 0.000778 19.0400n 0.000699
+ 19.0500n 0.000609 19.0600n 0.000509 19.0700n 0.000400 19.0800n 0.000283 19.0900n 0.000158 19.1000n 0.000026 19.1100n -0.000111 19.1200n -0.000252 19.1300n -0.000396 19.1400n -0.000542 19.1500n -0.000689 19.1600n -0.000835 19.1700n -0.000978 19.1800n -0.001118 19.1900n -0.001254
+ 19.2000n -0.001383 19.2100n -0.001505 19.2200n -0.001619 19.2300n -0.001723 19.2400n -0.001817 19.2500n -0.001899 19.2600n -0.001969 19.2700n -0.002027 19.2800n -0.002070 19.2900n -0.002100 19.3000n -0.002116 19.3100n -0.002118 19.3200n -0.002105 19.3300n -0.002079 19.3400n -0.002038
+ 19.3500n -0.001985 19.3600n -0.001919 19.3700n -0.001840 19.3800n -0.001751 19.3900n -0.001652 19.4000n -0.001544 19.4100n -0.001428 19.4200n -0.001305 19.4300n -0.001178 19.4400n -0.001047 19.4500n -0.000913 19.4600n -0.000779 19.4700n -0.000645 19.4800n -0.000514 19.4900n -0.000386
+ 19.5000n -0.000263 19.5100n -0.000146 19.5200n -0.000037 19.5300n 0.000063 19.5400n 0.000153 19.5500n 0.000233 19.5600n 0.000301 19.5700n 0.000356 19.5800n 0.000398 19.5900n 0.000427 19.6000n 0.000442 19.6100n 0.000443 19.6200n 0.000431 19.6300n 0.000404 19.6400n 0.000365
+ 19.6500n 0.000313 19.6600n 0.000248 19.6700n 0.000173 19.6800n 0.000087 19.6900n -0.000008 19.7000n -0.000112 19.7100n -0.000222 19.7200n -0.000337 19.7300n -0.000456 19.7400n -0.000577 19.7500n -0.000699 19.7600n -0.000820 19.7700n -0.000939 19.7800n -0.001053 19.7900n -0.001162
+ 19.8000n -0.001263 19.8100n -0.001356 19.8200n -0.001438 19.8300n -0.001508 19.8400n -0.001566 19.8500n -0.001611 19.8600n -0.001641 19.8700n -0.001656 19.8800n -0.001655 19.8900n -0.001639 19.9000n -0.001606 19.9100n -0.001558 19.9200n -0.001495 19.9300n -0.001416 19.9400n -0.001324
+ 19.9500n -0.001219 19.9600n -0.001103 19.9700n -0.000976 19.9800n -0.000841 19.9900n -0.000698 20.0000n -0.000551 20.0100n -0.000401 20.0200n -0.000250 20.0300n -0.000100 20.0400n 0.000046 20.0500n 0.000187 20.0600n 0.000321 20.0700n 0.000445 20.0800n 0.000558 20.0900n 0.000658
+ 20.1000n 0.000743 20.1100n 0.000813 20.1200n 0.000866 20.1300n 0.000901 20.1400n 0.000918 20.1500n 0.000917 20.1600n 0.000897 20.1700n 0.000858 20.1800n 0.000803 20.1900n 0.000731 20.2000n 0.000643 20.2100n 0.000542 20.2200n 0.000428 20.2300n 0.000305 20.2400n 0.000173
+ 20.2500n 0.000035 20.2600n -0.000107 20.2700n -0.000250 20.2800n -0.000392 20.2900n -0.000530 20.3000n -0.000662 20.3100n -0.000786 20.3200n -0.000900 20.3300n -0.001003 20.3400n -0.001091 20.3500n -0.001165 20.3600n -0.001223 20.3700n -0.001263 20.3800n -0.001287 20.3900n -0.001294
+ 20.4000n -0.001283 20.4100n -0.001257 20.4200n -0.001214 20.4300n -0.001158 20.4400n -0.001088 20.4500n -0.001008 20.4600n -0.000918 20.4700n -0.000821 20.4800n -0.000720 20.4900n -0.000616 20.5000n -0.000513 20.5100n -0.000411 20.5200n -0.000314 20.5300n -0.000224 20.5400n -0.000142
+ 20.5500n -0.000071 20.5600n -0.000011 20.5700n 0.000035 20.5800n 0.000067 20.5900n 0.000085 20.6000n 0.000089 20.6100n 0.000078 20.6200n 0.000053 20.6300n 0.000015 20.6400n -0.000035 20.6500n -0.000095 20.6600n -0.000164 20.6700n -0.000239 20.6800n -0.000319 20.6900n -0.000401
+ 20.7000n -0.000482 20.7100n -0.000560 20.7200n -0.000633 20.7300n -0.000698 20.7400n -0.000753 20.7500n -0.000797 20.7600n -0.000827 20.7700n -0.000842 20.7800n -0.000841 20.7900n -0.000823 20.8000n -0.000788 20.8100n -0.000736 20.8200n -0.000667 20.8300n -0.000582 20.8400n -0.000483
+ 20.8500n -0.000370 20.8600n -0.000247 20.8700n -0.000115 20.8800n 0.000024 20.8900n 0.000166 20.9000n 0.000309 20.9100n 0.000450 20.9200n 0.000585 20.9300n 0.000713 20.9400n 0.000830 20.9500n 0.000934 20.9600n 0.001022 20.9700n 0.001092 20.9800n 0.001143 20.9900n 0.001173
+ 21.0000n 0.001182 21.0100n 0.001168 21.0200n 0.001134 21.0300n 0.001077 21.0400n 0.001001 21.0500n 0.000906 21.0600n 0.000794 21.0700n 0.000668 21.0800n 0.000531 21.0900n 0.000384 21.1000n 0.000232 21.1100n 0.000078 21.1200n -0.000074 21.1300n -0.000222 21.1400n -0.000361
+ 21.1500n -0.000488 21.1600n -0.000601 21.1700n -0.000695 21.1800n -0.000769 21.1900n -0.000821 21.2000n -0.000849 21.2100n -0.000851 21.2200n -0.000827 21.2300n -0.000777 21.2400n -0.000701 21.2500n -0.000600 21.2600n -0.000475 21.2700n -0.000329 21.2800n -0.000163 21.2900n 0.000019
+ 21.3000n 0.000214 21.3100n 0.000420 21.3200n 0.000631 21.3300n 0.000845 21.3400n 0.001058 21.3500n 0.001265 21.3600n 0.001464 21.3700n 0.001650 21.3800n 0.001820 21.3900n 0.001973 21.4000n 0.002104 21.4100n 0.002211 21.4200n 0.002294 21.4300n 0.002352 21.4400n 0.002382
+ 21.4500n 0.002387 21.4600n 0.002366 21.4700n 0.002320 21.4800n 0.002250 21.4900n 0.002160 21.5000n 0.002051 21.5100n 0.001927 21.5200n 0.001789 21.5300n 0.001643 21.5400n 0.001490 21.5500n 0.001335 21.5600n 0.001181 21.5700n 0.001032 21.5800n 0.000891 21.5900n 0.000760
+ 21.6000n 0.000642 21.6100n 0.000541 21.6200n 0.000456 21.6300n 0.000390 21.6400n 0.000344 21.6500n 0.000318 21.6600n 0.000311 21.6700n 0.000324 21.6800n 0.000355 21.6900n 0.000401 21.7000n 0.000462 21.7100n 0.000535 21.7200n 0.000617 21.7300n 0.000705 21.7400n 0.000796
+ 21.7500n 0.000888 21.7600n 0.000976 21.7700n 0.001058 21.7800n 0.001131 21.7900n 0.001192 21.8000n 0.001239 21.8100n 0.001271 21.8200n 0.001285 21.8300n 0.001280 21.8400n 0.001256 21.8500n 0.001213 21.8600n 0.001152 21.8700n 0.001072 21.8800n 0.000977 21.8900n 0.000866
+ 21.9000n 0.000744 21.9100n 0.000612 21.9200n 0.000474 21.9300n 0.000332 21.9400n 0.000191 21.9500n 0.000052 21.9600n -0.000079 21.9700n -0.000201 21.9800n -0.000309 21.9900n -0.000402 22.0000n -0.000477 22.0100n -0.000531 22.0200n -0.000563 22.0300n -0.000572 22.0400n -0.000557
+ 22.0500n -0.000519 22.0600n -0.000459 22.0700n -0.000376 22.0800n -0.000274 22.0900n -0.000153 22.1000n -0.000018 22.1100n 0.000129 22.1200n 0.000285 22.1300n 0.000446 22.1400n 0.000607 22.1500n 0.000766 22.1600n 0.000917 22.1700n 0.001057 22.1800n 0.001183 22.1900n 0.001290
+ 22.2000n 0.001376 22.2100n 0.001438 22.2200n 0.001474 22.2300n 0.001482 22.2400n 0.001461 22.2500n 0.001411 22.2600n 0.001333 22.2700n 0.001226 22.2800n 0.001092 22.2900n 0.000935 22.3000n 0.000756 22.3100n 0.000558 22.3200n 0.000346 22.3300n 0.000123 22.3400n -0.000107
+ 22.3500n -0.000338 22.3600n -0.000566 22.3700n -0.000787 22.3800n -0.000995 22.3900n -0.001188 22.4000n -0.001360 22.4100n -0.001508 22.4200n -0.001629 22.4300n -0.001721 22.4400n -0.001781 22.4500n -0.001807 22.4600n -0.001800 22.4700n -0.001759 22.4800n -0.001685 22.4900n -0.001579
+ 22.5000n -0.001444 22.5100n -0.001281 22.5200n -0.001094 22.5300n -0.000886 22.5400n -0.000662 22.5500n -0.000426 22.5600n -0.000183 22.5700n 0.000064 22.5800n 0.000309 22.5900n 0.000548 22.6000n 0.000776 22.6100n 0.000990 22.6200n 0.001184 22.6300n 0.001358 22.6400n 0.001506
+ 22.6500n 0.001629 22.6600n 0.001722 22.6700n 0.001787 22.6800n 0.001822 22.6900n 0.001828 22.7000n 0.001806 22.7100n 0.001758 22.7200n 0.001685 22.7300n 0.001590 22.7400n 0.001477 22.7500n 0.001350 22.7600n 0.001210 22.7700n 0.001064 22.7800n 0.000914 22.7900n 0.000765
+ 22.8000n 0.000620 22.8100n 0.000484 22.8200n 0.000359 22.8300n 0.000249 22.8400n 0.000157 22.8500n 0.000083 22.8600n 0.000031 22.8700n 0.000000 22.8800n -0.000008 22.8900n 0.000005 22.9000n 0.000040 22.9100n 0.000095 22.9200n 0.000167 22.9300n 0.000255 22.9400n 0.000356
+ 22.9500n 0.000466 22.9600n 0.000582 22.9700n 0.000701 22.9800n 0.000818 22.9900n 0.000931 23.0000n 0.001035 23.0100n 0.001127 23.0200n 0.001204 23.0300n 0.001264 23.0400n 0.001303 23.0500n 0.001320 23.0600n 0.001314 23.0700n 0.001284 23.0800n 0.001229 23.0900n 0.001150
+ 23.1000n 0.001049 23.1100n 0.000926 23.1200n 0.000783 23.1300n 0.000624 23.1400n 0.000451 23.1500n 0.000267 23.1600n 0.000077 23.1700n -0.000117 23.1800n -0.000310 23.1900n -0.000497 23.2000n -0.000677 23.2100n -0.000844 23.2200n -0.000995 23.2300n -0.001128 23.2400n -0.001240
+ 23.2500n -0.001328 23.2600n -0.001391 23.2700n -0.001427 23.2800n -0.001437 23.2900n -0.001421 23.3000n -0.001379 23.3100n -0.001312 23.3200n -0.001223 23.3300n -0.001114 23.3400n -0.000988 23.3500n -0.000847 23.3600n -0.000697 23.3700n -0.000539 23.3800n -0.000380 23.3900n -0.000221
+ 23.4000n -0.000068 23.4100n 0.000075 23.4200n 0.000206 23.4300n 0.000321 23.4400n 0.000416 23.4500n 0.000490 23.4600n 0.000541 23.4700n 0.000567 23.4800n 0.000567 23.4900n 0.000541 23.5000n 0.000490 23.5100n 0.000415 23.5200n 0.000317 23.5300n 0.000199 23.5400n 0.000064
+ 23.5500n -0.000086 23.5600n -0.000247 23.5700n -0.000414 23.5800n -0.000584 23.5900n -0.000753 23.6000n -0.000916 23.6100n -0.001069 23.6200n -0.001207 23.6300n -0.001328 23.6400n -0.001428 23.6500n -0.001503 23.6600n -0.001551 23.6700n -0.001570 23.6800n -0.001558 23.6900n -0.001515
+ 23.7000n -0.001440 23.7100n -0.001333 23.7200n -0.001195 23.7300n -0.001029 23.7400n -0.000835 23.7500n -0.000618 23.7600n -0.000379 23.7700n -0.000122 23.7800n 0.000149 23.7900n 0.000429 23.8000n 0.000715 23.8100n 0.001002 23.8200n 0.001286 23.8300n 0.001563 23.8400n 0.001828
+ 23.8500n 0.002079 23.8600n 0.002311 23.8700n 0.002521 23.8800n 0.002707 23.8900n 0.002866 23.9000n 0.002997 23.9100n 0.003098 23.9200n 0.003170 23.9300n 0.003211 23.9400n 0.003223 23.9500n 0.003205 23.9600n 0.003160 23.9700n 0.003088 23.9800n 0.002993 23.9900n 0.002875
+ 24.0000n 0.002739 24.0100n 0.002586 24.0200n 0.002419 24.0300n 0.002242 24.0400n 0.002056 24.0500n 0.001865 24.0600n 0.001672 24.0700n 0.001478 24.0800n 0.001285 24.0900n 0.001096 24.1000n 0.000913 24.1100n 0.000735 24.1200n 0.000566 24.1300n 0.000404 24.1400n 0.000251
+ 24.1500n 0.000107 24.1600n -0.000029 24.1700n -0.000156 24.1800n -0.000276 24.1900n -0.000389 24.2000n -0.000495 24.2100n -0.000595 24.2200n -0.000690 24.2300n -0.000781 24.2400n -0.000869 24.2500n -0.000953 24.2600n -0.001035 24.2700n -0.001113 24.2800n -0.001190 24.2900n -0.001263
+ 24.3000n -0.001333 24.3100n -0.001399 24.3200n -0.001460 24.3300n -0.001515 24.3400n -0.001564 24.3500n -0.001604 24.3600n -0.001635 24.3700n -0.001656 24.3800n -0.001664 24.3900n -0.001660 24.4000n -0.001642 24.4100n -0.001609 24.4200n -0.001560 24.4300n -0.001495 24.4400n -0.001415
+ 24.4500n -0.001318 24.4600n -0.001206 24.4700n -0.001079 24.4800n -0.000939 24.4900n -0.000787 24.5000n -0.000625 24.5100n -0.000455 24.5200n -0.000279 24.5300n -0.000101 24.5400n 0.000078 24.5500n 0.000254 24.5600n 0.000424 24.5700n 0.000585 24.5800n 0.000735 24.5900n 0.000871
+ 24.6000n 0.000989 24.6100n 0.001089 24.6200n 0.001168 24.6300n 0.001224 24.6400n 0.001257 24.6500n 0.001264 24.6600n 0.001248 24.6700n 0.001206 24.6800n 0.001141 24.6900n 0.001054 24.7000n 0.000946 24.7100n 0.000819 24.7200n 0.000676 24.7300n 0.000520 24.7400n 0.000354
+ 24.7500n 0.000182 24.7600n 0.000008 24.7700n -0.000166 24.7800n -0.000334 24.7900n -0.000494 24.8000n -0.000642 24.8100n -0.000774 24.8200n -0.000887 24.8300n -0.000979 24.8400n -0.001048 24.8500n -0.001091 24.8600n -0.001107 24.8700n -0.001097 24.8800n -0.001058 24.8900n -0.000993
+ 24.9000n -0.000902 24.9100n -0.000787 24.9200n -0.000650 24.9300n -0.000493 24.9400n -0.000319 24.9500n -0.000133 24.9600n 0.000063 24.9700n 0.000264 24.9800n 0.000465 24.9900n 0.000664 25.0000n 0.000855 25.0100n 0.001035 25.0200n 0.001199 25.0300n 0.001345 25.0400n 0.001468
+ 25.0500n 0.001566 25.0600n 0.001636 25.0700n 0.001677 25.0800n 0.001688 25.0900n 0.001667 25.1000n 0.001615 25.1100n 0.001532 25.1200n 0.001419 25.1300n 0.001279 25.1400n 0.001112 25.1500n 0.000923 25.1600n 0.000715 25.1700n 0.000490 25.1800n 0.000253 25.1900n 0.000007
+ 25.2000n -0.000242 25.2100n -0.000491 25.2200n -0.000735 25.2300n -0.000970 25.2400n -0.001193 25.2500n -0.001400 25.2600n -0.001587 25.2700n -0.001751 25.2800n -0.001890 25.2900n -0.002002 25.3000n -0.002086 25.3100n -0.002140 25.3200n -0.002165 25.3300n -0.002160 25.3400n -0.002126
+ 25.3500n -0.002064 25.3600n -0.001977 25.3700n -0.001867 25.3800n -0.001735 25.3900n -0.001585 25.4000n -0.001420 25.4100n -0.001243 25.4200n -0.001059 25.4300n -0.000870 25.4400n -0.000679 25.4500n -0.000491 25.4600n -0.000309 25.4700n -0.000135 25.4800n 0.000027 25.4900n 0.000175
+ 25.5000n 0.000307 25.5100n 0.000421 25.5200n 0.000515 25.5300n 0.000589 25.5400n 0.000641 25.5500n 0.000672 25.5600n 0.000682 25.5700n 0.000671 25.5800n 0.000639 25.5900n 0.000589 25.6000n 0.000522 25.6100n 0.000439 25.6200n 0.000342 25.6300n 0.000232 25.6400n 0.000113
+ 25.6500n -0.000015 25.6600n -0.000149 25.6700n -0.000287 25.6800n -0.000427 25.6900n -0.000568 25.7000n -0.000708 25.7100n -0.000845 25.7200n -0.000978 25.7300n -0.001106 25.7400n -0.001228 25.7500n -0.001344 25.7600n -0.001451 25.7700n -0.001551 25.7800n -0.001642 25.7900n -0.001725
+ 25.8000n -0.001799 25.8100n -0.001864 25.8200n -0.001921 25.8300n -0.001968 25.8400n -0.002007 25.8500n -0.002037 25.8600n -0.002058 25.8700n -0.002070 25.8800n -0.002073 25.8900n -0.002067 25.9000n -0.002051 25.9100n -0.002025 25.9200n -0.001989 25.9300n -0.001942 25.9400n -0.001884
+ 25.9500n -0.001815 25.9600n -0.001735 25.9700n -0.001642 25.9800n -0.001538 25.9900n -0.001421 26.0000n -0.001293 26.0100n -0.001153 26.0200n -0.001003 26.0300n -0.000842 26.0400n -0.000672 26.0500n -0.000494 26.0600n -0.000310 26.0700n -0.000121 26.0800n 0.000071 26.0900n 0.000264
+ 26.1000n 0.000456 26.1100n 0.000643 26.1200n 0.000824 26.1300n 0.000995 26.1400n 0.001154 26.1500n 0.001299 26.1600n 0.001427 26.1700n 0.001536 26.1800n 0.001622 26.1900n 0.001685 26.2000n 0.001722 26.2100n 0.001732 26.2200n 0.001714 26.2300n 0.001668 26.2400n 0.001593
+ 26.2500n 0.001490 26.2600n 0.001359 26.2700n 0.001202 26.2800n 0.001021 26.2900n 0.000817 26.3000n 0.000594 26.3100n 0.000354 26.3200n 0.000102 26.3300n -0.000160 26.3400n -0.000427 26.3500n -0.000696 26.3600n -0.000961 26.3700n -0.001219 26.3800n -0.001465 26.3900n -0.001696
+ 26.4000n -0.001907 26.4100n -0.002095 26.4200n -0.002257 26.4300n -0.002390 26.4400n -0.002490 26.4500n -0.002558 26.4600n -0.002591 26.4700n -0.002588 26.4800n -0.002551 26.4900n -0.002478 26.5000n -0.002372 26.5100n -0.002234 26.5200n -0.002067 26.5300n -0.001873 26.5400n -0.001657
+ 26.5500n -0.001421 26.5600n -0.001170 26.5700n -0.000909 26.5800n -0.000641 26.5900n -0.000373 26.6000n -0.000109 26.6100n 0.000147 26.6200n 0.000390 26.6300n 0.000615 26.6400n 0.000818 26.6500n 0.000996 26.6600n 0.001146 26.6700n 0.001264 26.6800n 0.001349 26.6900n 0.001399
+ 26.7000n 0.001412 26.7100n 0.001390 26.7200n 0.001331 26.7300n 0.001237 26.7400n 0.001110 26.7500n 0.000952 26.7600n 0.000764 26.7700n 0.000551 26.7800n 0.000316 26.7900n 0.000063 26.8000n -0.000205 26.8100n -0.000482 26.8200n -0.000765 26.8300n -0.001048 26.8400n -0.001328
+ 26.8500n -0.001600 26.8600n -0.001859 26.8700n -0.002104 26.8800n -0.002329 26.8900n -0.002531 26.9000n -0.002709 26.9100n -0.002860 26.9200n -0.002983 26.9300n -0.003075 26.9400n -0.003137 26.9500n -0.003169 26.9600n -0.003171 26.9700n -0.003144 26.9800n -0.003089 26.9900n -0.003008
+ 27.0000n -0.002904 27.0100n -0.002779 27.0200n -0.002635 27.0300n -0.002476 27.0400n -0.002304 27.0500n -0.002123 27.0600n -0.001936 27.0700n -0.001745 27.0800n -0.001554 27.0900n -0.001366 27.1000n -0.001183 27.1100n -0.001008 27.1200n -0.000841 27.1300n -0.000686 27.1400n -0.000543
+ 27.1500n -0.000413 27.1600n -0.000298 27.1700n -0.000196 27.1800n -0.000109 27.1900n -0.000036 27.2000n 0.000025 27.2100n 0.000073 27.2200n 0.000110 27.2300n 0.000138 27.2400n 0.000157 27.2500n 0.000169 27.2600n 0.000177 27.2700n 0.000182 27.2800n 0.000184 27.2900n 0.000187
+ 27.3000n 0.000190 27.3100n 0.000197 27.3200n 0.000207 27.3300n 0.000221 27.3400n 0.000241 27.3500n 0.000267 27.3600n 0.000298 27.3700n 0.000336 27.3800n 0.000379 27.3900n 0.000428 27.4000n 0.000481 27.4100n 0.000539 27.4200n 0.000599 27.4300n 0.000661 27.4400n 0.000724
+ 27.4500n 0.000786 27.4600n 0.000847 27.4700n 0.000904 27.4800n 0.000956 27.4900n 0.001003 27.5000n 0.001043 27.5100n 0.001075 27.5200n 0.001098 27.5300n 0.001112 27.5400n 0.001116 27.5500n 0.001110 27.5600n 0.001094 27.5700n 0.001067 27.5800n 0.001031 27.5900n 0.000985
+ 27.6000n 0.000930 27.6100n 0.000867 27.6200n 0.000797 27.6300n 0.000722 27.6400n 0.000642 27.6500n 0.000558 27.6600n 0.000473 27.6700n 0.000387 27.6800n 0.000301 27.6900n 0.000219 27.7000n 0.000139 27.7100n 0.000065 27.7200n -0.000004 27.7300n -0.000066 27.7400n -0.000120
+ 27.7500n -0.000165 27.7600n -0.000201 27.7700n -0.000228 27.7800n -0.000244 27.7900n -0.000252 27.8000n -0.000249 27.8100n -0.000238 27.8200n -0.000217 27.8300n -0.000189 27.8400n -0.000154 27.8500n -0.000112 27.8600n -0.000065 27.8700n -0.000014 27.8800n 0.000041 27.8900n 0.000096
+ 27.9000n 0.000152 27.9100n 0.000207 27.9200n 0.000260 27.9300n 0.000310 27.9400n 0.000355 27.9500n 0.000395 27.9600n 0.000428 27.9700n 0.000454 27.9800n 0.000472 27.9900n 0.000481 28.0000n 0.000482 28.0100n 0.000473 28.0200n 0.000456 28.0300n 0.000429 28.0400n 0.000394
+ 28.0500n 0.000350 28.0600n 0.000300 28.0700n 0.000242 28.0800n 0.000179 28.0900n 0.000111 28.1000n 0.000040 28.1100n -0.000033 28.1200n -0.000106 28.1300n -0.000179 28.1400n -0.000249 28.1500n -0.000315 28.1600n -0.000375 28.1700n -0.000428 28.1800n -0.000472 28.1900n -0.000506
+ 28.2000n -0.000529 28.2100n -0.000538 28.2200n -0.000534 28.2300n -0.000515 28.2400n -0.000480 28.2500n -0.000429 28.2600n -0.000361 28.2700n -0.000276 28.2800n -0.000174 28.2900n -0.000056 28.3000n 0.000079 28.3100n 0.000228 28.3200n 0.000392 28.3300n 0.000569 28.3400n 0.000758
+ 28.3500n 0.000957 28.3600n 0.001164 28.3700n 0.001377 28.3800n 0.001593 28.3900n 0.001812 28.4000n 0.002030 28.4100n 0.002245 28.4200n 0.002453 28.4300n 0.002654 28.4400n 0.002844 28.4500n 0.003021 28.4600n 0.003182 28.4700n 0.003326 28.4800n 0.003450 28.4900n 0.003553
+ 28.5000n 0.003633 28.5100n 0.003688 28.5200n 0.003717 28.5300n 0.003720 28.5400n 0.003697 28.5500n 0.003646 28.5600n 0.003568 28.5700n 0.003464 28.5800n 0.003335 28.5900n 0.003181 28.6000n 0.003003 28.6100n 0.002805 28.6200n 0.002587 28.6300n 0.002352 28.6400n 0.002102
+ 28.6500n 0.001839 28.6600n 0.001568 28.6700n 0.001289 28.6800n 0.001007 28.6900n 0.000723 28.7000n 0.000442 28.7100n 0.000165 28.7200n -0.000105 28.7300n -0.000364 28.7400n -0.000611 28.7500n -0.000844 28.7600n -0.001060 28.7700n -0.001258 28.7800n -0.001436 28.7900n -0.001593
+ 28.8000n -0.001728 28.8100n -0.001841 28.8200n -0.001931 28.8300n -0.001999 28.8400n -0.002044 28.8500n -0.002068 28.8600n -0.002071 28.8700n -0.002055 28.8800n -0.002020 28.8900n -0.001968 28.9000n -0.001900 28.9100n -0.001819 28.9200n -0.001726 28.9300n -0.001623 28.9400n -0.001512
+ 28.9500n -0.001395 28.9600n -0.001274 28.9700n -0.001150 28.9800n -0.001025 28.9900n -0.000901 29.0000n -0.000780 29.0100n -0.000661 29.0200n -0.000548 29.0300n -0.000440 29.0400n -0.000338 29.0500n -0.000244 29.0600n -0.000158 29.0700n -0.000079 29.0800n -0.000008 29.0900n 0.000054
+ 29.1000n 0.000109 29.1100n 0.000156 29.1200n 0.000195 29.1300n 0.000227 29.1400n 0.000253 29.1500n 0.000272 29.1600n 0.000286 29.1700n 0.000295 29.1800n 0.000299 29.1900n 0.000300 29.2000n 0.000298 29.2100n 0.000293 29.2200n 0.000285 29.2300n 0.000276 29.2400n 0.000266
+ 29.2500n 0.000255 29.2600n 0.000243 29.2700n 0.000232 29.2800n 0.000220 29.2900n 0.000209 29.3000n 0.000199 29.3100n 0.000191 29.3200n 0.000183 29.3300n 0.000178 29.3400n 0.000174 29.3500n 0.000173 29.3600n 0.000175 29.3700n 0.000179 29.3800n 0.000187 29.3900n 0.000198
+ 29.4000n 0.000214 29.4100n 0.000234 29.4200n 0.000258 29.4300n 0.000287 29.4400n 0.000321 29.4500n 0.000360 29.4600n 0.000405 29.4700n 0.000455 29.4800n 0.000510 29.4900n 0.000571 29.5000n 0.000636 29.5100n 0.000706 29.5200n 0.000780 29.5300n 0.000857 29.5400n 0.000937
+ 29.5500n 0.001019 29.5600n 0.001102 29.5700n 0.001185 29.5800n 0.001266 29.5900n 0.001345 29.6000n 0.001421 29.6100n 0.001491 29.6200n 0.001554 29.6300n 0.001610 29.6400n 0.001657 29.6500n 0.001694 29.6600n 0.001719 29.6700n 0.001733 29.6800n 0.001733 29.6900n 0.001720
+ 29.7000n 0.001692 29.7100n 0.001650 29.7200n 0.001594 29.7300n 0.001524 29.7400n 0.001440 29.7500n 0.001343 29.7600n 0.001234 29.7700n 0.001114 29.7800n 0.000985 29.7900n 0.000848 29.8000n 0.000705 29.8100n 0.000558 29.8200n 0.000409 29.8300n 0.000261 29.8400n 0.000115
+ 29.8500n -0.000027 29.8600n -0.000162 29.8700n -0.000289 29.8800n -0.000405 29.8900n -0.000508 29.9000n -0.000597 29.9100n -0.000672 29.9200n -0.000730 29.9300n -0.000770 29.9400n -0.000794 29.9500n -0.000799 29.9600n -0.000787 29.9700n -0.000758 29.9800n -0.000713 29.9900n -0.000652
+ 30.0000n -0.000577 30.0100n -0.000491 30.0200n -0.000394 30.0300n -0.000289 30.0400n -0.000177 30.0500n -0.000062 30.0600n 0.000054 30.0700n 0.000170 30.0800n 0.000282 30.0900n 0.000390 30.1000n 0.000490 30.1100n 0.000580 30.1200n 0.000660 30.1300n 0.000728 30.1400n 0.000782
+ 30.1500n 0.000823 30.1600n 0.000849 30.1700n 0.000861 30.1800n 0.000859 30.1900n 0.000844 30.2000n 0.000816 30.2100n 0.000777 30.2200n 0.000729 30.2300n 0.000673 30.2400n 0.000612 30.2500n 0.000547 30.2600n 0.000480 30.2700n 0.000415 30.2800n 0.000354 30.2900n 0.000298
+ 30.3000n 0.000250 30.3100n 0.000213 30.3200n 0.000187 30.3300n 0.000175 30.3400n 0.000178 30.3500n 0.000196 30.3600n 0.000231 30.3700n 0.000282 30.3800n 0.000350 30.3900n 0.000433 30.4000n 0.000532 30.4100n 0.000644 30.4200n 0.000768 30.4300n 0.000902 30.4400n 0.001045
+ 30.4500n 0.001192 30.4600n 0.001343 30.4700n 0.001493 30.4800n 0.001641 30.4900n 0.001783 30.5000n 0.001916 30.5100n 0.002039 30.5200n 0.002147 30.5300n 0.002240 30.5400n 0.002315 30.5500n 0.002370 30.5600n 0.002405 30.5700n 0.002417 30.5800n 0.002406 30.5900n 0.002373
+ 30.6000n 0.002317 30.6100n 0.002239 30.6200n 0.002141 30.6300n 0.002023 30.6400n 0.001888 30.6500n 0.001737 30.6600n 0.001574 30.6700n 0.001400 30.6800n 0.001219 30.6900n 0.001034 30.7000n 0.000847 30.7100n 0.000662 30.7200n 0.000481 30.7300n 0.000308 30.7400n 0.000145
+ 30.7500n -0.000005 30.7600n -0.000141 30.7700n -0.000260 30.7800n -0.000362 30.7900n -0.000444 30.8000n -0.000506 30.8100n -0.000548 30.8200n -0.000571 30.8300n -0.000574 30.8400n -0.000558 30.8500n -0.000525 30.8600n -0.000476 30.8700n -0.000414 30.8800n -0.000340 30.8900n -0.000257
+ 30.9000n -0.000167 30.9100n -0.000074 30.9200n 0.000021 30.9300n 0.000114 30.9400n 0.000203 30.9500n 0.000286 30.9600n 0.000359 30.9700n 0.000422 30.9800n 0.000471 30.9900n 0.000505 31.0000n 0.000524 31.0100n 0.000525 31.0200n 0.000508 31.0300n 0.000474 31.0400n 0.000421
+ 31.0500n 0.000351 31.0600n 0.000264 31.0700n 0.000160 31.0800n 0.000042 31.0900n -0.000089 31.1000n -0.000232 31.1100n -0.000385 31.1200n -0.000545 31.1300n -0.000711 31.1400n -0.000881 31.1500n -0.001052 31.1600n -0.001222 31.1700n -0.001389 31.1800n -0.001552 31.1900n -0.001709
+ 31.2000n -0.001858 31.2100n -0.001998 31.2200n -0.002128 31.2300n -0.002246 31.2400n -0.002353 31.2500n -0.002447 31.2600n -0.002529 31.2700n -0.002598 31.2800n -0.002655 31.2900n -0.002699 31.3000n -0.002733 31.3100n -0.002755 31.3200n -0.002767 31.3300n -0.002770 31.3400n -0.002765
+ 31.3500n -0.002751 31.3600n -0.002732 31.3700n -0.002706 31.3800n -0.002676 31.3900n -0.002641 31.4000n -0.002603 31.4100n -0.002562 31.4200n -0.002519 31.4300n -0.002473 31.4400n -0.002425 31.4500n -0.002376 31.4600n -0.002325 31.4700n -0.002273 31.4800n -0.002219 31.4900n -0.002163
+ 31.5000n -0.002104 31.5100n -0.002043 31.5200n -0.001980 31.5300n -0.001913 31.5400n -0.001844 31.5500n -0.001771 31.5600n -0.001695 31.5700n -0.001615 31.5800n -0.001532 31.5900n -0.001445 31.6000n -0.001356 31.6100n -0.001263 31.6200n -0.001168 31.6300n -0.001071 31.6400n -0.000973
+ 31.6500n -0.000873 31.6600n -0.000774 31.6700n -0.000675 31.6800n -0.000577 31.6900n -0.000481 31.7000n -0.000387 31.7100n -0.000297 31.7200n -0.000210 31.7300n -0.000128 31.7400n -0.000051 31.7500n 0.000021 31.7600n 0.000088 31.7700n 0.000149 31.7800n 0.000204 31.7900n 0.000254
+ 31.8000n 0.000299 31.8100n 0.000338 31.8200n 0.000372 31.8300n 0.000403 31.8400n 0.000429 31.8500n 0.000452 31.8600n 0.000472 31.8700n 0.000489 31.8800n 0.000506 31.8900n 0.000521 31.9000n 0.000535 31.9100n 0.000549 31.9200n 0.000563 31.9300n 0.000577 31.9400n 0.000591
+ 31.9500n 0.000606 31.9600n 0.000621 31.9700n 0.000636 31.9800n 0.000650 31.9900n 0.000663 32.0000n 0.000674 32.0100n 0.000683 32.0200n 0.000688 32.0300n 0.000690 32.0400n 0.000686 32.0500n 0.000677 32.0600n 0.000662 32.0700n 0.000638 32.0800n 0.000607 32.0900n 0.000567
+ 32.1000n 0.000518 32.1100n 0.000460 32.1200n 0.000392 32.1300n 0.000314 32.1400n 0.000226 32.1500n 0.000130 32.1600n 0.000025 32.1700n -0.000087 32.1800n -0.000206 32.1900n -0.000330 32.2000n -0.000458 32.2100n -0.000589 32.2200n -0.000721 32.2300n -0.000852 32.2400n -0.000981
+ 32.2500n -0.001105 32.2600n -0.001223 32.2700n -0.001334 32.2800n -0.001436 32.2900n -0.001527 32.3000n -0.001606 32.3100n -0.001671 32.3200n -0.001723 32.3300n -0.001760 32.3400n -0.001782 32.3500n -0.001788 32.3600n -0.001779 32.3700n -0.001755 32.3800n -0.001717 32.3900n -0.001666
+ 32.4000n -0.001603 32.4100n -0.001528 32.4200n -0.001445 32.4300n -0.001353 32.4400n -0.001256 32.4500n -0.001155 32.4600n -0.001052 32.4700n -0.000950 32.4800n -0.000849 32.4900n -0.000752 32.5000n -0.000660 32.5100n -0.000575 32.5200n -0.000499 32.5300n -0.000433 32.5400n -0.000376
+ 32.5500n -0.000331 32.5600n -0.000298 32.5700n -0.000276 32.5800n -0.000265 32.5900n -0.000266 32.6000n -0.000277 32.6100n -0.000297 32.6200n -0.000325 32.6300n -0.000360 32.6400n -0.000400 32.6500n -0.000444 32.6600n -0.000490 32.6700n -0.000536 32.6800n -0.000581 32.6900n -0.000622
+ 32.7000n -0.000659 32.7100n -0.000689 32.7200n -0.000712 32.7300n -0.000725 32.7400n -0.000730 32.7500n -0.000724 32.7600n -0.000707 32.7700n -0.000680 32.7800n -0.000642 32.7900n -0.000594 32.8000n -0.000536 32.8100n -0.000469 32.8200n -0.000396 32.8300n -0.000316 32.8400n -0.000231
+ 32.8500n -0.000144 32.8600n -0.000055 32.8700n 0.000033 32.8800n 0.000119 32.8900n 0.000200 32.9000n 0.000276 32.9100n 0.000344 32.9200n 0.000404 32.9300n 0.000453 32.9400n 0.000491 32.9500n 0.000518 32.9600n 0.000532 32.9700n 0.000533 32.9800n 0.000522 32.9900n 0.000498
+ 33.0000n 0.000462 33.0100n 0.000416 33.0200n 0.000359 33.0300n 0.000294 33.0400n 0.000222 33.0500n 0.000145 33.0600n 0.000064 33.0700n -0.000018 33.0800n -0.000101 33.0900n -0.000181 33.1000n -0.000256 33.1100n -0.000326 33.1200n -0.000388 33.1300n -0.000441 33.1400n -0.000483
+ 33.1500n -0.000512 33.1600n -0.000529 33.1700n -0.000532 33.1800n -0.000520 33.1900n -0.000493 33.2000n -0.000452 33.2100n -0.000396 33.2200n -0.000326 33.2300n -0.000243 33.2400n -0.000148 33.2500n -0.000041 33.2600n 0.000075 33.2700n 0.000200 33.2800n 0.000332 33.2900n 0.000469
+ 33.3000n 0.000610 33.3100n 0.000752 33.3200n 0.000895 33.3300n 0.001037 33.3400n 0.001175 33.3500n 0.001310 33.3600n 0.001438 33.3700n 0.001560 33.3800n 0.001674 33.3900n 0.001779 33.4000n 0.001874 33.4100n 0.001959 33.4200n 0.002034 33.4300n 0.002097 33.4400n 0.002150
+ 33.4500n 0.002191 33.4600n 0.002222 33.4700n 0.002242 33.4800n 0.002251 33.4900n 0.002250 33.5000n 0.002239 33.5100n 0.002218 33.5200n 0.002188 33.5300n 0.002150 33.5400n 0.002104 33.5500n 0.002049 33.5600n 0.001987 33.5700n 0.001917 33.5800n 0.001841 33.5900n 0.001758
+ 33.6000n 0.001668 33.6100n 0.001573 33.6200n 0.001471 33.6300n 0.001364 33.6400n 0.001251 33.6500n 0.001133 33.6600n 0.001010 33.6700n 0.000883 33.6800n 0.000752 33.6900n 0.000618 33.7000n 0.000481 33.7100n 0.000342 33.7200n 0.000203 33.7300n 0.000063 33.7400n -0.000075
+ 33.7500n -0.000212 33.7600n -0.000345 33.7700n -0.000473 33.7800n -0.000595 33.7900n -0.000710 33.8000n -0.000817 33.8100n -0.000914 33.8200n -0.001000 33.8300n -0.001075 33.8400n -0.001136 33.8500n -0.001184 33.8600n -0.001217 33.8700n -0.001235 33.8800n -0.001239 33.8900n -0.001227
+ 33.9000n -0.001201 33.9100n -0.001161 33.9200n -0.001107 33.9300n -0.001040 33.9400n -0.000962 33.9500n -0.000875 33.9600n -0.000779 33.9700n -0.000677 33.9800n -0.000570 33.9900n -0.000461 34.0000n -0.000351 34.0100n -0.000244 34.0200n -0.000141 34.0300n -0.000043 34.0400n 0.000046
+ 34.0500n 0.000125 34.0600n 0.000192 34.0700n 0.000247 34.0800n 0.000287 34.0900n 0.000312 34.1000n 0.000322 34.1100n 0.000315 34.1200n 0.000293 34.1300n 0.000255 34.1400n 0.000203 34.1500n 0.000137 34.1600n 0.000058 34.1700n -0.000030 34.1800n -0.000128 34.1900n -0.000232
+ 34.2000n -0.000340 34.2100n -0.000450 34.2200n -0.000559 34.2300n -0.000665 34.2400n -0.000765 34.2500n -0.000857 34.2600n -0.000938 34.2700n -0.001007 34.2800n -0.001062 34.2900n -0.001100 34.3000n -0.001122 34.3100n -0.001124 34.3200n -0.001108 34.3300n -0.001073 34.3400n -0.001019
+ 34.3500n -0.000946 34.3600n -0.000855 34.3700n -0.000748 34.3800n -0.000625 34.3900n -0.000489 34.4000n -0.000342 34.4100n -0.000185 34.4200n -0.000021 34.4300n 0.000148 34.4400n 0.000319 34.4500n 0.000490 34.4600n 0.000658 34.4700n 0.000821 34.4800n 0.000977 34.4900n 0.001125
+ 34.5000n 0.001262 34.5100n 0.001388 34.5200n 0.001501 34.5300n 0.001600 34.5400n 0.001686 34.5500n 0.001757 34.5600n 0.001815 34.5700n 0.001859 34.5800n 0.001891 34.5900n 0.001912 34.6000n 0.001923 34.6100n 0.001926 34.6200n 0.001921 34.6300n 0.001912 34.6400n 0.001899
+ 34.6500n 0.001884 34.6600n 0.001870 34.6700n 0.001857 34.6800n 0.001847 34.6900n 0.001840 34.7000n 0.001839 34.7100n 0.001843 34.7200n 0.001853 34.7300n 0.001869 34.7400n 0.001890 34.7500n 0.001917 34.7600n 0.001947 34.7700n 0.001981 34.7800n 0.002015 34.7900n 0.002050
+ 34.8000n 0.002082 34.8100n 0.002110 34.8200n 0.002131 34.8300n 0.002145 34.8400n 0.002147 34.8500n 0.002137 34.8600n 0.002113 34.8700n 0.002073 34.8800n 0.002015 34.8900n 0.001938 34.9000n 0.001842 34.9100n 0.001725 34.9200n 0.001589 34.9300n 0.001433 34.9400n 0.001257
+ 34.9500n 0.001064 34.9600n 0.000855 34.9700n 0.000631 34.9800n 0.000394 34.9900n 0.000149 35.0000n -0.000104 35.0100n -0.000360 35.0200n -0.000616 35.0300n -0.000870 35.0400n -0.001117 35.0500n -0.001355 35.0600n -0.001580 35.0700n -0.001789 35.0800n -0.001980 35.0900n -0.002149
+ 35.1000n -0.002296 35.1100n -0.002417 35.1200n -0.002512 35.1300n -0.002579 35.1400n -0.002618 35.1500n -0.002630 35.1600n -0.002614 35.1700n -0.002572 35.1800n -0.002505 35.1900n -0.002415 35.2000n -0.002304 35.2100n -0.002174 35.2200n -0.002029 35.2300n -0.001871 35.2400n -0.001703
+ 35.2500n -0.001529 35.2600n -0.001352 35.2700n -0.001175 35.2800n -0.001001 35.2900n -0.000834 35.3000n -0.000674 35.3100n -0.000526 35.3200n -0.000391 35.3300n -0.000271 35.3400n -0.000167 35.3500n -0.000079 35.3600n -0.000009 35.3700n 0.000044 35.3800n 0.000080 35.3900n 0.000099
+ 35.4000n 0.000104 35.4100n 0.000095 35.4200n 0.000075 35.4300n 0.000044 35.4400n 0.000006 35.4500n -0.000037 35.4600n -0.000084 35.4700n -0.000131 35.4800n -0.000178 35.4900n -0.000220 35.5000n -0.000258 35.5100n -0.000288 35.5200n -0.000310 35.5300n -0.000322 35.5400n -0.000323
+ 35.5500n -0.000314 35.5600n -0.000293 35.5700n -0.000262 35.5800n -0.000220 35.5900n -0.000169 35.6000n -0.000110 35.6100n -0.000044 35.6200n 0.000027 35.6300n 0.000101 35.6400n 0.000176 35.6500n 0.000250 35.6600n 0.000321 35.6700n 0.000388 35.6800n 0.000447 35.6900n 0.000497
+ 35.7000n 0.000537 35.7100n 0.000565 35.7200n 0.000580 35.7300n 0.000582 35.7400n 0.000569 35.7500n 0.000542 35.7600n 0.000500 35.7700n 0.000445 35.7800n 0.000378 35.7900n 0.000299 35.8000n 0.000210 35.8100n 0.000113 35.8200n 0.000010 35.8300n -0.000097 35.8400n -0.000206
+ 35.8500n -0.000314 35.8600n -0.000419 35.8700n -0.000519 35.8800n -0.000611 35.8900n -0.000694 35.9000n -0.000765 35.9100n -0.000824 35.9200n -0.000868 35.9300n -0.000897 35.9400n -0.000909 35.9500n -0.000906 35.9600n -0.000887 35.9700n -0.000851 35.9800n -0.000801 35.9900n -0.000737
+ 36.0000n -0.000661 36.0100n -0.000574 36.0200n -0.000478 36.0300n -0.000376 36.0400n -0.000269 36.0500n -0.000161 36.0600n -0.000053 36.0700n 0.000053 36.0800n 0.000153 36.0900n 0.000246 36.1000n 0.000329 36.1100n 0.000402 36.1200n 0.000462 36.1300n 0.000509 36.1400n 0.000541
+ 36.1500n 0.000558 36.1600n 0.000560 36.1700n 0.000547 36.1800n 0.000519 36.1900n 0.000478 36.2000n 0.000424 36.2100n 0.000360 36.2200n 0.000286 36.2300n 0.000204 36.2400n 0.000117 36.2500n 0.000027 36.2600n -0.000064 36.2700n -0.000154 36.2800n -0.000240 36.2900n -0.000322
+ 36.3000n -0.000396 36.3100n -0.000461 36.3200n -0.000516 36.3300n -0.000559 36.3400n -0.000589 36.3500n -0.000607 36.3600n -0.000611 36.3700n -0.000602 36.3800n -0.000580 36.3900n -0.000545 36.4000n -0.000500 36.4100n -0.000444 36.4200n -0.000379 36.4300n -0.000307 36.4400n -0.000230
+ 36.4500n -0.000150 36.4600n -0.000068 36.4700n 0.000013 36.4800n 0.000092 36.4900n 0.000167 36.5000n 0.000235 36.5100n 0.000296 36.5200n 0.000348 36.5300n 0.000390 36.5400n 0.000422 36.5500n 0.000441 36.5600n 0.000449 36.5700n 0.000444 36.5800n 0.000428 36.5900n 0.000401
+ 36.6000n 0.000363 36.6100n 0.000315 36.6200n 0.000259 36.6300n 0.000195 36.6400n 0.000126 36.6500n 0.000053 36.6600n -0.000024 36.6700n -0.000101 36.6800n -0.000178 36.6900n -0.000254 36.7000n -0.000326 36.7100n -0.000394 36.7200n -0.000456 36.7300n -0.000512 36.7400n -0.000562
+ 36.7500n -0.000604 36.7600n -0.000638 36.7700n -0.000665 36.7800n -0.000685 36.7900n -0.000698 36.8000n -0.000705 36.8100n -0.000706 36.8200n -0.000703 36.8300n -0.000697 36.8400n -0.000688 36.8500n -0.000678 36.8600n -0.000668 36.8700n -0.000658 36.8800n -0.000651 36.8900n -0.000646
+ 36.9000n -0.000645 36.9100n -0.000648 36.9200n -0.000655 36.9300n -0.000667 36.9400n -0.000684 36.9500n -0.000706 36.9600n -0.000731 36.9700n -0.000760 36.9800n -0.000792 36.9900n -0.000826 37.0000n -0.000860 37.0100n -0.000894 37.0200n -0.000927 37.0300n -0.000956 37.0400n -0.000981
+ 37.0500n -0.001001 37.0600n -0.001014 37.0700n -0.001019 37.0800n -0.001015 37.0900n -0.001002 37.1000n -0.000979 37.1100n -0.000945 37.1200n -0.000900 37.1300n -0.000844 37.1400n -0.000778 37.1500n -0.000702 37.1600n -0.000617 37.1700n -0.000524 37.1800n -0.000425 37.1900n -0.000319
+ 37.2000n -0.000209 37.2100n -0.000097 37.2200n 0.000016 37.2300n 0.000128 37.2400n 0.000238 37.2500n 0.000344 37.2600n 0.000444 37.2700n 0.000537 37.2800n 0.000622 37.2900n 0.000697 37.3000n 0.000762 37.3100n 0.000816 37.3200n 0.000859 37.3300n 0.000891 37.3400n 0.000911
+ 37.3500n 0.000921 37.3600n 0.000919 37.3700n 0.000909 37.3800n 0.000889 37.3900n 0.000862 37.4000n 0.000829 37.4100n 0.000792 37.4200n 0.000750 37.4300n 0.000707 37.4400n 0.000663 37.4500n 0.000620 37.4600n 0.000579 37.4700n 0.000541 37.4800n 0.000507 37.4900n 0.000478
+ 37.5000n 0.000455 37.5100n 0.000437 37.5200n 0.000425 37.5300n 0.000419 37.5400n 0.000418 37.5500n 0.000422 37.5600n 0.000430 37.5700n 0.000440 37.5800n 0.000453 37.5900n 0.000467 37.6000n 0.000480 37.6100n 0.000491 37.6200n 0.000499 37.6300n 0.000503 37.6400n 0.000501
+ 37.6500n 0.000493 37.6600n 0.000477 37.6700n 0.000453 37.6800n 0.000421 37.6900n 0.000380 37.7000n 0.000331 37.7100n 0.000273 37.7200n 0.000208 37.7300n 0.000137 37.7400n 0.000060 37.7500n -0.000021 37.7600n -0.000104 37.7700n -0.000188 37.7800n -0.000270 37.7900n -0.000350
+ 37.8000n -0.000424 37.8100n -0.000491 37.8200n -0.000550 37.8300n -0.000598 37.8400n -0.000634 37.8500n -0.000657 37.8600n -0.000666 37.8700n -0.000659 37.8800n -0.000638 37.8900n -0.000602 37.9000n -0.000551 37.9100n -0.000486 37.9200n -0.000409 37.9300n -0.000321 37.9400n -0.000225
+ 37.9500n -0.000122 37.9600n -0.000015 37.9700n 0.000094 37.9800n 0.000200 37.9900n 0.000301 38.0000n 0.000395 38.0100n 0.000477 38.0200n 0.000545 38.0300n 0.000597 38.0400n 0.000630 38.0500n 0.000641 38.0600n 0.000629 38.0700n 0.000593 38.0800n 0.000531 38.0900n 0.000444
+ 38.1000n 0.000331 38.1100n 0.000194 38.1200n 0.000034 38.1300n -0.000148 38.1400n -0.000348 38.1500n -0.000563 38.1600n -0.000791 38.1700n -0.001027 38.1800n -0.001266 38.1900n -0.001506 38.2000n -0.001740 38.2100n -0.001964 38.2200n -0.002174 38.2300n -0.002364 38.2400n -0.002530
+ 38.2500n -0.002668 38.2600n -0.002775 38.2700n -0.002846 38.2800n -0.002880 38.2900n -0.002873 38.3000n -0.002824 38.3100n -0.002733 38.3200n -0.002599 38.3300n -0.002423 38.3400n -0.002206 38.3500n -0.001950 38.3600n -0.001659 38.3700n -0.001334 38.3800n -0.000982 38.3900n -0.000605
+ 38.4000n -0.000209 38.4100n 0.000200 38.4200n 0.000617 38.4300n 0.001036 38.4400n 0.001451 38.4500n 0.001856 38.4600n 0.002246 38.4700n 0.002615 38.4800n 0.002958 38.4900n 0.003271 38.5000n 0.003548 38.5100n 0.003787 38.5200n 0.003985 38.5300n 0.004139 38.5400n 0.004248
+ 38.5500n 0.004311 38.5600n 0.004328 38.5700n 0.004300 38.5800n 0.004229 38.5900n 0.004116 38.6000n 0.003964 38.6100n 0.003777 38.6200n 0.003559 38.6300n 0.003314 38.6400n 0.003046 38.6500n 0.002761 38.6600n 0.002462 38.6700n 0.002156 38.6800n 0.001848 38.6900n 0.001541
+ 38.7000n 0.001241 38.7100n 0.000952 38.7200n 0.000678 38.7300n 0.000423 38.7400n 0.000188 38.7500n -0.000023 38.7600n -0.000208 38.7700n -0.000366 38.7800n -0.000498 38.7900n -0.000601 38.8000n -0.000678 38.8100n -0.000728 38.8200n -0.000754 38.8300n -0.000757 38.8400n -0.000739
+ 38.8500n -0.000704 38.8600n -0.000653 38.8700n -0.000589 38.8800n -0.000516 38.8900n -0.000437 38.9000n -0.000354 38.9100n -0.000270 38.9200n -0.000189 38.9300n -0.000111 38.9400n -0.000039 38.9500n 0.000025 38.9600n 0.000079 38.9700n 0.000124 38.9800n 0.000158 38.9900n 0.000181
+ 39.0000n 0.000193 39.0100n 0.000196 39.0200n 0.000189 39.0300n 0.000175 39.0400n 0.000154 39.0500n 0.000128 39.0600n 0.000099 39.0700n 0.000069 39.0800n 0.000039 39.0900n 0.000012 39.1000n -0.000011 39.1100n -0.000027 39.1200n -0.000037 39.1300n -0.000037 39.1400n -0.000028
+ 39.1500n -0.000008 39.1600n 0.000023 39.1700n 0.000065 39.1800n 0.000118 39.1900n 0.000181 39.2000n 0.000253 39.2100n 0.000334 39.2200n 0.000422 39.2300n 0.000515 39.2400n 0.000613 39.2500n 0.000711 39.2600n 0.000810 39.2700n 0.000906 39.2800n 0.000998 39.2900n 0.001084
+ 39.3000n 0.001162 39.3100n 0.001229 39.3200n 0.001285 39.3300n 0.001329 39.3400n 0.001358 39.3500n 0.001373 39.3600n 0.001373 39.3700n 0.001356 39.3800n 0.001325 39.3900n 0.001278 39.4000n 0.001217 39.4100n 0.001142 39.4200n 0.001055 39.4300n 0.000956 39.4400n 0.000848
+ 39.4500n 0.000731 39.4600n 0.000608 39.4700n 0.000481 39.4800n 0.000350 39.4900n 0.000218 39.5000n 0.000087 39.5100n -0.000042 39.5200n -0.000168 39.5300n -0.000289 39.5400n -0.000404 39.5500n -0.000512 39.5600n -0.000614 39.5700n -0.000707 39.5800n -0.000793 39.5900n -0.000871
+ 39.6000n -0.000941 39.6100n -0.001004 39.6200n -0.001061 39.6300n -0.001112 39.6400n -0.001157 39.6500n -0.001198 39.6600n -0.001236 39.6700n -0.001272 39.6800n -0.001306 39.6900n -0.001339 39.7000n -0.001372 39.7100n -0.001406 39.7200n -0.001441 39.7300n -0.001478 39.7400n -0.001516
+ 39.7500n -0.001555 39.7600n -0.001596 39.7700n -0.001638 39.7800n -0.001680 39.7900n -0.001721 39.8000n -0.001761 39.8100n -0.001799 39.8200n -0.001834 39.8300n -0.001865 39.8400n -0.001890 39.8500n -0.001908 39.8600n -0.001919 39.8700n -0.001922 39.8800n -0.001916 39.8900n -0.001899
+ 39.9000n -0.001872 39.9100n -0.001835 39.9200n -0.001786 39.9300n -0.001727 39.9400n -0.001658 39.9500n -0.001579 39.9600n -0.001491 39.9700n -0.001395 39.9800n -0.001292 39.9900n -0.001184 40.0000n -0.001072 40.0100n -0.000957 40.0200n -0.000842 40.0300n -0.000728 40.0400n -0.000617
+ 40.0500n -0.000510 40.0600n -0.000409 40.0700n -0.000315 40.0800n -0.000229 40.0900n -0.000153 40.1000n -0.000086 40.1100n -0.000031 40.1200n 0.000013 40.1300n 0.000047 40.1400n 0.000070 40.1500n 0.000082 40.1600n 0.000086 40.1700n 0.000081 40.1800n 0.000069 40.1900n 0.000052
+ 40.2000n 0.000031 40.2100n 0.000007 40.2200n -0.000016 40.2300n -0.000038 40.2400n -0.000056 40.2500n -0.000068 40.2600n -0.000074 40.2700n -0.000071 40.2800n -0.000059 40.2900n -0.000035 40.3000n -0.000000 40.3100n 0.000047 40.3200n 0.000106 40.3300n 0.000178 40.3400n 0.000261
+ 40.3500n 0.000356 40.3600n 0.000459 40.3700n 0.000571 40.3800n 0.000689 40.3900n 0.000811 40.4000n 0.000935 40.4100n 0.001058 40.4200n 0.001178 40.4300n 0.001293 40.4400n 0.001399 40.4500n 0.001494 40.4600n 0.001576 40.4700n 0.001642 40.4800n 0.001689 40.4900n 0.001717
+ 40.5000n 0.001724 40.5100n 0.001708 40.5200n 0.001668 40.5300n 0.001605 40.5400n 0.001518 40.5500n 0.001407 40.5600n 0.001274 40.5700n 0.001120 40.5800n 0.000947 40.5900n 0.000756 40.6000n 0.000550 40.6100n 0.000333 40.6200n 0.000106 40.6300n -0.000126 40.6400n -0.000360
+ 40.6500n -0.000593 40.6600n -0.000821 40.6700n -0.001041 40.6800n -0.001250 40.6900n -0.001443 40.7000n -0.001618 40.7100n -0.001773 40.7200n -0.001905 40.7300n -0.002012 40.7400n -0.002091 40.7500n -0.002144 40.7600n -0.002167 40.7700n -0.002161 40.7800n -0.002127 40.7900n -0.002065
+ 40.8000n -0.001976 40.8100n -0.001862 40.8200n -0.001724 40.8300n -0.001565 40.8400n -0.001388 40.8500n -0.001196 40.8600n -0.000990 40.8700n -0.000776 40.8800n -0.000556 40.8900n -0.000334 40.9000n -0.000112 40.9100n 0.000105 40.9200n 0.000314 40.9300n 0.000514 40.9400n 0.000700
+ 40.9500n 0.000870 40.9600n 0.001022 40.9700n 0.001155 40.9800n 0.001267 40.9900n 0.001356 41.0000n 0.001423 41.0100n 0.001466 41.0200n 0.001485 41.0300n 0.001482 41.0400n 0.001457 41.0500n 0.001411 41.0600n 0.001345 41.0700n 0.001260 41.0800n 0.001160 41.0900n 0.001045
+ 41.1000n 0.000917 41.1100n 0.000780 41.1200n 0.000634 41.1300n 0.000483 41.1400n 0.000329 41.1500n 0.000173 41.1600n 0.000017 41.1700n -0.000136 41.1800n -0.000285 41.1900n -0.000428 41.2000n -0.000564 41.2100n -0.000692 41.2200n -0.000811 41.2300n -0.000921 41.2400n -0.001021
+ 41.2500n -0.001110 41.2600n -0.001189 41.2700n -0.001258 41.2800n -0.001318 41.2900n -0.001368 41.3000n -0.001409 41.3100n -0.001443 41.3200n -0.001469 41.3300n -0.001488 41.3400n -0.001502 41.3500n -0.001511 41.3600n -0.001516 41.3700n -0.001518 41.3800n -0.001516 41.3900n -0.001513
+ 41.4000n -0.001508 41.4100n -0.001502 41.4200n -0.001495 41.4300n -0.001488 41.4400n -0.001480 41.4500n -0.001471 41.4600n -0.001462 41.4700n -0.001451 41.4800n -0.001440 41.4900n -0.001427 41.5000n -0.001413 41.5100n -0.001396 41.5200n -0.001376 41.5300n -0.001354 41.5400n -0.001328
+ 41.5500n -0.001299 41.5600n -0.001266 41.5700n -0.001228 41.5800n -0.001186 41.5900n -0.001139 41.6000n -0.001088 41.6100n -0.001032 41.6200n -0.000972 41.6300n -0.000908 41.6400n -0.000841 41.6500n -0.000770 41.6600n -0.000697 41.6700n -0.000622 41.6800n -0.000546 41.6900n -0.000470
+ 41.7000n -0.000394 41.7100n -0.000319 41.7200n -0.000247 41.7300n -0.000177 41.7400n -0.000112 41.7500n -0.000051 41.7600n 0.000003 41.7700n 0.000052 41.7800n 0.000094 41.7900n 0.000128 41.8000n 0.000154 41.8100n 0.000171 41.8200n 0.000180 41.8300n 0.000181 41.8400n 0.000172
+ 41.8500n 0.000156 41.8600n 0.000131 41.8700n 0.000099 41.8800n 0.000059 41.8900n 0.000014 41.9000n -0.000037 41.9100n -0.000091 41.9200n -0.000149 41.9300n -0.000209 41.9400n -0.000269 41.9500n -0.000328 41.9600n -0.000385 41.9700n -0.000438 41.9800n -0.000485 41.9900n -0.000526
+ 42.0000n -0.000558 42.0100n -0.000581 42.0200n -0.000592 42.0300n -0.000592 42.0400n -0.000578 42.0500n -0.000550 42.0600n -0.000507 42.0700n -0.000448 42.0800n -0.000374 42.0900n -0.000283 42.1000n -0.000177 42.1100n -0.000056 42.1200n 0.000081 42.1300n 0.000232 42.1400n 0.000395
+ 42.1500n 0.000571 42.1600n 0.000756 42.1700n 0.000950 42.1800n 0.001150 42.1900n 0.001355 42.2000n 0.001561 42.2100n 0.001767 42.2200n 0.001970 42.2300n 0.002167 42.2400n 0.002357 42.2500n 0.002536 42.2600n 0.002702 42.2700n 0.002852 42.2800n 0.002985 42.2900n 0.003098
+ 42.3000n 0.003190 42.3100n 0.003259 42.3200n 0.003304 42.3300n 0.003324 42.3400n 0.003318 42.3500n 0.003286 42.3600n 0.003229 42.3700n 0.003147 42.3800n 0.003041 42.3900n 0.002912 42.4000n 0.002762 42.4100n 0.002593 42.4200n 0.002408 42.4300n 0.002209 42.4400n 0.002000
+ 42.4500n 0.001782 42.4600n 0.001561 42.4700n 0.001339 42.4800n 0.001119 42.4900n 0.000906 42.5000n 0.000702 42.5100n 0.000512 42.5200n 0.000337 42.5300n 0.000182 42.5400n 0.000047 42.5500n -0.000063 42.5600n -0.000148 42.5700n -0.000206 42.5800n -0.000236 42.5900n -0.000238
+ 42.6000n -0.000211 42.6100n -0.000157 42.6200n -0.000076 42.6300n 0.000029 42.6400n 0.000158 42.6500n 0.000308 42.6600n 0.000474 42.6700n 0.000656 42.6800n 0.000848 42.6900n 0.001047 42.7000n 0.001250 42.7100n 0.001451 42.7200n 0.001648 42.7300n 0.001836 42.7400n 0.002011
+ 42.7500n 0.002169 42.7600n 0.002308 42.7700n 0.002424 42.7800n 0.002514 42.7900n 0.002576 42.8000n 0.002609 42.8100n 0.002612 42.8200n 0.002583 42.8300n 0.002524 42.8400n 0.002433 42.8500n 0.002313 42.8600n 0.002166 42.8700n 0.001993 42.8800n 0.001797 42.8900n 0.001582
+ 42.9000n 0.001351 42.9100n 0.001109 42.9200n 0.000858 42.9300n 0.000604 42.9400n 0.000351 42.9500n 0.000103 42.9600n -0.000135 42.9700n -0.000359 42.9800n -0.000565 42.9900n -0.000749 43.0000n -0.000908 43.0100n -0.001040 43.0200n -0.001142 43.0300n -0.001212 43.0400n -0.001250
+ 43.0500n -0.001255 43.0600n -0.001226 43.0700n -0.001165 43.0800n -0.001074 43.0900n -0.000953 43.1000n -0.000807 43.1100n -0.000637 43.1200n -0.000447 43.1300n -0.000241 43.1400n -0.000024 43.1500n 0.000200 43.1600n 0.000427 43.1700n 0.000652 43.1800n 0.000869 43.1900n 0.001075
+ 43.2000n 0.001266 43.2100n 0.001437 43.2200n 0.001584 43.2300n 0.001704 43.2400n 0.001794 43.2500n 0.001853 43.2600n 0.001878 43.2700n 0.001869 43.2800n 0.001824 43.2900n 0.001745 43.3000n 0.001632 43.3100n 0.001487 43.3200n 0.001311 43.3300n 0.001108 43.3400n 0.000880
+ 43.3500n 0.000631 43.3600n 0.000365 43.3700n 0.000087 43.3800n -0.000199 43.3900n -0.000489 43.4000n -0.000777 43.4100n -0.001059 43.4200n -0.001331 43.4300n -0.001588 43.4400n -0.001825 43.4500n -0.002040 43.4600n -0.002228 43.4700n -0.002387 43.4800n -0.002514 43.4900n -0.002608
+ 43.5000n -0.002666 43.5100n -0.002689 43.5200n -0.002676 43.5300n -0.002628 43.5400n -0.002546 43.5500n -0.002430 43.5600n -0.002284 43.5700n -0.002110 43.5800n -0.001910 43.5900n -0.001689 43.6000n -0.001449 43.6100n -0.001196 43.6200n -0.000931 43.6300n -0.000661 43.6400n -0.000388
+ 43.6500n -0.000118 43.6600n 0.000147 43.6700n 0.000401 43.6800n 0.000642 43.6900n 0.000866 43.7000n 0.001070 43.7100n 0.001251 43.7200n 0.001408 43.7300n 0.001538 43.7400n 0.001640 43.7500n 0.001713 43.7600n 0.001757 43.7700n 0.001771 43.7800n 0.001756 43.7900n 0.001712
+ 43.8000n 0.001642 43.8100n 0.001545 43.8200n 0.001425 43.8300n 0.001283 43.8400n 0.001122 43.8500n 0.000944 43.8600n 0.000752 43.8700n 0.000548 43.8800n 0.000336 43.8900n 0.000118 43.9000n -0.000102 43.9100n -0.000323 43.9200n -0.000541 43.9300n -0.000754 43.9400n -0.000959
+ 43.9500n -0.001154 43.9600n -0.001337 43.9700n -0.001506 43.9800n -0.001660 43.9900n -0.001798 44.0000n -0.001917 44.0100n -0.002018 44.0200n -0.002099 44.0300n -0.002160 44.0400n -0.002201 44.0500n -0.002222 44.0600n -0.002223 44.0700n -0.002204 44.0800n -0.002167 44.0900n -0.002112
+ 44.1000n -0.002039 44.1100n -0.001950 44.1200n -0.001845 44.1300n -0.001727 44.1400n -0.001597 44.1500n -0.001455 44.1600n -0.001303 44.1700n -0.001144 44.1800n -0.000977 44.1900n -0.000806 44.2000n -0.000630 44.2100n -0.000453 44.2200n -0.000275 44.2300n -0.000099 44.2400n 0.000076
+ 44.2500n 0.000246 44.2600n 0.000412 44.2700n 0.000571 44.2800n 0.000723 44.2900n 0.000866 44.3000n 0.001000 44.3100n 0.001123 44.3200n 0.001235 44.3300n 0.001336 44.3400n 0.001424 44.3500n 0.001500 44.3600n 0.001564 44.3700n 0.001614 44.3800n 0.001653 44.3900n 0.001678
+ 44.4000n 0.001692 44.4100n 0.001693 44.4200n 0.001684 44.4300n 0.001664 44.4400n 0.001635 44.4500n 0.001596 44.4600n 0.001549 44.4700n 0.001494 44.4800n 0.001433 44.4900n 0.001367 44.5000n 0.001295 44.5100n 0.001219 44.5200n 0.001140 44.5300n 0.001059 44.5400n 0.000975
+ 44.5500n 0.000889 44.5600n 0.000803 44.5700n 0.000715 44.5800n 0.000627 44.5900n 0.000538 44.6000n 0.000448 44.6100n 0.000357 44.6200n 0.000265 44.6300n 0.000172 44.6400n 0.000076 44.6500n -0.000021 44.6600n -0.000122 44.6700n -0.000225 44.6800n -0.000332 44.6900n -0.000443
+ 44.7000n -0.000558 44.7100n -0.000678 44.7200n -0.000802 44.7300n -0.000931 44.7400n -0.001064 44.7500n -0.001202 44.7600n -0.001342 44.7700n -0.001485 44.7800n -0.001631 44.7900n -0.001777 44.8000n -0.001922 44.8100n -0.002066 44.8200n -0.002206 44.8300n -0.002340 44.8400n -0.002468
+ 44.8500n -0.002588 44.8600n -0.002696 44.8700n -0.002792 44.8800n -0.002874 44.8900n -0.002939 44.9000n -0.002987 44.9100n -0.003015 44.9200n -0.003022 44.9300n -0.003008 44.9400n -0.002972 44.9500n -0.002912 44.9600n -0.002829 44.9700n -0.002723 44.9800n -0.002594 44.9900n -0.002443
+ 45.0000n -0.002272 45.0100n -0.002081 45.0200n -0.001874 45.0300n -0.001651 45.0400n -0.001415 45.0500n -0.001169 45.0600n -0.000916 45.0700n -0.000659 45.0800n -0.000401 45.0900n -0.000146 45.1000n 0.000104 45.1100n 0.000346 45.1200n 0.000575 45.1300n 0.000790 45.1400n 0.000987
+ 45.1500n 0.001164 45.1600n 0.001318 45.1700n 0.001448 45.1800n 0.001553 45.1900n 0.001630 45.2000n 0.001680 45.2100n 0.001702 45.2200n 0.001696 45.2300n 0.001663 45.2400n 0.001603 45.2500n 0.001518 45.2600n 0.001410 45.2700n 0.001280 45.2800n 0.001131 45.2900n 0.000965
+ 45.3000n 0.000785 45.3100n 0.000594 45.3200n 0.000395 45.3300n 0.000190 45.3400n -0.000017 45.3500n -0.000224 45.3600n -0.000427 45.3700n -0.000625 45.3800n -0.000816 45.3900n -0.000996 45.4000n -0.001164 45.4100n -0.001320 45.4200n -0.001460 45.4300n -0.001586 45.4400n -0.001696
+ 45.4500n -0.001789 45.4600n -0.001867 45.4700n -0.001929 45.4800n -0.001976 45.4900n -0.002008 45.5000n -0.002028 45.5100n -0.002035 45.5200n -0.002032 45.5300n -0.002019 45.5400n -0.001997 45.5500n -0.001969 45.5600n -0.001934 45.5700n -0.001895 45.5800n -0.001853 45.5900n -0.001807
+ 45.6000n -0.001759 45.6100n -0.001710 45.6200n -0.001658 45.6300n -0.001606 45.6400n -0.001551 45.6500n -0.001495 45.6600n -0.001436 45.6700n -0.001374 45.6800n -0.001308 45.6900n -0.001237 45.7000n -0.001161 45.7100n -0.001079 45.7200n -0.000989 45.7300n -0.000891 45.7400n -0.000785
+ 45.7500n -0.000671 45.7600n -0.000547 45.7700n -0.000413 45.7800n -0.000271 45.7900n -0.000121 45.8000n 0.000038 45.8100n 0.000203 45.8200n 0.000373 45.8300n 0.000547 45.8400n 0.000723 45.8500n 0.000899 45.8600n 0.001073 45.8700n 0.001242 45.8800n 0.001405 45.8900n 0.001557
+ 45.9000n 0.001698 45.9100n 0.001825 45.9200n 0.001935 45.9300n 0.002027 45.9400n 0.002098 45.9500n 0.002148 45.9600n 0.002174 45.9700n 0.002176 45.9800n 0.002154 45.9900n 0.002107 46.0000n 0.002036 46.0100n 0.001941 46.0200n 0.001825 46.0300n 0.001688 46.0400n 0.001533
+ 46.0500n 0.001363 46.0600n 0.001179 46.0700n 0.000986 46.0800n 0.000787 46.0900n 0.000584 46.1000n 0.000383 46.1100n 0.000186 46.1200n -0.000003 46.1300n -0.000180 46.1400n -0.000343 46.1500n -0.000487 46.1600n -0.000611 46.1700n -0.000711 46.1800n -0.000786 46.1900n -0.000834
+ 46.2000n -0.000855 46.2100n -0.000847 46.2200n -0.000811 46.2300n -0.000747 46.2400n -0.000656 46.2500n -0.000541 46.2600n -0.000402 46.2700n -0.000243 46.2800n -0.000065 46.2900n 0.000126 46.3000n 0.000329 46.3100n 0.000539 46.3200n 0.000754 46.3300n 0.000968 46.3400n 0.001178
+ 46.3500n 0.001382 46.3600n 0.001574 46.3700n 0.001753 46.3800n 0.001915 46.3900n 0.002058 46.4000n 0.002180 46.4100n 0.002280 46.4200n 0.002355 46.4300n 0.002407 46.4400n 0.002434 46.4500n 0.002437 46.4600n 0.002417 46.4700n 0.002376 46.4800n 0.002315 46.4900n 0.002236
+ 46.5000n 0.002142 46.5100n 0.002036 46.5200n 0.001921 46.5300n 0.001799 46.5400n 0.001674 46.5500n 0.001549 46.5600n 0.001427 46.5700n 0.001310 46.5800n 0.001202 46.5900n 0.001103 46.6000n 0.001017 46.6100n 0.000945 46.6200n 0.000888 46.6300n 0.000847 46.6400n 0.000821
+ 46.6500n 0.000811 46.6600n 0.000815 46.6700n 0.000833 46.6800n 0.000864 46.6900n 0.000904 46.7000n 0.000953 46.7100n 0.001008 46.7200n 0.001065 46.7300n 0.001123 46.7400n 0.001178 46.7500n 0.001228 46.7600n 0.001270 46.7700n 0.001301 46.7800n 0.001320 46.7900n 0.001324
+ 46.8000n 0.001311 46.8100n 0.001280 46.8200n 0.001231 46.8300n 0.001162 46.8400n 0.001073 46.8500n 0.000966 46.8600n 0.000840 46.8700n 0.000698 46.8800n 0.000540 46.8900n 0.000369 46.9000n 0.000187 46.9100n -0.000003 46.9200n -0.000198 46.9300n -0.000395 46.9400n -0.000592
+ 46.9500n -0.000785 46.9600n -0.000971 46.9700n -0.001147 46.9800n -0.001310 46.9900n -0.001458 47.0000n -0.001589 47.0100n -0.001700 47.0200n -0.001791 47.0300n -0.001860 47.0400n -0.001907 47.0500n -0.001931 47.0600n -0.001933 47.0700n -0.001914 47.0800n -0.001874 47.0900n -0.001815
+ 47.1000n -0.001740 47.1100n -0.001649 47.1200n -0.001547 47.1300n -0.001435 47.1400n -0.001316 47.1500n -0.001193 47.1600n -0.001069 47.1700n -0.000947 47.1800n -0.000829 47.1900n -0.000718 47.2000n -0.000617 47.2100n -0.000526 47.2200n -0.000449 47.2300n -0.000386 47.2400n -0.000339
+ 47.2500n -0.000307 47.2600n -0.000292 47.2700n -0.000292 47.2800n -0.000308 47.2900n -0.000337 47.3000n -0.000380 47.3100n -0.000435 47.3200n -0.000499 47.3300n -0.000571 47.3400n -0.000648 47.3500n -0.000729 47.3600n -0.000810 47.3700n -0.000891 47.3800n -0.000968 47.3900n -0.001039
+ 47.4000n -0.001104 47.4100n -0.001159 47.4200n -0.001204 47.4300n -0.001239 47.4400n -0.001261 47.4500n -0.001270 47.4600n -0.001268 47.4700n -0.001253 47.4800n -0.001227 47.4900n -0.001190 47.5000n -0.001143 47.5100n -0.001088 47.5200n -0.001027 47.5300n -0.000962 47.5400n -0.000893
+ 47.5500n -0.000824 47.5600n -0.000755 47.5700n -0.000690 47.5800n -0.000629 47.5900n -0.000575 47.6000n -0.000528 47.6100n -0.000490 47.6200n -0.000463 47.6300n -0.000446 47.6400n -0.000440 47.6500n -0.000445 47.6600n -0.000462 47.6700n -0.000488 47.6800n -0.000525 47.6900n -0.000569
+ 47.7000n -0.000621 47.7100n -0.000679 47.7200n -0.000740 47.7300n -0.000804 47.7400n -0.000868 47.7500n -0.000931 47.7600n -0.000989 47.7700n -0.001043 47.7800n -0.001090 47.7900n -0.001128 47.8000n -0.001157 47.8100n -0.001175 47.8200n -0.001182 47.8300n -0.001177 47.8400n -0.001160
+ 47.8500n -0.001131 47.8600n -0.001091 47.8700n -0.001040 47.8800n -0.000981 47.8900n -0.000913 47.9000n -0.000839 47.9100n -0.000760 47.9200n -0.000679 47.9300n -0.000597 47.9400n -0.000517 47.9500n -0.000440 47.9600n -0.000369 47.9700n -0.000306 47.9800n -0.000252 47.9900n -0.000210
+ 48.0000n -0.000179 48.0100n -0.000162 48.0200n -0.000159 48.0300n -0.000171 48.0400n -0.000197 48.0500n -0.000237 48.0600n -0.000291 48.0700n -0.000357 48.0800n -0.000434 48.0900n -0.000521 48.1000n -0.000616 48.1100n -0.000715 48.1200n -0.000818 48.1300n -0.000921 48.1400n -0.001023
+ 48.1500n -0.001119 48.1600n -0.001209 48.1700n -0.001289 48.1800n -0.001356 48.1900n -0.001410 48.2000n -0.001448 48.2100n -0.001468 48.2200n -0.001470 48.2300n -0.001451 48.2400n -0.001413 48.2500n -0.001354 48.2600n -0.001275 48.2700n -0.001177 48.2800n -0.001060 48.2900n -0.000926
+ 48.3000n -0.000777 48.3100n -0.000615 48.3200n -0.000442 48.3300n -0.000261 48.3400n -0.000074 48.3500n 0.000116 48.3600n 0.000307 48.3700n 0.000494 48.3800n 0.000677 48.3900n 0.000851 48.4000n 0.001015 48.4100n 0.001166 48.4200n 0.001303 48.4300n 0.001423 48.4400n 0.001526
+ 48.4500n 0.001611 48.4600n 0.001676 48.4700n 0.001722 48.4800n 0.001750 48.4900n 0.001758 48.5000n 0.001749 48.5100n 0.001724 48.5200n 0.001683 48.5300n 0.001630 48.5400n 0.001565 48.5500n 0.001491 48.5600n 0.001410 48.5700n 0.001325 48.5800n 0.001237 48.5900n 0.001150
+ 48.6000n 0.001064 48.6100n 0.000983 48.6200n 0.000908 48.6300n 0.000841 48.6400n 0.000783 48.6500n 0.000735 48.6600n 0.000698 48.6700n 0.000673 48.6800n 0.000660 48.6900n 0.000658 48.7000n 0.000668 48.7100n 0.000688 48.7200n 0.000719 48.7300n 0.000757 48.7400n 0.000803
+ 48.7500n 0.000854 48.7600n 0.000909 48.7700n 0.000966 48.7800n 0.001022 48.7900n 0.001077 48.8000n 0.001128 48.8100n 0.001174 48.8200n 0.001212 48.8300n 0.001242 48.8400n 0.001262 48.8500n 0.001270 48.8600n 0.001267 48.8700n 0.001251 48.8800n 0.001222 48.8900n 0.001179
+ 48.9000n 0.001124 48.9100n 0.001055 48.9200n 0.000975 48.9300n 0.000884 48.9400n 0.000782 48.9500n 0.000671 48.9600n 0.000553 48.9700n 0.000429 48.9800n 0.000301 48.9900n 0.000170 49.0000n 0.000038 49.0100n -0.000094 49.0200n -0.000222 49.0300n -0.000347 49.0400n -0.000466
+ 49.0500n -0.000578 49.0600n -0.000682 49.0700n -0.000776 49.0800n -0.000860 49.0900n -0.000933 49.1000n -0.000994 49.1100n -0.001042 49.1200n -0.001079 49.1300n -0.001102 49.1400n -0.001113 49.1500n -0.001112 49.1600n -0.001099 49.1700n -0.001075 49.1800n -0.001040 49.1900n -0.000995
+ 49.2000n -0.000941 49.2100n -0.000878 49.2200n -0.000807 49.2300n -0.000731 49.2400n -0.000648 49.2500n -0.000560 49.2600n -0.000469 49.2700n -0.000374 49.2800n -0.000276 49.2900n -0.000178 49.3000n -0.000078 49.3100n 0.000022 49.3200n 0.000122 49.3300n 0.000221 49.3400n 0.000318
+ 49.3500n 0.000414 49.3600n 0.000507 49.3700n 0.000598 49.3800n 0.000685 49.3900n 0.000770 49.4000n 0.000850 49.4100n 0.000927 49.4200n 0.001000 49.4300n 0.001068 49.4400n 0.001132 49.4500n 0.001190 49.4600n 0.001244 49.4700n 0.001293 49.4800n 0.001336 49.4900n 0.001374
+ 49.5000n 0.001406 49.5100n 0.001433 49.5200n 0.001454 49.5300n 0.001470 49.5400n 0.001480 49.5500n 0.001486 49.5600n 0.001486 49.5700n 0.001482 49.5800n 0.001473 49.5900n 0.001461 49.6000n 0.001445 49.6100n 0.001426 49.6200n 0.001405 49.6300n 0.001383 49.6400n 0.001360
+ 49.6500n 0.001336 49.6600n 0.001313 49.6700n 0.001290 49.6800n 0.001270 49.6900n 0.001252 49.7000n 0.001237 49.7100n 0.001225 49.7200n 0.001217 49.7300n 0.001214 49.7400n 0.001215 49.7500n 0.001221 49.7600n 0.001231 49.7700n 0.001246 49.7800n 0.001265 49.7900n 0.001289
+ 49.8000n 0.001316 49.8100n 0.001345 49.8200n 0.001378 49.8300n 0.001412 49.8400n 0.001446 49.8500n 0.001481 49.8600n 0.001514 49.8700n 0.001545 49.8800n 0.001573 49.8900n 0.001597 49.9000n 0.001616 49.9100n 0.001629 49.9200n 0.001635 49.9300n 0.001634 49.9400n 0.001624
+ 49.9500n 0.001606 49.9600n 0.001578 49.9700n 0.001541 49.9800n 0.001493 49.9900n 0.001437 50.0000n 0.001370 50.0100n 0.001294 50.0200n 0.001209 50.0300n 0.001115 50.0400n 0.001013 50.0500n 0.000904 50.0600n 0.000789 50.0700n 0.000667 50.0800n 0.000541 50.0900n 0.000411
+ 50.1000n 0.000278 50.1100n 0.000143 50.1200n 0.000007 50.1300n -0.000130 50.1400n -0.000266 50.1500n -0.000401 50.1600n -0.000533 50.1700n -0.000663 50.1800n -0.000790 50.1900n -0.000913 50.2000n -0.001032 50.2100n -0.001147 50.2200n -0.001257 50.2300n -0.001361 50.2400n -0.001461
+ 50.2500n -0.001555 50.2600n -0.001644 50.2700n -0.001728 50.2800n -0.001806 50.2900n -0.001878 50.3000n -0.001944 50.3100n -0.002005 50.3200n -0.002059 50.3300n -0.002107 50.3400n -0.002148 50.3500n -0.002183 50.3600n -0.002210 50.3700n -0.002230 50.3800n -0.002242 50.3900n -0.002245
+ 50.4000n -0.002240 50.4100n -0.002226 50.4200n -0.002203 50.4300n -0.002170 50.4400n -0.002127 50.4500n -0.002075 50.4600n -0.002012 50.4700n -0.001940 50.4800n -0.001859 50.4900n -0.001769 50.5000n -0.001671 50.5100n -0.001565 50.5200n -0.001453 50.5300n -0.001335 50.5400n -0.001213
+ 50.5500n -0.001089 50.5600n -0.000963 50.5700n -0.000837 50.5800n -0.000714 50.5900n -0.000594 50.6000n -0.000480 50.6100n -0.000374 50.6200n -0.000276 50.6300n -0.000189 50.6400n -0.000114 50.6500n -0.000053 50.6600n -0.000006 50.6700n 0.000025 50.6800n 0.000041 50.6900n 0.000041
+ 50.7000n 0.000024 50.7100n -0.000008 50.7200n -0.000055 50.7300n -0.000117 50.7400n -0.000191 50.7500n -0.000275 50.7600n -0.000369 50.7700n -0.000470 50.7800n -0.000575 50.7900n -0.000681 50.8000n -0.000786 50.8100n -0.000886 50.8200n -0.000980 50.8300n -0.001063 50.8400n -0.001134
+ 50.8500n -0.001189 50.8600n -0.001225 50.8700n -0.001242 50.8800n -0.001236 50.8900n -0.001206 50.9000n -0.001151 50.9100n -0.001071 50.9200n -0.000965 50.9300n -0.000833 50.9400n -0.000677 50.9500n -0.000497 50.9600n -0.000295 50.9700n -0.000073 50.9800n 0.000165 50.9900n 0.000417
+ 51.0000n 0.000679 51.0100n 0.000949 51.0200n 0.001221 51.0300n 0.001492 51.0400n 0.001757 51.0500n 0.002013 51.0600n 0.002255 51.0700n 0.002480 51.0800n 0.002683 51.0900n 0.002862 51.1000n 0.003013 51.1100n 0.003134 51.1200n 0.003223 51.1300n 0.003278 51.1400n 0.003298
+ 51.1500n 0.003284 51.1600n 0.003235 51.1700n 0.003151 51.1800n 0.003036 51.1900n 0.002889 51.2000n 0.002715 51.2100n 0.002516 51.2200n 0.002296 51.2300n 0.002058 51.2400n 0.001807 51.2500n 0.001547 51.2600n 0.001282 51.2700n 0.001018 51.2800n 0.000757 51.2900n 0.000506
+ 51.3000n 0.000267 51.3100n 0.000045 51.3200n -0.000157 51.3300n -0.000335 51.3400n -0.000488 51.3500n -0.000614 51.3600n -0.000710 51.3700n -0.000776 51.3800n -0.000813 51.3900n -0.000820 51.4000n -0.000798 51.4100n -0.000750 51.4200n -0.000676 51.4300n -0.000581 51.4400n -0.000467
+ 51.4500n -0.000337 51.4600n -0.000196 51.4700n -0.000046 51.4800n 0.000107 51.4900n 0.000260 51.5000n 0.000409 51.5100n 0.000549 51.5200n 0.000678 51.5300n 0.000792 51.5400n 0.000887 51.5500n 0.000961 51.5600n 0.001012 51.5700n 0.001038 51.5800n 0.001039 51.5900n 0.001013
+ 51.6000n 0.000961 51.6100n 0.000884 51.6200n 0.000782 51.6300n 0.000658 51.6400n 0.000514 51.6500n 0.000351 51.6600n 0.000174 51.6700n -0.000014 51.6800n -0.000210 51.6900n -0.000411 51.7000n -0.000611 51.7100n -0.000808 51.7200n -0.000997 51.7300n -0.001176 51.7400n -0.001340
+ 51.7500n -0.001486 51.7600n -0.001612 51.7700n -0.001715 51.7800n -0.001794 51.7900n -0.001846 51.8000n -0.001871 51.8100n -0.001868 51.8200n -0.001837 51.8300n -0.001779 51.8400n -0.001695 51.8500n -0.001585 51.8600n -0.001453 51.8700n -0.001300 51.8800n -0.001128 51.8900n -0.000941
+ 51.9000n -0.000741 51.9100n -0.000532 51.9200n -0.000317 51.9300n -0.000098 51.9400n 0.000120 51.9500n 0.000335 51.9600n 0.000544 51.9700n 0.000744 51.9800n 0.000933 51.9900n 0.001108 52.0000n 0.001268 52.0100n 0.001411 52.0200n 0.001536 52.0300n 0.001641 52.0400n 0.001727
+ 52.0500n 0.001793 52.0600n 0.001840 52.0700n 0.001866 52.0800n 0.001874 52.0900n 0.001864 52.1000n 0.001838 52.1100n 0.001795 52.1200n 0.001738 52.1300n 0.001668 52.1400n 0.001587 52.1500n 0.001495 52.1600n 0.001395 52.1700n 0.001287 52.1800n 0.001172 52.1900n 0.001053
+ 52.2000n 0.000929 52.2100n 0.000802 52.2200n 0.000673 52.2300n 0.000542 52.2400n 0.000409 52.2500n 0.000276 52.2600n 0.000141 52.2700n 0.000007 52.2800n -0.000128 52.2900n -0.000263 52.3000n -0.000398 52.3100n -0.000532 52.3200n -0.000667 52.3300n -0.000800 52.3400n -0.000932
+ 52.3500n -0.001063 52.3600n -0.001192 52.3700n -0.001318 52.3800n -0.001440 52.3900n -0.001558 52.4000n -0.001671 52.4100n -0.001777 52.4200n -0.001876 52.4300n -0.001966 52.4400n -0.002046 52.4500n -0.002115 52.4600n -0.002171 52.4700n -0.002214 52.4800n -0.002243 52.4900n -0.002256
+ 52.5000n -0.002254 52.5100n -0.002234 52.5200n -0.002198 52.5300n -0.002146 52.5400n -0.002076 52.5500n -0.001990 52.5600n -0.001889 52.5700n -0.001773 52.5800n -0.001644 52.5900n -0.001504 52.6000n -0.001353 52.6100n -0.001193 52.6200n -0.001028 52.6300n -0.000859 52.6400n -0.000688
+ 52.6500n -0.000518 52.6600n -0.000350 52.6700n -0.000188 52.6800n -0.000034 52.6900n 0.000112 52.7000n 0.000245 52.7100n 0.000366 52.7200n 0.000472 52.7300n 0.000563 52.7400n 0.000637 52.7500n 0.000695 52.7600n 0.000735 52.7700n 0.000758 52.7800n 0.000765 52.7900n 0.000756
+ 52.8000n 0.000732 52.8100n 0.000695 52.8200n 0.000647 52.8300n 0.000588 52.8400n 0.000521 52.8500n 0.000448 52.8600n 0.000371 52.8700n 0.000292 52.8800n 0.000213 52.8900n 0.000136 52.9000n 0.000063 52.9100n -0.000006 52.9200n -0.000067 52.9300n -0.000121 52.9400n -0.000167
+ 52.9500n -0.000203 52.9600n -0.000231 52.9700n -0.000249 52.9800n -0.000258 52.9900n -0.000259 53.0000n -0.000254 53.0100n -0.000242 53.0200n -0.000225 53.0300n -0.000206 53.0400n -0.000185 53.0500n -0.000165 53.0600n -0.000146 53.0700n -0.000132 53.0800n -0.000122 53.0900n -0.000119
+ 53.1000n -0.000124 53.1100n -0.000138 53.1200n -0.000162 53.1300n -0.000196 53.1400n -0.000240 53.1500n -0.000293 53.1600n -0.000356 53.1700n -0.000427 53.1800n -0.000506 53.1900n -0.000590 53.2000n -0.000677 53.2100n -0.000766 53.2200n -0.000854 53.2300n -0.000939 53.2400n -0.001019
+ 53.2500n -0.001090 53.2600n -0.001150 53.2700n -0.001198 53.2800n -0.001230 53.2900n -0.001244 53.3000n -0.001240 53.3100n -0.001215 53.3200n -0.001169 53.3300n -0.001101 53.3400n -0.001011 53.3500n -0.000899 53.3600n -0.000767 53.3700n -0.000615 53.3800n -0.000445 53.3900n -0.000260
+ 53.4000n -0.000062 53.4100n 0.000146 53.4200n 0.000361 53.4300n 0.000579 53.4400n 0.000797 53.4500n 0.001010 53.4600n 0.001216 53.4700n 0.001410 53.4800n 0.001589 53.4900n 0.001749 53.5000n 0.001888 53.5100n 0.002003 53.5200n 0.002091 53.5300n 0.002151 53.5400n 0.002182
+ 53.5500n 0.002183 53.5600n 0.002153 53.5700n 0.002094 53.5800n 0.002006 53.5900n 0.001892 53.6000n 0.001752 53.6100n 0.001591 53.6200n 0.001410 53.6300n 0.001214 53.6400n 0.001006 53.6500n 0.000791 53.6600n 0.000573 53.6700n 0.000355 53.6800n 0.000142 53.6900n -0.000061
+ 53.7000n -0.000251 53.7100n -0.000424 53.7200n -0.000577 53.7300n -0.000707 53.7400n -0.000812 53.7500n -0.000890 53.7600n -0.000940 53.7700n -0.000960 53.7800n -0.000952 53.7900n -0.000915 53.8000n -0.000852 53.8100n -0.000763 53.8200n -0.000651 53.8300n -0.000520 53.8400n -0.000372
+ 53.8500n -0.000212 53.8600n -0.000042 53.8700n 0.000132 53.8800n 0.000307 53.8900n 0.000478 53.9000n 0.000641 53.9100n 0.000792 53.9200n 0.000928 53.9300n 0.001044 53.9400n 0.001139 53.9500n 0.001208 53.9600n 0.001251 53.9700n 0.001266 53.9800n 0.001252 53.9900n 0.001210
+ 54.0000n 0.001138 54.0100n 0.001039 54.0200n 0.000914 54.0300n 0.000766 54.0400n 0.000597 54.0500n 0.000410 54.0600n 0.000209 54.0700n -0.000003 54.0800n -0.000221 54.0900n -0.000441 54.1000n -0.000659 54.1100n -0.000870 54.1200n -0.001071 54.1300n -0.001258 54.1400n -0.001426
+ 54.1500n -0.001574 54.1600n -0.001698 54.1700n -0.001795 54.1800n -0.001865 54.1900n -0.001906 54.2000n -0.001917 54.2100n -0.001898 54.2200n -0.001851 54.2300n -0.001775 54.2400n -0.001673 54.2500n -0.001546 54.2600n -0.001398 54.2700n -0.001232 54.2800n -0.001050 54.2900n -0.000855
+ 54.3000n -0.000653 54.3100n -0.000446 54.3200n -0.000238 54.3300n -0.000033 54.3400n 0.000166 54.3500n 0.000356 54.3600n 0.000533 54.3700n 0.000696 54.3800n 0.000841 54.3900n 0.000967 54.4000n 0.001073 54.4100n 0.001158 54.4200n 0.001221 54.4300n 0.001263 54.4400n 0.001285
+ 54.4500n 0.001287 54.4600n 0.001270 54.4700n 0.001237 54.4800n 0.001189 54.4900n 0.001129 54.5000n 0.001059 54.5100n 0.000982 54.5200n 0.000900 54.5300n 0.000816 54.5400n 0.000732 54.5500n 0.000650 54.5600n 0.000573 54.5700n 0.000502 54.5800n 0.000439 54.5900n 0.000385
+ 54.6000n 0.000341 54.6100n 0.000306 54.6200n 0.000282 54.6300n 0.000268 54.6400n 0.000262 54.6500n 0.000264 54.6600n 0.000273 54.6700n 0.000287 54.6800n 0.000304 54.6900n 0.000321 54.7000n 0.000338 54.7100n 0.000350 54.7200n 0.000358 54.7300n 0.000357 54.7400n 0.000347
+ 54.7500n 0.000325 54.7600n 0.000289 54.7700n 0.000240 54.7800n 0.000175 54.7900n 0.000094 54.8000n -0.000003 54.8100n -0.000116 54.8200n -0.000245 54.8300n -0.000388 54.8400n -0.000544 54.8500n -0.000712 54.8600n -0.000889 54.8700n -0.001074 54.8800n -0.001263 54.8900n -0.001454
+ 54.9000n -0.001644 54.9100n -0.001830 54.9200n -0.002009 54.9300n -0.002179 54.9400n -0.002336 54.9500n -0.002479 54.9600n -0.002604 54.9700n -0.002710 54.9800n -0.002795 54.9900n -0.002857 55.0000n -0.002896 55.0100n -0.002912 55.0200n -0.002903 55.0300n -0.002871 55.0400n -0.002816
+ 55.0500n -0.002739 55.0600n -0.002642 55.0700n -0.002526 55.0800n -0.002395 55.0900n -0.002250 55.1000n -0.002095 55.1100n -0.001931 55.1200n -0.001762 55.1300n -0.001592 55.1400n -0.001423 55.1500n -0.001257 55.1600n -0.001099 55.1700n -0.000950 55.1800n -0.000813 55.1900n -0.000691
+ 55.2000n -0.000584 55.2100n -0.000494 55.2200n -0.000424 55.2300n -0.000372 55.2400n -0.000340 55.2500n -0.000328 55.2600n -0.000334 55.2700n -0.000360 55.2800n -0.000402 55.2900n -0.000460 55.3000n -0.000532 55.3100n -0.000616 55.3200n -0.000709 55.3300n -0.000811 55.3400n -0.000917
+ 55.3500n -0.001027 55.3600n -0.001136 55.3700n -0.001244 55.3800n -0.001347 55.3900n -0.001443 55.4000n -0.001531 55.4100n -0.001609 55.4200n -0.001675 55.4300n -0.001728 55.4400n -0.001767 55.4500n -0.001792 55.4600n -0.001801 55.4700n -0.001796 55.4800n -0.001776 55.4900n -0.001742
+ 55.5000n -0.001694 55.5100n -0.001633 55.5200n -0.001561 55.5300n -0.001480 55.5400n -0.001389 55.5500n -0.001292 55.5600n -0.001190 55.5700n -0.001084 55.5800n -0.000976 55.5900n -0.000868 55.6000n -0.000762 55.6100n -0.000658 55.6200n -0.000558 55.6300n -0.000464 55.6400n -0.000376
+ 55.6500n -0.000296 55.6600n -0.000223 55.6700n -0.000158 55.6800n -0.000102 55.6900n -0.000054 55.7000n -0.000015 55.7100n 0.000016 55.7200n 0.000039 55.7300n 0.000056 55.7400n 0.000066 55.7500n 0.000071 55.7600n 0.000071 55.7700n 0.000069 55.7800n 0.000064 55.7900n 0.000057
+ 55.8000n 0.000051 55.8100n 0.000045 55.8200n 0.000041 55.8300n 0.000040 55.8400n 0.000043 55.8500n 0.000049 55.8600n 0.000061 55.8700n 0.000078 55.8800n 0.000101 55.8900n 0.000130 55.9000n 0.000165 55.9100n 0.000207 55.9200n 0.000254 55.9300n 0.000307 55.9400n 0.000366
+ 55.9500n 0.000430 55.9600n 0.000499 55.9700n 0.000572 55.9800n 0.000648 55.9900n 0.000726 56.0000n 0.000807 56.0100n 0.000888 56.0200n 0.000970 56.0300n 0.001052 56.0400n 0.001133 56.0500n 0.001211 56.0600n 0.001287 56.0700n 0.001360 56.0800n 0.001429 56.0900n 0.001493
+ 56.1000n 0.001552 56.1100n 0.001606 56.1200n 0.001654 56.1300n 0.001697 56.1400n 0.001733 56.1500n 0.001762 56.1600n 0.001786 56.1700n 0.001803 56.1800n 0.001814 56.1900n 0.001819 56.2000n 0.001818 56.2100n 0.001812 56.2200n 0.001801 56.2300n 0.001785 56.2400n 0.001765
+ 56.2500n 0.001742 56.2600n 0.001716 56.2700n 0.001687 56.2800n 0.001657 56.2900n 0.001626 56.3000n 0.001595 56.3100n 0.001563 56.3200n 0.001532 56.3300n 0.001503 56.3400n 0.001475 56.3500n 0.001450 56.3600n 0.001427 56.3700n 0.001406 56.3800n 0.001389 56.3900n 0.001375
+ 56.4000n 0.001364 56.4100n 0.001356 56.4200n 0.001351 56.4300n 0.001348 56.4400n 0.001347 56.4500n 0.001348 56.4600n 0.001350 56.4700n 0.001353 56.4800n 0.001355 56.4900n 0.001356 56.5000n 0.001355 56.5100n 0.001351 56.5200n 0.001344 56.5300n 0.001331 56.5400n 0.001314
+ 56.5500n 0.001291 56.5600n 0.001260 56.5700n 0.001222 56.5800n 0.001177 56.5900n 0.001123 56.6000n 0.001061 56.6100n 0.000990 56.6200n 0.000911 56.6300n 0.000824 56.6400n 0.000729 56.6500n 0.000628 56.6600n 0.000520 56.6700n 0.000407 56.6800n 0.000290 56.6900n 0.000171
+ 56.7000n 0.000050 56.7100n -0.000071 56.7200n -0.000189 56.7300n -0.000305 56.7400n -0.000416 56.7500n -0.000520 56.7600n -0.000616 56.7700n -0.000703 56.7800n -0.000779 56.7900n -0.000843 56.8000n -0.000894 56.8100n -0.000932 56.8200n -0.000956 56.8300n -0.000965 56.8400n -0.000961
+ 56.8500n -0.000942 56.8600n -0.000910 56.8700n -0.000865 56.8800n -0.000809 56.8900n -0.000742 56.9000n -0.000667 56.9100n -0.000586 56.9200n -0.000500 56.9300n -0.000411 56.9400n -0.000321 56.9500n -0.000233 56.9600n -0.000149 56.9700n -0.000072 56.9800n -0.000002 56.9900n 0.000058
+ 57.0000n 0.000106 57.0100n 0.000141 57.0200n 0.000162 57.0300n 0.000167 57.0400n 0.000157 57.0500n 0.000131 57.0600n 0.000089 57.0700n 0.000033 57.0800n -0.000038 57.0900n -0.000121 57.1000n -0.000216 57.1100n -0.000319 57.1200n -0.000428 57.1300n -0.000541 57.1400n -0.000656
+ 57.1500n -0.000768 57.1600n -0.000876 57.1700n -0.000976 57.1800n -0.001064 57.1900n -0.001139 57.2000n -0.001197 57.2100n -0.001236 57.2200n -0.001254 57.2300n -0.001248 57.2400n -0.001218 57.2500n -0.001163 57.2600n -0.001081 57.2700n -0.000974 57.2800n -0.000841 57.2900n -0.000685
+ 57.3000n -0.000505 57.3100n -0.000306 57.3200n -0.000089 57.3300n 0.000143 57.3400n 0.000386 57.3500n 0.000637 57.3600n 0.000890 57.3700n 0.001143 57.3800n 0.001390 57.3900n 0.001627 57.4000n 0.001850 57.4100n 0.002055 57.4200n 0.002237 57.4300n 0.002393 57.4400n 0.002519
+ 57.4500n 0.002612 57.4600n 0.002671 57.4700n 0.002694 57.4800n 0.002678 57.4900n 0.002624 57.5000n 0.002533 57.5100n 0.002403 57.5200n 0.002238 57.5300n 0.002039 57.5400n 0.001810 57.5500n 0.001552 57.5600n 0.001271 57.5700n 0.000970 57.5800n 0.000654 57.5900n 0.000329
+ 57.6000n -0.000001 57.6100n -0.000331 57.6200n -0.000656 57.6300n -0.000969 57.6400n -0.001266 57.6500n -0.001543 57.6600n -0.001795 57.6700n -0.002018 57.6800n -0.002209 57.6900n -0.002364 57.7000n -0.002483 57.7100n -0.002563 57.7200n -0.002603 57.7300n -0.002604 57.7400n -0.002565
+ 57.7500n -0.002489 57.7600n -0.002376 57.7700n -0.002230 57.7800n -0.002053 57.7900n -0.001850 57.8000n -0.001623 57.8100n -0.001377 57.8200n -0.001117 57.8300n -0.000847 57.8400n -0.000572 57.8500n -0.000296 57.8600n -0.000025 57.8700n 0.000239 57.8800n 0.000491 57.8900n 0.000727
+ 57.9000n 0.000944 57.9100n 0.001140 57.9200n 0.001313 57.9300n 0.001460 57.9400n 0.001582 57.9500n 0.001678 57.9600n 0.001748 57.9700n 0.001793 57.9800n 0.001814 57.9900n 0.001814 58.0000n 0.001794 58.0100n 0.001758 58.0200n 0.001708 58.0300n 0.001647 58.0400n 0.001579
+ 58.0500n 0.001507 58.0600n 0.001435 58.0700n 0.001365 58.0800n 0.001300 58.0900n 0.001244 58.1000n 0.001198 58.1100n 0.001165 58.1200n 0.001146 58.1300n 0.001142 58.1400n 0.001153 58.1500n 0.001181 58.1600n 0.001223 58.1700n 0.001280 58.1800n 0.001350 58.1900n 0.001430
+ 58.2000n 0.001519 58.2100n 0.001613 58.2200n 0.001711 58.2300n 0.001808 58.2400n 0.001901 58.2500n 0.001988 58.2600n 0.002064 58.2700n 0.002127 58.2800n 0.002174 58.2900n 0.002202 58.3000n 0.002209 58.3100n 0.002193 58.3200n 0.002152 58.3300n 0.002086 58.3400n 0.001994
+ 58.3500n 0.001876 58.3600n 0.001733 58.3700n 0.001567 58.3800n 0.001379 58.3900n 0.001172 58.4000n 0.000949 58.4100n 0.000712 58.4200n 0.000465 58.4300n 0.000213 58.4400n -0.000041 58.4500n -0.000292 58.4600n -0.000537 58.4700n -0.000770 58.4800n -0.000988 58.4900n -0.001187
+ 58.5000n -0.001364 58.5100n -0.001516 58.5200n -0.001639 58.5300n -0.001731 58.5400n -0.001792 58.5500n -0.001820 58.5600n -0.001814 58.5700n -0.001776 58.5800n -0.001705 58.5900n -0.001604 58.6000n -0.001474 58.6100n -0.001319 58.6200n -0.001141 58.6300n -0.000945 58.6400n -0.000734
+ 58.6500n -0.000512 58.6600n -0.000284 58.6700n -0.000055 58.6800n 0.000170 58.6900n 0.000388 58.7000n 0.000593 58.7100n 0.000781 58.7200n 0.000949 58.7300n 0.001093 58.7400n 0.001210 58.7500n 0.001297 58.7600n 0.001353 58.7700n 0.001377 58.7800n 0.001368 58.7900n 0.001325
+ 58.8000n 0.001251 58.8100n 0.001146 58.8200n 0.001011 58.8300n 0.000851 58.8400n 0.000668 58.8500n 0.000465 58.8600n 0.000247 58.8700n 0.000017 58.8800n -0.000219 58.8900n -0.000456 58.9000n -0.000691 58.9100n -0.000918 58.9200n -0.001133 58.9300n -0.001332 58.9400n -0.001509
+ 58.9500n -0.001662 58.9600n -0.001788 58.9700n -0.001883 58.9800n -0.001945 58.9900n -0.001972 59.0000n -0.001965 59.0100n -0.001922 59.0200n -0.001843 59.0300n -0.001730 59.0400n -0.001584 59.0500n -0.001408 59.0600n -0.001203 59.0700n -0.000974 59.0800n -0.000724 59.0900n -0.000456
+ 59.1000n -0.000177 59.1100n 0.000111 59.1200n 0.000403 59.1300n 0.000693 59.1400n 0.000977 59.1500n 0.001251 59.1600n 0.001510 59.1700n 0.001749 59.1800n 0.001966 59.1900n 0.002156 59.2000n 0.002317 59.2100n 0.002447 59.2200n 0.002543 59.2300n 0.002604 59.2400n 0.002630
+ 59.2500n 0.002621 59.2600n 0.002576 59.2700n 0.002497 59.2800n 0.002386 59.2900n 0.002244 59.3000n 0.002075 59.3100n 0.001880 59.3200n 0.001665 59.3300n 0.001431 59.3400n 0.001184 59.3500n 0.000927 59.3600n 0.000664 59.3700n 0.000400 59.3800n 0.000139 59.3900n -0.000115
+ 59.4000n -0.000359 59.4100n -0.000589 59.4200n -0.000801 59.4300n -0.000992 59.4400n -0.001160 59.4500n -0.001304 59.4600n -0.001420 59.4700n -0.001508 59.4800n -0.001567 59.4900n -0.001597 59.5000n -0.001598 59.5100n -0.001571 59.5200n -0.001517 59.5300n -0.001438 59.5400n -0.001335
+ 59.5500n -0.001211 59.5600n -0.001069 59.5700n -0.000911 59.5800n -0.000741 59.5900n -0.000561 59.6000n -0.000376 59.6100n -0.000188 59.6200n -0.000000 59.6300n 0.000183 59.6400n 0.000360 59.6500n 0.000527 59.6600n 0.000681 59.6700n 0.000821 59.6800n 0.000944 59.6900n 0.001048
+ 59.7000n 0.001132 59.7100n 0.001195 59.7200n 0.001237 59.7300n 0.001256 59.7400n 0.001255 59.7500n 0.001232 59.7600n 0.001190 59.7700n 0.001128 59.7800n 0.001050 59.7900n 0.000956 59.8000n 0.000850 59.8100n 0.000732 59.8200n 0.000607 59.8300n 0.000476 59.8400n 0.000342
+ 59.8500n 0.000208 59.8600n 0.000076 59.8700n -0.000050 59.8800n -0.000169 59.8900n -0.000279 59.9000n -0.000376 59.9100n -0.000459 59.9200n -0.000527 59.9300n -0.000579 59.9400n -0.000613 59.9500n -0.000629 59.9600n -0.000626 59.9700n -0.000605 59.9800n -0.000567 59.9900n -0.000511
+ 60.0000n -0.000440 60.0100n -0.000355 60.0200n -0.000256 60.0300n -0.000148 60.0400n -0.000031 60.0500n 0.000092 60.0600n 0.000219 60.0700n 0.000346 60.0800n 0.000471 60.0900n 0.000592 60.1000n 0.000705 60.1100n 0.000809 60.1200n 0.000901 60.1300n 0.000978 60.1400n 0.001039
+ 60.1500n 0.001083 60.1600n 0.001107 60.1700n 0.001110 60.1800n 0.001092 60.1900n 0.001053 60.2000n 0.000991 60.2100n 0.000909 60.2200n 0.000806 60.2300n 0.000683 60.2400n 0.000541 60.2500n 0.000383 60.2600n 0.000210 60.2700n 0.000025 60.2800n -0.000170 60.2900n -0.000373
+ 60.3000n -0.000581 60.3100n -0.000791 60.3200n -0.000999 60.3300n -0.001205 60.3400n -0.001403 60.3500n -0.001593 60.3600n -0.001771 60.3700n -0.001935 60.3800n -0.002083 60.3900n -0.002213 60.4000n -0.002323 60.4100n -0.002413 60.4200n -0.002481 60.4300n -0.002527 60.4400n -0.002550
+ 60.4500n -0.002551 60.4600n -0.002529 60.4700n -0.002487 60.4800n -0.002424 60.4900n -0.002342 60.5000n -0.002243 60.5100n -0.002128 60.5200n -0.002000 60.5300n -0.001861 60.5400n -0.001712 60.5500n -0.001557 60.5600n -0.001397 60.5700n -0.001235 60.5800n -0.001073 60.5900n -0.000913
+ 60.6000n -0.000758 60.6100n -0.000609 60.6200n -0.000468 60.6300n -0.000337 60.6400n -0.000217 60.6500n -0.000108 60.6600n -0.000013 60.6700n 0.000069 60.6800n 0.000137 60.6900n 0.000192 60.7000n 0.000233 60.7100n 0.000260 60.7200n 0.000275 60.7300n 0.000278 60.7400n 0.000269
+ 60.7500n 0.000251 60.7600n 0.000223 60.7700n 0.000188 60.7800n 0.000146 60.7900n 0.000099 60.8000n 0.000048 60.8100n -0.000006 60.8200n -0.000061 60.8300n -0.000117 60.8400n -0.000172 60.8500n -0.000226 60.8600n -0.000277 60.8700n -0.000324 60.8800n -0.000368 60.8900n -0.000408
+ 60.9000n -0.000443 60.9100n -0.000472 60.9200n -0.000497 60.9300n -0.000516 60.9400n -0.000530 60.9500n -0.000539 60.9600n -0.000543 60.9700n -0.000542 60.9800n -0.000536 60.9900n -0.000526 61.0000n -0.000511 61.0100n -0.000493 61.0200n -0.000471 61.0300n -0.000446 61.0400n -0.000417
+ 61.0500n -0.000386 61.0600n -0.000352 61.0700n -0.000315 61.0800n -0.000277 61.0900n -0.000236 61.1000n -0.000194 61.1100n -0.000149 61.1200n -0.000104 61.1300n -0.000058 61.1400n -0.000010 61.1500n 0.000037 61.1600n 0.000085 61.1700n 0.000132 61.1800n 0.000179 61.1900n 0.000223
+ 61.2000n 0.000266 61.2100n 0.000307 61.2200n 0.000344 61.2300n 0.000377 61.2400n 0.000405 61.2500n 0.000428 61.2600n 0.000444 61.2700n 0.000454 61.2800n 0.000457 61.2900n 0.000451 61.3000n 0.000437 61.3100n 0.000414 61.3200n 0.000382 61.3300n 0.000341 61.3400n 0.000291
+ 61.3500n 0.000232 61.3600n 0.000163 61.3700n 0.000087 61.3800n 0.000003 61.3900n -0.000087 61.4000n -0.000183 61.4100n -0.000284 61.4200n -0.000388 61.4300n -0.000494 61.4400n -0.000601 61.4500n -0.000706 61.4600n -0.000809 61.4700n -0.000908 61.4800n -0.001002 61.4900n -0.001089
+ 61.5000n -0.001168 61.5100n -0.001237 61.5200n -0.001296 61.5300n -0.001345 61.5400n -0.001381 61.5500n -0.001406 61.5600n -0.001419 61.5700n -0.001420 61.5800n -0.001410 61.5900n -0.001389 61.6000n -0.001359 61.6100n -0.001320 61.6200n -0.001275 61.6300n -0.001224 61.6400n -0.001170
+ 61.6500n -0.001115 61.6600n -0.001060 61.6700n -0.001008 61.6800n -0.000960 61.6900n -0.000919 61.7000n -0.000886 61.7100n -0.000863 61.7200n -0.000853 61.7300n -0.000855 61.7400n -0.000870 61.7500n -0.000901 61.7600n -0.000946 61.7700n -0.001006 61.7800n -0.001080 61.7900n -0.001168
+ 61.8000n -0.001268 61.8100n -0.001379 61.8200n -0.001498 61.8300n -0.001625 61.8400n -0.001755 61.8500n -0.001887 61.8600n -0.002018 61.8700n -0.002144 61.8800n -0.002263 61.8900n -0.002372 61.9000n -0.002467 61.9100n -0.002546 61.9200n -0.002606 61.9300n -0.002646 61.9400n -0.002661
+ 61.9500n -0.002653 61.9600n -0.002618 61.9700n -0.002556 61.9800n -0.002467 61.9900n -0.002352 62.0000n -0.002210 62.0100n -0.002044 62.0200n -0.001854 62.0300n -0.001644 62.0400n -0.001415 62.0500n -0.001171 62.0600n -0.000915 62.0700n -0.000651 62.0800n -0.000383 62.0900n -0.000113
+ 62.1000n 0.000152 62.1100n 0.000411 62.1200n 0.000658 62.1300n 0.000890 62.1400n 0.001104 62.1500n 0.001297 62.1600n 0.001466 62.1700n 0.001608 62.1800n 0.001723 62.1900n 0.001809 62.2000n 0.001865 62.2100n 0.001892 62.2200n 0.001890 62.2300n 0.001861 62.2400n 0.001805
+ 62.2500n 0.001725 62.2600n 0.001625 62.2700n 0.001506 62.2800n 0.001372 62.2900n 0.001228 62.3000n 0.001076 62.3100n 0.000921 62.3200n 0.000766 62.3300n 0.000616 62.3400n 0.000474 62.3500n 0.000344 62.3600n 0.000228 62.3700n 0.000130 62.3800n 0.000051 62.3900n -0.000006
+ 62.4000n -0.000041 62.4100n -0.000053 62.4200n -0.000041 62.4300n -0.000007 62.4400n 0.000049 62.4500n 0.000125 62.4600n 0.000218 62.4700n 0.000327 62.4800n 0.000448 62.4900n 0.000577 62.5000n 0.000712 62.5100n 0.000848 62.5200n 0.000981 62.5300n 0.001109 62.5400n 0.001227
+ 62.5500n 0.001332 62.5600n 0.001421 62.5700n 0.001490 62.5800n 0.001538 62.5900n 0.001563 62.6000n 0.001564 62.6100n 0.001539 62.6200n 0.001490 62.6300n 0.001415 62.6400n 0.001317 62.6500n 0.001197 62.6600n 0.001057 62.6700n 0.000901 62.6800n 0.000731 62.6900n 0.000552
+ 62.7000n 0.000366 62.7100n 0.000178 62.7200n -0.000007 62.7300n -0.000186 62.7400n -0.000354 62.7500n -0.000507 62.7600n -0.000642 62.7700n -0.000755 62.7800n -0.000844 62.7900n -0.000905 62.8000n -0.000938 62.8100n -0.000940 62.8200n -0.000912 62.8300n -0.000854 62.8400n -0.000765
+ 62.8500n -0.000649 62.8600n -0.000507 62.8700n -0.000341 62.8800n -0.000154 62.8900n 0.000048 62.9000n 0.000263 62.9100n 0.000486 62.9200n 0.000712 62.9300n 0.000937 62.9400n 0.001156 62.9500n 0.001364 62.9600n 0.001557 62.9700n 0.001731 62.9800n 0.001882 62.9900n 0.002006
+ 63.0000n 0.002102 63.0100n 0.002168 63.0200n 0.002201 63.0300n 0.002201 63.0400n 0.002168 63.0500n 0.002102 63.0600n 0.002006 63.0700n 0.001881 63.0800n 0.001730 63.0900n 0.001556 63.1000n 0.001363 63.1100n 0.001155 63.1200n 0.000936 63.1300n 0.000711 63.1400n 0.000485
+ 63.1500n 0.000261 63.1600n 0.000046 63.1700n -0.000157 63.1800n -0.000344 63.1900n -0.000511 63.2000n -0.000656 63.2100n -0.000774 63.2200n -0.000866 63.2300n -0.000928 63.2400n -0.000961 63.2500n -0.000966 63.2600n -0.000942 63.2700n -0.000891 63.2800n -0.000815 63.2900n -0.000717
+ 63.3000n -0.000601 63.3100n -0.000470 63.3200n -0.000327 63.3300n -0.000178 63.3400n -0.000027 63.3500n 0.000122 63.3600n 0.000264 63.3700n 0.000395 63.3800n 0.000512 63.3900n 0.000609 63.4000n 0.000685 63.4100n 0.000736 63.4200n 0.000761 63.4300n 0.000758 63.4400n 0.000726
+ 63.4500n 0.000665 63.4600n 0.000576 63.4700n 0.000461 63.4800n 0.000321 63.4900n 0.000158 63.5000n -0.000023 63.5100n -0.000219 63.5200n -0.000427 63.5300n -0.000641 63.5400n -0.000857 63.5500n -0.001071 63.5600n -0.001278 63.5700n -0.001472 63.5800n -0.001651 63.5900n -0.001809
+ 63.6000n -0.001943 63.6100n -0.002051 63.6200n -0.002129 63.6300n -0.002175 63.6400n -0.002189 63.6500n -0.002170 63.6600n -0.002118 63.6700n -0.002033 63.6800n -0.001918 63.6900n -0.001775 63.7000n -0.001606 63.7100n -0.001416 63.7200n -0.001207 63.7300n -0.000984 63.7400n -0.000751
+ 63.7500n -0.000513 63.7600n -0.000275 63.7700n -0.000042 63.7800n 0.000183 63.7900n 0.000394 63.8000n 0.000589 63.8100n 0.000763 63.8200n 0.000913 63.8300n 0.001038 63.8400n 0.001135 63.8500n 0.001204 63.8600n 0.001243 63.8700n 0.001254 63.8800n 0.001238 63.8900n 0.001195
+ 63.9000n 0.001129 63.9100n 0.001042 63.9200n 0.000938 63.9300n 0.000819 63.9400n 0.000690 63.9500n 0.000556 63.9600n 0.000420 63.9700n 0.000286 63.9800n 0.000160 63.9900n 0.000043 64.0000n -0.000058 64.0100n -0.000143 64.0200n -0.000207 64.0300n -0.000249 64.0400n -0.000268
+ 64.0500n -0.000262 64.0600n -0.000231 64.0700n -0.000175 64.0800n -0.000097 64.0900n 0.000003 64.1000n 0.000122 64.1100n 0.000257 64.1200n 0.000404 64.1300n 0.000560 64.1400n 0.000721 64.1500n 0.000882 64.1600n 0.001039 64.1700n 0.001188 64.1800n 0.001324 64.1900n 0.001442
+ 64.2000n 0.001540 64.2100n 0.001614 64.2200n 0.001661 64.2300n 0.001679 64.2400n 0.001667 64.2500n 0.001622 64.2600n 0.001546 64.2700n 0.001438 64.2800n 0.001300 64.2900n 0.001133 64.3000n 0.000941 64.3100n 0.000727 64.3200n 0.000494 64.3300n 0.000246 64.3400n -0.000011
+ 64.3500n -0.000274 64.3600n -0.000536 64.3700n -0.000793 64.3800n -0.001040 64.3900n -0.001272 64.4000n -0.001484 64.4100n -0.001673 64.4200n -0.001833 64.4300n -0.001963 64.4400n -0.002060 64.4500n -0.002121 64.4600n -0.002146 64.4700n -0.002134 64.4800n -0.002086 64.4900n -0.002004
+ 64.5000n -0.001888 64.5100n -0.001742 64.5200n -0.001569 64.5300n -0.001372 64.5400n -0.001157 64.5500n -0.000928 64.5600n -0.000690 64.5700n -0.000447 64.5800n -0.000207 64.5900n 0.000027 64.6000n 0.000249 64.6100n 0.000455 64.6200n 0.000640 64.6300n 0.000799 64.6400n 0.000931
+ 64.6500n 0.001031 64.6600n 0.001099 64.6700n 0.001132 64.6800n 0.001131 64.6900n 0.001095 64.7000n 0.001025 64.7100n 0.000924 64.7200n 0.000793 64.7300n 0.000637 64.7400n 0.000457 64.7500n 0.000260 64.7600n 0.000049 64.7700n -0.000171 64.7800n -0.000394 64.7900n -0.000615
+ 64.8000n -0.000830 64.8100n -0.001033 64.8200n -0.001218 64.8300n -0.001383 64.8400n -0.001522 64.8500n -0.001632 64.8600n -0.001710 64.8700n -0.001753 64.8800n -0.001760 64.8900n -0.001731 64.9000n -0.001664 64.9100n -0.001560 64.9200n -0.001421 64.9300n -0.001247 64.9400n -0.001043
+ 64.9500n -0.000810 64.9600n -0.000552 64.9700n -0.000274 64.9800n 0.000021 64.9900n 0.000328 65.0000n 0.000642 65.0100n 0.000959 65.0200n 0.001273 65.0300n 0.001581 65.0400n 0.001878 65.0500n 0.002160 65.0600n 0.002423 65.0700n 0.002665 65.0800n 0.002881 65.0900n 0.003071
+ 65.1000n 0.003233 65.1100n 0.003365 65.1200n 0.003467 65.1300n 0.003538 65.1400n 0.003580 65.1500n 0.003594 65.1600n 0.003580 65.1700n 0.003541 65.1800n 0.003480 65.1900n 0.003397 65.2000n 0.003296 65.2100n 0.003180 65.2200n 0.003052 65.2300n 0.002914 65.2400n 0.002768
+ 65.2500n 0.002619 65.2600n 0.002467 65.2700n 0.002315 65.2800n 0.002165 65.2900n 0.002019 65.3000n 0.001876 65.3100n 0.001740 65.3200n 0.001609 65.3300n 0.001485 65.3400n 0.001367 65.3500n 0.001255 65.3600n 0.001148 65.3700n 0.001046 65.3800n 0.000947 65.3900n 0.000851
+ 65.4000n 0.000757 65.4100n 0.000663 65.4200n 0.000570 65.4300n 0.000475 65.4400n 0.000378 65.4500n 0.000279 65.4600n 0.000177 65.4700n 0.000073 65.4800n -0.000033 65.4900n -0.000142 65.5000n -0.000252 65.5100n -0.000362 65.5200n -0.000471 65.5300n -0.000578 65.5400n -0.000680
+ 65.5500n -0.000777 65.5600n -0.000867 65.5700n -0.000947 65.5800n -0.001016 65.5900n -0.001072 65.6000n -0.001114 65.6100n -0.001140 65.6200n -0.001149 65.6300n -0.001140 65.6400n -0.001113 65.6500n -0.001067 65.6600n -0.001003 65.6700n -0.000920 65.6800n -0.000821 65.6900n -0.000706
+ 65.7000n -0.000577 65.7100n -0.000436 65.7200n -0.000286 65.7300n -0.000128 65.7400n 0.000034 65.7500n 0.000197 65.7600n 0.000358 65.7700n 0.000513 65.7800n 0.000661 65.7900n 0.000798 65.8000n 0.000920 65.8100n 0.001026 65.8200n 0.001113 65.8300n 0.001179 65.8400n 0.001222
+ 65.8500n 0.001241 65.8600n 0.001236 65.8700n 0.001207 65.8800n 0.001153 65.8900n 0.001076 65.9000n 0.000977 65.9100n 0.000857 65.9200n 0.000719 65.9300n 0.000566 65.9400n 0.000400 65.9500n 0.000224 65.9600n 0.000042 65.9700n -0.000141 65.9800n -0.000324 65.9900n -0.000502
+ 66.0000n -0.000671 66.0100n -0.000829 66.0200n -0.000971 66.0300n -0.001096 66.0400n -0.001200 66.0500n -0.001282 66.0600n -0.001340 66.0700n -0.001373 66.0800n -0.001380 66.0900n -0.001361 66.1000n -0.001317 66.1100n -0.001249 66.1200n -0.001157 66.1300n -0.001045 66.1400n -0.000915
+ 66.1500n -0.000768 66.1600n -0.000610 66.1700n -0.000442 66.1800n -0.000268 66.1900n -0.000093 66.2000n 0.000081 66.2100n 0.000249 66.2200n 0.000408 66.2300n 0.000554 66.2400n 0.000685 66.2500n 0.000798 66.2600n 0.000890 66.2700n 0.000960 66.2800n 0.001006 66.2900n 0.001026
+ 66.3000n 0.001021 66.3100n 0.000990 66.3200n 0.000934 66.3300n 0.000854 66.3400n 0.000752 66.3500n 0.000629 66.3600n 0.000487 66.3700n 0.000331 66.3800n 0.000161 66.3900n -0.000018 66.4000n -0.000203 66.4100n -0.000391 66.4200n -0.000579 66.4300n -0.000762 66.4400n -0.000937
+ 66.4500n -0.001103 66.4600n -0.001254 66.4700n -0.001390 66.4800n -0.001508 66.4900n -0.001605 66.5000n -0.001681 66.5100n -0.001735 66.5200n -0.001765 66.5300n -0.001772 66.5400n -0.001755 66.5500n -0.001716 66.5600n -0.001656 66.5700n -0.001575 66.5800n -0.001476 66.5900n -0.001361
+ 66.6000n -0.001232 66.6100n -0.001091 66.6200n -0.000941 66.6300n -0.000785 66.6400n -0.000626 66.6500n -0.000465 66.6600n -0.000307 66.6700n -0.000153 66.6800n -0.000005 66.6900n 0.000133 66.7000n 0.000260 66.7100n 0.000375 66.7200n 0.000474 66.7300n 0.000559 66.7400n 0.000626
+ 66.7500n 0.000677 66.7600n 0.000710 66.7700n 0.000724 66.7800n 0.000721 66.7900n 0.000701 66.8000n 0.000663 66.8100n 0.000610 66.8200n 0.000541 66.8300n 0.000458 66.8400n 0.000363 66.8500n 0.000255 66.8600n 0.000138 66.8700n 0.000011 66.8800n -0.000123 66.8900n -0.000262
+ 66.9000n -0.000407 66.9100n -0.000554 66.9200n -0.000702 66.9300n -0.000850 66.9400n -0.000997 66.9500n -0.001142 66.9600n -0.001282 66.9700n -0.001417 66.9800n -0.001545 66.9900n -0.001666 67.0000n -0.001777 67.0100n -0.001879 67.0200n -0.001969 67.0300n -0.002047 67.0400n -0.002112
+ 67.0500n -0.002162 67.0600n -0.002197 67.0700n -0.002216 67.0800n -0.002218 67.0900n -0.002203 67.1000n -0.002170 67.1100n -0.002118 67.1200n -0.002047 67.1300n -0.001957 67.1400n -0.001849 67.1500n -0.001721 67.1600n -0.001576 67.1700n -0.001412 67.1800n -0.001233 67.1900n -0.001038
+ 67.2000n -0.000829 67.2100n -0.000608 67.2200n -0.000376 67.2300n -0.000137 67.2400n 0.000108 67.2500n 0.000356 67.2600n 0.000604 67.2700n 0.000849 67.2800n 0.001088 67.2900n 0.001318 67.3000n 0.001535 67.3100n 0.001737 67.3200n 0.001921 67.3300n 0.002084 67.3400n 0.002222
+ 67.3500n 0.002334 67.3600n 0.002418 67.3700n 0.002471 67.3800n 0.002493 67.3900n 0.002482 67.4000n 0.002438 67.4100n 0.002360 67.4200n 0.002250 67.4300n 0.002108 67.4400n 0.001937 67.4500n 0.001737 67.4600n 0.001512 67.4700n 0.001264 67.4800n 0.000997 67.4900n 0.000715
+ 67.5000n 0.000422 67.5100n 0.000122 67.5200n -0.000181 67.5300n -0.000481 67.5400n -0.000775 67.5500n -0.001057 67.5600n -0.001323 67.5700n -0.001569 67.5800n -0.001791 67.5900n -0.001985 67.6000n -0.002149 67.6100n -0.002279 67.6200n -0.002374 67.6300n -0.002432 67.6400n -0.002453
+ 67.6500n -0.002435 67.6600n -0.002380 67.6700n -0.002289 67.6800n -0.002163 67.6900n -0.002004 67.7000n -0.001817 67.7100n -0.001603 67.7200n -0.001368 67.7300n -0.001115 67.7400n -0.000850 67.7500n -0.000576 67.7600n -0.000299 67.7700n -0.000024 67.7800n 0.000244 67.7900n 0.000499
+ 67.8000n 0.000738 67.8100n 0.000956 67.8200n 0.001149 67.8300n 0.001314 67.8400n 0.001447 67.8500n 0.001545 67.8600n 0.001608 67.8700n 0.001634 67.8800n 0.001623 67.8900n 0.001575 67.9000n 0.001490 67.9100n 0.001370 67.9200n 0.001219 67.9300n 0.001037 67.9400n 0.000829
+ 67.9500n 0.000599 67.9600n 0.000350 67.9700n 0.000087 67.9800n -0.000184 67.9900n -0.000460 68.0000n -0.000735 68.0100n -0.001005 68.0200n -0.001264 68.0300n -0.001508 68.0400n -0.001733 68.0500n -0.001934 68.0600n -0.002109 68.0700n -0.002255 68.0800n -0.002368 68.0900n -0.002447
+ 68.1000n -0.002491 68.1100n -0.002499 68.1200n -0.002471 68.1300n -0.002408 68.1400n -0.002311 68.1500n -0.002181 68.1600n -0.002022 68.1700n -0.001836 68.1800n -0.001625 68.1900n -0.001395 68.2000n -0.001148 68.2100n -0.000888 68.2200n -0.000620 68.2300n -0.000348 68.2400n -0.000076
+ 68.2500n 0.000192 68.2600n 0.000452 68.2700n 0.000700 68.2800n 0.000933 68.2900n 0.001148 68.3000n 0.001342 68.3100n 0.001513 68.3200n 0.001659 68.3300n 0.001780 68.3400n 0.001874 68.3500n 0.001940 68.3600n 0.001980 68.3700n 0.001994 68.3800n 0.001983 68.3900n 0.001948
+ 68.4000n 0.001891 68.4100n 0.001815 68.4200n 0.001722 68.4300n 0.001614 68.4400n 0.001494 68.4500n 0.001365 68.4600n 0.001229 68.4700n 0.001091 68.4800n 0.000951 68.4900n 0.000813 68.5000n 0.000680 68.5100n 0.000552 68.5200n 0.000433 68.5300n 0.000324 68.5400n 0.000227
+ 68.5500n 0.000141 68.5600n 0.000069 68.5700n 0.000010 68.5800n -0.000035 68.5900n -0.000067 68.6000n -0.000087 68.6100n -0.000094 68.6200n -0.000090 68.6300n -0.000076 68.6400n -0.000053 68.6500n -0.000023 68.6600n 0.000012 68.6700n 0.000052 68.6800n 0.000095 68.6900n 0.000139
+ 68.7000n 0.000183 68.7100n 0.000226 68.7200n 0.000266 68.7300n 0.000303 68.7400n 0.000335 68.7500n 0.000363 68.7600n 0.000385 68.7700n 0.000402 68.7800n 0.000413 68.7900n 0.000419 68.8000n 0.000420 68.8100n 0.000417 68.8200n 0.000410 68.8300n 0.000401 68.8400n 0.000390
+ 68.8500n 0.000377 68.8600n 0.000366 68.8700n 0.000355 68.8800n 0.000348 68.8900n 0.000344 68.9000n 0.000344 68.9100n 0.000350 68.9200n 0.000361 68.9300n 0.000380 68.9400n 0.000406 68.9500n 0.000439 68.9600n 0.000479 68.9700n 0.000527 68.9800n 0.000582 68.9900n 0.000643
+ 69.0000n 0.000710 69.0100n 0.000782 69.0200n 0.000858 69.0300n 0.000937 69.0400n 0.001016 69.0500n 0.001096 69.0600n 0.001174 69.0700n 0.001249 69.0800n 0.001319 69.0900n 0.001383 69.1000n 0.001439 69.1100n 0.001487 69.1200n 0.001524 69.1300n 0.001551 69.1400n 0.001565
+ 69.1500n 0.001566 69.1600n 0.001553 69.1700n 0.001527 69.1800n 0.001487 69.1900n 0.001433 69.2000n 0.001366 69.2100n 0.001286 69.2200n 0.001194 69.2300n 0.001092 69.2400n 0.000981 69.2500n 0.000862 69.2600n 0.000737 69.2700n 0.000608 69.2800n 0.000476 69.2900n 0.000345
+ 69.3000n 0.000216 69.3100n 0.000091 69.3200n -0.000028 69.3300n -0.000138 69.3400n -0.000238 69.3500n -0.000325 69.3600n -0.000399 69.3700n -0.000457 69.3800n -0.000498 69.3900n -0.000521 69.4000n -0.000526 69.4100n -0.000511 69.4200n -0.000477 69.4300n -0.000423 69.4400n -0.000351
+ 69.4500n -0.000261 69.4600n -0.000153 69.4700n -0.000030 69.4800n 0.000108 69.4900n 0.000258 69.5000n 0.000418 69.5100n 0.000587 69.5200n 0.000761 69.5300n 0.000938 69.5400n 0.001115 69.5500n 0.001290 69.5600n 0.001460 69.5700n 0.001622 69.5800n 0.001774 69.5900n 0.001913
+ 69.6000n 0.002036 69.6100n 0.002142 69.6200n 0.002229 69.6300n 0.002294 69.6400n 0.002337 69.6500n 0.002357 69.6600n 0.002352 69.6700n 0.002323 69.6800n 0.002269 69.6900n 0.002191 69.7000n 0.002089 69.7100n 0.001965 69.7200n 0.001819 69.7300n 0.001654 69.7400n 0.001470
+ 69.7500n 0.001271 69.7600n 0.001059 69.7700n 0.000836 69.7800n 0.000605 69.7900n 0.000368 69.8000n 0.000128 69.8100n -0.000111 69.8200n -0.000347 69.8300n -0.000578 69.8400n -0.000801 69.8500n -0.001014 69.8600n -0.001215 69.8700n -0.001401 69.8800n -0.001571 69.8900n -0.001724
+ 69.9000n -0.001859 69.9100n -0.001975 69.9200n -0.002072 69.9300n -0.002149 69.9400n -0.002207 69.9500n -0.002246 69.9600n -0.002268 69.9700n -0.002272 69.9800n -0.002261 69.9900n -0.002236 70.0000n -0.002199 70.0100n -0.002150 70.0200n -0.002093 70.0300n -0.002028 70.0400n -0.001959
+ 70.0500n -0.001885 70.0600n -0.001810 70.0700n -0.001735 70.0800n -0.001662 70.0900n -0.001591 70.1000n -0.001524 70.1100n -0.001461 70.1200n -0.001404 70.1300n -0.001353 70.1400n -0.001308 70.1500n -0.001269 70.1600n -0.001237 70.1700n -0.001209 70.1800n -0.001187 70.1900n -0.001168
+ 70.2000n -0.001153 70.2100n -0.001140 70.2200n -0.001128 70.2300n -0.001117 70.2400n -0.001104 70.2500n -0.001089 70.2600n -0.001071 70.2700n -0.001048 70.2800n -0.001021 70.2900n -0.000988 70.3000n -0.000949 70.3100n -0.000903 70.3200n -0.000850 70.3300n -0.000791 70.3400n -0.000725
+ 70.3500n -0.000654 70.3600n -0.000577 70.3700n -0.000496 70.3800n -0.000411 70.3900n -0.000324 70.4000n -0.000235 70.4100n -0.000147 70.4200n -0.000060 70.4300n 0.000025 70.4400n 0.000105 70.4500n 0.000181 70.4600n 0.000250 70.4700n 0.000311 70.4800n 0.000365 70.4900n 0.000410
+ 70.5000n 0.000445 70.5100n 0.000471 70.5200n 0.000487 70.5300n 0.000493 70.5400n 0.000491 70.5500n 0.000479 70.5600n 0.000460 70.5700n 0.000435 70.5800n 0.000403 70.5900n 0.000367 70.6000n 0.000329 70.6100n 0.000289 70.6200n 0.000249 70.6300n 0.000210 70.6400n 0.000174
+ 70.6500n 0.000143 70.6600n 0.000117 70.6700n 0.000098 70.6800n 0.000086 70.6900n 0.000082 70.7000n 0.000087 70.7100n 0.000101 70.7200n 0.000124 70.7300n 0.000155 70.7400n 0.000194 70.7500n 0.000240 70.7600n 0.000293 70.7700n 0.000349 70.7800n 0.000410 70.7900n 0.000472
+ 70.8000n 0.000533 70.8100n 0.000593 70.8200n 0.000649 70.8300n 0.000700 70.8400n 0.000743 70.8500n 0.000777 70.8600n 0.000800 70.8700n 0.000812 70.8800n 0.000810 70.8900n 0.000794 70.9000n 0.000765 70.9100n 0.000720 70.9200n 0.000661 70.9300n 0.000587 70.9400n 0.000500
+ 70.9500n 0.000401 70.9600n 0.000290 70.9700n 0.000170 70.9800n 0.000043 70.9900n -0.000090 71.0000n -0.000226 71.0100n -0.000363 71.0200n -0.000498 71.0300n -0.000629 71.0400n -0.000752 71.0500n -0.000867 71.0600n -0.000970 71.0700n -0.001060 71.0800n -0.001134 71.0900n -0.001192
+ 71.1000n -0.001231 71.1100n -0.001252 71.1200n -0.001253 71.1300n -0.001235 71.1400n -0.001197 71.1500n -0.001141 71.1600n -0.001067 71.1700n -0.000978 71.1800n -0.000874 71.1900n -0.000758 71.2000n -0.000632 71.2100n -0.000498 71.2200n -0.000360 71.2300n -0.000220 71.2400n -0.000081
+ 71.2500n 0.000055 71.2600n 0.000184 71.2700n 0.000305 71.2800n 0.000415 71.2900n 0.000511 71.3000n 0.000593 71.3100n 0.000659 71.3200n 0.000707 71.3300n 0.000738 71.3400n 0.000751 71.3500n 0.000746 71.3600n 0.000724 71.3700n 0.000686 71.3800n 0.000634 71.3900n 0.000569
+ 71.4000n 0.000494 71.4100n 0.000411 71.4200n 0.000321 71.4300n 0.000229 71.4400n 0.000137 71.4500n 0.000048 71.4600n -0.000036 71.4700n -0.000113 71.4800n -0.000178 71.4900n -0.000231 71.5000n -0.000270 71.5100n -0.000292 71.5200n -0.000298 71.5300n -0.000285 71.5400n -0.000255
+ 71.5500n -0.000206 71.5600n -0.000141 71.5700n -0.000059 71.5800n 0.000037 71.5900n 0.000146 71.6000n 0.000265 71.6100n 0.000392 71.6200n 0.000524 71.6300n 0.000657 71.6400n 0.000788 71.6500n 0.000914 71.6600n 0.001032 71.6700n 0.001139 71.6800n 0.001230 71.6900n 0.001304
+ 71.7000n 0.001359 71.7100n 0.001390 71.7200n 0.001398 71.7300n 0.001380 71.7400n 0.001336 71.7500n 0.001265 71.7600n 0.001167 71.7700n 0.001043 71.7800n 0.000895 71.7900n 0.000723 71.8000n 0.000530 71.8100n 0.000319 71.8200n 0.000092 71.8300n -0.000147 71.8400n -0.000395
+ 71.8500n -0.000647 71.8600n -0.000901 71.8700n -0.001152 71.8800n -0.001397 71.8900n -0.001631 71.9000n -0.001851 71.9100n -0.002054 71.9200n -0.002237 71.9300n -0.002397 71.9400n -0.002532 71.9500n -0.002641 71.9600n -0.002721 71.9700n -0.002773 71.9800n -0.002795 71.9900n -0.002789
+ 72.0000n -0.002755 72.0100n -0.002695 72.0200n -0.002610 72.0300n -0.002502 72.0400n -0.002373 72.0500n -0.002228 72.0600n -0.002067 72.0700n -0.001896 72.0800n -0.001717 72.0900n -0.001532 72.1000n -0.001347 72.1100n -0.001163 72.1200n -0.000985 72.1300n -0.000814 72.1400n -0.000653
+ 72.1500n -0.000504 72.1600n -0.000370 72.1700n -0.000252 72.1800n -0.000151 72.1900n -0.000067 72.2000n -0.000001 72.2100n 0.000047 72.2200n 0.000078 72.2300n 0.000092 72.2400n 0.000091 72.2500n 0.000076 72.2600n 0.000048 72.2700n 0.000010 72.2800n -0.000037 72.2900n -0.000090
+ 72.3000n -0.000149 72.3100n -0.000210 72.3200n -0.000272 72.3300n -0.000334 72.3400n -0.000393 72.3500n -0.000449 72.3600n -0.000499 72.3700n -0.000545 72.3800n -0.000584 72.3900n -0.000617 72.4000n -0.000644 72.4100n -0.000665 72.4200n -0.000680 72.4300n -0.000690 72.4400n -0.000697
+ 72.4500n -0.000700 72.4600n -0.000702 72.4700n -0.000704 72.4800n -0.000707 72.4900n -0.000712 72.5000n -0.000720 72.5100n -0.000733 72.5200n -0.000752 72.5300n -0.000776 72.5400n -0.000807 72.5500n -0.000846 72.5600n -0.000891 72.5700n -0.000943 72.5800n -0.001002 72.5900n -0.001066
+ 72.6000n -0.001134 72.6100n -0.001206 72.6200n -0.001279 72.6300n -0.001353 72.6400n -0.001425 72.6500n -0.001493 72.6600n -0.001556 72.6700n -0.001611 72.6800n -0.001656 72.6900n -0.001691 72.7000n -0.001713 72.7100n -0.001720 72.7200n -0.001712 72.7300n -0.001688 72.7400n -0.001646
+ 72.7500n -0.001587 72.7600n -0.001511 72.7700n -0.001417 72.7800n -0.001307 72.7900n -0.001181 72.8000n -0.001042 72.8100n -0.000890 72.8200n -0.000728 72.8300n -0.000557 72.8400n -0.000381 72.8500n -0.000202 72.8600n -0.000021 72.8700n 0.000157 72.8800n 0.000331 72.8900n 0.000497
+ 72.9000n 0.000654 72.9100n 0.000799 72.9200n 0.000931 72.9300n 0.001046 72.9400n 0.001145 72.9500n 0.001224 72.9600n 0.001285 72.9700n 0.001326 72.9800n 0.001348 72.9900n 0.001350 73.0000n 0.001333 73.0100n 0.001298 73.0200n 0.001247 73.0300n 0.001181 73.0400n 0.001102
+ 73.0500n 0.001012 73.0600n 0.000913 73.0700n 0.000807 73.0800n 0.000697 73.0900n 0.000585 73.1000n 0.000473 73.1100n 0.000363 73.1200n 0.000257 73.1300n 0.000157 73.1400n 0.000065 73.1500n -0.000019 73.1600n -0.000093 73.1700n -0.000157 73.1800n -0.000211 73.1900n -0.000254
+ 73.2000n -0.000286 73.2100n -0.000309 73.2200n -0.000324 73.2300n -0.000330 73.2400n -0.000331 73.2500n -0.000326 73.2600n -0.000318 73.2700n -0.000309 73.2800n -0.000300 73.2900n -0.000293 73.3000n -0.000289 73.3100n -0.000289 73.3200n -0.000296 73.3300n -0.000310 73.3400n -0.000333
+ 73.3500n -0.000364 73.3600n -0.000403 73.3700n -0.000452 73.3800n -0.000510 73.3900n -0.000575 73.4000n -0.000647 73.4100n -0.000726 73.4200n -0.000809 73.4300n -0.000894 73.4400n -0.000981 73.4500n -0.001067 73.4600n -0.001149 73.4700n -0.001227 73.4800n -0.001297 73.4900n -0.001358
+ 73.5000n -0.001407 73.5100n -0.001444 73.5200n -0.001465 73.5300n -0.001471 73.5400n -0.001460 73.5500n -0.001432 73.5600n -0.001385 73.5700n -0.001320 73.5800n -0.001237 73.5900n -0.001137 73.6000n -0.001021 73.6100n -0.000890 73.6200n -0.000746 73.6300n -0.000591 73.6400n -0.000427
+ 73.6500n -0.000256 73.6600n -0.000081 73.6700n 0.000096 73.6800n 0.000271 73.6900n 0.000443 73.7000n 0.000609 73.7100n 0.000767 73.7200n 0.000914 73.7300n 0.001048 73.7400n 0.001167 73.7500n 0.001270 73.7600n 0.001357 73.7700n 0.001425 73.7800n 0.001475 73.7900n 0.001506
+ 73.8000n 0.001519 73.8100n 0.001515 73.8200n 0.001495 73.8300n 0.001459 73.8400n 0.001409 73.8500n 0.001348 73.8600n 0.001277 73.8700n 0.001199 73.8800n 0.001116 73.8900n 0.001029 73.9000n 0.000942 73.9100n 0.000857 73.9200n 0.000777 73.9300n 0.000702 73.9400n 0.000635
+ 73.9500n 0.000578 73.9600n 0.000533 73.9700n 0.000499 73.9800n 0.000479 73.9900n 0.000472 74.0000n 0.000479 74.0100n 0.000500 74.0200n 0.000534 74.0300n 0.000580 74.0400n 0.000637 74.0500n 0.000705 74.0600n 0.000781 74.0700n 0.000864 74.0800n 0.000952 74.0900n 0.001043
+ 74.1000n 0.001134 74.1100n 0.001225 74.1200n 0.001313 74.1300n 0.001396 74.1400n 0.001472 74.1500n 0.001540 74.1600n 0.001598 74.1700n 0.001644 74.1800n 0.001679 74.1900n 0.001701 74.2000n 0.001709 74.2100n 0.001703 74.2200n 0.001684 74.2300n 0.001651 74.2400n 0.001606
+ 74.2500n 0.001548 74.2600n 0.001480 74.2700n 0.001401 74.2800n 0.001314 74.2900n 0.001220 74.3000n 0.001120 74.3100n 0.001017 74.3200n 0.000912 74.3300n 0.000806 74.3400n 0.000702 74.3500n 0.000600 74.3600n 0.000503 74.3700n 0.000411 74.3800n 0.000327 74.3900n 0.000251
+ 74.4000n 0.000184 74.4100n 0.000128 74.4200n 0.000082 74.4300n 0.000047 74.4400n 0.000023 74.4500n 0.000011 74.4600n 0.000010 74.4700n 0.000021 74.4800n 0.000042 74.4900n 0.000074 74.5000n 0.000115 74.5100n 0.000165 74.5200n 0.000224 74.5300n 0.000289 74.5400n 0.000362
+ 74.5500n 0.000439 74.5600n 0.000522 74.5700n 0.000608 74.5800n 0.000696 74.5900n 0.000786 74.6000n 0.000877 74.6100n 0.000968 74.6200n 0.001058 74.6300n 0.001146 74.6400n 0.001231 74.6500n 0.001313 74.6600n 0.001390 74.6700n 0.001462 74.6800n 0.001529 74.6900n 0.001589
+ 74.7000n 0.001643 74.7100n 0.001689 74.7200n 0.001726 74.7300n 0.001755 74.7400n 0.001775 74.7500n 0.001786 74.7600n 0.001786 74.7700n 0.001777 74.7800n 0.001757 74.7900n 0.001726 74.8000n 0.001685 74.8100n 0.001634 74.8200n 0.001572 74.8300n 0.001501 74.8400n 0.001420
+ 74.8500n 0.001330 74.8600n 0.001233 74.8700n 0.001128 74.8800n 0.001018 74.8900n 0.000903 74.9000n 0.000784 74.9100n 0.000664 74.9200n 0.000543 74.9300n 0.000423 74.9400n 0.000306 74.9500n 0.000195 74.9600n 0.000089 74.9700n -0.000008 74.9800n -0.000095 74.9900n -0.000171
+ 75.0000n -0.000233 75.0100n -0.000281 75.0200n -0.000314 75.0300n -0.000330 75.0400n -0.000329 75.0500n -0.000311 75.0600n -0.000275 75.0700n -0.000221 75.0800n -0.000151 75.0900n -0.000065 75.1000n 0.000037 75.1100n 0.000151 75.1200n 0.000278 75.1300n 0.000414 75.1400n 0.000558
+ 75.1500n 0.000707 75.1600n 0.000858 75.1700n 0.001009 75.1800n 0.001156 75.1900n 0.001298 75.2000n 0.001430 75.2100n 0.001551 75.2200n 0.001657 75.2300n 0.001747 75.2400n 0.001818 75.2500n 0.001868 75.2600n 0.001896 75.2700n 0.001900 75.2800n 0.001879 75.2900n 0.001834
+ 75.3000n 0.001764 75.3100n 0.001670 75.3200n 0.001552 75.3300n 0.001413 75.3400n 0.001254 75.3500n 0.001076 75.3600n 0.000883 75.3700n 0.000677 75.3800n 0.000462 75.3900n 0.000241 75.4000n 0.000017 75.4100n -0.000207 75.4200n -0.000426 75.4300n -0.000637 75.4400n -0.000838
+ 75.4500n -0.001024 75.4600n -0.001192 75.4700n -0.001341 75.4800n -0.001467 75.4900n -0.001569 75.5000n -0.001646 75.5100n -0.001695 75.5200n -0.001717 75.5300n -0.001712 75.5400n -0.001679 75.5500n -0.001619 75.5600n -0.001535 75.5700n -0.001427 75.5800n -0.001297 75.5900n -0.001148
+ 75.6000n -0.000982 75.6100n -0.000802 75.6200n -0.000612 75.6300n -0.000414 75.6400n -0.000211 75.6500n -0.000007 75.6600n 0.000195 75.6700n 0.000393 75.6800n 0.000584 75.6900n 0.000766 75.7000n 0.000936 75.7100n 0.001093 75.7200n 0.001234 75.7300n 0.001361 75.7400n 0.001470
+ 75.7500n 0.001563 75.7600n 0.001640 75.7700n 0.001700 75.7800n 0.001745 75.7900n 0.001776 75.8000n 0.001794 75.8100n 0.001801 75.8200n 0.001798 75.8300n 0.001787 75.8400n 0.001771 75.8500n 0.001751 75.8600n 0.001728 75.8700n 0.001705 75.8800n 0.001683 75.8900n 0.001664
+ 75.9000n 0.001647 75.9100n 0.001635 75.9200n 0.001627 75.9300n 0.001624 75.9400n 0.001626 75.9500n 0.001631 75.9600n 0.001639 75.9700n 0.001650 75.9800n 0.001661 75.9900n 0.001670 76.0000n 0.001677 76.0100n 0.001679 76.0200n 0.001674 76.0300n 0.001660 76.0400n 0.001635
+ 76.0500n 0.001597 76.0600n 0.001544 76.0700n 0.001475 76.0800n 0.001389 76.0900n 0.001284 76.1000n 0.001160 76.1100n 0.001017 76.1200n 0.000854 76.1300n 0.000673 76.1400n 0.000475 76.1500n 0.000260 76.1600n 0.000032 76.1700n -0.000209 76.1800n -0.000459 76.1900n -0.000715
+ 76.2000n -0.000974 76.2100n -0.001233 76.2200n -0.001487 76.2300n -0.001735 76.2400n -0.001970 76.2500n -0.002192 76.2600n -0.002394 76.2700n -0.002575 76.2800n -0.002732 76.2900n -0.002861 76.3000n -0.002961 76.3100n -0.003030 76.3200n -0.003066 76.3300n -0.003069 76.3400n -0.003038
+ 76.3500n -0.002974 76.3600n -0.002878 76.3700n -0.002750 76.3800n -0.002594 76.3900n -0.002410 76.4000n -0.002203 76.4100n -0.001975 76.4200n -0.001730 76.4300n -0.001472 76.4400n -0.001205 76.4500n -0.000932 76.4600n -0.000659 76.4700n -0.000390 76.4800n -0.000128 76.4900n 0.000122
+ 76.5000n 0.000356 76.5100n 0.000572 76.5200n 0.000766 76.5300n 0.000935 76.5400n 0.001078 76.5500n 0.001192 76.5600n 0.001277 76.5700n 0.001332 76.5800n 0.001356 76.5900n 0.001351 76.6000n 0.001316 76.6100n 0.001254 76.6200n 0.001167 76.6300n 0.001055 76.6400n 0.000923
+ 76.6500n 0.000773 76.6600n 0.000608 76.6700n 0.000432 76.6800n 0.000247 76.6900n 0.000058 76.7000n -0.000133 76.7100n -0.000322 76.7200n -0.000506 76.7300n -0.000681 76.7400n -0.000845 76.7500n -0.000996 76.7600n -0.001132 76.7700n -0.001250 76.7800n -0.001350 76.7900n -0.001429
+ 76.8000n -0.001489 76.8100n -0.001528 76.8200n -0.001546 76.8300n -0.001545 76.8400n -0.001524 76.8500n -0.001485 76.8600n -0.001429 76.8700n -0.001358 76.8800n -0.001274 76.8900n -0.001178 76.9000n -0.001073 76.9100n -0.000960 76.9200n -0.000841 76.9300n -0.000720 76.9400n -0.000596
+ 76.9500n -0.000473 76.9600n -0.000353 76.9700n -0.000235 76.9800n -0.000123 76.9900n -0.000017 77.0000n 0.000082 77.0100n 0.000173 77.0200n 0.000256 77.0300n 0.000330 77.0400n 0.000394 77.0500n 0.000449 77.0600n 0.000496 77.0700n 0.000533 77.0800n 0.000562 77.0900n 0.000583
+ 77.1000n 0.000597 77.1100n 0.000603 77.1200n 0.000604 77.1300n 0.000598 77.1400n 0.000588 77.1500n 0.000573 77.1600n 0.000554 77.1700n 0.000532 77.1800n 0.000506 77.1900n 0.000478 77.2000n 0.000448 77.2100n 0.000416 77.2200n 0.000381 77.2300n 0.000346 77.2400n 0.000308
+ 77.2500n 0.000270 77.2600n 0.000230 77.2700n 0.000189 77.2800n 0.000146 77.2900n 0.000103 77.3000n 0.000060 77.3100n 0.000015 77.3200n -0.000030 77.3300n -0.000074 77.3400n -0.000119 77.3500n -0.000163 77.3600n -0.000205 77.3700n -0.000246 77.3800n -0.000286 77.3900n -0.000322
+ 77.4000n -0.000356 77.4100n -0.000385 77.4200n -0.000411 77.4300n -0.000432 77.4400n -0.000449 77.4500n -0.000459 77.4600n -0.000465 77.4700n -0.000464 77.4800n -0.000458 77.4900n -0.000446 77.5000n -0.000429 77.5100n -0.000406 77.5200n -0.000379 77.5300n -0.000347 77.5400n -0.000311
+ 77.5500n -0.000273 77.5600n -0.000233 77.5700n -0.000191 77.5800n -0.000150 77.5900n -0.000109 77.6000n -0.000071 77.6100n -0.000036 77.6200n -0.000005 77.6300n 0.000021 77.6400n 0.000040 77.6500n 0.000053 77.6600n 0.000057 77.6700n 0.000054 77.6800n 0.000041 77.6900n 0.000020
+ 77.7000n -0.000011 77.7100n -0.000051 77.7200n -0.000100 77.7300n -0.000158 77.7400n -0.000224 77.7500n -0.000298 77.7600n -0.000378 77.7700n -0.000463 77.7800n -0.000553 77.7900n -0.000647 77.8000n -0.000742 77.8100n -0.000839 77.8200n -0.000936 77.8300n -0.001030 77.8400n -0.001123
+ 77.8500n -0.001211 77.8600n -0.001294 77.8700n -0.001372 77.8800n -0.001443 77.8900n -0.001507 77.9000n -0.001563 77.9100n -0.001611 77.9200n -0.001651 77.9300n -0.001682 77.9400n -0.001706 77.9500n -0.001721 77.9600n -0.001729 77.9700n -0.001730 77.9800n -0.001724 77.9900n -0.001713
+ 78.0000n -0.001697 78.0100n -0.001676 78.0200n -0.001653 78.0300n -0.001626 78.0400n -0.001598 78.0500n -0.001569 78.0600n -0.001538 78.0700n -0.001508 78.0800n -0.001478 78.0900n -0.001449 78.1000n -0.001420 78.1100n -0.001392 78.1200n -0.001365 78.1300n -0.001339 78.1400n -0.001312
+ 78.1500n -0.001286 78.1600n -0.001259 78.1700n -0.001230 78.1800n -0.001201 78.1900n -0.001168 78.2000n -0.001134 78.2100n -0.001095 78.2200n -0.001053 78.2300n -0.001007 78.2400n -0.000956 78.2500n -0.000900 78.2600n -0.000840 78.2700n -0.000774 78.2800n -0.000704 78.2900n -0.000629
+ 78.3000n -0.000551 78.3100n -0.000469 78.3200n -0.000384 78.3300n -0.000298 78.3400n -0.000210 78.3500n -0.000123 78.3600n -0.000037 78.3700n 0.000047 78.3800n 0.000128 78.3900n 0.000204 78.4000n 0.000275 78.4100n 0.000340 78.4200n 0.000397 78.4300n 0.000447 78.4400n 0.000488
+ 78.4500n 0.000520 78.4600n 0.000544 78.4700n 0.000558 78.4800n 0.000563 78.4900n 0.000559 78.5000n 0.000547 78.5100n 0.000528 78.5200n 0.000501 78.5300n 0.000469 78.5400n 0.000432 78.5500n 0.000391 78.5600n 0.000347 78.5700n 0.000302 78.5800n 0.000257 78.5900n 0.000213
+ 78.6000n 0.000171 78.6100n 0.000132 78.6200n 0.000097 78.6300n 0.000066 78.6400n 0.000041 78.6500n 0.000021 78.6600n 0.000006 78.6700n -0.000002 78.6800n -0.000006 78.6900n -0.000004 78.7000n 0.000002 78.7100n 0.000012 78.7200n 0.000024 78.7300n 0.000037 78.7400n 0.000051
+ 78.7500n 0.000064 78.7600n 0.000075 78.7700n 0.000082 78.7800n 0.000085 78.7900n 0.000083 78.8000n 0.000074 78.8100n 0.000057 78.8200n 0.000033 78.8300n -0.000000 78.8400n -0.000041 78.8500n -0.000091 78.8600n -0.000149 78.8700n -0.000214 78.8800n -0.000286 78.8900n -0.000363
+ 78.9000n -0.000444 78.9100n -0.000528 78.9200n -0.000612 78.9300n -0.000696 78.9400n -0.000776 78.9500n -0.000851 78.9600n -0.000920 78.9700n -0.000979 78.9800n -0.001028 78.9900n -0.001065 79.0000n -0.001088 79.0100n -0.001095 79.0200n -0.001087 79.0300n -0.001062 79.0400n -0.001021
+ 79.0500n -0.000963 79.0600n -0.000889 79.0700n -0.000800 79.0800n -0.000696 79.0900n -0.000581 79.1000n -0.000455 79.1100n -0.000322 79.1200n -0.000183 79.1300n -0.000041 79.1400n 0.000100 79.1500n 0.000237 79.1600n 0.000368 79.1700n 0.000490 79.1800n 0.000599 79.1900n 0.000692
+ 79.2000n 0.000768 79.2100n 0.000823 79.2200n 0.000856 79.2300n 0.000866 79.2400n 0.000851 79.2500n 0.000810 79.2600n 0.000745 79.2700n 0.000654 79.2800n 0.000540 79.2900n 0.000403 79.3000n 0.000247 79.3100n 0.000073 79.3200n -0.000116 79.3300n -0.000316 79.3400n -0.000523
+ 79.3500n -0.000734 79.3600n -0.000944 79.3700n -0.001149 79.3800n -0.001344 79.3900n -0.001526 79.4000n -0.001691 79.4100n -0.001834 79.4200n -0.001951 79.4300n -0.002041 79.4400n -0.002099 79.4500n -0.002124 79.4600n -0.002115 79.4700n -0.002070 79.4800n -0.001989 79.4900n -0.001872
+ 79.5000n -0.001720 79.5100n -0.001535 79.5200n -0.001319 79.5300n -0.001075 79.5400n -0.000806 79.5500n -0.000516 79.5600n -0.000209 79.5700n 0.000110 79.5800n 0.000436 79.5900n 0.000765 79.6000n 0.001091 79.6100n 0.001409 79.6200n 0.001715 79.6300n 0.002004 79.6400n 0.002272
+ 79.6500n 0.002514 79.6600n 0.002727 79.6700n 0.002908 79.6800n 0.003054 79.6900n 0.003165 79.7000n 0.003238 79.7100n 0.003273 79.7200n 0.003270 79.7300n 0.003231 79.7400n 0.003155 79.7500n 0.003047 79.7600n 0.002907 79.7700n 0.002739 79.7800n 0.002547 79.7900n 0.002334
+ 79.8000n 0.002104 79.8100n 0.001862 79.8200n 0.001612 79.8300n 0.001357 79.8400n 0.001103 79.8500n 0.000853 79.8600n 0.000611 79.8700n 0.000381 79.8800n 0.000166 79.8900n -0.000031 79.9000n -0.000209 79.9100n -0.000365 79.9200n -0.000499 79.9300n -0.000608 79.9400n -0.000694
+ 79.9500n -0.000757 79.9600n -0.000797 79.9700n -0.000816 79.9800n -0.000815 79.9900n -0.000796 80.0000n -0.000761 80.0100n -0.000714 80.0200n -0.000656 80.0300n -0.000591 80.0400n -0.000521 80.0500n -0.000448 80.0600n -0.000377 80.0700n -0.000308 80.0800n -0.000244 80.0900n -0.000187
+ 80.1000n -0.000139 80.1100n -0.000100 80.1200n -0.000073 80.1300n -0.000056 80.1400n -0.000051 80.1500n -0.000057 80.1600n -0.000074 80.1700n -0.000100 80.1800n -0.000135 80.1900n -0.000176 80.2000n -0.000223 80.2100n -0.000272 80.2200n -0.000323 80.2300n -0.000374 80.2400n -0.000421
+ 80.2500n -0.000464 80.2600n -0.000501 80.2700n -0.000529 80.2800n -0.000548 80.2900n -0.000557 80.3000n -0.000553 80.3100n -0.000538 80.3200n -0.000509 80.3300n -0.000469 80.3400n -0.000416 80.3500n -0.000352 80.3600n -0.000278 80.3700n -0.000194 80.3800n -0.000104 80.3900n -0.000007
+ 80.4000n 0.000093 80.4100n 0.000196 80.4200n 0.000297 80.4300n 0.000397 80.4400n 0.000491 80.4500n 0.000579 80.4600n 0.000658 80.4700n 0.000727 80.4800n 0.000784 80.4900n 0.000827 80.5000n 0.000856 80.5100n 0.000870 80.5200n 0.000868 80.5300n 0.000850 80.5400n 0.000816
+ 80.5500n 0.000767 80.5600n 0.000703 80.5700n 0.000626 80.5800n 0.000535 80.5900n 0.000434 80.6000n 0.000323 80.6100n 0.000204 80.6200n 0.000078 80.6300n -0.000052 80.6400n -0.000184 80.6500n -0.000318 80.6600n -0.000452 80.6700n -0.000583 80.6800n -0.000710 80.6900n -0.000833
+ 80.7000n -0.000951 80.7100n -0.001061 80.7200n -0.001165 80.7300n -0.001261 80.7400n -0.001350 80.7500n -0.001431 80.7600n -0.001505 80.7700n -0.001571 80.7800n -0.001632 80.7900n -0.001686 80.8000n -0.001735 80.8100n -0.001780 80.8200n -0.001822 80.8300n -0.001860 80.8400n -0.001896
+ 80.8500n -0.001931 80.8600n -0.001964 80.8700n -0.001996 80.8800n -0.002028 80.8900n -0.002059 80.9000n -0.002089 80.9100n -0.002117 80.9200n -0.002144 80.9300n -0.002169 80.9400n -0.002190 80.9500n -0.002206 80.9600n -0.002218 80.9700n -0.002223 80.9800n -0.002220 80.9900n -0.002209
+ 81.0000n -0.002188 81.0100n -0.002157 81.0200n -0.002114 81.0300n -0.002059 81.0400n -0.001991 81.0500n -0.001911 81.0600n -0.001817 81.0700n -0.001712 81.0800n -0.001594 81.0900n -0.001465 81.1000n -0.001326 81.1100n -0.001178 81.1200n -0.001023 81.1300n -0.000864 81.1400n -0.000701
+ 81.1500n -0.000537 81.1600n -0.000375 81.1700n -0.000217 81.1800n -0.000065 81.1900n 0.000078 81.2000n 0.000211 81.2100n 0.000330 81.2200n 0.000434 81.2300n 0.000521 81.2400n 0.000590 81.2500n 0.000640 81.2600n 0.000670 81.2700n 0.000679 81.2800n 0.000669 81.2900n 0.000638
+ 81.3000n 0.000589 81.3100n 0.000521 81.3200n 0.000438 81.3300n 0.000342 81.3400n 0.000233 81.3500n 0.000116 81.3600n -0.000007 81.3700n -0.000133 81.3800n -0.000259 81.3900n -0.000382 81.4000n -0.000498 81.4100n -0.000604 81.4200n -0.000697 81.4300n -0.000776 81.4400n -0.000836
+ 81.4500n -0.000877 81.4600n -0.000896 81.4700n -0.000892 81.4800n -0.000865 81.4900n -0.000813 81.5000n -0.000738 81.5100n -0.000639 81.5200n -0.000519 81.5300n -0.000378 81.5400n -0.000219 81.5500n -0.000044 81.5600n 0.000144 81.5700n 0.000342 81.5800n 0.000546 81.5900n 0.000753
+ 81.6000n 0.000960 81.6100n 0.001162 81.6200n 0.001356 81.6300n 0.001538 81.6400n 0.001705 81.6500n 0.001855 81.6600n 0.001983 81.6700n 0.002088 81.6800n 0.002168 81.6900n 0.002222 81.7000n 0.002248 81.7100n 0.002245 81.7200n 0.002215 81.7300n 0.002158 81.7400n 0.002074
+ 81.7500n 0.001965 81.7600n 0.001835 81.7700n 0.001684 81.7800n 0.001516 81.7900n 0.001334 81.8000n 0.001142 81.8100n 0.000943 81.8200n 0.000741 81.8300n 0.000540 81.8400n 0.000343 81.8500n 0.000155 81.8600n -0.000022 81.8700n -0.000184 81.8800n -0.000328 81.8900n -0.000451
+ 81.9000n -0.000552 81.9100n -0.000629 81.9200n -0.000680 81.9300n -0.000705 81.9400n -0.000703 81.9500n -0.000675 81.9600n -0.000621 81.9700n -0.000542 81.9800n -0.000441 81.9900n -0.000319 82.0000n -0.000179 82.0100n -0.000022 82.0200n 0.000147 82.0300n 0.000326 82.0400n 0.000512
+ 82.0500n 0.000701 82.0600n 0.000891 82.0700n 0.001077 82.0800n 0.001257 82.0900n 0.001428 82.1000n 0.001587 82.1100n 0.001733 82.1200n 0.001862 82.1300n 0.001973 82.1400n 0.002065 82.1500n 0.002136 82.1600n 0.002187 82.1700n 0.002216 82.1800n 0.002224 82.1900n 0.002211
+ 82.2000n 0.002179 82.2100n 0.002127 82.2200n 0.002059 82.2300n 0.001974 82.2400n 0.001875 82.2500n 0.001764 82.2600n 0.001642 82.2700n 0.001513 82.2800n 0.001377 82.2900n 0.001237 82.3000n 0.001095 82.3100n 0.000953 82.3200n 0.000812 82.3300n 0.000674 82.3400n 0.000541
+ 82.3500n 0.000413 82.3600n 0.000292 82.3700n 0.000178 82.3800n 0.000072 82.3900n -0.000026 82.4000n -0.000115 82.4100n -0.000196 82.4200n -0.000269 82.4300n -0.000334 82.4400n -0.000392 82.4500n -0.000442 82.4600n -0.000486 82.4700n -0.000525 82.4800n -0.000559 82.4900n -0.000588
+ 82.5000n -0.000614 82.5100n -0.000636 82.5200n -0.000656 82.5300n -0.000674 82.5400n -0.000690 82.5500n -0.000704 82.5600n -0.000717 82.5700n -0.000728 82.5800n -0.000738 82.5900n -0.000745 82.6000n -0.000751 82.6100n -0.000755 82.6200n -0.000756 82.6300n -0.000753 82.6400n -0.000747
+ 82.6500n -0.000738 82.6600n -0.000723 82.6700n -0.000704 82.6800n -0.000680 82.6900n -0.000650 82.7000n -0.000615 82.7100n -0.000574 82.7200n -0.000526 82.7300n -0.000473 82.7400n -0.000414 82.7500n -0.000350 82.7600n -0.000280 82.7700n -0.000206 82.7800n -0.000128 82.7900n -0.000046
+ 82.8000n 0.000039 82.8100n 0.000127 82.8200n 0.000216 82.8300n 0.000305 82.8400n 0.000395 82.8500n 0.000484 82.8600n 0.000572 82.8700n 0.000657 82.8800n 0.000740 82.8900n 0.000819 82.9000n 0.000894 82.9100n 0.000965 82.9200n 0.001031 82.9300n 0.001092 82.9400n 0.001147
+ 82.9500n 0.001198 82.9600n 0.001243 82.9700n 0.001283 82.9800n 0.001317 82.9900n 0.001347 83.0000n 0.001372 83.0100n 0.001392 83.0200n 0.001409 83.0300n 0.001422 83.0400n 0.001431 83.0500n 0.001438 83.0600n 0.001443 83.0700n 0.001445 83.0800n 0.001447 83.0900n 0.001447
+ 83.1000n 0.001446 83.1100n 0.001445 83.1200n 0.001445 83.1300n 0.001445 83.1400n 0.001446 83.1500n 0.001448 83.1600n 0.001452 83.1700n 0.001458 83.1800n 0.001466 83.1900n 0.001476 83.2000n 0.001489 83.2100n 0.001505 83.2200n 0.001524 83.2300n 0.001546 83.2400n 0.001572
+ 83.2500n 0.001602 83.2600n 0.001636 83.2700n 0.001674 83.2800n 0.001716 83.2900n 0.001762 83.3000n 0.001812 83.3100n 0.001867 83.3200n 0.001925 83.3300n 0.001987 83.3400n 0.002053 83.3500n 0.002122 83.3600n 0.002193 83.3700n 0.002265 83.3800n 0.002339 83.3900n 0.002414
+ 83.4000n 0.002487 83.4100n 0.002559 83.4200n 0.002628 83.4300n 0.002693 83.4400n 0.002753 83.4500n 0.002806 83.4600n 0.002851 83.4700n 0.002887 83.4800n 0.002912 83.4900n 0.002925 83.5000n 0.002926 83.5100n 0.002912 83.5200n 0.002883 83.5300n 0.002839 83.5400n 0.002778
+ 83.5500n 0.002700 83.5600n 0.002605 83.5700n 0.002494 83.5800n 0.002366 83.5900n 0.002223 83.6000n 0.002065 83.6100n 0.001893 83.6200n 0.001710 83.6300n 0.001516 83.6400n 0.001313 83.6500n 0.001105 83.6600n 0.000893 83.6700n 0.000680 83.6800n 0.000468 83.6900n 0.000261
+ 83.7000n 0.000060 83.7100n -0.000130 83.7200n -0.000308 83.7300n -0.000471 83.7400n -0.000617 83.7500n -0.000744 83.7600n -0.000849 83.7700n -0.000932 83.7800n -0.000990 83.7900n -0.001023 83.8000n -0.001032 83.8100n -0.001015 83.8200n -0.000973 83.8300n -0.000907 83.8400n -0.000819
+ 83.8500n -0.000710 83.8600n -0.000582 83.8700n -0.000438 83.8800n -0.000280 83.8900n -0.000112 83.9000n 0.000063 83.9100n 0.000242 83.9200n 0.000421 83.9300n 0.000597 83.9400n 0.000765 83.9500n 0.000924 83.9600n 0.001068 83.9700n 0.001196 83.9800n 0.001305 83.9900n 0.001392
+ 84.0000n 0.001455 84.0100n 0.001493 84.0200n 0.001504 84.0300n 0.001488 84.0400n 0.001446 84.0500n 0.001377 84.0600n 0.001282 84.0700n 0.001164 84.0800n 0.001023 84.0900n 0.000863 84.1000n 0.000686 84.1100n 0.000495 84.1200n 0.000294 84.1300n 0.000087 84.1400n -0.000123
+ 84.1500n -0.000332 84.1600n -0.000536 84.1700n -0.000731 84.1800n -0.000914 84.1900n -0.001081 84.2000n -0.001229 84.2100n -0.001355 84.2200n -0.001458 84.2300n -0.001534 84.2400n -0.001584 84.2500n -0.001606 84.2600n -0.001600 84.2700n -0.001566 84.2800n -0.001505 84.2900n -0.001419
+ 84.3000n -0.001310 84.3100n -0.001180 84.3200n -0.001032 84.3300n -0.000869 84.3400n -0.000695 84.3500n -0.000514 84.3600n -0.000329 84.3700n -0.000146 84.3800n 0.000033 84.3900n 0.000203 84.4000n 0.000360 84.4100n 0.000500 84.4200n 0.000620 84.4300n 0.000717 84.4400n 0.000789
+ 84.4500n 0.000833 84.4600n 0.000848 84.4700n 0.000833 84.4800n 0.000787 84.4900n 0.000711 84.5000n 0.000605 84.5100n 0.000471 84.5200n 0.000310 84.5300n 0.000125 84.5400n -0.000081 84.5500n -0.000306 84.5600n -0.000545 84.5700n -0.000794 84.5800n -0.001049 84.5900n -0.001307
+ 84.6000n -0.001562 84.6100n -0.001810 84.6200n -0.002048 84.6300n -0.002270 84.6400n -0.002474 84.6500n -0.002655 84.6600n -0.002811 84.6700n -0.002938 84.6800n -0.003035 84.6900n -0.003099 84.7000n -0.003130 84.7100n -0.003127 84.7200n -0.003089 84.7300n -0.003018 84.7400n -0.002913
+ 84.7500n -0.002778 84.7600n -0.002613 84.7700n -0.002421 84.7800n -0.002205 84.7900n -0.001968 84.8000n -0.001714 84.8100n -0.001447 84.8200n -0.001169 84.8300n -0.000886 84.8400n -0.000602 84.8500n -0.000320 84.8600n -0.000044 84.8700n 0.000222 84.8800n 0.000475 84.8900n 0.000710
+ 84.9000n 0.000926 84.9100n 0.001120 84.9200n 0.001289 84.9300n 0.001431 84.9400n 0.001546 84.9500n 0.001632 84.9600n 0.001689 84.9700n 0.001716 84.9800n 0.001714 84.9900n 0.001683 85.0000n 0.001625 85.0100n 0.001542 85.0200n 0.001433 85.0300n 0.001303 85.0400n 0.001152
+ 85.0500n 0.000984 85.0600n 0.000800 85.0700n 0.000604 85.0800n 0.000398 85.0900n 0.000185 85.1000n -0.000033 85.1100n -0.000252 85.1200n -0.000470 85.1300n -0.000685 85.1400n -0.000894 85.1500n -0.001096 85.1600n -0.001287 85.1700n -0.001467 85.1800n -0.001635 85.1900n -0.001787
+ 85.2000n -0.001924 85.2100n -0.002045 85.2200n -0.002149 85.2300n -0.002235 85.2400n -0.002304 85.2500n -0.002354 85.2600n -0.002387 85.2700n -0.002403 85.2800n -0.002402 85.2900n -0.002385 85.3000n -0.002352 85.3100n -0.002305 85.3200n -0.002244 85.3300n -0.002170 85.3400n -0.002085
+ 85.3500n -0.001990 85.3600n -0.001886 85.3700n -0.001774 85.3800n -0.001655 85.3900n -0.001531 85.4000n -0.001404 85.4100n -0.001274 85.4200n -0.001142 85.4300n -0.001011 85.4400n -0.000881 85.4500n -0.000753 85.4600n -0.000629 85.4700n -0.000509 85.4800n -0.000395 85.4900n -0.000287
+ 85.5000n -0.000187 85.5100n -0.000095 85.5200n -0.000012 85.5300n 0.000062 85.5400n 0.000125 85.5500n 0.000178 85.5600n 0.000220 85.5700n 0.000251 85.5800n 0.000271 85.5900n 0.000279 85.6000n 0.000277 85.6100n 0.000263 85.6200n 0.000239 85.6300n 0.000204 85.6400n 0.000160
+ 85.6500n 0.000106 85.6600n 0.000043 85.6700n -0.000028 85.6800n -0.000107 85.6900n -0.000192 85.7000n -0.000283 85.7100n -0.000380 85.7200n -0.000480 85.7300n -0.000585 85.7400n -0.000692 85.7500n -0.000801 85.7600n -0.000912 85.7700n -0.001023 85.7800n -0.001135 85.7900n -0.001245
+ 85.8000n -0.001355 85.8100n -0.001462 85.8200n -0.001568 85.8300n -0.001671 85.8400n -0.001770 85.8500n -0.001867 85.8600n -0.001959 85.8700n -0.002048 85.8800n -0.002132 85.8900n -0.002212 85.9000n -0.002286 85.9100n -0.002356 85.9200n -0.002420 85.9300n -0.002479 85.9400n -0.002531
+ 85.9500n -0.002577 85.9600n -0.002617 85.9700n -0.002649 85.9800n -0.002673 85.9900n -0.002690 86.0000n -0.002698 86.0100n -0.002696 86.0200n -0.002686 86.0300n -0.002665 86.0400n -0.002634 86.0500n -0.002591 86.0600n -0.002538 86.0700n -0.002473 86.0800n -0.002397 86.0900n -0.002308
+ 86.1000n -0.002208 86.1100n -0.002096 86.1200n -0.001973 86.1300n -0.001838 86.1400n -0.001694 86.1500n -0.001539 86.1600n -0.001376 86.1700n -0.001206 86.1800n -0.001028 86.1900n -0.000846 86.2000n -0.000660 86.2100n -0.000472 86.2200n -0.000284 86.2300n -0.000097 86.2400n 0.000086
+ 86.2500n 0.000264 86.2600n 0.000434 86.2700n 0.000596 86.2800n 0.000747 86.2900n 0.000886 86.3000n 0.001010 86.3100n 0.001119 86.3200n 0.001211 86.3300n 0.001286 86.3400n 0.001342 86.3500n 0.001379 86.3600n 0.001396 86.3700n 0.001394 86.3800n 0.001373 86.3900n 0.001333
+ 86.4000n 0.001274 86.4100n 0.001199 86.4200n 0.001108 86.4300n 0.001003 86.4400n 0.000885 86.4500n 0.000756 86.4600n 0.000619 86.4700n 0.000474 86.4800n 0.000325 86.4900n 0.000174 86.5000n 0.000022 86.5100n -0.000128 86.5200n -0.000275 86.5300n -0.000415 86.5400n -0.000548
+ 86.5500n -0.000671 86.5600n -0.000784 86.5700n -0.000884 86.5800n -0.000972 86.5900n -0.001045 86.6000n -0.001105 86.6100n -0.001149 86.6200n -0.001179 86.6300n -0.001194 86.6400n -0.001195 86.6500n -0.001181 86.6600n -0.001155 86.6700n -0.001117 86.6800n -0.001067 86.6900n -0.001008
+ 86.7000n -0.000939 86.7100n -0.000862 86.7200n -0.000779 86.7300n -0.000690 86.7400n -0.000597 86.7500n -0.000500 86.7600n -0.000400 86.7700n -0.000299 86.7800n -0.000196 86.7900n -0.000093 86.8000n 0.000011 86.8100n 0.000114 86.8200n 0.000217 86.8300n 0.000321 86.8400n 0.000424
+ 86.8500n 0.000527 86.8600n 0.000630 86.8700n 0.000734 86.8800n 0.000838 86.8900n 0.000944 86.9000n 0.001051 86.9100n 0.001160 86.9200n 0.001270 86.9300n 0.001381 86.9400n 0.001494 86.9500n 0.001607 86.9600n 0.001721 86.9700n 0.001835 86.9800n 0.001948 86.9900n 0.002059
+ 87.0000n 0.002166 87.0100n 0.002270 87.0200n 0.002368 87.0300n 0.002458 87.0400n 0.002540 87.0500n 0.002612 87.0600n 0.002672 87.0700n 0.002719 87.0800n 0.002752 87.0900n 0.002768 87.1000n 0.002768 87.1100n 0.002749 87.1200n 0.002712 87.1300n 0.002656 87.1400n 0.002580
+ 87.1500n 0.002485 87.1600n 0.002372 87.1700n 0.002240 87.1800n 0.002092 87.1900n 0.001928 87.2000n 0.001750 87.2100n 0.001561 87.2200n 0.001362 87.2300n 0.001155 87.2400n 0.000945 87.2500n 0.000732 87.2600n 0.000521 87.2700n 0.000313 87.2800n 0.000113 87.2900n -0.000078
+ 87.3000n -0.000256 87.3100n -0.000420 87.3200n -0.000567 87.3300n -0.000694 87.3400n -0.000801 87.3500n -0.000886 87.3600n -0.000947 87.3700n -0.000985 87.3800n -0.001000 87.3900n -0.000991 87.4000n -0.000960 87.4100n -0.000907 87.4200n -0.000835 87.4300n -0.000745 87.4400n -0.000639
+ 87.4500n -0.000520 87.4600n -0.000390 87.4700n -0.000253 87.4800n -0.000111 87.4900n 0.000032 87.5000n 0.000174 87.5100n 0.000311 87.5200n 0.000441 87.5300n 0.000561 87.5400n 0.000668 87.5500n 0.000761 87.5600n 0.000837 87.5700n 0.000895 87.5800n 0.000935 87.5900n 0.000955
+ 87.6000n 0.000956 87.6100n 0.000937 87.6200n 0.000900 87.6300n 0.000846 87.6400n 0.000775 87.6500n 0.000691 87.6600n 0.000594 87.6700n 0.000488 87.6800n 0.000374 87.6900n 0.000256 87.7000n 0.000136 87.7100n 0.000018 87.7200n -0.000097 87.7300n -0.000206 87.7400n -0.000306
+ 87.7500n -0.000396 87.7600n -0.000472 87.7700n -0.000534 87.7800n -0.000581 87.7900n -0.000611 87.8000n -0.000625 87.8100n -0.000622 87.8200n -0.000602 87.8300n -0.000568 87.8400n -0.000518 87.8500n -0.000457 87.8600n -0.000384 87.8700n -0.000303 87.8800n -0.000215 87.8900n -0.000124
+ 87.9000n -0.000032 87.9100n 0.000058 87.9200n 0.000144 87.9300n 0.000222 87.9400n 0.000291 87.9500n 0.000347 87.9600n 0.000390 87.9700n 0.000416 87.9800n 0.000425 87.9900n 0.000416 88.0000n 0.000387 88.0100n 0.000338 88.0200n 0.000270 88.0300n 0.000183 88.0400n 0.000077
+ 88.0500n -0.000045 88.0600n -0.000182 88.0700n -0.000332 88.0800n -0.000494 88.0900n -0.000663 88.1000n -0.000839 88.1100n -0.001017 88.1200n -0.001196 88.1300n -0.001371 88.1400n -0.001542 88.1500n -0.001704 88.1600n -0.001855 88.1700n -0.001994 88.1800n -0.002117 88.1900n -0.002224
+ 88.2000n -0.002313 88.2100n -0.002383 88.2200n -0.002434 88.2300n -0.002465 88.2400n -0.002476 88.2500n -0.002468 88.2600n -0.002441 88.2700n -0.002398 88.2800n -0.002339 88.2900n -0.002266 88.3000n -0.002182 88.3100n -0.002087 88.3200n -0.001986 88.3300n -0.001879 88.3400n -0.001769
+ 88.3500n -0.001659 88.3600n -0.001550 88.3700n -0.001445 88.3800n -0.001345 88.3900n -0.001253 88.4000n -0.001169 88.4100n -0.001094 88.4200n -0.001030 88.4300n -0.000976 88.4400n -0.000933 88.4500n -0.000902 88.4600n -0.000880 88.4700n -0.000869 88.4800n -0.000866 88.4900n -0.000871
+ 88.5000n -0.000882 88.5100n -0.000898 88.5200n -0.000917 88.5300n -0.000938 88.5400n -0.000959 88.5500n -0.000978 88.5600n -0.000994 88.5700n -0.001005 88.5800n -0.001010 88.5900n -0.001008 88.6000n -0.000997 88.6100n -0.000979 88.6200n -0.000950 88.6300n -0.000913 88.6400n -0.000866
+ 88.6500n -0.000810 88.6600n -0.000746 88.6700n -0.000674 88.6800n -0.000595 88.6900n -0.000510 88.7000n -0.000421 88.7100n -0.000328 88.7200n -0.000234 88.7300n -0.000139 88.7400n -0.000046 88.7500n 0.000045 88.7600n 0.000133 88.7700n 0.000215 88.7800n 0.000291 88.7900n 0.000361
+ 88.8000n 0.000423 88.8100n 0.000477 88.8200n 0.000523 88.8300n 0.000560 88.8400n 0.000589 88.8500n 0.000610 88.8600n 0.000624 88.8700n 0.000631 88.8800n 0.000632 88.8900n 0.000629 88.9000n 0.000621 88.9100n 0.000612 88.9200n 0.000600 88.9300n 0.000589 88.9400n 0.000578
+ 88.9500n 0.000569 88.9600n 0.000563 88.9700n 0.000561 88.9800n 0.000563 88.9900n 0.000570 89.0000n 0.000582 89.0100n 0.000599 89.0200n 0.000621 89.0300n 0.000648 89.0400n 0.000680 89.0500n 0.000715 89.0600n 0.000753 89.0700n 0.000793 89.0800n 0.000835 89.0900n 0.000876
+ 89.1000n 0.000915 89.1100n 0.000952 89.1200n 0.000986 89.1300n 0.001015 89.1400n 0.001037 89.1500n 0.001053 89.1600n 0.001062 89.1700n 0.001062 89.1800n 0.001054 89.1900n 0.001037 89.2000n 0.001011 89.2100n 0.000977 89.2200n 0.000935 89.2300n 0.000886 89.2400n 0.000830
+ 89.2500n 0.000769 89.2600n 0.000704 89.2700n 0.000637 89.2800n 0.000568 89.2900n 0.000500 89.3000n 0.000433 89.3100n 0.000371 89.3200n 0.000314 89.3300n 0.000264 89.3400n 0.000222 89.3500n 0.000189 89.3600n 0.000168 89.3700n 0.000158 89.3800n 0.000160 89.3900n 0.000174
+ 89.4000n 0.000202 89.4100n 0.000242 89.4200n 0.000295 89.4300n 0.000359 89.4400n 0.000434 89.4500n 0.000520 89.4600n 0.000613 89.4700n 0.000714 89.4800n 0.000820 89.4900n 0.000929 89.5000n 0.001041 89.5100n 0.001152 89.5200n 0.001261 89.5300n 0.001367 89.5400n 0.001466
+ 89.5500n 0.001559 89.5600n 0.001643 89.5700n 0.001717 89.5800n 0.001780 89.5900n 0.001831 89.6000n 0.001869 89.6100n 0.001893 89.6200n 0.001905 89.6300n 0.001904 89.6400n 0.001890 89.6500n 0.001863 89.6600n 0.001826 89.6700n 0.001778 89.6800n 0.001721 89.6900n 0.001656
+ 89.7000n 0.001586 89.7100n 0.001510 89.7200n 0.001432 89.7300n 0.001351 89.7400n 0.001271 89.7500n 0.001193 89.7600n 0.001117 89.7700n 0.001045 89.7800n 0.000979 89.7900n 0.000919 89.8000n 0.000866 89.8100n 0.000820 89.8200n 0.000782 89.8300n 0.000751 89.8400n 0.000728
+ 89.8500n 0.000713 89.8600n 0.000705 89.8700n 0.000702 89.8800n 0.000705 89.8900n 0.000712 89.9000n 0.000723 89.9100n 0.000735 89.9200n 0.000748 89.9300n 0.000761 89.9400n 0.000772 89.9500n 0.000781 89.9600n 0.000786 89.9700n 0.000786 89.9800n 0.000780 89.9900n 0.000768
+ 90.0000n 0.000750 90.0100n 0.000723 90.0200n 0.000690 90.0300n 0.000649 90.0400n 0.000600 90.0500n 0.000544 90.0600n 0.000482 90.0700n 0.000413 90.0800n 0.000339 90.0900n 0.000261 90.1000n 0.000179 90.1100n 0.000095 90.1200n 0.000009 90.1300n -0.000077 90.1400n -0.000162
+ 90.1500n -0.000245 90.1600n -0.000326 90.1700n -0.000403 90.1800n -0.000476 90.1900n -0.000543 90.2000n -0.000604 90.2100n -0.000658 90.2200n -0.000706 90.2300n -0.000746 90.2400n -0.000779 90.2500n -0.000804 90.2600n -0.000821 90.2700n -0.000832 90.2800n -0.000835 90.2900n -0.000831
+ 90.3000n -0.000821 90.3100n -0.000805 90.3200n -0.000783 90.3300n -0.000756 90.3400n -0.000724 90.3500n -0.000688 90.3600n -0.000647 90.3700n -0.000604 90.3800n -0.000556 90.3900n -0.000506 90.4000n -0.000453 90.4100n -0.000398 90.4200n -0.000340 90.4300n -0.000279 90.4400n -0.000217
+ 90.4500n -0.000152 90.4600n -0.000085 90.4700n -0.000015 90.4800n 0.000056 90.4900n 0.000130 90.5000n 0.000206 90.5100n 0.000284 90.5200n 0.000364 90.5300n 0.000445 90.5400n 0.000527 90.5500n 0.000611 90.5600n 0.000695 90.5700n 0.000779 90.5800n 0.000862 90.5900n 0.000944
+ 90.6000n 0.001024 90.6100n 0.001101 90.6200n 0.001175 90.6300n 0.001244 90.6400n 0.001309 90.6500n 0.001368 90.6600n 0.001420 90.6700n 0.001465 90.6800n 0.001502 90.6900n 0.001531 90.7000n 0.001552 90.7100n 0.001563 90.7200n 0.001565 90.7300n 0.001558 90.7400n 0.001542
+ 90.7500n 0.001517 90.7600n 0.001484 90.7700n 0.001443 90.7800n 0.001394 90.7900n 0.001339 90.8000n 0.001278 90.8100n 0.001213 90.8200n 0.001143 90.8300n 0.001071 90.8400n 0.000997 90.8500n 0.000923 90.8600n 0.000849 90.8700n 0.000776 90.8800n 0.000706 90.8900n 0.000638
+ 90.9000n 0.000574 90.9100n 0.000514 90.9200n 0.000459 90.9300n 0.000409 90.9400n 0.000363 90.9500n 0.000323 90.9600n 0.000287 90.9700n 0.000255 90.9800n 0.000227 90.9900n 0.000202 91.0000n 0.000180 91.0100n 0.000160 91.0200n 0.000140 91.0300n 0.000120 91.0400n 0.000100
+ 91.0500n 0.000078 91.0600n 0.000053 91.0700n 0.000026 91.0800n -0.000006 91.0900n -0.000042 91.1000n -0.000082 91.1100n -0.000127 91.1200n -0.000177 91.1300n -0.000232 91.1400n -0.000292 91.1500n -0.000355 91.1600n -0.000422 91.1700n -0.000492 91.1800n -0.000563 91.1900n -0.000635
+ 91.2000n -0.000708 91.2100n -0.000778 91.2200n -0.000847 91.2300n -0.000912 91.2400n -0.000972 91.2500n -0.001026 91.2600n -0.001074 91.2700n -0.001115 91.2800n -0.001147 91.2900n -0.001171 91.3000n -0.001186 91.3100n -0.001193 91.3200n -0.001190 91.3300n -0.001179 91.3400n -0.001160
+ 91.3500n -0.001134 91.3600n -0.001102 91.3700n -0.001064 91.3800n -0.001023 91.3900n -0.000979 91.4000n -0.000933 91.4100n -0.000888 91.4200n -0.000844 91.4300n -0.000803 91.4400n -0.000767 91.4500n -0.000736 91.4600n -0.000711 91.4700n -0.000694 91.4800n -0.000685 91.4900n -0.000685
+ 91.5000n -0.000693 91.5100n -0.000709 91.5200n -0.000734 91.5300n -0.000766 91.5400n -0.000805 91.5500n -0.000849 91.5600n -0.000897 91.5700n -0.000947 91.5800n -0.000998 91.5900n -0.001047 91.6000n -0.001094 91.6100n -0.001135 91.6200n -0.001168 91.6300n -0.001193 91.6400n -0.001206
+ 91.6500n -0.001207 91.6600n -0.001194 91.6700n -0.001165 91.6800n -0.001120 91.6900n -0.001059 91.7000n -0.000981 91.7100n -0.000886 91.7200n -0.000775 91.7300n -0.000648 91.7400n -0.000508 91.7500n -0.000355 91.7600n -0.000192 91.7700n -0.000021 91.7800n 0.000155 91.7900n 0.000335
+ 91.8000n 0.000514 91.8100n 0.000691 91.8200n 0.000862 91.8300n 0.001024 91.8400n 0.001174 91.8500n 0.001310 91.8600n 0.001430 91.8700n 0.001532 91.8800n 0.001613 91.8900n 0.001672 91.9000n 0.001709 91.9100n 0.001723 91.9200n 0.001715 91.9300n 0.001684 91.9400n 0.001632
+ 91.9500n 0.001560 91.9600n 0.001470 91.9700n 0.001365 91.9800n 0.001246 91.9900n 0.001118 92.0000n 0.000984 92.0100n 0.000846 92.0200n 0.000708 92.0300n 0.000574 92.0400n 0.000448 92.0500n 0.000332 92.0600n 0.000229 92.0700n 0.000143 92.0800n 0.000076 92.0900n 0.000030
+ 92.1000n 0.000006 92.1100n 0.000006 92.1200n 0.000029 92.1300n 0.000077 92.1400n 0.000148 92.1500n 0.000240 92.1600n 0.000353 92.1700n 0.000484 92.1800n 0.000630 92.1900n 0.000787 92.2000n 0.000953 92.2100n 0.001123 92.2200n 0.001294 92.2300n 0.001461 92.2400n 0.001620
+ 92.2500n 0.001768 92.2600n 0.001899 92.2700n 0.002010 92.2800n 0.002099 92.2900n 0.002161 92.3000n 0.002195 92.3100n 0.002199 92.3200n 0.002171 92.3300n 0.002111 92.3400n 0.002018 92.3500n 0.001894 92.3600n 0.001740 92.3700n 0.001557 92.3800n 0.001348 92.3900n 0.001116
+ 92.4000n 0.000865 92.4100n 0.000600 92.4200n 0.000323 92.4300n 0.000041 92.4400n -0.000242 92.4500n -0.000522 92.4600n -0.000793 92.4700n -0.001051 92.4800n -0.001291 92.4900n -0.001509 92.5000n -0.001701 92.5100n -0.001865 92.5200n -0.001997 92.5300n -0.002095 92.5400n -0.002159
+ 92.5500n -0.002187 92.5600n -0.002179 92.5700n -0.002137 92.5800n -0.002062 92.5900n -0.001955 92.6000n -0.001820 92.6100n -0.001660 92.6200n -0.001479 92.6300n -0.001281 92.6400n -0.001071 92.6500n -0.000853 92.6600n -0.000632 92.6700n -0.000413 92.6800n -0.000201 92.6900n -0.000001
+ 92.7000n 0.000184 92.7100n 0.000349 92.7200n 0.000490 92.7300n 0.000606 92.7400n 0.000693 92.7500n 0.000750 92.7600n 0.000776 92.7700n 0.000770 92.7800n 0.000734 92.7900n 0.000667 92.8000n 0.000573 92.8100n 0.000453 92.8200n 0.000311 92.8300n 0.000149 92.8400n -0.000028
+ 92.8500n -0.000215 92.8600n -0.000409 92.8700n -0.000605 92.8800n -0.000797 92.8900n -0.000982 92.9000n -0.001155 92.9100n -0.001311 92.9200n -0.001446 92.9300n -0.001558 92.9400n -0.001643 92.9500n -0.001698 92.9600n -0.001721 92.9700n -0.001713 92.9800n -0.001671 92.9900n -0.001596
+ 93.0000n -0.001488 93.0100n -0.001350 93.0200n -0.001183 93.0300n -0.000990 93.0400n -0.000774 93.0500n -0.000538 93.0600n -0.000286 93.0700n -0.000023 93.0800n 0.000248 93.0900n 0.000521 93.1000n 0.000792 93.1100n 0.001058 93.1200n 0.001312 93.1300n 0.001553 93.1400n 0.001775
+ 93.1500n 0.001976 93.1600n 0.002153 93.1700n 0.002303 93.1800n 0.002425 93.1900n 0.002516 93.2000n 0.002577 93.2100n 0.002608 93.2200n 0.002607 93.2300n 0.002577 93.2400n 0.002519 93.2500n 0.002434 93.2600n 0.002324 93.2700n 0.002192 93.2800n 0.002040 93.2900n 0.001872
+ 93.3000n 0.001690 93.3100n 0.001497 93.3200n 0.001296 93.3300n 0.001090 93.3400n 0.000882 93.3500n 0.000675 93.3600n 0.000471 93.3700n 0.000271 93.3800n 0.000078 93.3900n -0.000106 93.4000n -0.000282 93.4100n -0.000447 93.4200n -0.000602 93.4300n -0.000745 93.4400n -0.000878
+ 93.4500n -0.001001 93.4600n -0.001114 93.4700n -0.001218 93.4800n -0.001313 93.4900n -0.001401 93.5000n -0.001482 93.5100n -0.001557 93.5200n -0.001628 93.5300n -0.001695 93.5400n -0.001757 93.5500n -0.001817 93.5600n -0.001874 93.5700n -0.001928 93.5800n -0.001978 93.5900n -0.002025
+ 93.6000n -0.002068 93.6100n -0.002106 93.6200n -0.002138 93.6300n -0.002163 93.6400n -0.002180 93.6500n -0.002188 93.6600n -0.002185 93.6700n -0.002170 93.6800n -0.002143 93.6900n -0.002102 93.7000n -0.002046 93.7100n -0.001976 93.7200n -0.001890 93.7300n -0.001790 93.7400n -0.001674
+ 93.7500n -0.001544 93.7600n -0.001401 93.7700n -0.001246 93.7800n -0.001081 93.7900n -0.000907 93.8000n -0.000728 93.8100n -0.000545 93.8200n -0.000361 93.8300n -0.000179 93.8400n -0.000002 93.8500n 0.000167 93.8600n 0.000326 93.8700n 0.000471 93.8800n 0.000600 93.8900n 0.000710
+ 93.9000n 0.000800 93.9100n 0.000867 93.9200n 0.000911 93.9300n 0.000929 93.9400n 0.000922 93.9500n 0.000890 93.9600n 0.000833 93.9700n 0.000751 93.9800n 0.000647 93.9900n 0.000522 94.0000n 0.000379 94.0100n 0.000220 94.0200n 0.000047 94.0300n -0.000134 94.0400n -0.000322
+ 94.0500n -0.000513 94.0600n -0.000702 94.0700n -0.000887 94.0800n -0.001063 94.0900n -0.001227 94.1000n -0.001377 94.1100n -0.001509 94.1200n -0.001620 94.1300n -0.001710 94.1400n -0.001776 94.1500n -0.001817 94.1600n -0.001832 94.1700n -0.001822 94.1800n -0.001788 94.1900n -0.001730
+ 94.2000n -0.001649 94.2100n -0.001549 94.2200n -0.001431 94.2300n -0.001298 94.2400n -0.001153 94.2500n -0.001000 94.2600n -0.000842 94.2700n -0.000682 94.2800n -0.000525 94.2900n -0.000374 94.3000n -0.000231 94.3100n -0.000101 94.3200n 0.000015 94.3300n 0.000113 94.3400n 0.000193
+ 94.3500n 0.000252 94.3600n 0.000291 94.3700n 0.000307 94.3800n 0.000301 94.3900n 0.000275 94.4000n 0.000229 94.4100n 0.000165 94.4200n 0.000085 94.4300n -0.000008 94.4400n -0.000112 94.4500n -0.000224 94.4600n -0.000340 94.4700n -0.000456 94.4800n -0.000570 94.4900n -0.000678
+ 94.5000n -0.000777 94.5100n -0.000863 94.5200n -0.000935 94.5300n -0.000988 94.5400n -0.001023 94.5500n -0.001036 94.5600n -0.001027 94.5700n -0.000996 94.5800n -0.000942 94.5900n -0.000867 94.6000n -0.000770 94.6100n -0.000655 94.6200n -0.000522 94.6300n -0.000375 94.6400n -0.000217
+ 94.6500n -0.000050 94.6600n 0.000121 94.6700n 0.000293 94.6800n 0.000463 94.6900n 0.000627 94.7000n 0.000780 94.7100n 0.000920 94.7200n 0.001044 94.7300n 0.001148 94.7400n 0.001230 94.7500n 0.001288 94.7600n 0.001321 94.7700n 0.001327 94.7800n 0.001306 94.7900n 0.001259
+ 94.8000n 0.001185 94.8100n 0.001087 94.8200n 0.000966 94.8300n 0.000825 94.8400n 0.000666 94.8500n 0.000492 94.8600n 0.000307 94.8700n 0.000115 94.8800n -0.000080 94.8900n -0.000275 94.9000n -0.000465 94.9100n -0.000646 94.9200n -0.000815 94.9300n -0.000969 94.9400n -0.001103
+ 94.9500n -0.001216 94.9600n -0.001304 94.9700n -0.001367 94.9800n -0.001403 94.9900n -0.001410 95.0000n -0.001390 95.0100n -0.001342 95.0200n -0.001268 95.0300n -0.001169 95.0400n -0.001047 95.0500n -0.000905 95.0600n -0.000746 95.0700n -0.000573 95.0800n -0.000389 95.0900n -0.000199
+ 95.1000n -0.000006 95.1100n 0.000185 95.1200n 0.000371 95.1300n 0.000549 95.1400n 0.000714 95.1500n 0.000863 95.1600n 0.000993 95.1700n 0.001102 95.1800n 0.001188 95.1900n 0.001249 95.2000n 0.001284 95.2100n 0.001293 95.2200n 0.001276 95.2300n 0.001232 95.2400n 0.001164
+ 95.2500n 0.001072 95.2600n 0.000960 95.2700n 0.000828 95.2800n 0.000681 95.2900n 0.000521 95.3000n 0.000351 95.3100n 0.000175 95.3200n -0.000003 95.3300n -0.000181 95.3400n -0.000354 95.3500n -0.000520 95.3600n -0.000675 95.3700n -0.000816 95.3800n -0.000940 95.3900n -0.001047
+ 95.4000n -0.001133 95.4100n -0.001197 95.4200n -0.001238 95.4300n -0.001257 95.4400n -0.001252 95.4500n -0.001224 95.4600n -0.001175 95.4700n -0.001104 95.4800n -0.001014 95.4900n -0.000907 95.5000n -0.000784 95.5100n -0.000648 95.5200n -0.000501 95.5300n -0.000346 95.5400n -0.000186
+ 95.5500n -0.000024 95.5600n 0.000140 95.5700n 0.000300 95.5800n 0.000457 95.5900n 0.000607 95.6000n 0.000748 95.6100n 0.000879 95.6200n 0.000999 95.6300n 0.001106 95.6400n 0.001201 95.6500n 0.001281 95.6600n 0.001348 95.6700n 0.001401 95.6800n 0.001441 95.6900n 0.001468
+ 95.7000n 0.001483 95.7100n 0.001486 95.7200n 0.001480 95.7300n 0.001465 95.7400n 0.001442 95.7500n 0.001412 95.7600n 0.001377 95.7700n 0.001338 95.7800n 0.001295 95.7900n 0.001249 95.8000n 0.001202 95.8100n 0.001154 95.8200n 0.001105 95.8300n 0.001056 95.8400n 0.001006
+ 95.8500n 0.000955 95.8600n 0.000904 95.8700n 0.000852 95.8800n 0.000798 95.8900n 0.000742 95.9000n 0.000683 95.9100n 0.000620 95.9200n 0.000553 95.9300n 0.000481 95.9400n 0.000404 95.9500n 0.000321 95.9600n 0.000231 95.9700n 0.000134 95.9800n 0.000030 95.9900n -0.000081
+ 96.0000n -0.000198 96.0100n -0.000321 96.0200n -0.000450 96.0300n -0.000584 96.0400n -0.000721 96.0500n -0.000861 96.0600n -0.001002 96.0700n -0.001143 96.0800n -0.001282 96.0900n -0.001417 96.1000n -0.001548 96.1100n -0.001671 96.1200n -0.001785 96.1300n -0.001889 96.1400n -0.001982
+ 96.1500n -0.002061 96.1600n -0.002125 96.1700n -0.002174 96.1800n -0.002206 96.1900n -0.002221 96.2000n -0.002219 96.2100n -0.002199 96.2200n -0.002162 96.2300n -0.002108 96.2400n -0.002037 96.2500n -0.001951 96.2600n -0.001851 96.2700n -0.001738 96.2800n -0.001613 96.2900n -0.001480
+ 96.3000n -0.001338 96.3100n -0.001192 96.3200n -0.001041 96.3300n -0.000890 96.3400n -0.000740 96.3500n -0.000592 96.3600n -0.000449 96.3700n -0.000314 96.3800n -0.000186 96.3900n -0.000069 96.4000n 0.000036 96.4100n 0.000129 96.4200n 0.000207 96.4300n 0.000272 96.4400n 0.000321
+ 96.4500n 0.000356 96.4600n 0.000375 96.4700n 0.000380 96.4800n 0.000371 96.4900n 0.000348 96.5000n 0.000313 96.5100n 0.000267 96.5200n 0.000211 96.5300n 0.000147 96.5400n 0.000076 96.5500n 0.000001 96.5600n -0.000078 96.5700n -0.000159 96.5800n -0.000239 96.5900n -0.000318
+ 96.6000n -0.000392 96.6100n -0.000462 96.6200n -0.000526 96.6300n -0.000581 96.6400n -0.000628 96.6500n -0.000665 96.6600n -0.000692 96.6700n -0.000708 96.6800n -0.000712 96.6900n -0.000705 96.7000n -0.000686 96.7100n -0.000657 96.7200n -0.000616 96.7300n -0.000566 96.7400n -0.000505
+ 96.7500n -0.000437 96.7600n -0.000361 96.7700n -0.000279 96.7800n -0.000192 96.7900n -0.000101 96.8000n -0.000008 96.8100n 0.000086 96.8200n 0.000180 96.8300n 0.000271 96.8400n 0.000360 96.8500n 0.000444 96.8600n 0.000523 96.8700n 0.000595 96.8800n 0.000660 96.8900n 0.000716
+ 96.9000n 0.000763 96.9100n 0.000800 96.9200n 0.000827 96.9300n 0.000845 96.9400n 0.000852 96.9500n 0.000849 96.9600n 0.000837 96.9700n 0.000815 96.9800n 0.000785 96.9900n 0.000747 97.0000n 0.000703 97.0100n 0.000652 97.0200n 0.000598 97.0300n 0.000540 97.0400n 0.000481
+ 97.0500n 0.000421 97.0600n 0.000362 97.0700n 0.000305 97.0800n 0.000253 97.0900n 0.000206 97.1000n 0.000166 97.1100n 0.000134 97.1200n 0.000110 97.1300n 0.000097 97.1400n 0.000095 97.1500n 0.000105 97.1600n 0.000126 97.1700n 0.000160 97.1800n 0.000207 97.1900n 0.000266
+ 97.2000n 0.000337 97.2100n 0.000420 97.2200n 0.000513 97.2300n 0.000616 97.2400n 0.000728 97.2500n 0.000847 97.2600n 0.000971 97.2700n 0.001099 97.2800n 0.001229 97.2900n 0.001359 97.3000n 0.001487 97.3100n 0.001611 97.3200n 0.001729 97.3300n 0.001839 97.3400n 0.001940
+ 97.3500n 0.002028 97.3600n 0.002103 97.3700n 0.002163 97.3800n 0.002206 97.3900n 0.002232 97.4000n 0.002240 97.4100n 0.002229 97.4200n 0.002199 97.4300n 0.002149 97.4400n 0.002081 97.4500n 0.001995 97.4600n 0.001891 97.4700n 0.001770 97.4800n 0.001635 97.4900n 0.001487
+ 97.5000n 0.001327 97.5100n 0.001158 97.5200n 0.000982 97.5300n 0.000801 97.5400n 0.000618 97.5500n 0.000435 97.5600n 0.000254 97.5700n 0.000079 97.5800n -0.000090 97.5900n -0.000249 97.6000n -0.000398 97.6100n -0.000533 97.6200n -0.000654 97.6300n -0.000760 97.6400n -0.000849
+ 97.6500n -0.000921 97.6600n -0.000976 97.6700n -0.001013 97.6800n -0.001034 97.6900n -0.001038 97.7000n -0.001027 97.7100n -0.001003 97.7200n -0.000966 97.7300n -0.000918 97.7400n -0.000861 97.7500n -0.000798 97.7600n -0.000730 97.7700n -0.000659 97.7800n -0.000589 97.7900n -0.000520
+ 97.8000n -0.000455 97.8100n -0.000396 97.8200n -0.000345 97.8300n -0.000303 97.8400n -0.000271 97.8500n -0.000251 97.8600n -0.000244 97.8700n -0.000249 97.8800n -0.000267 97.8900n -0.000299 97.9000n -0.000343 97.9100n -0.000399 97.9200n -0.000465 97.9300n -0.000541 97.9400n -0.000626
+ 97.9500n -0.000717 97.9600n -0.000813 97.9700n -0.000912 97.9800n -0.001012 97.9900n -0.001111 98.0000n -0.001207 98.0100n -0.001299 98.0200n -0.001384 98.0300n -0.001462 98.0400n -0.001531 98.0500n -0.001589 98.0600n -0.001636 98.0700n -0.001671 98.0800n -0.001694 98.0900n -0.001705
+ 98.1000n -0.001704 98.1100n -0.001690 98.1200n -0.001666 98.1300n -0.001632 98.1400n -0.001588 98.1500n -0.001536 98.1600n -0.001478 98.1700n -0.001415 98.1800n -0.001349 98.1900n -0.001280 98.2000n -0.001210 98.2100n -0.001142 98.2200n -0.001075 98.2300n -0.001012 98.2400n -0.000953
+ 98.2500n -0.000898 98.2600n -0.000849 98.2700n -0.000806 98.2800n -0.000768 98.2900n -0.000735 98.3000n -0.000707 98.3100n -0.000683 98.3200n -0.000661 98.3300n -0.000642 98.3400n -0.000622 98.3500n -0.000602 98.3600n -0.000579 98.3700n -0.000551 98.3800n -0.000518 98.3900n -0.000478
+ 98.4000n -0.000428 98.4100n -0.000369 98.4200n -0.000298 98.4300n -0.000216 98.4400n -0.000120 98.4500n -0.000012 98.4600n 0.000108 98.4700n 0.000242 98.4800n 0.000386 98.4900n 0.000542 98.5000n 0.000706 98.5100n 0.000878 98.5200n 0.001055 98.5300n 0.001236 98.5400n 0.001416
+ 98.5500n 0.001595 98.5600n 0.001769 98.5700n 0.001934 98.5800n 0.002090 98.5900n 0.002231 98.6000n 0.002357 98.6100n 0.002464 98.6200n 0.002550 98.6300n 0.002613 98.6400n 0.002652 98.6500n 0.002665 98.6600n 0.002652 98.6700n 0.002612 98.6800n 0.002545 98.6900n 0.002453
+ 98.7000n 0.002336 98.7100n 0.002196 98.7200n 0.002034 98.7300n 0.001855 98.7400n 0.001659 98.7500n 0.001451 98.7600n 0.001235 98.7700n 0.001013 98.7800n 0.000789 98.7900n 0.000568 98.8000n 0.000354 98.8100n 0.000150 98.8200n -0.000040 98.8300n -0.000212 98.8400n -0.000364
+ 98.8500n -0.000493 98.8600n -0.000595 98.8700n -0.000670 98.8800n -0.000715 98.8900n -0.000730 98.9000n -0.000715 98.9100n -0.000670 98.9200n -0.000595 98.9300n -0.000492 98.9400n -0.000363 98.9500n -0.000210 98.9600n -0.000035 98.9700n 0.000157 98.9800n 0.000364 98.9900n 0.000581
+ 99.0000n 0.000806 99.0100n 0.001034 99.0200n 0.001260 99.0300n 0.001481 99.0400n 0.001694 99.0500n 0.001893 99.0600n 0.002077 99.0700n 0.002242 99.0800n 0.002386 99.0900n 0.002506 99.1000n 0.002600 99.1100n 0.002668 99.1200n 0.002709 99.1300n 0.002723 99.1400n 0.002710
+ 99.1500n 0.002671 99.1600n 0.002608 99.1700n 0.002522 99.1800n 0.002416 99.1900n 0.002293 99.2000n 0.002154 99.2100n 0.002004 99.2200n 0.001846 99.2300n 0.001683 99.2400n 0.001518 99.2500n 0.001355 99.2600n 0.001196 99.2700n 0.001045 99.2800n 0.000905 99.2900n 0.000777
+ 99.3000n 0.000663 99.3100n 0.000566 99.3200n 0.000486 99.3300n 0.000423 99.3400n 0.000378 99.3500n 0.000351 99.3600n 0.000341 99.3700n 0.000347 99.3800n 0.000367 99.3900n 0.000399 99.4000n 0.000441 99.4100n 0.000491 99.4200n 0.000546 99.4300n 0.000603 99.4400n 0.000659
+ 99.4500n 0.000713 99.4600n 0.000760 99.4700n 0.000799 99.4800n 0.000827 99.4900n 0.000843 99.5000n 0.000844 99.5100n 0.000829 99.5200n 0.000797 99.5300n 0.000748 99.5400n 0.000681 99.5500n 0.000597 99.5600n 0.000497 99.5700n 0.000381 99.5800n 0.000252 99.5900n 0.000111
+ 99.6000n -0.000039 99.6100n -0.000196 99.6200n -0.000356 99.6300n -0.000518 99.6400n -0.000678 99.6500n -0.000833 99.6600n -0.000980 99.6700n -0.001116 99.6800n -0.001239 99.6900n -0.001345 99.7000n -0.001432 99.7100n -0.001499 99.7200n -0.001544 99.7300n -0.001566 99.7400n -0.001565
+ 99.7500n -0.001539 99.7600n -0.001489 99.7700n -0.001416 99.7800n -0.001321 99.7900n -0.001206 99.8000n -0.001072 99.8100n -0.000922 99.8200n -0.000758 99.8300n -0.000583 99.8400n -0.000401 99.8500n -0.000215 99.8600n -0.000028 99.8700n 0.000157 99.8800n 0.000336 99.8900n 0.000507
+ 99.9000n 0.000665 99.9100n 0.000809 99.9200n 0.000936 99.9300n 0.001043 99.9400n 0.001130 99.9500n 0.001194 99.9600n 0.001235 99.9700n 0.001251 99.9800n 0.001244 99.9900n 0.001214 100.0000n 0.001161 100.0100n 0.001086 100.0200n 0.000993 100.0300n 0.000881 100.0400n 0.000755
+ 100.0500n 0.000616 100.0600n 0.000468 100.0700n 0.000313 100.0800n 0.000155 100.0900n -0.000003 100.1000n -0.000157 100.1100n -0.000306 100.1200n -0.000446 100.1300n -0.000573 100.1400n -0.000687 100.1500n -0.000783 100.1600n -0.000861 100.1700n -0.000919 100.1800n -0.000956 100.1900n -0.000971
+ 100.2000n -0.000964 100.2100n -0.000935 100.2200n -0.000885 100.2300n -0.000814 100.2400n -0.000725 100.2500n -0.000619 100.2600n -0.000498 100.2700n -0.000364 100.2800n -0.000221 100.2900n -0.000071 100.3000n 0.000082 100.3100n 0.000236 100.3200n 0.000388 100.3300n 0.000533 100.3400n 0.000669
+ 100.3500n 0.000793 100.3600n 0.000903 100.3700n 0.000994 100.3800n 0.001066 100.3900n 0.001116 100.4000n 0.001143 100.4100n 0.001145 100.4200n 0.001122 100.4300n 0.001073 100.4400n 0.000998 100.4500n 0.000897 100.4600n 0.000772 100.4700n 0.000624 100.4800n 0.000454 100.4900n 0.000266
+ 100.5000n 0.000060 100.5100n -0.000160 100.5200n -0.000391 100.5300n -0.000629 100.5400n -0.000872 100.5500n -0.001116 100.5600n -0.001357 100.5700n -0.001592 100.5800n -0.001816 100.5900n -0.002027 100.6000n -0.002221 100.6100n -0.002396 100.6200n -0.002548 100.6300n -0.002674 100.6400n -0.002773
+ 100.6500n -0.002843 100.6600n -0.002882 100.6700n -0.002890 100.6800n -0.002866 100.6900n -0.002809 100.7000n -0.002721 100.7100n -0.002602 100.7200n -0.002454 100.7300n -0.002277 100.7400n -0.002076 100.7500n -0.001851 100.7600n -0.001606 100.7700n -0.001345 100.7800n -0.001070 100.7900n -0.000785
+ 100.8000n -0.000494 100.8100n -0.000202 100.8200n 0.000090 100.8300n 0.000375 100.8400n 0.000651 100.8500n 0.000914 100.8600n 0.001161 100.8700n 0.001388 100.8800n 0.001592 100.8900n 0.001772 100.9000n 0.001925 100.9100n 0.002049 100.9200n 0.002143 100.9300n 0.002207 100.9400n 0.002241
+ 100.9500n 0.002244 100.9600n 0.002217 100.9700n 0.002163 100.9800n 0.002081 100.9900n 0.001975 101.0000n 0.001847 101.0100n 0.001700 101.0200n 0.001537 101.0300n 0.001361 101.0400n 0.001177 101.0500n 0.000987 101.0600n 0.000795 101.0700n 0.000606 101.0800n 0.000422 101.0900n 0.000248
+ 101.1000n 0.000086 101.1100n -0.000060 101.1200n -0.000188 101.1300n -0.000296 101.1400n -0.000381 101.1500n -0.000442 101.1600n -0.000479 101.1700n -0.000491 101.1800n -0.000477 101.1900n -0.000439 101.2000n -0.000377 101.2100n -0.000294 101.2200n -0.000191 101.2300n -0.000071 101.2400n 0.000063
+ 101.2500n 0.000209 101.2600n 0.000363 101.2700n 0.000520 101.2800n 0.000678 101.2900n 0.000832 101.3000n 0.000979 101.3100n 0.001114 101.3200n 0.001235 101.3300n 0.001338 101.3400n 0.001419 101.3500n 0.001477 101.3600n 0.001509 101.3700n 0.001512 101.3800n 0.001487 101.3900n 0.001431
+ 101.4000n 0.001345 101.4100n 0.001228 101.4200n 0.001083 101.4300n 0.000910 101.4400n 0.000711 101.4500n 0.000488 101.4600n 0.000245 101.4700n -0.000016 101.4800n -0.000290 101.4900n -0.000574 101.5000n -0.000863 101.5100n -0.001155 101.5200n -0.001443 101.5300n -0.001724 101.5400n -0.001994
+ 101.5500n -0.002248 101.5600n -0.002484 101.5700n -0.002697 101.5800n -0.002884 101.5900n -0.003043 101.6000n -0.003172 101.6100n -0.003268 101.6200n -0.003332 101.6300n -0.003361 101.6400n -0.003357 101.6500n -0.003319 101.6600n -0.003249 101.6700n -0.003149 101.6800n -0.003020 101.6900n -0.002864
+ 101.7000n -0.002686 101.7100n -0.002488 101.7200n -0.002273 101.7300n -0.002045 101.7400n -0.001809 101.7500n -0.001567 101.7600n -0.001324 101.7700n -0.001084 101.7800n -0.000849 101.7900n -0.000624 101.8000n -0.000412 101.8100n -0.000215 101.8200n -0.000035 101.8300n 0.000124 101.8400n 0.000263
+ 101.8500n 0.000380 101.8600n 0.000473 101.8700n 0.000544 101.8800n 0.000591 101.8900n 0.000617 101.9000n 0.000622 101.9100n 0.000608 101.9200n 0.000576 101.9300n 0.000528 101.9400n 0.000468 101.9500n 0.000397 101.9600n 0.000317 101.9700n 0.000233 101.9800n 0.000146 101.9900n 0.000059
+ 102.0000n -0.000026 102.0100n -0.000106 102.0200n -0.000179 102.0300n -0.000244 102.0400n -0.000298 102.0500n -0.000341 102.0600n -0.000371 102.0700n -0.000389 102.0800n -0.000393 102.0900n -0.000384 102.1000n -0.000362 102.1100n -0.000329 102.1200n -0.000284 102.1300n -0.000230 102.1400n -0.000167
+ 102.1500n -0.000098 102.1600n -0.000024 102.1700n 0.000054 102.1800n 0.000132 102.1900n 0.000209 102.2000n 0.000284 102.2100n 0.000354 102.2200n 0.000417 102.2300n 0.000473 102.2400n 0.000520 102.2500n 0.000557 102.2600n 0.000582 102.2700n 0.000595 102.2800n 0.000596 102.2900n 0.000584
+ 102.3000n 0.000560 102.3100n 0.000523 102.3200n 0.000474 102.3300n 0.000414 102.3400n 0.000344 102.3500n 0.000265 102.3600n 0.000177 102.3700n 0.000082 102.3800n -0.000018 102.3900n -0.000123 102.4000n -0.000230 102.4100n -0.000340 102.4200n -0.000449 102.4300n -0.000557 102.4400n -0.000663
+ 102.4500n -0.000766 102.4600n -0.000864 102.4700n -0.000957 102.4800n -0.001045 102.4900n -0.001125 102.5000n -0.001199 102.5100n -0.001265 102.5200n -0.001324 102.5300n -0.001374 102.5400n -0.001417 102.5500n -0.001452 102.5600n -0.001479 102.5700n -0.001498 102.5800n -0.001511 102.5900n -0.001516
+ 102.6000n -0.001514 102.6100n -0.001505 102.6200n -0.001491 102.6300n -0.001470 102.6400n -0.001444 102.6500n -0.001413 102.6600n -0.001377 102.6700n -0.001336 102.6800n -0.001292 102.6900n -0.001243 102.7000n -0.001191 102.7100n -0.001136 102.7200n -0.001079 102.7300n -0.001020 102.7400n -0.000960
+ 102.7500n -0.000899 102.7600n -0.000838 102.7700n -0.000778 102.7800n -0.000719 102.7900n -0.000664 102.8000n -0.000611 102.8100n -0.000564 102.8200n -0.000521 102.8300n -0.000486 102.8400n -0.000457 102.8500n -0.000438 102.8600n -0.000427 102.8700n -0.000427 102.8800n -0.000437 102.8900n -0.000459
+ 102.9000n -0.000492 102.9100n -0.000537 102.9200n -0.000595 102.9300n -0.000663 102.9400n -0.000743 102.9500n -0.000834 102.9600n -0.000934 102.9700n -0.001042 102.9800n -0.001157 102.9900n -0.001276 103.0000n -0.001399 103.0100n -0.001523 103.0200n -0.001645 103.0300n -0.001763 103.0400n -0.001874
+ 103.0500n -0.001977 103.0600n -0.002068 103.0700n -0.002144 103.0800n -0.002204 103.0900n -0.002245 103.1000n -0.002264 103.1100n -0.002261 103.1200n -0.002234 103.1300n -0.002181 103.1400n -0.002101 103.1500n -0.001995 103.1600n -0.001862 103.1700n -0.001703 103.1800n -0.001519 103.1900n -0.001311
+ 103.2000n -0.001081 103.2100n -0.000832 103.2200n -0.000566 103.2300n -0.000286 103.2400n 0.000004 103.2500n 0.000301 103.2600n 0.000602 103.2700n 0.000901 103.2800n 0.001195 103.2900n 0.001481 103.3000n 0.001753 103.3100n 0.002010 103.3200n 0.002246 103.3300n 0.002459 103.3400n 0.002646
+ 103.3500n 0.002805 103.3600n 0.002934 103.3700n 0.003031 103.3800n 0.003095 103.3900n 0.003127 103.4000n 0.003126 103.4100n 0.003094 103.4200n 0.003031 103.4300n 0.002939 103.4400n 0.002822 103.4500n 0.002680 103.4600n 0.002519 103.4700n 0.002341 103.4800n 0.002150 103.4900n 0.001949
+ 103.5000n 0.001744 103.5100n 0.001536 103.5200n 0.001332 103.5300n 0.001133 103.5400n 0.000944 103.5500n 0.000768 103.5600n 0.000606 103.5700n 0.000463 103.5800n 0.000339 103.5900n 0.000236 103.6000n 0.000155 103.6100n 0.000095 103.6200n 0.000056 103.6300n 0.000039 103.6400n 0.000040
+ 103.6500n 0.000059 103.6600n 0.000094 103.6700n 0.000141 103.6800n 0.000198 103.6900n 0.000261 103.7000n 0.000328 103.7100n 0.000395 103.7200n 0.000460 103.7300n 0.000518 103.7400n 0.000567 103.7500n 0.000605 103.7600n 0.000628 103.7700n 0.000636 103.7800n 0.000627 103.7900n 0.000600
+ 103.8000n 0.000554 103.8100n 0.000490 103.8200n 0.000408 103.8300n 0.000310 103.8400n 0.000198 103.8500n 0.000073 103.8600n -0.000062 103.8700n -0.000204 103.8800n -0.000348 103.8900n -0.000493 103.9000n -0.000633 103.9100n -0.000766 103.9200n -0.000887 103.9300n -0.000994 103.9400n -0.001081
+ 103.9500n -0.001148 103.9600n -0.001190 103.9700n -0.001207 103.9800n -0.001195 103.9900n -0.001154 104.0000n -0.001083 104.0100n -0.000983 104.0200n -0.000854 104.0300n -0.000698 104.0400n -0.000517 104.0500n -0.000313 104.0600n -0.000089 104.0700n 0.000150 104.0800n 0.000401 104.0900n 0.000659
+ 104.1000n 0.000920 104.1100n 0.001179 104.1200n 0.001431 104.1300n 0.001672 104.1400n 0.001896 104.1500n 0.002099 104.1600n 0.002278 104.1700n 0.002428 104.1800n 0.002548 104.1900n 0.002633 104.2000n 0.002683 104.2100n 0.002696 104.2200n 0.002671 104.2300n 0.002610 104.2400n 0.002513
+ 104.2500n 0.002382 104.2600n 0.002219 104.2700n 0.002026 104.2800n 0.001809 104.2900n 0.001570 104.3000n 0.001314 104.3100n 0.001045 104.3200n 0.000769 104.3300n 0.000491 104.3400n 0.000215 104.3500n -0.000053 104.3600n -0.000310 104.3700n -0.000550 104.3800n -0.000770 104.3900n -0.000966
+ 104.4000n -0.001136 104.4100n -0.001277 104.4200n -0.001388 104.4300n -0.001467 104.4400n -0.001515 104.4500n -0.001531 104.4600n -0.001517 104.4700n -0.001475 104.4800n -0.001407 104.4900n -0.001315 104.5000n -0.001204 104.5100n -0.001076 104.5200n -0.000936 104.5300n -0.000787 104.5400n -0.000635
+ 104.5500n -0.000482 104.5600n -0.000334 104.5700n -0.000194 104.5800n -0.000065 104.5900n 0.000049 104.6000n 0.000145 104.6100n 0.000222 104.6200n 0.000277 104.6300n 0.000310 104.6400n 0.000321 104.6500n 0.000309 104.6600n 0.000275 104.6700n 0.000220 104.6800n 0.000147 104.6900n 0.000058
+ 104.7000n -0.000044 104.7100n -0.000156 104.7200n -0.000275 104.7300n -0.000397 104.7400n -0.000518 104.7500n -0.000634 104.7600n -0.000742 104.7700n -0.000839 104.7800n -0.000921 104.7900n -0.000986 104.8000n -0.001030 104.8100n -0.001053 104.8200n -0.001053 104.8300n -0.001030 104.8400n -0.000982
+ 104.8500n -0.000911 104.8600n -0.000817 104.8700n -0.000703 104.8800n -0.000570 104.8900n -0.000420 104.9000n -0.000258 104.9100n -0.000086 104.9200n 0.000092 104.9300n 0.000273 104.9400n 0.000452 104.9500n 0.000625 104.9600n 0.000789 104.9700n 0.000941 104.9800n 0.001076 104.9900n 0.001192
+ 105.0000n 0.001287 105.0100n 0.001358 105.0200n 0.001405 105.0300n 0.001425 105.0400n 0.001420 105.0500n 0.001389 105.0600n 0.001333 105.0700n 0.001254 105.0800n 0.001154 105.0900n 0.001036 105.1000n 0.000902 105.1100n 0.000756 105.1200n 0.000602 105.1300n 0.000443 105.1400n 0.000283
+ 105.1500n 0.000127 105.1600n -0.000022 105.1700n -0.000160 105.1800n -0.000283 105.1900n -0.000389 105.2000n -0.000476 105.2100n -0.000540 105.2200n -0.000581 105.2300n -0.000597 105.2400n -0.000588 105.2500n -0.000555 105.2600n -0.000499 105.2700n -0.000420 105.2800n -0.000322 105.2900n -0.000206
+ 105.3000n -0.000077 105.3100n 0.000063 105.3200n 0.000210 105.3300n 0.000360 105.3400n 0.000508 105.3500n 0.000650 105.3600n 0.000783 105.3700n 0.000903 105.3800n 0.001005 105.3900n 0.001087 105.4000n 0.001146 105.4100n 0.001180 105.4200n 0.001186 105.4300n 0.001165 105.4400n 0.001115
+ 105.4500n 0.001038 105.4600n 0.000933 105.4700n 0.000803 105.4800n 0.000651 105.4900n 0.000478 105.5000n 0.000290 105.5100n 0.000088 105.5200n -0.000121 105.5300n -0.000334 105.5400n -0.000545 105.5500n -0.000751 105.5600n -0.000945 105.5700n -0.001124 105.5800n -0.001283 105.5900n -0.001418
+ 105.6000n -0.001525 105.6100n -0.001601 105.6200n -0.001644 105.6300n -0.001651 105.6400n -0.001623 105.6500n -0.001558 105.6600n -0.001457 105.6700n -0.001322 105.6800n -0.001153 105.6900n -0.000955 105.7000n -0.000729 105.7100n -0.000481 105.7200n -0.000214 105.7300n 0.000067 105.7400n 0.000356
+ 105.7500n 0.000648 105.7600n 0.000938 105.7700n 0.001220 105.7800n 0.001489 105.7900n 0.001739 105.8000n 0.001966 105.8100n 0.002165 105.8200n 0.002334 105.8300n 0.002468 105.8400n 0.002564 105.8500n 0.002623 105.8600n 0.002641 105.8700n 0.002620 105.8800n 0.002559 105.8900n 0.002461
+ 105.9000n 0.002327 105.9100n 0.002160 105.9200n 0.001963 105.9300n 0.001742 105.9400n 0.001500 105.9500n 0.001242 105.9600n 0.000973 105.9700n 0.000700 105.9800n 0.000427 105.9900n 0.000160 106.0000n -0.000096 106.0100n -0.000336 106.0200n -0.000555 106.0300n -0.000748 106.0400n -0.000912
+ 106.0500n -0.001045 106.0600n -0.001143 106.0700n -0.001204 106.0800n -0.001229 106.0900n -0.001215 106.1000n -0.001165 106.1100n -0.001078 106.1200n -0.000957 106.1300n -0.000805 106.1400n -0.000623 106.1500n -0.000417 106.1600n -0.000189 106.1700n 0.000056 106.1800n 0.000313 106.1900n 0.000578
+ 106.2000n 0.000846 106.2100n 0.001112 106.2200n 0.001371 106.2300n 0.001620 106.2400n 0.001854 106.2500n 0.002069 106.2600n 0.002263 106.2700n 0.002431 106.2800n 0.002573 106.2900n 0.002686 106.3000n 0.002769 106.3100n 0.002821 106.3200n 0.002843 106.3300n 0.002834 106.3400n 0.002797
+ 106.3500n 0.002732 106.3600n 0.002641 106.3700n 0.002527 106.3800n 0.002391 106.3900n 0.002238 106.4000n 0.002069 106.4100n 0.001887 106.4200n 0.001696 106.4300n 0.001499 106.4400n 0.001298 106.4500n 0.001096 106.4600n 0.000896 106.4700n 0.000699 106.4800n 0.000508 106.4900n 0.000325
+ 106.5000n 0.000150 106.5100n -0.000016 106.5200n -0.000171 106.5300n -0.000316 106.5400n -0.000450 106.5500n -0.000574 106.5600n -0.000687 106.5700n -0.000792 106.5800n -0.000889 106.5900n -0.000978 106.6000n -0.001060 106.6100n -0.001137 106.6200n -0.001210 106.6300n -0.001279 106.6400n -0.001345
+ 106.6500n -0.001410 106.6600n -0.001472 106.6700n -0.001533 106.6800n -0.001592 106.6900n -0.001650 106.7000n -0.001706 106.7100n -0.001760 106.7200n -0.001810 106.7300n -0.001856 106.7400n -0.001897 106.7500n -0.001932 106.7600n -0.001959 106.7700n -0.001977 106.7800n -0.001985 106.7900n -0.001982
+ 106.8000n -0.001966 106.8100n -0.001938 106.8200n -0.001895 106.8300n -0.001839 106.8400n -0.001768 106.8500n -0.001682 106.8600n -0.001582 106.8700n -0.001469 106.8800n -0.001342 106.8900n -0.001205 106.9000n -0.001058 106.9100n -0.000902 106.9200n -0.000740 106.9300n -0.000575 106.9400n -0.000408
+ 106.9500n -0.000242 106.9600n -0.000079 106.9700n 0.000078 106.9800n 0.000226 106.9900n 0.000363 107.0000n 0.000487 107.0100n 0.000596 107.0200n 0.000687 107.0300n 0.000759 107.0400n 0.000812 107.0500n 0.000844 107.0600n 0.000854 107.0700n 0.000843 107.0800n 0.000810 107.0900n 0.000756
+ 107.1000n 0.000683 107.1100n 0.000592 107.1200n 0.000483 107.1300n 0.000360 107.1400n 0.000225 107.1500n 0.000080 107.1600n -0.000072 107.1700n -0.000229 107.1800n -0.000388 107.1900n -0.000546 107.2000n -0.000699 107.2100n -0.000847 107.2200n -0.000985 107.2300n -0.001112 107.2400n -0.001225
+ 107.2500n -0.001324 107.2600n -0.001406 107.2700n -0.001471 107.2800n -0.001517 107.2900n -0.001545 107.3000n -0.001555 107.3100n -0.001547 107.3200n -0.001522 107.3300n -0.001480 107.3400n -0.001424 107.3500n -0.001356 107.3600n -0.001276 107.3700n -0.001188 107.3800n -0.001094 107.3900n -0.000995
+ 107.4000n -0.000895 107.4100n -0.000796 107.4200n -0.000699 107.4300n -0.000609 107.4400n -0.000525 107.4500n -0.000452 107.4600n -0.000389 107.4700n -0.000339 107.4800n -0.000302 107.4900n -0.000280 107.5000n -0.000273 107.5100n -0.000281 107.5200n -0.000304 107.5300n -0.000341 107.5400n -0.000393
+ 107.5500n -0.000458 107.5600n -0.000534 107.5700n -0.000620 107.5800n -0.000715 107.5900n -0.000816 107.6000n -0.000922 107.6100n -0.001030 107.6200n -0.001140 107.6300n -0.001247 107.6400n -0.001351 107.6500n -0.001450 107.6600n -0.001541 107.6700n -0.001623 107.6800n -0.001695 107.6900n -0.001754
+ 107.7000n -0.001800 107.7100n -0.001832 107.7200n -0.001849 107.7300n -0.001851 107.7400n -0.001837 107.7500n -0.001807 107.7600n -0.001762 107.7700n -0.001702 107.7800n -0.001627 107.7900n -0.001539 107.8000n -0.001438 107.8100n -0.001326 107.8200n -0.001204 107.8300n -0.001072 107.8400n -0.000934
+ 107.8500n -0.000790 107.8600n -0.000641 107.8700n -0.000490 107.8800n -0.000338 107.8900n -0.000187 107.9000n -0.000038 107.9100n 0.000106 107.9200n 0.000246 107.9300n 0.000378 107.9400n 0.000501 107.9500n 0.000616 107.9600n 0.000719 107.9700n 0.000810 107.9800n 0.000888 107.9900n 0.000952
+ 108.0000n 0.001001 108.0100n 0.001035 108.0200n 0.001053 108.0300n 0.001055 108.0400n 0.001041 108.0500n 0.001010 108.0600n 0.000964 108.0700n 0.000901 108.0800n 0.000823 108.0900n 0.000731 108.1000n 0.000625 108.1100n 0.000506 108.1200n 0.000376 108.1300n 0.000237 108.1400n 0.000089
+ 108.1500n -0.000066 108.1600n -0.000224 108.1700n -0.000385 108.1800n -0.000546 108.1900n -0.000705 108.2000n -0.000859 108.2100n -0.001006 108.2200n -0.001143 108.2300n -0.001268 108.2400n -0.001379 108.2500n -0.001472 108.2600n -0.001546 108.2700n -0.001600 108.2800n -0.001630 108.2900n -0.001635
+ 108.3000n -0.001615 108.3100n -0.001568 108.3200n -0.001493 108.3300n -0.001391 108.3400n -0.001262 108.3500n -0.001105 108.3600n -0.000922 108.3700n -0.000715 108.3800n -0.000486 108.3900n -0.000236 108.4000n 0.000032 108.4100n 0.000314 108.4200n 0.000608 108.4300n 0.000909 108.4400n 0.001214
+ 108.4500n 0.001518 108.4600n 0.001818 108.4700n 0.002108 108.4800n 0.002386 108.4900n 0.002646 108.5000n 0.002885 108.5100n 0.003098 108.5200n 0.003283 108.5300n 0.003436 108.5400n 0.003554 108.5500n 0.003634 108.5600n 0.003676 108.5700n 0.003678 108.5800n 0.003639 108.5900n 0.003560
+ 108.6000n 0.003440 108.6100n 0.003281 108.6200n 0.003086 108.6300n 0.002855 108.6400n 0.002593 108.6500n 0.002303 108.6600n 0.001989 108.6700n 0.001655 108.6800n 0.001305 108.6900n 0.000946 108.7000n 0.000582 108.7100n 0.000218 108.7200n -0.000141 108.7300n -0.000488 108.7400n -0.000821
+ 108.7500n -0.001133 108.7600n -0.001420 108.7700n -0.001678 108.7800n -0.001905 108.7900n -0.002096 108.8000n -0.002251 108.8100n -0.002366 108.8200n -0.002442 108.8300n -0.002477 108.8400n -0.002473 108.8500n -0.002430 108.8600n -0.002350 108.8700n -0.002236 108.8800n -0.002090 108.8900n -0.001915
+ 108.9000n -0.001717 108.9100n -0.001498 108.9200n -0.001264 108.9300n -0.001020 108.9400n -0.000770 108.9500n -0.000519 108.9600n -0.000273 108.9700n -0.000035 108.9800n 0.000189 108.9900n 0.000395 109.0000n 0.000579 109.0100n 0.000739 109.0200n 0.000871 109.0300n 0.000973 109.0400n 0.001043
+ 109.0500n 0.001080 109.0600n 0.001085 109.0700n 0.001057 109.0800n 0.000997 109.0900n 0.000907 109.1000n 0.000789 109.1100n 0.000645 109.1200n 0.000479 109.1300n 0.000294 109.1400n 0.000094 109.1500n -0.000117 109.1600n -0.000334 109.1700n -0.000553 109.1800n -0.000770 109.1900n -0.000979
+ 109.2000n -0.001178 109.2100n -0.001361 109.2200n -0.001526 109.2300n -0.001669 109.2400n -0.001786 109.2500n -0.001876 109.2600n -0.001936 109.2700n -0.001965 109.2800n -0.001962 109.2900n -0.001928 109.3000n -0.001861 109.3100n -0.001764 109.3200n -0.001637 109.3300n -0.001482 109.3400n -0.001302
+ 109.3500n -0.001099 109.3600n -0.000877 109.3700n -0.000639 109.3800n -0.000388 109.3900n -0.000128 109.4000n 0.000137 109.4100n 0.000404 109.4200n 0.000667 109.4300n 0.000925 109.4400n 0.001172 109.4500n 0.001407 109.4600n 0.001626 109.4700n 0.001826 109.4800n 0.002006 109.4900n 0.002163
+ 109.5000n 0.002296 109.5100n 0.002404 109.5200n 0.002487 109.5300n 0.002544 109.5400n 0.002576 109.5500n 0.002584 109.5600n 0.002568 109.5700n 0.002530 109.5800n 0.002471 109.5900n 0.002395 109.6000n 0.002303 109.6100n 0.002197 109.6200n 0.002079 109.6300n 0.001953 109.6400n 0.001822
+ 109.6500n 0.001686 109.6600n 0.001550 109.6700n 0.001415 109.6800n 0.001283 109.6900n 0.001157 109.7000n 0.001038 109.7100n 0.000927 109.7200n 0.000826 109.7300n 0.000736 109.7400n 0.000658 109.7500n 0.000592 109.7600n 0.000537 109.7700n 0.000495 109.7800n 0.000464 109.7900n 0.000444
+ 109.8000n 0.000434 109.8100n 0.000433 109.8200n 0.000441 109.8300n 0.000456 109.8400n 0.000476 109.8500n 0.000501 109.8600n 0.000529 109.8700n 0.000558 109.8800n 0.000589 109.8900n 0.000619 109.9000n 0.000647 109.9100n 0.000673 109.9200n 0.000696 109.9300n 0.000716 109.9400n 0.000731
+ 109.9500n 0.000741 109.9600n 0.000747 109.9700n 0.000749 109.9800n 0.000746 109.9900n 0.000740 110.0000n 0.000730 110.0100n 0.000717 110.0200n 0.000703 110.0300n 0.000687 110.0400n 0.000671 110.0500n 0.000655 110.0600n 0.000640 110.0700n 0.000628 110.0800n 0.000619 110.0900n 0.000613
+ 110.1000n 0.000611 110.1100n 0.000614 110.1200n 0.000622 110.1300n 0.000636 110.1400n 0.000655 110.1500n 0.000679 110.1600n 0.000708 110.1700n 0.000742 110.1800n 0.000780 110.1900n 0.000822 110.2000n 0.000866 110.2100n 0.000912 110.2200n 0.000958 110.2300n 0.001003 110.2400n 0.001047
+ 110.2500n 0.001087 110.2600n 0.001123 110.2700n 0.001153 110.2800n 0.001176 110.2900n 0.001191 110.3000n 0.001196 110.3100n 0.001192 110.3200n 0.001175 110.3300n 0.001148 110.3400n 0.001107 110.3500n 0.001054 110.3600n 0.000989 110.3700n 0.000911 110.3800n 0.000820 110.3900n 0.000718
+ 110.4000n 0.000605 110.4100n 0.000482 110.4200n 0.000351 110.4300n 0.000213 110.4400n 0.000069 110.4500n -0.000078 110.4600n -0.000226 110.4700n -0.000374 110.4800n -0.000520 110.4900n -0.000661 110.5000n -0.000794 110.5100n -0.000919 110.5200n -0.001032 110.5300n -0.001132 110.5400n -0.001216
+ 110.5500n -0.001284 110.5600n -0.001334 110.5700n -0.001364 110.5800n -0.001374 110.5900n -0.001362 110.6000n -0.001330 110.6100n -0.001275 110.6200n -0.001199 110.6300n -0.001103 110.6400n -0.000987 110.6500n -0.000852 110.6600n -0.000701 110.6700n -0.000535 110.6800n -0.000356 110.6900n -0.000167
+ 110.7000n 0.000029 110.7100n 0.000231 110.7200n 0.000434 110.7300n 0.000636 110.7400n 0.000835 110.7500n 0.001025 110.7600n 0.001206 110.7700n 0.001374 110.7800n 0.001526 110.7900n 0.001660 110.8000n 0.001773 110.8100n 0.001864 110.8200n 0.001931 110.8300n 0.001972 110.8400n 0.001988
+ 110.8500n 0.001976 110.8600n 0.001938 110.8700n 0.001874 110.8800n 0.001783 110.8900n 0.001669 110.9000n 0.001531 110.9100n 0.001371 110.9200n 0.001193 110.9300n 0.000998 110.9400n 0.000789 110.9500n 0.000570 110.9600n 0.000342 110.9700n 0.000109 110.9800n -0.000125 110.9900n -0.000358
+ 111.0000n -0.000587 111.0100n -0.000808 111.0200n -0.001019 111.0300n -0.001217 111.0400n -0.001401 111.0500n -0.001568 111.0600n -0.001717 111.0700n -0.001846 111.0800n -0.001956 111.0900n -0.002045 111.1000n -0.002113 111.1100n -0.002162 111.1200n -0.002191 111.1300n -0.002202 111.1400n -0.002197
+ 111.1500n -0.002177 111.1600n -0.002144 111.1700n -0.002101 111.1800n -0.002050 111.1900n -0.001994 111.2000n -0.001934 111.2100n -0.001873 111.2200n -0.001815 111.2300n -0.001760 111.2400n -0.001712 111.2500n -0.001671 111.2600n -0.001640 111.2700n -0.001619 111.2800n -0.001610 111.2900n -0.001613
+ 111.3000n -0.001628 111.3100n -0.001655 111.3200n -0.001694 111.3300n -0.001742 111.3400n -0.001800 111.3500n -0.001864 111.3600n -0.001934 111.3700n -0.002007 111.3800n -0.002080 111.3900n -0.002151 111.4000n -0.002218 111.4100n -0.002278 111.4200n -0.002328 111.4300n -0.002366 111.4400n -0.002390
+ 111.4500n -0.002397 111.4600n -0.002386 111.4700n -0.002356 111.4800n -0.002305 111.4900n -0.002233 111.5000n -0.002139 111.5100n -0.002023 111.5200n -0.001887 111.5300n -0.001731 111.5400n -0.001557 111.5500n -0.001367 111.5600n -0.001162 111.5700n -0.000946 111.5800n -0.000721 111.5900n -0.000490
+ 111.6000n -0.000257 111.6100n -0.000024 111.6200n 0.000205 111.6300n 0.000426 111.6400n 0.000637 111.6500n 0.000834 111.6600n 0.001014 111.6700n 0.001176 111.6800n 0.001317 111.6900n 0.001436 111.7000n 0.001530 111.7100n 0.001599 111.7200n 0.001643 111.7300n 0.001661 111.7400n 0.001655
+ 111.7500n 0.001625 111.7600n 0.001572 111.7700n 0.001499 111.7800n 0.001408 111.7900n 0.001301 111.8000n 0.001181 111.8100n 0.001051 111.8200n 0.000913 111.8300n 0.000773 111.8400n 0.000631 111.8500n 0.000492 111.8600n 0.000359 111.8700n 0.000234 111.8800n 0.000121 111.8900n 0.000020
+ 111.9000n -0.000066 111.9100n -0.000135 111.9200n -0.000186 111.9300n -0.000219 111.9400n -0.000234 111.9500n -0.000231 111.9600n -0.000210 111.9700n -0.000173 111.9800n -0.000122 111.9900n -0.000057 112.0000n 0.000019 112.0100n 0.000102 112.0200n 0.000192 112.0300n 0.000285 112.0400n 0.000378
+ 112.0500n 0.000469 112.0600n 0.000554 112.0700n 0.000632 112.0800n 0.000700 112.0900n 0.000755 112.1000n 0.000797 112.1100n 0.000823 112.1200n 0.000833 112.1300n 0.000826 112.1400n 0.000802 112.1500n 0.000760 112.1600n 0.000701 112.1700n 0.000627 112.1800n 0.000538 112.1900n 0.000437
+ 112.2000n 0.000324 112.2100n 0.000204 112.2200n 0.000077 112.2300n -0.000053 112.2400n -0.000184 112.2500n -0.000313 112.2600n -0.000437 112.2700n -0.000554 112.2800n -0.000662 112.2900n -0.000758 112.3000n -0.000840 112.3100n -0.000908 112.3200n -0.000958 112.3300n -0.000992 112.3400n -0.001007
+ 112.3500n -0.001005 112.3600n -0.000985 112.3700n -0.000947 112.3800n -0.000894 112.3900n -0.000826 112.4000n -0.000745 112.4100n -0.000653 112.4200n -0.000551 112.4300n -0.000443 112.4400n -0.000330 112.4500n -0.000216 112.4600n -0.000101 112.4700n 0.000011 112.4800n 0.000119 112.4900n 0.000220
+ 112.5000n 0.000313 112.5100n 0.000397 112.5200n 0.000470 112.5300n 0.000531 112.5400n 0.000580 112.5500n 0.000618 112.5600n 0.000644 112.5700n 0.000659 112.5800n 0.000664 112.5900n 0.000660 112.6000n 0.000649 112.6100n 0.000632 112.6200n 0.000611 112.6300n 0.000589 112.6400n 0.000566
+ 112.6500n 0.000546 112.6600n 0.000530 112.6700n 0.000520 112.6800n 0.000517 112.6900n 0.000523 112.7000n 0.000540 112.7100n 0.000566 112.7200n 0.000604 112.7300n 0.000653 112.7400n 0.000714 112.7500n 0.000784 112.7600n 0.000863 112.7700n 0.000950 112.7800n 0.001043 112.7900n 0.001139
+ 112.8000n 0.001237 112.8100n 0.001334 112.8200n 0.001426 112.8300n 0.001513 112.8400n 0.001589 112.8500n 0.001654 112.8600n 0.001704 112.8700n 0.001736 112.8800n 0.001749 112.8900n 0.001741 112.9000n 0.001709 112.9100n 0.001654 112.9200n 0.001573 112.9300n 0.001467 112.9400n 0.001337
+ 112.9500n 0.001181 112.9600n 0.001003 112.9700n 0.000804 112.9800n 0.000585 112.9900n 0.000349 113.0000n 0.000099 113.0100n -0.000161 113.0200n -0.000428 113.0300n -0.000699 113.0400n -0.000970 113.0500n -0.001236 113.0600n -0.001495 113.0700n -0.001741 113.0800n -0.001972 113.0900n -0.002185
+ 113.1000n -0.002376 113.1100n -0.002543 113.1200n -0.002683 113.1300n -0.002795 113.1400n -0.002877 113.1500n -0.002928 113.1600n -0.002949 113.1700n -0.002940 113.1800n -0.002901 113.1900n -0.002834 113.2000n -0.002739 113.2100n -0.002621 113.2200n -0.002480 113.2300n -0.002320 113.2400n -0.002144
+ 113.2500n -0.001955 113.2600n -0.001757 113.2700n -0.001552 113.2800n -0.001345 113.2900n -0.001139 113.3000n -0.000936 113.3100n -0.000740 113.3200n -0.000553 113.3300n -0.000378 113.3400n -0.000217 113.3500n -0.000072 113.3600n 0.000058 113.3700n 0.000170 113.3800n 0.000264 113.3900n 0.000340
+ 113.4000n 0.000399 113.4100n 0.000442 113.4200n 0.000469 113.4300n 0.000482 113.4400n 0.000482 113.4500n 0.000472 113.4600n 0.000452 113.4700n 0.000426 113.4800n 0.000394 113.4900n 0.000359 113.5000n 0.000323 113.5100n 0.000286 113.5200n 0.000251 113.5300n 0.000219 113.5400n 0.000191
+ 113.5500n 0.000166 113.5600n 0.000146 113.5700n 0.000131 113.5800n 0.000120 113.5900n 0.000113 113.6000n 0.000109 113.6100n 0.000107 113.6200n 0.000106 113.6300n 0.000104 113.6400n 0.000100 113.6500n 0.000092 113.6600n 0.000079 113.6700n 0.000060 113.6800n 0.000032 113.6900n -0.000004
+ 113.7000n -0.000051 113.7100n -0.000109 113.7200n -0.000178 113.7300n -0.000258 113.7400n -0.000350 113.7500n -0.000452 113.7600n -0.000565 113.7700n -0.000686 113.7800n -0.000814 113.7900n -0.000948 113.8000n -0.001085 113.8100n -0.001223 113.8200n -0.001359 113.8300n -0.001491 113.8400n -0.001616
+ 113.8500n -0.001731 113.8600n -0.001835 113.8700n -0.001923 113.8800n -0.001995 113.8900n -0.002047 113.9000n -0.002078 113.9100n -0.002087 113.9200n -0.002073 113.9300n -0.002034 113.9400n -0.001971 113.9500n -0.001884 113.9600n -0.001774 113.9700n -0.001642 113.9800n -0.001489 113.9900n -0.001319
+ 114.0000n -0.001132 114.0100n -0.000932 114.0200n -0.000723 114.0300n -0.000506 114.0400n -0.000287 114.0500n -0.000068 114.0600n 0.000146 114.0700n 0.000353 114.0800n 0.000549 114.0900n 0.000730 114.1000n 0.000894 114.1100n 0.001037 114.1200n 0.001158 114.1300n 0.001255 114.1400n 0.001326
+ 114.1500n 0.001370 114.1600n 0.001387 114.1700n 0.001378 114.1800n 0.001341 114.1900n 0.001279 114.2000n 0.001194 114.2100n 0.001086 114.2200n 0.000959 114.2300n 0.000816 114.2400n 0.000658 114.2500n 0.000491 114.2600n 0.000316 114.2700n 0.000137 114.2800n -0.000042 114.2900n -0.000217
+ 114.3000n -0.000387 114.3100n -0.000547 114.3200n -0.000695 114.3300n -0.000828 114.3400n -0.000945 114.3500n -0.001044 114.3600n -0.001124 114.3700n -0.001183 114.3800n -0.001223 114.3900n -0.001242 114.4000n -0.001243 114.4100n -0.001225 114.4200n -0.001190 114.4300n -0.001140 114.4400n -0.001078
+ 114.4500n -0.001006 114.4600n -0.000926 114.4700n -0.000841 114.4800n -0.000754 114.4900n -0.000667 114.5000n -0.000584 114.5100n -0.000507 114.5200n -0.000437 114.5300n -0.000378 114.5400n -0.000331 114.5500n -0.000297 114.5600n -0.000277 114.5700n -0.000273 114.5800n -0.000283 114.5900n -0.000308
+ 114.6000n -0.000347 114.6100n -0.000399 114.6200n -0.000463 114.6300n -0.000537 114.6400n -0.000618 114.6500n -0.000704 114.6600n -0.000793 114.6700n -0.000882 114.6800n -0.000968 114.6900n -0.001049 114.7000n -0.001121 114.7100n -0.001182 114.7200n -0.001229 114.7300n -0.001261 114.7400n -0.001276
+ 114.7500n -0.001271 114.7600n -0.001245 114.7700n -0.001198 114.7800n -0.001130 114.7900n -0.001040 114.8000n -0.000928 114.8100n -0.000796 114.8200n -0.000645 114.8300n -0.000476 114.8400n -0.000292 114.8500n -0.000095 114.8600n 0.000114 114.8700n 0.000329 114.8800n 0.000550 114.8900n 0.000773
+ 114.9000n 0.000995 114.9100n 0.001212 114.9200n 0.001422 114.9300n 0.001622 114.9400n 0.001810 114.9500n 0.001983 114.9600n 0.002139 114.9700n 0.002276 114.9800n 0.002393 114.9900n 0.002489 115.0000n 0.002563 115.0100n 0.002615 115.0200n 0.002646 115.0300n 0.002655 115.0400n 0.002643
+ 115.0500n 0.002613 115.0600n 0.002565 115.0700n 0.002501 115.0800n 0.002423 115.0900n 0.002334 115.1000n 0.002235 115.1100n 0.002130 115.1200n 0.002020 115.1300n 0.001908 115.1400n 0.001796 115.1500n 0.001686 115.1600n 0.001581 115.1700n 0.001482 115.1800n 0.001391 115.1900n 0.001310
+ 115.2000n 0.001238 115.2100n 0.001177 115.2200n 0.001128 115.2300n 0.001091 115.2400n 0.001065 115.2500n 0.001051 115.2600n 0.001047 115.2700n 0.001053 115.2800n 0.001067 115.2900n 0.001089 115.3000n 0.001117 115.3100n 0.001149 115.3200n 0.001184 115.3300n 0.001221 115.3400n 0.001257
+ 115.3500n 0.001291 115.3600n 0.001322 115.3700n 0.001348 115.3800n 0.001369 115.3900n 0.001382 115.4000n 0.001387 115.4100n 0.001384 115.4200n 0.001372 115.4300n 0.001350 115.4400n 0.001319 115.4500n 0.001279 115.4600n 0.001230 115.4700n 0.001172 115.4800n 0.001107 115.4900n 0.001035
+ 115.5000n 0.000957 115.5100n 0.000874 115.5200n 0.000788 115.5300n 0.000699 115.5400n 0.000610 115.5500n 0.000521 115.5600n 0.000434 115.5700n 0.000350 115.5800n 0.000270 115.5900n 0.000195 115.6000n 0.000127 115.6100n 0.000065 115.6200n 0.000012 115.6300n -0.000032 115.6400n -0.000068
+ 115.6500n -0.000094 115.6600n -0.000110 115.6700n -0.000117 115.6800n -0.000114 115.6900n -0.000101 115.7000n -0.000080 115.7100n -0.000051 115.7200n -0.000013 115.7300n 0.000031 115.7400n 0.000082 115.7500n 0.000137 115.7600n 0.000197 115.7700n 0.000260 115.7800n 0.000325 115.7900n 0.000391
+ 115.8000n 0.000457 115.8100n 0.000521 115.8200n 0.000583 115.8300n 0.000640 115.8400n 0.000694 115.8500n 0.000741 115.8600n 0.000781 115.8700n 0.000814 115.8800n 0.000839 115.8900n 0.000854 115.9000n 0.000859 115.9100n 0.000854 115.9200n 0.000839 115.9300n 0.000812 115.9400n 0.000774
+ 115.9500n 0.000726 115.9600n 0.000666 115.9700n 0.000596 115.9800n 0.000515 115.9900n 0.000425 116.0000n 0.000326 116.0100n 0.000219 116.0200n 0.000106 116.0300n -0.000013 116.0400n -0.000136 116.0500n -0.000263 116.0600n -0.000390 116.0700n -0.000517 116.0800n -0.000643 116.0900n -0.000764
+ 116.1000n -0.000880 116.1100n -0.000989 116.1200n -0.001089 116.1300n -0.001178 116.1400n -0.001256 116.1500n -0.001319 116.1600n -0.001369 116.1700n -0.001402 116.1800n -0.001418 116.1900n -0.001417 116.2000n -0.001398 116.2100n -0.001361 116.2200n -0.001306 116.2300n -0.001234 116.2400n -0.001145
+ 116.2500n -0.001040 116.2600n -0.000920 116.2700n -0.000788 116.2800n -0.000644 116.2900n -0.000491 116.3000n -0.000331 116.3100n -0.000167 116.3200n -0.000001 116.3300n 0.000164 116.3400n 0.000326 116.3500n 0.000481 116.3600n 0.000626 116.3700n 0.000760 116.3800n 0.000880 116.3900n 0.000983
+ 116.4000n 0.001067 116.4100n 0.001131 116.4200n 0.001172 116.4300n 0.001190 116.4400n 0.001184 116.4500n 0.001154 116.4600n 0.001099 116.4700n 0.001020 116.4800n 0.000918 116.4900n 0.000794 116.5000n 0.000650 116.5100n 0.000488 116.5200n 0.000310 116.5300n 0.000120 116.5400n -0.000079
+ 116.5500n -0.000286 116.5600n -0.000494 116.5700n -0.000703 116.5800n -0.000907 116.5900n -0.001102 116.6000n -0.001287 116.6100n -0.001456 116.6200n -0.001608 116.6300n -0.001738 116.6400n -0.001845 116.6500n -0.001926 116.6600n -0.001979 116.6700n -0.002004 116.6800n -0.001998 116.6900n -0.001962
+ 116.7000n -0.001895 116.7100n -0.001799 116.7200n -0.001674 116.7300n -0.001522 116.7400n -0.001344 116.7500n -0.001144 116.7600n -0.000924 116.7700n -0.000687 116.7800n -0.000436 116.7900n -0.000176 116.8000n 0.000092 116.8100n 0.000362 116.8200n 0.000631 116.8300n 0.000896 116.8400n 0.001153
+ 116.8500n 0.001398 116.8600n 0.001628 116.8700n 0.001842 116.8800n 0.002036 116.8900n 0.002208 116.9000n 0.002356 116.9100n 0.002480 116.9200n 0.002579 116.9300n 0.002652 116.9400n 0.002700 116.9500n 0.002723 116.9600n 0.002721 116.9700n 0.002697 116.9800n 0.002652 116.9900n 0.002587
+ 117.0000n 0.002505 117.0100n 0.002409 117.0200n 0.002300 117.0300n 0.002181 117.0400n 0.002054 117.0500n 0.001922 117.0600n 0.001788 117.0700n 0.001652 117.0800n 0.001518 117.0900n 0.001387 117.1000n 0.001260 117.1100n 0.001139 117.1200n 0.001024 117.1300n 0.000916 117.1400n 0.000814
+ 117.1500n 0.000720 117.1600n 0.000632 117.1700n 0.000550 117.1800n 0.000473 117.1900n 0.000399 117.2000n 0.000328 117.2100n 0.000258 117.2200n 0.000187 117.2300n 0.000114 117.2400n 0.000039 117.2500n -0.000042 117.2600n -0.000128 117.2700n -0.000222 117.2800n -0.000323 117.2900n -0.000432
+ 117.3000n -0.000549 117.3100n -0.000676 117.3200n -0.000810 117.3300n -0.000951 117.3400n -0.001099 117.3500n -0.001252 117.3600n -0.001409 117.3700n -0.001567 117.3800n -0.001724 117.3900n -0.001879 117.4000n -0.002028 117.4100n -0.002169 117.4200n -0.002300 117.4300n -0.002417 117.4400n -0.002519
+ 117.4500n -0.002603 117.4600n -0.002667 117.4700n -0.002708 117.4800n -0.002725 117.4900n -0.002717 117.5000n -0.002683 117.5100n -0.002621 117.5200n -0.002533 117.5300n -0.002417 117.5400n -0.002275 117.5500n -0.002108 117.5600n -0.001917 117.5700n -0.001704 117.5800n -0.001472 117.5900n -0.001223
+ 117.6000n -0.000960 117.6100n -0.000687 117.6200n -0.000406 117.6300n -0.000122 117.6400n 0.000162 117.6500n 0.000443 117.6600n 0.000716 117.6700n 0.000978 117.6800n 0.001225 117.6900n 0.001456 117.7000n 0.001665 117.7100n 0.001852 117.7200n 0.002013 117.7300n 0.002147 117.7400n 0.002252
+ 117.7500n 0.002327 117.7600n 0.002372 117.7700n 0.002387 117.7800n 0.002371 117.7900n 0.002327 117.8000n 0.002254 117.8100n 0.002155 117.8200n 0.002031 117.8300n 0.001885 117.8400n 0.001720 117.8500n 0.001538 117.8600n 0.001342 117.8700n 0.001135 117.8800n 0.000922 117.8900n 0.000704
+ 117.9000n 0.000486 117.9100n 0.000270 117.9200n 0.000059 117.9300n -0.000142 117.9400n -0.000333 117.9500n -0.000510 117.9600n -0.000671 117.9700n -0.000815 117.9800n -0.000938 117.9900n -0.001042 118.0000n -0.001123 118.0100n -0.001183 118.0200n -0.001220 118.0300n -0.001234 118.0400n -0.001227
+ 118.0500n -0.001199 118.0600n -0.001150 118.0700n -0.001083 118.0800n -0.000998 118.0900n -0.000898 118.1000n -0.000784 118.1100n -0.000658 118.1200n -0.000523 118.1300n -0.000380 118.1400n -0.000233 118.1500n -0.000083 118.1600n 0.000068 118.1700n 0.000216 118.1800n 0.000360 118.1900n 0.000498
+ 118.2000n 0.000628 118.2100n 0.000747 118.2200n 0.000854 118.2300n 0.000948 118.2400n 0.001028 118.2500n 0.001091 118.2600n 0.001137 118.2700n 0.001166 118.2800n 0.001176 118.2900n 0.001168 118.3000n 0.001141 118.3100n 0.001096 118.3200n 0.001033 118.3300n 0.000953 118.3400n 0.000856
+ 118.3500n 0.000743 118.3600n 0.000616 118.3700n 0.000476 118.3800n 0.000325 118.3900n 0.000164 118.4000n -0.000005 118.4100n -0.000180 118.4200n -0.000359 118.4300n -0.000539 118.4400n -0.000719 118.4500n -0.000896 118.4600n -0.001068 118.4700n -0.001233 118.4800n -0.001389 118.4900n -0.001534
+ 118.5000n -0.001665 118.5100n -0.001782 118.5200n -0.001881 118.5300n -0.001963 118.5400n -0.002026 118.5500n -0.002068 118.5600n -0.002090 118.5700n -0.002090 118.5800n -0.002069 118.5900n -0.002027 118.6000n -0.001964 118.6100n -0.001881 118.6200n -0.001779 118.6300n -0.001660 118.6400n -0.001524
+ 118.6500n -0.001375 118.6600n -0.001214 118.6700n -0.001043 118.6800n -0.000865 118.6900n -0.000683 118.7000n -0.000499 118.7100n -0.000316 118.7200n -0.000137 118.7300n 0.000036 118.7400n 0.000199 118.7500n 0.000350 118.7600n 0.000487 118.7700n 0.000607 118.7800n 0.000709 118.7900n 0.000791
+ 118.8000n 0.000852 118.8100n 0.000890 118.8200n 0.000905 118.8300n 0.000896 118.8400n 0.000864 118.8500n 0.000809 118.8600n 0.000732 118.8700n 0.000634 118.8800n 0.000516 118.8900n 0.000381 118.9000n 0.000230 118.9100n 0.000066 118.9200n -0.000109 118.9300n -0.000292 118.9400n -0.000481
+ 118.9500n -0.000673 118.9600n -0.000864 118.9700n -0.001052 118.9800n -0.001234 118.9900n -0.001408 119.0000n -0.001571 119.0100n -0.001722 119.0200n -0.001858 119.0300n -0.001977 119.0400n -0.002079 119.0500n -0.002163 119.0600n -0.002226 119.0700n -0.002271 119.0800n -0.002296 119.0900n -0.002301
+ 119.1000n -0.002288 119.1100n -0.002257 119.1200n -0.002210 119.1300n -0.002148 119.1400n -0.002072 119.1500n -0.001984 119.1600n -0.001887 119.1700n -0.001781 119.1800n -0.001669 119.1900n -0.001553 119.2000n -0.001435 119.2100n -0.001316 119.2200n -0.001198 119.2300n -0.001082 119.2400n -0.000970
+ 119.2500n -0.000863 119.2600n -0.000760 119.2700n -0.000664 119.2800n -0.000574 119.2900n -0.000490 119.3000n -0.000412 119.3100n -0.000340 119.3200n -0.000274 119.3300n -0.000212 119.3400n -0.000154 119.3500n -0.000099 119.3600n -0.000046 119.3700n 0.000006 119.3800n 0.000058 119.3900n 0.000110
+ 119.4000n 0.000165 119.4100n 0.000222 119.4200n 0.000281 119.4300n 0.000345 119.4400n 0.000412 119.4500n 0.000483 119.4600n 0.000557 119.4700n 0.000636 119.4800n 0.000717 119.4900n 0.000801 119.5000n 0.000886 119.5100n 0.000973 119.5200n 0.001059 119.5300n 0.001144 119.5400n 0.001226
+ 119.5500n 0.001304 119.5600n 0.001378 119.5700n 0.001446 119.5800n 0.001507 119.5900n 0.001560 119.6000n 0.001604 119.6100n 0.001639 119.6200n 0.001665 119.6300n 0.001680 119.6400n 0.001686 119.6500n 0.001682 119.6600n 0.001669 119.6700n 0.001647 119.6800n 0.001617 119.6900n 0.001581
+ 119.7000n 0.001539 119.7100n 0.001492 119.7200n 0.001443 119.7300n 0.001392 119.7400n 0.001341 119.7500n 0.001291 119.7600n 0.001244 119.7700n 0.001201 119.7800n 0.001162 119.7900n 0.001130 119.8000n 0.001103 119.8100n 0.001084 119.8200n 0.001072 119.8300n 0.001067 119.8400n 0.001069
+ 119.8500n 0.001077 119.8600n 0.001091 119.8700n 0.001109 119.8800n 0.001130 119.8900n 0.001154 119.9000n 0.001177 119.9100n 0.001198 119.9200n 0.001216 119.9300n 0.001229 119.9400n 0.001235 119.9500n 0.001232 119.9600n 0.001219 119.9700n 0.001194 119.9800n 0.001156 119.9900n 0.001105
+ 120.0000n 0.001039 120.0100n 0.000959 120.0200n 0.000864 120.0300n 0.000755 120.0400n 0.000632 120.0500n 0.000498 120.0600n 0.000353 120.0700n 0.000199 120.0800n 0.000038 120.0900n -0.000127 120.1000n -0.000294 120.1100n -0.000460 120.1200n -0.000622 120.1300n -0.000776 120.1400n -0.000922
+ 120.1500n -0.001055 120.1600n -0.001172 120.1700n -0.001273 120.1800n -0.001353 120.1900n -0.001413 120.2000n -0.001449 120.2100n -0.001462 120.2200n -0.001451 120.2300n -0.001415 120.2400n -0.001356 120.2500n -0.001273 120.2600n -0.001170 120.2700n -0.001047 120.2800n -0.000907 120.2900n -0.000752
+ 120.3000n -0.000587 120.3100n -0.000414 120.3200n -0.000236 120.3300n -0.000059 120.3400n 0.000115 120.3500n 0.000282 120.3600n 0.000438 120.3700n 0.000579 120.3800n 0.000703 120.3900n 0.000805 120.4000n 0.000884 120.4100n 0.000938 120.4200n 0.000965 120.4300n 0.000963 120.4400n 0.000933
+ 120.4500n 0.000874 120.4600n 0.000788 120.4700n 0.000675 120.4800n 0.000538 120.4900n 0.000379 120.5000n 0.000200 120.5100n 0.000006 120.5200n -0.000200 120.5300n -0.000415 120.5400n -0.000632 120.5500n -0.000850 120.5600n -0.001062 120.5700n -0.001264 120.5800n -0.001453 120.5900n -0.001624
+ 120.6000n -0.001773 120.6100n -0.001898 120.6200n -0.001995 120.6300n -0.002062 120.6400n -0.002098 120.6500n -0.002100 120.6600n -0.002070 120.6700n -0.002007 120.6800n -0.001911 120.6900n -0.001785 120.7000n -0.001629 120.7100n -0.001448 120.7200n -0.001244 120.7300n -0.001020 120.7400n -0.000780
+ 120.7500n -0.000529 120.7600n -0.000271 120.7700n -0.000010 120.7800n 0.000249 120.7900n 0.000501 120.8000n 0.000743 120.8100n 0.000970 120.8200n 0.001179 120.8300n 0.001366 120.8400n 0.001528 120.8500n 0.001664 120.8600n 0.001771 120.8700n 0.001849 120.8800n 0.001897 120.8900n 0.001914
+ 120.9000n 0.001902 120.9100n 0.001861 120.9200n 0.001794 120.9300n 0.001702 120.9400n 0.001589 120.9500n 0.001456 120.9600n 0.001309 120.9700n 0.001149 120.9800n 0.000980 120.9900n 0.000807 121.0000n 0.000632 121.0100n 0.000460 121.0200n 0.000293 121.0300n 0.000135 121.0400n -0.000013
+ 121.0500n -0.000146 121.0600n -0.000264 121.0700n -0.000366 121.0800n -0.000449 121.0900n -0.000515 121.1000n -0.000562 121.1100n -0.000592 121.1200n -0.000604 121.1300n -0.000602 121.1400n -0.000586 121.1500n -0.000558 121.1600n -0.000520 121.1700n -0.000476 121.1800n -0.000427 121.1900n -0.000377
+ 121.2000n -0.000327 121.2100n -0.000281 121.2200n -0.000240 121.2300n -0.000207 121.2400n -0.000184 121.2500n -0.000171 121.2600n -0.000170 121.2700n -0.000182 121.2800n -0.000207 121.2900n -0.000245 121.3000n -0.000295 121.3100n -0.000356 121.3200n -0.000428 121.3300n -0.000507 121.3400n -0.000594
+ 121.3500n -0.000684 121.3600n -0.000776 121.3700n -0.000868 121.3800n -0.000956 121.3900n -0.001038 121.4000n -0.001112 121.4100n -0.001176 121.4200n -0.001227 121.4300n -0.001263 121.4400n -0.001284 121.4500n -0.001287 121.4600n -0.001272 121.4700n -0.001239 121.4800n -0.001187 121.4900n -0.001118
+ 121.5000n -0.001032 121.5100n -0.000931 121.5200n -0.000816 121.5300n -0.000690 121.5400n -0.000554 121.5500n -0.000412 121.5600n -0.000266 121.5700n -0.000120 121.5800n 0.000024 121.5900n 0.000162 121.6000n 0.000293 121.6100n 0.000412 121.6200n 0.000517 121.6300n 0.000606 121.6400n 0.000677
+ 121.6500n 0.000729 121.6600n 0.000759 121.6700n 0.000768 121.6800n 0.000755 121.6900n 0.000719 121.7000n 0.000662 121.7100n 0.000585 121.7200n 0.000488 121.7300n 0.000374 121.7400n 0.000244 121.7500n 0.000101 121.7600n -0.000052 121.7700n -0.000214 121.7800n -0.000380 121.7900n -0.000549
+ 121.8000n -0.000717 121.8100n -0.000881 121.8200n -0.001040 121.8300n -0.001191 121.8400n -0.001331 121.8500n -0.001459 121.8600n -0.001574 121.8700n -0.001674 121.8800n -0.001758 121.8900n -0.001827 121.9000n -0.001880 121.9100n -0.001919 121.9200n -0.001942 121.9300n -0.001952 121.9400n -0.001950
+ 121.9500n -0.001938 121.9600n -0.001917 121.9700n -0.001889 121.9800n -0.001856 121.9900n -0.001820 122.0000n -0.001783 122.0100n -0.001747 122.0200n -0.001712 122.0300n -0.001681 122.0400n -0.001655 122.0500n -0.001634 122.0600n -0.001618 122.0700n -0.001609 122.0800n -0.001606 122.0900n -0.001608
+ 122.1000n -0.001615 122.1100n -0.001625 122.1200n -0.001637 122.1300n -0.001649 122.1400n -0.001660 122.1500n -0.001667 122.1600n -0.001669 122.1700n -0.001663 122.1800n -0.001648 122.1900n -0.001622 122.2000n -0.001582 122.2100n -0.001528 122.2200n -0.001459 122.2300n -0.001372 122.2400n -0.001269
+ 122.2500n -0.001149 122.2600n -0.001011 122.2700n -0.000858 122.2800n -0.000690 122.2900n -0.000509 122.3000n -0.000316 122.3100n -0.000115 122.3200n 0.000093 122.3300n 0.000304 122.3400n 0.000515 122.3500n 0.000724 122.3600n 0.000925 122.3700n 0.001117 122.3800n 0.001296 122.3900n 0.001459
+ 122.4000n 0.001603 122.4100n 0.001726 122.4200n 0.001825 122.4300n 0.001899 122.4400n 0.001946 122.4500n 0.001966 122.4600n 0.001959 122.4700n 0.001925 122.4800n 0.001864 122.4900n 0.001779 122.5000n 0.001672 122.5100n 0.001545 122.5200n 0.001401 122.5300n 0.001243 122.5400n 0.001076
+ 122.5500n 0.000903 122.5600n 0.000728 122.5700n 0.000556 122.5800n 0.000391 122.5900n 0.000237 122.6000n 0.000098 122.6100n -0.000022 122.6200n -0.000120 122.6300n -0.000193 122.6400n -0.000238 122.6500n -0.000255 122.6600n -0.000241 122.6700n -0.000196 122.6800n -0.000120 122.6900n -0.000014
+ 122.7000n 0.000121 122.7100n 0.000283 122.7200n 0.000468 122.7300n 0.000675 122.7400n 0.000898 122.7500n 0.001135 122.7600n 0.001380 122.7700n 0.001629 122.7800n 0.001877 122.7900n 0.002119 122.8000n 0.002350 122.8100n 0.002565 122.8200n 0.002760 122.8300n 0.002931 122.8400n 0.003074
+ 122.8500n 0.003186 122.8600n 0.003263 122.8700n 0.003304 122.8800n 0.003308 122.8900n 0.003273 122.9000n 0.003200 122.9100n 0.003089 122.9200n 0.002942 122.9300n 0.002760 122.9400n 0.002547 122.9500n 0.002305 122.9600n 0.002039 122.9700n 0.001752 122.9800n 0.001449 122.9900n 0.001135
+ 123.0000n 0.000814 123.0100n 0.000493 123.0200n 0.000175 123.0300n -0.000134 123.0400n -0.000430 123.0500n -0.000708 123.0600n -0.000965 123.0700n -0.001196 123.0800n -0.001400 123.0900n -0.001572 123.1000n -0.001713 123.1100n -0.001819 123.1200n -0.001892 123.1300n -0.001930 123.1400n -0.001934
+ 123.1500n -0.001907 123.1600n -0.001849 123.1700n -0.001763 123.1800n -0.001651 123.1900n -0.001518 123.2000n -0.001365 123.2100n -0.001198 123.2200n -0.001019 123.2300n -0.000833 123.2400n -0.000643 123.2500n -0.000454 123.2600n -0.000269 123.2700n -0.000091 123.2800n 0.000077 123.2900n 0.000232
+ 123.3000n 0.000371 123.3100n 0.000493 123.3200n 0.000597 123.3300n 0.000681 123.3400n 0.000745 123.3500n 0.000788 123.3600n 0.000812 123.3700n 0.000818 123.3800n 0.000805 123.3900n 0.000777 123.4000n 0.000735 123.4100n 0.000680 123.4200n 0.000616 123.4300n 0.000545 123.4400n 0.000469
+ 123.4500n 0.000390 123.4600n 0.000311 123.4700n 0.000235 123.4800n 0.000163 123.4900n 0.000098 123.5000n 0.000040 123.5100n -0.000008 123.5200n -0.000046 123.5300n -0.000072 123.5400n -0.000088 123.5500n -0.000091 123.5600n -0.000083 123.5700n -0.000064 123.5800n -0.000035 123.5900n 0.000003
+ 123.6000n 0.000050 123.6100n 0.000103 123.6200n 0.000161 123.6300n 0.000223 123.6400n 0.000287 123.6500n 0.000351 123.6600n 0.000414 123.6700n 0.000475 123.6800n 0.000532 123.6900n 0.000584 123.7000n 0.000630 123.7100n 0.000670 123.7200n 0.000702 123.7300n 0.000728 123.7400n 0.000746
+ 123.7500n 0.000756 123.7600n 0.000760 123.7700n 0.000757 123.7800n 0.000749 123.7900n 0.000737 123.8000n 0.000721 123.8100n 0.000702 123.8200n 0.000683 123.8300n 0.000663 123.8400n 0.000645 123.8500n 0.000628 123.8600n 0.000615 123.8700n 0.000606 123.8800n 0.000602 123.8900n 0.000603
+ 123.9000n 0.000611 123.9100n 0.000624 123.9200n 0.000643 123.9300n 0.000669 123.9400n 0.000700 123.9500n 0.000736 123.9600n 0.000776 123.9700n 0.000819 123.9800n 0.000864 123.9900n 0.000911 124.0000n 0.000957 124.0100n 0.001002 124.0200n 0.001044 124.0300n 0.001082 124.0400n 0.001115
+ 124.0500n 0.001142 124.0600n 0.001161 124.0700n 0.001173 124.0800n 0.001175 124.0900n 0.001169 124.1000n 0.001153 124.1100n 0.001128 124.1200n 0.001093 124.1300n 0.001049 124.1400n 0.000996 124.1500n 0.000936 124.1600n 0.000869 124.1700n 0.000797 124.1800n 0.000719 124.1900n 0.000639
+ 124.2000n 0.000557 124.2100n 0.000475 124.2200n 0.000394 124.2300n 0.000316 124.2400n 0.000242 124.2500n 0.000173 124.2600n 0.000111 124.2700n 0.000057 124.2800n 0.000012 124.2900n -0.000023 124.3000n -0.000048 124.3100n -0.000062 124.3200n -0.000065 124.3300n -0.000057 124.3400n -0.000039
+ 124.3500n -0.000009 124.3600n 0.000030 124.3700n 0.000079 124.3800n 0.000137 124.3900n 0.000202 124.4000n 0.000274 124.4100n 0.000352 124.4200n 0.000434 124.4300n 0.000519 124.4400n 0.000606 124.4500n 0.000693 124.4600n 0.000780 124.4700n 0.000866 124.4800n 0.000950 124.4900n 0.001029
+ 124.5000n 0.001105 124.5100n 0.001175 124.5200n 0.001240 124.5300n 0.001299 124.5400n 0.001351 124.5500n 0.001396 124.5600n 0.001435 124.5700n 0.001466 124.5800n 0.001490 124.5900n 0.001507 124.6000n 0.001517 124.6100n 0.001520 124.6200n 0.001516 124.6300n 0.001507 124.6400n 0.001490
+ 124.6500n 0.001468 124.6600n 0.001441 124.6700n 0.001407 124.6800n 0.001368 124.6900n 0.001324 124.7000n 0.001275 124.7100n 0.001220 124.7200n 0.001161 124.7300n 0.001097 124.7400n 0.001028 124.7500n 0.000954 124.7600n 0.000876 124.7700n 0.000794 124.7800n 0.000707 124.7900n 0.000617
+ 124.8000n 0.000523 124.8100n 0.000426 124.8200n 0.000327 124.8300n 0.000225 124.8400n 0.000123 124.8500n 0.000020 124.8600n -0.000083 124.8700n -0.000185 124.8800n -0.000284 124.8900n -0.000380 124.9000n -0.000471 124.9100n -0.000557 124.9200n -0.000636 124.9300n -0.000707 124.9400n -0.000770
+ 124.9500n -0.000822 124.9600n -0.000864 124.9700n -0.000895 124.9800n -0.000913 124.9900n -0.000919 125.0000n -0.000912 125.0100n -0.000893 125.0200n -0.000860 125.0300n -0.000816 125.0400n -0.000760 125.0500n -0.000694 125.0600n -0.000617 125.0700n -0.000533 125.0800n -0.000441 125.0900n -0.000344
+ 125.1000n -0.000244 125.1100n -0.000142 125.1200n -0.000041 125.1300n 0.000057 125.1400n 0.000151 125.1500n 0.000238 125.1600n 0.000316 125.1700n 0.000384 125.1800n 0.000438 125.1900n 0.000479 125.2000n 0.000504 125.2100n 0.000512 125.2200n 0.000502 125.2300n 0.000475 125.2400n 0.000428
+ 125.2500n 0.000363 125.2600n 0.000280 125.2700n 0.000179 125.2800n 0.000062 125.2900n -0.000071 125.3000n -0.000217 125.3100n -0.000376 125.3200n -0.000544 125.3300n -0.000720 125.3400n -0.000901 125.3500n -0.001084 125.3600n -0.001268 125.3700n -0.001449 125.3800n -0.001625 125.3900n -0.001793
+ 125.4000n -0.001952 125.4100n -0.002098 125.4200n -0.002230 125.4300n -0.002346 125.4400n -0.002445 125.4500n -0.002525 125.4600n -0.002586 125.4700n -0.002627 125.4800n -0.002648 125.4900n -0.002649 125.5000n -0.002631 125.5100n -0.002594 125.5200n -0.002540 125.5300n -0.002471 125.5400n -0.002387
+ 125.5500n -0.002291 125.5600n -0.002185 125.5700n -0.002072 125.5800n -0.001953 125.5900n -0.001831 125.6000n -0.001709 125.6100n -0.001588 125.6200n -0.001472 125.6300n -0.001362 125.6400n -0.001261 125.6500n -0.001169 125.6600n -0.001090 125.6700n -0.001023 125.6800n -0.000969 125.6900n -0.000931
+ 125.7000n -0.000907 125.7100n -0.000897 125.7200n -0.000903 125.7300n -0.000922 125.7400n -0.000954 125.7500n -0.000997 125.7600n -0.001051 125.7700n -0.001114 125.7800n -0.001183 125.7900n -0.001258 125.8000n -0.001335 125.8100n -0.001412 125.8200n -0.001488 125.8300n -0.001560 125.8400n -0.001626
+ 125.8500n -0.001684 125.8600n -0.001733 125.8700n -0.001769 125.8800n -0.001793 125.8900n -0.001802 125.9000n -0.001796 125.9100n -0.001774 125.9200n -0.001735 125.9300n -0.001679 125.9400n -0.001606 125.9500n -0.001516 125.9600n -0.001410 125.9700n -0.001289 125.9800n -0.001154 125.9900n -0.001006
+ 126.0000n -0.000846 126.0100n -0.000677 126.0200n -0.000500 126.0300n -0.000317 126.0400n -0.000130 126.0500n 0.000059 126.0600n 0.000247 126.0700n 0.000433 126.0800n 0.000615 126.0900n 0.000791 126.1000n 0.000958 126.1100n 0.001115 126.1200n 0.001261 126.1300n 0.001394 126.1400n 0.001512
+ 126.1500n 0.001615 126.1600n 0.001701 126.1700n 0.001770 126.1800n 0.001822 126.1900n 0.001855 126.2000n 0.001870 126.2100n 0.001867 126.2200n 0.001847 126.2300n 0.001808 126.2400n 0.001754 126.2500n 0.001683 126.2600n 0.001597 126.2700n 0.001497 126.2800n 0.001384 126.2900n 0.001259
+ 126.3000n 0.001125 126.3100n 0.000981 126.3200n 0.000830 126.3300n 0.000673 126.3400n 0.000512 126.3500n 0.000348 126.3600n 0.000183 126.3700n 0.000018 126.3800n -0.000145 126.3900n -0.000305 126.4000n -0.000461 126.4100n -0.000611 126.4200n -0.000754 126.4300n -0.000888 126.4400n -0.001014
+ 126.4500n -0.001129 126.4600n -0.001234 126.4700n -0.001327 126.4800n -0.001408 126.4900n -0.001476 126.5000n -0.001532 126.5100n -0.001575 126.5200n -0.001604 126.5300n -0.001621 126.5400n -0.001625 126.5500n -0.001617 126.5600n -0.001597 126.5700n -0.001566 126.5800n -0.001525 126.5900n -0.001474
+ 126.6000n -0.001415 126.6100n -0.001348 126.6200n -0.001274 126.6300n -0.001195 126.6400n -0.001112 126.6500n -0.001026 126.6600n -0.000938 126.6700n -0.000849 126.6800n -0.000761 126.6900n -0.000675 126.7000n -0.000593 126.7100n -0.000514 126.7200n -0.000440 126.7300n -0.000372 126.7400n -0.000311
+ 126.7500n -0.000258 126.7600n -0.000213 126.7700n -0.000176 126.7800n -0.000148 126.7900n -0.000130 126.8000n -0.000121 126.8100n -0.000121 126.8200n -0.000131 126.8300n -0.000149 126.8400n -0.000176 126.8500n -0.000211 126.8600n -0.000253 126.8700n -0.000302 126.8800n -0.000358 126.8900n -0.000419
+ 126.9000n -0.000484 126.9100n -0.000554 126.9200n -0.000626 126.9300n -0.000701 126.9400n -0.000776 126.9500n -0.000852 126.9600n -0.000928 126.9700n -0.001002 126.9800n -0.001075 126.9900n -0.001145 127.0000n -0.001211 127.0100n -0.001273 127.0200n -0.001331 127.0300n -0.001384 127.0400n -0.001431
+ 127.0500n -0.001472 127.0600n -0.001507 127.0700n -0.001535 127.0800n -0.001557 127.0900n -0.001571 127.1000n -0.001577 127.1100n -0.001576 127.1200n -0.001568 127.1300n -0.001551 127.1400n -0.001526 127.1500n -0.001492 127.1600n -0.001450 127.1700n -0.001400 127.1800n -0.001341 127.1900n -0.001273
+ 127.2000n -0.001197 127.2100n -0.001112 127.2200n -0.001019 127.2300n -0.000917 127.2400n -0.000807 127.2500n -0.000689 127.2600n -0.000563 127.2700n -0.000430 127.2800n -0.000290 127.2900n -0.000144 127.3000n 0.000007 127.3100n 0.000164 127.3200n 0.000323 127.3300n 0.000486 127.3400n 0.000651
+ 127.3500n 0.000816 127.3600n 0.000980 127.3700n 0.001143 127.3800n 0.001302 127.3900n 0.001457 127.4000n 0.001606 127.4100n 0.001747 127.4200n 0.001880 127.4300n 0.002003 127.4400n 0.002114 127.4500n 0.002213 127.4600n 0.002299 127.4700n 0.002370 127.4800n 0.002427 127.4900n 0.002467
+ 127.5000n 0.002491 127.5100n 0.002499 127.5200n 0.002491 127.5300n 0.002466 127.5400n 0.002426 127.5500n 0.002370 127.5600n 0.002301 127.5700n 0.002217 127.5800n 0.002122 127.5900n 0.002015 127.6000n 0.001900 127.6100n 0.001776 127.6200n 0.001647 127.6300n 0.001513 127.6400n 0.001376
+ 127.6500n 0.001239 127.6600n 0.001104 127.6700n 0.000971 127.6800n 0.000842 127.6900n 0.000720 127.7000n 0.000606 127.7100n 0.000501 127.7200n 0.000406 127.7300n 0.000322 127.7400n 0.000250 127.7500n 0.000191 127.7600n 0.000145 127.7700n 0.000112 127.7800n 0.000092 127.7900n 0.000085
+ 127.8000n 0.000090 127.8100n 0.000107 127.8200n 0.000136 127.8300n 0.000174 127.8400n 0.000223 127.8500n 0.000279 127.8600n 0.000343 127.8700n 0.000413 127.8800n 0.000488 127.8900n 0.000566 127.9000n 0.000648 127.9100n 0.000731 127.9200n 0.000814 127.9300n 0.000898 127.9400n 0.000981
+ 127.9500n 0.001062 127.9600n 0.001141 127.9700n 0.001218 127.9800n 0.001292 127.9900n 0.001362 128.0000n 0.001430 128.0100n 0.001494 128.0200n 0.001555 128.0300n 0.001613 128.0400n 0.001667 128.0500n 0.001719 128.0600n 0.001768 128.0700n 0.001813 128.0800n 0.001856 128.0900n 0.001896
+ 128.1000n 0.001934 128.1100n 0.001968 128.1200n 0.001998 128.1300n 0.002025 128.1400n 0.002047 128.1500n 0.002064 128.1600n 0.002076 128.1700n 0.002081 128.1800n 0.002080 128.1900n 0.002070 128.2000n 0.002051 128.2100n 0.002023 128.2200n 0.001985 128.2300n 0.001935 128.2400n 0.001874
+ 128.2500n 0.001800 128.2600n 0.001713 128.2700n 0.001613 128.2800n 0.001501 128.2900n 0.001376 128.3000n 0.001238 128.3100n 0.001089 128.3200n 0.000928 128.3300n 0.000758 128.3400n 0.000580 128.3500n 0.000395 128.3600n 0.000206 128.3700n 0.000013 128.3800n -0.000180 128.3900n -0.000372
+ 128.4000n -0.000560 128.4100n -0.000742 128.4200n -0.000915 128.4300n -0.001077 128.4400n -0.001226 128.4500n -0.001359 128.4600n -0.001475 128.4700n -0.001572 128.4800n -0.001648 128.4900n -0.001703 128.5000n -0.001735 128.5100n -0.001745 128.5200n -0.001731 128.5300n -0.001695 128.5400n -0.001637
+ 128.5500n -0.001558 128.5600n -0.001459 128.5700n -0.001343 128.5800n -0.001211 128.5900n -0.001066 128.6000n -0.000910 128.6100n -0.000747 128.6200n -0.000580 128.6300n -0.000410 128.6400n -0.000243 128.6500n -0.000079 128.6600n 0.000076 128.6700n 0.000221 128.6800n 0.000353 128.6900n 0.000470
+ 128.7000n 0.000569 128.7100n 0.000648 128.7200n 0.000708 128.7300n 0.000745 128.7400n 0.000761 128.7500n 0.000754 128.7600n 0.000726 128.7700n 0.000677 128.7800n 0.000609 128.7900n 0.000523 128.8000n 0.000420 128.8100n 0.000304 128.8200n 0.000177 128.8300n 0.000041 128.8400n -0.000099
+ 128.8500n -0.000242 128.8600n -0.000385 128.8700n -0.000524 128.8800n -0.000656 128.8900n -0.000779 128.9000n -0.000890 128.9100n -0.000987 128.9200n -0.001068 128.9300n -0.001132 128.9400n -0.001177 128.9500n -0.001203 128.9600n -0.001210 128.9700n -0.001197 128.9800n -0.001165 128.9900n -0.001116
+ 129.0000n -0.001051 129.0100n -0.000971 129.0200n -0.000878 129.0300n -0.000776 129.0400n -0.000667 129.0500n -0.000553 129.0600n -0.000437 129.0700n -0.000323 129.0800n -0.000213 129.0900n -0.000110 129.1000n -0.000016 129.1100n 0.000066 129.1200n 0.000133 129.1300n 0.000185 129.1400n 0.000219
+ 129.1500n 0.000235 129.1600n 0.000232 129.1700n 0.000209 129.1800n 0.000168 129.1900n 0.000107 129.2000n 0.000030 129.2100n -0.000063 129.2200n -0.000171 129.2300n -0.000290 129.2400n -0.000419 129.2500n -0.000554 129.2600n -0.000694 129.2700n -0.000835 129.2800n -0.000974 129.2900n -0.001109
+ 129.3000n -0.001236 129.3100n -0.001352 129.3200n -0.001457 129.3300n -0.001546 129.3400n -0.001619 129.3500n -0.001674 129.3600n -0.001709 129.3700n -0.001724 129.3800n -0.001718 129.3900n -0.001692 129.4000n -0.001646 129.4100n -0.001580 129.4200n -0.001496 129.4300n -0.001396 129.4400n -0.001281
+ 129.4500n -0.001153 129.4600n -0.001016 129.4700n -0.000870 129.4800n -0.000719 129.4900n -0.000565 129.5000n -0.000412 129.5100n -0.000260 129.5200n -0.000114 129.5300n 0.000025 129.5400n 0.000155 129.5500n 0.000275 129.5600n 0.000382 129.5700n 0.000476 129.5800n 0.000556 129.5900n 0.000621
+ 129.6000n 0.000672 129.6100n 0.000708 129.6200n 0.000731 129.6300n 0.000741 129.6400n 0.000739 129.6500n 0.000726 129.6600n 0.000706 129.6700n 0.000678 129.6800n 0.000645 129.6900n 0.000609 129.7000n 0.000572 129.7100n 0.000535 129.7200n 0.000501 129.7300n 0.000472 129.7400n 0.000447
+ 129.7500n 0.000430 129.7600n 0.000420 129.7700n 0.000420 129.7800n 0.000428 129.7900n 0.000446 129.8000n 0.000473 129.8100n 0.000509 129.8200n 0.000553 129.8300n 0.000605 129.8400n 0.000663 129.8500n 0.000727 129.8600n 0.000794 129.8700n 0.000863 129.8800n 0.000932 129.8900n 0.001000
+ 129.9000n 0.001065 129.9100n 0.001126 129.9200n 0.001180 129.9300n 0.001227 129.9400n 0.001266 129.9500n 0.001294 129.9600n 0.001312 129.9700n 0.001318 129.9800n 0.001313 129.9900n 0.001296 130.0000n 0.001268 130.0100n 0.001228 130.0200n 0.001178 130.0300n 0.001119 130.0400n 0.001050
+ 130.0500n 0.000974 130.0600n 0.000892 130.0700n 0.000806 130.0800n 0.000716 130.0900n 0.000624 130.1000n 0.000532 130.1100n 0.000441 130.1200n 0.000352 130.1300n 0.000268 130.1400n 0.000187 130.1500n 0.000113 130.1600n 0.000045 130.1700n -0.000016 130.1800n -0.000071 130.1900n -0.000117
+ 130.2000n -0.000157 130.2100n -0.000190 130.2200n -0.000216 130.2300n -0.000237 130.2400n -0.000252 130.2500n -0.000264 130.2600n -0.000271 130.2700n -0.000277 130.2800n -0.000281 130.2900n -0.000284 130.3000n -0.000287 130.3100n -0.000291 130.3200n -0.000297 130.3300n -0.000304 130.3400n -0.000314
+ 130.3500n -0.000326 130.3600n -0.000340 130.3700n -0.000356 130.3800n -0.000373 130.3900n -0.000391 130.4000n -0.000409 130.4100n -0.000426 130.4200n -0.000440 130.4300n -0.000451 130.4400n -0.000457 130.4500n -0.000458 130.4600n -0.000451 130.4700n -0.000436 130.4800n -0.000412 130.4900n -0.000377
+ 130.5000n -0.000330 130.5100n -0.000272 130.5200n -0.000202 130.5300n -0.000120 130.5400n -0.000025 130.5500n 0.000081 130.5600n 0.000198 130.5700n 0.000325 130.5800n 0.000461 130.5900n 0.000604 130.6000n 0.000752 130.6100n 0.000904 130.6200n 0.001057 130.6300n 0.001210 130.6400n 0.001359
+ 130.6500n 0.001502 130.6600n 0.001637 130.6700n 0.001762 130.6800n 0.001875 130.6900n 0.001973 130.7000n 0.002054 130.7100n 0.002118 130.7200n 0.002163 130.7300n 0.002187 130.7400n 0.002190 130.7500n 0.002172 130.7600n 0.002133 130.7700n 0.002073 130.7800n 0.001994 130.7900n 0.001895
+ 130.8000n 0.001779 130.8100n 0.001648 130.8200n 0.001503 130.8300n 0.001347 130.8400n 0.001181 130.8500n 0.001009 130.8600n 0.000834 130.8700n 0.000657 130.8800n 0.000482 130.8900n 0.000310 130.9000n 0.000145 130.9100n -0.000012 130.9200n -0.000159 130.9300n -0.000293 130.9400n -0.000415
+ 130.9500n -0.000521 130.9600n -0.000613 130.9700n -0.000690 130.9800n -0.000751 130.9900n -0.000797 131.0000n -0.000829 131.0100n -0.000847 131.0200n -0.000854 131.0300n -0.000850 131.0400n -0.000838 131.0500n -0.000819 131.0600n -0.000796 131.0700n -0.000770 131.0800n -0.000744 131.0900n -0.000720
+ 131.1000n -0.000700 131.1100n -0.000685 131.1200n -0.000678 131.1300n -0.000680 131.1400n -0.000692 131.1500n -0.000715 131.1600n -0.000750 131.1700n -0.000796 131.1800n -0.000855 131.1900n -0.000925 131.2000n -0.001007 131.2100n -0.001098 131.2200n -0.001198 131.2300n -0.001306 131.2400n -0.001419
+ 131.2500n -0.001536 131.2600n -0.001655 131.2700n -0.001774 131.2800n -0.001891 131.2900n -0.002003 131.3000n -0.002109 131.3100n -0.002206 131.3200n -0.002293 131.3300n -0.002368 131.3400n -0.002430 131.3500n -0.002478 131.3600n -0.002511 131.3700n -0.002528 131.3800n -0.002529 131.3900n -0.002513
+ 131.4000n -0.002482 131.4100n -0.002435 131.4200n -0.002373 131.4300n -0.002298 131.4400n -0.002210 131.4500n -0.002111 131.4600n -0.002003 131.4700n -0.001886 131.4800n -0.001763 131.4900n -0.001635 131.5000n -0.001505 131.5100n -0.001372 131.5200n -0.001240 131.5300n -0.001109 131.5400n -0.000981
+ 131.5500n -0.000856 131.5600n -0.000735 131.5700n -0.000619 131.5800n -0.000509 131.5900n -0.000405 131.6000n -0.000306 131.6100n -0.000213 131.6200n -0.000126 131.6300n -0.000043 131.6400n 0.000036 131.6500n 0.000111 131.6600n 0.000184 131.6700n 0.000254 131.6800n 0.000323 131.6900n 0.000392
+ 131.7000n 0.000461 131.7100n 0.000530 131.7200n 0.000601 131.7300n 0.000673 131.7400n 0.000747 131.7500n 0.000823 131.7600n 0.000900 131.7700n 0.000979 131.7800n 0.001058 131.7900n 0.001137 131.8000n 0.001215 131.8100n 0.001291 131.8200n 0.001365 131.8300n 0.001434 131.8400n 0.001498
+ 131.8500n 0.001555 131.8600n 0.001605 131.8700n 0.001646 131.8800n 0.001676 131.8900n 0.001696 131.9000n 0.001704 131.9100n 0.001699 131.9200n 0.001681 131.9300n 0.001649 131.9400n 0.001604 131.9500n 0.001546 131.9600n 0.001475 131.9700n 0.001391 131.9800n 0.001296 131.9900n 0.001190
+ 132.0000n 0.001075 132.0100n 0.000951 132.0200n 0.000821 132.0300n 0.000686 132.0400n 0.000547 132.0500n 0.000407 132.0600n 0.000266 132.0700n 0.000127 132.0800n -0.000010 132.0900n -0.000142 132.1000n -0.000268 132.1100n -0.000388 132.1200n -0.000500 132.1300n -0.000603 132.1400n -0.000697
+ 132.1500n -0.000782 132.1600n -0.000857 132.1700n -0.000923 132.1800n -0.000980 132.1900n -0.001028 132.2000n -0.001068 132.2100n -0.001101 132.2200n -0.001127 132.2300n -0.001148 132.2400n -0.001165 132.2500n -0.001177 132.2600n -0.001188 132.2700n -0.001196 132.2800n -0.001204 132.2900n -0.001213
+ 132.3000n -0.001221 132.3100n -0.001231 132.3200n -0.001243 132.3300n -0.001256 132.3400n -0.001270 132.3500n -0.001286 132.3600n -0.001303 132.3700n -0.001321 132.3800n -0.001338 132.3900n -0.001354 132.4000n -0.001369 132.4100n -0.001381 132.4200n -0.001389 132.4300n -0.001393 132.4400n -0.001391
+ 132.4500n -0.001383 132.4600n -0.001368 132.4700n -0.001345 132.4800n -0.001314 132.4900n -0.001275 132.5000n -0.001228 132.5100n -0.001173 132.5200n -0.001111 132.5300n -0.001041 132.5400n -0.000965 132.5500n -0.000884 132.5600n -0.000799 132.5700n -0.000712 132.5800n -0.000624 132.5900n -0.000536
+ 132.6000n -0.000451 132.6100n -0.000369 132.6200n -0.000293 132.6300n -0.000224 132.6400n -0.000164 132.6500n -0.000113 132.6600n -0.000074 132.6700n -0.000046 132.6800n -0.000030 132.6900n -0.000026 132.7000n -0.000035 132.7100n -0.000057 132.7200n -0.000090 132.7300n -0.000133 132.7400n -0.000185
+ 132.7500n -0.000246 132.7600n -0.000312 132.7700n -0.000382 132.7800n -0.000454 132.7900n -0.000525 132.8000n -0.000594 132.8100n -0.000657 132.8200n -0.000712 132.8300n -0.000758 132.8400n -0.000792 132.8500n -0.000812 132.8600n -0.000816 132.8700n -0.000804 132.8800n -0.000775 132.8900n -0.000727
+ 132.9000n -0.000660 132.9100n -0.000576 132.9200n -0.000474 132.9300n -0.000356 132.9400n -0.000223 132.9500n -0.000077 132.9600n 0.000080 132.9700n 0.000245 132.9800n 0.000416 132.9900n 0.000589 133.0000n 0.000762 133.0100n 0.000931 133.0200n 0.001093 133.0300n 0.001245 133.0400n 0.001385
+ 133.0500n 0.001509 133.0600n 0.001615 133.0700n 0.001701 133.0800n 0.001766 133.0900n 0.001807 133.1000n 0.001826 133.1100n 0.001820 133.1200n 0.001791 133.1300n 0.001739 133.1400n 0.001666 133.1500n 0.001573 133.1600n 0.001462 133.1700n 0.001336 133.1800n 0.001199 133.1900n 0.001052
+ 133.2000n 0.000899 133.2100n 0.000745 133.2200n 0.000593 133.2300n 0.000445 133.2400n 0.000306 133.2500n 0.000179 133.2600n 0.000067 133.2700n -0.000027 133.2800n -0.000102 133.2900n -0.000156 133.3000n -0.000186 133.3100n -0.000194 133.3200n -0.000178 133.3300n -0.000139 133.3400n -0.000078
+ 133.3500n 0.000003 133.3600n 0.000103 133.3700n 0.000217 133.3800n 0.000345 133.3900n 0.000481 133.4000n 0.000623 133.4100n 0.000766 133.4200n 0.000906 133.4300n 0.001040 133.4400n 0.001162 133.4500n 0.001270 133.4600n 0.001360 133.4700n 0.001428 133.4800n 0.001472 133.4900n 0.001489
+ 133.5000n 0.001477 133.5100n 0.001436 133.5200n 0.001364 133.5300n 0.001263 133.5400n 0.001131 133.5500n 0.000972 133.5600n 0.000787 133.5700n 0.000579 133.5800n 0.000351 133.5900n 0.000106 133.6000n -0.000150 133.6100n -0.000414 133.6200n -0.000681 133.6300n -0.000946 133.6400n -0.001204
+ 133.6500n -0.001450 133.6600n -0.001680 133.6700n -0.001890 133.6800n -0.002074 133.6900n -0.002231 133.7000n -0.002356 133.7100n -0.002447 133.7200n -0.002503 133.7300n -0.002523 133.7400n -0.002506 133.7500n -0.002453 133.7600n -0.002365 133.7700n -0.002243 133.7800n -0.002091 133.7900n -0.001912
+ 133.8000n -0.001709 133.8100n -0.001487 133.8200n -0.001250 133.8300n -0.001003 133.8400n -0.000751 133.8500n -0.000500 133.8600n -0.000253 133.8700n -0.000017 133.8800n 0.000204 133.8900n 0.000406 133.9000n 0.000584 133.9100n 0.000736 133.9200n 0.000859 133.9300n 0.000951 133.9400n 0.001009
+ 133.9500n 0.001035 133.9600n 0.001027 133.9700n 0.000987 133.9800n 0.000916 133.9900n 0.000817 134.0000n 0.000693 134.0100n 0.000546 134.0200n 0.000381 134.0300n 0.000203 134.0400n 0.000016 134.0500n -0.000175 134.0600n -0.000365 134.0700n -0.000549 134.0800n -0.000722 134.0900n -0.000879
+ 134.1000n -0.001017 134.1100n -0.001130 134.1200n -0.001217 134.1300n -0.001274 134.1400n -0.001298 134.1500n -0.001289 134.1600n -0.001245 134.1700n -0.001168 134.1800n -0.001056 134.1900n -0.000912 134.2000n -0.000739 134.2100n -0.000537 134.2200n -0.000312 134.2300n -0.000067 134.2400n 0.000195
+ 134.2500n 0.000468 134.2600n 0.000747 134.2700n 0.001028 134.2800n 0.001306 134.2900n 0.001576 134.3000n 0.001833 134.3100n 0.002073 134.3200n 0.002291 134.3300n 0.002485 134.3400n 0.002651 134.3500n 0.002786 134.3600n 0.002889 134.3700n 0.002958 134.3800n 0.002993 134.3900n 0.002994
+ 134.4000n 0.002962 134.4100n 0.002897 134.4200n 0.002802 134.4300n 0.002679 134.4400n 0.002531 134.4500n 0.002361 134.4600n 0.002174 134.4700n 0.001972 134.4800n 0.001759 134.4900n 0.001541 134.5000n 0.001320 134.5100n 0.001101 134.5200n 0.000887 134.5300n 0.000682 134.5400n 0.000488
+ 134.5500n 0.000309 134.5600n 0.000146 134.5700n 0.000001 134.5800n -0.000124 134.5900n -0.000229 134.6000n -0.000314 134.6100n -0.000378 134.6200n -0.000423 134.6300n -0.000450 134.6400n -0.000460 134.6500n -0.000455 134.6600n -0.000438 134.6700n -0.000411 134.6800n -0.000375 134.6900n -0.000335
+ 134.7000n -0.000291 134.7100n -0.000247 134.7200n -0.000205 134.7300n -0.000168 134.7400n -0.000136 134.7500n -0.000112 134.7600n -0.000096 134.7700n -0.000090 134.7800n -0.000094 134.7900n -0.000109 134.8000n -0.000133 134.8100n -0.000167 134.8200n -0.000210 134.8300n -0.000260 134.8400n -0.000316
+ 134.8500n -0.000377 134.8600n -0.000440 134.8700n -0.000504 134.8800n -0.000566 134.8900n -0.000626 134.9000n -0.000682 134.9100n -0.000731 134.9200n -0.000773 134.9300n -0.000805 134.9400n -0.000829 134.9500n -0.000842 134.9600n -0.000845 134.9700n -0.000838 134.9800n -0.000822 134.9900n -0.000796
+ 135.0000n -0.000764 135.0100n -0.000724 135.0200n -0.000681 135.0300n -0.000635 135.0400n -0.000588 135.0500n -0.000543 135.0600n -0.000502 135.0700n -0.000467 135.0800n -0.000440 135.0900n -0.000424 135.1000n -0.000419 135.1100n -0.000428 135.1200n -0.000451 135.1300n -0.000489 135.1400n -0.000543
+ 135.1500n -0.000612 135.1600n -0.000697 135.1700n -0.000796 135.1800n -0.000908 135.1900n -0.001032 135.2000n -0.001164 135.2100n -0.001303 135.2200n -0.001446 135.2300n -0.001590 135.2400n -0.001732 135.2500n -0.001868 135.2600n -0.001994 135.2700n -0.002109 135.2800n -0.002208 135.2900n -0.002289
+ 135.3000n -0.002349 135.3100n -0.002385 135.3200n -0.002395 135.3300n -0.002378 135.3400n -0.002333 135.3500n -0.002259 135.3600n -0.002156 135.3700n -0.002025 135.3800n -0.001867 135.3900n -0.001683 135.4000n -0.001476 135.4100n -0.001249 135.4200n -0.001004 135.4300n -0.000744 135.4400n -0.000475
+ 135.4500n -0.000199 135.4600n 0.000079 135.4700n 0.000354 135.4800n 0.000624 135.4900n 0.000882 135.5000n 0.001127 135.5100n 0.001353 135.5200n 0.001558 135.5300n 0.001739 135.5400n 0.001894 135.5500n 0.002019 135.5600n 0.002115 135.5700n 0.002181 135.5800n 0.002216 135.5900n 0.002220
+ 135.6000n 0.002196 135.6100n 0.002144 135.6200n 0.002068 135.6300n 0.001968 135.6400n 0.001850 135.6500n 0.001716 135.6600n 0.001569 135.6700n 0.001415 135.6800n 0.001256 135.6900n 0.001098 135.7000n 0.000944 135.7100n 0.000797 135.7200n 0.000663 135.7300n 0.000543 135.7400n 0.000441
+ 135.7500n 0.000360 135.7600n 0.000301 135.7700n 0.000266 135.7800n 0.000256 135.7900n 0.000270 135.8000n 0.000309 135.8100n 0.000372 135.8200n 0.000457 135.8300n 0.000563 135.8400n 0.000686 135.8500n 0.000824 135.8600n 0.000973 135.8700n 0.001130 135.8800n 0.001291 135.8900n 0.001452
+ 135.9000n 0.001610 135.9100n 0.001760 135.9200n 0.001898 135.9300n 0.002021 135.9400n 0.002126 135.9500n 0.002210 135.9600n 0.002270 135.9700n 0.002305 135.9800n 0.002313 135.9900n 0.002293 136.0000n 0.002244 136.0100n 0.002169 136.0200n 0.002066 136.0300n 0.001938 136.0400n 0.001787
+ 136.0500n 0.001615 136.0600n 0.001426 136.0700n 0.001222 136.0800n 0.001008 136.0900n 0.000788 136.1000n 0.000565 136.1100n 0.000344 136.1200n 0.000129 136.1300n -0.000075 136.1400n -0.000266 136.1500n -0.000438 136.1600n -0.000589 136.1700n -0.000716 136.1800n -0.000816 136.1900n -0.000886
+ 136.2000n -0.000927 136.2100n -0.000936 136.2200n -0.000913 136.2300n -0.000858 136.2400n -0.000773 136.2500n -0.000658 136.2600n -0.000515 136.2700n -0.000348 136.2800n -0.000158 136.2900n 0.000050 136.3000n 0.000275 136.3100n 0.000511 136.3200n 0.000754 136.3300n 0.001001 136.3400n 0.001248
+ 136.3500n 0.001489 136.3600n 0.001722 136.3700n 0.001943 136.3800n 0.002148 136.3900n 0.002333 136.4000n 0.002496 136.4100n 0.002635 136.4200n 0.002748 136.4300n 0.002833 136.4400n 0.002888 136.4500n 0.002915 136.4600n 0.002912 136.4700n 0.002881 136.4800n 0.002822 136.4900n 0.002737
+ 136.5000n 0.002627 136.5100n 0.002496 136.5200n 0.002345 136.5300n 0.002178 136.5400n 0.001997 136.5500n 0.001805 136.5600n 0.001607 136.5700n 0.001405 136.5800n 0.001202 136.5900n 0.001003 136.6000n 0.000809 136.6100n 0.000623 136.6200n 0.000450 136.6300n 0.000289 136.6400n 0.000145
+ 136.6500n 0.000017 136.6600n -0.000091 136.6700n -0.000180 136.6800n -0.000248 136.6900n -0.000296 136.7000n -0.000323 136.7100n -0.000330 136.7200n -0.000318 136.7300n -0.000288 136.7400n -0.000241 136.7500n -0.000178 136.7600n -0.000102 136.7700n -0.000014 136.7800n 0.000083 136.7900n 0.000188
+ 136.8000n 0.000298 136.8100n 0.000411 136.8200n 0.000525 136.8300n 0.000638 136.8400n 0.000749 136.8500n 0.000854 136.8600n 0.000953 136.8700n 0.001044 136.8800n 0.001125 136.8900n 0.001196 136.9000n 0.001255 136.9100n 0.001302 136.9200n 0.001336 136.9300n 0.001356 136.9400n 0.001364
+ 136.9500n 0.001357 136.9600n 0.001338 136.9700n 0.001306 136.9800n 0.001261 136.9900n 0.001204 137.0000n 0.001136 137.0100n 0.001057 137.0200n 0.000969 137.0300n 0.000871 137.0400n 0.000765 137.0500n 0.000652 137.0600n 0.000533 137.0700n 0.000408 137.0800n 0.000278 137.0900n 0.000144
+ 137.1000n 0.000007 137.1100n -0.000133 137.1200n -0.000275 137.1300n -0.000418 137.1400n -0.000561 137.1500n -0.000705 137.1600n -0.000848 137.1700n -0.000991 137.1800n -0.001132 137.1900n -0.001271 137.2000n -0.001407 137.2100n -0.001541 137.2200n -0.001671 137.2300n -0.001798 137.2400n -0.001920
+ 137.2500n -0.002038 137.2600n -0.002150 137.2700n -0.002255 137.2800n -0.002355 137.2900n -0.002446 137.3000n -0.002530 137.3100n -0.002605 137.3200n -0.002671 137.3300n -0.002727 137.3400n -0.002772 137.3500n -0.002805 137.3600n -0.002827 137.3700n -0.002836 137.3800n -0.002832 137.3900n -0.002815
+ 137.4000n -0.002784 137.4100n -0.002739 137.4200n -0.002680 137.4300n -0.002607 137.4400n -0.002519 137.4500n -0.002418 137.4600n -0.002304 137.4700n -0.002177 137.4800n -0.002038 137.4900n -0.001887 137.5000n -0.001727 137.5100n -0.001557 137.5200n -0.001381 137.5300n -0.001198 137.5400n -0.001010
+ 137.5500n -0.000820 137.5600n -0.000628 137.5700n -0.000438 137.5800n -0.000250 137.5900n -0.000066 137.6000n 0.000111 137.6100n 0.000279 137.6200n 0.000437 137.6300n 0.000583 137.6400n 0.000716 137.6500n 0.000833 137.6600n 0.000934 137.6700n 0.001017 137.6800n 0.001081 137.6900n 0.001125
+ 137.7000n 0.001150 137.7100n 0.001154 137.7200n 0.001138 137.7300n 0.001102 137.7400n 0.001046 137.7500n 0.000972 137.7600n 0.000880 137.7700n 0.000772 137.7800n 0.000649 137.7900n 0.000513 137.8000n 0.000366 137.8100n 0.000210 137.8200n 0.000048 137.8300n -0.000119 137.8400n -0.000287
+ 137.8500n -0.000455 137.8600n -0.000619 137.8700n -0.000778 137.8800n -0.000929 137.8900n -0.001069 137.9000n -0.001197 137.9100n -0.001311 137.9200n -0.001409 137.9300n -0.001491 137.9400n -0.001554 137.9500n -0.001598 137.9600n -0.001623 137.9700n -0.001629 137.9800n -0.001616 137.9900n -0.001584
+ 138.0000n -0.001535 138.0100n -0.001470 138.0200n -0.001390 138.0300n -0.001297 138.0400n -0.001194 138.0500n -0.001082 138.0600n -0.000964 138.0700n -0.000842 138.0800n -0.000720 138.0900n -0.000600 138.1000n -0.000483 138.1100n -0.000374 138.1200n -0.000274 138.1300n -0.000185 138.1400n -0.000109
+ 138.1500n -0.000048 138.1600n -0.000003 138.1700n 0.000025 138.1800n 0.000035 138.1900n 0.000027 138.2000n 0.000001 138.2100n -0.000042 138.2200n -0.000102 138.2300n -0.000176 138.2400n -0.000264 138.2500n -0.000363 138.2600n -0.000471 138.2700n -0.000585 138.2800n -0.000703 138.2900n -0.000822
+ 138.3000n -0.000939 138.3100n -0.001050 138.3200n -0.001154 138.3300n -0.001247 138.3400n -0.001326 138.3500n -0.001390 138.3600n -0.001435 138.3700n -0.001461 138.3800n -0.001465 138.3900n -0.001447 138.4000n -0.001406 138.4100n -0.001343 138.4200n -0.001257 138.4300n -0.001149 138.4400n -0.001021
+ 138.4500n -0.000874 138.4600n -0.000711 138.4700n -0.000535 138.4800n -0.000348 138.4900n -0.000154 138.5000n 0.000045 138.5100n 0.000243 138.5200n 0.000438 138.5300n 0.000626 138.5400n 0.000803 138.5500n 0.000965 138.5600n 0.001110 138.5700n 0.001233 138.5800n 0.001332 138.5900n 0.001406
+ 138.6000n 0.001451 138.6100n 0.001466 138.6200n 0.001452 138.6300n 0.001406 138.6400n 0.001330 138.6500n 0.001225 138.6600n 0.001091 138.6700n 0.000931 138.6800n 0.000746 138.6900n 0.000541 138.7000n 0.000319 138.7100n 0.000082 138.7200n -0.000165 138.7300n -0.000418 138.7400n -0.000672
+ 138.7500n -0.000923 138.7600n -0.001167 138.7700n -0.001400 138.7800n -0.001617 138.7900n -0.001816 138.8000n -0.001991 138.8100n -0.002142 138.8200n -0.002264 138.8300n -0.002357 138.8400n -0.002418 138.8500n -0.002447 138.8600n -0.002444 138.8700n -0.002409 138.8800n -0.002343 138.8900n -0.002248
+ 138.9000n -0.002126 138.9100n -0.001980 138.9200n -0.001812 138.9300n -0.001626 138.9400n -0.001426 138.9500n -0.001217 138.9600n -0.001001 138.9700n -0.000784 138.9800n -0.000570 138.9900n -0.000363 139.0000n -0.000166 139.0100n 0.000016 139.0200n 0.000180 139.0300n 0.000323 139.0400n 0.000443
+ 139.0500n 0.000537 139.0600n 0.000604 139.0700n 0.000643 139.0800n 0.000653 139.0900n 0.000636 139.1000n 0.000591 139.1100n 0.000520 139.1200n 0.000424 139.1300n 0.000307 139.1400n 0.000171 139.1500n 0.000018 139.1600n -0.000148 139.1700n -0.000323 139.1800n -0.000504 139.1900n -0.000686
+ 139.2000n -0.000867 139.2100n -0.001043 139.2200n -0.001209 139.2300n -0.001363 139.2400n -0.001502 139.2500n -0.001623 139.2600n -0.001725 139.2700n -0.001805 139.2800n -0.001861 139.2900n -0.001894 139.3000n -0.001903 139.3100n -0.001888 139.3200n -0.001849 139.3300n -0.001788 139.3400n -0.001706
+ 139.3500n -0.001605 139.3600n -0.001487 139.3700n -0.001355 139.3800n -0.001210 139.3900n -0.001056 139.4000n -0.000896 139.4100n -0.000732 139.4200n -0.000566 139.4300n -0.000403 139.4400n -0.000243 139.4500n -0.000090 139.4600n 0.000056 139.4700n 0.000191 139.4800n 0.000316 139.4900n 0.000428
+ 139.5000n 0.000527 139.5100n 0.000614 139.5200n 0.000687 139.5300n 0.000748 139.5400n 0.000797 139.5500n 0.000836 139.5600n 0.000864 139.5700n 0.000885 139.5800n 0.000899 139.5900n 0.000907 139.6000n 0.000912 139.6100n 0.000916 139.6200n 0.000919 139.6300n 0.000923 139.6400n 0.000930
+ 139.6500n 0.000940 139.6600n 0.000955 139.6700n 0.000975 139.6800n 0.001000 139.6900n 0.001031 139.7000n 0.001066 139.7100n 0.001107 139.7200n 0.001151 139.7300n 0.001198 139.7400n 0.001247 139.7500n 0.001296 139.7600n 0.001343 139.7700n 0.001388 139.7800n 0.001428 139.7900n 0.001461
+ 139.8000n 0.001487 139.8100n 0.001502 139.8200n 0.001507 139.8300n 0.001500 139.8400n 0.001481 139.8500n 0.001447 139.8600n 0.001400 139.8700n 0.001339 139.8800n 0.001264 139.8900n 0.001177 139.9000n 0.001078 139.9100n 0.000969 139.9200n 0.000852 139.9300n 0.000727 139.9400n 0.000599
+ 139.9500n 0.000468 139.9600n 0.000338 139.9700n 0.000211 139.9800n 0.000090 139.9900n -0.000023 140.0000n -0.000125 140.0100n -0.000213 140.0200n -0.000286 140.0300n -0.000341 140.0400n -0.000378 140.0500n -0.000393 140.0600n -0.000388 140.0700n -0.000361 140.0800n -0.000312 140.0900n -0.000241
+ 140.1000n -0.000150 140.1100n -0.000040 140.1200n 0.000088 140.1300n 0.000231 140.1400n 0.000387 140.1500n 0.000554 140.1600n 0.000728 140.1700n 0.000907 140.1800n 0.001086 140.1900n 0.001264 140.2000n 0.001435 140.2100n 0.001598 140.2200n 0.001749 140.2300n 0.001886 140.2400n 0.002005
+ 140.2500n 0.002105 140.2600n 0.002183 140.2700n 0.002238 140.2800n 0.002269 140.2900n 0.002276 140.3000n 0.002258 140.3100n 0.002216 140.3200n 0.002150 140.3300n 0.002062 140.3400n 0.001954 140.3500n 0.001827 140.3600n 0.001685 140.3700n 0.001530 140.3800n 0.001364 140.3900n 0.001192
+ 140.4000n 0.001015 140.4100n 0.000839 140.4200n 0.000664 140.4300n 0.000496 140.4400n 0.000336 140.4500n 0.000187 140.4600n 0.000053 140.4700n -0.000066 140.4800n -0.000168 140.4900n -0.000250 140.5000n -0.000313 140.5100n -0.000357 140.5200n -0.000380 140.5300n -0.000384 140.5400n -0.000370
+ 140.5500n -0.000339 140.5600n -0.000293 140.5700n -0.000234 140.5800n -0.000164 140.5900n -0.000087 140.6000n -0.000004 140.6100n 0.000081 140.6200n 0.000165 140.6300n 0.000245 140.6400n 0.000318 140.6500n 0.000383 140.6600n 0.000435 140.6700n 0.000474 140.6800n 0.000496 140.6900n 0.000501
+ 140.7000n 0.000487 140.7100n 0.000453 140.7200n 0.000399 140.7300n 0.000325 140.7400n 0.000231 140.7500n 0.000119 140.7600n -0.000010 140.7700n -0.000155 140.7800n -0.000314 140.7900n -0.000484 140.8000n -0.000662 140.8100n -0.000847 140.8200n -0.001036 140.8300n -0.001224 140.8400n -0.001410
+ 140.8500n -0.001590 140.8600n -0.001761 140.8700n -0.001922 140.8800n -0.002069 140.8900n -0.002200 140.9000n -0.002314 140.9100n -0.002408 140.9200n -0.002482 140.9300n -0.002535 140.9400n -0.002565 140.9500n -0.002574 140.9600n -0.002561 140.9700n -0.002527 140.9800n -0.002473 140.9900n -0.002400
+ 141.0000n -0.002310 141.0100n -0.002204 141.0200n -0.002086 141.0300n -0.001956 141.0400n -0.001818 141.0500n -0.001673 141.0600n -0.001525 141.0700n -0.001375 141.0800n -0.001225 141.0900n -0.001079 141.1000n -0.000938 141.1100n -0.000803 141.1200n -0.000677 141.1300n -0.000561 141.1400n -0.000455
+ 141.1500n -0.000362 141.1600n -0.000280 141.1700n -0.000210 141.1800n -0.000153 141.1900n -0.000107 141.2000n -0.000073 141.2100n -0.000049 141.2200n -0.000034 141.2300n -0.000027 141.2400n -0.000027 141.2500n -0.000032 141.2600n -0.000040 141.2700n -0.000050 141.2800n -0.000061 141.2900n -0.000070
+ 141.3000n -0.000077 141.3100n -0.000079 141.3200n -0.000076 141.3300n -0.000066 141.3400n -0.000049 141.3500n -0.000024 141.3600n 0.000009 141.3700n 0.000051 141.3800n 0.000102 141.3900n 0.000162 141.4000n 0.000229 141.4100n 0.000304 141.4200n 0.000386 141.4300n 0.000472 141.4400n 0.000563
+ 141.4500n 0.000657 141.4600n 0.000752 141.4700n 0.000847 141.4800n 0.000940 141.4900n 0.001030 141.5000n 0.001114 141.5100n 0.001192 141.5200n 0.001261 141.5300n 0.001320 141.5400n 0.001369 141.5500n 0.001404 141.5600n 0.001427 141.5700n 0.001435 141.5800n 0.001428 141.5900n 0.001405
+ 141.6000n 0.001367 141.6100n 0.001314 141.6200n 0.001245 141.6300n 0.001161 141.6400n 0.001062 141.6500n 0.000951 141.6600n 0.000827 141.6700n 0.000693 141.6800n 0.000549 141.6900n 0.000398 141.7000n 0.000241 141.7100n 0.000080 141.7200n -0.000083 141.7300n -0.000245 141.7400n -0.000406
+ 141.7500n -0.000561 141.7600n -0.000710 141.7700n -0.000850 141.7800n -0.000979 141.7900n -0.001096 141.8000n -0.001198 141.8100n -0.001284 141.8200n -0.001353 141.8300n -0.001403 141.8400n -0.001433 141.8500n -0.001443 141.8600n -0.001432 141.8700n -0.001399 141.8800n -0.001346 141.8900n -0.001273
+ 141.9000n -0.001179 141.9100n -0.001067 141.9200n -0.000936 141.9300n -0.000790 141.9400n -0.000629 141.9500n -0.000456 141.9600n -0.000273 141.9700n -0.000081 141.9800n 0.000115 141.9900n 0.000314 142.0000n 0.000513 142.0100n 0.000709 142.0200n 0.000899 142.0300n 0.001081 142.0400n 0.001252
+ 142.0500n 0.001410 142.0600n 0.001551 142.0700n 0.001675 142.0800n 0.001779 142.0900n 0.001862 142.1000n 0.001922 142.1100n 0.001958 142.1200n 0.001971 142.1300n 0.001960 142.1400n 0.001925 142.1500n 0.001866 142.1600n 0.001786 142.1700n 0.001684 142.1800n 0.001564 142.1900n 0.001427
+ 142.2000n 0.001276 142.2100n 0.001113 142.2200n 0.000942 142.2300n 0.000764 142.2400n 0.000585 142.2500n 0.000407 142.2600n 0.000233 142.2700n 0.000066 142.2800n -0.000090 142.2900n -0.000232 142.3000n -0.000357 142.3100n -0.000464 142.3200n -0.000549 142.3300n -0.000612 142.3400n -0.000651
+ 142.3500n -0.000664 142.3600n -0.000652 142.3700n -0.000615 142.3800n -0.000553 142.3900n -0.000467 142.4000n -0.000360 142.4100n -0.000233 142.4200n -0.000088 142.4300n 0.000072 142.4400n 0.000243 142.4500n 0.000421 142.4600n 0.000604 142.4700n 0.000787 142.4800n 0.000966 142.4900n 0.001138
+ 142.5000n 0.001298 142.5100n 0.001442 142.5200n 0.001567 142.5300n 0.001670 142.5400n 0.001748 142.5500n 0.001798 142.5600n 0.001819 142.5700n 0.001808 142.5800n 0.001766 142.5900n 0.001690 142.6000n 0.001583 142.6100n 0.001444 142.6200n 0.001276 142.6300n 0.001079 142.6400n 0.000858
+ 142.6500n 0.000614 142.6600n 0.000351 142.6700n 0.000074 142.6800n -0.000214 142.6900n -0.000507 142.7000n -0.000802 142.7100n -0.001093 142.7200n -0.001376 142.7300n -0.001647 142.7400n -0.001899 142.7500n -0.002130 142.7600n -0.002335 142.7700n -0.002512 142.7800n -0.002656 142.7900n -0.002765
+ 142.8000n -0.002838 142.8100n -0.002874 142.8200n -0.002871 142.8300n -0.002829 142.8400n -0.002750 142.8500n -0.002635 142.8600n -0.002485 142.8700n -0.002303 142.8800n -0.002092 142.8900n -0.001856 142.9000n -0.001598 142.9100n -0.001323 142.9200n -0.001036 142.9300n -0.000740 142.9400n -0.000441
+ 142.9500n -0.000143 142.9600n 0.000149 142.9700n 0.000430 142.9800n 0.000697 142.9900n 0.000945 143.0000n 0.001171 143.0100n 0.001372 143.0200n 0.001545 143.0300n 0.001689 143.0400n 0.001803 143.0500n 0.001885 143.0600n 0.001935 143.0700n 0.001954 143.0800n 0.001943 143.0900n 0.001903
+ 143.1000n 0.001837 143.1100n 0.001746 143.1200n 0.001634 143.1300n 0.001505 143.1400n 0.001361 143.1500n 0.001206 143.1600n 0.001044 143.1700n 0.000879 143.1800n 0.000714 143.1900n 0.000554 143.2000n 0.000401 143.2100n 0.000259 143.2200n 0.000131 143.2300n 0.000019 143.2400n -0.000075
+ 143.2500n -0.000149 143.2600n -0.000202 143.2700n -0.000233 143.2800n -0.000242 143.2900n -0.000230 143.3000n -0.000198 143.3100n -0.000145 143.3200n -0.000075 143.3300n 0.000011 143.3400n 0.000110 143.3500n 0.000221 143.3600n 0.000339 143.3700n 0.000463 143.3800n 0.000588 143.3900n 0.000713
+ 143.4000n 0.000833 143.4100n 0.000947 143.4200n 0.001050 143.4300n 0.001142 143.4400n 0.001219 143.4500n 0.001279 143.4600n 0.001321 143.4700n 0.001344 143.4800n 0.001346 143.4900n 0.001327 143.5000n 0.001287 143.5100n 0.001226 143.5200n 0.001145 143.5300n 0.001044 143.5400n 0.000926
+ 143.5500n 0.000791 143.5600n 0.000641 143.5700n 0.000479 143.5800n 0.000306 143.5900n 0.000126 143.6000n -0.000059 143.6100n -0.000248 143.6200n -0.000436 143.6300n -0.000623 143.6400n -0.000804 143.6500n -0.000979 143.6600n -0.001144 143.6700n -0.001298 143.6800n -0.001439 143.6900n -0.001566
+ 143.7000n -0.001677 143.7100n -0.001772 143.7200n -0.001848 143.7300n -0.001907 143.7400n -0.001946 143.7500n -0.001968 143.7600n -0.001971 143.7700n -0.001956 143.7800n -0.001924 143.7900n -0.001875 143.8000n -0.001811 143.8100n -0.001733 143.8200n -0.001641 143.8300n -0.001537 143.8400n -0.001423
+ 143.8500n -0.001300 143.8600n -0.001170 143.8700n -0.001034 143.8800n -0.000894 143.8900n -0.000751 143.9000n -0.000607 143.9100n -0.000464 143.9200n -0.000323 143.9300n -0.000185 143.9400n -0.000052 143.9500n 0.000075 143.9600n 0.000195 143.9700n 0.000306 143.9800n 0.000407 143.9900n 0.000497
+ 144.0000n 0.000576 144.0100n 0.000643 144.0200n 0.000696 144.0300n 0.000736 144.0400n 0.000762 144.0500n 0.000773 144.0600n 0.000770 144.0700n 0.000753 144.0800n 0.000721 144.0900n 0.000676 144.1000n 0.000618 144.1100n 0.000547 144.1200n 0.000464 144.1300n 0.000371 144.1400n 0.000269
+ 144.1500n 0.000158 144.1600n 0.000042 144.1700n -0.000079 144.1800n -0.000203 144.1900n -0.000327 144.2000n -0.000450 144.2100n -0.000569 144.2200n -0.000682 144.2300n -0.000788 144.2400n -0.000883 144.2500n -0.000967 144.2600n -0.001036 144.2700n -0.001089 144.2800n -0.001125 144.2900n -0.001142
+ 144.3000n -0.001139 144.3100n -0.001115 144.3200n -0.001069 144.3300n -0.001001 144.3400n -0.000911 144.3500n -0.000800 144.3600n -0.000667 144.3700n -0.000515 144.3800n -0.000344 144.3900n -0.000157 144.4000n 0.000045 144.4100n 0.000259 144.4200n 0.000482 144.4300n 0.000713 144.4400n 0.000947
+ 144.4500n 0.001182 144.4600n 0.001414 144.4700n 0.001641 144.4800n 0.001859 144.4900n 0.002065 144.5000n 0.002256 144.5100n 0.002430 144.5200n 0.002584 144.5300n 0.002715 144.5400n 0.002823 144.5500n 0.002906 144.5600n 0.002962 144.5700n 0.002990 144.5800n 0.002992 144.5900n 0.002966
+ 144.6000n 0.002914 144.6100n 0.002836 144.6200n 0.002734 144.6300n 0.002610 144.6400n 0.002465 144.6500n 0.002303 144.6600n 0.002125 144.6700n 0.001935 144.6800n 0.001735 144.6900n 0.001528 144.7000n 0.001318 144.7100n 0.001107 144.7200n 0.000898 144.7300n 0.000694 144.7400n 0.000496
+ 144.7500n 0.000308 144.7600n 0.000131 144.7700n -0.000034 144.7800n -0.000184 144.7900n -0.000321 144.8000n -0.000442 144.8100n -0.000549 144.8200n -0.000641 144.8300n -0.000719 144.8400n -0.000783 144.8500n -0.000836 144.8600n -0.000878 144.8700n -0.000912 144.8800n -0.000938 144.8900n -0.000959
+ 144.9000n -0.000976 144.9100n -0.000991 144.9200n -0.001006 144.9300n -0.001023 144.9400n -0.001042 144.9500n -0.001064 144.9600n -0.001091 144.9700n -0.001123 144.9800n -0.001160 144.9900n -0.001202 145.0000n -0.001248 145.0100n -0.001297 145.0200n -0.001348 145.0300n -0.001400 145.0400n -0.001450
+ 145.0500n -0.001498 145.0600n -0.001539 145.0700n -0.001573 145.0800n -0.001597 145.0900n -0.001608 145.1000n -0.001605 145.1100n -0.001585 145.1200n -0.001546 145.1300n -0.001486 145.1400n -0.001404 145.1500n -0.001300 145.1600n -0.001172 145.1700n -0.001021 145.1800n -0.000846 145.1900n -0.000649
+ 145.2000n -0.000431 145.2100n -0.000194 145.2200n 0.000061 145.2300n 0.000330 145.2400n 0.000610 145.2500n 0.000898 145.2600n 0.001190 145.2700n 0.001483 145.2800n 0.001771 145.2900n 0.002051 145.3000n 0.002320 145.3100n 0.002572 145.3200n 0.002803 145.3300n 0.003011 145.3400n 0.003192
+ 145.3500n 0.003343 145.3600n 0.003461 145.3700n 0.003544 145.3800n 0.003592 145.3900n 0.003603 145.4000n 0.003577 145.4100n 0.003514 145.4200n 0.003416 145.4300n 0.003283 145.4400n 0.003119 145.4500n 0.002925 145.4600n 0.002706 145.4700n 0.002464 145.4800n 0.002203 145.4900n 0.001929
+ 145.5000n 0.001644 145.5100n 0.001354 145.5200n 0.001063 145.5300n 0.000776 145.5400n 0.000497 145.5500n 0.000229 145.5600n -0.000022 145.5700n -0.000254 145.5800n -0.000464 145.5900n -0.000650 145.6000n -0.000809 145.6100n -0.000939 145.6200n -0.001041 145.6300n -0.001113 145.6400n -0.001157
+ 145.6500n -0.001172 145.6600n -0.001161 145.6700n -0.001125 145.6800n -0.001066 145.6900n -0.000987 145.7000n -0.000891 145.7100n -0.000781 145.7200n -0.000660 145.7300n -0.000531 145.7400n -0.000398 145.7500n -0.000265 145.7600n -0.000133 145.7700n -0.000006 145.7800n 0.000113 145.7900n 0.000222
+ 145.8000n 0.000319 145.8100n 0.000403 145.8200n 0.000473 145.8300n 0.000527 145.8400n 0.000567 145.8500n 0.000591 145.8600n 0.000600 145.8700n 0.000596 145.8800n 0.000580 145.8900n 0.000553 145.9000n 0.000517 145.9100n 0.000475 145.9200n 0.000427 145.9300n 0.000377 145.9400n 0.000326
+ 145.9500n 0.000276 145.9600n 0.000229 145.9700n 0.000188 145.9800n 0.000153 145.9900n 0.000125 146.0000n 0.000106 146.0100n 0.000096 146.0200n 0.000096 146.0300n 0.000104 146.0400n 0.000121 146.0500n 0.000146 146.0600n 0.000177 146.0700n 0.000214 146.0800n 0.000254 146.0900n 0.000297
+ 146.1000n 0.000339 146.1100n 0.000380 146.1200n 0.000416 146.1300n 0.000447 146.1400n 0.000470 146.1500n 0.000484 146.1600n 0.000488 146.1700n 0.000479 146.1800n 0.000459 146.1900n 0.000425 146.2000n 0.000378 146.2100n 0.000318 146.2200n 0.000246 146.2300n 0.000163 146.2400n 0.000070
+ 146.2500n -0.000031 146.2600n -0.000139 146.2700n -0.000250 146.2800n -0.000362 146.2900n -0.000474 146.3000n -0.000582 146.3100n -0.000683 146.3200n -0.000776 146.3300n -0.000857 146.3400n -0.000924 146.3500n -0.000976 146.3600n -0.001010 146.3700n -0.001026 146.3800n -0.001022 146.3900n -0.000998
+ 146.4000n -0.000955 146.4100n -0.000892 146.4200n -0.000811 146.4300n -0.000712 146.4400n -0.000599 146.4500n -0.000474 146.4600n -0.000338 146.4700n -0.000196 146.4800n -0.000050 146.4900n 0.000096 146.5000n 0.000239 146.5100n 0.000374 146.5200n 0.000499 146.5300n 0.000610 146.5400n 0.000703
+ 146.5500n 0.000776 146.5600n 0.000827 146.5700n 0.000852 146.5800n 0.000852 146.5900n 0.000823 146.6000n 0.000767 146.6100n 0.000683 146.6200n 0.000571 146.6300n 0.000433 146.6400n 0.000272 146.6500n 0.000089 146.6600n -0.000113 146.6700n -0.000331 146.6800n -0.000560 146.6900n -0.000796
+ 146.7000n -0.001036 146.7100n -0.001274 146.7200n -0.001506 146.7300n -0.001729 146.7400n -0.001936 146.7500n -0.002125 146.7600n -0.002291 146.7700n -0.002432 146.7800n -0.002544 146.7900n -0.002625 146.8000n -0.002673 146.8100n -0.002687 146.8200n -0.002667 146.8300n -0.002613 146.8400n -0.002526
+ 146.8500n -0.002408 146.8600n -0.002260 146.8700n -0.002086 146.8800n -0.001888 146.8900n -0.001672 146.9000n -0.001440 146.9100n -0.001199 146.9200n -0.000951 146.9300n -0.000703 146.9400n -0.000459 146.9500n -0.000224 146.9600n -0.000002 146.9700n 0.000202 146.9800n 0.000383 146.9900n 0.000539
+ 147.0000n 0.000667 147.0100n 0.000764 147.0200n 0.000828 147.0300n 0.000858 147.0400n 0.000854 147.0500n 0.000816 147.0600n 0.000744 147.0700n 0.000642 147.0800n 0.000510 147.0900n 0.000352 147.1000n 0.000170 147.1100n -0.000030 147.1200n -0.000245 147.1300n -0.000471 147.1400n -0.000702
+ 147.1500n -0.000934 147.1600n -0.001161 147.1700n -0.001380 147.1800n -0.001586 147.1900n -0.001774 147.2000n -0.001940 147.2100n -0.002081 147.2200n -0.002194 147.2300n -0.002276 147.2400n -0.002326 147.2500n -0.002342 147.2600n -0.002324 147.2700n -0.002271 147.2800n -0.002184 147.2900n -0.002065
+ 147.3000n -0.001915 147.3100n -0.001738 147.3200n -0.001535 147.3300n -0.001310 147.3400n -0.001067 147.3500n -0.000809 147.3600n -0.000541 147.3700n -0.000268 147.3800n 0.000007 147.3900n 0.000280 147.4000n 0.000545 147.4100n 0.000800 147.4200n 0.001040 147.4300n 0.001262 147.4400n 0.001463
+ 147.4500n 0.001641 147.4600n 0.001794 147.4700n 0.001919 147.4800n 0.002015 147.4900n 0.002083 147.5000n 0.002121 147.5100n 0.002130 147.5200n 0.002110 147.5300n 0.002063 147.5400n 0.001991 147.5500n 0.001894 147.5600n 0.001775 147.5700n 0.001636 147.5800n 0.001480 147.5900n 0.001309
+ 147.6000n 0.001125 147.6100n 0.000931 147.6200n 0.000730 147.6300n 0.000524 147.6400n 0.000314 147.6500n 0.000104 147.6600n -0.000104 147.6700n -0.000311 147.6800n -0.000513 147.6900n -0.000709 147.7000n -0.000900 147.7100n -0.001084 147.7200n -0.001260 147.7300n -0.001428 147.7400n -0.001589
+ 147.7500n -0.001742 147.7600n -0.001888 147.7700n -0.002026 147.7800n -0.002158 147.7900n -0.002282 147.8000n -0.002401 147.8100n -0.002513 147.8200n -0.002620 147.8300n -0.002721 147.8400n -0.002817 147.8500n -0.002908 147.8600n -0.002993 147.8700n -0.003072 147.8800n -0.003144 147.8900n -0.003210
+ 147.9000n -0.003269 147.9100n -0.003319 147.9200n -0.003361 147.9300n -0.003393 147.9400n -0.003415 147.9500n -0.003426 147.9600n -0.003425 147.9700n -0.003411 147.9800n -0.003383 147.9900n -0.003343 148.0000n -0.003288 148.0100n -0.003218 148.0200n -0.003135 148.0300n -0.003037 148.0400n -0.002926
+ 148.0500n -0.002802 148.0600n -0.002665 148.0700n -0.002517 148.0800n -0.002359 148.0900n -0.002193 148.1000n -0.002019 148.1100n -0.001839 148.1200n -0.001656 148.1300n -0.001470 148.1400n -0.001284 148.1500n -0.001099 148.1600n -0.000918 148.1700n -0.000742 148.1800n -0.000572 148.1900n -0.000410
+ 148.2000n -0.000258 148.2100n -0.000117 148.2200n 0.000013 148.2300n 0.000131 148.2400n 0.000235 148.2500n 0.000326 148.2600n 0.000403 148.2700n 0.000467 148.2800n 0.000518 148.2900n 0.000555 148.3000n 0.000581 148.3100n 0.000596 148.3200n 0.000600 148.3300n 0.000596 148.3400n 0.000583
+ 148.3500n 0.000564 148.3600n 0.000539 148.3700n 0.000510 148.3800n 0.000477 148.3900n 0.000443 148.4000n 0.000409 148.4100n 0.000374 148.4200n 0.000341 148.4300n 0.000310 148.4400n 0.000282 148.4500n 0.000257 148.4600n 0.000236 148.4700n 0.000218 148.4800n 0.000204 148.4900n 0.000195
+ 148.5000n 0.000189 148.5100n 0.000186 148.5200n 0.000187 148.5300n 0.000191 148.5400n 0.000197 148.5500n 0.000204 148.5600n 0.000213 148.5700n 0.000223 148.5800n 0.000233 148.5900n 0.000243 148.6000n 0.000252 148.6100n 0.000260 148.6200n 0.000267 148.6300n 0.000272 148.6400n 0.000276
+ 148.6500n 0.000277 148.6600n 0.000277 148.6700n 0.000274 148.6800n 0.000270 148.6900n 0.000264 148.7000n 0.000256 148.7100n 0.000247 148.7200n 0.000236 148.7300n 0.000225 148.7400n 0.000212 148.7500n 0.000199 148.7600n 0.000186 148.7700n 0.000172 148.7800n 0.000157 148.7900n 0.000142
+ 148.8000n 0.000127 148.8100n 0.000112 148.8200n 0.000096 148.8300n 0.000079 148.8400n 0.000061 148.8500n 0.000043 148.8600n 0.000024 148.8700n 0.000003 148.8800n -0.000020 148.8900n -0.000043 148.9000n -0.000069 148.9100n -0.000096 148.9200n -0.000125 148.9300n -0.000156 148.9400n -0.000187
+ 148.9500n -0.000220 148.9600n -0.000254 148.9700n -0.000287 148.9800n -0.000321 148.9900n -0.000353 149.0000n -0.000384 149.0100n -0.000413 149.0200n -0.000438 149.0300n -0.000460 149.0400n -0.000477 149.0500n -0.000489 149.0600n -0.000494 149.0700n -0.000494 149.0800n -0.000486 149.0900n -0.000471
+ 149.1000n -0.000448 149.1100n -0.000417 149.1200n -0.000379 149.1300n -0.000334 149.1400n -0.000282 149.1500n -0.000223 149.1600n -0.000160 149.1700n -0.000092 149.1800n -0.000021 149.1900n 0.000052 149.2000n 0.000125 149.2100n 0.000197 149.2200n 0.000265 149.2300n 0.000329 149.2400n 0.000387
+ 149.2500n 0.000437 149.2600n 0.000478 149.2700n 0.000508 149.2800n 0.000527 149.2900n 0.000533 149.3000n 0.000525 149.3100n 0.000504 149.3200n 0.000468 149.3300n 0.000419 149.3400n 0.000357 149.3500n 0.000283 149.3600n 0.000197 149.3700n 0.000103 149.3800n 0.000000 149.3900n -0.000107
+ 149.4000n -0.000217 149.4100n -0.000328 149.4200n -0.000436 149.4300n -0.000538 149.4400n -0.000632 149.4500n -0.000714 149.4600n -0.000782 149.4700n -0.000832 149.4800n -0.000862 149.4900n -0.000869 149.5000n -0.000853 149.5100n -0.000810 149.5200n -0.000740 149.5300n -0.000642 149.5400n -0.000515
+ 149.5500n -0.000360 149.5600n -0.000178 149.5700n 0.000029 149.5800n 0.000261 149.5900n 0.000515 149.6000n 0.000787 149.6100n 0.001075 149.6200n 0.001374 149.6300n 0.001680 149.6400n 0.001990 149.6500n 0.002297 149.6600n 0.002598 149.6700n 0.002888 149.6800n 0.003162 149.6900n 0.003416
+ 149.7000n 0.003644 149.7100n 0.003843 149.7200n 0.004009 149.7300n 0.004139 149.7400n 0.004230 149.7500n 0.004280 149.7600n 0.004287 149.7700n 0.004251 149.7800n 0.004171 149.7900n 0.004049 149.8000n 0.003885 149.8100n 0.003681 149.8200n 0.003440 149.8300n 0.003165 149.8400n 0.002860
+ 149.8500n 0.002530 149.8600n 0.002179 149.8700n 0.001812 149.8800n 0.001435 149.8900n 0.001054 149.9000n 0.000673 149.9100n 0.000299 149.9200n -0.000062 149.9300n -0.000407 149.9400n -0.000729 149.9500n -0.001024 149.9600n -0.001289 149.9700n -0.001519 149.9800n -0.001712 149.9900n -0.001866
+ 150.0000n -0.001979 150.0100n -0.002051 150.0200n -0.002081 150.0300n -0.002070 150.0400n -0.002020 150.0500n -0.001933 150.0600n -0.001811 150.0700n -0.001658 150.0800n -0.001477 150.0900n -0.001273 150.1000n -0.001051 150.1100n -0.000814 150.1200n -0.000569 150.1300n -0.000320 150.1400n -0.000071
+ 150.1500n 0.000171 150.1600n 0.000403 150.1700n 0.000620 150.1800n 0.000818 150.1900n 0.000995 150.2000n 0.001146 150.2100n 0.001270 150.2200n 0.001364 150.2300n 0.001428 150.2400n 0.001461 150.2500n 0.001464 150.2600n 0.001436 150.2700n 0.001380 150.2800n 0.001297 150.2900n 0.001190
+ 150.3000n 0.001062 150.3100n 0.000916 150.3200n 0.000755 150.3300n 0.000584 150.3400n 0.000406 150.3500n 0.000226 150.3600n 0.000047 150.3700n -0.000125 150.3800n -0.000289 150.3900n -0.000438 150.4000n -0.000572 150.4100n -0.000686 150.4200n -0.000777 150.4300n -0.000845 150.4400n -0.000887
+ 150.4500n -0.000902 150.4600n -0.000890 150.4700n -0.000850 150.4800n -0.000784 150.4900n -0.000692 150.5000n -0.000575 150.5100n -0.000436 150.5200n -0.000277 150.5300n -0.000100 150.5400n 0.000091 150.5500n 0.000294 150.5600n 0.000505 150.5700n 0.000721 150.5800n 0.000938 150.5900n 0.001153
+ 150.6000n 0.001363 150.6100n 0.001564 150.6200n 0.001754 150.6300n 0.001931 150.6400n 0.002090 150.6500n 0.002232 150.6600n 0.002353 150.6700n 0.002453 150.6800n 0.002531 150.6900n 0.002586 150.7000n 0.002619 150.7100n 0.002629 150.7200n 0.002618 150.7300n 0.002585 150.7400n 0.002534
+ 150.7500n 0.002464 150.7600n 0.002378 150.7700n 0.002278 150.7800n 0.002166 150.7900n 0.002044 150.8000n 0.001914 150.8100n 0.001779 150.8200n 0.001641 150.8300n 0.001503 150.8400n 0.001365 150.8500n 0.001231 150.8600n 0.001102 150.8700n 0.000979 150.8800n 0.000864 150.8900n 0.000758
+ 150.9000n 0.000661 150.9100n 0.000576 150.9200n 0.000501 150.9300n 0.000438 150.9400n 0.000385 150.9500n 0.000344 150.9600n 0.000313 150.9700n 0.000293 150.9800n 0.000281 150.9900n 0.000278 151.0000n 0.000283 151.0100n 0.000295 151.0200n 0.000312 151.0300n 0.000334 151.0400n 0.000360
+ 151.0500n 0.000388 151.0600n 0.000418 151.0700n 0.000449 151.0800n 0.000481 151.0900n 0.000512 151.1000n 0.000542 151.1100n 0.000571 151.1200n 0.000598 151.1300n 0.000623 151.1400n 0.000645 151.1500n 0.000666 151.1600n 0.000684 151.1700n 0.000701 151.1800n 0.000715 151.1900n 0.000728
+ 151.2000n 0.000740 151.2100n 0.000751 151.2200n 0.000761 151.2300n 0.000771 151.2400n 0.000781 151.2500n 0.000792 151.2600n 0.000803 151.2700n 0.000815 151.2800n 0.000827 151.2900n 0.000841 151.3000n 0.000856 151.3100n 0.000872 151.3200n 0.000888 151.3300n 0.000905 151.3400n 0.000922
+ 151.3500n 0.000939 151.3600n 0.000955 151.3700n 0.000970 151.3800n 0.000983 151.3900n 0.000994 151.4000n 0.001001 151.4100n 0.001005 151.4200n 0.001004 151.4300n 0.000997 151.4400n 0.000985 151.4500n 0.000966 151.4600n 0.000940 151.4700n 0.000905 151.4800n 0.000863 151.4900n 0.000812
+ 151.5000n 0.000751 151.5100n 0.000682 151.5200n 0.000603 151.5300n 0.000515 151.5400n 0.000418 151.5500n 0.000312 151.5600n 0.000197 151.5700n 0.000076 151.5800n -0.000053 151.5900n -0.000188 151.6000n -0.000328 151.6100n -0.000472 151.6200n -0.000618 151.6300n -0.000766 151.6400n -0.000914
+ 151.6500n -0.001060 151.6600n -0.001202 151.6700n -0.001340 151.6800n -0.001470 151.6900n -0.001593 151.7000n -0.001706 151.7100n -0.001808 151.7200n -0.001896 151.7300n -0.001971 151.7400n -0.002030 151.7500n -0.002073 151.7600n -0.002098 151.7700n -0.002105 151.7800n -0.002094 151.7900n -0.002064
+ 151.8000n -0.002016 151.8100n -0.001948 151.8200n -0.001863 151.8300n -0.001761 151.8400n -0.001643 151.8500n -0.001509 151.8600n -0.001363 151.8700n -0.001205 151.8800n -0.001037 151.8900n -0.000862 151.9000n -0.000682 151.9100n -0.000499 151.9200n -0.000315 151.9300n -0.000134 151.9400n 0.000042
+ 151.9500n 0.000211 151.9600n 0.000369 151.9700n 0.000516 151.9800n 0.000649 151.9900n 0.000765 152.0000n 0.000863 152.0100n 0.000941 152.0200n 0.000999 152.0300n 0.001036 152.0400n 0.001050 152.0500n 0.001042 152.0600n 0.001011 152.0700n 0.000960 152.0800n 0.000887 152.0900n 0.000795
+ 152.1000n 0.000686 152.1100n 0.000560 152.1200n 0.000421 152.1300n 0.000270 152.1400n 0.000110 152.1500n -0.000055 152.1600n -0.000225 152.1700n -0.000394 152.1800n -0.000562 152.1900n -0.000724 152.2000n -0.000879 152.2100n -0.001023 152.2200n -0.001155 152.2300n -0.001272 152.2400n -0.001373
+ 152.2500n -0.001457 152.2600n -0.001522 152.2700n -0.001568 152.2800n -0.001594 152.2900n -0.001601 152.3000n -0.001590 152.3100n -0.001561 152.3200n -0.001515 152.3300n -0.001455 152.3400n -0.001382 152.3500n -0.001298 152.3600n -0.001207 152.3700n -0.001110 152.3800n -0.001010 152.3900n -0.000910
+ 152.4000n -0.000812 152.4100n -0.000720 152.4200n -0.000635 152.4300n -0.000560 152.4400n -0.000498 152.4500n -0.000449 152.4600n -0.000415 152.4700n -0.000397 152.4800n -0.000396 152.4900n -0.000412 152.5000n -0.000444 152.5100n -0.000492 152.5200n -0.000554 152.5300n -0.000630 152.5400n -0.000717
+ 152.5500n -0.000813 152.5600n -0.000916 152.5700n -0.001022 152.5800n -0.001129 152.5900n -0.001233 152.6000n -0.001331 152.6100n -0.001421 152.6200n -0.001499 152.6300n -0.001562 152.6400n -0.001609 152.6500n -0.001635 152.6600n -0.001640 152.6700n -0.001621 152.6800n -0.001578 152.6900n -0.001510
+ 152.7000n -0.001416 152.7100n -0.001298 152.7200n -0.001155 152.7300n -0.000990 152.7400n -0.000803 152.7500n -0.000598 152.7600n -0.000377 152.7700n -0.000143 152.7800n 0.000100 152.7900n 0.000349 152.8000n 0.000600 152.8100n 0.000849 152.8200n 0.001092 152.8300n 0.001325 152.8400n 0.001544
+ 152.8500n 0.001746 152.8600n 0.001926 152.8700n 0.002084 152.8800n 0.002215 152.8900n 0.002317 152.9000n 0.002390 152.9100n 0.002432 152.9200n 0.002443 152.9300n 0.002422 152.9400n 0.002371 152.9500n 0.002291 152.9600n 0.002183 152.9700n 0.002050 152.9800n 0.001895 152.9900n 0.001721
+ 153.0000n 0.001532 153.0100n 0.001330 153.0200n 0.001121 153.0300n 0.000909 153.0400n 0.000697 153.0500n 0.000489 153.0600n 0.000291 153.0700n 0.000105 153.0800n -0.000065 153.0900n -0.000216 153.1000n -0.000345 153.1100n -0.000449 153.1200n -0.000528 153.1300n -0.000580 153.1400n -0.000603
+ 153.1500n -0.000599 153.1600n -0.000568 153.1700n -0.000509 153.1800n -0.000426 153.1900n -0.000321 153.2000n -0.000194 153.2100n -0.000050 153.2200n 0.000108 153.2300n 0.000277 153.2400n 0.000454 153.2500n 0.000634 153.2600n 0.000814 153.2700n 0.000991 153.2800n 0.001160 153.2900n 0.001318
+ 153.3000n 0.001463 153.3100n 0.001591 153.3200n 0.001700 153.3300n 0.001788 153.3400n 0.001854 153.3500n 0.001897 153.3600n 0.001915 153.3700n 0.001909 153.3800n 0.001880 153.3900n 0.001827 153.4000n 0.001754 153.4100n 0.001660 153.4200n 0.001549 153.4300n 0.001423 153.4400n 0.001284
+ 153.4500n 0.001135 153.4600n 0.000980 153.4700n 0.000821 153.4800n 0.000661 153.4900n 0.000503 153.5000n 0.000350 153.5100n 0.000205 153.5200n 0.000069 153.5300n -0.000054 153.5400n -0.000164 153.5500n -0.000259 153.5600n -0.000337 153.5700n -0.000398 153.5800n -0.000442 153.5900n -0.000469
+ 153.6000n -0.000480 153.6100n -0.000474 153.6200n -0.000454 153.6300n -0.000421 153.6400n -0.000375 153.6500n -0.000320 153.6600n -0.000257 153.6700n -0.000187 153.6800n -0.000114 153.6900n -0.000039 153.7000n 0.000037 153.7100n 0.000110 153.7200n 0.000179 153.7300n 0.000244 153.7400n 0.000302
+ 153.7500n 0.000352 153.7600n 0.000393 153.7700n 0.000426 153.7800n 0.000449 153.7900n 0.000462 153.8000n 0.000466 153.8100n 0.000461 153.8200n 0.000447 153.8300n 0.000426 153.8400n 0.000398 153.8500n 0.000365 153.8600n 0.000326 153.8700n 0.000285 153.8800n 0.000241 153.8900n 0.000196
+ 153.9000n 0.000150 153.9100n 0.000106 153.9200n 0.000062 153.9300n 0.000022 153.9400n -0.000017 153.9500n -0.000052 153.9600n -0.000084 153.9700n -0.000113 153.9800n -0.000140 153.9900n -0.000164 154.0000n -0.000187 154.0100n -0.000208 154.0200n -0.000230 154.0300n -0.000252 154.0400n -0.000276
+ 154.0500n -0.000303 154.0600n -0.000333 154.0700n -0.000368 154.0800n -0.000409 154.0900n -0.000455 154.1000n -0.000508 154.1100n -0.000567 154.1200n -0.000634 154.1300n -0.000708 154.1400n -0.000788 154.1500n -0.000875 154.1600n -0.000967 154.1700n -0.001063 154.1800n -0.001163 154.1900n -0.001266
+ 154.2000n -0.001368 154.2100n -0.001471 154.2200n -0.001570 154.2300n -0.001666 154.2400n -0.001755 154.2500n -0.001837 154.2600n -0.001910 154.2700n -0.001973 154.2800n -0.002023 154.2900n -0.002060 154.3000n -0.002083 154.3100n -0.002092 154.3200n -0.002084 154.3300n -0.002062 154.3400n -0.002023
+ 154.3500n -0.001970 154.3600n -0.001901 154.3700n -0.001819 154.3800n -0.001724 154.3900n -0.001618 154.4000n -0.001502 154.4100n -0.001377 154.4200n -0.001246 154.4300n -0.001110 154.4400n -0.000971 154.4500n -0.000831 154.4600n -0.000693 154.4700n -0.000557 154.4800n -0.000425 154.4900n -0.000300
+ 154.5000n -0.000182 154.5100n -0.000073 154.5200n 0.000026 154.5300n 0.000116 154.5400n 0.000194 154.5500n 0.000262 154.5600n 0.000318 154.5700n 0.000363 154.5800n 0.000398 154.5900n 0.000423 154.6000n 0.000439 154.6100n 0.000447 154.6200n 0.000448 154.6300n 0.000442 154.6400n 0.000432
+ 154.6500n 0.000417 154.6600n 0.000399 154.6700n 0.000379 154.6800n 0.000358 154.6900n 0.000336 154.7000n 0.000313 154.7100n 0.000291 154.7200n 0.000269 154.7300n 0.000247 154.7400n 0.000225 154.7500n 0.000202 154.7600n 0.000177 154.7700n 0.000150 154.7800n 0.000119 154.7900n 0.000084
+ 154.8000n 0.000043 154.8100n -0.000005 154.8200n -0.000061 154.8300n -0.000127 154.8400n -0.000203 154.8500n -0.000291 154.8600n -0.000391 154.8700n -0.000504 154.8800n -0.000630 154.8900n -0.000769 154.9000n -0.000921 154.9100n -0.001086 154.9200n -0.001262 154.9300n -0.001448 154.9400n -0.001643
+ 154.9500n -0.001845 154.9600n -0.002052 154.9700n -0.002261 154.9800n -0.002470 154.9900n -0.002675 155.0000n -0.002875 155.0100n -0.003066 155.0200n -0.003244 155.0300n -0.003408 155.0400n -0.003554 155.0500n -0.003680 155.0600n -0.003782 155.0700n -0.003860 155.0800n -0.003910 155.0900n -0.003932
+ 155.1000n -0.003924 155.1100n -0.003886 155.1200n -0.003817 155.1300n -0.003718 155.1400n -0.003589 155.1500n -0.003432 155.1600n -0.003248 155.1700n -0.003040 155.1800n -0.002810 155.1900n -0.002560 155.2000n -0.002294 155.2100n -0.002016 155.2200n -0.001728 155.2300n -0.001435 155.2400n -0.001140
+ 155.2500n -0.000847 155.2600n -0.000561 155.2700n -0.000283 155.2800n -0.000018 155.2900n 0.000231 155.3000n 0.000462 155.3100n 0.000672 155.3200n 0.000859 155.3300n 0.001022 155.3400n 0.001159 155.3500n 0.001271 155.3600n 0.001357 155.3700n 0.001417 155.3800n 0.001452 155.3900n 0.001463
+ 155.4000n 0.001453 155.4100n 0.001423 155.4200n 0.001375 155.4300n 0.001312 155.4400n 0.001236 155.4500n 0.001151 155.4600n 0.001058 155.4700n 0.000962 155.4800n 0.000865 155.4900n 0.000769 155.5000n 0.000677 155.5100n 0.000591 155.5200n 0.000514 155.5300n 0.000446 155.5400n 0.000389
+ 155.5500n 0.000343 155.5600n 0.000310 155.5700n 0.000289 155.5800n 0.000281 155.5900n 0.000284 155.6000n 0.000297 155.6100n 0.000319 155.6200n 0.000349 155.6300n 0.000384 155.6400n 0.000423 155.6500n 0.000464 155.6600n 0.000504 155.6700n 0.000542 155.6800n 0.000574 155.6900n 0.000600
+ 155.7000n 0.000616 155.7100n 0.000622 155.7200n 0.000616 155.7300n 0.000597 155.7400n 0.000565 155.7500n 0.000518 155.7600n 0.000456 155.7700n 0.000381 155.7800n 0.000292 155.7900n 0.000192 155.8000n 0.000080 155.8100n -0.000041 155.8200n -0.000169 155.8300n -0.000303 155.8400n -0.000438
+ 155.8500n -0.000574 155.8600n -0.000707 155.8700n -0.000834 155.8800n -0.000953 155.8900n -0.001062 155.9000n -0.001157 155.9100n -0.001236 155.9200n -0.001298 155.9300n -0.001340 155.9400n -0.001362 155.9500n -0.001361 155.9600n -0.001337 155.9700n -0.001291 155.9800n -0.001221 155.9900n -0.001129
+ 156.0000n -0.001014 156.0100n -0.000880 156.0200n -0.000726 156.0300n -0.000555 156.0400n -0.000369 156.0500n -0.000171 156.0600n 0.000036 156.0700n 0.000250 156.0800n 0.000469 156.0900n 0.000688 156.1000n 0.000904 156.1100n 0.001116 156.1200n 0.001319 156.1300n 0.001512 156.1400n 0.001691
+ 156.1500n 0.001854 156.1600n 0.002000 156.1700n 0.002127 156.1800n 0.002233 156.1900n 0.002317 156.2000n 0.002378 156.2100n 0.002417 156.2200n 0.002433 156.2300n 0.002427 156.2400n 0.002399 156.2500n 0.002350 156.2600n 0.002281 156.2700n 0.002195 156.2800n 0.002092 156.2900n 0.001976
+ 156.3000n 0.001846 156.3100n 0.001707 156.3200n 0.001560 156.3300n 0.001407 156.3400n 0.001251 156.3500n 0.001094 156.3600n 0.000937 156.3700n 0.000783 156.3800n 0.000633 156.3900n 0.000490 156.4000n 0.000353 156.4100n 0.000226 156.4200n 0.000108 156.4300n 0.000001 156.4400n -0.000095
+ 156.4500n -0.000180 156.4600n -0.000253 156.4700n -0.000315 156.4800n -0.000365 156.4900n -0.000405 156.5000n -0.000435 156.5100n -0.000455 156.5200n -0.000466 156.5300n -0.000470 156.5400n -0.000467 156.5500n -0.000457 156.5600n -0.000443 156.5700n -0.000425 156.5800n -0.000404 156.5900n -0.000381
+ 156.6000n -0.000357 156.6100n -0.000333 156.6200n -0.000309 156.6300n -0.000285 156.6400n -0.000264 156.6500n -0.000244 156.6600n -0.000226 156.6700n -0.000211 156.6800n -0.000199 156.6900n -0.000189 156.7000n -0.000182 156.7100n -0.000177 156.7200n -0.000175 156.7300n -0.000174 156.7400n -0.000175
+ 156.7500n -0.000178 156.7600n -0.000181 156.7700n -0.000185 156.7800n -0.000189 156.7900n -0.000193 156.8000n -0.000196 156.8100n -0.000199 156.8200n -0.000199 156.8300n -0.000198 156.8400n -0.000196 156.8500n -0.000190 156.8600n -0.000183 156.8700n -0.000173 156.8800n -0.000160 156.8900n -0.000145
+ 156.9000n -0.000127 156.9100n -0.000107 156.9200n -0.000084 156.9300n -0.000060 156.9400n -0.000034 156.9500n -0.000007 156.9600n 0.000022 156.9700n 0.000050 156.9800n 0.000079 156.9900n 0.000106 157.0000n 0.000133 157.0100n 0.000157 157.0200n 0.000179 157.0300n 0.000198 157.0400n 0.000213
+ 157.0500n 0.000223 157.0600n 0.000229 157.0700n 0.000229 157.0800n 0.000223 157.0900n 0.000211 157.1000n 0.000192 157.1100n 0.000166 157.1200n 0.000133 157.1300n 0.000093 157.1400n 0.000045 157.1500n -0.000009 157.1600n -0.000070 157.1700n -0.000137 157.1800n -0.000209 157.1900n -0.000287
+ 157.2000n -0.000368 157.2100n -0.000452 157.2200n -0.000538 157.2300n -0.000625 157.2400n -0.000711 157.2500n -0.000796 157.2600n -0.000877 157.2700n -0.000954 157.2800n -0.001024 157.2900n -0.001088 157.3000n -0.001142 157.3100n -0.001187 157.3200n -0.001221 157.3300n -0.001242 157.3400n -0.001251
+ 157.3500n -0.001247 157.3600n -0.001228 157.3700n -0.001195 157.3800n -0.001148 157.3900n -0.001088 157.4000n -0.001014 157.4100n -0.000927 157.4200n -0.000829 157.4300n -0.000720 157.4400n -0.000603 157.4500n -0.000479 157.4600n -0.000349 157.4700n -0.000217 157.4800n -0.000083 157.4900n 0.000048
+ 157.5000n 0.000177 157.5100n 0.000299 157.5200n 0.000412 157.5300n 0.000515 157.5400n 0.000605 157.5500n 0.000680 157.5600n 0.000739 157.5700n 0.000780 157.5800n 0.000801 157.5900n 0.000802 157.6000n 0.000782 157.6100n 0.000741 157.6200n 0.000680 157.6300n 0.000598 157.6400n 0.000497
+ 157.6500n 0.000379 157.6600n 0.000244 157.6700n 0.000095 157.6800n -0.000065 157.6900n -0.000234 157.7000n -0.000409 157.7100n -0.000587 157.7200n -0.000764 157.7300n -0.000938 157.7400n -0.001104 157.7500n -0.001259 157.7600n -0.001400 157.7700n -0.001524 157.7800n -0.001628 157.7900n -0.001709
+ 157.8000n -0.001765 157.8100n -0.001794 157.8200n -0.001795 157.8300n -0.001766 157.8400n -0.001706 157.8500n -0.001615 157.8600n -0.001495 157.8700n -0.001344 157.8800n -0.001166 157.8900n -0.000961 157.9000n -0.000732 157.9100n -0.000481 157.9200n -0.000212 157.9300n 0.000073 157.9400n 0.000370
+ 157.9500n 0.000676 157.9600n 0.000986 157.9700n 0.001296 157.9800n 0.001603 157.9900n 0.001903 158.0000n 0.002192 158.0100n 0.002467 158.0200n 0.002724 158.0300n 0.002961 158.0400n 0.003176 158.0500n 0.003365 158.0600n 0.003527 158.0700n 0.003662 158.0800n 0.003767 158.0900n 0.003844
+ 158.1000n 0.003891 158.1100n 0.003910 158.1200n 0.003902 158.1300n 0.003867 158.1400n 0.003809 158.1500n 0.003728 158.1600n 0.003627 158.1700n 0.003509 158.1800n 0.003377 158.1900n 0.003233 158.2000n 0.003080 158.2100n 0.002921 158.2200n 0.002759 158.2300n 0.002596 158.2400n 0.002435
+ 158.2500n 0.002278 158.2600n 0.002127 158.2700n 0.001984 158.2800n 0.001849 158.2900n 0.001724 158.3000n 0.001609 158.3100n 0.001505 158.3200n 0.001411 158.3300n 0.001328 158.3400n 0.001254 158.3500n 0.001188 158.3600n 0.001129 158.3700n 0.001077 158.3800n 0.001028 158.3900n 0.000982
+ 158.4000n 0.000937 158.4100n 0.000891 158.4200n 0.000843 158.4300n 0.000790 158.4400n 0.000732 158.4500n 0.000667 158.4600n 0.000594 158.4700n 0.000513 158.4800n 0.000422 158.4900n 0.000322 158.5000n 0.000213 158.5100n 0.000094 158.5200n -0.000032 158.5300n -0.000166 158.5400n -0.000306
+ 158.5500n -0.000451 158.5600n -0.000599 158.5700n -0.000748 158.5800n -0.000896 158.5900n -0.001041 158.6000n -0.001181 158.6100n -0.001314 158.6200n -0.001437 158.6300n -0.001550 158.6400n -0.001649 158.6500n -0.001733 158.6600n -0.001801 158.6700n -0.001851 158.6800n -0.001883 158.6900n -0.001896
+ 158.7000n -0.001889 158.7100n -0.001863 158.7200n -0.001818 158.7300n -0.001754 158.7400n -0.001672 158.7500n -0.001574 158.7600n -0.001460 158.7700n -0.001334 158.7800n -0.001196 158.7900n -0.001049 158.8000n -0.000895 158.8100n -0.000736 158.8200n -0.000575 158.8300n -0.000414 158.8400n -0.000256
+ 158.8500n -0.000103 158.8600n 0.000044 158.8700n 0.000181 158.8800n 0.000308 158.8900n 0.000422 158.9000n 0.000522 158.9100n 0.000607 158.9200n 0.000676 158.9300n 0.000728 158.9400n 0.000763 158.9500n 0.000782 158.9600n 0.000783 158.9700n 0.000768 158.9800n 0.000738 158.9900n 0.000692
+ 159.0000n 0.000633 159.0100n 0.000562 159.0200n 0.000480 159.0300n 0.000389 159.0400n 0.000291 159.0500n 0.000186 159.0600n 0.000078 159.0700n -0.000032 159.0800n -0.000142 159.0900n -0.000251 159.1000n -0.000357 159.1100n -0.000457 159.1200n -0.000551 159.1300n -0.000637 159.1400n -0.000714
+ 159.1500n -0.000780 159.1600n -0.000834 159.1700n -0.000877 159.1800n -0.000906 159.1900n -0.000921 159.2000n -0.000923 159.2100n -0.000910 159.2200n -0.000883 159.2300n -0.000841 159.2400n -0.000786 159.2500n -0.000716 159.2600n -0.000634 159.2700n -0.000539 159.2800n -0.000432 159.2900n -0.000315
+ 159.3000n -0.000188 159.3100n -0.000052 159.3200n 0.000090 159.3300n 0.000238 159.3400n 0.000391 159.3500n 0.000546 159.3600n 0.000702 159.3700n 0.000857 159.3800n 0.001009 159.3900n 0.001157 159.4000n 0.001299 159.4100n 0.001432 159.4200n 0.001555 159.4300n 0.001666 159.4400n 0.001763
+ 159.4500n 0.001845 159.4600n 0.001910 159.4700n 0.001956 159.4800n 0.001982 159.4900n 0.001988 159.5000n 0.001972 159.5100n 0.001933 159.5200n 0.001872 159.5300n 0.001788 159.5400n 0.001682 159.5500n 0.001553 159.5600n 0.001403 159.5700n 0.001232 159.5800n 0.001044 159.5900n 0.000838
+ 159.6000n 0.000617 159.6100n 0.000384 159.6200n 0.000142 159.6300n -0.000108 159.6400n -0.000362 159.6500n -0.000616 159.6600n -0.000867 159.6700n -0.001113 159.6800n -0.001349 159.6900n -0.001572 159.7000n -0.001780 159.7100n -0.001968 159.7200n -0.002135 159.7300n -0.002277 159.7400n -0.002392
+ 159.7500n -0.002479 159.7600n -0.002536 159.7700n -0.002561 159.7800n -0.002555 159.7900n -0.002517 159.8000n -0.002447 159.8100n -0.002347 159.8200n -0.002218 159.8300n -0.002062 159.8400n -0.001881 159.8500n -0.001678 159.8600n -0.001456 159.8700n -0.001218 159.8800n -0.000970 159.8900n -0.000713
+ 159.9000n -0.000454 159.9100n -0.000195 159.9200n 0.000059 159.9300n 0.000303 159.9400n 0.000534 159.9500n 0.000748 159.9600n 0.000941 159.9700n 0.001110 159.9800n 0.001253 159.9900n 0.001367 160.0000n 0.001450 160.0100n 0.001501 160.0200n 0.001519 160.0300n 0.001505 160.0400n 0.001459
+ 160.0500n 0.001381 160.0600n 0.001274 160.0700n 0.001139 160.0800n 0.000979 160.0900n 0.000798 160.1000n 0.000597 160.1100n 0.000382 160.1200n 0.000156 160.1300n -0.000077 160.1400n -0.000312 160.1500n -0.000546 160.1600n -0.000774 160.1700n -0.000993 160.1800n -0.001198 160.1900n -0.001386
+ 160.2000n -0.001554 160.2100n -0.001699 160.2200n -0.001819 160.2300n -0.001912 160.2400n -0.001977 160.2500n -0.002013 160.2600n -0.002020 160.2700n -0.001998 160.2800n -0.001947 160.2900n -0.001869 160.3000n -0.001766 160.3100n -0.001640 160.3200n -0.001493 160.3300n -0.001327 160.3400n -0.001146
+ 160.3500n -0.000952 160.3600n -0.000750 160.3700n -0.000541 160.3800n -0.000329 160.3900n -0.000117 160.4000n 0.000091 160.4100n 0.000295 160.4200n 0.000490 160.4300n 0.000676 160.4400n 0.000850 160.4500n 0.001012 160.4600n 0.001159 160.4700n 0.001292 160.4800n 0.001410 160.4900n 0.001514
+ 160.5000n 0.001603 160.5100n 0.001680 160.5200n 0.001743 160.5300n 0.001796 160.5400n 0.001839 160.5500n 0.001874 160.5600n 0.001902 160.5700n 0.001926 160.5800n 0.001946 160.5900n 0.001964 160.6000n 0.001982 160.6100n 0.002001 160.6200n 0.002021 160.6300n 0.002044 160.6400n 0.002070
+ 160.6500n 0.002100 160.6600n 0.002133 160.6700n 0.002169 160.6800n 0.002208 160.6900n 0.002248 160.7000n 0.002290 160.7100n 0.002331 160.7200n 0.002370 160.7300n 0.002406 160.7400n 0.002438 160.7500n 0.002463 160.7600n 0.002481 160.7700n 0.002491 160.7800n 0.002490 160.7900n 0.002477
+ 160.8000n 0.002453 160.8100n 0.002416 160.8200n 0.002365 160.8300n 0.002302 160.8400n 0.002225 160.8500n 0.002135 160.8600n 0.002034 160.8700n 0.001922 160.8800n 0.001800 160.8900n 0.001670 160.9000n 0.001534 160.9100n 0.001394 160.9200n 0.001251 160.9300n 0.001108 160.9400n 0.000967
+ 160.9500n 0.000829 160.9600n 0.000698 160.9700n 0.000573 160.9800n 0.000458 160.9900n 0.000353 161.0000n 0.000260 161.0100n 0.000180 161.0200n 0.000112 161.0300n 0.000057 161.0400n 0.000016 161.0500n -0.000013 161.0600n -0.000031 161.0700n -0.000039 161.0800n -0.000037 161.0900n -0.000029
+ 161.1000n -0.000015 161.1100n 0.000003 161.1200n 0.000021 161.1300n 0.000038 161.1400n 0.000051 161.1500n 0.000059 161.1600n 0.000060 161.1700n 0.000051 161.1800n 0.000032 161.1900n -0.000000 161.2000n -0.000046 161.2100n -0.000105 161.2200n -0.000178 161.2300n -0.000265 161.2400n -0.000365
+ 161.2500n -0.000478 161.2600n -0.000602 161.2700n -0.000735 161.2800n -0.000876 161.2900n -0.001022 161.3000n -0.001170 161.3100n -0.001318 161.3200n -0.001463 161.3300n -0.001603 161.3400n -0.001734 161.3500n -0.001853 161.3600n -0.001958 161.3700n -0.002048 161.3800n -0.002119 161.3900n -0.002169
+ 161.4000n -0.002199 161.4100n -0.002206 161.4200n -0.002191 161.4300n -0.002153 161.4400n -0.002093 161.4500n -0.002013 161.4600n -0.001913 161.4700n -0.001796 161.4800n -0.001664 161.4900n -0.001520 161.5000n -0.001366 161.5100n -0.001208 161.5200n -0.001047 161.5300n -0.000887 161.5400n -0.000733
+ 161.5500n -0.000588 161.5600n -0.000455 161.5700n -0.000337 161.5800n -0.000238 161.5900n -0.000159 161.6000n -0.000104 161.6100n -0.000074 161.6200n -0.000070 161.6300n -0.000092 161.6400n -0.000141 161.6500n -0.000216 161.6600n -0.000316 161.6700n -0.000439 161.6800n -0.000583 161.6900n -0.000746
+ 161.7000n -0.000924 161.7100n -0.001114 161.7200n -0.001311 161.7300n -0.001513 161.7400n -0.001715 161.7500n -0.001912 161.7600n -0.002101 161.7700n -0.002277 161.7800n -0.002438 161.7900n -0.002578 161.8000n -0.002696 161.8100n -0.002788 161.8200n -0.002852 161.8300n -0.002886 161.8400n -0.002890
+ 161.8500n -0.002863 161.8600n -0.002805 161.8700n -0.002717 161.8800n -0.002600 161.8900n -0.002455 161.9000n -0.002286 161.9100n -0.002094 161.9200n -0.001883 161.9300n -0.001657 161.9400n -0.001419 161.9500n -0.001174 161.9600n -0.000924 161.9700n -0.000675 161.9800n -0.000430 161.9900n -0.000192
+ 162.0000n 0.000034 162.0100n 0.000246 162.0200n 0.000440 162.0300n 0.000615 162.0400n 0.000768 162.0500n 0.000899 162.0600n 0.001005 162.0700n 0.001088 162.0800n 0.001147 162.0900n 0.001182 162.1000n 0.001196 162.1100n 0.001189 162.1200n 0.001164 162.1300n 0.001122 162.1400n 0.001067
+ 162.1500n 0.001002 162.1600n 0.000928 162.1700n 0.000849 162.1800n 0.000769 162.1900n 0.000689 162.2000n 0.000612 162.2100n 0.000541 162.2200n 0.000478 162.2300n 0.000424 162.2400n 0.000382 162.2500n 0.000351 162.2600n 0.000333 162.2700n 0.000327 162.2800n 0.000333 162.2900n 0.000351
+ 162.3000n 0.000379 162.3100n 0.000416 162.3200n 0.000460 162.3300n 0.000509 162.3400n 0.000561 162.3500n 0.000614 162.3600n 0.000665 162.3700n 0.000712 162.3800n 0.000753 162.3900n 0.000785 162.4000n 0.000807 162.4100n 0.000817 162.4200n 0.000813 162.4300n 0.000796 162.4400n 0.000763
+ 162.4500n 0.000716 162.4600n 0.000654 162.4700n 0.000577 162.4800n 0.000488 162.4900n 0.000387 162.5000n 0.000276 162.5100n 0.000157 162.5200n 0.000033 162.5300n -0.000094 162.5400n -0.000221 162.5500n -0.000346 162.5600n -0.000466 162.5700n -0.000578 162.5800n -0.000679 162.5900n -0.000768
+ 162.6000n -0.000843 162.6100n -0.000901 162.6200n -0.000941 162.6300n -0.000963 162.6400n -0.000966 162.6500n -0.000951 162.6600n -0.000916 162.6700n -0.000865 162.6800n -0.000797 162.6900n -0.000715 162.7000n -0.000620 162.7100n -0.000517 162.7200n -0.000406 162.7300n -0.000291 162.7400n -0.000176
+ 162.7500n -0.000063 162.7600n 0.000045 162.7700n 0.000143 162.7800n 0.000231 162.7900n 0.000304 162.8000n 0.000360 162.8100n 0.000398 162.8200n 0.000416 162.8300n 0.000412 162.8400n 0.000386 162.8500n 0.000339 162.8600n 0.000269 162.8700n 0.000179 162.8800n 0.000069 162.8900n -0.000058
+ 162.9000n -0.000201 162.9100n -0.000356 162.9200n -0.000521 162.9300n -0.000693 162.9400n -0.000867 162.9500n -0.001041 162.9600n -0.001211 162.9700n -0.001373 162.9800n -0.001525 162.9900n -0.001662 163.0000n -0.001783 163.0100n -0.001885 163.0200n -0.001965 163.0300n -0.002023 163.0400n -0.002057
+ 163.0500n -0.002066 163.0600n -0.002052 163.0700n -0.002013 163.0800n -0.001952 163.0900n -0.001869 163.1000n -0.001768 163.1100n -0.001650 163.1200n -0.001518 163.1300n -0.001375 163.1400n -0.001225 163.1500n -0.001071 163.1600n -0.000917 163.1700n -0.000765 163.1800n -0.000620 163.1900n -0.000485
+ 163.2000n -0.000361 163.2100n -0.000253 163.2200n -0.000162 163.2300n -0.000090 163.2400n -0.000038 163.2500n -0.000006 163.2600n 0.000005 163.2700n -0.000005 163.2800n -0.000034 163.2900n -0.000081 163.3000n -0.000143 163.3100n -0.000220 163.3200n -0.000307 163.3300n -0.000402 163.3400n -0.000501
+ 163.3500n -0.000602 163.3600n -0.000700 163.3700n -0.000792 163.3800n -0.000875 163.3900n -0.000946 163.4000n -0.001001 163.4100n -0.001039 163.4200n -0.001057 163.4300n -0.001053 163.4400n -0.001026 163.4500n -0.000976 163.4600n -0.000904 163.4700n -0.000808 163.4800n -0.000691 163.4900n -0.000554
+ 163.5000n -0.000399 163.5100n -0.000230 163.5200n -0.000048 163.5300n 0.000142 163.5400n 0.000337 163.5500n 0.000532 163.5600n 0.000725 163.5700n 0.000911 163.5800n 0.001086 163.5900n 0.001247 163.6000n 0.001390 163.6100n 0.001513 163.6200n 0.001612 163.6300n 0.001686 163.6400n 0.001734
+ 163.6500n 0.001754 163.6600n 0.001745 163.6700n 0.001710 163.6800n 0.001647 163.6900n 0.001560 163.7000n 0.001450 163.7100n 0.001319 163.7200n 0.001172 163.7300n 0.001012 163.7400n 0.000842 163.7500n 0.000666 163.7600n 0.000491 163.7700n 0.000318 163.7800n 0.000154 163.7900n 0.000002
+ 163.8000n -0.000135 163.8100n -0.000251 163.8200n -0.000344 163.8300n -0.000412 163.8400n -0.000452 163.8500n -0.000462 163.8600n -0.000443 163.8700n -0.000392 163.8800n -0.000312 163.8900n -0.000203 163.9000n -0.000067 163.9100n 0.000093 163.9200n 0.000275 163.9300n 0.000475 163.9400n 0.000688
+ 163.9500n 0.000910 163.9600n 0.001137 163.9700n 0.001363 163.9800n 0.001584 163.9900n 0.001795 164.0000n 0.001990 164.0100n 0.002166 164.0200n 0.002318 164.0300n 0.002442 164.0400n 0.002536 164.0500n 0.002595 164.0600n 0.002619 164.0700n 0.002606 164.0800n 0.002555 164.0900n 0.002466
+ 164.1000n 0.002341 164.1100n 0.002180 164.1200n 0.001986 164.1300n 0.001761 164.1400n 0.001510 164.1500n 0.001235 164.1600n 0.000942 164.1700n 0.000635 164.1800n 0.000319 164.1900n -0.000002 164.2000n -0.000320 164.2100n -0.000633 164.2200n -0.000934 164.2300n -0.001220 164.2400n -0.001485
+ 164.2500n -0.001726 164.2600n -0.001940 164.2700n -0.002123 164.2800n -0.002274 164.2900n -0.002391 164.3000n -0.002473 164.3100n -0.002520 164.3200n -0.002532 164.3300n -0.002510 164.3400n -0.002457 164.3500n -0.002374 164.3600n -0.002264 164.3700n -0.002131 164.3800n -0.001978 164.3900n -0.001809
+ 164.4000n -0.001629 164.4100n -0.001440 164.4200n -0.001248 164.4300n -0.001056 164.4400n -0.000870 164.4500n -0.000691 164.4600n -0.000524 164.4700n -0.000372 164.4800n -0.000237 164.4900n -0.000121 164.5000n -0.000027 164.5100n 0.000046 164.5200n 0.000096 164.5300n 0.000124 164.5400n 0.000129
+ 164.5500n 0.000115 164.5600n 0.000081 164.5700n 0.000029 164.5800n -0.000037 164.5900n -0.000115 164.6000n -0.000202 164.6100n -0.000296 164.6200n -0.000393 164.6300n -0.000490 164.6400n -0.000584 164.6500n -0.000672 164.6600n -0.000751 164.6700n -0.000819 164.6800n -0.000873 164.6900n -0.000912
+ 164.7000n -0.000934 164.7100n -0.000938 164.7200n -0.000923 164.7300n -0.000890 164.7400n -0.000838 164.7500n -0.000769 164.7600n -0.000682 164.7700n -0.000580 164.7800n -0.000464 164.7900n -0.000336 164.8000n -0.000198 164.8100n -0.000052 164.8200n 0.000098 164.8300n 0.000251 164.8400n 0.000404
+ 164.8500n 0.000555 164.8600n 0.000701 164.8700n 0.000841 164.8800n 0.000973 164.8900n 0.001094 164.9000n 0.001204 164.9100n 0.001301 164.9200n 0.001386 164.9300n 0.001456 164.9400n 0.001514 164.9500n 0.001557 164.9600n 0.001588 164.9700n 0.001607 164.9800n 0.001616 164.9900n 0.001614
+ 165.0000n 0.001604 165.0100n 0.001587 165.0200n 0.001565 165.0300n 0.001540 165.0400n 0.001513 165.0500n 0.001485 165.0600n 0.001459 165.0700n 0.001435 165.0800n 0.001415 165.0900n 0.001399 165.1000n 0.001388 165.1100n 0.001383 165.1200n 0.001384 165.1300n 0.001391 165.1400n 0.001403
+ 165.1500n 0.001421 165.1600n 0.001443 165.1700n 0.001468 165.1800n 0.001495 165.1900n 0.001524 165.2000n 0.001552 165.2100n 0.001578 165.2200n 0.001601 165.2300n 0.001620 165.2400n 0.001633 165.2500n 0.001638 165.2600n 0.001636 165.2700n 0.001624 165.2800n 0.001602 165.2900n 0.001570
+ 165.3000n 0.001527 165.3100n 0.001473 165.3200n 0.001409 165.3300n 0.001334 165.3400n 0.001250 165.3500n 0.001158 165.3600n 0.001058 165.3700n 0.000952 165.3800n 0.000841 165.3900n 0.000728 165.4000n 0.000613 165.4100n 0.000499 165.4200n 0.000387 165.4300n 0.000279 165.4400n 0.000177
+ 165.4500n 0.000081 165.4600n -0.000005 165.4700n -0.000082 165.4800n -0.000149 165.4900n -0.000204 165.5000n -0.000246 165.5100n -0.000277 165.5200n -0.000295 165.5300n -0.000301 165.5400n -0.000295 165.5500n -0.000279 165.5600n -0.000253 165.5700n -0.000219 165.5800n -0.000178 165.5900n -0.000131
+ 165.6000n -0.000081 165.6100n -0.000029 165.6200n 0.000023 165.6300n 0.000074 165.6400n 0.000121 165.6500n 0.000162 165.6600n 0.000196 165.6700n 0.000221 165.6800n 0.000237 165.6900n 0.000241 165.7000n 0.000234 165.7100n 0.000214 165.7200n 0.000180 165.7300n 0.000134 165.7400n 0.000074
+ 165.7500n 0.000001 165.7600n -0.000083 165.7700n -0.000179 165.7800n -0.000285 165.7900n -0.000400 165.8000n -0.000522 165.8100n -0.000650 165.8200n -0.000782 165.8300n -0.000916 165.8400n -0.001051 165.8500n -0.001183 165.8600n -0.001313 165.8700n -0.001437 165.8800n -0.001554 165.8900n -0.001662
+ 165.9000n -0.001760 165.9100n -0.001847 165.9200n -0.001922 165.9300n -0.001983 165.9400n -0.002030 165.9500n -0.002062 165.9600n -0.002080 165.9700n -0.002083 165.9800n -0.002070 165.9900n -0.002044 166.0000n -0.002004 166.0100n -0.001951 166.0200n -0.001885 166.0300n -0.001808 166.0400n -0.001722
+ 166.0500n -0.001626 166.0600n -0.001523 166.0700n -0.001414 166.0800n -0.001300 166.0900n -0.001182 166.1000n -0.001062 166.1100n -0.000941 166.1200n -0.000820 166.1300n -0.000700 166.1400n -0.000582 166.1500n -0.000468 166.1600n -0.000357 166.1700n -0.000251 166.1800n -0.000150 166.1900n -0.000055
+ 166.2000n 0.000034 166.2100n 0.000117 166.2200n 0.000193 166.2300n 0.000264 166.2400n 0.000327 166.2500n 0.000385 166.2600n 0.000436 166.2700n 0.000481 166.2800n 0.000520 166.2900n 0.000553 166.3000n 0.000581 166.3100n 0.000603 166.3200n 0.000620 166.3300n 0.000632 166.3400n 0.000640
+ 166.3500n 0.000642 166.3600n 0.000640 166.3700n 0.000632 166.3800n 0.000620 166.3900n 0.000603 166.4000n 0.000582 166.4100n 0.000555 166.4200n 0.000523 166.4300n 0.000486 166.4400n 0.000443 166.4500n 0.000395 166.4600n 0.000341 166.4700n 0.000282 166.4800n 0.000218 166.4900n 0.000147
+ 166.5000n 0.000072 166.5100n -0.000009 166.5200n -0.000095 166.5300n -0.000186 166.5400n -0.000281 166.5500n -0.000381 166.5600n -0.000483 166.5700n -0.000588 166.5800n -0.000696 166.5900n -0.000805 166.6000n -0.000914 166.6100n -0.001024 166.6200n -0.001132 166.6300n -0.001238 166.6400n -0.001341
+ 166.6500n -0.001440 166.6600n -0.001535 166.6700n -0.001623 166.6800n -0.001705 166.6900n -0.001779 166.7000n -0.001844 166.7100n -0.001901 166.7200n -0.001948 166.7300n -0.001984 166.7400n -0.002009 166.7500n -0.002023 166.7600n -0.002025 166.7700n -0.002016 166.7800n -0.001995 166.7900n -0.001962
+ 166.8000n -0.001918 166.8100n -0.001863 166.8200n -0.001797 166.8300n -0.001721 166.8400n -0.001636 166.8500n -0.001542 166.8600n -0.001441 166.8700n -0.001333 166.8800n -0.001219 166.8900n -0.001101 166.9000n -0.000980 166.9100n -0.000857 166.9200n -0.000733 166.9300n -0.000609 166.9400n -0.000486
+ 166.9500n -0.000366 166.9600n -0.000249 166.9700n -0.000137 166.9800n -0.000030 166.9900n 0.000070 167.0000n 0.000163 167.0100n 0.000250 167.0200n 0.000328 167.0300n 0.000398 167.0400n 0.000460 167.0500n 0.000513 167.0600n 0.000559 167.0700n 0.000597 167.0800n 0.000628 167.0900n 0.000652
+ 167.1000n 0.000671 167.1100n 0.000684 167.1200n 0.000694 167.1300n 0.000700 167.1400n 0.000705 167.1500n 0.000710 167.1600n 0.000714 167.1700n 0.000721 167.1800n 0.000730 167.1900n 0.000743 167.2000n 0.000761 167.2100n 0.000784 167.2200n 0.000815 167.2300n 0.000852 167.2400n 0.000898
+ 167.2500n 0.000951 167.2600n 0.001012 167.2700n 0.001082 167.2800n 0.001160 167.2900n 0.001244 167.3000n 0.001336 167.3100n 0.001433 167.3200n 0.001535 167.3300n 0.001640 167.3400n 0.001747 167.3500n 0.001855 167.3600n 0.001961 167.3700n 0.002064 167.3800n 0.002162 167.3900n 0.002253
+ 167.4000n 0.002336 167.4100n 0.002408 167.4200n 0.002467 167.4300n 0.002513 167.4400n 0.002543 167.4500n 0.002556 167.4600n 0.002551 167.4700n 0.002528 167.4800n 0.002484 167.4900n 0.002420 167.5000n 0.002336 167.5100n 0.002232 167.5200n 0.002108 167.5300n 0.001966 167.5400n 0.001805
+ 167.5500n 0.001628 167.5600n 0.001436 167.5700n 0.001230 167.5800n 0.001014 167.5900n 0.000788 167.6000n 0.000556 167.6100n 0.000320 167.6200n 0.000083 167.6300n -0.000153 167.6400n -0.000386 167.6500n -0.000611 167.6600n -0.000828 167.6700n -0.001034 167.6800n -0.001226 167.6900n -0.001402
+ 167.7000n -0.001562 167.7100n -0.001702 167.7200n -0.001822 167.7300n -0.001922 167.7400n -0.001999 167.7500n -0.002055 167.7600n -0.002089 167.7700n -0.002102 167.7800n -0.002094 167.7900n -0.002066 167.8000n -0.002019 167.8100n -0.001955 167.8200n -0.001876 167.8300n -0.001784 167.8400n -0.001679
+ 167.8500n -0.001566 167.8600n -0.001445 167.8700n -0.001319 167.8800n -0.001191 167.8900n -0.001062 167.9000n -0.000935 167.9100n -0.000811 167.9200n -0.000693 167.9300n -0.000582 167.9400n -0.000479 167.9500n -0.000386 167.9600n -0.000304 167.9700n -0.000232 167.9800n -0.000173 167.9900n -0.000126
+ 168.0000n -0.000090 168.0100n -0.000066 168.0200n -0.000053 168.0300n -0.000051 168.0400n -0.000058 168.0500n -0.000074 168.0600n -0.000097 168.0700n -0.000126 168.0800n -0.000160 168.0900n -0.000197 168.1000n -0.000236 168.1100n -0.000276 168.1200n -0.000315 168.1300n -0.000352 168.1400n -0.000386
+ 168.1500n -0.000417 168.1600n -0.000442 168.1700n -0.000462 168.1800n -0.000476 168.1900n -0.000483 168.2000n -0.000483 168.2100n -0.000476 168.2200n -0.000462 168.2300n -0.000442 168.2400n -0.000415 168.2500n -0.000382 168.2600n -0.000343 168.2700n -0.000299 168.2800n -0.000250 168.2900n -0.000198
+ 168.3000n -0.000142 168.3100n -0.000084 168.3200n -0.000023 168.3300n 0.000039 168.3400n 0.000102 168.3500n 0.000166 168.3600n 0.000230 168.3700n 0.000294 168.3800n 0.000358 168.3900n 0.000421 168.4000n 0.000484 168.4100n 0.000546 168.4200n 0.000607 168.4300n 0.000668 168.4400n 0.000728
+ 168.4500n 0.000787 168.4600n 0.000847 168.4700n 0.000905 168.4800n 0.000963 168.4900n 0.001021 168.5000n 0.001078 168.5100n 0.001135 168.5200n 0.001190 168.5300n 0.001244 168.5400n 0.001297 168.5500n 0.001347 168.5600n 0.001394 168.5700n 0.001438 168.5800n 0.001478 168.5900n 0.001513
+ 168.6000n 0.001543 168.6100n 0.001567 168.6200n 0.001583 168.6300n 0.001592 168.6400n 0.001593 168.6500n 0.001584 168.6600n 0.001566 168.6700n 0.001539 168.6800n 0.001501 168.6900n 0.001454 168.7000n 0.001396 168.7100n 0.001329 168.7200n 0.001253 168.7300n 0.001168 168.7400n 0.001075
+ 168.7500n 0.000976 168.7600n 0.000871 168.7700n 0.000761 168.7800n 0.000649 168.7900n 0.000535 168.8000n 0.000421 168.8100n 0.000310 168.8200n 0.000202 168.8300n 0.000100 168.8400n 0.000005 168.8500n -0.000082 168.8600n -0.000157 168.8700n -0.000222 168.8800n -0.000273 168.8900n -0.000310
+ 168.9000n -0.000332 168.9100n -0.000338 168.9200n -0.000328 168.9300n -0.000301 168.9400n -0.000259 168.9500n -0.000200 168.9600n -0.000126 168.9700n -0.000037 168.9800n 0.000066 168.9900n 0.000181 169.0000n 0.000307 169.0100n 0.000443 169.0200n 0.000587 169.0300n 0.000737 169.0400n 0.000890
+ 169.0500n 0.001047 169.0600n 0.001204 169.0700n 0.001359 169.0800n 0.001511 169.0900n 0.001658 169.1000n 0.001799 169.1100n 0.001932 169.1200n 0.002056 169.1300n 0.002169 169.1400n 0.002271 169.1500n 0.002361 169.1600n 0.002438 169.1700n 0.002502 169.1800n 0.002553 169.1900n 0.002590
+ 169.2000n 0.002614 169.2100n 0.002626 169.2200n 0.002624 169.2300n 0.002611 169.2400n 0.002586 169.2500n 0.002550 169.2600n 0.002504 169.2700n 0.002448 169.2800n 0.002383 169.2900n 0.002309 169.3000n 0.002228 169.3100n 0.002139 169.3200n 0.002043 169.3300n 0.001941 169.3400n 0.001832
+ 169.3500n 0.001717 169.3600n 0.001597 169.3700n 0.001470 169.3800n 0.001338 169.3900n 0.001200 169.4000n 0.001057 169.4100n 0.000909 169.4200n 0.000755 169.4300n 0.000596 169.4400n 0.000432 169.4500n 0.000264 169.4600n 0.000092 169.4700n -0.000083 169.4800n -0.000261 169.4900n -0.000440
+ 169.5000n -0.000620 169.5100n -0.000799 169.5200n -0.000976 169.5300n -0.001149 169.5400n -0.001317 169.5500n -0.001479 169.5600n -0.001631 169.5700n -0.001773 169.5800n -0.001903 169.5900n -0.002018 169.6000n -0.002118 169.6100n -0.002200 169.6200n -0.002264 169.6300n -0.002308 169.6400n -0.002331
+ 169.6500n -0.002332 169.6600n -0.002311 169.6700n -0.002268 169.6800n -0.002202 169.6900n -0.002115 169.7000n -0.002008 169.7100n -0.001881 169.7200n -0.001737 169.7300n -0.001576 169.7400n -0.001403 169.7500n -0.001218 169.7600n -0.001025 169.7700n -0.000827 169.7800n -0.000626 169.7900n -0.000426
+ 169.8000n -0.000231 169.8100n -0.000043 169.8200n 0.000135 169.8300n 0.000300 169.8400n 0.000449 169.8500n 0.000579 169.8600n 0.000689 169.8700n 0.000777 169.8800n 0.000842 169.8900n 0.000882 169.9000n 0.000898 169.9100n 0.000889 169.9200n 0.000856 169.9300n 0.000800 169.9400n 0.000723
+ 169.9500n 0.000626 169.9600n 0.000513 169.9700n 0.000384 169.9800n 0.000244 169.9900n 0.000097 170.0000n -0.000056 170.0100n -0.000210 170.0200n -0.000361 170.0300n -0.000506 170.0400n -0.000642 170.0500n -0.000766 170.0600n -0.000873 170.0700n -0.000962 170.0800n -0.001031 170.0900n -0.001077
+ 170.1000n -0.001099 170.1100n -0.001096 170.1200n -0.001068 170.1300n -0.001015 170.1400n -0.000938 170.1500n -0.000838 170.1600n -0.000717 170.1700n -0.000577 170.1800n -0.000421 170.1900n -0.000252 170.2000n -0.000073 170.2100n 0.000112 170.2200n 0.000299 170.2300n 0.000485 170.2400n 0.000665
+ 170.2500n 0.000835 170.2600n 0.000993 170.2700n 0.001134 170.2800n 0.001255 170.2900n 0.001353 170.3000n 0.001427 170.3100n 0.001474 170.3200n 0.001493 170.3300n 0.001483 170.3400n 0.001444 170.3500n 0.001376 170.3600n 0.001281 170.3700n 0.001160 170.3800n 0.001014 170.3900n 0.000847
+ 170.4000n 0.000661 170.4100n 0.000459 170.4200n 0.000246 170.4300n 0.000025 170.4400n -0.000200 170.4500n -0.000425 170.4600n -0.000645 170.4700n -0.000858 170.4800n -0.001058 170.4900n -0.001243 170.5000n -0.001409 170.5100n -0.001553 170.5200n -0.001674 170.5300n -0.001768 170.5400n -0.001836
+ 170.5500n -0.001875 170.5600n -0.001886 170.5700n -0.001869 170.5800n -0.001824 170.5900n -0.001754 170.6000n -0.001660 170.6100n -0.001543 170.6200n -0.001408 170.6300n -0.001256 170.6400n -0.001091 170.6500n -0.000916 170.6600n -0.000735 170.6700n -0.000552 170.6800n -0.000369 170.6900n -0.000191
+ 170.7000n -0.000020 170.7100n 0.000140 170.7200n 0.000288 170.7300n 0.000420 170.7400n 0.000535 170.7500n 0.000632 170.7600n 0.000709 170.7700n 0.000767 170.7800n 0.000804 170.7900n 0.000822 170.8000n 0.000821 170.8100n 0.000803 170.8200n 0.000769 170.8300n 0.000721 170.8400n 0.000661
+ 170.8500n 0.000592 170.8600n 0.000517 170.8700n 0.000438 170.8800n 0.000357 170.8900n 0.000277 170.9000n 0.000202 170.9100n 0.000132 170.9200n 0.000071 170.9300n 0.000019 170.9400n -0.000021 170.9500n -0.000048 170.9600n -0.000062 170.9700n -0.000062 170.9800n -0.000048 170.9900n -0.000020
+ 171.0000n 0.000020 171.0100n 0.000073 171.0200n 0.000136 171.0300n 0.000208 171.0400n 0.000287 171.0500n 0.000371 171.0600n 0.000457 171.0700n 0.000545 171.0800n 0.000631 171.0900n 0.000712 171.1000n 0.000788 171.1100n 0.000856 171.1200n 0.000914 171.1300n 0.000960 171.1400n 0.000994
+ 171.1500n 0.001013 171.1600n 0.001018 171.1700n 0.001008 171.1800n 0.000983 171.1900n 0.000943 171.2000n 0.000888 171.2100n 0.000820 171.2200n 0.000738 171.2300n 0.000646 171.2400n 0.000543 171.2500n 0.000432 171.2600n 0.000314 171.2700n 0.000191 171.2800n 0.000065 171.2900n -0.000062
+ 171.3000n -0.000189 171.3100n -0.000315 171.3200n -0.000436 171.3300n -0.000554 171.3400n -0.000665 171.3500n -0.000770 171.3600n -0.000867 171.3700n -0.000957 171.3800n -0.001039 171.3900n -0.001114 171.4000n -0.001180 171.4100n -0.001240 171.4200n -0.001292 171.4300n -0.001339 171.4400n -0.001381
+ 171.4500n -0.001418 171.4600n -0.001452 171.4700n -0.001484 171.4800n -0.001513 171.4900n -0.001542 171.5000n -0.001570 171.5100n -0.001598 171.5200n -0.001626 171.5300n -0.001654 171.5400n -0.001682 171.5500n -0.001710 171.5600n -0.001738 171.5700n -0.001763 171.5800n -0.001787 171.5900n -0.001807
+ 171.6000n -0.001822 171.6100n -0.001831 171.6200n -0.001833 171.6300n -0.001826 171.6400n -0.001809 171.6500n -0.001780 171.6600n -0.001740 171.6700n -0.001685 171.6800n -0.001617 171.6900n -0.001533 171.7000n -0.001435 171.7100n -0.001321 171.7200n -0.001192 171.7300n -0.001049 171.7400n -0.000892
+ 171.7500n -0.000724 171.7600n -0.000544 171.7700n -0.000356 171.7800n -0.000161 171.7900n 0.000038 171.8000n 0.000239 171.8100n 0.000440 171.8200n 0.000636 171.8300n 0.000826 171.8400n 0.001007 171.8500n 0.001176 171.8600n 0.001330 171.8700n 0.001468 171.8800n 0.001586 171.8900n 0.001683
+ 171.9000n 0.001758 171.9100n 0.001809 171.9200n 0.001835 171.9300n 0.001837 171.9400n 0.001814 171.9500n 0.001766 171.9600n 0.001695 171.9700n 0.001602 171.9800n 0.001489 171.9900n 0.001358 172.0000n 0.001211 172.0100n 0.001051 172.0200n 0.000880 172.0300n 0.000703 172.0400n 0.000521
+ 172.0500n 0.000338 172.0600n 0.000157 172.0700n -0.000019 172.0800n -0.000186 172.0900n -0.000344 172.1000n -0.000488 172.1100n -0.000618 172.1200n -0.000731 172.1300n -0.000827 172.1400n -0.000904 172.1500n -0.000963 172.1600n -0.001002 172.1700n -0.001023 172.1800n -0.001027 172.1900n -0.001015
+ 172.2000n -0.000988 172.2100n -0.000948 172.2200n -0.000898 172.2300n -0.000840 172.2400n -0.000777 172.2500n -0.000711 172.2600n -0.000645 172.2700n -0.000581 172.2800n -0.000523 172.2900n -0.000471 172.3000n -0.000430 172.3100n -0.000400 172.3200n -0.000383 172.3300n -0.000381 172.3400n -0.000393
+ 172.3500n -0.000422 172.3600n -0.000466 172.3700n -0.000525 172.3800n -0.000600 172.3900n -0.000688 172.4000n -0.000788 172.4100n -0.000898 172.4200n -0.001017 172.4300n -0.001142 172.4400n -0.001271 172.4500n -0.001401 172.4600n -0.001530 172.4700n -0.001655 172.4800n -0.001774 172.4900n -0.001884
+ 172.5000n -0.001983 172.5100n -0.002069 172.5200n -0.002140 172.5300n -0.002196 172.5400n -0.002234 172.5500n -0.002255 172.5600n -0.002257 172.5700n -0.002241 172.5800n -0.002208 172.5900n -0.002157 172.6000n -0.002091 172.6100n -0.002010 172.6200n -0.001916 172.6300n -0.001811 172.6400n -0.001697
+ 172.6500n -0.001577 172.6600n -0.001451 172.6700n -0.001324 172.6800n -0.001196 172.6900n -0.001071 172.7000n -0.000950 172.7100n -0.000835 172.7200n -0.000727 172.7300n -0.000628 172.7400n -0.000540 172.7500n -0.000462 172.7600n -0.000396 172.7700n -0.000342 172.7800n -0.000299 172.7900n -0.000267
+ 172.8000n -0.000246 172.8100n -0.000234 172.8200n -0.000230 172.8300n -0.000233 172.8400n -0.000241 172.8500n -0.000253 172.8600n -0.000267 172.8700n -0.000281 172.8800n -0.000293 172.8900n -0.000303 172.9000n -0.000308 172.9100n -0.000308 172.9200n -0.000301 172.9300n -0.000286 172.9400n -0.000263
+ 172.9500n -0.000232 172.9600n -0.000191 172.9700n -0.000143 172.9800n -0.000086 172.9900n -0.000022 173.0000n 0.000048 173.0100n 0.000123 173.0200n 0.000201 173.0300n 0.000282 173.0400n 0.000363 173.0500n 0.000443 173.0600n 0.000520 173.0700n 0.000592 173.0800n 0.000657 173.0900n 0.000714
+ 173.1000n 0.000762 173.1100n 0.000800 173.1200n 0.000825 173.1300n 0.000838 173.1400n 0.000838 173.1500n 0.000824 173.1600n 0.000797 173.1700n 0.000757 173.1800n 0.000704 173.1900n 0.000639 173.2000n 0.000564 173.2100n 0.000478 173.2200n 0.000384 173.2300n 0.000284 173.2400n 0.000178
+ 173.2500n 0.000069 173.2600n -0.000042 173.2700n -0.000152 173.2800n -0.000261 173.2900n -0.000367 173.3000n -0.000467 173.3100n -0.000561 173.3200n -0.000648 173.3300n -0.000726 173.3400n -0.000795 173.3500n -0.000854 173.3600n -0.000903 173.3700n -0.000942 173.3800n -0.000970 173.3900n -0.000989
+ 173.4000n -0.000998 173.4100n -0.000998 173.4200n -0.000990 173.4300n -0.000976 173.4400n -0.000955 173.4500n -0.000929 173.4600n -0.000899 173.4700n -0.000867 173.4800n -0.000832 173.4900n -0.000796 173.5000n -0.000760 173.5100n -0.000724 173.5200n -0.000689 173.5300n -0.000656 173.5400n -0.000624
+ 173.5500n -0.000594 173.5600n -0.000566 173.5700n -0.000539 173.5800n -0.000514 173.5900n -0.000489 173.6000n -0.000464 173.6100n -0.000439 173.6200n -0.000413 173.6300n -0.000385 173.6400n -0.000355 173.6500n -0.000322 173.6600n -0.000286 173.6700n -0.000246 173.6800n -0.000201 173.6900n -0.000153
+ 173.7000n -0.000100 173.7100n -0.000043 173.7200n 0.000018 173.7300n 0.000081 173.7400n 0.000148 173.7500n 0.000216 173.7600n 0.000284 173.7700n 0.000352 173.7800n 0.000419 173.7900n 0.000482 173.8000n 0.000542 173.8100n 0.000596 173.8200n 0.000644 173.8300n 0.000683 173.8400n 0.000714
+ 173.8500n 0.000736 173.8600n 0.000747 173.8700n 0.000747 173.8800n 0.000736 173.8900n 0.000714 173.9000n 0.000681 173.9100n 0.000638 173.9200n 0.000585 173.9300n 0.000523 173.9400n 0.000454 173.9500n 0.000379 173.9600n 0.000300 173.9700n 0.000218 173.9800n 0.000135 173.9900n 0.000054
+ 174.0000n -0.000024 174.0100n -0.000097 174.0200n -0.000162 174.0300n -0.000219 174.0400n -0.000266 174.0500n -0.000301 174.0600n -0.000322 174.0700n -0.000331 174.0800n -0.000324 174.0900n -0.000304 174.1000n -0.000269 174.1100n -0.000220 174.1200n -0.000158 174.1300n -0.000084 174.1400n 0.000000
+ 174.1500n 0.000094 174.1600n 0.000193 174.1700n 0.000298 174.1800n 0.000404 174.1900n 0.000511 174.2000n 0.000615 174.2100n 0.000713 174.2200n 0.000804 174.2300n 0.000886 174.2400n 0.000955 174.2500n 0.001011 174.2600n 0.001052 174.2700n 0.001076 174.2800n 0.001083 174.2900n 0.001072
+ 174.3000n 0.001044 174.3100n 0.000998 174.3200n 0.000935 174.3300n 0.000858 174.3400n 0.000766 174.3500n 0.000663 174.3600n 0.000551 174.3700n 0.000431 174.3800n 0.000307 174.3900n 0.000181 174.4000n 0.000057 174.4100n -0.000063 174.4200n -0.000176 174.4300n -0.000278 174.4400n -0.000369
+ 174.4500n -0.000444 174.4600n -0.000503 174.4700n -0.000544 174.4800n -0.000565 174.4900n -0.000566 174.5000n -0.000547 174.5100n -0.000508 174.5200n -0.000450 174.5300n -0.000374 174.5400n -0.000282 174.5500n -0.000176 174.5600n -0.000059 174.5700n 0.000067 174.5800n 0.000198 174.5900n 0.000332
+ 174.6000n 0.000464 174.6100n 0.000591 174.6200n 0.000710 174.6300n 0.000816 174.6400n 0.000908 174.6500n 0.000983 174.6600n 0.001037 174.6700n 0.001068 174.6800n 0.001076 174.6900n 0.001058 174.7000n 0.001015 174.7100n 0.000946 174.7200n 0.000853 174.7300n 0.000736 174.7400n 0.000597
+ 174.7500n 0.000438 174.7600n 0.000263 174.7700n 0.000075 174.7800n -0.000122 174.7900n -0.000325 174.8000n -0.000529 174.8100n -0.000731 174.8200n -0.000924 174.8300n -0.001105 174.8400n -0.001271 174.8500n -0.001416 174.8600n -0.001537 174.8700n -0.001631 174.8800n -0.001695 174.8900n -0.001728
+ 174.9000n -0.001727 174.9100n -0.001691 174.9200n -0.001621 174.9300n -0.001516 174.9400n -0.001379 174.9500n -0.001210 174.9600n -0.001013 174.9700n -0.000790 174.9800n -0.000545 174.9900n -0.000283 175.0000n -0.000007 175.0100n 0.000278 175.0200n 0.000565 175.0300n 0.000851 175.0400n 0.001131
+ 175.0500n 0.001398 175.0600n 0.001649 175.0700n 0.001878 175.0800n 0.002083 175.0900n 0.002259 175.1000n 0.002403 175.1100n 0.002512 175.1200n 0.002586 175.1300n 0.002623 175.1400n 0.002622 175.1500n 0.002585 175.1600n 0.002511 175.1700n 0.002404 175.1800n 0.002266 175.1900n 0.002100
+ 175.2000n 0.001909 175.2100n 0.001697 175.2200n 0.001470 175.2300n 0.001231 175.2400n 0.000986 175.2500n 0.000739 175.2600n 0.000496 175.2700n 0.000262 175.2800n 0.000040 175.2900n -0.000164 175.3000n -0.000348 175.3100n -0.000507 175.3200n -0.000639 175.3300n -0.000743 175.3400n -0.000816
+ 175.3500n -0.000857 175.3600n -0.000868 175.3700n -0.000847 175.3800n -0.000797 175.3900n -0.000719 175.4000n -0.000617 175.4100n -0.000492 175.4200n -0.000348 175.4300n -0.000189 175.4400n -0.000019 175.4500n 0.000157 175.4600n 0.000336 175.4700n 0.000513 175.4800n 0.000684 175.4900n 0.000845
+ 175.5000n 0.000992 175.5100n 0.001122 175.5200n 0.001232 175.5300n 0.001320 175.5400n 0.001383 175.5500n 0.001421 175.5600n 0.001432 175.5700n 0.001417 175.5800n 0.001376 175.5900n 0.001311 175.6000n 0.001223 175.6100n 0.001114 175.6200n 0.000987 175.6300n 0.000845 175.6400n 0.000692
+ 175.6500n 0.000531 175.6600n 0.000365 175.6700n 0.000199 175.6800n 0.000037 175.6900n -0.000119 175.7000n -0.000263 175.7100n -0.000394 175.7200n -0.000507 175.7300n -0.000602 175.7400n -0.000674 175.7500n -0.000724 175.7600n -0.000749 175.7700n -0.000750 175.7800n -0.000726 175.7900n -0.000677
+ 175.8000n -0.000606 175.8100n -0.000512 175.8200n -0.000400 175.8300n -0.000270 175.8400n -0.000125 175.8500n 0.000031 175.8600n 0.000196 175.8700n 0.000365 175.8800n 0.000537 175.8900n 0.000707 175.9000n 0.000871 175.9100n 0.001028 175.9200n 0.001174 175.9300n 0.001307 175.9400n 0.001424
+ 175.9500n 0.001524 175.9600n 0.001605 175.9700n 0.001666 175.9800n 0.001706 175.9900n 0.001726 176.0000n 0.001725 176.0100n 0.001705 176.0200n 0.001666 176.0300n 0.001610 176.0400n 0.001539 176.0500n 0.001454 176.0600n 0.001358 176.0700n 0.001253 176.0800n 0.001141 176.0900n 0.001025
+ 176.1000n 0.000907 176.1100n 0.000790 176.1200n 0.000674 176.1300n 0.000563 176.1400n 0.000457 176.1500n 0.000359 176.1600n 0.000268 176.1700n 0.000186 176.1800n 0.000114 176.1900n 0.000050 176.2000n -0.000004 176.2100n -0.000050 176.2200n -0.000089 176.2300n -0.000121 176.2400n -0.000148
+ 176.2500n -0.000170 176.2600n -0.000190 176.2700n -0.000209 176.2800n -0.000229 176.2900n -0.000250 176.3000n -0.000274 176.3100n -0.000302 176.3200n -0.000336 176.3300n -0.000375 176.3400n -0.000421 176.3500n -0.000473 176.3600n -0.000531 176.3700n -0.000594 176.3800n -0.000663 176.3900n -0.000735
+ 176.4000n -0.000809 176.4100n -0.000885 176.4200n -0.000959 176.4300n -0.001031 176.4400n -0.001097 176.4500n -0.001156 176.4600n -0.001206 176.4700n -0.001244 176.4800n -0.001269 176.4900n -0.001278 176.5000n -0.001270 176.5100n -0.001244 176.5200n -0.001199 176.5300n -0.001133 176.5400n -0.001047
+ 176.5500n -0.000940 176.5600n -0.000813 176.5700n -0.000667 176.5800n -0.000504 176.5900n -0.000323 176.6000n -0.000129 176.6100n 0.000077 176.6200n 0.000293 176.6300n 0.000515 176.6400n 0.000740 176.6500n 0.000965 176.6600n 0.001187 176.6700n 0.001403 176.6800n 0.001609 176.6900n 0.001803
+ 176.7000n 0.001981 176.7100n 0.002141 176.7200n 0.002280 176.7300n 0.002398 176.7400n 0.002491 176.7500n 0.002560 176.7600n 0.002604 176.7700n 0.002622 176.7800n 0.002615 176.7900n 0.002584 176.8000n 0.002530 176.8100n 0.002455 176.8200n 0.002362 176.8300n 0.002251 176.8400n 0.002127
+ 176.8500n 0.001993 176.8600n 0.001852 176.8700n 0.001707 176.8800n 0.001561 176.8900n 0.001419 176.9000n 0.001282 176.9100n 0.001156 176.9200n 0.001042 176.9300n 0.000943 176.9400n 0.000861 176.9500n 0.000798 176.9600n 0.000757 176.9700n 0.000736 176.9800n 0.000738 176.9900n 0.000763
+ 177.0000n 0.000809 177.0100n 0.000875 177.0200n 0.000961 177.0300n 0.001065 177.0400n 0.001183 177.0500n 0.001314 177.0600n 0.001455 177.0700n 0.001602 177.0800n 0.001753 177.0900n 0.001903 177.1000n 0.002049 177.1100n 0.002189 177.1200n 0.002319 177.1300n 0.002435 177.1400n 0.002535
+ 177.1500n 0.002616 177.1600n 0.002677 177.1700n 0.002715 177.1800n 0.002729 177.1900n 0.002718 177.2000n 0.002682 177.2100n 0.002621 177.2200n 0.002536 177.2300n 0.002427 177.2400n 0.002296 177.2500n 0.002146 177.2600n 0.001979 177.2700n 0.001796 177.2800n 0.001602 177.2900n 0.001400
+ 177.3000n 0.001192 177.3100n 0.000983 177.3200n 0.000777 177.3300n 0.000575 177.3400n 0.000383 177.3500n 0.000203 177.3600n 0.000038 177.3700n -0.000109 177.3800n -0.000235 177.3900n -0.000339 177.4000n -0.000419 177.4100n -0.000474 177.4200n -0.000504 177.4300n -0.000507 177.4400n -0.000484
+ 177.4500n -0.000437 177.4600n -0.000366 177.4700n -0.000273 177.4800n -0.000160 177.4900n -0.000030 177.5000n 0.000115 177.5100n 0.000271 177.5200n 0.000436 177.5300n 0.000605 177.5400n 0.000776 177.5500n 0.000944 177.5600n 0.001106 177.5700n 0.001259 177.5800n 0.001399 177.5900n 0.001523
+ 177.6000n 0.001628 177.6100n 0.001713 177.6200n 0.001774 177.6300n 0.001810 177.6400n 0.001819 177.6500n 0.001801 177.6600n 0.001755 177.6700n 0.001681 177.6800n 0.001579 177.6900n 0.001451 177.7000n 0.001298 177.7100n 0.001120 177.7200n 0.000922 177.7300n 0.000704 177.7400n 0.000470
+ 177.7500n 0.000222 177.7600n -0.000035 177.7700n -0.000300 177.7800n -0.000567 177.7900n -0.000835 177.8000n -0.001099 177.8100n -0.001356 177.8200n -0.001603 177.8300n -0.001837 177.8400n -0.002054 177.8500n -0.002252 177.8600n -0.002429 177.8700n -0.002583 177.8800n -0.002712 177.8900n -0.002815
+ 177.9000n -0.002891 177.9100n -0.002939 177.9200n -0.002959 177.9300n -0.002952 177.9400n -0.002919 177.9500n -0.002860 177.9600n -0.002777 177.9700n -0.002671 177.9800n -0.002545 177.9900n -0.002401 178.0000n -0.002241 178.0100n -0.002068 178.0200n -0.001885 178.0300n -0.001694 178.0400n -0.001499
+ 178.0500n -0.001303 178.0600n -0.001108 178.0700n -0.000917 178.0800n -0.000734 178.0900n -0.000559 178.1000n -0.000396 178.1100n -0.000247 178.1200n -0.000114 178.1300n 0.000002 178.1400n 0.000100 178.1500n 0.000179 178.1600n 0.000237 178.1700n 0.000275 178.1800n 0.000292 178.1900n 0.000289
+ 178.2000n 0.000267 178.2100n 0.000225 178.2200n 0.000165 178.2300n 0.000088 178.2400n -0.000004 178.2500n -0.000111 178.2600n -0.000230 178.2700n -0.000359 178.2800n -0.000497 178.2900n -0.000642 178.3000n -0.000792 178.3100n -0.000946 178.3200n -0.001101 178.3300n -0.001256 178.3400n -0.001409
+ 178.3500n -0.001560 178.3600n -0.001706 178.3700n -0.001846 178.3800n -0.001980 178.3900n -0.002107 178.4000n -0.002226 178.4100n -0.002336 178.4200n -0.002438 178.4300n -0.002530 178.4400n -0.002613 178.4500n -0.002687 178.4600n -0.002752 178.4700n -0.002808 178.4800n -0.002855 178.4900n -0.002894
+ 178.5000n -0.002925 178.5100n -0.002947 178.5200n -0.002962 178.5300n -0.002970 178.5400n -0.002969 178.5500n -0.002962 178.5600n -0.002947 178.5700n -0.002925 178.5800n -0.002895 178.5900n -0.002857 178.6000n -0.002811 178.6100n -0.002757 178.6200n -0.002694 178.6300n -0.002623 178.6400n -0.002541
+ 178.6500n -0.002450 178.6600n -0.002349 178.6700n -0.002238 178.6800n -0.002117 178.6900n -0.001985 178.7000n -0.001843 178.7100n -0.001692 178.7200n -0.001531 178.7300n -0.001361 178.7400n -0.001184 178.7500n -0.001000 178.7600n -0.000811 178.7700n -0.000618 178.7800n -0.000423 178.7900n -0.000228
+ 178.8000n -0.000034 178.8100n 0.000156 178.8200n 0.000339 178.8300n 0.000515 178.8400n 0.000679 178.8500n 0.000831 178.8600n 0.000967 178.8700n 0.001087 178.8800n 0.001187 178.8900n 0.001266 178.9000n 0.001323 178.9100n 0.001356 178.9200n 0.001364 178.9300n 0.001348 178.9400n 0.001306
+ 178.9500n 0.001240 178.9600n 0.001149 178.9700n 0.001035 178.9800n 0.000899 178.9900n 0.000744 179.0000n 0.000570 179.0100n 0.000382 179.0200n 0.000182 179.0300n -0.000026 179.0400n -0.000241 179.0500n -0.000457 179.0600n -0.000671 179.0700n -0.000879 179.0800n -0.001079 179.0900n -0.001265
+ 179.1000n -0.001435 179.1100n -0.001586 179.1200n -0.001715 179.1300n -0.001820 179.1400n -0.001897 179.1500n -0.001946 179.1600n -0.001967 179.1700n -0.001957 179.1800n -0.001918 179.1900n -0.001849 179.2000n -0.001753 179.2100n -0.001630 179.2200n -0.001484 179.2300n -0.001317 179.2400n -0.001131
+ 179.2500n -0.000932 179.2600n -0.000722 179.2700n -0.000505 179.2800n -0.000287 179.2900n -0.000072 179.3000n 0.000137 179.3100n 0.000334 179.3200n 0.000516 179.3300n 0.000678 179.3400n 0.000818 179.3500n 0.000931 179.3600n 0.001016 179.3700n 0.001070 179.3800n 0.001093 179.3900n 0.001082
+ 179.4000n 0.001038 179.4100n 0.000961 179.4200n 0.000853 179.4300n 0.000716 179.4400n 0.000551 179.4500n 0.000362 179.4600n 0.000152 179.4700n -0.000074 179.4800n -0.000312 179.4900n -0.000558 179.5000n -0.000806 179.5100n -0.001052 179.5200n -0.001291 179.5300n -0.001518 179.5400n -0.001728
+ 179.5500n -0.001917 179.5600n -0.002081 179.5700n -0.002216 179.5800n -0.002319 179.5900n -0.002389 179.6000n -0.002424 179.6100n -0.002422 179.6200n -0.002384 179.6300n -0.002310 179.6400n -0.002202 179.6500n -0.002061 179.6600n -0.001891 179.6700n -0.001694 179.6800n -0.001475 179.6900n -0.001237
+ 179.7000n -0.000987 179.7100n -0.000729 179.7200n -0.000467 179.7300n -0.000208 179.7400n 0.000042 179.7500n 0.000280 179.7600n 0.000499 179.7700n 0.000696 179.7800n 0.000866 179.7900n 0.001006 179.8000n 0.001112 179.8100n 0.001182 179.8200n 0.001215 179.8300n 0.001209 179.8400n 0.001166
+ 179.8500n 0.001086 179.8600n 0.000969 179.8700n 0.000820 179.8800n 0.000640 179.8900n 0.000433 179.9000n 0.000205 179.9100n -0.000041 179.9200n -0.000299 179.9300n -0.000564 179.9400n -0.000831 179.9500n -0.001092 179.9600n -0.001344 179.9700n -0.001579 179.9800n -0.001794 179.9900n -0.001983
+ 180.0000n -0.002143 180.0100n -0.002269 180.0200n -0.002358 180.0300n -0.002408 180.0400n -0.002418 180.0500n -0.002387 180.0600n -0.002316 180.0700n -0.002204 180.0800n -0.002053 180.0900n -0.001868 180.1000n -0.001649 180.1100n -0.001402 180.1200n -0.001131 180.1300n -0.000841 180.1400n -0.000537
+ 180.1500n -0.000225 180.1600n 0.000090 180.1700n 0.000401 180.1800n 0.000704 180.1900n 0.000992 180.2000n 0.001260 180.2100n 0.001504 180.2200n 0.001719 180.2300n 0.001901 180.2400n 0.002048 180.2500n 0.002156 180.2600n 0.002226 180.2700n 0.002255 180.2800n 0.002243 180.2900n 0.002192
+ 180.3000n 0.002103 180.3100n 0.001979 180.3200n 0.001821 180.3300n 0.001635 180.3400n 0.001423 180.3500n 0.001191 180.3600n 0.000943 180.3700n 0.000684 180.3800n 0.000420 180.3900n 0.000156 180.4000n -0.000103 180.4100n -0.000352 180.4200n -0.000587 180.4300n -0.000802 180.4400n -0.000994
+ 180.4500n -0.001160 180.4600n -0.001296 180.4700n -0.001402 180.4800n -0.001474 180.4900n -0.001513 180.5000n -0.001519 180.5100n -0.001491 180.5200n -0.001432 180.5300n -0.001342 180.5400n -0.001225 180.5500n -0.001082 180.5600n -0.000918 180.5700n -0.000736 180.5800n -0.000539 180.5900n -0.000332
+ 180.6000n -0.000119 180.6100n 0.000096 180.6200n 0.000310 180.6300n 0.000518 180.6400n 0.000718 180.6500n 0.000905 180.6600n 0.001077 180.6700n 0.001232 180.6800n 0.001368 180.6900n 0.001483 180.7000n 0.001577 180.7100n 0.001650 180.7200n 0.001701 180.7300n 0.001731 180.7400n 0.001741
+ 180.7500n 0.001733 180.7600n 0.001709 180.7700n 0.001671 180.7800n 0.001620 180.7900n 0.001560 180.8000n 0.001494 180.8100n 0.001423 180.8200n 0.001351 180.8300n 0.001279 180.8400n 0.001211 180.8500n 0.001147 180.8600n 0.001091 180.8700n 0.001043 180.8800n 0.001005 180.8900n 0.000977
+ 180.9000n 0.000959 180.9100n 0.000952 180.9200n 0.000955 180.9300n 0.000967 180.9400n 0.000987 180.9500n 0.001014 180.9600n 0.001047 180.9700n 0.001083 180.9800n 0.001121 180.9900n 0.001158 181.0000n 0.001193 181.0100n 0.001223 181.0200n 0.001248 181.0300n 0.001264 181.0400n 0.001271
+ 181.0500n 0.001267 181.0600n 0.001252 181.0700n 0.001224 181.0800n 0.001184 181.0900n 0.001132 181.1000n 0.001068 181.1100n 0.000992 181.1200n 0.000906 181.1300n 0.000812 181.1400n 0.000710 181.1500n 0.000604 181.1600n 0.000494 181.1700n 0.000383 181.1800n 0.000274 181.1900n 0.000169
+ 181.2000n 0.000069 181.2100n -0.000022 181.2200n -0.000103 181.2300n -0.000172 181.2400n -0.000227 181.2500n -0.000268 181.2600n -0.000293 181.2700n -0.000302 181.2800n -0.000294 181.2900n -0.000271 181.3000n -0.000232 181.3100n -0.000178 181.3200n -0.000111 181.3300n -0.000033 181.3400n 0.000055
+ 181.3500n 0.000150 181.3600n 0.000250 181.3700n 0.000352 181.3800n 0.000453 181.3900n 0.000552 181.4000n 0.000645 181.4100n 0.000729 181.4200n 0.000803 181.4300n 0.000865 181.4400n 0.000911 181.4500n 0.000941 181.4600n 0.000954 181.4700n 0.000949 181.4800n 0.000925 181.4900n 0.000882
+ 181.5000n 0.000821 181.5100n 0.000743 181.5200n 0.000648 181.5300n 0.000540 181.5400n 0.000418 181.5500n 0.000287 181.5600n 0.000148 181.5700n 0.000004 181.5800n -0.000142 181.5900n -0.000287 181.6000n -0.000428 181.6100n -0.000563 181.6200n -0.000688 181.6300n -0.000801 181.6400n -0.000900
+ 181.6500n -0.000982 181.6600n -0.001046 181.6700n -0.001091 181.6800n -0.001115 181.6900n -0.001119 181.7000n -0.001102 181.7100n -0.001064 181.7200n -0.001007 181.7300n -0.000931 181.7400n -0.000839 181.7500n -0.000731 181.7600n -0.000612 181.7700n -0.000483 181.7800n -0.000346 181.7900n -0.000206
+ 181.8000n -0.000065 181.8100n 0.000075 181.8200n 0.000209 181.8300n 0.000335 181.8400n 0.000451 181.8500n 0.000553 181.8600n 0.000640 181.8700n 0.000710 181.8800n 0.000760 181.8900n 0.000791 181.9000n 0.000800 181.9100n 0.000788 181.9200n 0.000754 181.9300n 0.000699 181.9400n 0.000625
+ 181.9500n 0.000531 181.9600n 0.000421 181.9700n 0.000295 181.9800n 0.000156 181.9900n 0.000007 182.0000n -0.000151 182.0100n -0.000314 182.0200n -0.000480 182.0300n -0.000645 182.0400n -0.000808 182.0500n -0.000965 182.0600n -0.001114 182.0700n -0.001252 182.0800n -0.001379 182.0900n -0.001491
+ 182.1000n -0.001588 182.1100n -0.001668 182.1200n -0.001731 182.1300n -0.001776 182.1400n -0.001804 182.1500n -0.001813 182.1600n -0.001806 182.1700n -0.001783 182.1800n -0.001744 182.1900n -0.001692 182.2000n -0.001628 182.2100n -0.001554 182.2200n -0.001471 182.2300n -0.001382 182.2400n -0.001289
+ 182.2500n -0.001193 182.2600n -0.001096 182.2700n -0.001000 182.2800n -0.000908 182.2900n -0.000819 182.3000n -0.000736 182.3100n -0.000659 182.3200n -0.000590 182.3300n -0.000529 182.3400n -0.000477 182.3500n -0.000432 182.3600n -0.000396 182.3700n -0.000368 182.3800n -0.000347 182.3900n -0.000333
+ 182.4000n -0.000324 182.4100n -0.000320 182.4200n -0.000319 182.4300n -0.000321 182.4400n -0.000323 182.4500n -0.000325 182.4600n -0.000325 182.4700n -0.000322 182.4800n -0.000315 182.4900n -0.000303 182.5000n -0.000286 182.5100n -0.000262 182.5200n -0.000231 182.5300n -0.000193 182.5400n -0.000148
+ 182.5500n -0.000095 182.5600n -0.000036 182.5700n 0.000030 182.5800n 0.000102 182.5900n 0.000179 182.6000n 0.000260 182.6100n 0.000344 182.6200n 0.000430 182.6300n 0.000517 182.6400n 0.000603 182.6500n 0.000687 182.6600n 0.000769 182.6700n 0.000846 182.6800n 0.000918 182.6900n 0.000983
+ 182.7000n 0.001041 182.7100n 0.001090 182.7200n 0.001131 182.7300n 0.001162 182.7400n 0.001183 182.7500n 0.001194 182.7600n 0.001195 182.7700n 0.001185 182.7800n 0.001166 182.7900n 0.001138 182.8000n 0.001101 182.8100n 0.001056 182.8200n 0.001004 182.8300n 0.000946 182.8400n 0.000883
+ 182.8500n 0.000816 182.8600n 0.000747 182.8700n 0.000677 182.8800n 0.000607 182.8900n 0.000539 182.9000n 0.000473 182.9100n 0.000412 182.9200n 0.000356 182.9300n 0.000306 182.9400n 0.000264 182.9500n 0.000230 182.9600n 0.000206 182.9700n 0.000192 182.9800n 0.000189 182.9900n 0.000197
+ 183.0000n 0.000217 183.0100n 0.000249 183.0200n 0.000292 183.0300n 0.000347 183.0400n 0.000414 183.0500n 0.000491 183.0600n 0.000579 183.0700n 0.000676 183.0800n 0.000782 183.0900n 0.000895 183.1000n 0.001015 183.1100n 0.001140 183.1200n 0.001270 183.1300n 0.001401 183.1400n 0.001533
+ 183.1500n 0.001665 183.1600n 0.001794 183.1700n 0.001919 183.1800n 0.002039 183.1900n 0.002151 183.2000n 0.002254 183.2100n 0.002347 183.2200n 0.002427 183.2300n 0.002495 183.2400n 0.002548 183.2500n 0.002585 183.2600n 0.002606 183.2700n 0.002610 183.2800n 0.002596 183.2900n 0.002564
+ 183.3000n 0.002514 183.3100n 0.002446 183.3200n 0.002361 183.3300n 0.002259 183.3400n 0.002141 183.3500n 0.002008 183.3600n 0.001862 183.3700n 0.001704 183.3800n 0.001535 183.3900n 0.001359 183.4000n 0.001177 183.4100n 0.000990 183.4200n 0.000802 183.4300n 0.000615 183.4400n 0.000431
+ 183.4500n 0.000253 183.4600n 0.000082 183.4700n -0.000079 183.4800n -0.000228 183.4900n -0.000364 183.5000n -0.000484 183.5100n -0.000588 183.5200n -0.000674 183.5300n -0.000742 183.5400n -0.000791 183.5500n -0.000820 183.5600n -0.000831 183.5700n -0.000824 183.5800n -0.000799 183.5900n -0.000759
+ 183.6000n -0.000704 183.6100n -0.000636 183.6200n -0.000558 183.6300n -0.000472 183.6400n -0.000380 183.6500n -0.000285 183.6600n -0.000189 183.6700n -0.000097 183.6800n -0.000009 183.6900n 0.000071 183.7000n 0.000140 183.7100n 0.000196 183.7200n 0.000238 183.7300n 0.000263 183.7400n 0.000269
+ 183.7500n 0.000257 183.7600n 0.000224 183.7700n 0.000170 183.7800n 0.000097 183.7900n 0.000003 183.8000n -0.000109 183.8100n -0.000239 183.8200n -0.000384 183.8300n -0.000543 183.8400n -0.000712 183.8500n -0.000890 183.8600n -0.001073 183.8700n -0.001257 183.8800n -0.001439 183.8900n -0.001616
+ 183.9000n -0.001784 183.9100n -0.001940 183.9200n -0.002080 183.9300n -0.002202 183.9400n -0.002301 183.9500n -0.002376 183.9600n -0.002425 183.9700n -0.002445 183.9800n -0.002435 183.9900n -0.002395 184.0000n -0.002324 184.0100n -0.002222 184.0200n -0.002090 184.0300n -0.001929 184.0400n -0.001741
+ 184.0500n -0.001528 184.0600n -0.001292 184.0700n -0.001038 184.0800n -0.000767 184.0900n -0.000484 184.1000n -0.000193 184.1100n 0.000102 184.1200n 0.000398 184.1300n 0.000689 184.1400n 0.000973 184.1500n 0.001244 184.1600n 0.001500 184.1700n 0.001737 184.1800n 0.001951 184.1900n 0.002140
+ 184.2000n 0.002301 184.2100n 0.002434 184.2200n 0.002535 184.2300n 0.002606 184.2400n 0.002644 184.2500n 0.002651 184.2600n 0.002628 184.2700n 0.002575 184.2800n 0.002494 184.2900n 0.002388 184.3000n 0.002259 184.3100n 0.002109 184.3200n 0.001943 184.3300n 0.001764 184.3400n 0.001574
+ 184.3500n 0.001378 184.3600n 0.001179 184.3700n 0.000980 184.3800n 0.000786 184.3900n 0.000599 184.4000n 0.000423 184.4100n 0.000259 184.4200n 0.000111 184.4300n -0.000020 184.4400n -0.000132 184.4500n -0.000224 184.4600n -0.000295 184.4700n -0.000346 184.4800n -0.000376 184.4900n -0.000386
+ 184.5000n -0.000377 184.5100n -0.000351 184.5200n -0.000310 184.5300n -0.000255 184.5400n -0.000189 184.5500n -0.000115 184.5600n -0.000034 184.5700n 0.000049 184.5800n 0.000132 184.5900n 0.000213 184.6000n 0.000288 184.6100n 0.000356 184.6200n 0.000413 184.6300n 0.000457 184.6400n 0.000487
+ 184.6500n 0.000501 184.6600n 0.000497 184.6700n 0.000475 184.6800n 0.000434 184.6900n 0.000374 184.7000n 0.000295 184.7100n 0.000197 184.7200n 0.000082 184.7300n -0.000050 184.7400n -0.000198 184.7500n -0.000358 184.7600n -0.000530 184.7700n -0.000711 184.7800n -0.000898 184.7900n -0.001091
+ 184.8000n -0.001284 184.8100n -0.001477 184.8200n -0.001667 184.8300n -0.001851 184.8400n -0.002026 184.8500n -0.002190 184.8600n -0.002342 184.8700n -0.002478 184.8800n -0.002598 184.8900n -0.002700 184.9000n -0.002781 184.9100n -0.002842 184.9200n -0.002881 184.9300n -0.002898 184.9400n -0.002893
+ 184.9500n -0.002865 184.9600n -0.002815 184.9700n -0.002743 184.9800n -0.002650 184.9900n -0.002536 185.0000n -0.002404 185.0100n -0.002255 185.0200n -0.002089 185.0300n -0.001910 185.0400n -0.001717 185.0500n -0.001515 185.0600n -0.001304 185.0700n -0.001086 185.0800n -0.000865 185.0900n -0.000641
+ 185.1000n -0.000418 185.1100n -0.000197 185.1200n 0.000019 185.1300n 0.000229 185.1400n 0.000430 185.1500n 0.000620 185.1600n 0.000798 185.1700n 0.000961 185.1800n 0.001109 185.1900n 0.001240 185.2000n 0.001353 185.2100n 0.001445 185.2200n 0.001518 185.2300n 0.001570 185.2400n 0.001600
+ 185.2500n 0.001609 185.2600n 0.001596 185.2700n 0.001562 185.2800n 0.001507 185.2900n 0.001432 185.3000n 0.001338 185.3100n 0.001226 185.3200n 0.001098 185.3300n 0.000955 185.3400n 0.000799 185.3500n 0.000633 185.3600n 0.000457 185.3700n 0.000276 185.3800n 0.000091 185.3900n -0.000096
+ 185.4000n -0.000281 185.4100n -0.000463 185.4200n -0.000638 185.4300n -0.000804 185.4400n -0.000959 185.4500n -0.001100 185.4600n -0.001225 185.4700n -0.001333 185.4800n -0.001422 185.4900n -0.001489 185.5000n -0.001535 185.5100n -0.001558 185.5200n -0.001558 185.5300n -0.001534 185.5400n -0.001487
+ 185.5500n -0.001417 185.5600n -0.001325 185.5700n -0.001212 185.5800n -0.001080 185.5900n -0.000930 185.6000n -0.000764 185.6100n -0.000585 185.6200n -0.000395 185.6300n -0.000197 185.6400n 0.000007 185.6500n 0.000214 185.6600n 0.000421 185.6700n 0.000625 185.6800n 0.000824 185.6900n 0.001014
+ 185.7000n 0.001194 185.7100n 0.001361 185.7200n 0.001513 185.7300n 0.001649 185.7400n 0.001766 185.7500n 0.001864 185.7600n 0.001941 185.7700n 0.001998 185.7800n 0.002034 185.7900n 0.002049 185.8000n 0.002043 185.8100n 0.002018 185.8200n 0.001974 185.8300n 0.001913 185.8400n 0.001835
+ 185.8500n 0.001744 185.8600n 0.001639 185.8700n 0.001525 185.8800n 0.001401 185.8900n 0.001272 185.9000n 0.001137 185.9100n 0.001000 185.9200n 0.000863 185.9300n 0.000726 185.9400n 0.000593 185.9500n 0.000463 185.9600n 0.000339 185.9700n 0.000220 185.9800n 0.000109 185.9900n 0.000006
+ 186.0000n -0.000089 186.0100n -0.000176 186.0200n -0.000254 186.0300n -0.000325 186.0400n -0.000387 186.0500n -0.000442 186.0600n -0.000491 186.0700n -0.000533 186.0800n -0.000569 186.0900n -0.000601 186.1000n -0.000627 186.1100n -0.000650 186.1200n -0.000669 186.1300n -0.000685 186.1400n -0.000698
+ 186.1500n -0.000708 186.1600n -0.000714 186.1700n -0.000717 186.1800n -0.000715 186.1900n -0.000709 186.2000n -0.000698 186.2100n -0.000680 186.2200n -0.000656 186.2300n -0.000623 186.2400n -0.000581 186.2500n -0.000529 186.2600n -0.000466 186.2700n -0.000391 186.2800n -0.000303 186.2900n -0.000202
+ 186.3000n -0.000087 186.3100n 0.000041 186.3200n 0.000184 186.3300n 0.000340 186.3400n 0.000508 186.3500n 0.000689 186.3600n 0.000880 186.3700n 0.001081 186.3800n 0.001289 186.3900n 0.001502 186.4000n 0.001718 186.4100n 0.001935 186.4200n 0.002150 186.4300n 0.002360 186.4400n 0.002562
+ 186.4500n 0.002754 186.4600n 0.002932 186.4700n 0.003094 186.4800n 0.003238 186.4900n 0.003360 186.5000n 0.003458 186.5100n 0.003532 186.5200n 0.003579 186.5300n 0.003598 186.5400n 0.003588 186.5500n 0.003549 186.5600n 0.003481 186.5700n 0.003385 186.5800n 0.003261 186.5900n 0.003112
+ 186.6000n 0.002939 186.6100n 0.002744 186.6200n 0.002530 186.6300n 0.002299 186.6400n 0.002056 186.6500n 0.001803 186.6600n 0.001543 186.6700n 0.001281 186.6800n 0.001020 186.6900n 0.000763 186.7000n 0.000515 186.7100n 0.000277 186.7200n 0.000054 186.7300n -0.000153 186.7400n -0.000340
+ 186.7500n -0.000506 186.7600n -0.000649 186.7700n -0.000767 186.7800n -0.000861 186.7900n -0.000930 186.8000n -0.000973 186.8100n -0.000992 186.8200n -0.000988 186.8300n -0.000961 186.8400n -0.000914 186.8500n -0.000849 186.8600n -0.000768 186.8700n -0.000673 186.8800n -0.000566 186.8900n -0.000452
+ 186.9000n -0.000332 186.9100n -0.000209 186.9200n -0.000086 186.9300n 0.000034 186.9400n 0.000150 186.9500n 0.000259 186.9600n 0.000360 186.9700n 0.000450 186.9800n 0.000528 186.9900n 0.000594 187.0000n 0.000646 187.0100n 0.000685 187.0200n 0.000710 187.0300n 0.000721 187.0400n 0.000719
+ 187.0500n 0.000705 187.0600n 0.000679 187.0700n 0.000642 187.0800n 0.000597 187.0900n 0.000543 187.1000n 0.000482 187.1100n 0.000415 187.1200n 0.000344 187.1300n 0.000270 187.1400n 0.000193 187.1500n 0.000115 187.1600n 0.000036 187.1700n -0.000042 187.1800n -0.000121 187.1900n -0.000200
+ 187.2000n -0.000278 187.2100n -0.000356 187.2200n -0.000434 187.2300n -0.000513 187.2400n -0.000593 187.2500n -0.000674 187.2600n -0.000759 187.2700n -0.000846 187.2800n -0.000937 187.2900n -0.001032 187.3000n -0.001131 187.3100n -0.001235 187.3200n -0.001344 187.3300n -0.001458 187.3400n -0.001576
+ 187.3500n -0.001697 187.3600n -0.001821 187.3700n -0.001947 187.3800n -0.002073 187.3900n -0.002198 187.4000n -0.002320 187.4100n -0.002437 187.4200n -0.002547 187.4300n -0.002648 187.4400n -0.002738 187.4500n -0.002815 187.4600n -0.002877 187.4700n -0.002922 187.4800n -0.002949 187.4900n -0.002955
+ 187.5000n -0.002941 187.5100n -0.002904 187.5200n -0.002846 187.5300n -0.002765 187.5400n -0.002663 187.5500n -0.002539 187.5600n -0.002396 187.5700n -0.002234 187.5800n -0.002057 187.5900n -0.001867 187.6000n -0.001665 187.6100n -0.001457 187.6200n -0.001245 187.6300n -0.001032 187.6400n -0.000823
+ 187.6500n -0.000621 187.6600n -0.000429 187.6700n -0.000253 187.6800n -0.000094 187.6900n 0.000044 187.7000n 0.000158 187.7100n 0.000245 187.7200n 0.000304 187.7300n 0.000333 187.7400n 0.000331 187.7500n 0.000298 187.7600n 0.000234 187.7700n 0.000141 187.7800n 0.000018 187.7900n -0.000130
+ 187.8000n -0.000303 187.8100n -0.000496 187.8200n -0.000707 187.8300n -0.000930 187.8400n -0.001163 187.8500n -0.001400 187.8600n -0.001637 187.8700n -0.001869 187.8800n -0.002091 187.8900n -0.002299 187.9000n -0.002489 187.9100n -0.002657 187.9200n -0.002799 187.9300n -0.002912 187.9400n -0.002993
+ 187.9500n -0.003042 187.9600n -0.003055 187.9700n -0.003034 187.9800n -0.002977 187.9900n -0.002887 188.0000n -0.002763 188.0100n -0.002610 188.0200n -0.002428 188.0300n -0.002222 188.0400n -0.001995 188.0500n -0.001753 188.0600n -0.001498 188.0700n -0.001237 188.0800n -0.000974 188.0900n -0.000715
+ 188.1000n -0.000464 188.1100n -0.000227 188.1200n -0.000007 188.1300n 0.000191 188.1400n 0.000362 188.1500n 0.000504 188.1600n 0.000614 188.1700n 0.000689 188.1800n 0.000729 188.1900n 0.000732 188.2000n 0.000699 188.2100n 0.000630 188.2200n 0.000527 188.2300n 0.000392 188.2400n 0.000227
+ 188.2500n 0.000037 188.2600n -0.000176 188.2700n -0.000407 188.2800n -0.000651 188.2900n -0.000904 188.3000n -0.001159 188.3100n -0.001413 188.3200n -0.001660 188.3300n -0.001894 188.3400n -0.002112 188.3500n -0.002308 188.3600n -0.002479 188.3700n -0.002621 188.3800n -0.002731 188.3900n -0.002807
+ 188.4000n -0.002846 188.4100n -0.002847 188.4200n -0.002810 188.4300n -0.002735 188.4400n -0.002623 188.4500n -0.002475 188.4600n -0.002294 188.4700n -0.002081 188.4800n -0.001840 188.4900n -0.001574 188.5000n -0.001288 188.5100n -0.000985 188.5200n -0.000669 188.5300n -0.000346 188.5400n -0.000019
+ 188.5500n 0.000307 188.5600n 0.000628 188.5700n 0.000940 188.5800n 0.001238 188.5900n 0.001520 188.6000n 0.001782 188.6100n 0.002021 188.6200n 0.002236 188.6300n 0.002424 188.6400n 0.002583 188.6500n 0.002714 188.6600n 0.002816 188.6700n 0.002888 188.6800n 0.002932 188.6900n 0.002947
+ 188.7000n 0.002936 188.7100n 0.002899 188.7200n 0.002839 188.7300n 0.002757 188.7400n 0.002656 188.7500n 0.002537 188.7600n 0.002403 188.7700n 0.002256 188.7800n 0.002099 188.7900n 0.001934 188.8000n 0.001762 188.8100n 0.001585 188.8200n 0.001406 188.8300n 0.001225 188.8400n 0.001044
+ 188.8500n 0.000865 188.8600n 0.000688 188.8700n 0.000513 188.8800n 0.000342 188.8900n 0.000176 188.9000n 0.000013 188.9100n -0.000145 188.9200n -0.000298 188.9300n -0.000447 188.9400n -0.000590 188.9500n -0.000729 188.9600n -0.000863 188.9700n -0.000992 188.9800n -0.001116 188.9900n -0.001234
+ 189.0000n -0.001346 189.0100n -0.001453 189.0200n -0.001552 189.0300n -0.001644 189.0400n -0.001728 189.0500n -0.001804 189.0600n -0.001871 189.0700n -0.001927 189.0800n -0.001973 189.0900n -0.002007 189.1000n -0.002029 189.1100n -0.002038 189.1200n -0.002034 189.1300n -0.002017 189.1400n -0.001986
+ 189.1500n -0.001941 189.1600n -0.001884 189.1700n -0.001813 189.1800n -0.001729 189.1900n -0.001634 189.2000n -0.001528 189.2100n -0.001413 189.2200n -0.001289 189.2300n -0.001159 189.2400n -0.001023 189.2500n -0.000884 189.2600n -0.000743 189.2700n -0.000602 189.2800n -0.000462 189.2900n -0.000326
+ 189.3000n -0.000195 189.3100n -0.000071 189.3200n 0.000046 189.3300n 0.000154 189.3400n 0.000251 189.3500n 0.000338 189.3600n 0.000413 189.3700n 0.000477 189.3800n 0.000529 189.3900n 0.000569 189.4000n 0.000598 189.4100n 0.000616 189.4200n 0.000625 189.4300n 0.000626 189.4400n 0.000618
+ 189.4500n 0.000605 189.4600n 0.000587 189.4700n 0.000565 189.4800n 0.000542 189.4900n 0.000518 189.5000n 0.000495 189.5100n 0.000474 189.5200n 0.000457 189.5300n 0.000443 189.5400n 0.000435 189.5500n 0.000432 189.5600n 0.000435 189.5700n 0.000443 189.5800n 0.000458 189.5900n 0.000479
+ 189.6000n 0.000504 189.6100n 0.000535 189.6200n 0.000568 189.6300n 0.000604 189.6400n 0.000642 189.6500n 0.000679 189.6600n 0.000716 189.6700n 0.000751 189.6800n 0.000782 189.6900n 0.000809 189.7000n 0.000830 189.7100n 0.000845 189.7200n 0.000854 189.7300n 0.000855 189.7400n 0.000849
+ 189.7500n 0.000835 189.7600n 0.000814 189.7700n 0.000787 189.7800n 0.000754 189.7900n 0.000715 189.8000n 0.000674 189.8100n 0.000630 189.8200n 0.000585 189.8300n 0.000541 189.8400n 0.000499 189.8500n 0.000462 189.8600n 0.000430 189.8700n 0.000406 189.8800n 0.000391 189.8900n 0.000386
+ 189.9000n 0.000391 189.9100n 0.000409 189.9200n 0.000439 189.9300n 0.000482 189.9400n 0.000538 189.9500n 0.000606 189.9600n 0.000685 189.9700n 0.000775 189.9800n 0.000873 189.9900n 0.000979 190.0000n 0.001090 190.0100n 0.001204 190.0200n 0.001319 190.0300n 0.001432 190.0400n 0.001541
+ 190.0500n 0.001642 190.0600n 0.001734 190.0700n 0.001814 190.0800n 0.001880 190.0900n 0.001929 190.1000n 0.001961 190.1100n 0.001972 190.1200n 0.001963 190.1300n 0.001933 190.1400n 0.001880 190.1500n 0.001807 190.1600n 0.001712 190.1700n 0.001597 190.1800n 0.001464 190.1900n 0.001314
+ 190.2000n 0.001150 190.2100n 0.000974 190.2200n 0.000789 190.2300n 0.000599 190.2400n 0.000406 190.2500n 0.000214 190.2600n 0.000025 190.2700n -0.000155 190.2800n -0.000326 190.2900n -0.000482 190.3000n -0.000623 190.3100n -0.000745 190.3200n -0.000846 190.3300n -0.000925 190.3400n -0.000982
+ 190.3500n -0.001014 190.3600n -0.001022 190.3700n -0.001007 190.3800n -0.000970 190.3900n -0.000911 190.4000n -0.000834 190.4100n -0.000739 190.4200n -0.000631 190.4300n -0.000511 190.4400n -0.000383 190.4500n -0.000251 190.4600n -0.000117 190.4700n 0.000014 190.4800n 0.000139 190.4900n 0.000255
+ 190.5000n 0.000359 190.5100n 0.000449 190.5200n 0.000521 190.5300n 0.000575 190.5400n 0.000608 190.5500n 0.000620 190.5600n 0.000610 190.5700n 0.000579 190.5800n 0.000528 190.5900n 0.000458 190.6000n 0.000370 190.6100n 0.000267 190.6200n 0.000153 190.6300n 0.000029 190.6400n -0.000100
+ 190.6500n -0.000230 190.6600n -0.000358 190.6700n -0.000480 190.6800n -0.000591 190.6900n -0.000689 190.7000n -0.000768 190.7100n -0.000827 190.7200n -0.000862 190.7300n -0.000871 190.7400n -0.000851 190.7500n -0.000801 190.7600n -0.000721 190.7700n -0.000611 190.7800n -0.000471 190.7900n -0.000301
+ 190.8000n -0.000105 190.8100n 0.000115 190.8200n 0.000357 190.8300n 0.000616 190.8400n 0.000890 190.8500n 0.001172 190.8600n 0.001459 190.8700n 0.001746 190.8800n 0.002027 190.8900n 0.002297 190.9000n 0.002552 190.9100n 0.002787 190.9200n 0.002997 190.9300n 0.003179 190.9400n 0.003328
+ 190.9500n 0.003442 190.9600n 0.003518 190.9700n 0.003554 190.9800n 0.003550 190.9900n 0.003505 191.0000n 0.003420 191.0100n 0.003296 191.0200n 0.003134 191.0300n 0.002938 191.0400n 0.002710 191.0500n 0.002454 191.0600n 0.002175 191.0700n 0.001878 191.0800n 0.001566 191.0900n 0.001246
+ 191.1000n 0.000924 191.1100n 0.000603 191.1200n 0.000290 191.1300n -0.000010 191.1400n -0.000292 191.1500n -0.000552 191.1600n -0.000787 191.1700n -0.000992 191.1800n -0.001165 191.1900n -0.001303 191.2000n -0.001405 191.2100n -0.001470 191.2200n -0.001499 191.2300n -0.001491 191.2400n -0.001448
+ 191.2500n -0.001373 191.2600n -0.001267 191.2700n -0.001133 191.2800n -0.000976 191.2900n -0.000799 191.3000n -0.000606 191.3100n -0.000403 191.3200n -0.000193 191.3300n 0.000019 191.3400n 0.000228 191.3500n 0.000430 191.3600n 0.000620 191.3700n 0.000796 191.3800n 0.000953 191.3900n 0.001088
+ 191.4000n 0.001199 191.4100n 0.001285 191.4200n 0.001344 191.4300n 0.001375 191.4400n 0.001378 191.4500n 0.001354 191.4600n 0.001304 191.4700n 0.001229 191.4800n 0.001132 191.4900n 0.001015 191.5000n 0.000882 191.5100n 0.000735 191.5200n 0.000578 191.5300n 0.000415 191.5400n 0.000249
+ 191.5500n 0.000085 191.5600n -0.000075 191.5700n -0.000226 191.5800n -0.000366 191.5900n -0.000491 191.6000n -0.000599 191.6100n -0.000687 191.6200n -0.000754 191.6300n -0.000799 191.6400n -0.000821 191.6500n -0.000819 191.6600n -0.000794 191.6700n -0.000746 191.6800n -0.000676 191.6900n -0.000587
+ 191.7000n -0.000480 191.7100n -0.000357 191.7200n -0.000222 191.7300n -0.000076 191.7400n 0.000077 191.7500n 0.000233 191.7600n 0.000391 191.7700n 0.000546 191.7800n 0.000696 191.7900n 0.000837 191.8000n 0.000967 191.8100n 0.001084 191.8200n 0.001185 191.8300n 0.001269 191.8400n 0.001333
+ 191.8500n 0.001377 191.8600n 0.001401 191.8700n 0.001403 191.8800n 0.001384 191.8900n 0.001345 191.9000n 0.001285 191.9100n 0.001207 191.9200n 0.001112 191.9300n 0.001000 191.9400n 0.000875 191.9500n 0.000739 191.9600n 0.000593 191.9700n 0.000440 191.9800n 0.000282 191.9900n 0.000121
+ 192.0000n -0.000039 192.0100n -0.000198 192.0200n -0.000352 192.0300n -0.000500 192.0400n -0.000640 192.0500n -0.000771 192.0600n -0.000892 192.0700n -0.001000 192.0800n -0.001097 192.0900n -0.001180 192.1000n -0.001251 192.1100n -0.001308 192.1200n -0.001352 192.1300n -0.001383 192.1400n -0.001403
+ 192.1500n -0.001411 192.1600n -0.001409 192.1700n -0.001398 192.1800n -0.001378 192.1900n -0.001352 192.2000n -0.001320 192.2100n -0.001283 192.2200n -0.001242 192.2300n -0.001200 192.2400n -0.001156 192.2500n -0.001112 192.2600n -0.001069 192.2700n -0.001027 192.2800n -0.000987 192.2900n -0.000950
+ 192.3000n -0.000916 192.3100n -0.000885 192.3200n -0.000858 192.3300n -0.000834 192.3400n -0.000813 192.3500n -0.000796 192.3600n -0.000781 192.3700n -0.000769 192.3800n -0.000759 192.3900n -0.000751 192.4000n -0.000744 192.4100n -0.000738 192.4200n -0.000731 192.4300n -0.000725 192.4400n -0.000717
+ 192.4500n -0.000709 192.4600n -0.000698 192.4700n -0.000686 192.4800n -0.000671 192.4900n -0.000654 192.5000n -0.000634 192.5100n -0.000611 192.5200n -0.000585 192.5300n -0.000557 192.5400n -0.000526 192.5500n -0.000492 192.5600n -0.000456 192.5700n -0.000418 192.5800n -0.000379 192.5900n -0.000338
+ 192.6000n -0.000296 192.6100n -0.000254 192.6200n -0.000212 192.6300n -0.000171 192.6400n -0.000131 192.6500n -0.000092 192.6600n -0.000055 192.6700n -0.000021 192.6800n 0.000010 192.6900n 0.000038 192.7000n 0.000062 192.7100n 0.000081 192.7200n 0.000096 192.7300n 0.000107 192.7400n 0.000113
+ 192.7500n 0.000113 192.7600n 0.000109 192.7700n 0.000099 192.7800n 0.000085 192.7900n 0.000065 192.8000n 0.000042 192.8100n 0.000014 192.8200n -0.000018 192.8300n -0.000053 192.8400n -0.000091 192.8500n -0.000131 192.8600n -0.000173 192.8700n -0.000215 192.8800n -0.000257 192.8900n -0.000298
+ 192.9000n -0.000337 192.9100n -0.000374 192.9200n -0.000408 192.9300n -0.000437 192.9400n -0.000461 192.9500n -0.000479 192.9600n -0.000491 192.9700n -0.000496 192.9800n -0.000493 192.9900n -0.000483 193.0000n -0.000464 193.0100n -0.000438 193.0200n -0.000403 193.0300n -0.000360 193.0400n -0.000309
+ 193.0500n -0.000252 193.0600n -0.000188 193.0700n -0.000118 193.0800n -0.000044 193.0900n 0.000034 193.1000n 0.000114 193.1100n 0.000195 193.1200n 0.000276 193.1300n 0.000354 193.1400n 0.000430 193.1500n 0.000500 193.1600n 0.000564 193.1700n 0.000621 193.1800n 0.000668 193.1900n 0.000704
+ 193.2000n 0.000729 193.2100n 0.000742 193.2200n 0.000741 193.2300n 0.000727 193.2400n 0.000698 193.2500n 0.000655 193.2600n 0.000598 193.2700n 0.000528 193.2800n 0.000444 193.2900n 0.000348 193.3000n 0.000242 193.3100n 0.000125 193.3200n 0.000001 193.3300n -0.000130 193.3400n -0.000265
+ 193.3500n -0.000403 193.3600n -0.000542 193.3700n -0.000678 193.3800n -0.000811 193.3900n -0.000939 193.4000n -0.001058 193.4100n -0.001169 193.4200n -0.001268 193.4300n -0.001354 193.4400n -0.001426 193.4500n -0.001484 193.4600n -0.001526 193.4700n -0.001552 193.4800n -0.001562 193.4900n -0.001556
+ 193.5000n -0.001534 193.5100n -0.001498 193.5200n -0.001449 193.5300n -0.001387 193.5400n -0.001315 193.5500n -0.001234 193.5600n -0.001146 193.5700n -0.001053 193.5800n -0.000957 193.5900n -0.000861 193.6000n -0.000766 193.6100n -0.000675 193.6200n -0.000590 193.6300n -0.000511 193.6400n -0.000441
+ 193.6500n -0.000382 193.6600n -0.000333 193.6700n -0.000296 193.6800n -0.000270 193.6900n -0.000257 193.7000n -0.000255 193.7100n -0.000265 193.7200n -0.000284 193.7300n -0.000312 193.7400n -0.000346 193.7500n -0.000386 193.7600n -0.000428 193.7700n -0.000471 193.7800n -0.000512 193.7900n -0.000549
+ 193.8000n -0.000579 193.8100n -0.000599 193.8200n -0.000608 193.8300n -0.000603 193.8400n -0.000583 193.8500n -0.000545 193.8600n -0.000489 193.8700n -0.000413 193.8800n -0.000317 193.8900n -0.000201 193.9000n -0.000065 193.9100n 0.000091 193.9200n 0.000264 193.9300n 0.000453 193.9400n 0.000656
+ 193.9500n 0.000871 193.9600n 0.001095 193.9700n 0.001325 193.9800n 0.001557 193.9900n 0.001787 194.0000n 0.002013 194.0100n 0.002230 194.0200n 0.002434 194.0300n 0.002623 194.0400n 0.002792 194.0500n 0.002939 194.0600n 0.003060 194.0700n 0.003154 194.0800n 0.003217 194.0900n 0.003249
+ 194.1000n 0.003249 194.1100n 0.003215 194.1200n 0.003148 194.1300n 0.003048 194.1400n 0.002917 194.1500n 0.002756 194.1600n 0.002568 194.1700n 0.002355 194.1800n 0.002120 194.1900n 0.001867 194.2000n 0.001600 194.2100n 0.001323 194.2200n 0.001041 194.2300n 0.000757 194.2400n 0.000476
+ 194.2500n 0.000203 194.2600n -0.000059 194.2700n -0.000304 194.2800n -0.000530 194.2900n -0.000733 194.3000n -0.000910 194.3100n -0.001058 194.3200n -0.001176 194.3300n -0.001262 194.3400n -0.001315 194.3500n -0.001335 194.3600n -0.001322 194.3700n -0.001278 194.3800n -0.001203 194.3900n -0.001100
+ 194.4000n -0.000971 194.4100n -0.000819 194.4200n -0.000648 194.4300n -0.000460 194.4400n -0.000261 194.4500n -0.000053 194.4600n 0.000158 194.4700n 0.000369 194.4800n 0.000576 194.4900n 0.000774 194.5000n 0.000960 194.5100n 0.001131 194.5200n 0.001284 194.5300n 0.001414 194.5400n 0.001522
+ 194.5500n 0.001604 194.5600n 0.001659 194.5700n 0.001686 194.5800n 0.001686 194.5900n 0.001658 194.6000n 0.001604 194.6100n 0.001523 194.6200n 0.001419 194.6300n 0.001293 194.6400n 0.001148 194.6500n 0.000985 194.6600n 0.000810 194.6700n 0.000623 194.6800n 0.000430 194.6900n 0.000233
+ 194.7000n 0.000036 194.7100n -0.000158 194.7200n -0.000346 194.7300n -0.000525 194.7400n -0.000692 194.7500n -0.000844 194.7600n -0.000980 194.7700n -0.001096 194.7800n -0.001193 194.7900n -0.001269 194.8000n -0.001323 194.8100n -0.001355 194.8200n -0.001365 194.8300n -0.001354 194.8400n -0.001322
+ 194.8500n -0.001271 194.8600n -0.001202 194.8700n -0.001117 194.8800n -0.001019 194.8900n -0.000908 194.9000n -0.000788 194.9100n -0.000661 194.9200n -0.000530 194.9300n -0.000397 194.9400n -0.000264 194.9500n -0.000133 194.9600n -0.000008 194.9700n 0.000110 194.9800n 0.000219 194.9900n 0.000317
+ 195.0000n 0.000403 195.0100n 0.000476 195.0200n 0.000534 195.0300n 0.000577 195.0400n 0.000605 195.0500n 0.000617 195.0600n 0.000613 195.0700n 0.000594 195.0800n 0.000560 195.0900n 0.000512 195.1000n 0.000450 195.1100n 0.000377 195.1200n 0.000292 195.1300n 0.000198 195.1400n 0.000096
+ 195.1500n -0.000013 195.1600n -0.000128 195.1700n -0.000246 195.1800n -0.000366 195.1900n -0.000487 195.2000n -0.000608 195.2100n -0.000726 195.2200n -0.000841 195.2300n -0.000951 195.2400n -0.001056 195.2500n -0.001153 195.2600n -0.001243 195.2700n -0.001324 195.2800n -0.001396 195.2900n -0.001458
+ 195.3000n -0.001510 195.3100n -0.001551 195.3200n -0.001581 195.3300n -0.001600 195.3400n -0.001607 195.3500n -0.001604 195.3600n -0.001591 195.3700n -0.001566 195.3800n -0.001532 195.3900n -0.001489 195.4000n -0.001437 195.4100n -0.001376 195.4200n -0.001308 195.4300n -0.001234 195.4400n -0.001153
+ 195.4500n -0.001068 195.4600n -0.000979 195.4700n -0.000887 195.4800n -0.000793 195.4900n -0.000699 195.5000n -0.000604 195.5100n -0.000510 195.5200n -0.000419 195.5300n -0.000330 195.5400n -0.000245 195.5500n -0.000164 195.5600n -0.000088 195.5700n -0.000018 195.5800n 0.000046 195.5900n 0.000103
+ 195.6000n 0.000154 195.6100n 0.000198 195.6200n 0.000235 195.6300n 0.000266 195.6400n 0.000291 195.6500n 0.000310 195.6600n 0.000324 195.6700n 0.000334 195.6800n 0.000340 195.6900n 0.000343 195.7000n 0.000344 195.7100n 0.000345 195.7200n 0.000345 195.7300n 0.000347 195.7400n 0.000351
+ 195.7500n 0.000358 195.7600n 0.000369 195.7700n 0.000384 195.7800n 0.000405 195.7900n 0.000431 195.8000n 0.000463 195.8100n 0.000501 195.8200n 0.000544 195.8300n 0.000594 195.8400n 0.000648 195.8500n 0.000707 195.8600n 0.000769 195.8700n 0.000833 195.8800n 0.000897 195.8900n 0.000962
+ 195.9000n 0.001023 195.9100n 0.001080 195.9200n 0.001132 195.9300n 0.001175 195.9400n 0.001208 195.9500n 0.001229 195.9600n 0.001237 195.9700n 0.001229 195.9800n 0.001204 195.9900n 0.001161 196.0000n 0.001098 196.0100n 0.001014 196.0200n 0.000910 196.0300n 0.000784 196.0400n 0.000637
+ 196.0500n 0.000469 196.0600n 0.000280 196.0700n 0.000073 196.0800n -0.000151 196.0900n -0.000392 196.1000n -0.000645 196.1100n -0.000910 196.1200n -0.001182 196.1300n -0.001460 196.1400n -0.001740 196.1500n -0.002019 196.1600n -0.002293 196.1700n -0.002558 196.1800n -0.002812 196.1900n -0.003052
+ 196.2000n -0.003273 196.2100n -0.003473 196.2200n -0.003649 196.2300n -0.003799 196.2400n -0.003921 196.2500n -0.004012 196.2600n -0.004072 196.2700n -0.004100 196.2800n -0.004095 196.2900n -0.004057 196.3000n -0.003986 196.3100n -0.003884 196.3200n -0.003752 196.3300n -0.003591 196.3400n -0.003404
+ 196.3500n -0.003192 196.3600n -0.002960 196.3700n -0.002709 196.3800n -0.002443 196.3900n -0.002165 196.4000n -0.001879 196.4100n -0.001587 196.4200n -0.001294 196.4300n -0.001002 196.4400n -0.000715 196.4500n -0.000435 196.4600n -0.000166 196.4700n 0.000091 196.4800n 0.000333 196.4900n 0.000559
+ 196.5000n 0.000766 196.5100n 0.000955 196.5200n 0.001125 196.5300n 0.001274 196.5400n 0.001404 196.5500n 0.001514 196.5600n 0.001606 196.5700n 0.001680 196.5800n 0.001737 196.5900n 0.001779 196.6000n 0.001808 196.6100n 0.001825 196.6200n 0.001831 196.6300n 0.001829 196.6400n 0.001820
+ 196.6500n 0.001806 196.6600n 0.001788 196.6700n 0.001768 196.6800n 0.001747 196.6900n 0.001726 196.7000n 0.001706 196.7100n 0.001687 196.7200n 0.001669 196.7300n 0.001653 196.7400n 0.001638 196.7500n 0.001625 196.7600n 0.001612 196.7700n 0.001598 196.7800n 0.001583 196.7900n 0.001566
+ 196.8000n 0.001545 196.8100n 0.001520 196.8200n 0.001490 196.8300n 0.001452 196.8400n 0.001407 196.8500n 0.001353 196.8600n 0.001290 196.8700n 0.001217 196.8800n 0.001133 196.8900n 0.001039 196.9000n 0.000935 196.9100n 0.000821 196.9200n 0.000697 196.9300n 0.000565 196.9400n 0.000426
+ 196.9500n 0.000280 196.9600n 0.000130 196.9700n -0.000023 196.9800n -0.000177 196.9900n -0.000329 197.0000n -0.000479 197.0100n -0.000623 197.0200n -0.000760 197.0300n -0.000888 197.0400n -0.001004 197.0500n -0.001107 197.0600n -0.001196 197.0700n -0.001268 197.0800n -0.001322 197.0900n -0.001359
+ 197.1000n -0.001376 197.1100n -0.001373 197.1200n -0.001351 197.1300n -0.001309 197.1400n -0.001248 197.1500n -0.001169 197.1600n -0.001072 197.1700n -0.000960 197.1800n -0.000833 197.1900n -0.000694 197.2000n -0.000545 197.2100n -0.000386 197.2200n -0.000222 197.2300n -0.000053 197.2400n 0.000118
+ 197.2500n 0.000288 197.2600n 0.000455 197.2700n 0.000618 197.2800n 0.000774 197.2900n 0.000921 197.3000n 0.001058 197.3100n 0.001183 197.3200n 0.001295 197.3300n 0.001392 197.3400n 0.001475 197.3500n 0.001541 197.3600n 0.001592 197.3700n 0.001626 197.3800n 0.001645 197.3900n 0.001647
+ 197.4000n 0.001634 197.4100n 0.001606 197.4200n 0.001565 197.4300n 0.001510 197.4400n 0.001444 197.4500n 0.001366 197.4600n 0.001279 197.4700n 0.001184 197.4800n 0.001081 197.4900n 0.000972 197.5000n 0.000858 197.5100n 0.000741 197.5200n 0.000621 197.5300n 0.000499 197.5400n 0.000377
+ 197.5500n 0.000254 197.5600n 0.000133 197.5700n 0.000014 197.5800n -0.000103 197.5900n -0.000217 197.6000n -0.000328 197.6100n -0.000434 197.6200n -0.000537 197.6300n -0.000634 197.6400n -0.000726 197.6500n -0.000813 197.6600n -0.000894 197.6700n -0.000969 197.6800n -0.001037 197.6900n -0.001099
+ 197.7000n -0.001153 197.7100n -0.001201 197.7200n -0.001240 197.7300n -0.001271 197.7400n -0.001294 197.7500n -0.001308 197.7600n -0.001314 197.7700n -0.001310 197.7800n -0.001297 197.7900n -0.001274 197.8000n -0.001242 197.8100n -0.001200 197.8200n -0.001148 197.8300n -0.001088 197.8400n -0.001018
+ 197.8500n -0.000940 197.8600n -0.000854 197.8700n -0.000760 197.8800n -0.000660 197.8900n -0.000553 197.9000n -0.000442 197.9100n -0.000326 197.9200n -0.000208 197.9300n -0.000087 197.9400n 0.000034 197.9500n 0.000154 197.9600n 0.000273 197.9700n 0.000388 197.9800n 0.000500 197.9900n 0.000606
+ 198.0000n 0.000706 198.0100n 0.000799 198.0200n 0.000883 198.0300n 0.000959 198.0400n 0.001025 198.0500n 0.001080 198.0600n 0.001125 198.0700n 0.001159 198.0800n 0.001182 198.0900n 0.001194 198.1000n 0.001195 198.1100n 0.001186 198.1200n 0.001167 198.1300n 0.001138 198.1400n 0.001100
+ 198.1500n 0.001053 198.1600n 0.000999 198.1700n 0.000939 198.1800n 0.000872 198.1900n 0.000800 198.2000n 0.000724 198.2100n 0.000645 198.2200n 0.000563 198.2300n 0.000478 198.2400n 0.000393 198.2500n 0.000307 198.2600n 0.000222 198.2700n 0.000137 198.2800n 0.000052 198.2900n -0.000030
+ 198.3000n -0.000111 198.3100n -0.000189 198.3200n -0.000265 198.3300n -0.000339 198.3400n -0.000409 198.3500n -0.000476 198.3600n -0.000540 198.3700n -0.000600 198.3800n -0.000656 198.3900n -0.000707 198.4000n -0.000754 198.4100n -0.000796 198.4200n -0.000833 198.4300n -0.000863 198.4400n -0.000888
+ 198.4500n -0.000905 198.4600n -0.000915 198.4700n -0.000918 198.4800n -0.000911 198.4900n -0.000896 198.5000n -0.000871 198.5100n -0.000837 198.5200n -0.000792 198.5300n -0.000738 198.5400n -0.000672 198.5500n -0.000597 198.5600n -0.000511 198.5700n -0.000416 198.5800n -0.000312 198.5900n -0.000199
+ 198.6000n -0.000078 198.6100n 0.000048 198.6200n 0.000180 198.6300n 0.000315 198.6400n 0.000453 198.6500n 0.000590 198.6600n 0.000726 198.6700n 0.000858 198.6800n 0.000985 198.6900n 0.001104 198.7000n 0.001213 198.7100n 0.001311 198.7200n 0.001395 198.7300n 0.001465 198.7400n 0.001518
+ 198.7500n 0.001553 198.7600n 0.001569 198.7700n 0.001566 198.7800n 0.001543 198.7900n 0.001500 198.8000n 0.001437 198.8100n 0.001355 198.8200n 0.001255 198.8300n 0.001139 198.8400n 0.001007 198.8500n 0.000862 198.8600n 0.000706 198.8700n 0.000541 198.8800n 0.000371 198.8900n 0.000199
+ 198.9000n 0.000027 198.9100n -0.000142 198.9200n -0.000304 198.9300n -0.000456 198.9400n -0.000596 198.9500n -0.000720 198.9600n -0.000827 198.9700n -0.000912 198.9800n -0.000976 198.9900n -0.001016 199.0000n -0.001030 199.0100n -0.001019 199.0200n -0.000981 199.0300n -0.000917 199.0400n -0.000828
+ 199.0500n -0.000714 199.0600n -0.000578 199.0700n -0.000421 199.0800n -0.000245 199.0900n -0.000053 199.1000n 0.000152 199.1100n 0.000367 199.1200n 0.000587 199.1300n 0.000811 199.1400n 0.001033 199.1500n 0.001251 199.1600n 0.001461 199.1700n 0.001659 199.1800n 0.001842 199.1900n 0.002008
+ 199.2000n 0.002154 199.2100n 0.002277 199.2200n 0.002376 199.2300n 0.002450 199.2400n 0.002496 199.2500n 0.002516 199.2600n 0.002509 199.2700n 0.002476 199.2800n 0.002417 199.2900n 0.002335 199.3000n 0.002230 199.3100n 0.002106 199.3200n 0.001964 199.3300n 0.001808 199.3400n 0.001641
+ 199.3500n 0.001465 199.3600n 0.001285 199.3700n 0.001102 199.3800n 0.000922 199.3900n 0.000746 199.4000n 0.000577 199.4100n 0.000418 199.4200n 0.000272 199.4300n 0.000141 199.4400n 0.000025 199.4500n -0.000072 199.4600n -0.000152 199.4700n -0.000212 199.4800n -0.000254 199.4900n -0.000277
+ 199.5000n -0.000282 199.5100n -0.000271 199.5200n -0.000244 199.5300n -0.000204 199.5400n -0.000153 199.5500n -0.000093 199.5600n -0.000026 199.5700n 0.000046 199.5800n 0.000119 199.5900n 0.000191 199.6000n 0.000260 199.6100n 0.000324 199.6200n 0.000380 199.6300n 0.000427 199.6400n 0.000464
+ 199.6500n 0.000488 199.6600n 0.000499 199.6700n 0.000496 199.6800n 0.000479 199.6900n 0.000448 199.7000n 0.000404 199.7100n 0.000347 199.7200n 0.000277 199.7300n 0.000197 199.7400n 0.000108 199.7500n 0.000012 199.7600n -0.000091 199.7700n -0.000196 199.7800n -0.000304 199.7900n -0.000411
+ 199.8000n -0.000516 199.8100n -0.000617 199.8200n -0.000711 199.8300n -0.000798 199.8400n -0.000877 199.8500n -0.000945 199.8600n -0.001001 199.8700n -0.001047 199.8800n -0.001080 199.8900n -0.001101 199.9000n -0.001110 199.9100n -0.001107 199.9200n -0.001094 199.9300n -0.001071 199.9400n -0.001038
+ 199.9500n -0.000999 199.9600n -0.000953 199.9700n -0.000902 199.9800n -0.000849 199.9900n -0.000794 200.0000n -0.000740 )
V_NOISE_N b1_src b_cm DC 0 PWL ( 0.0000n -0.001424 0.0100n -0.001341 0.0200n -0.001261 0.0300n -0.001185 0.0400n -0.001114 0.0500n -0.001047 0.0600n -0.000983 0.0700n -0.000922 0.0800n -0.000863 0.0900n -0.000805 0.1000n -0.000747 0.1100n -0.000688 0.1200n -0.000627 0.1300n -0.000561 0.1400n -0.000491
+ 0.1500n -0.000415 0.1600n -0.000331 0.1700n -0.000240 0.1800n -0.000141 0.1900n -0.000032 0.2000n 0.000086 0.2100n 0.000213 0.2200n 0.000349 0.2300n 0.000493 0.2400n 0.000645 0.2500n 0.000803 0.2600n 0.000967 0.2700n 0.001135 0.2800n 0.001305 0.2900n 0.001476
+ 0.3000n 0.001645 0.3100n 0.001811 0.3200n 0.001973 0.3300n 0.002127 0.3400n 0.002273 0.3500n 0.002408 0.3600n 0.002530 0.3700n 0.002640 0.3800n 0.002734 0.3900n 0.002812 0.4000n 0.002874 0.4100n 0.002919 0.4200n 0.002946 0.4300n 0.002957 0.4400n 0.002950
+ 0.4500n 0.002928 0.4600n 0.002890 0.4700n 0.002839 0.4800n 0.002776 0.4900n 0.002702 0.5000n 0.002619 0.5100n 0.002531 0.5200n 0.002437 0.5300n 0.002342 0.5400n 0.002247 0.5500n 0.002154 0.5600n 0.002066 0.5700n 0.001985 0.5800n 0.001912 0.5900n 0.001850
+ 0.6000n 0.001799 0.6100n 0.001762 0.6200n 0.001739 0.6300n 0.001731 0.6400n 0.001738 0.6500n 0.001761 0.6600n 0.001799 0.6700n 0.001851 0.6800n 0.001916 0.6900n 0.001994 0.7000n 0.002082 0.7100n 0.002180 0.7200n 0.002284 0.7300n 0.002394 0.7400n 0.002505
+ 0.7500n 0.002617 0.7600n 0.002726 0.7700n 0.002829 0.7800n 0.002925 0.7900n 0.003010 0.8000n 0.003083 0.8100n 0.003141 0.8200n 0.003182 0.8300n 0.003203 0.8400n 0.003205 0.8500n 0.003185 0.8600n 0.003142 0.8700n 0.003075 0.8800n 0.002985 0.8900n 0.002872
+ 0.9000n 0.002736 0.9100n 0.002578 0.9200n 0.002398 0.9300n 0.002199 0.9400n 0.001983 0.9500n 0.001750 0.9600n 0.001505 0.9700n 0.001249 0.9800n 0.000986 0.9900n 0.000717 1.0000n 0.000447 1.0100n 0.000178 1.0200n -0.000087 1.0300n -0.000344 1.0400n -0.000591
+ 1.0500n -0.000824 1.0600n -0.001042 1.0700n -0.001242 1.0800n -0.001421 1.0900n -0.001578 1.1000n -0.001711 1.1100n -0.001819 1.1200n -0.001902 1.1300n -0.001958 1.1400n -0.001988 1.1500n -0.001991 1.1600n -0.001970 1.1700n -0.001924 1.1800n -0.001856 1.1900n -0.001767
+ 1.2000n -0.001659 1.2100n -0.001535 1.2200n -0.001397 1.2300n -0.001248 1.2400n -0.001092 1.2500n -0.000930 1.2600n -0.000766 1.2700n -0.000604 1.2800n -0.000446 1.2900n -0.000295 1.3000n -0.000154 1.3100n -0.000026 1.3200n 0.000087 1.3300n 0.000183 1.3400n 0.000261
+ 1.3500n 0.000318 1.3600n 0.000354 1.3700n 0.000369 1.3800n 0.000361 1.3900n 0.000332 1.4000n 0.000282 1.4100n 0.000212 1.4200n 0.000123 1.4300n 0.000017 1.4400n -0.000103 1.4500n -0.000236 1.4600n -0.000380 1.4700n -0.000530 1.4800n -0.000684 1.4900n -0.000840
+ 1.5000n -0.000993 1.5100n -0.001142 1.5200n -0.001282 1.5300n -0.001412 1.5400n -0.001528 1.5500n -0.001628 1.5600n -0.001710 1.5700n -0.001771 1.5800n -0.001811 1.5900n -0.001829 1.6000n -0.001823 1.6100n -0.001793 1.6200n -0.001740 1.6300n -0.001664 1.6400n -0.001567
+ 1.6500n -0.001449 1.6600n -0.001313 1.6700n -0.001160 1.6800n -0.000994 1.6900n -0.000816 1.7000n -0.000631 1.7100n -0.000441 1.7200n -0.000249 1.7300n -0.000060 1.7400n 0.000125 1.7500n 0.000301 1.7600n 0.000466 1.7700n 0.000616 1.7800n 0.000750 1.7900n 0.000864
+ 1.8000n 0.000957 1.8100n 0.001026 1.8200n 0.001072 1.8300n 0.001092 1.8400n 0.001088 1.8500n 0.001059 1.8600n 0.001005 1.8700n 0.000929 1.8800n 0.000830 1.8900n 0.000713 1.9000n 0.000578 1.9100n 0.000429 1.9200n 0.000269 1.9300n 0.000100 1.9400n -0.000073
+ 1.9500n -0.000248 1.9600n -0.000420 1.9700n -0.000586 1.9800n -0.000743 1.9900n -0.000887 2.0000n -0.001016 2.0100n -0.001125 2.0200n -0.001214 2.0300n -0.001280 2.0400n -0.001321 2.0500n -0.001335 2.0600n -0.001323 2.0700n -0.001283 2.0800n -0.001217 2.0900n -0.001124
+ 2.1000n -0.001006 2.1100n -0.000865 2.1200n -0.000702 2.1300n -0.000520 2.1400n -0.000322 2.1500n -0.000111 2.1600n 0.000110 2.1700n 0.000337 2.1800n 0.000567 2.1900n 0.000795 2.2000n 0.001019 2.2100n 0.001234 2.2200n 0.001437 2.2300n 0.001624 2.2400n 0.001794
+ 2.2500n 0.001942 2.2600n 0.002067 2.2700n 0.002166 2.2800n 0.002237 2.2900n 0.002281 2.3000n 0.002296 2.3100n 0.002281 2.3200n 0.002238 2.3300n 0.002166 2.3400n 0.002067 2.3500n 0.001942 2.3600n 0.001794 2.3700n 0.001625 2.3800n 0.001437 2.3900n 0.001233
+ 2.4000n 0.001016 2.4100n 0.000790 2.4200n 0.000557 2.4300n 0.000322 2.4400n 0.000088 2.4500n -0.000142 2.4600n -0.000365 2.4700n -0.000578 2.4800n -0.000777 2.4900n -0.000961 2.5000n -0.001126 2.5100n -0.001271 2.5200n -0.001394 2.5300n -0.001493 2.5400n -0.001568
+ 2.5500n -0.001617 2.5600n -0.001641 2.5700n -0.001640 2.5800n -0.001613 2.5900n -0.001562 2.6000n -0.001488 2.6100n -0.001391 2.6200n -0.001274 2.6300n -0.001138 2.6400n -0.000985 2.6500n -0.000818 2.6600n -0.000638 2.6700n -0.000449 2.6800n -0.000252 2.6900n -0.000050
+ 2.7000n 0.000155 2.7100n 0.000360 2.7200n 0.000562 2.7300n 0.000760 2.7400n 0.000951 2.7500n 0.001133 2.7600n 0.001304 2.7700n 0.001462 2.7800n 0.001607 2.7900n 0.001736 2.8000n 0.001848 2.8100n 0.001942 2.8200n 0.002018 2.8300n 0.002075 2.8400n 0.002112
+ 2.8500n 0.002129 2.8600n 0.002127 2.8700n 0.002105 2.8800n 0.002065 2.8900n 0.002005 2.9000n 0.001928 2.9100n 0.001834 2.9200n 0.001725 2.9300n 0.001601 2.9400n 0.001464 2.9500n 0.001315 2.9600n 0.001156 2.9700n 0.000988 2.9800n 0.000814 2.9900n 0.000635
+ 3.0000n 0.000453 3.0100n 0.000269 3.0200n 0.000086 3.0300n -0.000095 3.0400n -0.000271 3.0500n -0.000442 3.0600n -0.000605 3.0700n -0.000760 3.0800n -0.000903 3.0900n -0.001036 3.1000n -0.001155 3.1100n -0.001261 3.1200n -0.001352 3.1300n -0.001428 3.1400n -0.001489
+ 3.1500n -0.001534 3.1600n -0.001564 3.1700n -0.001579 3.1800n -0.001579 3.1900n -0.001565 3.2000n -0.001538 3.2100n -0.001500 3.2200n -0.001450 3.2300n -0.001392 3.2400n -0.001326 3.2500n -0.001254 3.2600n -0.001177 3.2700n -0.001098 3.2800n -0.001017 3.2900n -0.000938
+ 3.3000n -0.000860 3.3100n -0.000786 3.3200n -0.000717 3.3300n -0.000655 3.3400n -0.000599 3.3500n -0.000552 3.3600n -0.000513 3.3700n -0.000484 3.3800n -0.000463 3.3900n -0.000452 3.4000n -0.000448 3.4100n -0.000453 3.4200n -0.000465 3.4300n -0.000482 3.4400n -0.000504
+ 3.4500n -0.000530 3.4600n -0.000557 3.4700n -0.000583 3.4800n -0.000608 3.4900n -0.000630 3.5000n -0.000646 3.5100n -0.000655 3.5200n -0.000656 3.5300n -0.000647 3.5400n -0.000628 3.5500n -0.000596 3.5600n -0.000552 3.5700n -0.000495 3.5800n -0.000425 3.5900n -0.000342
+ 3.6000n -0.000248 3.6100n -0.000142 3.6200n -0.000026 3.6300n 0.000099 3.6400n 0.000231 3.6500n 0.000367 3.6600n 0.000505 3.6700n 0.000644 3.6800n 0.000779 3.6900n 0.000910 3.7000n 0.001033 3.7100n 0.001145 3.7200n 0.001243 3.7300n 0.001326 3.7400n 0.001391
+ 3.7500n 0.001436 3.7600n 0.001459 3.7700n 0.001459 3.7800n 0.001435 3.7900n 0.001386 3.8000n 0.001311 3.8100n 0.001212 3.8200n 0.001088 3.8300n 0.000941 3.8400n 0.000773 3.8500n 0.000584 3.8600n 0.000378 3.8700n 0.000156 3.8800n -0.000077 3.8900n -0.000320
+ 3.9000n -0.000568 3.9100n -0.000819 3.9200n -0.001068 3.9300n -0.001312 3.9400n -0.001548 3.9500n -0.001773 3.9600n -0.001982 3.9700n -0.002174 3.9800n -0.002345 3.9900n -0.002494 4.0000n -0.002617 4.0100n -0.002714 4.0200n -0.002784 4.0300n -0.002825 4.0400n -0.002838
+ 4.0500n -0.002822 4.0600n -0.002779 4.0700n -0.002709 4.0800n -0.002614 4.0900n -0.002496 4.1000n -0.002356 4.1100n -0.002197 4.1200n -0.002022 4.1300n -0.001833 4.1400n -0.001633 4.1500n -0.001425 4.1600n -0.001211 4.1700n -0.000995 4.1800n -0.000779 4.1900n -0.000565
+ 4.2000n -0.000355 4.2100n -0.000152 4.2200n 0.000042 4.2300n 0.000227 4.2400n 0.000402 4.2500n 0.000565 4.2600n 0.000716 4.2700n 0.000855 4.2800n 0.000982 4.2900n 0.001097 4.3000n 0.001202 4.3100n 0.001297 4.3200n 0.001382 4.3300n 0.001460 4.3400n 0.001530
+ 4.3500n 0.001595 4.3600n 0.001655 4.3700n 0.001711 4.3800n 0.001764 4.3900n 0.001814 4.4000n 0.001864 4.4100n 0.001911 4.4200n 0.001958 4.4300n 0.002003 4.4400n 0.002047 4.4500n 0.002088 4.4600n 0.002126 4.4700n 0.002159 4.4800n 0.002188 4.4900n 0.002209
+ 4.5000n 0.002222 4.5100n 0.002226 4.5200n 0.002218 4.5300n 0.002198 4.5400n 0.002163 4.5500n 0.002113 4.5600n 0.002047 4.5700n 0.001964 4.5800n 0.001862 4.5900n 0.001743 4.6000n 0.001606 4.6100n 0.001452 4.6200n 0.001281 4.6300n 0.001094 4.6400n 0.000894
+ 4.6500n 0.000682 4.6600n 0.000460 4.6700n 0.000231 4.6800n -0.000003 4.6900n -0.000238 4.7000n -0.000471 4.7100n -0.000699 4.7200n -0.000919 4.7300n -0.001127 4.7400n -0.001321 4.7500n -0.001496 4.7600n -0.001651 4.7700n -0.001783 4.7800n -0.001890 4.7900n -0.001969
+ 4.8000n -0.002020 4.8100n -0.002042 4.8200n -0.002034 4.8300n -0.001997 4.8400n -0.001930 4.8500n -0.001836 4.8600n -0.001715 4.8700n -0.001571 4.8800n -0.001404 4.8900n -0.001219 4.9000n -0.001019 4.9100n -0.000806 4.9200n -0.000584 4.9300n -0.000359 4.9400n -0.000132
+ 4.9500n 0.000092 4.9600n 0.000309 4.9700n 0.000515 4.9800n 0.000708 4.9900n 0.000884 5.0000n 0.001041 5.0100n 0.001176 5.0200n 0.001287 5.0300n 0.001373 5.0400n 0.001433 5.0500n 0.001466 5.0600n 0.001473 5.0700n 0.001455 5.0800n 0.001411 5.0900n 0.001344
+ 5.1000n 0.001256 5.1100n 0.001148 5.1200n 0.001023 5.1300n 0.000883 5.1400n 0.000733 5.1500n 0.000573 5.1600n 0.000408 5.1700n 0.000240 5.1800n 0.000073 5.1900n -0.000093 5.2000n -0.000253 5.2100n -0.000406 5.2200n -0.000550 5.2300n -0.000683 5.2400n -0.000805
+ 5.2500n -0.000914 5.2600n -0.001011 5.2700n -0.001095 5.2800n -0.001167 5.2900n -0.001227 5.3000n -0.001277 5.3100n -0.001317 5.3200n -0.001349 5.3300n -0.001375 5.3400n -0.001396 5.3500n -0.001414 5.3600n -0.001432 5.3700n -0.001450 5.3800n -0.001470 5.3900n -0.001494
+ 5.4000n -0.001523 5.4100n -0.001557 5.4200n -0.001598 5.4300n -0.001645 5.4400n -0.001699 5.4500n -0.001759 5.4600n -0.001824 5.4700n -0.001894 5.4800n -0.001967 5.4900n -0.002041 5.5000n -0.002115 5.5100n -0.002186 5.5200n -0.002253 5.5300n -0.002314 5.5400n -0.002366
+ 5.5500n -0.002407 5.5600n -0.002435 5.5700n -0.002448 5.5800n -0.002445 5.5900n -0.002425 5.6000n -0.002385 5.6100n -0.002327 5.6200n -0.002249 5.6300n -0.002153 5.6400n -0.002037 5.6500n -0.001904 5.6600n -0.001756 5.6700n -0.001593 5.6800n -0.001419 5.6900n -0.001235
+ 5.7000n -0.001045 5.7100n -0.000853 5.7200n -0.000660 5.7300n -0.000471 5.7400n -0.000289 5.7500n -0.000117 5.7600n 0.000042 5.7700n 0.000184 5.7800n 0.000306 5.7900n 0.000407 5.8000n 0.000484 5.8100n 0.000536 5.8200n 0.000561 5.8300n 0.000560 5.8400n 0.000531
+ 5.8500n 0.000475 5.8600n 0.000394 5.8700n 0.000288 5.8800n 0.000161 5.8900n 0.000013 5.9000n -0.000151 5.9100n -0.000329 5.9200n -0.000517 5.9300n -0.000712 5.9400n -0.000909 5.9500n -0.001104 5.9600n -0.001294 5.9700n -0.001475 5.9800n -0.001643 5.9900n -0.001795
+ 6.0000n -0.001927 6.0100n -0.002037 6.0200n -0.002122 6.0300n -0.002181 6.0400n -0.002213 6.0500n -0.002216 6.0600n -0.002190 6.0700n -0.002136 6.0800n -0.002054 6.0900n -0.001946 6.1000n -0.001814 6.1100n -0.001659 6.1200n -0.001485 6.1300n -0.001293 6.1400n -0.001088
+ 6.1500n -0.000873 6.1600n -0.000651 6.1700n -0.000425 6.1800n -0.000200 6.1900n 0.000023 6.2000n 0.000238 6.2100n 0.000445 6.2200n 0.000639 6.2300n 0.000819 6.2400n 0.000984 6.2500n 0.001130 6.2600n 0.001259 6.2700n 0.001368 6.2800n 0.001457 6.2900n 0.001528
+ 6.3000n 0.001581 6.3100n 0.001616 6.3200n 0.001636 6.3300n 0.001641 6.3400n 0.001634 6.3500n 0.001616 6.3600n 0.001590 6.3700n 0.001558 6.3800n 0.001522 6.3900n 0.001484 6.4000n 0.001446 6.4100n 0.001410 6.4200n 0.001377 6.4300n 0.001349 6.4400n 0.001326
+ 6.4500n 0.001309 6.4600n 0.001298 6.4700n 0.001293 6.4800n 0.001294 6.4900n 0.001300 6.5000n 0.001311 6.5100n 0.001324 6.5200n 0.001338 6.5300n 0.001352 6.5400n 0.001364 6.5500n 0.001372 6.5600n 0.001375 6.5700n 0.001371 6.5800n 0.001357 6.5900n 0.001334
+ 6.6000n 0.001299 6.6100n 0.001252 6.6200n 0.001192 6.6300n 0.001119 6.6400n 0.001032 6.6500n 0.000934 6.6600n 0.000823 6.6700n 0.000702 6.6800n 0.000572 6.6900n 0.000435 6.7000n 0.000292 6.7100n 0.000148 6.7200n 0.000003 6.7300n -0.000139 6.7400n -0.000275
+ 6.7500n -0.000403 6.7600n -0.000521 6.7700n -0.000624 6.7800n -0.000712 6.7900n -0.000782 6.8000n -0.000832 6.8100n -0.000862 6.8200n -0.000869 6.8300n -0.000853 6.8400n -0.000815 6.8500n -0.000755 6.8600n -0.000673 6.8700n -0.000571 6.8800n -0.000451 6.8900n -0.000316
+ 6.9000n -0.000167 6.9100n -0.000009 6.9200n 0.000157 6.9300n 0.000326 6.9400n 0.000495 6.9500n 0.000659 6.9600n 0.000816 6.9700n 0.000962 6.9800n 0.001093 6.9900n 0.001207 7.0000n 0.001300 7.0100n 0.001370 7.0200n 0.001415 7.0300n 0.001434 7.0400n 0.001425
+ 7.0500n 0.001389 7.0600n 0.001325 7.0700n 0.001234 7.0800n 0.001117 7.0900n 0.000976 7.1000n 0.000815 7.1100n 0.000634 7.1200n 0.000438 7.1300n 0.000230 7.1400n 0.000014 7.1500n -0.000205 7.1600n -0.000425 7.1700n -0.000641 7.1800n -0.000848 7.1900n -0.001042
+ 7.2000n -0.001221 7.2100n -0.001380 7.2200n -0.001516 7.2300n -0.001628 7.2400n -0.001711 7.2500n -0.001766 7.2600n -0.001791 7.2700n -0.001785 7.2800n -0.001748 7.2900n -0.001682 7.3000n -0.001586 7.3100n -0.001465 7.3200n -0.001318 7.3300n -0.001150 7.3400n -0.000962
+ 7.3500n -0.000760 7.3600n -0.000546 7.3700n -0.000324 7.3800n -0.000099 7.3900n 0.000127 7.4000n 0.000348 7.4100n 0.000561 7.4200n 0.000763 7.4300n 0.000950 7.4400n 0.001120 7.4500n 0.001269 7.4600n 0.001396 7.4700n 0.001499 7.4800n 0.001577 7.4900n 0.001629
+ 7.5000n 0.001656 7.5100n 0.001657 7.5200n 0.001634 7.5300n 0.001587 7.5400n 0.001520 7.5500n 0.001433 7.5600n 0.001330 7.5700n 0.001212 7.5800n 0.001084 7.5900n 0.000948 7.6000n 0.000807 7.6100n 0.000664 7.6200n 0.000523 7.6300n 0.000386 7.6400n 0.000256
+ 7.6500n 0.000135 7.6600n 0.000026 7.6700n -0.000069 7.6800n -0.000149 7.6900n -0.000212 7.7000n -0.000259 7.7100n -0.000287 7.7200n -0.000298 7.7300n -0.000292 7.7400n -0.000269 7.7500n -0.000230 7.7600n -0.000177 7.7700n -0.000111 7.7800n -0.000034 7.7900n 0.000052
+ 7.8000n 0.000146 7.8100n 0.000245 7.8200n 0.000348 7.8300n 0.000452 7.8400n 0.000555 7.8500n 0.000655 7.8600n 0.000752 7.8700n 0.000843 7.8800n 0.000927 7.8900n 0.001004 7.9000n 0.001071 7.9100n 0.001130 7.9200n 0.001179 7.9300n 0.001218 7.9400n 0.001248
+ 7.9500n 0.001268 7.9600n 0.001280 7.9700n 0.001283 7.9800n 0.001279 7.9900n 0.001268 8.0000n 0.001251 8.0100n 0.001229 8.0200n 0.001204 8.0300n 0.001174 8.0400n 0.001143 8.0500n 0.001109 8.0600n 0.001075 8.0700n 0.001039 8.0800n 0.001003 8.0900n 0.000967
+ 8.1000n 0.000930 8.1100n 0.000893 8.1200n 0.000856 8.1300n 0.000818 8.1400n 0.000778 8.1500n 0.000737 8.1600n 0.000694 8.1700n 0.000648 8.1800n 0.000599 8.1900n 0.000546 8.2000n 0.000489 8.2100n 0.000428 8.2200n 0.000361 8.2300n 0.000291 8.2400n 0.000215
+ 8.2500n 0.000134 8.2600n 0.000050 8.2700n -0.000039 8.2800n -0.000131 8.2900n -0.000226 8.3000n -0.000323 8.3100n -0.000420 8.3200n -0.000518 8.3300n -0.000613 8.3400n -0.000707 8.3500n -0.000797 8.3600n -0.000881 8.3700n -0.000960 8.3800n -0.001032 8.3900n -0.001097
+ 8.4000n -0.001152 8.4100n -0.001199 8.4200n -0.001236 8.4300n -0.001263 8.4400n -0.001280 8.4500n -0.001288 8.4600n -0.001286 8.4700n -0.001276 8.4800n -0.001258 8.4900n -0.001234 8.5000n -0.001204 8.5100n -0.001171 8.5200n -0.001135 8.5300n -0.001098 8.5400n -0.001062
+ 8.5500n -0.001029 8.5600n -0.001000 8.5700n -0.000977 8.5800n -0.000961 8.5900n -0.000954 8.6000n -0.000956 8.6100n -0.000970 8.6200n -0.000995 8.6300n -0.001033 8.6400n -0.001083 8.6500n -0.001145 8.6600n -0.001219 8.6700n -0.001305 8.6800n -0.001401 8.6900n -0.001507
+ 8.7000n -0.001620 8.7100n -0.001739 8.7200n -0.001863 8.7300n -0.001989 8.7400n -0.002114 8.7500n -0.002237 8.7600n -0.002356 8.7700n -0.002467 8.7800n -0.002569 8.7900n -0.002659 8.8000n -0.002734 8.8100n -0.002794 8.8200n -0.002836 8.8300n -0.002859 8.8400n -0.002861
+ 8.8500n -0.002841 8.8600n -0.002799 8.8700n -0.002733 8.8800n -0.002645 8.8900n -0.002534 8.9000n -0.002401 8.9100n -0.002247 8.9200n -0.002072 8.9300n -0.001879 8.9400n -0.001669 8.9500n -0.001444 8.9600n -0.001206 8.9700n -0.000957 8.9800n -0.000701 8.9900n -0.000438
+ 9.0000n -0.000172 9.0100n 0.000094 9.0200n 0.000359 9.0300n 0.000619 9.0400n 0.000873 9.0500n 0.001117 9.0600n 0.001351 9.0700n 0.001572 9.0800n 0.001779 9.0900n 0.001970 9.1000n 0.002143 9.1100n 0.002298 9.1200n 0.002435 9.1300n 0.002551 9.1400n 0.002648
+ 9.1500n 0.002726 9.1600n 0.002783 9.1700n 0.002821 9.1800n 0.002840 9.1900n 0.002841 9.2000n 0.002825 9.2100n 0.002792 9.2200n 0.002744 9.2300n 0.002683 9.2400n 0.002608 9.2500n 0.002523 9.2600n 0.002427 9.2700n 0.002324 9.2800n 0.002213 9.2900n 0.002097
+ 9.3000n 0.001977 9.3100n 0.001854 9.3200n 0.001730 9.3300n 0.001607 9.3400n 0.001485 9.3500n 0.001366 9.3600n 0.001252 9.3700n 0.001142 9.3800n 0.001039 9.3900n 0.000943 9.4000n 0.000856 9.4100n 0.000777 9.4200n 0.000708 9.4300n 0.000649 9.4400n 0.000600
+ 9.4500n 0.000563 9.4600n 0.000536 9.4700n 0.000521 9.4800n 0.000516 9.4900n 0.000522 9.5000n 0.000538 9.5100n 0.000564 9.5200n 0.000598 9.5300n 0.000640 9.5400n 0.000689 9.5500n 0.000743 9.5600n 0.000801 9.5700n 0.000862 9.5800n 0.000924 9.5900n 0.000985
+ 9.6000n 0.001044 9.6100n 0.001099 9.6200n 0.001147 9.6300n 0.001188 9.6400n 0.001219 9.6500n 0.001240 9.6600n 0.001248 9.6700n 0.001241 9.6800n 0.001220 9.6900n 0.001182 9.7000n 0.001128 9.7100n 0.001056 9.7200n 0.000966 9.7300n 0.000859 9.7400n 0.000735
+ 9.7500n 0.000595 9.7600n 0.000439 9.7700n 0.000269 9.7800n 0.000087 9.7900n -0.000106 9.8000n -0.000307 9.8100n -0.000514 9.8200n -0.000724 9.8300n -0.000934 9.8400n -0.001142 9.8500n -0.001345 9.8600n -0.001539 9.8700n -0.001721 9.8800n -0.001890 9.8900n -0.002041
+ 9.9000n -0.002173 9.9100n -0.002283 9.9200n -0.002369 9.9300n -0.002430 9.9400n -0.002464 9.9500n -0.002471 9.9600n -0.002449 9.9700n -0.002399 9.9800n -0.002322 9.9900n -0.002218 10.0000n -0.002088 10.0100n -0.001934 10.0200n -0.001759 10.0300n -0.001564 10.0400n -0.001354
+ 10.0500n -0.001130 10.0600n -0.000896 10.0700n -0.000655 10.0800n -0.000412 10.0900n -0.000170 10.1000n 0.000068 10.1100n 0.000299 10.1200n 0.000518 10.1300n 0.000722 10.1400n 0.000909 10.1500n 0.001077 10.1600n 0.001223 10.1700n 0.001345 10.1800n 0.001442 10.1900n 0.001514
+ 10.2000n 0.001560 10.2100n 0.001580 10.2200n 0.001574 10.2300n 0.001545 10.2400n 0.001493 10.2500n 0.001421 10.2600n 0.001331 10.2700n 0.001225 10.2800n 0.001106 10.2900n 0.000978 10.3000n 0.000844 10.3100n 0.000707 10.3200n 0.000570 10.3300n 0.000437 10.3400n 0.000311
+ 10.3500n 0.000195 10.3600n 0.000091 10.3700n 0.000001 10.3800n -0.000071 10.3900n -0.000126 10.4000n -0.000161 10.4100n -0.000175 10.4200n -0.000169 10.4300n -0.000143 10.4400n -0.000097 10.4500n -0.000033 10.4600n 0.000048 10.4700n 0.000145 10.4800n 0.000254 10.4900n 0.000373
+ 10.5000n 0.000500 10.5100n 0.000632 10.5200n 0.000764 10.5300n 0.000896 10.5400n 0.001022 10.5500n 0.001140 10.5600n 0.001248 10.5700n 0.001342 10.5800n 0.001420 10.5900n 0.001480 10.6000n 0.001520 10.6100n 0.001538 10.6200n 0.001534 10.6300n 0.001506 10.6400n 0.001455
+ 10.6500n 0.001380 10.6600n 0.001283 10.6700n 0.001165 10.6800n 0.001026 10.6900n 0.000869 10.7000n 0.000695 10.7100n 0.000508 10.7200n 0.000309 10.7300n 0.000102 10.7400n -0.000111 10.7500n -0.000327 10.7600n -0.000542 10.7700n -0.000754 10.7800n -0.000960 10.7900n -0.001156
+ 10.8000n -0.001342 10.8100n -0.001513 10.8200n -0.001669 10.8300n -0.001807 10.8400n -0.001926 10.8500n -0.002024 10.8600n -0.002101 10.8700n -0.002157 10.8800n -0.002190 10.8900n -0.002202 10.9000n -0.002192 10.9100n -0.002161 10.9200n -0.002110 10.9300n -0.002040 10.9400n -0.001953
+ 10.9500n -0.001850 10.9600n -0.001732 10.9700n -0.001601 10.9800n -0.001460 10.9900n -0.001308 11.0000n -0.001149 11.0100n -0.000984 11.0200n -0.000814 11.0300n -0.000641 11.0400n -0.000467 11.0500n -0.000292 11.0600n -0.000117 11.0700n 0.000056 11.0800n 0.000226 11.0900n 0.000393
+ 11.1000n 0.000556 11.1100n 0.000715 11.1200n 0.000869 11.1300n 0.001019 11.1400n 0.001163 11.1500n 0.001302 11.1600n 0.001435 11.1700n 0.001563 11.1800n 0.001685 11.1900n 0.001802 11.2000n 0.001914 11.2100n 0.002019 11.2200n 0.002118 11.2300n 0.002212 11.2400n 0.002299
+ 11.2500n 0.002380 11.2600n 0.002453 11.2700n 0.002520 11.2800n 0.002579 11.2900n 0.002631 11.3000n 0.002674 11.3100n 0.002709 11.3200n 0.002734 11.3300n 0.002751 11.3400n 0.002758 11.3500n 0.002756 11.3600n 0.002744 11.3700n 0.002722 11.3800n 0.002690 11.3900n 0.002648
+ 11.4000n 0.002596 11.4100n 0.002536 11.4200n 0.002466 11.4300n 0.002387 11.4400n 0.002301 11.4500n 0.002206 11.4600n 0.002105 11.4700n 0.001998 11.4800n 0.001884 11.4900n 0.001766 11.5000n 0.001644 11.5100n 0.001518 11.5200n 0.001389 11.5300n 0.001258 11.5400n 0.001126
+ 11.5500n 0.000992 11.5600n 0.000858 11.5700n 0.000724 11.5800n 0.000590 11.5900n 0.000457 11.6000n 0.000326 11.6100n 0.000195 11.6200n 0.000066 11.6300n -0.000062 11.6400n -0.000187 11.6500n -0.000311 11.6600n -0.000432 11.6700n -0.000551 11.6800n -0.000667 11.6900n -0.000780
+ 11.7000n -0.000890 11.7100n -0.000996 11.7200n -0.001097 11.7300n -0.001194 11.7400n -0.001285 11.7500n -0.001370 11.7600n -0.001447 11.7700n -0.001517 11.7800n -0.001578 11.7900n -0.001629 11.8000n -0.001669 11.8100n -0.001697 11.8200n -0.001713 11.8300n -0.001716 11.8400n -0.001705
+ 11.8500n -0.001678 11.8600n -0.001637 11.8700n -0.001580 11.8800n -0.001507 11.8900n -0.001420 11.9000n -0.001317 11.9100n -0.001199 11.9200n -0.001068 11.9300n -0.000925 11.9400n -0.000770 11.9500n -0.000606 11.9600n -0.000435 11.9700n -0.000258 11.9800n -0.000078 11.9900n 0.000104
+ 12.0000n 0.000283 12.0100n 0.000458 12.0200n 0.000626 12.0300n 0.000785 12.0400n 0.000932 12.0500n 0.001064 12.0600n 0.001179 12.0700n 0.001275 12.0800n 0.001351 12.0900n 0.001405 12.1000n 0.001436 12.1100n 0.001443 12.1200n 0.001425 12.1300n 0.001383 12.1400n 0.001318
+ 12.1500n 0.001230 12.1600n 0.001120 12.1700n 0.000990 12.1800n 0.000842 12.1900n 0.000680 12.2000n 0.000504 12.2100n 0.000319 12.2200n 0.000127 12.2300n -0.000067 12.2400n -0.000262 12.2500n -0.000453 12.2600n -0.000637 12.2700n -0.000812 12.2800n -0.000973 12.2900n -0.001119
+ 12.3000n -0.001247 12.3100n -0.001355 12.3200n -0.001442 12.3300n -0.001507 12.3400n -0.001548 12.3500n -0.001566 12.3600n -0.001561 12.3700n -0.001534 12.3800n -0.001487 12.3900n -0.001421 12.4000n -0.001339 12.4100n -0.001243 12.4200n -0.001137 12.4300n -0.001022 12.4400n -0.000904
+ 12.4500n -0.000785 12.4600n -0.000669 12.4700n -0.000559 12.4800n -0.000460 12.4900n -0.000373 12.5000n -0.000302 12.5100n -0.000250 12.5200n -0.000218 12.5300n -0.000209 12.5400n -0.000223 12.5500n -0.000261 12.5600n -0.000324 12.5700n -0.000410 12.5800n -0.000518 12.5900n -0.000648
+ 12.6000n -0.000796 12.6100n -0.000960 12.6200n -0.001137 12.6300n -0.001324 12.6400n -0.001516 12.6500n -0.001710 12.6600n -0.001902 12.6700n -0.002087 12.6800n -0.002261 12.6900n -0.002421 12.7000n -0.002562 12.7100n -0.002681 12.7200n -0.002775 12.7300n -0.002841 12.7400n -0.002877
+ 12.7500n -0.002882 12.7600n -0.002854 12.7700n -0.002794 12.7800n -0.002701 12.7900n -0.002577 12.8000n -0.002423 12.8100n -0.002242 12.8200n -0.002036 12.8300n -0.001809 12.8400n -0.001565 12.8500n -0.001308 12.8600n -0.001043 12.8700n -0.000774 12.8800n -0.000506 12.8900n -0.000244
+ 12.9000n 0.000007 12.9100n 0.000242 12.9200n 0.000458 12.9300n 0.000650 12.9400n 0.000815 12.9500n 0.000949 12.9600n 0.001050 12.9700n 0.001118 12.9800n 0.001149 12.9900n 0.001145 13.0000n 0.001104 13.0100n 0.001030 13.0200n 0.000922 13.0300n 0.000784 13.0400n 0.000618
+ 13.0500n 0.000428 13.0600n 0.000217 13.0700n -0.000009 13.0800n -0.000246 13.0900n -0.000490 13.1000n -0.000736 13.1100n -0.000978 13.1200n -0.001212 13.1300n -0.001433 13.1400n -0.001636 13.1500n -0.001819 13.1600n -0.001977 13.1700n -0.002107 13.1800n -0.002207 13.1900n -0.002276
+ 13.2000n -0.002312 13.2100n -0.002314 13.2200n -0.002283 13.2300n -0.002221 13.2400n -0.002128 13.2500n -0.002006 13.2600n -0.001860 13.2700n -0.001690 13.2800n -0.001502 13.2900n -0.001300 13.3000n -0.001087 13.3100n -0.000868 13.3200n -0.000647 13.3300n -0.000429 13.3400n -0.000218
+ 13.3500n -0.000019 13.3600n 0.000166 13.3700n 0.000333 13.3800n 0.000478 13.3900n 0.000600 13.4000n 0.000696 13.4100n 0.000766 13.4200n 0.000807 13.4300n 0.000822 13.4400n 0.000809 13.4500n 0.000770 13.4600n 0.000706 13.4700n 0.000621 13.4800n 0.000516 13.4900n 0.000394
+ 13.5000n 0.000259 13.5100n 0.000114 13.5200n -0.000037 13.5300n -0.000191 13.5400n -0.000342 13.5500n -0.000489 13.5600n -0.000626 13.5700n -0.000752 13.5800n -0.000863 13.5900n -0.000955 13.6000n -0.001029 13.6100n -0.001080 13.6200n -0.001109 13.6300n -0.001115 13.6400n -0.001098
+ 13.6500n -0.001057 13.6600n -0.000994 13.6700n -0.000911 13.6800n -0.000809 13.6900n -0.000690 13.7000n -0.000557 13.7100n -0.000413 13.7200n -0.000260 13.7300n -0.000103 13.7400n 0.000055 13.7500n 0.000212 13.7600n 0.000364 13.7700n 0.000508 13.7800n 0.000642 13.7900n 0.000761
+ 13.8000n 0.000866 13.8100n 0.000952 13.8200n 0.001020 13.8300n 0.001067 13.8400n 0.001094 13.8500n 0.001101 13.8600n 0.001087 13.8700n 0.001053 13.8800n 0.001001 13.8900n 0.000933 13.9000n 0.000850 13.9100n 0.000754 13.9200n 0.000649 13.9300n 0.000536 13.9400n 0.000419
+ 13.9500n 0.000301 13.9600n 0.000184 13.9700n 0.000071 13.9800n -0.000034 13.9900n -0.000130 14.0000n -0.000214 14.0100n -0.000284 14.0200n -0.000338 14.0300n -0.000375 14.0400n -0.000394 14.0500n -0.000394 14.0600n -0.000375 14.0700n -0.000338 14.0800n -0.000281 14.0900n -0.000208
+ 14.1000n -0.000117 14.1100n -0.000013 14.1200n 0.000105 14.1300n 0.000234 14.1400n 0.000371 14.1500n 0.000515 14.1600n 0.000663 14.1700n 0.000813 14.1800n 0.000962 14.1900n 0.001108 14.2000n 0.001249 14.2100n 0.001383 14.2200n 0.001508 14.2300n 0.001623 14.2400n 0.001726
+ 14.2500n 0.001816 14.2600n 0.001893 14.2700n 0.001956 14.2800n 0.002005 14.2900n 0.002040 14.3000n 0.002062 14.3100n 0.002072 14.3200n 0.002069 14.3300n 0.002057 14.3400n 0.002035 14.3500n 0.002005 14.3600n 0.001969 14.3700n 0.001929 14.3800n 0.001885 14.3900n 0.001840
+ 14.4000n 0.001795 14.4100n 0.001751 14.4200n 0.001710 14.4300n 0.001672 14.4400n 0.001639 14.4500n 0.001612 14.4600n 0.001591 14.4700n 0.001575 14.4800n 0.001567 14.4900n 0.001564 14.5000n 0.001567 14.5100n 0.001575 14.5200n 0.001588 14.5300n 0.001604 14.5400n 0.001623
+ 14.5500n 0.001643 14.5600n 0.001663 14.5700n 0.001682 14.5800n 0.001699 14.5900n 0.001713 14.6000n 0.001721 14.6100n 0.001724 14.6200n 0.001719 14.6300n 0.001706 14.6400n 0.001685 14.6500n 0.001654 14.6600n 0.001614 14.6700n 0.001564 14.6800n 0.001504 14.6900n 0.001433
+ 14.7000n 0.001354 14.7100n 0.001266 14.7200n 0.001169 14.7300n 0.001066 14.7400n 0.000956 14.7500n 0.000841 14.7600n 0.000723 14.7700n 0.000603 14.7800n 0.000482 14.7900n 0.000361 14.8000n 0.000243 14.8100n 0.000128 14.8200n 0.000019 14.8300n -0.000084 14.8400n -0.000180
+ 14.8500n -0.000267 14.8600n -0.000344 14.8700n -0.000410 14.8800n -0.000466 14.8900n -0.000510 14.9000n -0.000542 14.9100n -0.000562 14.9200n -0.000570 14.9300n -0.000567 14.9400n -0.000552 14.9500n -0.000528 14.9600n -0.000494 14.9700n -0.000451 14.9800n -0.000402 14.9900n -0.000346
+ 15.0000n -0.000286 15.0100n -0.000223 15.0200n -0.000158 15.0300n -0.000094 15.0400n -0.000031 15.0500n 0.000029 15.0600n 0.000084 15.0700n 0.000133 15.0800n 0.000174 15.0900n 0.000207 15.1000n 0.000230 15.1100n 0.000242 15.1200n 0.000242 15.1300n 0.000230 15.1400n 0.000205
+ 15.1500n 0.000168 15.1600n 0.000117 15.1700n 0.000053 15.1800n -0.000022 15.1900n -0.000110 15.2000n -0.000208 15.2100n -0.000317 15.2200n -0.000433 15.2300n -0.000557 15.2400n -0.000687 15.2500n -0.000821 15.2600n -0.000957 15.2700n -0.001093 15.2800n -0.001228 15.2900n -0.001359
+ 15.3000n -0.001485 15.3100n -0.001604 15.3200n -0.001714 15.3300n -0.001813 15.3400n -0.001900 15.3500n -0.001973 15.3600n -0.002031 15.3700n -0.002074 15.3800n -0.002099 15.3900n -0.002108 15.4000n -0.002100 15.4100n -0.002074 15.4200n -0.002032 15.4300n -0.001973 15.4400n -0.001900
+ 15.4500n -0.001812 15.4600n -0.001711 15.4700n -0.001600 15.4800n -0.001480 15.4900n -0.001353 15.5000n -0.001221 15.5100n -0.001087 15.5200n -0.000952 15.5300n -0.000821 15.5400n -0.000694 15.5500n -0.000574 15.5600n -0.000463 15.5700n -0.000364 15.5800n -0.000278 15.5900n -0.000207
+ 15.6000n -0.000151 15.6100n -0.000113 15.6200n -0.000093 15.6300n -0.000090 15.6400n -0.000105 15.6500n -0.000138 15.6600n -0.000187 15.6700n -0.000251 15.6800n -0.000329 15.6900n -0.000418 15.7000n -0.000517 15.7100n -0.000623 15.7200n -0.000733 15.7300n -0.000845 15.7400n -0.000955
+ 15.7500n -0.001060 15.7600n -0.001158 15.7700n -0.001245 15.7800n -0.001318 15.7900n -0.001376 15.8000n -0.001415 15.8100n -0.001434 15.8200n -0.001431 15.8300n -0.001405 15.8400n -0.001355 15.8500n -0.001280 15.8600n -0.001182 15.8700n -0.001061 15.8800n -0.000918 15.8900n -0.000755
+ 15.9000n -0.000574 15.9100n -0.000378 15.9200n -0.000170 15.9300n 0.000047 15.9400n 0.000268 15.9500n 0.000489 15.9600n 0.000707 15.9700n 0.000917 15.9800n 0.001114 15.9900n 0.001295 16.0000n 0.001456 16.0100n 0.001593 16.0200n 0.001703 16.0300n 0.001782 16.0400n 0.001828
+ 16.0500n 0.001840 16.0600n 0.001815 16.0700n 0.001754 16.0800n 0.001655 16.0900n 0.001521 16.1000n 0.001352 16.1100n 0.001151 16.1200n 0.000919 16.1300n 0.000661 16.1400n 0.000380 16.1500n 0.000081 16.1600n -0.000232 16.1700n -0.000553 16.1800n -0.000877 16.1900n -0.001199
+ 16.2000n -0.001513 16.2100n -0.001814 16.2200n -0.002095 16.2300n -0.002352 16.2400n -0.002581 16.2500n -0.002777 16.2600n -0.002936 16.2700n -0.003055 16.2800n -0.003132 16.2900n -0.003166 16.3000n -0.003154 16.3100n -0.003098 16.3200n -0.002998 16.3300n -0.002855 16.3400n -0.002672
+ 16.3500n -0.002452 16.3600n -0.002198 16.3700n -0.001915 16.3800n -0.001608 16.3900n -0.001281 16.4000n -0.000942 16.4100n -0.000595 16.4200n -0.000246 16.4300n 0.000098 16.4400n 0.000431 16.4500n 0.000749 16.4600n 0.001045 16.4700n 0.001314 16.4800n 0.001552 16.4900n 0.001756
+ 16.5000n 0.001921 16.5100n 0.002047 16.5200n 0.002130 16.5300n 0.002170 16.5400n 0.002167 16.5500n 0.002123 16.5600n 0.002037 16.5700n 0.001913 16.5800n 0.001753 16.5900n 0.001561 16.6000n 0.001342 16.6100n 0.001099 16.6200n 0.000837 16.6300n 0.000563 16.6400n 0.000280
+ 16.6500n -0.000005 16.6600n -0.000288 16.6700n -0.000563 16.6800n -0.000826 16.6900n -0.001072 16.7000n -0.001297 16.7100n -0.001498 16.7200n -0.001672 16.7300n -0.001817 16.7400n -0.001931 16.7500n -0.002014 16.7600n -0.002066 16.7700n -0.002087 16.7800n -0.002079 16.7900n -0.002042
+ 16.8000n -0.001981 16.8100n -0.001898 16.8200n -0.001795 16.8300n -0.001678 16.8400n -0.001549 16.8500n -0.001414 16.8600n -0.001275 16.8700n -0.001137 16.8800n -0.001003 16.8900n -0.000878 16.9000n -0.000765 16.9100n -0.000666 16.9200n -0.000584 16.9300n -0.000521 16.9400n -0.000477
+ 16.9500n -0.000454 16.9600n -0.000451 16.9700n -0.000468 16.9800n -0.000504 16.9900n -0.000557 17.0000n -0.000624 17.0100n -0.000703 17.0200n -0.000791 17.0300n -0.000884 17.0400n -0.000978 17.0500n -0.001070 17.0600n -0.001155 17.0700n -0.001231 17.0800n -0.001293 17.0900n -0.001337
+ 17.1000n -0.001361 17.1100n -0.001362 17.1200n -0.001338 17.1300n -0.001287 17.1400n -0.001208 17.1500n -0.001101 17.1600n -0.000966 17.1700n -0.000803 17.1800n -0.000614 17.1900n -0.000402 17.2000n -0.000169 17.2100n 0.000082 17.2200n 0.000346 17.2300n 0.000621 17.2400n 0.000901
+ 17.2500n 0.001182 17.2600n 0.001460 17.2700n 0.001728 17.2800n 0.001984 17.2900n 0.002221 17.3000n 0.002437 17.3100n 0.002627 17.3200n 0.002788 17.3300n 0.002917 17.3400n 0.003013 17.3500n 0.003073 17.3600n 0.003096 17.3700n 0.003083 17.3800n 0.003034 17.3900n 0.002951
+ 17.4000n 0.002835 17.4100n 0.002689 17.4200n 0.002516 17.4300n 0.002321 17.4400n 0.002107 17.4500n 0.001879 17.4600n 0.001641 17.4700n 0.001400 17.4800n 0.001159 17.4900n 0.000925 17.5000n 0.000701 17.5100n 0.000493 17.5200n 0.000306 17.5300n 0.000142 17.5400n 0.000006
+ 17.5500n -0.000100 17.5600n -0.000173 17.5700n -0.000213 17.5800n -0.000218 17.5900n -0.000188 17.6000n -0.000125 17.6100n -0.000028 17.6200n 0.000098 17.6300n 0.000253 17.6400n 0.000431 17.6500n 0.000630 17.6600n 0.000845 17.6700n 0.001071 17.6800n 0.001303 17.6900n 0.001536
+ 17.7000n 0.001766 17.7100n 0.001986 17.7200n 0.002192 17.7300n 0.002379 17.7400n 0.002542 17.7500n 0.002678 17.7600n 0.002784 17.7700n 0.002855 17.7800n 0.002891 17.7900n 0.002889 17.8000n 0.002849 17.8100n 0.002770 17.8200n 0.002653 17.8300n 0.002500 17.8400n 0.002311
+ 17.8500n 0.002091 17.8600n 0.001841 17.8700n 0.001566 17.8800n 0.001270 17.8900n 0.000957 17.9000n 0.000632 17.9100n 0.000301 17.9200n -0.000033 17.9300n -0.000363 17.9400n -0.000685 17.9500n -0.000994 17.9600n -0.001285 17.9700n -0.001555 17.9800n -0.001799 17.9900n -0.002015
+ 18.0000n -0.002199 18.0100n -0.002349 18.0200n -0.002464 18.0300n -0.002543 18.0400n -0.002585 18.0500n -0.002591 18.0600n -0.002562 18.0700n -0.002499 18.0800n -0.002404 18.0900n -0.002281 18.1000n -0.002131 18.1100n -0.001958 18.1200n -0.001765 18.1300n -0.001558 18.1400n -0.001338
+ 18.1500n -0.001111 18.1600n -0.000881 18.1700n -0.000651 18.1800n -0.000425 18.1900n -0.000207 18.2000n -0.000001 18.2100n 0.000192 18.2200n 0.000367 18.2300n 0.000524 18.2400n 0.000659 18.2500n 0.000772 18.2600n 0.000863 18.2700n 0.000929 18.2800n 0.000973 18.2900n 0.000993
+ 18.3000n 0.000991 18.3100n 0.000968 18.3200n 0.000925 18.3300n 0.000865 18.3400n 0.000789 18.3500n 0.000701 18.3600n 0.000601 18.3700n 0.000494 18.3800n 0.000381 18.3900n 0.000264 18.4000n 0.000148 18.4100n 0.000033 18.4200n -0.000078 18.4300n -0.000182 18.4400n -0.000278
+ 18.4500n -0.000365 18.4600n -0.000441 18.4700n -0.000505 18.4800n -0.000555 18.4900n -0.000593 18.5000n -0.000617 18.5100n -0.000628 18.5200n -0.000625 18.5300n -0.000611 18.5400n -0.000585 18.5500n -0.000548 18.5600n -0.000502 18.5700n -0.000448 18.5800n -0.000388 18.5900n -0.000322
+ 18.6000n -0.000254 18.6100n -0.000184 18.6200n -0.000114 18.6300n -0.000045 18.6400n 0.000020 18.6500n 0.000081 18.6600n 0.000137 18.6700n 0.000185 18.6800n 0.000226 18.6900n 0.000258 18.7000n 0.000281 18.7100n 0.000294 18.7200n 0.000297 18.7300n 0.000290 18.7400n 0.000272
+ 18.7500n 0.000245 18.7600n 0.000209 18.7700n 0.000164 18.7800n 0.000110 18.7900n 0.000050 18.8000n -0.000017 18.8100n -0.000090 18.8200n -0.000166 18.8300n -0.000246 18.8400n -0.000327 18.8500n -0.000409 18.8600n -0.000490 18.8700n -0.000569 18.8800n -0.000645 18.8900n -0.000716
+ 18.9000n -0.000782 18.9100n -0.000842 18.9200n -0.000894 18.9300n -0.000937 18.9400n -0.000971 18.9500n -0.000995 18.9600n -0.001008 18.9700n -0.001010 18.9800n -0.001001 18.9900n -0.000980 19.0000n -0.000947 19.0100n -0.000902 19.0200n -0.000846 19.0300n -0.000778 19.0400n -0.000699
+ 19.0500n -0.000609 19.0600n -0.000509 19.0700n -0.000400 19.0800n -0.000283 19.0900n -0.000158 19.1000n -0.000026 19.1100n 0.000111 19.1200n 0.000252 19.1300n 0.000396 19.1400n 0.000542 19.1500n 0.000689 19.1600n 0.000835 19.1700n 0.000978 19.1800n 0.001118 19.1900n 0.001254
+ 19.2000n 0.001383 19.2100n 0.001505 19.2200n 0.001619 19.2300n 0.001723 19.2400n 0.001817 19.2500n 0.001899 19.2600n 0.001969 19.2700n 0.002027 19.2800n 0.002070 19.2900n 0.002100 19.3000n 0.002116 19.3100n 0.002118 19.3200n 0.002105 19.3300n 0.002079 19.3400n 0.002038
+ 19.3500n 0.001985 19.3600n 0.001919 19.3700n 0.001840 19.3800n 0.001751 19.3900n 0.001652 19.4000n 0.001544 19.4100n 0.001428 19.4200n 0.001305 19.4300n 0.001178 19.4400n 0.001047 19.4500n 0.000913 19.4600n 0.000779 19.4700n 0.000645 19.4800n 0.000514 19.4900n 0.000386
+ 19.5000n 0.000263 19.5100n 0.000146 19.5200n 0.000037 19.5300n -0.000063 19.5400n -0.000153 19.5500n -0.000233 19.5600n -0.000301 19.5700n -0.000356 19.5800n -0.000398 19.5900n -0.000427 19.6000n -0.000442 19.6100n -0.000443 19.6200n -0.000431 19.6300n -0.000404 19.6400n -0.000365
+ 19.6500n -0.000313 19.6600n -0.000248 19.6700n -0.000173 19.6800n -0.000087 19.6900n 0.000008 19.7000n 0.000112 19.7100n 0.000222 19.7200n 0.000337 19.7300n 0.000456 19.7400n 0.000577 19.7500n 0.000699 19.7600n 0.000820 19.7700n 0.000939 19.7800n 0.001053 19.7900n 0.001162
+ 19.8000n 0.001263 19.8100n 0.001356 19.8200n 0.001438 19.8300n 0.001508 19.8400n 0.001566 19.8500n 0.001611 19.8600n 0.001641 19.8700n 0.001656 19.8800n 0.001655 19.8900n 0.001639 19.9000n 0.001606 19.9100n 0.001558 19.9200n 0.001495 19.9300n 0.001416 19.9400n 0.001324
+ 19.9500n 0.001219 19.9600n 0.001103 19.9700n 0.000976 19.9800n 0.000841 19.9900n 0.000698 20.0000n 0.000551 20.0100n 0.000401 20.0200n 0.000250 20.0300n 0.000100 20.0400n -0.000046 20.0500n -0.000187 20.0600n -0.000321 20.0700n -0.000445 20.0800n -0.000558 20.0900n -0.000658
+ 20.1000n -0.000743 20.1100n -0.000813 20.1200n -0.000866 20.1300n -0.000901 20.1400n -0.000918 20.1500n -0.000917 20.1600n -0.000897 20.1700n -0.000858 20.1800n -0.000803 20.1900n -0.000731 20.2000n -0.000643 20.2100n -0.000542 20.2200n -0.000428 20.2300n -0.000305 20.2400n -0.000173
+ 20.2500n -0.000035 20.2600n 0.000107 20.2700n 0.000250 20.2800n 0.000392 20.2900n 0.000530 20.3000n 0.000662 20.3100n 0.000786 20.3200n 0.000900 20.3300n 0.001003 20.3400n 0.001091 20.3500n 0.001165 20.3600n 0.001223 20.3700n 0.001263 20.3800n 0.001287 20.3900n 0.001294
+ 20.4000n 0.001283 20.4100n 0.001257 20.4200n 0.001214 20.4300n 0.001158 20.4400n 0.001088 20.4500n 0.001008 20.4600n 0.000918 20.4700n 0.000821 20.4800n 0.000720 20.4900n 0.000616 20.5000n 0.000513 20.5100n 0.000411 20.5200n 0.000314 20.5300n 0.000224 20.5400n 0.000142
+ 20.5500n 0.000071 20.5600n 0.000011 20.5700n -0.000035 20.5800n -0.000067 20.5900n -0.000085 20.6000n -0.000089 20.6100n -0.000078 20.6200n -0.000053 20.6300n -0.000015 20.6400n 0.000035 20.6500n 0.000095 20.6600n 0.000164 20.6700n 0.000239 20.6800n 0.000319 20.6900n 0.000401
+ 20.7000n 0.000482 20.7100n 0.000560 20.7200n 0.000633 20.7300n 0.000698 20.7400n 0.000753 20.7500n 0.000797 20.7600n 0.000827 20.7700n 0.000842 20.7800n 0.000841 20.7900n 0.000823 20.8000n 0.000788 20.8100n 0.000736 20.8200n 0.000667 20.8300n 0.000582 20.8400n 0.000483
+ 20.8500n 0.000370 20.8600n 0.000247 20.8700n 0.000115 20.8800n -0.000024 20.8900n -0.000166 20.9000n -0.000309 20.9100n -0.000450 20.9200n -0.000585 20.9300n -0.000713 20.9400n -0.000830 20.9500n -0.000934 20.9600n -0.001022 20.9700n -0.001092 20.9800n -0.001143 20.9900n -0.001173
+ 21.0000n -0.001182 21.0100n -0.001168 21.0200n -0.001134 21.0300n -0.001077 21.0400n -0.001001 21.0500n -0.000906 21.0600n -0.000794 21.0700n -0.000668 21.0800n -0.000531 21.0900n -0.000384 21.1000n -0.000232 21.1100n -0.000078 21.1200n 0.000074 21.1300n 0.000222 21.1400n 0.000361
+ 21.1500n 0.000488 21.1600n 0.000601 21.1700n 0.000695 21.1800n 0.000769 21.1900n 0.000821 21.2000n 0.000849 21.2100n 0.000851 21.2200n 0.000827 21.2300n 0.000777 21.2400n 0.000701 21.2500n 0.000600 21.2600n 0.000475 21.2700n 0.000329 21.2800n 0.000163 21.2900n -0.000019
+ 21.3000n -0.000214 21.3100n -0.000420 21.3200n -0.000631 21.3300n -0.000845 21.3400n -0.001058 21.3500n -0.001265 21.3600n -0.001464 21.3700n -0.001650 21.3800n -0.001820 21.3900n -0.001973 21.4000n -0.002104 21.4100n -0.002211 21.4200n -0.002294 21.4300n -0.002352 21.4400n -0.002382
+ 21.4500n -0.002387 21.4600n -0.002366 21.4700n -0.002320 21.4800n -0.002250 21.4900n -0.002160 21.5000n -0.002051 21.5100n -0.001927 21.5200n -0.001789 21.5300n -0.001643 21.5400n -0.001490 21.5500n -0.001335 21.5600n -0.001181 21.5700n -0.001032 21.5800n -0.000891 21.5900n -0.000760
+ 21.6000n -0.000642 21.6100n -0.000541 21.6200n -0.000456 21.6300n -0.000390 21.6400n -0.000344 21.6500n -0.000318 21.6600n -0.000311 21.6700n -0.000324 21.6800n -0.000355 21.6900n -0.000401 21.7000n -0.000462 21.7100n -0.000535 21.7200n -0.000617 21.7300n -0.000705 21.7400n -0.000796
+ 21.7500n -0.000888 21.7600n -0.000976 21.7700n -0.001058 21.7800n -0.001131 21.7900n -0.001192 21.8000n -0.001239 21.8100n -0.001271 21.8200n -0.001285 21.8300n -0.001280 21.8400n -0.001256 21.8500n -0.001213 21.8600n -0.001152 21.8700n -0.001072 21.8800n -0.000977 21.8900n -0.000866
+ 21.9000n -0.000744 21.9100n -0.000612 21.9200n -0.000474 21.9300n -0.000332 21.9400n -0.000191 21.9500n -0.000052 21.9600n 0.000079 21.9700n 0.000201 21.9800n 0.000309 21.9900n 0.000402 22.0000n 0.000477 22.0100n 0.000531 22.0200n 0.000563 22.0300n 0.000572 22.0400n 0.000557
+ 22.0500n 0.000519 22.0600n 0.000459 22.0700n 0.000376 22.0800n 0.000274 22.0900n 0.000153 22.1000n 0.000018 22.1100n -0.000129 22.1200n -0.000285 22.1300n -0.000446 22.1400n -0.000607 22.1500n -0.000766 22.1600n -0.000917 22.1700n -0.001057 22.1800n -0.001183 22.1900n -0.001290
+ 22.2000n -0.001376 22.2100n -0.001438 22.2200n -0.001474 22.2300n -0.001482 22.2400n -0.001461 22.2500n -0.001411 22.2600n -0.001333 22.2700n -0.001226 22.2800n -0.001092 22.2900n -0.000935 22.3000n -0.000756 22.3100n -0.000558 22.3200n -0.000346 22.3300n -0.000123 22.3400n 0.000107
+ 22.3500n 0.000338 22.3600n 0.000566 22.3700n 0.000787 22.3800n 0.000995 22.3900n 0.001188 22.4000n 0.001360 22.4100n 0.001508 22.4200n 0.001629 22.4300n 0.001721 22.4400n 0.001781 22.4500n 0.001807 22.4600n 0.001800 22.4700n 0.001759 22.4800n 0.001685 22.4900n 0.001579
+ 22.5000n 0.001444 22.5100n 0.001281 22.5200n 0.001094 22.5300n 0.000886 22.5400n 0.000662 22.5500n 0.000426 22.5600n 0.000183 22.5700n -0.000064 22.5800n -0.000309 22.5900n -0.000548 22.6000n -0.000776 22.6100n -0.000990 22.6200n -0.001184 22.6300n -0.001358 22.6400n -0.001506
+ 22.6500n -0.001629 22.6600n -0.001722 22.6700n -0.001787 22.6800n -0.001822 22.6900n -0.001828 22.7000n -0.001806 22.7100n -0.001758 22.7200n -0.001685 22.7300n -0.001590 22.7400n -0.001477 22.7500n -0.001350 22.7600n -0.001210 22.7700n -0.001064 22.7800n -0.000914 22.7900n -0.000765
+ 22.8000n -0.000620 22.8100n -0.000484 22.8200n -0.000359 22.8300n -0.000249 22.8400n -0.000157 22.8500n -0.000083 22.8600n -0.000031 22.8700n -0.000000 22.8800n 0.000008 22.8900n -0.000005 22.9000n -0.000040 22.9100n -0.000095 22.9200n -0.000167 22.9300n -0.000255 22.9400n -0.000356
+ 22.9500n -0.000466 22.9600n -0.000582 22.9700n -0.000701 22.9800n -0.000818 22.9900n -0.000931 23.0000n -0.001035 23.0100n -0.001127 23.0200n -0.001204 23.0300n -0.001264 23.0400n -0.001303 23.0500n -0.001320 23.0600n -0.001314 23.0700n -0.001284 23.0800n -0.001229 23.0900n -0.001150
+ 23.1000n -0.001049 23.1100n -0.000926 23.1200n -0.000783 23.1300n -0.000624 23.1400n -0.000451 23.1500n -0.000267 23.1600n -0.000077 23.1700n 0.000117 23.1800n 0.000310 23.1900n 0.000497 23.2000n 0.000677 23.2100n 0.000844 23.2200n 0.000995 23.2300n 0.001128 23.2400n 0.001240
+ 23.2500n 0.001328 23.2600n 0.001391 23.2700n 0.001427 23.2800n 0.001437 23.2900n 0.001421 23.3000n 0.001379 23.3100n 0.001312 23.3200n 0.001223 23.3300n 0.001114 23.3400n 0.000988 23.3500n 0.000847 23.3600n 0.000697 23.3700n 0.000539 23.3800n 0.000380 23.3900n 0.000221
+ 23.4000n 0.000068 23.4100n -0.000075 23.4200n -0.000206 23.4300n -0.000321 23.4400n -0.000416 23.4500n -0.000490 23.4600n -0.000541 23.4700n -0.000567 23.4800n -0.000567 23.4900n -0.000541 23.5000n -0.000490 23.5100n -0.000415 23.5200n -0.000317 23.5300n -0.000199 23.5400n -0.000064
+ 23.5500n 0.000086 23.5600n 0.000247 23.5700n 0.000414 23.5800n 0.000584 23.5900n 0.000753 23.6000n 0.000916 23.6100n 0.001069 23.6200n 0.001207 23.6300n 0.001328 23.6400n 0.001428 23.6500n 0.001503 23.6600n 0.001551 23.6700n 0.001570 23.6800n 0.001558 23.6900n 0.001515
+ 23.7000n 0.001440 23.7100n 0.001333 23.7200n 0.001195 23.7300n 0.001029 23.7400n 0.000835 23.7500n 0.000618 23.7600n 0.000379 23.7700n 0.000122 23.7800n -0.000149 23.7900n -0.000429 23.8000n -0.000715 23.8100n -0.001002 23.8200n -0.001286 23.8300n -0.001563 23.8400n -0.001828
+ 23.8500n -0.002079 23.8600n -0.002311 23.8700n -0.002521 23.8800n -0.002707 23.8900n -0.002866 23.9000n -0.002997 23.9100n -0.003098 23.9200n -0.003170 23.9300n -0.003211 23.9400n -0.003223 23.9500n -0.003205 23.9600n -0.003160 23.9700n -0.003088 23.9800n -0.002993 23.9900n -0.002875
+ 24.0000n -0.002739 24.0100n -0.002586 24.0200n -0.002419 24.0300n -0.002242 24.0400n -0.002056 24.0500n -0.001865 24.0600n -0.001672 24.0700n -0.001478 24.0800n -0.001285 24.0900n -0.001096 24.1000n -0.000913 24.1100n -0.000735 24.1200n -0.000566 24.1300n -0.000404 24.1400n -0.000251
+ 24.1500n -0.000107 24.1600n 0.000029 24.1700n 0.000156 24.1800n 0.000276 24.1900n 0.000389 24.2000n 0.000495 24.2100n 0.000595 24.2200n 0.000690 24.2300n 0.000781 24.2400n 0.000869 24.2500n 0.000953 24.2600n 0.001035 24.2700n 0.001113 24.2800n 0.001190 24.2900n 0.001263
+ 24.3000n 0.001333 24.3100n 0.001399 24.3200n 0.001460 24.3300n 0.001515 24.3400n 0.001564 24.3500n 0.001604 24.3600n 0.001635 24.3700n 0.001656 24.3800n 0.001664 24.3900n 0.001660 24.4000n 0.001642 24.4100n 0.001609 24.4200n 0.001560 24.4300n 0.001495 24.4400n 0.001415
+ 24.4500n 0.001318 24.4600n 0.001206 24.4700n 0.001079 24.4800n 0.000939 24.4900n 0.000787 24.5000n 0.000625 24.5100n 0.000455 24.5200n 0.000279 24.5300n 0.000101 24.5400n -0.000078 24.5500n -0.000254 24.5600n -0.000424 24.5700n -0.000585 24.5800n -0.000735 24.5900n -0.000871
+ 24.6000n -0.000989 24.6100n -0.001089 24.6200n -0.001168 24.6300n -0.001224 24.6400n -0.001257 24.6500n -0.001264 24.6600n -0.001248 24.6700n -0.001206 24.6800n -0.001141 24.6900n -0.001054 24.7000n -0.000946 24.7100n -0.000819 24.7200n -0.000676 24.7300n -0.000520 24.7400n -0.000354
+ 24.7500n -0.000182 24.7600n -0.000008 24.7700n 0.000166 24.7800n 0.000334 24.7900n 0.000494 24.8000n 0.000642 24.8100n 0.000774 24.8200n 0.000887 24.8300n 0.000979 24.8400n 0.001048 24.8500n 0.001091 24.8600n 0.001107 24.8700n 0.001097 24.8800n 0.001058 24.8900n 0.000993
+ 24.9000n 0.000902 24.9100n 0.000787 24.9200n 0.000650 24.9300n 0.000493 24.9400n 0.000319 24.9500n 0.000133 24.9600n -0.000063 24.9700n -0.000264 24.9800n -0.000465 24.9900n -0.000664 25.0000n -0.000855 25.0100n -0.001035 25.0200n -0.001199 25.0300n -0.001345 25.0400n -0.001468
+ 25.0500n -0.001566 25.0600n -0.001636 25.0700n -0.001677 25.0800n -0.001688 25.0900n -0.001667 25.1000n -0.001615 25.1100n -0.001532 25.1200n -0.001419 25.1300n -0.001279 25.1400n -0.001112 25.1500n -0.000923 25.1600n -0.000715 25.1700n -0.000490 25.1800n -0.000253 25.1900n -0.000007
+ 25.2000n 0.000242 25.2100n 0.000491 25.2200n 0.000735 25.2300n 0.000970 25.2400n 0.001193 25.2500n 0.001400 25.2600n 0.001587 25.2700n 0.001751 25.2800n 0.001890 25.2900n 0.002002 25.3000n 0.002086 25.3100n 0.002140 25.3200n 0.002165 25.3300n 0.002160 25.3400n 0.002126
+ 25.3500n 0.002064 25.3600n 0.001977 25.3700n 0.001867 25.3800n 0.001735 25.3900n 0.001585 25.4000n 0.001420 25.4100n 0.001243 25.4200n 0.001059 25.4300n 0.000870 25.4400n 0.000679 25.4500n 0.000491 25.4600n 0.000309 25.4700n 0.000135 25.4800n -0.000027 25.4900n -0.000175
+ 25.5000n -0.000307 25.5100n -0.000421 25.5200n -0.000515 25.5300n -0.000589 25.5400n -0.000641 25.5500n -0.000672 25.5600n -0.000682 25.5700n -0.000671 25.5800n -0.000639 25.5900n -0.000589 25.6000n -0.000522 25.6100n -0.000439 25.6200n -0.000342 25.6300n -0.000232 25.6400n -0.000113
+ 25.6500n 0.000015 25.6600n 0.000149 25.6700n 0.000287 25.6800n 0.000427 25.6900n 0.000568 25.7000n 0.000708 25.7100n 0.000845 25.7200n 0.000978 25.7300n 0.001106 25.7400n 0.001228 25.7500n 0.001344 25.7600n 0.001451 25.7700n 0.001551 25.7800n 0.001642 25.7900n 0.001725
+ 25.8000n 0.001799 25.8100n 0.001864 25.8200n 0.001921 25.8300n 0.001968 25.8400n 0.002007 25.8500n 0.002037 25.8600n 0.002058 25.8700n 0.002070 25.8800n 0.002073 25.8900n 0.002067 25.9000n 0.002051 25.9100n 0.002025 25.9200n 0.001989 25.9300n 0.001942 25.9400n 0.001884
+ 25.9500n 0.001815 25.9600n 0.001735 25.9700n 0.001642 25.9800n 0.001538 25.9900n 0.001421 26.0000n 0.001293 26.0100n 0.001153 26.0200n 0.001003 26.0300n 0.000842 26.0400n 0.000672 26.0500n 0.000494 26.0600n 0.000310 26.0700n 0.000121 26.0800n -0.000071 26.0900n -0.000264
+ 26.1000n -0.000456 26.1100n -0.000643 26.1200n -0.000824 26.1300n -0.000995 26.1400n -0.001154 26.1500n -0.001299 26.1600n -0.001427 26.1700n -0.001536 26.1800n -0.001622 26.1900n -0.001685 26.2000n -0.001722 26.2100n -0.001732 26.2200n -0.001714 26.2300n -0.001668 26.2400n -0.001593
+ 26.2500n -0.001490 26.2600n -0.001359 26.2700n -0.001202 26.2800n -0.001021 26.2900n -0.000817 26.3000n -0.000594 26.3100n -0.000354 26.3200n -0.000102 26.3300n 0.000160 26.3400n 0.000427 26.3500n 0.000696 26.3600n 0.000961 26.3700n 0.001219 26.3800n 0.001465 26.3900n 0.001696
+ 26.4000n 0.001907 26.4100n 0.002095 26.4200n 0.002257 26.4300n 0.002390 26.4400n 0.002490 26.4500n 0.002558 26.4600n 0.002591 26.4700n 0.002588 26.4800n 0.002551 26.4900n 0.002478 26.5000n 0.002372 26.5100n 0.002234 26.5200n 0.002067 26.5300n 0.001873 26.5400n 0.001657
+ 26.5500n 0.001421 26.5600n 0.001170 26.5700n 0.000909 26.5800n 0.000641 26.5900n 0.000373 26.6000n 0.000109 26.6100n -0.000147 26.6200n -0.000390 26.6300n -0.000615 26.6400n -0.000818 26.6500n -0.000996 26.6600n -0.001146 26.6700n -0.001264 26.6800n -0.001349 26.6900n -0.001399
+ 26.7000n -0.001412 26.7100n -0.001390 26.7200n -0.001331 26.7300n -0.001237 26.7400n -0.001110 26.7500n -0.000952 26.7600n -0.000764 26.7700n -0.000551 26.7800n -0.000316 26.7900n -0.000063 26.8000n 0.000205 26.8100n 0.000482 26.8200n 0.000765 26.8300n 0.001048 26.8400n 0.001328
+ 26.8500n 0.001600 26.8600n 0.001859 26.8700n 0.002104 26.8800n 0.002329 26.8900n 0.002531 26.9000n 0.002709 26.9100n 0.002860 26.9200n 0.002983 26.9300n 0.003075 26.9400n 0.003137 26.9500n 0.003169 26.9600n 0.003171 26.9700n 0.003144 26.9800n 0.003089 26.9900n 0.003008
+ 27.0000n 0.002904 27.0100n 0.002779 27.0200n 0.002635 27.0300n 0.002476 27.0400n 0.002304 27.0500n 0.002123 27.0600n 0.001936 27.0700n 0.001745 27.0800n 0.001554 27.0900n 0.001366 27.1000n 0.001183 27.1100n 0.001008 27.1200n 0.000841 27.1300n 0.000686 27.1400n 0.000543
+ 27.1500n 0.000413 27.1600n 0.000298 27.1700n 0.000196 27.1800n 0.000109 27.1900n 0.000036 27.2000n -0.000025 27.2100n -0.000073 27.2200n -0.000110 27.2300n -0.000138 27.2400n -0.000157 27.2500n -0.000169 27.2600n -0.000177 27.2700n -0.000182 27.2800n -0.000184 27.2900n -0.000187
+ 27.3000n -0.000190 27.3100n -0.000197 27.3200n -0.000207 27.3300n -0.000221 27.3400n -0.000241 27.3500n -0.000267 27.3600n -0.000298 27.3700n -0.000336 27.3800n -0.000379 27.3900n -0.000428 27.4000n -0.000481 27.4100n -0.000539 27.4200n -0.000599 27.4300n -0.000661 27.4400n -0.000724
+ 27.4500n -0.000786 27.4600n -0.000847 27.4700n -0.000904 27.4800n -0.000956 27.4900n -0.001003 27.5000n -0.001043 27.5100n -0.001075 27.5200n -0.001098 27.5300n -0.001112 27.5400n -0.001116 27.5500n -0.001110 27.5600n -0.001094 27.5700n -0.001067 27.5800n -0.001031 27.5900n -0.000985
+ 27.6000n -0.000930 27.6100n -0.000867 27.6200n -0.000797 27.6300n -0.000722 27.6400n -0.000642 27.6500n -0.000558 27.6600n -0.000473 27.6700n -0.000387 27.6800n -0.000301 27.6900n -0.000219 27.7000n -0.000139 27.7100n -0.000065 27.7200n 0.000004 27.7300n 0.000066 27.7400n 0.000120
+ 27.7500n 0.000165 27.7600n 0.000201 27.7700n 0.000228 27.7800n 0.000244 27.7900n 0.000252 27.8000n 0.000249 27.8100n 0.000238 27.8200n 0.000217 27.8300n 0.000189 27.8400n 0.000154 27.8500n 0.000112 27.8600n 0.000065 27.8700n 0.000014 27.8800n -0.000041 27.8900n -0.000096
+ 27.9000n -0.000152 27.9100n -0.000207 27.9200n -0.000260 27.9300n -0.000310 27.9400n -0.000355 27.9500n -0.000395 27.9600n -0.000428 27.9700n -0.000454 27.9800n -0.000472 27.9900n -0.000481 28.0000n -0.000482 28.0100n -0.000473 28.0200n -0.000456 28.0300n -0.000429 28.0400n -0.000394
+ 28.0500n -0.000350 28.0600n -0.000300 28.0700n -0.000242 28.0800n -0.000179 28.0900n -0.000111 28.1000n -0.000040 28.1100n 0.000033 28.1200n 0.000106 28.1300n 0.000179 28.1400n 0.000249 28.1500n 0.000315 28.1600n 0.000375 28.1700n 0.000428 28.1800n 0.000472 28.1900n 0.000506
+ 28.2000n 0.000529 28.2100n 0.000538 28.2200n 0.000534 28.2300n 0.000515 28.2400n 0.000480 28.2500n 0.000429 28.2600n 0.000361 28.2700n 0.000276 28.2800n 0.000174 28.2900n 0.000056 28.3000n -0.000079 28.3100n -0.000228 28.3200n -0.000392 28.3300n -0.000569 28.3400n -0.000758
+ 28.3500n -0.000957 28.3600n -0.001164 28.3700n -0.001377 28.3800n -0.001593 28.3900n -0.001812 28.4000n -0.002030 28.4100n -0.002245 28.4200n -0.002453 28.4300n -0.002654 28.4400n -0.002844 28.4500n -0.003021 28.4600n -0.003182 28.4700n -0.003326 28.4800n -0.003450 28.4900n -0.003553
+ 28.5000n -0.003633 28.5100n -0.003688 28.5200n -0.003717 28.5300n -0.003720 28.5400n -0.003697 28.5500n -0.003646 28.5600n -0.003568 28.5700n -0.003464 28.5800n -0.003335 28.5900n -0.003181 28.6000n -0.003003 28.6100n -0.002805 28.6200n -0.002587 28.6300n -0.002352 28.6400n -0.002102
+ 28.6500n -0.001839 28.6600n -0.001568 28.6700n -0.001289 28.6800n -0.001007 28.6900n -0.000723 28.7000n -0.000442 28.7100n -0.000165 28.7200n 0.000105 28.7300n 0.000364 28.7400n 0.000611 28.7500n 0.000844 28.7600n 0.001060 28.7700n 0.001258 28.7800n 0.001436 28.7900n 0.001593
+ 28.8000n 0.001728 28.8100n 0.001841 28.8200n 0.001931 28.8300n 0.001999 28.8400n 0.002044 28.8500n 0.002068 28.8600n 0.002071 28.8700n 0.002055 28.8800n 0.002020 28.8900n 0.001968 28.9000n 0.001900 28.9100n 0.001819 28.9200n 0.001726 28.9300n 0.001623 28.9400n 0.001512
+ 28.9500n 0.001395 28.9600n 0.001274 28.9700n 0.001150 28.9800n 0.001025 28.9900n 0.000901 29.0000n 0.000780 29.0100n 0.000661 29.0200n 0.000548 29.0300n 0.000440 29.0400n 0.000338 29.0500n 0.000244 29.0600n 0.000158 29.0700n 0.000079 29.0800n 0.000008 29.0900n -0.000054
+ 29.1000n -0.000109 29.1100n -0.000156 29.1200n -0.000195 29.1300n -0.000227 29.1400n -0.000253 29.1500n -0.000272 29.1600n -0.000286 29.1700n -0.000295 29.1800n -0.000299 29.1900n -0.000300 29.2000n -0.000298 29.2100n -0.000293 29.2200n -0.000285 29.2300n -0.000276 29.2400n -0.000266
+ 29.2500n -0.000255 29.2600n -0.000243 29.2700n -0.000232 29.2800n -0.000220 29.2900n -0.000209 29.3000n -0.000199 29.3100n -0.000191 29.3200n -0.000183 29.3300n -0.000178 29.3400n -0.000174 29.3500n -0.000173 29.3600n -0.000175 29.3700n -0.000179 29.3800n -0.000187 29.3900n -0.000198
+ 29.4000n -0.000214 29.4100n -0.000234 29.4200n -0.000258 29.4300n -0.000287 29.4400n -0.000321 29.4500n -0.000360 29.4600n -0.000405 29.4700n -0.000455 29.4800n -0.000510 29.4900n -0.000571 29.5000n -0.000636 29.5100n -0.000706 29.5200n -0.000780 29.5300n -0.000857 29.5400n -0.000937
+ 29.5500n -0.001019 29.5600n -0.001102 29.5700n -0.001185 29.5800n -0.001266 29.5900n -0.001345 29.6000n -0.001421 29.6100n -0.001491 29.6200n -0.001554 29.6300n -0.001610 29.6400n -0.001657 29.6500n -0.001694 29.6600n -0.001719 29.6700n -0.001733 29.6800n -0.001733 29.6900n -0.001720
+ 29.7000n -0.001692 29.7100n -0.001650 29.7200n -0.001594 29.7300n -0.001524 29.7400n -0.001440 29.7500n -0.001343 29.7600n -0.001234 29.7700n -0.001114 29.7800n -0.000985 29.7900n -0.000848 29.8000n -0.000705 29.8100n -0.000558 29.8200n -0.000409 29.8300n -0.000261 29.8400n -0.000115
+ 29.8500n 0.000027 29.8600n 0.000162 29.8700n 0.000289 29.8800n 0.000405 29.8900n 0.000508 29.9000n 0.000597 29.9100n 0.000672 29.9200n 0.000730 29.9300n 0.000770 29.9400n 0.000794 29.9500n 0.000799 29.9600n 0.000787 29.9700n 0.000758 29.9800n 0.000713 29.9900n 0.000652
+ 30.0000n 0.000577 30.0100n 0.000491 30.0200n 0.000394 30.0300n 0.000289 30.0400n 0.000177 30.0500n 0.000062 30.0600n -0.000054 30.0700n -0.000170 30.0800n -0.000282 30.0900n -0.000390 30.1000n -0.000490 30.1100n -0.000580 30.1200n -0.000660 30.1300n -0.000728 30.1400n -0.000782
+ 30.1500n -0.000823 30.1600n -0.000849 30.1700n -0.000861 30.1800n -0.000859 30.1900n -0.000844 30.2000n -0.000816 30.2100n -0.000777 30.2200n -0.000729 30.2300n -0.000673 30.2400n -0.000612 30.2500n -0.000547 30.2600n -0.000480 30.2700n -0.000415 30.2800n -0.000354 30.2900n -0.000298
+ 30.3000n -0.000250 30.3100n -0.000213 30.3200n -0.000187 30.3300n -0.000175 30.3400n -0.000178 30.3500n -0.000196 30.3600n -0.000231 30.3700n -0.000282 30.3800n -0.000350 30.3900n -0.000433 30.4000n -0.000532 30.4100n -0.000644 30.4200n -0.000768 30.4300n -0.000902 30.4400n -0.001045
+ 30.4500n -0.001192 30.4600n -0.001343 30.4700n -0.001493 30.4800n -0.001641 30.4900n -0.001783 30.5000n -0.001916 30.5100n -0.002039 30.5200n -0.002147 30.5300n -0.002240 30.5400n -0.002315 30.5500n -0.002370 30.5600n -0.002405 30.5700n -0.002417 30.5800n -0.002406 30.5900n -0.002373
+ 30.6000n -0.002317 30.6100n -0.002239 30.6200n -0.002141 30.6300n -0.002023 30.6400n -0.001888 30.6500n -0.001737 30.6600n -0.001574 30.6700n -0.001400 30.6800n -0.001219 30.6900n -0.001034 30.7000n -0.000847 30.7100n -0.000662 30.7200n -0.000481 30.7300n -0.000308 30.7400n -0.000145
+ 30.7500n 0.000005 30.7600n 0.000141 30.7700n 0.000260 30.7800n 0.000362 30.7900n 0.000444 30.8000n 0.000506 30.8100n 0.000548 30.8200n 0.000571 30.8300n 0.000574 30.8400n 0.000558 30.8500n 0.000525 30.8600n 0.000476 30.8700n 0.000414 30.8800n 0.000340 30.8900n 0.000257
+ 30.9000n 0.000167 30.9100n 0.000074 30.9200n -0.000021 30.9300n -0.000114 30.9400n -0.000203 30.9500n -0.000286 30.9600n -0.000359 30.9700n -0.000422 30.9800n -0.000471 30.9900n -0.000505 31.0000n -0.000524 31.0100n -0.000525 31.0200n -0.000508 31.0300n -0.000474 31.0400n -0.000421
+ 31.0500n -0.000351 31.0600n -0.000264 31.0700n -0.000160 31.0800n -0.000042 31.0900n 0.000089 31.1000n 0.000232 31.1100n 0.000385 31.1200n 0.000545 31.1300n 0.000711 31.1400n 0.000881 31.1500n 0.001052 31.1600n 0.001222 31.1700n 0.001389 31.1800n 0.001552 31.1900n 0.001709
+ 31.2000n 0.001858 31.2100n 0.001998 31.2200n 0.002128 31.2300n 0.002246 31.2400n 0.002353 31.2500n 0.002447 31.2600n 0.002529 31.2700n 0.002598 31.2800n 0.002655 31.2900n 0.002699 31.3000n 0.002733 31.3100n 0.002755 31.3200n 0.002767 31.3300n 0.002770 31.3400n 0.002765
+ 31.3500n 0.002751 31.3600n 0.002732 31.3700n 0.002706 31.3800n 0.002676 31.3900n 0.002641 31.4000n 0.002603 31.4100n 0.002562 31.4200n 0.002519 31.4300n 0.002473 31.4400n 0.002425 31.4500n 0.002376 31.4600n 0.002325 31.4700n 0.002273 31.4800n 0.002219 31.4900n 0.002163
+ 31.5000n 0.002104 31.5100n 0.002043 31.5200n 0.001980 31.5300n 0.001913 31.5400n 0.001844 31.5500n 0.001771 31.5600n 0.001695 31.5700n 0.001615 31.5800n 0.001532 31.5900n 0.001445 31.6000n 0.001356 31.6100n 0.001263 31.6200n 0.001168 31.6300n 0.001071 31.6400n 0.000973
+ 31.6500n 0.000873 31.6600n 0.000774 31.6700n 0.000675 31.6800n 0.000577 31.6900n 0.000481 31.7000n 0.000387 31.7100n 0.000297 31.7200n 0.000210 31.7300n 0.000128 31.7400n 0.000051 31.7500n -0.000021 31.7600n -0.000088 31.7700n -0.000149 31.7800n -0.000204 31.7900n -0.000254
+ 31.8000n -0.000299 31.8100n -0.000338 31.8200n -0.000372 31.8300n -0.000403 31.8400n -0.000429 31.8500n -0.000452 31.8600n -0.000472 31.8700n -0.000489 31.8800n -0.000506 31.8900n -0.000521 31.9000n -0.000535 31.9100n -0.000549 31.9200n -0.000563 31.9300n -0.000577 31.9400n -0.000591
+ 31.9500n -0.000606 31.9600n -0.000621 31.9700n -0.000636 31.9800n -0.000650 31.9900n -0.000663 32.0000n -0.000674 32.0100n -0.000683 32.0200n -0.000688 32.0300n -0.000690 32.0400n -0.000686 32.0500n -0.000677 32.0600n -0.000662 32.0700n -0.000638 32.0800n -0.000607 32.0900n -0.000567
+ 32.1000n -0.000518 32.1100n -0.000460 32.1200n -0.000392 32.1300n -0.000314 32.1400n -0.000226 32.1500n -0.000130 32.1600n -0.000025 32.1700n 0.000087 32.1800n 0.000206 32.1900n 0.000330 32.2000n 0.000458 32.2100n 0.000589 32.2200n 0.000721 32.2300n 0.000852 32.2400n 0.000981
+ 32.2500n 0.001105 32.2600n 0.001223 32.2700n 0.001334 32.2800n 0.001436 32.2900n 0.001527 32.3000n 0.001606 32.3100n 0.001671 32.3200n 0.001723 32.3300n 0.001760 32.3400n 0.001782 32.3500n 0.001788 32.3600n 0.001779 32.3700n 0.001755 32.3800n 0.001717 32.3900n 0.001666
+ 32.4000n 0.001603 32.4100n 0.001528 32.4200n 0.001445 32.4300n 0.001353 32.4400n 0.001256 32.4500n 0.001155 32.4600n 0.001052 32.4700n 0.000950 32.4800n 0.000849 32.4900n 0.000752 32.5000n 0.000660 32.5100n 0.000575 32.5200n 0.000499 32.5300n 0.000433 32.5400n 0.000376
+ 32.5500n 0.000331 32.5600n 0.000298 32.5700n 0.000276 32.5800n 0.000265 32.5900n 0.000266 32.6000n 0.000277 32.6100n 0.000297 32.6200n 0.000325 32.6300n 0.000360 32.6400n 0.000400 32.6500n 0.000444 32.6600n 0.000490 32.6700n 0.000536 32.6800n 0.000581 32.6900n 0.000622
+ 32.7000n 0.000659 32.7100n 0.000689 32.7200n 0.000712 32.7300n 0.000725 32.7400n 0.000730 32.7500n 0.000724 32.7600n 0.000707 32.7700n 0.000680 32.7800n 0.000642 32.7900n 0.000594 32.8000n 0.000536 32.8100n 0.000469 32.8200n 0.000396 32.8300n 0.000316 32.8400n 0.000231
+ 32.8500n 0.000144 32.8600n 0.000055 32.8700n -0.000033 32.8800n -0.000119 32.8900n -0.000200 32.9000n -0.000276 32.9100n -0.000344 32.9200n -0.000404 32.9300n -0.000453 32.9400n -0.000491 32.9500n -0.000518 32.9600n -0.000532 32.9700n -0.000533 32.9800n -0.000522 32.9900n -0.000498
+ 33.0000n -0.000462 33.0100n -0.000416 33.0200n -0.000359 33.0300n -0.000294 33.0400n -0.000222 33.0500n -0.000145 33.0600n -0.000064 33.0700n 0.000018 33.0800n 0.000101 33.0900n 0.000181 33.1000n 0.000256 33.1100n 0.000326 33.1200n 0.000388 33.1300n 0.000441 33.1400n 0.000483
+ 33.1500n 0.000512 33.1600n 0.000529 33.1700n 0.000532 33.1800n 0.000520 33.1900n 0.000493 33.2000n 0.000452 33.2100n 0.000396 33.2200n 0.000326 33.2300n 0.000243 33.2400n 0.000148 33.2500n 0.000041 33.2600n -0.000075 33.2700n -0.000200 33.2800n -0.000332 33.2900n -0.000469
+ 33.3000n -0.000610 33.3100n -0.000752 33.3200n -0.000895 33.3300n -0.001037 33.3400n -0.001175 33.3500n -0.001310 33.3600n -0.001438 33.3700n -0.001560 33.3800n -0.001674 33.3900n -0.001779 33.4000n -0.001874 33.4100n -0.001959 33.4200n -0.002034 33.4300n -0.002097 33.4400n -0.002150
+ 33.4500n -0.002191 33.4600n -0.002222 33.4700n -0.002242 33.4800n -0.002251 33.4900n -0.002250 33.5000n -0.002239 33.5100n -0.002218 33.5200n -0.002188 33.5300n -0.002150 33.5400n -0.002104 33.5500n -0.002049 33.5600n -0.001987 33.5700n -0.001917 33.5800n -0.001841 33.5900n -0.001758
+ 33.6000n -0.001668 33.6100n -0.001573 33.6200n -0.001471 33.6300n -0.001364 33.6400n -0.001251 33.6500n -0.001133 33.6600n -0.001010 33.6700n -0.000883 33.6800n -0.000752 33.6900n -0.000618 33.7000n -0.000481 33.7100n -0.000342 33.7200n -0.000203 33.7300n -0.000063 33.7400n 0.000075
+ 33.7500n 0.000212 33.7600n 0.000345 33.7700n 0.000473 33.7800n 0.000595 33.7900n 0.000710 33.8000n 0.000817 33.8100n 0.000914 33.8200n 0.001000 33.8300n 0.001075 33.8400n 0.001136 33.8500n 0.001184 33.8600n 0.001217 33.8700n 0.001235 33.8800n 0.001239 33.8900n 0.001227
+ 33.9000n 0.001201 33.9100n 0.001161 33.9200n 0.001107 33.9300n 0.001040 33.9400n 0.000962 33.9500n 0.000875 33.9600n 0.000779 33.9700n 0.000677 33.9800n 0.000570 33.9900n 0.000461 34.0000n 0.000351 34.0100n 0.000244 34.0200n 0.000141 34.0300n 0.000043 34.0400n -0.000046
+ 34.0500n -0.000125 34.0600n -0.000192 34.0700n -0.000247 34.0800n -0.000287 34.0900n -0.000312 34.1000n -0.000322 34.1100n -0.000315 34.1200n -0.000293 34.1300n -0.000255 34.1400n -0.000203 34.1500n -0.000137 34.1600n -0.000058 34.1700n 0.000030 34.1800n 0.000128 34.1900n 0.000232
+ 34.2000n 0.000340 34.2100n 0.000450 34.2200n 0.000559 34.2300n 0.000665 34.2400n 0.000765 34.2500n 0.000857 34.2600n 0.000938 34.2700n 0.001007 34.2800n 0.001062 34.2900n 0.001100 34.3000n 0.001122 34.3100n 0.001124 34.3200n 0.001108 34.3300n 0.001073 34.3400n 0.001019
+ 34.3500n 0.000946 34.3600n 0.000855 34.3700n 0.000748 34.3800n 0.000625 34.3900n 0.000489 34.4000n 0.000342 34.4100n 0.000185 34.4200n 0.000021 34.4300n -0.000148 34.4400n -0.000319 34.4500n -0.000490 34.4600n -0.000658 34.4700n -0.000821 34.4800n -0.000977 34.4900n -0.001125
+ 34.5000n -0.001262 34.5100n -0.001388 34.5200n -0.001501 34.5300n -0.001600 34.5400n -0.001686 34.5500n -0.001757 34.5600n -0.001815 34.5700n -0.001859 34.5800n -0.001891 34.5900n -0.001912 34.6000n -0.001923 34.6100n -0.001926 34.6200n -0.001921 34.6300n -0.001912 34.6400n -0.001899
+ 34.6500n -0.001884 34.6600n -0.001870 34.6700n -0.001857 34.6800n -0.001847 34.6900n -0.001840 34.7000n -0.001839 34.7100n -0.001843 34.7200n -0.001853 34.7300n -0.001869 34.7400n -0.001890 34.7500n -0.001917 34.7600n -0.001947 34.7700n -0.001981 34.7800n -0.002015 34.7900n -0.002050
+ 34.8000n -0.002082 34.8100n -0.002110 34.8200n -0.002131 34.8300n -0.002145 34.8400n -0.002147 34.8500n -0.002137 34.8600n -0.002113 34.8700n -0.002073 34.8800n -0.002015 34.8900n -0.001938 34.9000n -0.001842 34.9100n -0.001725 34.9200n -0.001589 34.9300n -0.001433 34.9400n -0.001257
+ 34.9500n -0.001064 34.9600n -0.000855 34.9700n -0.000631 34.9800n -0.000394 34.9900n -0.000149 35.0000n 0.000104 35.0100n 0.000360 35.0200n 0.000616 35.0300n 0.000870 35.0400n 0.001117 35.0500n 0.001355 35.0600n 0.001580 35.0700n 0.001789 35.0800n 0.001980 35.0900n 0.002149
+ 35.1000n 0.002296 35.1100n 0.002417 35.1200n 0.002512 35.1300n 0.002579 35.1400n 0.002618 35.1500n 0.002630 35.1600n 0.002614 35.1700n 0.002572 35.1800n 0.002505 35.1900n 0.002415 35.2000n 0.002304 35.2100n 0.002174 35.2200n 0.002029 35.2300n 0.001871 35.2400n 0.001703
+ 35.2500n 0.001529 35.2600n 0.001352 35.2700n 0.001175 35.2800n 0.001001 35.2900n 0.000834 35.3000n 0.000674 35.3100n 0.000526 35.3200n 0.000391 35.3300n 0.000271 35.3400n 0.000167 35.3500n 0.000079 35.3600n 0.000009 35.3700n -0.000044 35.3800n -0.000080 35.3900n -0.000099
+ 35.4000n -0.000104 35.4100n -0.000095 35.4200n -0.000075 35.4300n -0.000044 35.4400n -0.000006 35.4500n 0.000037 35.4600n 0.000084 35.4700n 0.000131 35.4800n 0.000178 35.4900n 0.000220 35.5000n 0.000258 35.5100n 0.000288 35.5200n 0.000310 35.5300n 0.000322 35.5400n 0.000323
+ 35.5500n 0.000314 35.5600n 0.000293 35.5700n 0.000262 35.5800n 0.000220 35.5900n 0.000169 35.6000n 0.000110 35.6100n 0.000044 35.6200n -0.000027 35.6300n -0.000101 35.6400n -0.000176 35.6500n -0.000250 35.6600n -0.000321 35.6700n -0.000388 35.6800n -0.000447 35.6900n -0.000497
+ 35.7000n -0.000537 35.7100n -0.000565 35.7200n -0.000580 35.7300n -0.000582 35.7400n -0.000569 35.7500n -0.000542 35.7600n -0.000500 35.7700n -0.000445 35.7800n -0.000378 35.7900n -0.000299 35.8000n -0.000210 35.8100n -0.000113 35.8200n -0.000010 35.8300n 0.000097 35.8400n 0.000206
+ 35.8500n 0.000314 35.8600n 0.000419 35.8700n 0.000519 35.8800n 0.000611 35.8900n 0.000694 35.9000n 0.000765 35.9100n 0.000824 35.9200n 0.000868 35.9300n 0.000897 35.9400n 0.000909 35.9500n 0.000906 35.9600n 0.000887 35.9700n 0.000851 35.9800n 0.000801 35.9900n 0.000737
+ 36.0000n 0.000661 36.0100n 0.000574 36.0200n 0.000478 36.0300n 0.000376 36.0400n 0.000269 36.0500n 0.000161 36.0600n 0.000053 36.0700n -0.000053 36.0800n -0.000153 36.0900n -0.000246 36.1000n -0.000329 36.1100n -0.000402 36.1200n -0.000462 36.1300n -0.000509 36.1400n -0.000541
+ 36.1500n -0.000558 36.1600n -0.000560 36.1700n -0.000547 36.1800n -0.000519 36.1900n -0.000478 36.2000n -0.000424 36.2100n -0.000360 36.2200n -0.000286 36.2300n -0.000204 36.2400n -0.000117 36.2500n -0.000027 36.2600n 0.000064 36.2700n 0.000154 36.2800n 0.000240 36.2900n 0.000322
+ 36.3000n 0.000396 36.3100n 0.000461 36.3200n 0.000516 36.3300n 0.000559 36.3400n 0.000589 36.3500n 0.000607 36.3600n 0.000611 36.3700n 0.000602 36.3800n 0.000580 36.3900n 0.000545 36.4000n 0.000500 36.4100n 0.000444 36.4200n 0.000379 36.4300n 0.000307 36.4400n 0.000230
+ 36.4500n 0.000150 36.4600n 0.000068 36.4700n -0.000013 36.4800n -0.000092 36.4900n -0.000167 36.5000n -0.000235 36.5100n -0.000296 36.5200n -0.000348 36.5300n -0.000390 36.5400n -0.000422 36.5500n -0.000441 36.5600n -0.000449 36.5700n -0.000444 36.5800n -0.000428 36.5900n -0.000401
+ 36.6000n -0.000363 36.6100n -0.000315 36.6200n -0.000259 36.6300n -0.000195 36.6400n -0.000126 36.6500n -0.000053 36.6600n 0.000024 36.6700n 0.000101 36.6800n 0.000178 36.6900n 0.000254 36.7000n 0.000326 36.7100n 0.000394 36.7200n 0.000456 36.7300n 0.000512 36.7400n 0.000562
+ 36.7500n 0.000604 36.7600n 0.000638 36.7700n 0.000665 36.7800n 0.000685 36.7900n 0.000698 36.8000n 0.000705 36.8100n 0.000706 36.8200n 0.000703 36.8300n 0.000697 36.8400n 0.000688 36.8500n 0.000678 36.8600n 0.000668 36.8700n 0.000658 36.8800n 0.000651 36.8900n 0.000646
+ 36.9000n 0.000645 36.9100n 0.000648 36.9200n 0.000655 36.9300n 0.000667 36.9400n 0.000684 36.9500n 0.000706 36.9600n 0.000731 36.9700n 0.000760 36.9800n 0.000792 36.9900n 0.000826 37.0000n 0.000860 37.0100n 0.000894 37.0200n 0.000927 37.0300n 0.000956 37.0400n 0.000981
+ 37.0500n 0.001001 37.0600n 0.001014 37.0700n 0.001019 37.0800n 0.001015 37.0900n 0.001002 37.1000n 0.000979 37.1100n 0.000945 37.1200n 0.000900 37.1300n 0.000844 37.1400n 0.000778 37.1500n 0.000702 37.1600n 0.000617 37.1700n 0.000524 37.1800n 0.000425 37.1900n 0.000319
+ 37.2000n 0.000209 37.2100n 0.000097 37.2200n -0.000016 37.2300n -0.000128 37.2400n -0.000238 37.2500n -0.000344 37.2600n -0.000444 37.2700n -0.000537 37.2800n -0.000622 37.2900n -0.000697 37.3000n -0.000762 37.3100n -0.000816 37.3200n -0.000859 37.3300n -0.000891 37.3400n -0.000911
+ 37.3500n -0.000921 37.3600n -0.000919 37.3700n -0.000909 37.3800n -0.000889 37.3900n -0.000862 37.4000n -0.000829 37.4100n -0.000792 37.4200n -0.000750 37.4300n -0.000707 37.4400n -0.000663 37.4500n -0.000620 37.4600n -0.000579 37.4700n -0.000541 37.4800n -0.000507 37.4900n -0.000478
+ 37.5000n -0.000455 37.5100n -0.000437 37.5200n -0.000425 37.5300n -0.000419 37.5400n -0.000418 37.5500n -0.000422 37.5600n -0.000430 37.5700n -0.000440 37.5800n -0.000453 37.5900n -0.000467 37.6000n -0.000480 37.6100n -0.000491 37.6200n -0.000499 37.6300n -0.000503 37.6400n -0.000501
+ 37.6500n -0.000493 37.6600n -0.000477 37.6700n -0.000453 37.6800n -0.000421 37.6900n -0.000380 37.7000n -0.000331 37.7100n -0.000273 37.7200n -0.000208 37.7300n -0.000137 37.7400n -0.000060 37.7500n 0.000021 37.7600n 0.000104 37.7700n 0.000188 37.7800n 0.000270 37.7900n 0.000350
+ 37.8000n 0.000424 37.8100n 0.000491 37.8200n 0.000550 37.8300n 0.000598 37.8400n 0.000634 37.8500n 0.000657 37.8600n 0.000666 37.8700n 0.000659 37.8800n 0.000638 37.8900n 0.000602 37.9000n 0.000551 37.9100n 0.000486 37.9200n 0.000409 37.9300n 0.000321 37.9400n 0.000225
+ 37.9500n 0.000122 37.9600n 0.000015 37.9700n -0.000094 37.9800n -0.000200 37.9900n -0.000301 38.0000n -0.000395 38.0100n -0.000477 38.0200n -0.000545 38.0300n -0.000597 38.0400n -0.000630 38.0500n -0.000641 38.0600n -0.000629 38.0700n -0.000593 38.0800n -0.000531 38.0900n -0.000444
+ 38.1000n -0.000331 38.1100n -0.000194 38.1200n -0.000034 38.1300n 0.000148 38.1400n 0.000348 38.1500n 0.000563 38.1600n 0.000791 38.1700n 0.001027 38.1800n 0.001266 38.1900n 0.001506 38.2000n 0.001740 38.2100n 0.001964 38.2200n 0.002174 38.2300n 0.002364 38.2400n 0.002530
+ 38.2500n 0.002668 38.2600n 0.002775 38.2700n 0.002846 38.2800n 0.002880 38.2900n 0.002873 38.3000n 0.002824 38.3100n 0.002733 38.3200n 0.002599 38.3300n 0.002423 38.3400n 0.002206 38.3500n 0.001950 38.3600n 0.001659 38.3700n 0.001334 38.3800n 0.000982 38.3900n 0.000605
+ 38.4000n 0.000209 38.4100n -0.000200 38.4200n -0.000617 38.4300n -0.001036 38.4400n -0.001451 38.4500n -0.001856 38.4600n -0.002246 38.4700n -0.002615 38.4800n -0.002958 38.4900n -0.003271 38.5000n -0.003548 38.5100n -0.003787 38.5200n -0.003985 38.5300n -0.004139 38.5400n -0.004248
+ 38.5500n -0.004311 38.5600n -0.004328 38.5700n -0.004300 38.5800n -0.004229 38.5900n -0.004116 38.6000n -0.003964 38.6100n -0.003777 38.6200n -0.003559 38.6300n -0.003314 38.6400n -0.003046 38.6500n -0.002761 38.6600n -0.002462 38.6700n -0.002156 38.6800n -0.001848 38.6900n -0.001541
+ 38.7000n -0.001241 38.7100n -0.000952 38.7200n -0.000678 38.7300n -0.000423 38.7400n -0.000188 38.7500n 0.000023 38.7600n 0.000208 38.7700n 0.000366 38.7800n 0.000498 38.7900n 0.000601 38.8000n 0.000678 38.8100n 0.000728 38.8200n 0.000754 38.8300n 0.000757 38.8400n 0.000739
+ 38.8500n 0.000704 38.8600n 0.000653 38.8700n 0.000589 38.8800n 0.000516 38.8900n 0.000437 38.9000n 0.000354 38.9100n 0.000270 38.9200n 0.000189 38.9300n 0.000111 38.9400n 0.000039 38.9500n -0.000025 38.9600n -0.000079 38.9700n -0.000124 38.9800n -0.000158 38.9900n -0.000181
+ 39.0000n -0.000193 39.0100n -0.000196 39.0200n -0.000189 39.0300n -0.000175 39.0400n -0.000154 39.0500n -0.000128 39.0600n -0.000099 39.0700n -0.000069 39.0800n -0.000039 39.0900n -0.000012 39.1000n 0.000011 39.1100n 0.000027 39.1200n 0.000037 39.1300n 0.000037 39.1400n 0.000028
+ 39.1500n 0.000008 39.1600n -0.000023 39.1700n -0.000065 39.1800n -0.000118 39.1900n -0.000181 39.2000n -0.000253 39.2100n -0.000334 39.2200n -0.000422 39.2300n -0.000515 39.2400n -0.000613 39.2500n -0.000711 39.2600n -0.000810 39.2700n -0.000906 39.2800n -0.000998 39.2900n -0.001084
+ 39.3000n -0.001162 39.3100n -0.001229 39.3200n -0.001285 39.3300n -0.001329 39.3400n -0.001358 39.3500n -0.001373 39.3600n -0.001373 39.3700n -0.001356 39.3800n -0.001325 39.3900n -0.001278 39.4000n -0.001217 39.4100n -0.001142 39.4200n -0.001055 39.4300n -0.000956 39.4400n -0.000848
+ 39.4500n -0.000731 39.4600n -0.000608 39.4700n -0.000481 39.4800n -0.000350 39.4900n -0.000218 39.5000n -0.000087 39.5100n 0.000042 39.5200n 0.000168 39.5300n 0.000289 39.5400n 0.000404 39.5500n 0.000512 39.5600n 0.000614 39.5700n 0.000707 39.5800n 0.000793 39.5900n 0.000871
+ 39.6000n 0.000941 39.6100n 0.001004 39.6200n 0.001061 39.6300n 0.001112 39.6400n 0.001157 39.6500n 0.001198 39.6600n 0.001236 39.6700n 0.001272 39.6800n 0.001306 39.6900n 0.001339 39.7000n 0.001372 39.7100n 0.001406 39.7200n 0.001441 39.7300n 0.001478 39.7400n 0.001516
+ 39.7500n 0.001555 39.7600n 0.001596 39.7700n 0.001638 39.7800n 0.001680 39.7900n 0.001721 39.8000n 0.001761 39.8100n 0.001799 39.8200n 0.001834 39.8300n 0.001865 39.8400n 0.001890 39.8500n 0.001908 39.8600n 0.001919 39.8700n 0.001922 39.8800n 0.001916 39.8900n 0.001899
+ 39.9000n 0.001872 39.9100n 0.001835 39.9200n 0.001786 39.9300n 0.001727 39.9400n 0.001658 39.9500n 0.001579 39.9600n 0.001491 39.9700n 0.001395 39.9800n 0.001292 39.9900n 0.001184 40.0000n 0.001072 40.0100n 0.000957 40.0200n 0.000842 40.0300n 0.000728 40.0400n 0.000617
+ 40.0500n 0.000510 40.0600n 0.000409 40.0700n 0.000315 40.0800n 0.000229 40.0900n 0.000153 40.1000n 0.000086 40.1100n 0.000031 40.1200n -0.000013 40.1300n -0.000047 40.1400n -0.000070 40.1500n -0.000082 40.1600n -0.000086 40.1700n -0.000081 40.1800n -0.000069 40.1900n -0.000052
+ 40.2000n -0.000031 40.2100n -0.000007 40.2200n 0.000016 40.2300n 0.000038 40.2400n 0.000056 40.2500n 0.000068 40.2600n 0.000074 40.2700n 0.000071 40.2800n 0.000059 40.2900n 0.000035 40.3000n 0.000000 40.3100n -0.000047 40.3200n -0.000106 40.3300n -0.000178 40.3400n -0.000261
+ 40.3500n -0.000356 40.3600n -0.000459 40.3700n -0.000571 40.3800n -0.000689 40.3900n -0.000811 40.4000n -0.000935 40.4100n -0.001058 40.4200n -0.001178 40.4300n -0.001293 40.4400n -0.001399 40.4500n -0.001494 40.4600n -0.001576 40.4700n -0.001642 40.4800n -0.001689 40.4900n -0.001717
+ 40.5000n -0.001724 40.5100n -0.001708 40.5200n -0.001668 40.5300n -0.001605 40.5400n -0.001518 40.5500n -0.001407 40.5600n -0.001274 40.5700n -0.001120 40.5800n -0.000947 40.5900n -0.000756 40.6000n -0.000550 40.6100n -0.000333 40.6200n -0.000106 40.6300n 0.000126 40.6400n 0.000360
+ 40.6500n 0.000593 40.6600n 0.000821 40.6700n 0.001041 40.6800n 0.001250 40.6900n 0.001443 40.7000n 0.001618 40.7100n 0.001773 40.7200n 0.001905 40.7300n 0.002012 40.7400n 0.002091 40.7500n 0.002144 40.7600n 0.002167 40.7700n 0.002161 40.7800n 0.002127 40.7900n 0.002065
+ 40.8000n 0.001976 40.8100n 0.001862 40.8200n 0.001724 40.8300n 0.001565 40.8400n 0.001388 40.8500n 0.001196 40.8600n 0.000990 40.8700n 0.000776 40.8800n 0.000556 40.8900n 0.000334 40.9000n 0.000112 40.9100n -0.000105 40.9200n -0.000314 40.9300n -0.000514 40.9400n -0.000700
+ 40.9500n -0.000870 40.9600n -0.001022 40.9700n -0.001155 40.9800n -0.001267 40.9900n -0.001356 41.0000n -0.001423 41.0100n -0.001466 41.0200n -0.001485 41.0300n -0.001482 41.0400n -0.001457 41.0500n -0.001411 41.0600n -0.001345 41.0700n -0.001260 41.0800n -0.001160 41.0900n -0.001045
+ 41.1000n -0.000917 41.1100n -0.000780 41.1200n -0.000634 41.1300n -0.000483 41.1400n -0.000329 41.1500n -0.000173 41.1600n -0.000017 41.1700n 0.000136 41.1800n 0.000285 41.1900n 0.000428 41.2000n 0.000564 41.2100n 0.000692 41.2200n 0.000811 41.2300n 0.000921 41.2400n 0.001021
+ 41.2500n 0.001110 41.2600n 0.001189 41.2700n 0.001258 41.2800n 0.001318 41.2900n 0.001368 41.3000n 0.001409 41.3100n 0.001443 41.3200n 0.001469 41.3300n 0.001488 41.3400n 0.001502 41.3500n 0.001511 41.3600n 0.001516 41.3700n 0.001518 41.3800n 0.001516 41.3900n 0.001513
+ 41.4000n 0.001508 41.4100n 0.001502 41.4200n 0.001495 41.4300n 0.001488 41.4400n 0.001480 41.4500n 0.001471 41.4600n 0.001462 41.4700n 0.001451 41.4800n 0.001440 41.4900n 0.001427 41.5000n 0.001413 41.5100n 0.001396 41.5200n 0.001376 41.5300n 0.001354 41.5400n 0.001328
+ 41.5500n 0.001299 41.5600n 0.001266 41.5700n 0.001228 41.5800n 0.001186 41.5900n 0.001139 41.6000n 0.001088 41.6100n 0.001032 41.6200n 0.000972 41.6300n 0.000908 41.6400n 0.000841 41.6500n 0.000770 41.6600n 0.000697 41.6700n 0.000622 41.6800n 0.000546 41.6900n 0.000470
+ 41.7000n 0.000394 41.7100n 0.000319 41.7200n 0.000247 41.7300n 0.000177 41.7400n 0.000112 41.7500n 0.000051 41.7600n -0.000003 41.7700n -0.000052 41.7800n -0.000094 41.7900n -0.000128 41.8000n -0.000154 41.8100n -0.000171 41.8200n -0.000180 41.8300n -0.000181 41.8400n -0.000172
+ 41.8500n -0.000156 41.8600n -0.000131 41.8700n -0.000099 41.8800n -0.000059 41.8900n -0.000014 41.9000n 0.000037 41.9100n 0.000091 41.9200n 0.000149 41.9300n 0.000209 41.9400n 0.000269 41.9500n 0.000328 41.9600n 0.000385 41.9700n 0.000438 41.9800n 0.000485 41.9900n 0.000526
+ 42.0000n 0.000558 42.0100n 0.000581 42.0200n 0.000592 42.0300n 0.000592 42.0400n 0.000578 42.0500n 0.000550 42.0600n 0.000507 42.0700n 0.000448 42.0800n 0.000374 42.0900n 0.000283 42.1000n 0.000177 42.1100n 0.000056 42.1200n -0.000081 42.1300n -0.000232 42.1400n -0.000395
+ 42.1500n -0.000571 42.1600n -0.000756 42.1700n -0.000950 42.1800n -0.001150 42.1900n -0.001355 42.2000n -0.001561 42.2100n -0.001767 42.2200n -0.001970 42.2300n -0.002167 42.2400n -0.002357 42.2500n -0.002536 42.2600n -0.002702 42.2700n -0.002852 42.2800n -0.002985 42.2900n -0.003098
+ 42.3000n -0.003190 42.3100n -0.003259 42.3200n -0.003304 42.3300n -0.003324 42.3400n -0.003318 42.3500n -0.003286 42.3600n -0.003229 42.3700n -0.003147 42.3800n -0.003041 42.3900n -0.002912 42.4000n -0.002762 42.4100n -0.002593 42.4200n -0.002408 42.4300n -0.002209 42.4400n -0.002000
+ 42.4500n -0.001782 42.4600n -0.001561 42.4700n -0.001339 42.4800n -0.001119 42.4900n -0.000906 42.5000n -0.000702 42.5100n -0.000512 42.5200n -0.000337 42.5300n -0.000182 42.5400n -0.000047 42.5500n 0.000063 42.5600n 0.000148 42.5700n 0.000206 42.5800n 0.000236 42.5900n 0.000238
+ 42.6000n 0.000211 42.6100n 0.000157 42.6200n 0.000076 42.6300n -0.000029 42.6400n -0.000158 42.6500n -0.000308 42.6600n -0.000474 42.6700n -0.000656 42.6800n -0.000848 42.6900n -0.001047 42.7000n -0.001250 42.7100n -0.001451 42.7200n -0.001648 42.7300n -0.001836 42.7400n -0.002011
+ 42.7500n -0.002169 42.7600n -0.002308 42.7700n -0.002424 42.7800n -0.002514 42.7900n -0.002576 42.8000n -0.002609 42.8100n -0.002612 42.8200n -0.002583 42.8300n -0.002524 42.8400n -0.002433 42.8500n -0.002313 42.8600n -0.002166 42.8700n -0.001993 42.8800n -0.001797 42.8900n -0.001582
+ 42.9000n -0.001351 42.9100n -0.001109 42.9200n -0.000858 42.9300n -0.000604 42.9400n -0.000351 42.9500n -0.000103 42.9600n 0.000135 42.9700n 0.000359 42.9800n 0.000565 42.9900n 0.000749 43.0000n 0.000908 43.0100n 0.001040 43.0200n 0.001142 43.0300n 0.001212 43.0400n 0.001250
+ 43.0500n 0.001255 43.0600n 0.001226 43.0700n 0.001165 43.0800n 0.001074 43.0900n 0.000953 43.1000n 0.000807 43.1100n 0.000637 43.1200n 0.000447 43.1300n 0.000241 43.1400n 0.000024 43.1500n -0.000200 43.1600n -0.000427 43.1700n -0.000652 43.1800n -0.000869 43.1900n -0.001075
+ 43.2000n -0.001266 43.2100n -0.001437 43.2200n -0.001584 43.2300n -0.001704 43.2400n -0.001794 43.2500n -0.001853 43.2600n -0.001878 43.2700n -0.001869 43.2800n -0.001824 43.2900n -0.001745 43.3000n -0.001632 43.3100n -0.001487 43.3200n -0.001311 43.3300n -0.001108 43.3400n -0.000880
+ 43.3500n -0.000631 43.3600n -0.000365 43.3700n -0.000087 43.3800n 0.000199 43.3900n 0.000489 43.4000n 0.000777 43.4100n 0.001059 43.4200n 0.001331 43.4300n 0.001588 43.4400n 0.001825 43.4500n 0.002040 43.4600n 0.002228 43.4700n 0.002387 43.4800n 0.002514 43.4900n 0.002608
+ 43.5000n 0.002666 43.5100n 0.002689 43.5200n 0.002676 43.5300n 0.002628 43.5400n 0.002546 43.5500n 0.002430 43.5600n 0.002284 43.5700n 0.002110 43.5800n 0.001910 43.5900n 0.001689 43.6000n 0.001449 43.6100n 0.001196 43.6200n 0.000931 43.6300n 0.000661 43.6400n 0.000388
+ 43.6500n 0.000118 43.6600n -0.000147 43.6700n -0.000401 43.6800n -0.000642 43.6900n -0.000866 43.7000n -0.001070 43.7100n -0.001251 43.7200n -0.001408 43.7300n -0.001538 43.7400n -0.001640 43.7500n -0.001713 43.7600n -0.001757 43.7700n -0.001771 43.7800n -0.001756 43.7900n -0.001712
+ 43.8000n -0.001642 43.8100n -0.001545 43.8200n -0.001425 43.8300n -0.001283 43.8400n -0.001122 43.8500n -0.000944 43.8600n -0.000752 43.8700n -0.000548 43.8800n -0.000336 43.8900n -0.000118 43.9000n 0.000102 43.9100n 0.000323 43.9200n 0.000541 43.9300n 0.000754 43.9400n 0.000959
+ 43.9500n 0.001154 43.9600n 0.001337 43.9700n 0.001506 43.9800n 0.001660 43.9900n 0.001798 44.0000n 0.001917 44.0100n 0.002018 44.0200n 0.002099 44.0300n 0.002160 44.0400n 0.002201 44.0500n 0.002222 44.0600n 0.002223 44.0700n 0.002204 44.0800n 0.002167 44.0900n 0.002112
+ 44.1000n 0.002039 44.1100n 0.001950 44.1200n 0.001845 44.1300n 0.001727 44.1400n 0.001597 44.1500n 0.001455 44.1600n 0.001303 44.1700n 0.001144 44.1800n 0.000977 44.1900n 0.000806 44.2000n 0.000630 44.2100n 0.000453 44.2200n 0.000275 44.2300n 0.000099 44.2400n -0.000076
+ 44.2500n -0.000246 44.2600n -0.000412 44.2700n -0.000571 44.2800n -0.000723 44.2900n -0.000866 44.3000n -0.001000 44.3100n -0.001123 44.3200n -0.001235 44.3300n -0.001336 44.3400n -0.001424 44.3500n -0.001500 44.3600n -0.001564 44.3700n -0.001614 44.3800n -0.001653 44.3900n -0.001678
+ 44.4000n -0.001692 44.4100n -0.001693 44.4200n -0.001684 44.4300n -0.001664 44.4400n -0.001635 44.4500n -0.001596 44.4600n -0.001549 44.4700n -0.001494 44.4800n -0.001433 44.4900n -0.001367 44.5000n -0.001295 44.5100n -0.001219 44.5200n -0.001140 44.5300n -0.001059 44.5400n -0.000975
+ 44.5500n -0.000889 44.5600n -0.000803 44.5700n -0.000715 44.5800n -0.000627 44.5900n -0.000538 44.6000n -0.000448 44.6100n -0.000357 44.6200n -0.000265 44.6300n -0.000172 44.6400n -0.000076 44.6500n 0.000021 44.6600n 0.000122 44.6700n 0.000225 44.6800n 0.000332 44.6900n 0.000443
+ 44.7000n 0.000558 44.7100n 0.000678 44.7200n 0.000802 44.7300n 0.000931 44.7400n 0.001064 44.7500n 0.001202 44.7600n 0.001342 44.7700n 0.001485 44.7800n 0.001631 44.7900n 0.001777 44.8000n 0.001922 44.8100n 0.002066 44.8200n 0.002206 44.8300n 0.002340 44.8400n 0.002468
+ 44.8500n 0.002588 44.8600n 0.002696 44.8700n 0.002792 44.8800n 0.002874 44.8900n 0.002939 44.9000n 0.002987 44.9100n 0.003015 44.9200n 0.003022 44.9300n 0.003008 44.9400n 0.002972 44.9500n 0.002912 44.9600n 0.002829 44.9700n 0.002723 44.9800n 0.002594 44.9900n 0.002443
+ 45.0000n 0.002272 45.0100n 0.002081 45.0200n 0.001874 45.0300n 0.001651 45.0400n 0.001415 45.0500n 0.001169 45.0600n 0.000916 45.0700n 0.000659 45.0800n 0.000401 45.0900n 0.000146 45.1000n -0.000104 45.1100n -0.000346 45.1200n -0.000575 45.1300n -0.000790 45.1400n -0.000987
+ 45.1500n -0.001164 45.1600n -0.001318 45.1700n -0.001448 45.1800n -0.001553 45.1900n -0.001630 45.2000n -0.001680 45.2100n -0.001702 45.2200n -0.001696 45.2300n -0.001663 45.2400n -0.001603 45.2500n -0.001518 45.2600n -0.001410 45.2700n -0.001280 45.2800n -0.001131 45.2900n -0.000965
+ 45.3000n -0.000785 45.3100n -0.000594 45.3200n -0.000395 45.3300n -0.000190 45.3400n 0.000017 45.3500n 0.000224 45.3600n 0.000427 45.3700n 0.000625 45.3800n 0.000816 45.3900n 0.000996 45.4000n 0.001164 45.4100n 0.001320 45.4200n 0.001460 45.4300n 0.001586 45.4400n 0.001696
+ 45.4500n 0.001789 45.4600n 0.001867 45.4700n 0.001929 45.4800n 0.001976 45.4900n 0.002008 45.5000n 0.002028 45.5100n 0.002035 45.5200n 0.002032 45.5300n 0.002019 45.5400n 0.001997 45.5500n 0.001969 45.5600n 0.001934 45.5700n 0.001895 45.5800n 0.001853 45.5900n 0.001807
+ 45.6000n 0.001759 45.6100n 0.001710 45.6200n 0.001658 45.6300n 0.001606 45.6400n 0.001551 45.6500n 0.001495 45.6600n 0.001436 45.6700n 0.001374 45.6800n 0.001308 45.6900n 0.001237 45.7000n 0.001161 45.7100n 0.001079 45.7200n 0.000989 45.7300n 0.000891 45.7400n 0.000785
+ 45.7500n 0.000671 45.7600n 0.000547 45.7700n 0.000413 45.7800n 0.000271 45.7900n 0.000121 45.8000n -0.000038 45.8100n -0.000203 45.8200n -0.000373 45.8300n -0.000547 45.8400n -0.000723 45.8500n -0.000899 45.8600n -0.001073 45.8700n -0.001242 45.8800n -0.001405 45.8900n -0.001557
+ 45.9000n -0.001698 45.9100n -0.001825 45.9200n -0.001935 45.9300n -0.002027 45.9400n -0.002098 45.9500n -0.002148 45.9600n -0.002174 45.9700n -0.002176 45.9800n -0.002154 45.9900n -0.002107 46.0000n -0.002036 46.0100n -0.001941 46.0200n -0.001825 46.0300n -0.001688 46.0400n -0.001533
+ 46.0500n -0.001363 46.0600n -0.001179 46.0700n -0.000986 46.0800n -0.000787 46.0900n -0.000584 46.1000n -0.000383 46.1100n -0.000186 46.1200n 0.000003 46.1300n 0.000180 46.1400n 0.000343 46.1500n 0.000487 46.1600n 0.000611 46.1700n 0.000711 46.1800n 0.000786 46.1900n 0.000834
+ 46.2000n 0.000855 46.2100n 0.000847 46.2200n 0.000811 46.2300n 0.000747 46.2400n 0.000656 46.2500n 0.000541 46.2600n 0.000402 46.2700n 0.000243 46.2800n 0.000065 46.2900n -0.000126 46.3000n -0.000329 46.3100n -0.000539 46.3200n -0.000754 46.3300n -0.000968 46.3400n -0.001178
+ 46.3500n -0.001382 46.3600n -0.001574 46.3700n -0.001753 46.3800n -0.001915 46.3900n -0.002058 46.4000n -0.002180 46.4100n -0.002280 46.4200n -0.002355 46.4300n -0.002407 46.4400n -0.002434 46.4500n -0.002437 46.4600n -0.002417 46.4700n -0.002376 46.4800n -0.002315 46.4900n -0.002236
+ 46.5000n -0.002142 46.5100n -0.002036 46.5200n -0.001921 46.5300n -0.001799 46.5400n -0.001674 46.5500n -0.001549 46.5600n -0.001427 46.5700n -0.001310 46.5800n -0.001202 46.5900n -0.001103 46.6000n -0.001017 46.6100n -0.000945 46.6200n -0.000888 46.6300n -0.000847 46.6400n -0.000821
+ 46.6500n -0.000811 46.6600n -0.000815 46.6700n -0.000833 46.6800n -0.000864 46.6900n -0.000904 46.7000n -0.000953 46.7100n -0.001008 46.7200n -0.001065 46.7300n -0.001123 46.7400n -0.001178 46.7500n -0.001228 46.7600n -0.001270 46.7700n -0.001301 46.7800n -0.001320 46.7900n -0.001324
+ 46.8000n -0.001311 46.8100n -0.001280 46.8200n -0.001231 46.8300n -0.001162 46.8400n -0.001073 46.8500n -0.000966 46.8600n -0.000840 46.8700n -0.000698 46.8800n -0.000540 46.8900n -0.000369 46.9000n -0.000187 46.9100n 0.000003 46.9200n 0.000198 46.9300n 0.000395 46.9400n 0.000592
+ 46.9500n 0.000785 46.9600n 0.000971 46.9700n 0.001147 46.9800n 0.001310 46.9900n 0.001458 47.0000n 0.001589 47.0100n 0.001700 47.0200n 0.001791 47.0300n 0.001860 47.0400n 0.001907 47.0500n 0.001931 47.0600n 0.001933 47.0700n 0.001914 47.0800n 0.001874 47.0900n 0.001815
+ 47.1000n 0.001740 47.1100n 0.001649 47.1200n 0.001547 47.1300n 0.001435 47.1400n 0.001316 47.1500n 0.001193 47.1600n 0.001069 47.1700n 0.000947 47.1800n 0.000829 47.1900n 0.000718 47.2000n 0.000617 47.2100n 0.000526 47.2200n 0.000449 47.2300n 0.000386 47.2400n 0.000339
+ 47.2500n 0.000307 47.2600n 0.000292 47.2700n 0.000292 47.2800n 0.000308 47.2900n 0.000337 47.3000n 0.000380 47.3100n 0.000435 47.3200n 0.000499 47.3300n 0.000571 47.3400n 0.000648 47.3500n 0.000729 47.3600n 0.000810 47.3700n 0.000891 47.3800n 0.000968 47.3900n 0.001039
+ 47.4000n 0.001104 47.4100n 0.001159 47.4200n 0.001204 47.4300n 0.001239 47.4400n 0.001261 47.4500n 0.001270 47.4600n 0.001268 47.4700n 0.001253 47.4800n 0.001227 47.4900n 0.001190 47.5000n 0.001143 47.5100n 0.001088 47.5200n 0.001027 47.5300n 0.000962 47.5400n 0.000893
+ 47.5500n 0.000824 47.5600n 0.000755 47.5700n 0.000690 47.5800n 0.000629 47.5900n 0.000575 47.6000n 0.000528 47.6100n 0.000490 47.6200n 0.000463 47.6300n 0.000446 47.6400n 0.000440 47.6500n 0.000445 47.6600n 0.000462 47.6700n 0.000488 47.6800n 0.000525 47.6900n 0.000569
+ 47.7000n 0.000621 47.7100n 0.000679 47.7200n 0.000740 47.7300n 0.000804 47.7400n 0.000868 47.7500n 0.000931 47.7600n 0.000989 47.7700n 0.001043 47.7800n 0.001090 47.7900n 0.001128 47.8000n 0.001157 47.8100n 0.001175 47.8200n 0.001182 47.8300n 0.001177 47.8400n 0.001160
+ 47.8500n 0.001131 47.8600n 0.001091 47.8700n 0.001040 47.8800n 0.000981 47.8900n 0.000913 47.9000n 0.000839 47.9100n 0.000760 47.9200n 0.000679 47.9300n 0.000597 47.9400n 0.000517 47.9500n 0.000440 47.9600n 0.000369 47.9700n 0.000306 47.9800n 0.000252 47.9900n 0.000210
+ 48.0000n 0.000179 48.0100n 0.000162 48.0200n 0.000159 48.0300n 0.000171 48.0400n 0.000197 48.0500n 0.000237 48.0600n 0.000291 48.0700n 0.000357 48.0800n 0.000434 48.0900n 0.000521 48.1000n 0.000616 48.1100n 0.000715 48.1200n 0.000818 48.1300n 0.000921 48.1400n 0.001023
+ 48.1500n 0.001119 48.1600n 0.001209 48.1700n 0.001289 48.1800n 0.001356 48.1900n 0.001410 48.2000n 0.001448 48.2100n 0.001468 48.2200n 0.001470 48.2300n 0.001451 48.2400n 0.001413 48.2500n 0.001354 48.2600n 0.001275 48.2700n 0.001177 48.2800n 0.001060 48.2900n 0.000926
+ 48.3000n 0.000777 48.3100n 0.000615 48.3200n 0.000442 48.3300n 0.000261 48.3400n 0.000074 48.3500n -0.000116 48.3600n -0.000307 48.3700n -0.000494 48.3800n -0.000677 48.3900n -0.000851 48.4000n -0.001015 48.4100n -0.001166 48.4200n -0.001303 48.4300n -0.001423 48.4400n -0.001526
+ 48.4500n -0.001611 48.4600n -0.001676 48.4700n -0.001722 48.4800n -0.001750 48.4900n -0.001758 48.5000n -0.001749 48.5100n -0.001724 48.5200n -0.001683 48.5300n -0.001630 48.5400n -0.001565 48.5500n -0.001491 48.5600n -0.001410 48.5700n -0.001325 48.5800n -0.001237 48.5900n -0.001150
+ 48.6000n -0.001064 48.6100n -0.000983 48.6200n -0.000908 48.6300n -0.000841 48.6400n -0.000783 48.6500n -0.000735 48.6600n -0.000698 48.6700n -0.000673 48.6800n -0.000660 48.6900n -0.000658 48.7000n -0.000668 48.7100n -0.000688 48.7200n -0.000719 48.7300n -0.000757 48.7400n -0.000803
+ 48.7500n -0.000854 48.7600n -0.000909 48.7700n -0.000966 48.7800n -0.001022 48.7900n -0.001077 48.8000n -0.001128 48.8100n -0.001174 48.8200n -0.001212 48.8300n -0.001242 48.8400n -0.001262 48.8500n -0.001270 48.8600n -0.001267 48.8700n -0.001251 48.8800n -0.001222 48.8900n -0.001179
+ 48.9000n -0.001124 48.9100n -0.001055 48.9200n -0.000975 48.9300n -0.000884 48.9400n -0.000782 48.9500n -0.000671 48.9600n -0.000553 48.9700n -0.000429 48.9800n -0.000301 48.9900n -0.000170 49.0000n -0.000038 49.0100n 0.000094 49.0200n 0.000222 49.0300n 0.000347 49.0400n 0.000466
+ 49.0500n 0.000578 49.0600n 0.000682 49.0700n 0.000776 49.0800n 0.000860 49.0900n 0.000933 49.1000n 0.000994 49.1100n 0.001042 49.1200n 0.001079 49.1300n 0.001102 49.1400n 0.001113 49.1500n 0.001112 49.1600n 0.001099 49.1700n 0.001075 49.1800n 0.001040 49.1900n 0.000995
+ 49.2000n 0.000941 49.2100n 0.000878 49.2200n 0.000807 49.2300n 0.000731 49.2400n 0.000648 49.2500n 0.000560 49.2600n 0.000469 49.2700n 0.000374 49.2800n 0.000276 49.2900n 0.000178 49.3000n 0.000078 49.3100n -0.000022 49.3200n -0.000122 49.3300n -0.000221 49.3400n -0.000318
+ 49.3500n -0.000414 49.3600n -0.000507 49.3700n -0.000598 49.3800n -0.000685 49.3900n -0.000770 49.4000n -0.000850 49.4100n -0.000927 49.4200n -0.001000 49.4300n -0.001068 49.4400n -0.001132 49.4500n -0.001190 49.4600n -0.001244 49.4700n -0.001293 49.4800n -0.001336 49.4900n -0.001374
+ 49.5000n -0.001406 49.5100n -0.001433 49.5200n -0.001454 49.5300n -0.001470 49.5400n -0.001480 49.5500n -0.001486 49.5600n -0.001486 49.5700n -0.001482 49.5800n -0.001473 49.5900n -0.001461 49.6000n -0.001445 49.6100n -0.001426 49.6200n -0.001405 49.6300n -0.001383 49.6400n -0.001360
+ 49.6500n -0.001336 49.6600n -0.001313 49.6700n -0.001290 49.6800n -0.001270 49.6900n -0.001252 49.7000n -0.001237 49.7100n -0.001225 49.7200n -0.001217 49.7300n -0.001214 49.7400n -0.001215 49.7500n -0.001221 49.7600n -0.001231 49.7700n -0.001246 49.7800n -0.001265 49.7900n -0.001289
+ 49.8000n -0.001316 49.8100n -0.001345 49.8200n -0.001378 49.8300n -0.001412 49.8400n -0.001446 49.8500n -0.001481 49.8600n -0.001514 49.8700n -0.001545 49.8800n -0.001573 49.8900n -0.001597 49.9000n -0.001616 49.9100n -0.001629 49.9200n -0.001635 49.9300n -0.001634 49.9400n -0.001624
+ 49.9500n -0.001606 49.9600n -0.001578 49.9700n -0.001541 49.9800n -0.001493 49.9900n -0.001437 50.0000n -0.001370 50.0100n -0.001294 50.0200n -0.001209 50.0300n -0.001115 50.0400n -0.001013 50.0500n -0.000904 50.0600n -0.000789 50.0700n -0.000667 50.0800n -0.000541 50.0900n -0.000411
+ 50.1000n -0.000278 50.1100n -0.000143 50.1200n -0.000007 50.1300n 0.000130 50.1400n 0.000266 50.1500n 0.000401 50.1600n 0.000533 50.1700n 0.000663 50.1800n 0.000790 50.1900n 0.000913 50.2000n 0.001032 50.2100n 0.001147 50.2200n 0.001257 50.2300n 0.001361 50.2400n 0.001461
+ 50.2500n 0.001555 50.2600n 0.001644 50.2700n 0.001728 50.2800n 0.001806 50.2900n 0.001878 50.3000n 0.001944 50.3100n 0.002005 50.3200n 0.002059 50.3300n 0.002107 50.3400n 0.002148 50.3500n 0.002183 50.3600n 0.002210 50.3700n 0.002230 50.3800n 0.002242 50.3900n 0.002245
+ 50.4000n 0.002240 50.4100n 0.002226 50.4200n 0.002203 50.4300n 0.002170 50.4400n 0.002127 50.4500n 0.002075 50.4600n 0.002012 50.4700n 0.001940 50.4800n 0.001859 50.4900n 0.001769 50.5000n 0.001671 50.5100n 0.001565 50.5200n 0.001453 50.5300n 0.001335 50.5400n 0.001213
+ 50.5500n 0.001089 50.5600n 0.000963 50.5700n 0.000837 50.5800n 0.000714 50.5900n 0.000594 50.6000n 0.000480 50.6100n 0.000374 50.6200n 0.000276 50.6300n 0.000189 50.6400n 0.000114 50.6500n 0.000053 50.6600n 0.000006 50.6700n -0.000025 50.6800n -0.000041 50.6900n -0.000041
+ 50.7000n -0.000024 50.7100n 0.000008 50.7200n 0.000055 50.7300n 0.000117 50.7400n 0.000191 50.7500n 0.000275 50.7600n 0.000369 50.7700n 0.000470 50.7800n 0.000575 50.7900n 0.000681 50.8000n 0.000786 50.8100n 0.000886 50.8200n 0.000980 50.8300n 0.001063 50.8400n 0.001134
+ 50.8500n 0.001189 50.8600n 0.001225 50.8700n 0.001242 50.8800n 0.001236 50.8900n 0.001206 50.9000n 0.001151 50.9100n 0.001071 50.9200n 0.000965 50.9300n 0.000833 50.9400n 0.000677 50.9500n 0.000497 50.9600n 0.000295 50.9700n 0.000073 50.9800n -0.000165 50.9900n -0.000417
+ 51.0000n -0.000679 51.0100n -0.000949 51.0200n -0.001221 51.0300n -0.001492 51.0400n -0.001757 51.0500n -0.002013 51.0600n -0.002255 51.0700n -0.002480 51.0800n -0.002683 51.0900n -0.002862 51.1000n -0.003013 51.1100n -0.003134 51.1200n -0.003223 51.1300n -0.003278 51.1400n -0.003298
+ 51.1500n -0.003284 51.1600n -0.003235 51.1700n -0.003151 51.1800n -0.003036 51.1900n -0.002889 51.2000n -0.002715 51.2100n -0.002516 51.2200n -0.002296 51.2300n -0.002058 51.2400n -0.001807 51.2500n -0.001547 51.2600n -0.001282 51.2700n -0.001018 51.2800n -0.000757 51.2900n -0.000506
+ 51.3000n -0.000267 51.3100n -0.000045 51.3200n 0.000157 51.3300n 0.000335 51.3400n 0.000488 51.3500n 0.000614 51.3600n 0.000710 51.3700n 0.000776 51.3800n 0.000813 51.3900n 0.000820 51.4000n 0.000798 51.4100n 0.000750 51.4200n 0.000676 51.4300n 0.000581 51.4400n 0.000467
+ 51.4500n 0.000337 51.4600n 0.000196 51.4700n 0.000046 51.4800n -0.000107 51.4900n -0.000260 51.5000n -0.000409 51.5100n -0.000549 51.5200n -0.000678 51.5300n -0.000792 51.5400n -0.000887 51.5500n -0.000961 51.5600n -0.001012 51.5700n -0.001038 51.5800n -0.001039 51.5900n -0.001013
+ 51.6000n -0.000961 51.6100n -0.000884 51.6200n -0.000782 51.6300n -0.000658 51.6400n -0.000514 51.6500n -0.000351 51.6600n -0.000174 51.6700n 0.000014 51.6800n 0.000210 51.6900n 0.000411 51.7000n 0.000611 51.7100n 0.000808 51.7200n 0.000997 51.7300n 0.001176 51.7400n 0.001340
+ 51.7500n 0.001486 51.7600n 0.001612 51.7700n 0.001715 51.7800n 0.001794 51.7900n 0.001846 51.8000n 0.001871 51.8100n 0.001868 51.8200n 0.001837 51.8300n 0.001779 51.8400n 0.001695 51.8500n 0.001585 51.8600n 0.001453 51.8700n 0.001300 51.8800n 0.001128 51.8900n 0.000941
+ 51.9000n 0.000741 51.9100n 0.000532 51.9200n 0.000317 51.9300n 0.000098 51.9400n -0.000120 51.9500n -0.000335 51.9600n -0.000544 51.9700n -0.000744 51.9800n -0.000933 51.9900n -0.001108 52.0000n -0.001268 52.0100n -0.001411 52.0200n -0.001536 52.0300n -0.001641 52.0400n -0.001727
+ 52.0500n -0.001793 52.0600n -0.001840 52.0700n -0.001866 52.0800n -0.001874 52.0900n -0.001864 52.1000n -0.001838 52.1100n -0.001795 52.1200n -0.001738 52.1300n -0.001668 52.1400n -0.001587 52.1500n -0.001495 52.1600n -0.001395 52.1700n -0.001287 52.1800n -0.001172 52.1900n -0.001053
+ 52.2000n -0.000929 52.2100n -0.000802 52.2200n -0.000673 52.2300n -0.000542 52.2400n -0.000409 52.2500n -0.000276 52.2600n -0.000141 52.2700n -0.000007 52.2800n 0.000128 52.2900n 0.000263 52.3000n 0.000398 52.3100n 0.000532 52.3200n 0.000667 52.3300n 0.000800 52.3400n 0.000932
+ 52.3500n 0.001063 52.3600n 0.001192 52.3700n 0.001318 52.3800n 0.001440 52.3900n 0.001558 52.4000n 0.001671 52.4100n 0.001777 52.4200n 0.001876 52.4300n 0.001966 52.4400n 0.002046 52.4500n 0.002115 52.4600n 0.002171 52.4700n 0.002214 52.4800n 0.002243 52.4900n 0.002256
+ 52.5000n 0.002254 52.5100n 0.002234 52.5200n 0.002198 52.5300n 0.002146 52.5400n 0.002076 52.5500n 0.001990 52.5600n 0.001889 52.5700n 0.001773 52.5800n 0.001644 52.5900n 0.001504 52.6000n 0.001353 52.6100n 0.001193 52.6200n 0.001028 52.6300n 0.000859 52.6400n 0.000688
+ 52.6500n 0.000518 52.6600n 0.000350 52.6700n 0.000188 52.6800n 0.000034 52.6900n -0.000112 52.7000n -0.000245 52.7100n -0.000366 52.7200n -0.000472 52.7300n -0.000563 52.7400n -0.000637 52.7500n -0.000695 52.7600n -0.000735 52.7700n -0.000758 52.7800n -0.000765 52.7900n -0.000756
+ 52.8000n -0.000732 52.8100n -0.000695 52.8200n -0.000647 52.8300n -0.000588 52.8400n -0.000521 52.8500n -0.000448 52.8600n -0.000371 52.8700n -0.000292 52.8800n -0.000213 52.8900n -0.000136 52.9000n -0.000063 52.9100n 0.000006 52.9200n 0.000067 52.9300n 0.000121 52.9400n 0.000167
+ 52.9500n 0.000203 52.9600n 0.000231 52.9700n 0.000249 52.9800n 0.000258 52.9900n 0.000259 53.0000n 0.000254 53.0100n 0.000242 53.0200n 0.000225 53.0300n 0.000206 53.0400n 0.000185 53.0500n 0.000165 53.0600n 0.000146 53.0700n 0.000132 53.0800n 0.000122 53.0900n 0.000119
+ 53.1000n 0.000124 53.1100n 0.000138 53.1200n 0.000162 53.1300n 0.000196 53.1400n 0.000240 53.1500n 0.000293 53.1600n 0.000356 53.1700n 0.000427 53.1800n 0.000506 53.1900n 0.000590 53.2000n 0.000677 53.2100n 0.000766 53.2200n 0.000854 53.2300n 0.000939 53.2400n 0.001019
+ 53.2500n 0.001090 53.2600n 0.001150 53.2700n 0.001198 53.2800n 0.001230 53.2900n 0.001244 53.3000n 0.001240 53.3100n 0.001215 53.3200n 0.001169 53.3300n 0.001101 53.3400n 0.001011 53.3500n 0.000899 53.3600n 0.000767 53.3700n 0.000615 53.3800n 0.000445 53.3900n 0.000260
+ 53.4000n 0.000062 53.4100n -0.000146 53.4200n -0.000361 53.4300n -0.000579 53.4400n -0.000797 53.4500n -0.001010 53.4600n -0.001216 53.4700n -0.001410 53.4800n -0.001589 53.4900n -0.001749 53.5000n -0.001888 53.5100n -0.002003 53.5200n -0.002091 53.5300n -0.002151 53.5400n -0.002182
+ 53.5500n -0.002183 53.5600n -0.002153 53.5700n -0.002094 53.5800n -0.002006 53.5900n -0.001892 53.6000n -0.001752 53.6100n -0.001591 53.6200n -0.001410 53.6300n -0.001214 53.6400n -0.001006 53.6500n -0.000791 53.6600n -0.000573 53.6700n -0.000355 53.6800n -0.000142 53.6900n 0.000061
+ 53.7000n 0.000251 53.7100n 0.000424 53.7200n 0.000577 53.7300n 0.000707 53.7400n 0.000812 53.7500n 0.000890 53.7600n 0.000940 53.7700n 0.000960 53.7800n 0.000952 53.7900n 0.000915 53.8000n 0.000852 53.8100n 0.000763 53.8200n 0.000651 53.8300n 0.000520 53.8400n 0.000372
+ 53.8500n 0.000212 53.8600n 0.000042 53.8700n -0.000132 53.8800n -0.000307 53.8900n -0.000478 53.9000n -0.000641 53.9100n -0.000792 53.9200n -0.000928 53.9300n -0.001044 53.9400n -0.001139 53.9500n -0.001208 53.9600n -0.001251 53.9700n -0.001266 53.9800n -0.001252 53.9900n -0.001210
+ 54.0000n -0.001138 54.0100n -0.001039 54.0200n -0.000914 54.0300n -0.000766 54.0400n -0.000597 54.0500n -0.000410 54.0600n -0.000209 54.0700n 0.000003 54.0800n 0.000221 54.0900n 0.000441 54.1000n 0.000659 54.1100n 0.000870 54.1200n 0.001071 54.1300n 0.001258 54.1400n 0.001426
+ 54.1500n 0.001574 54.1600n 0.001698 54.1700n 0.001795 54.1800n 0.001865 54.1900n 0.001906 54.2000n 0.001917 54.2100n 0.001898 54.2200n 0.001851 54.2300n 0.001775 54.2400n 0.001673 54.2500n 0.001546 54.2600n 0.001398 54.2700n 0.001232 54.2800n 0.001050 54.2900n 0.000855
+ 54.3000n 0.000653 54.3100n 0.000446 54.3200n 0.000238 54.3300n 0.000033 54.3400n -0.000166 54.3500n -0.000356 54.3600n -0.000533 54.3700n -0.000696 54.3800n -0.000841 54.3900n -0.000967 54.4000n -0.001073 54.4100n -0.001158 54.4200n -0.001221 54.4300n -0.001263 54.4400n -0.001285
+ 54.4500n -0.001287 54.4600n -0.001270 54.4700n -0.001237 54.4800n -0.001189 54.4900n -0.001129 54.5000n -0.001059 54.5100n -0.000982 54.5200n -0.000900 54.5300n -0.000816 54.5400n -0.000732 54.5500n -0.000650 54.5600n -0.000573 54.5700n -0.000502 54.5800n -0.000439 54.5900n -0.000385
+ 54.6000n -0.000341 54.6100n -0.000306 54.6200n -0.000282 54.6300n -0.000268 54.6400n -0.000262 54.6500n -0.000264 54.6600n -0.000273 54.6700n -0.000287 54.6800n -0.000304 54.6900n -0.000321 54.7000n -0.000338 54.7100n -0.000350 54.7200n -0.000358 54.7300n -0.000357 54.7400n -0.000347
+ 54.7500n -0.000325 54.7600n -0.000289 54.7700n -0.000240 54.7800n -0.000175 54.7900n -0.000094 54.8000n 0.000003 54.8100n 0.000116 54.8200n 0.000245 54.8300n 0.000388 54.8400n 0.000544 54.8500n 0.000712 54.8600n 0.000889 54.8700n 0.001074 54.8800n 0.001263 54.8900n 0.001454
+ 54.9000n 0.001644 54.9100n 0.001830 54.9200n 0.002009 54.9300n 0.002179 54.9400n 0.002336 54.9500n 0.002479 54.9600n 0.002604 54.9700n 0.002710 54.9800n 0.002795 54.9900n 0.002857 55.0000n 0.002896 55.0100n 0.002912 55.0200n 0.002903 55.0300n 0.002871 55.0400n 0.002816
+ 55.0500n 0.002739 55.0600n 0.002642 55.0700n 0.002526 55.0800n 0.002395 55.0900n 0.002250 55.1000n 0.002095 55.1100n 0.001931 55.1200n 0.001762 55.1300n 0.001592 55.1400n 0.001423 55.1500n 0.001257 55.1600n 0.001099 55.1700n 0.000950 55.1800n 0.000813 55.1900n 0.000691
+ 55.2000n 0.000584 55.2100n 0.000494 55.2200n 0.000424 55.2300n 0.000372 55.2400n 0.000340 55.2500n 0.000328 55.2600n 0.000334 55.2700n 0.000360 55.2800n 0.000402 55.2900n 0.000460 55.3000n 0.000532 55.3100n 0.000616 55.3200n 0.000709 55.3300n 0.000811 55.3400n 0.000917
+ 55.3500n 0.001027 55.3600n 0.001136 55.3700n 0.001244 55.3800n 0.001347 55.3900n 0.001443 55.4000n 0.001531 55.4100n 0.001609 55.4200n 0.001675 55.4300n 0.001728 55.4400n 0.001767 55.4500n 0.001792 55.4600n 0.001801 55.4700n 0.001796 55.4800n 0.001776 55.4900n 0.001742
+ 55.5000n 0.001694 55.5100n 0.001633 55.5200n 0.001561 55.5300n 0.001480 55.5400n 0.001389 55.5500n 0.001292 55.5600n 0.001190 55.5700n 0.001084 55.5800n 0.000976 55.5900n 0.000868 55.6000n 0.000762 55.6100n 0.000658 55.6200n 0.000558 55.6300n 0.000464 55.6400n 0.000376
+ 55.6500n 0.000296 55.6600n 0.000223 55.6700n 0.000158 55.6800n 0.000102 55.6900n 0.000054 55.7000n 0.000015 55.7100n -0.000016 55.7200n -0.000039 55.7300n -0.000056 55.7400n -0.000066 55.7500n -0.000071 55.7600n -0.000071 55.7700n -0.000069 55.7800n -0.000064 55.7900n -0.000057
+ 55.8000n -0.000051 55.8100n -0.000045 55.8200n -0.000041 55.8300n -0.000040 55.8400n -0.000043 55.8500n -0.000049 55.8600n -0.000061 55.8700n -0.000078 55.8800n -0.000101 55.8900n -0.000130 55.9000n -0.000165 55.9100n -0.000207 55.9200n -0.000254 55.9300n -0.000307 55.9400n -0.000366
+ 55.9500n -0.000430 55.9600n -0.000499 55.9700n -0.000572 55.9800n -0.000648 55.9900n -0.000726 56.0000n -0.000807 56.0100n -0.000888 56.0200n -0.000970 56.0300n -0.001052 56.0400n -0.001133 56.0500n -0.001211 56.0600n -0.001287 56.0700n -0.001360 56.0800n -0.001429 56.0900n -0.001493
+ 56.1000n -0.001552 56.1100n -0.001606 56.1200n -0.001654 56.1300n -0.001697 56.1400n -0.001733 56.1500n -0.001762 56.1600n -0.001786 56.1700n -0.001803 56.1800n -0.001814 56.1900n -0.001819 56.2000n -0.001818 56.2100n -0.001812 56.2200n -0.001801 56.2300n -0.001785 56.2400n -0.001765
+ 56.2500n -0.001742 56.2600n -0.001716 56.2700n -0.001687 56.2800n -0.001657 56.2900n -0.001626 56.3000n -0.001595 56.3100n -0.001563 56.3200n -0.001532 56.3300n -0.001503 56.3400n -0.001475 56.3500n -0.001450 56.3600n -0.001427 56.3700n -0.001406 56.3800n -0.001389 56.3900n -0.001375
+ 56.4000n -0.001364 56.4100n -0.001356 56.4200n -0.001351 56.4300n -0.001348 56.4400n -0.001347 56.4500n -0.001348 56.4600n -0.001350 56.4700n -0.001353 56.4800n -0.001355 56.4900n -0.001356 56.5000n -0.001355 56.5100n -0.001351 56.5200n -0.001344 56.5300n -0.001331 56.5400n -0.001314
+ 56.5500n -0.001291 56.5600n -0.001260 56.5700n -0.001222 56.5800n -0.001177 56.5900n -0.001123 56.6000n -0.001061 56.6100n -0.000990 56.6200n -0.000911 56.6300n -0.000824 56.6400n -0.000729 56.6500n -0.000628 56.6600n -0.000520 56.6700n -0.000407 56.6800n -0.000290 56.6900n -0.000171
+ 56.7000n -0.000050 56.7100n 0.000071 56.7200n 0.000189 56.7300n 0.000305 56.7400n 0.000416 56.7500n 0.000520 56.7600n 0.000616 56.7700n 0.000703 56.7800n 0.000779 56.7900n 0.000843 56.8000n 0.000894 56.8100n 0.000932 56.8200n 0.000956 56.8300n 0.000965 56.8400n 0.000961
+ 56.8500n 0.000942 56.8600n 0.000910 56.8700n 0.000865 56.8800n 0.000809 56.8900n 0.000742 56.9000n 0.000667 56.9100n 0.000586 56.9200n 0.000500 56.9300n 0.000411 56.9400n 0.000321 56.9500n 0.000233 56.9600n 0.000149 56.9700n 0.000072 56.9800n 0.000002 56.9900n -0.000058
+ 57.0000n -0.000106 57.0100n -0.000141 57.0200n -0.000162 57.0300n -0.000167 57.0400n -0.000157 57.0500n -0.000131 57.0600n -0.000089 57.0700n -0.000033 57.0800n 0.000038 57.0900n 0.000121 57.1000n 0.000216 57.1100n 0.000319 57.1200n 0.000428 57.1300n 0.000541 57.1400n 0.000656
+ 57.1500n 0.000768 57.1600n 0.000876 57.1700n 0.000976 57.1800n 0.001064 57.1900n 0.001139 57.2000n 0.001197 57.2100n 0.001236 57.2200n 0.001254 57.2300n 0.001248 57.2400n 0.001218 57.2500n 0.001163 57.2600n 0.001081 57.2700n 0.000974 57.2800n 0.000841 57.2900n 0.000685
+ 57.3000n 0.000505 57.3100n 0.000306 57.3200n 0.000089 57.3300n -0.000143 57.3400n -0.000386 57.3500n -0.000637 57.3600n -0.000890 57.3700n -0.001143 57.3800n -0.001390 57.3900n -0.001627 57.4000n -0.001850 57.4100n -0.002055 57.4200n -0.002237 57.4300n -0.002393 57.4400n -0.002519
+ 57.4500n -0.002612 57.4600n -0.002671 57.4700n -0.002694 57.4800n -0.002678 57.4900n -0.002624 57.5000n -0.002533 57.5100n -0.002403 57.5200n -0.002238 57.5300n -0.002039 57.5400n -0.001810 57.5500n -0.001552 57.5600n -0.001271 57.5700n -0.000970 57.5800n -0.000654 57.5900n -0.000329
+ 57.6000n 0.000001 57.6100n 0.000331 57.6200n 0.000656 57.6300n 0.000969 57.6400n 0.001266 57.6500n 0.001543 57.6600n 0.001795 57.6700n 0.002018 57.6800n 0.002209 57.6900n 0.002364 57.7000n 0.002483 57.7100n 0.002563 57.7200n 0.002603 57.7300n 0.002604 57.7400n 0.002565
+ 57.7500n 0.002489 57.7600n 0.002376 57.7700n 0.002230 57.7800n 0.002053 57.7900n 0.001850 57.8000n 0.001623 57.8100n 0.001377 57.8200n 0.001117 57.8300n 0.000847 57.8400n 0.000572 57.8500n 0.000296 57.8600n 0.000025 57.8700n -0.000239 57.8800n -0.000491 57.8900n -0.000727
+ 57.9000n -0.000944 57.9100n -0.001140 57.9200n -0.001313 57.9300n -0.001460 57.9400n -0.001582 57.9500n -0.001678 57.9600n -0.001748 57.9700n -0.001793 57.9800n -0.001814 57.9900n -0.001814 58.0000n -0.001794 58.0100n -0.001758 58.0200n -0.001708 58.0300n -0.001647 58.0400n -0.001579
+ 58.0500n -0.001507 58.0600n -0.001435 58.0700n -0.001365 58.0800n -0.001300 58.0900n -0.001244 58.1000n -0.001198 58.1100n -0.001165 58.1200n -0.001146 58.1300n -0.001142 58.1400n -0.001153 58.1500n -0.001181 58.1600n -0.001223 58.1700n -0.001280 58.1800n -0.001350 58.1900n -0.001430
+ 58.2000n -0.001519 58.2100n -0.001613 58.2200n -0.001711 58.2300n -0.001808 58.2400n -0.001901 58.2500n -0.001988 58.2600n -0.002064 58.2700n -0.002127 58.2800n -0.002174 58.2900n -0.002202 58.3000n -0.002209 58.3100n -0.002193 58.3200n -0.002152 58.3300n -0.002086 58.3400n -0.001994
+ 58.3500n -0.001876 58.3600n -0.001733 58.3700n -0.001567 58.3800n -0.001379 58.3900n -0.001172 58.4000n -0.000949 58.4100n -0.000712 58.4200n -0.000465 58.4300n -0.000213 58.4400n 0.000041 58.4500n 0.000292 58.4600n 0.000537 58.4700n 0.000770 58.4800n 0.000988 58.4900n 0.001187
+ 58.5000n 0.001364 58.5100n 0.001516 58.5200n 0.001639 58.5300n 0.001731 58.5400n 0.001792 58.5500n 0.001820 58.5600n 0.001814 58.5700n 0.001776 58.5800n 0.001705 58.5900n 0.001604 58.6000n 0.001474 58.6100n 0.001319 58.6200n 0.001141 58.6300n 0.000945 58.6400n 0.000734
+ 58.6500n 0.000512 58.6600n 0.000284 58.6700n 0.000055 58.6800n -0.000170 58.6900n -0.000388 58.7000n -0.000593 58.7100n -0.000781 58.7200n -0.000949 58.7300n -0.001093 58.7400n -0.001210 58.7500n -0.001297 58.7600n -0.001353 58.7700n -0.001377 58.7800n -0.001368 58.7900n -0.001325
+ 58.8000n -0.001251 58.8100n -0.001146 58.8200n -0.001011 58.8300n -0.000851 58.8400n -0.000668 58.8500n -0.000465 58.8600n -0.000247 58.8700n -0.000017 58.8800n 0.000219 58.8900n 0.000456 58.9000n 0.000691 58.9100n 0.000918 58.9200n 0.001133 58.9300n 0.001332 58.9400n 0.001509
+ 58.9500n 0.001662 58.9600n 0.001788 58.9700n 0.001883 58.9800n 0.001945 58.9900n 0.001972 59.0000n 0.001965 59.0100n 0.001922 59.0200n 0.001843 59.0300n 0.001730 59.0400n 0.001584 59.0500n 0.001408 59.0600n 0.001203 59.0700n 0.000974 59.0800n 0.000724 59.0900n 0.000456
+ 59.1000n 0.000177 59.1100n -0.000111 59.1200n -0.000403 59.1300n -0.000693 59.1400n -0.000977 59.1500n -0.001251 59.1600n -0.001510 59.1700n -0.001749 59.1800n -0.001966 59.1900n -0.002156 59.2000n -0.002317 59.2100n -0.002447 59.2200n -0.002543 59.2300n -0.002604 59.2400n -0.002630
+ 59.2500n -0.002621 59.2600n -0.002576 59.2700n -0.002497 59.2800n -0.002386 59.2900n -0.002244 59.3000n -0.002075 59.3100n -0.001880 59.3200n -0.001665 59.3300n -0.001431 59.3400n -0.001184 59.3500n -0.000927 59.3600n -0.000664 59.3700n -0.000400 59.3800n -0.000139 59.3900n 0.000115
+ 59.4000n 0.000359 59.4100n 0.000589 59.4200n 0.000801 59.4300n 0.000992 59.4400n 0.001160 59.4500n 0.001304 59.4600n 0.001420 59.4700n 0.001508 59.4800n 0.001567 59.4900n 0.001597 59.5000n 0.001598 59.5100n 0.001571 59.5200n 0.001517 59.5300n 0.001438 59.5400n 0.001335
+ 59.5500n 0.001211 59.5600n 0.001069 59.5700n 0.000911 59.5800n 0.000741 59.5900n 0.000561 59.6000n 0.000376 59.6100n 0.000188 59.6200n 0.000000 59.6300n -0.000183 59.6400n -0.000360 59.6500n -0.000527 59.6600n -0.000681 59.6700n -0.000821 59.6800n -0.000944 59.6900n -0.001048
+ 59.7000n -0.001132 59.7100n -0.001195 59.7200n -0.001237 59.7300n -0.001256 59.7400n -0.001255 59.7500n -0.001232 59.7600n -0.001190 59.7700n -0.001128 59.7800n -0.001050 59.7900n -0.000956 59.8000n -0.000850 59.8100n -0.000732 59.8200n -0.000607 59.8300n -0.000476 59.8400n -0.000342
+ 59.8500n -0.000208 59.8600n -0.000076 59.8700n 0.000050 59.8800n 0.000169 59.8900n 0.000279 59.9000n 0.000376 59.9100n 0.000459 59.9200n 0.000527 59.9300n 0.000579 59.9400n 0.000613 59.9500n 0.000629 59.9600n 0.000626 59.9700n 0.000605 59.9800n 0.000567 59.9900n 0.000511
+ 60.0000n 0.000440 60.0100n 0.000355 60.0200n 0.000256 60.0300n 0.000148 60.0400n 0.000031 60.0500n -0.000092 60.0600n -0.000219 60.0700n -0.000346 60.0800n -0.000471 60.0900n -0.000592 60.1000n -0.000705 60.1100n -0.000809 60.1200n -0.000901 60.1300n -0.000978 60.1400n -0.001039
+ 60.1500n -0.001083 60.1600n -0.001107 60.1700n -0.001110 60.1800n -0.001092 60.1900n -0.001053 60.2000n -0.000991 60.2100n -0.000909 60.2200n -0.000806 60.2300n -0.000683 60.2400n -0.000541 60.2500n -0.000383 60.2600n -0.000210 60.2700n -0.000025 60.2800n 0.000170 60.2900n 0.000373
+ 60.3000n 0.000581 60.3100n 0.000791 60.3200n 0.000999 60.3300n 0.001205 60.3400n 0.001403 60.3500n 0.001593 60.3600n 0.001771 60.3700n 0.001935 60.3800n 0.002083 60.3900n 0.002213 60.4000n 0.002323 60.4100n 0.002413 60.4200n 0.002481 60.4300n 0.002527 60.4400n 0.002550
+ 60.4500n 0.002551 60.4600n 0.002529 60.4700n 0.002487 60.4800n 0.002424 60.4900n 0.002342 60.5000n 0.002243 60.5100n 0.002128 60.5200n 0.002000 60.5300n 0.001861 60.5400n 0.001712 60.5500n 0.001557 60.5600n 0.001397 60.5700n 0.001235 60.5800n 0.001073 60.5900n 0.000913
+ 60.6000n 0.000758 60.6100n 0.000609 60.6200n 0.000468 60.6300n 0.000337 60.6400n 0.000217 60.6500n 0.000108 60.6600n 0.000013 60.6700n -0.000069 60.6800n -0.000137 60.6900n -0.000192 60.7000n -0.000233 60.7100n -0.000260 60.7200n -0.000275 60.7300n -0.000278 60.7400n -0.000269
+ 60.7500n -0.000251 60.7600n -0.000223 60.7700n -0.000188 60.7800n -0.000146 60.7900n -0.000099 60.8000n -0.000048 60.8100n 0.000006 60.8200n 0.000061 60.8300n 0.000117 60.8400n 0.000172 60.8500n 0.000226 60.8600n 0.000277 60.8700n 0.000324 60.8800n 0.000368 60.8900n 0.000408
+ 60.9000n 0.000443 60.9100n 0.000472 60.9200n 0.000497 60.9300n 0.000516 60.9400n 0.000530 60.9500n 0.000539 60.9600n 0.000543 60.9700n 0.000542 60.9800n 0.000536 60.9900n 0.000526 61.0000n 0.000511 61.0100n 0.000493 61.0200n 0.000471 61.0300n 0.000446 61.0400n 0.000417
+ 61.0500n 0.000386 61.0600n 0.000352 61.0700n 0.000315 61.0800n 0.000277 61.0900n 0.000236 61.1000n 0.000194 61.1100n 0.000149 61.1200n 0.000104 61.1300n 0.000058 61.1400n 0.000010 61.1500n -0.000037 61.1600n -0.000085 61.1700n -0.000132 61.1800n -0.000179 61.1900n -0.000223
+ 61.2000n -0.000266 61.2100n -0.000307 61.2200n -0.000344 61.2300n -0.000377 61.2400n -0.000405 61.2500n -0.000428 61.2600n -0.000444 61.2700n -0.000454 61.2800n -0.000457 61.2900n -0.000451 61.3000n -0.000437 61.3100n -0.000414 61.3200n -0.000382 61.3300n -0.000341 61.3400n -0.000291
+ 61.3500n -0.000232 61.3600n -0.000163 61.3700n -0.000087 61.3800n -0.000003 61.3900n 0.000087 61.4000n 0.000183 61.4100n 0.000284 61.4200n 0.000388 61.4300n 0.000494 61.4400n 0.000601 61.4500n 0.000706 61.4600n 0.000809 61.4700n 0.000908 61.4800n 0.001002 61.4900n 0.001089
+ 61.5000n 0.001168 61.5100n 0.001237 61.5200n 0.001296 61.5300n 0.001345 61.5400n 0.001381 61.5500n 0.001406 61.5600n 0.001419 61.5700n 0.001420 61.5800n 0.001410 61.5900n 0.001389 61.6000n 0.001359 61.6100n 0.001320 61.6200n 0.001275 61.6300n 0.001224 61.6400n 0.001170
+ 61.6500n 0.001115 61.6600n 0.001060 61.6700n 0.001008 61.6800n 0.000960 61.6900n 0.000919 61.7000n 0.000886 61.7100n 0.000863 61.7200n 0.000853 61.7300n 0.000855 61.7400n 0.000870 61.7500n 0.000901 61.7600n 0.000946 61.7700n 0.001006 61.7800n 0.001080 61.7900n 0.001168
+ 61.8000n 0.001268 61.8100n 0.001379 61.8200n 0.001498 61.8300n 0.001625 61.8400n 0.001755 61.8500n 0.001887 61.8600n 0.002018 61.8700n 0.002144 61.8800n 0.002263 61.8900n 0.002372 61.9000n 0.002467 61.9100n 0.002546 61.9200n 0.002606 61.9300n 0.002646 61.9400n 0.002661
+ 61.9500n 0.002653 61.9600n 0.002618 61.9700n 0.002556 61.9800n 0.002467 61.9900n 0.002352 62.0000n 0.002210 62.0100n 0.002044 62.0200n 0.001854 62.0300n 0.001644 62.0400n 0.001415 62.0500n 0.001171 62.0600n 0.000915 62.0700n 0.000651 62.0800n 0.000383 62.0900n 0.000113
+ 62.1000n -0.000152 62.1100n -0.000411 62.1200n -0.000658 62.1300n -0.000890 62.1400n -0.001104 62.1500n -0.001297 62.1600n -0.001466 62.1700n -0.001608 62.1800n -0.001723 62.1900n -0.001809 62.2000n -0.001865 62.2100n -0.001892 62.2200n -0.001890 62.2300n -0.001861 62.2400n -0.001805
+ 62.2500n -0.001725 62.2600n -0.001625 62.2700n -0.001506 62.2800n -0.001372 62.2900n -0.001228 62.3000n -0.001076 62.3100n -0.000921 62.3200n -0.000766 62.3300n -0.000616 62.3400n -0.000474 62.3500n -0.000344 62.3600n -0.000228 62.3700n -0.000130 62.3800n -0.000051 62.3900n 0.000006
+ 62.4000n 0.000041 62.4100n 0.000053 62.4200n 0.000041 62.4300n 0.000007 62.4400n -0.000049 62.4500n -0.000125 62.4600n -0.000218 62.4700n -0.000327 62.4800n -0.000448 62.4900n -0.000577 62.5000n -0.000712 62.5100n -0.000848 62.5200n -0.000981 62.5300n -0.001109 62.5400n -0.001227
+ 62.5500n -0.001332 62.5600n -0.001421 62.5700n -0.001490 62.5800n -0.001538 62.5900n -0.001563 62.6000n -0.001564 62.6100n -0.001539 62.6200n -0.001490 62.6300n -0.001415 62.6400n -0.001317 62.6500n -0.001197 62.6600n -0.001057 62.6700n -0.000901 62.6800n -0.000731 62.6900n -0.000552
+ 62.7000n -0.000366 62.7100n -0.000178 62.7200n 0.000007 62.7300n 0.000186 62.7400n 0.000354 62.7500n 0.000507 62.7600n 0.000642 62.7700n 0.000755 62.7800n 0.000844 62.7900n 0.000905 62.8000n 0.000938 62.8100n 0.000940 62.8200n 0.000912 62.8300n 0.000854 62.8400n 0.000765
+ 62.8500n 0.000649 62.8600n 0.000507 62.8700n 0.000341 62.8800n 0.000154 62.8900n -0.000048 62.9000n -0.000263 62.9100n -0.000486 62.9200n -0.000712 62.9300n -0.000937 62.9400n -0.001156 62.9500n -0.001364 62.9600n -0.001557 62.9700n -0.001731 62.9800n -0.001882 62.9900n -0.002006
+ 63.0000n -0.002102 63.0100n -0.002168 63.0200n -0.002201 63.0300n -0.002201 63.0400n -0.002168 63.0500n -0.002102 63.0600n -0.002006 63.0700n -0.001881 63.0800n -0.001730 63.0900n -0.001556 63.1000n -0.001363 63.1100n -0.001155 63.1200n -0.000936 63.1300n -0.000711 63.1400n -0.000485
+ 63.1500n -0.000261 63.1600n -0.000046 63.1700n 0.000157 63.1800n 0.000344 63.1900n 0.000511 63.2000n 0.000656 63.2100n 0.000774 63.2200n 0.000866 63.2300n 0.000928 63.2400n 0.000961 63.2500n 0.000966 63.2600n 0.000942 63.2700n 0.000891 63.2800n 0.000815 63.2900n 0.000717
+ 63.3000n 0.000601 63.3100n 0.000470 63.3200n 0.000327 63.3300n 0.000178 63.3400n 0.000027 63.3500n -0.000122 63.3600n -0.000264 63.3700n -0.000395 63.3800n -0.000512 63.3900n -0.000609 63.4000n -0.000685 63.4100n -0.000736 63.4200n -0.000761 63.4300n -0.000758 63.4400n -0.000726
+ 63.4500n -0.000665 63.4600n -0.000576 63.4700n -0.000461 63.4800n -0.000321 63.4900n -0.000158 63.5000n 0.000023 63.5100n 0.000219 63.5200n 0.000427 63.5300n 0.000641 63.5400n 0.000857 63.5500n 0.001071 63.5600n 0.001278 63.5700n 0.001472 63.5800n 0.001651 63.5900n 0.001809
+ 63.6000n 0.001943 63.6100n 0.002051 63.6200n 0.002129 63.6300n 0.002175 63.6400n 0.002189 63.6500n 0.002170 63.6600n 0.002118 63.6700n 0.002033 63.6800n 0.001918 63.6900n 0.001775 63.7000n 0.001606 63.7100n 0.001416 63.7200n 0.001207 63.7300n 0.000984 63.7400n 0.000751
+ 63.7500n 0.000513 63.7600n 0.000275 63.7700n 0.000042 63.7800n -0.000183 63.7900n -0.000394 63.8000n -0.000589 63.8100n -0.000763 63.8200n -0.000913 63.8300n -0.001038 63.8400n -0.001135 63.8500n -0.001204 63.8600n -0.001243 63.8700n -0.001254 63.8800n -0.001238 63.8900n -0.001195
+ 63.9000n -0.001129 63.9100n -0.001042 63.9200n -0.000938 63.9300n -0.000819 63.9400n -0.000690 63.9500n -0.000556 63.9600n -0.000420 63.9700n -0.000286 63.9800n -0.000160 63.9900n -0.000043 64.0000n 0.000058 64.0100n 0.000143 64.0200n 0.000207 64.0300n 0.000249 64.0400n 0.000268
+ 64.0500n 0.000262 64.0600n 0.000231 64.0700n 0.000175 64.0800n 0.000097 64.0900n -0.000003 64.1000n -0.000122 64.1100n -0.000257 64.1200n -0.000404 64.1300n -0.000560 64.1400n -0.000721 64.1500n -0.000882 64.1600n -0.001039 64.1700n -0.001188 64.1800n -0.001324 64.1900n -0.001442
+ 64.2000n -0.001540 64.2100n -0.001614 64.2200n -0.001661 64.2300n -0.001679 64.2400n -0.001667 64.2500n -0.001622 64.2600n -0.001546 64.2700n -0.001438 64.2800n -0.001300 64.2900n -0.001133 64.3000n -0.000941 64.3100n -0.000727 64.3200n -0.000494 64.3300n -0.000246 64.3400n 0.000011
+ 64.3500n 0.000274 64.3600n 0.000536 64.3700n 0.000793 64.3800n 0.001040 64.3900n 0.001272 64.4000n 0.001484 64.4100n 0.001673 64.4200n 0.001833 64.4300n 0.001963 64.4400n 0.002060 64.4500n 0.002121 64.4600n 0.002146 64.4700n 0.002134 64.4800n 0.002086 64.4900n 0.002004
+ 64.5000n 0.001888 64.5100n 0.001742 64.5200n 0.001569 64.5300n 0.001372 64.5400n 0.001157 64.5500n 0.000928 64.5600n 0.000690 64.5700n 0.000447 64.5800n 0.000207 64.5900n -0.000027 64.6000n -0.000249 64.6100n -0.000455 64.6200n -0.000640 64.6300n -0.000799 64.6400n -0.000931
+ 64.6500n -0.001031 64.6600n -0.001099 64.6700n -0.001132 64.6800n -0.001131 64.6900n -0.001095 64.7000n -0.001025 64.7100n -0.000924 64.7200n -0.000793 64.7300n -0.000637 64.7400n -0.000457 64.7500n -0.000260 64.7600n -0.000049 64.7700n 0.000171 64.7800n 0.000394 64.7900n 0.000615
+ 64.8000n 0.000830 64.8100n 0.001033 64.8200n 0.001218 64.8300n 0.001383 64.8400n 0.001522 64.8500n 0.001632 64.8600n 0.001710 64.8700n 0.001753 64.8800n 0.001760 64.8900n 0.001731 64.9000n 0.001664 64.9100n 0.001560 64.9200n 0.001421 64.9300n 0.001247 64.9400n 0.001043
+ 64.9500n 0.000810 64.9600n 0.000552 64.9700n 0.000274 64.9800n -0.000021 64.9900n -0.000328 65.0000n -0.000642 65.0100n -0.000959 65.0200n -0.001273 65.0300n -0.001581 65.0400n -0.001878 65.0500n -0.002160 65.0600n -0.002423 65.0700n -0.002665 65.0800n -0.002881 65.0900n -0.003071
+ 65.1000n -0.003233 65.1100n -0.003365 65.1200n -0.003467 65.1300n -0.003538 65.1400n -0.003580 65.1500n -0.003594 65.1600n -0.003580 65.1700n -0.003541 65.1800n -0.003480 65.1900n -0.003397 65.2000n -0.003296 65.2100n -0.003180 65.2200n -0.003052 65.2300n -0.002914 65.2400n -0.002768
+ 65.2500n -0.002619 65.2600n -0.002467 65.2700n -0.002315 65.2800n -0.002165 65.2900n -0.002019 65.3000n -0.001876 65.3100n -0.001740 65.3200n -0.001609 65.3300n -0.001485 65.3400n -0.001367 65.3500n -0.001255 65.3600n -0.001148 65.3700n -0.001046 65.3800n -0.000947 65.3900n -0.000851
+ 65.4000n -0.000757 65.4100n -0.000663 65.4200n -0.000570 65.4300n -0.000475 65.4400n -0.000378 65.4500n -0.000279 65.4600n -0.000177 65.4700n -0.000073 65.4800n 0.000033 65.4900n 0.000142 65.5000n 0.000252 65.5100n 0.000362 65.5200n 0.000471 65.5300n 0.000578 65.5400n 0.000680
+ 65.5500n 0.000777 65.5600n 0.000867 65.5700n 0.000947 65.5800n 0.001016 65.5900n 0.001072 65.6000n 0.001114 65.6100n 0.001140 65.6200n 0.001149 65.6300n 0.001140 65.6400n 0.001113 65.6500n 0.001067 65.6600n 0.001003 65.6700n 0.000920 65.6800n 0.000821 65.6900n 0.000706
+ 65.7000n 0.000577 65.7100n 0.000436 65.7200n 0.000286 65.7300n 0.000128 65.7400n -0.000034 65.7500n -0.000197 65.7600n -0.000358 65.7700n -0.000513 65.7800n -0.000661 65.7900n -0.000798 65.8000n -0.000920 65.8100n -0.001026 65.8200n -0.001113 65.8300n -0.001179 65.8400n -0.001222
+ 65.8500n -0.001241 65.8600n -0.001236 65.8700n -0.001207 65.8800n -0.001153 65.8900n -0.001076 65.9000n -0.000977 65.9100n -0.000857 65.9200n -0.000719 65.9300n -0.000566 65.9400n -0.000400 65.9500n -0.000224 65.9600n -0.000042 65.9700n 0.000141 65.9800n 0.000324 65.9900n 0.000502
+ 66.0000n 0.000671 66.0100n 0.000829 66.0200n 0.000971 66.0300n 0.001096 66.0400n 0.001200 66.0500n 0.001282 66.0600n 0.001340 66.0700n 0.001373 66.0800n 0.001380 66.0900n 0.001361 66.1000n 0.001317 66.1100n 0.001249 66.1200n 0.001157 66.1300n 0.001045 66.1400n 0.000915
+ 66.1500n 0.000768 66.1600n 0.000610 66.1700n 0.000442 66.1800n 0.000268 66.1900n 0.000093 66.2000n -0.000081 66.2100n -0.000249 66.2200n -0.000408 66.2300n -0.000554 66.2400n -0.000685 66.2500n -0.000798 66.2600n -0.000890 66.2700n -0.000960 66.2800n -0.001006 66.2900n -0.001026
+ 66.3000n -0.001021 66.3100n -0.000990 66.3200n -0.000934 66.3300n -0.000854 66.3400n -0.000752 66.3500n -0.000629 66.3600n -0.000487 66.3700n -0.000331 66.3800n -0.000161 66.3900n 0.000018 66.4000n 0.000203 66.4100n 0.000391 66.4200n 0.000579 66.4300n 0.000762 66.4400n 0.000937
+ 66.4500n 0.001103 66.4600n 0.001254 66.4700n 0.001390 66.4800n 0.001508 66.4900n 0.001605 66.5000n 0.001681 66.5100n 0.001735 66.5200n 0.001765 66.5300n 0.001772 66.5400n 0.001755 66.5500n 0.001716 66.5600n 0.001656 66.5700n 0.001575 66.5800n 0.001476 66.5900n 0.001361
+ 66.6000n 0.001232 66.6100n 0.001091 66.6200n 0.000941 66.6300n 0.000785 66.6400n 0.000626 66.6500n 0.000465 66.6600n 0.000307 66.6700n 0.000153 66.6800n 0.000005 66.6900n -0.000133 66.7000n -0.000260 66.7100n -0.000375 66.7200n -0.000474 66.7300n -0.000559 66.7400n -0.000626
+ 66.7500n -0.000677 66.7600n -0.000710 66.7700n -0.000724 66.7800n -0.000721 66.7900n -0.000701 66.8000n -0.000663 66.8100n -0.000610 66.8200n -0.000541 66.8300n -0.000458 66.8400n -0.000363 66.8500n -0.000255 66.8600n -0.000138 66.8700n -0.000011 66.8800n 0.000123 66.8900n 0.000262
+ 66.9000n 0.000407 66.9100n 0.000554 66.9200n 0.000702 66.9300n 0.000850 66.9400n 0.000997 66.9500n 0.001142 66.9600n 0.001282 66.9700n 0.001417 66.9800n 0.001545 66.9900n 0.001666 67.0000n 0.001777 67.0100n 0.001879 67.0200n 0.001969 67.0300n 0.002047 67.0400n 0.002112
+ 67.0500n 0.002162 67.0600n 0.002197 67.0700n 0.002216 67.0800n 0.002218 67.0900n 0.002203 67.1000n 0.002170 67.1100n 0.002118 67.1200n 0.002047 67.1300n 0.001957 67.1400n 0.001849 67.1500n 0.001721 67.1600n 0.001576 67.1700n 0.001412 67.1800n 0.001233 67.1900n 0.001038
+ 67.2000n 0.000829 67.2100n 0.000608 67.2200n 0.000376 67.2300n 0.000137 67.2400n -0.000108 67.2500n -0.000356 67.2600n -0.000604 67.2700n -0.000849 67.2800n -0.001088 67.2900n -0.001318 67.3000n -0.001535 67.3100n -0.001737 67.3200n -0.001921 67.3300n -0.002084 67.3400n -0.002222
+ 67.3500n -0.002334 67.3600n -0.002418 67.3700n -0.002471 67.3800n -0.002493 67.3900n -0.002482 67.4000n -0.002438 67.4100n -0.002360 67.4200n -0.002250 67.4300n -0.002108 67.4400n -0.001937 67.4500n -0.001737 67.4600n -0.001512 67.4700n -0.001264 67.4800n -0.000997 67.4900n -0.000715
+ 67.5000n -0.000422 67.5100n -0.000122 67.5200n 0.000181 67.5300n 0.000481 67.5400n 0.000775 67.5500n 0.001057 67.5600n 0.001323 67.5700n 0.001569 67.5800n 0.001791 67.5900n 0.001985 67.6000n 0.002149 67.6100n 0.002279 67.6200n 0.002374 67.6300n 0.002432 67.6400n 0.002453
+ 67.6500n 0.002435 67.6600n 0.002380 67.6700n 0.002289 67.6800n 0.002163 67.6900n 0.002004 67.7000n 0.001817 67.7100n 0.001603 67.7200n 0.001368 67.7300n 0.001115 67.7400n 0.000850 67.7500n 0.000576 67.7600n 0.000299 67.7700n 0.000024 67.7800n -0.000244 67.7900n -0.000499
+ 67.8000n -0.000738 67.8100n -0.000956 67.8200n -0.001149 67.8300n -0.001314 67.8400n -0.001447 67.8500n -0.001545 67.8600n -0.001608 67.8700n -0.001634 67.8800n -0.001623 67.8900n -0.001575 67.9000n -0.001490 67.9100n -0.001370 67.9200n -0.001219 67.9300n -0.001037 67.9400n -0.000829
+ 67.9500n -0.000599 67.9600n -0.000350 67.9700n -0.000087 67.9800n 0.000184 67.9900n 0.000460 68.0000n 0.000735 68.0100n 0.001005 68.0200n 0.001264 68.0300n 0.001508 68.0400n 0.001733 68.0500n 0.001934 68.0600n 0.002109 68.0700n 0.002255 68.0800n 0.002368 68.0900n 0.002447
+ 68.1000n 0.002491 68.1100n 0.002499 68.1200n 0.002471 68.1300n 0.002408 68.1400n 0.002311 68.1500n 0.002181 68.1600n 0.002022 68.1700n 0.001836 68.1800n 0.001625 68.1900n 0.001395 68.2000n 0.001148 68.2100n 0.000888 68.2200n 0.000620 68.2300n 0.000348 68.2400n 0.000076
+ 68.2500n -0.000192 68.2600n -0.000452 68.2700n -0.000700 68.2800n -0.000933 68.2900n -0.001148 68.3000n -0.001342 68.3100n -0.001513 68.3200n -0.001659 68.3300n -0.001780 68.3400n -0.001874 68.3500n -0.001940 68.3600n -0.001980 68.3700n -0.001994 68.3800n -0.001983 68.3900n -0.001948
+ 68.4000n -0.001891 68.4100n -0.001815 68.4200n -0.001722 68.4300n -0.001614 68.4400n -0.001494 68.4500n -0.001365 68.4600n -0.001229 68.4700n -0.001091 68.4800n -0.000951 68.4900n -0.000813 68.5000n -0.000680 68.5100n -0.000552 68.5200n -0.000433 68.5300n -0.000324 68.5400n -0.000227
+ 68.5500n -0.000141 68.5600n -0.000069 68.5700n -0.000010 68.5800n 0.000035 68.5900n 0.000067 68.6000n 0.000087 68.6100n 0.000094 68.6200n 0.000090 68.6300n 0.000076 68.6400n 0.000053 68.6500n 0.000023 68.6600n -0.000012 68.6700n -0.000052 68.6800n -0.000095 68.6900n -0.000139
+ 68.7000n -0.000183 68.7100n -0.000226 68.7200n -0.000266 68.7300n -0.000303 68.7400n -0.000335 68.7500n -0.000363 68.7600n -0.000385 68.7700n -0.000402 68.7800n -0.000413 68.7900n -0.000419 68.8000n -0.000420 68.8100n -0.000417 68.8200n -0.000410 68.8300n -0.000401 68.8400n -0.000390
+ 68.8500n -0.000377 68.8600n -0.000366 68.8700n -0.000355 68.8800n -0.000348 68.8900n -0.000344 68.9000n -0.000344 68.9100n -0.000350 68.9200n -0.000361 68.9300n -0.000380 68.9400n -0.000406 68.9500n -0.000439 68.9600n -0.000479 68.9700n -0.000527 68.9800n -0.000582 68.9900n -0.000643
+ 69.0000n -0.000710 69.0100n -0.000782 69.0200n -0.000858 69.0300n -0.000937 69.0400n -0.001016 69.0500n -0.001096 69.0600n -0.001174 69.0700n -0.001249 69.0800n -0.001319 69.0900n -0.001383 69.1000n -0.001439 69.1100n -0.001487 69.1200n -0.001524 69.1300n -0.001551 69.1400n -0.001565
+ 69.1500n -0.001566 69.1600n -0.001553 69.1700n -0.001527 69.1800n -0.001487 69.1900n -0.001433 69.2000n -0.001366 69.2100n -0.001286 69.2200n -0.001194 69.2300n -0.001092 69.2400n -0.000981 69.2500n -0.000862 69.2600n -0.000737 69.2700n -0.000608 69.2800n -0.000476 69.2900n -0.000345
+ 69.3000n -0.000216 69.3100n -0.000091 69.3200n 0.000028 69.3300n 0.000138 69.3400n 0.000238 69.3500n 0.000325 69.3600n 0.000399 69.3700n 0.000457 69.3800n 0.000498 69.3900n 0.000521 69.4000n 0.000526 69.4100n 0.000511 69.4200n 0.000477 69.4300n 0.000423 69.4400n 0.000351
+ 69.4500n 0.000261 69.4600n 0.000153 69.4700n 0.000030 69.4800n -0.000108 69.4900n -0.000258 69.5000n -0.000418 69.5100n -0.000587 69.5200n -0.000761 69.5300n -0.000938 69.5400n -0.001115 69.5500n -0.001290 69.5600n -0.001460 69.5700n -0.001622 69.5800n -0.001774 69.5900n -0.001913
+ 69.6000n -0.002036 69.6100n -0.002142 69.6200n -0.002229 69.6300n -0.002294 69.6400n -0.002337 69.6500n -0.002357 69.6600n -0.002352 69.6700n -0.002323 69.6800n -0.002269 69.6900n -0.002191 69.7000n -0.002089 69.7100n -0.001965 69.7200n -0.001819 69.7300n -0.001654 69.7400n -0.001470
+ 69.7500n -0.001271 69.7600n -0.001059 69.7700n -0.000836 69.7800n -0.000605 69.7900n -0.000368 69.8000n -0.000128 69.8100n 0.000111 69.8200n 0.000347 69.8300n 0.000578 69.8400n 0.000801 69.8500n 0.001014 69.8600n 0.001215 69.8700n 0.001401 69.8800n 0.001571 69.8900n 0.001724
+ 69.9000n 0.001859 69.9100n 0.001975 69.9200n 0.002072 69.9300n 0.002149 69.9400n 0.002207 69.9500n 0.002246 69.9600n 0.002268 69.9700n 0.002272 69.9800n 0.002261 69.9900n 0.002236 70.0000n 0.002199 70.0100n 0.002150 70.0200n 0.002093 70.0300n 0.002028 70.0400n 0.001959
+ 70.0500n 0.001885 70.0600n 0.001810 70.0700n 0.001735 70.0800n 0.001662 70.0900n 0.001591 70.1000n 0.001524 70.1100n 0.001461 70.1200n 0.001404 70.1300n 0.001353 70.1400n 0.001308 70.1500n 0.001269 70.1600n 0.001237 70.1700n 0.001209 70.1800n 0.001187 70.1900n 0.001168
+ 70.2000n 0.001153 70.2100n 0.001140 70.2200n 0.001128 70.2300n 0.001117 70.2400n 0.001104 70.2500n 0.001089 70.2600n 0.001071 70.2700n 0.001048 70.2800n 0.001021 70.2900n 0.000988 70.3000n 0.000949 70.3100n 0.000903 70.3200n 0.000850 70.3300n 0.000791 70.3400n 0.000725
+ 70.3500n 0.000654 70.3600n 0.000577 70.3700n 0.000496 70.3800n 0.000411 70.3900n 0.000324 70.4000n 0.000235 70.4100n 0.000147 70.4200n 0.000060 70.4300n -0.000025 70.4400n -0.000105 70.4500n -0.000181 70.4600n -0.000250 70.4700n -0.000311 70.4800n -0.000365 70.4900n -0.000410
+ 70.5000n -0.000445 70.5100n -0.000471 70.5200n -0.000487 70.5300n -0.000493 70.5400n -0.000491 70.5500n -0.000479 70.5600n -0.000460 70.5700n -0.000435 70.5800n -0.000403 70.5900n -0.000367 70.6000n -0.000329 70.6100n -0.000289 70.6200n -0.000249 70.6300n -0.000210 70.6400n -0.000174
+ 70.6500n -0.000143 70.6600n -0.000117 70.6700n -0.000098 70.6800n -0.000086 70.6900n -0.000082 70.7000n -0.000087 70.7100n -0.000101 70.7200n -0.000124 70.7300n -0.000155 70.7400n -0.000194 70.7500n -0.000240 70.7600n -0.000293 70.7700n -0.000349 70.7800n -0.000410 70.7900n -0.000472
+ 70.8000n -0.000533 70.8100n -0.000593 70.8200n -0.000649 70.8300n -0.000700 70.8400n -0.000743 70.8500n -0.000777 70.8600n -0.000800 70.8700n -0.000812 70.8800n -0.000810 70.8900n -0.000794 70.9000n -0.000765 70.9100n -0.000720 70.9200n -0.000661 70.9300n -0.000587 70.9400n -0.000500
+ 70.9500n -0.000401 70.9600n -0.000290 70.9700n -0.000170 70.9800n -0.000043 70.9900n 0.000090 71.0000n 0.000226 71.0100n 0.000363 71.0200n 0.000498 71.0300n 0.000629 71.0400n 0.000752 71.0500n 0.000867 71.0600n 0.000970 71.0700n 0.001060 71.0800n 0.001134 71.0900n 0.001192
+ 71.1000n 0.001231 71.1100n 0.001252 71.1200n 0.001253 71.1300n 0.001235 71.1400n 0.001197 71.1500n 0.001141 71.1600n 0.001067 71.1700n 0.000978 71.1800n 0.000874 71.1900n 0.000758 71.2000n 0.000632 71.2100n 0.000498 71.2200n 0.000360 71.2300n 0.000220 71.2400n 0.000081
+ 71.2500n -0.000055 71.2600n -0.000184 71.2700n -0.000305 71.2800n -0.000415 71.2900n -0.000511 71.3000n -0.000593 71.3100n -0.000659 71.3200n -0.000707 71.3300n -0.000738 71.3400n -0.000751 71.3500n -0.000746 71.3600n -0.000724 71.3700n -0.000686 71.3800n -0.000634 71.3900n -0.000569
+ 71.4000n -0.000494 71.4100n -0.000411 71.4200n -0.000321 71.4300n -0.000229 71.4400n -0.000137 71.4500n -0.000048 71.4600n 0.000036 71.4700n 0.000113 71.4800n 0.000178 71.4900n 0.000231 71.5000n 0.000270 71.5100n 0.000292 71.5200n 0.000298 71.5300n 0.000285 71.5400n 0.000255
+ 71.5500n 0.000206 71.5600n 0.000141 71.5700n 0.000059 71.5800n -0.000037 71.5900n -0.000146 71.6000n -0.000265 71.6100n -0.000392 71.6200n -0.000524 71.6300n -0.000657 71.6400n -0.000788 71.6500n -0.000914 71.6600n -0.001032 71.6700n -0.001139 71.6800n -0.001230 71.6900n -0.001304
+ 71.7000n -0.001359 71.7100n -0.001390 71.7200n -0.001398 71.7300n -0.001380 71.7400n -0.001336 71.7500n -0.001265 71.7600n -0.001167 71.7700n -0.001043 71.7800n -0.000895 71.7900n -0.000723 71.8000n -0.000530 71.8100n -0.000319 71.8200n -0.000092 71.8300n 0.000147 71.8400n 0.000395
+ 71.8500n 0.000647 71.8600n 0.000901 71.8700n 0.001152 71.8800n 0.001397 71.8900n 0.001631 71.9000n 0.001851 71.9100n 0.002054 71.9200n 0.002237 71.9300n 0.002397 71.9400n 0.002532 71.9500n 0.002641 71.9600n 0.002721 71.9700n 0.002773 71.9800n 0.002795 71.9900n 0.002789
+ 72.0000n 0.002755 72.0100n 0.002695 72.0200n 0.002610 72.0300n 0.002502 72.0400n 0.002373 72.0500n 0.002228 72.0600n 0.002067 72.0700n 0.001896 72.0800n 0.001717 72.0900n 0.001532 72.1000n 0.001347 72.1100n 0.001163 72.1200n 0.000985 72.1300n 0.000814 72.1400n 0.000653
+ 72.1500n 0.000504 72.1600n 0.000370 72.1700n 0.000252 72.1800n 0.000151 72.1900n 0.000067 72.2000n 0.000001 72.2100n -0.000047 72.2200n -0.000078 72.2300n -0.000092 72.2400n -0.000091 72.2500n -0.000076 72.2600n -0.000048 72.2700n -0.000010 72.2800n 0.000037 72.2900n 0.000090
+ 72.3000n 0.000149 72.3100n 0.000210 72.3200n 0.000272 72.3300n 0.000334 72.3400n 0.000393 72.3500n 0.000449 72.3600n 0.000499 72.3700n 0.000545 72.3800n 0.000584 72.3900n 0.000617 72.4000n 0.000644 72.4100n 0.000665 72.4200n 0.000680 72.4300n 0.000690 72.4400n 0.000697
+ 72.4500n 0.000700 72.4600n 0.000702 72.4700n 0.000704 72.4800n 0.000707 72.4900n 0.000712 72.5000n 0.000720 72.5100n 0.000733 72.5200n 0.000752 72.5300n 0.000776 72.5400n 0.000807 72.5500n 0.000846 72.5600n 0.000891 72.5700n 0.000943 72.5800n 0.001002 72.5900n 0.001066
+ 72.6000n 0.001134 72.6100n 0.001206 72.6200n 0.001279 72.6300n 0.001353 72.6400n 0.001425 72.6500n 0.001493 72.6600n 0.001556 72.6700n 0.001611 72.6800n 0.001656 72.6900n 0.001691 72.7000n 0.001713 72.7100n 0.001720 72.7200n 0.001712 72.7300n 0.001688 72.7400n 0.001646
+ 72.7500n 0.001587 72.7600n 0.001511 72.7700n 0.001417 72.7800n 0.001307 72.7900n 0.001181 72.8000n 0.001042 72.8100n 0.000890 72.8200n 0.000728 72.8300n 0.000557 72.8400n 0.000381 72.8500n 0.000202 72.8600n 0.000021 72.8700n -0.000157 72.8800n -0.000331 72.8900n -0.000497
+ 72.9000n -0.000654 72.9100n -0.000799 72.9200n -0.000931 72.9300n -0.001046 72.9400n -0.001145 72.9500n -0.001224 72.9600n -0.001285 72.9700n -0.001326 72.9800n -0.001348 72.9900n -0.001350 73.0000n -0.001333 73.0100n -0.001298 73.0200n -0.001247 73.0300n -0.001181 73.0400n -0.001102
+ 73.0500n -0.001012 73.0600n -0.000913 73.0700n -0.000807 73.0800n -0.000697 73.0900n -0.000585 73.1000n -0.000473 73.1100n -0.000363 73.1200n -0.000257 73.1300n -0.000157 73.1400n -0.000065 73.1500n 0.000019 73.1600n 0.000093 73.1700n 0.000157 73.1800n 0.000211 73.1900n 0.000254
+ 73.2000n 0.000286 73.2100n 0.000309 73.2200n 0.000324 73.2300n 0.000330 73.2400n 0.000331 73.2500n 0.000326 73.2600n 0.000318 73.2700n 0.000309 73.2800n 0.000300 73.2900n 0.000293 73.3000n 0.000289 73.3100n 0.000289 73.3200n 0.000296 73.3300n 0.000310 73.3400n 0.000333
+ 73.3500n 0.000364 73.3600n 0.000403 73.3700n 0.000452 73.3800n 0.000510 73.3900n 0.000575 73.4000n 0.000647 73.4100n 0.000726 73.4200n 0.000809 73.4300n 0.000894 73.4400n 0.000981 73.4500n 0.001067 73.4600n 0.001149 73.4700n 0.001227 73.4800n 0.001297 73.4900n 0.001358
+ 73.5000n 0.001407 73.5100n 0.001444 73.5200n 0.001465 73.5300n 0.001471 73.5400n 0.001460 73.5500n 0.001432 73.5600n 0.001385 73.5700n 0.001320 73.5800n 0.001237 73.5900n 0.001137 73.6000n 0.001021 73.6100n 0.000890 73.6200n 0.000746 73.6300n 0.000591 73.6400n 0.000427
+ 73.6500n 0.000256 73.6600n 0.000081 73.6700n -0.000096 73.6800n -0.000271 73.6900n -0.000443 73.7000n -0.000609 73.7100n -0.000767 73.7200n -0.000914 73.7300n -0.001048 73.7400n -0.001167 73.7500n -0.001270 73.7600n -0.001357 73.7700n -0.001425 73.7800n -0.001475 73.7900n -0.001506
+ 73.8000n -0.001519 73.8100n -0.001515 73.8200n -0.001495 73.8300n -0.001459 73.8400n -0.001409 73.8500n -0.001348 73.8600n -0.001277 73.8700n -0.001199 73.8800n -0.001116 73.8900n -0.001029 73.9000n -0.000942 73.9100n -0.000857 73.9200n -0.000777 73.9300n -0.000702 73.9400n -0.000635
+ 73.9500n -0.000578 73.9600n -0.000533 73.9700n -0.000499 73.9800n -0.000479 73.9900n -0.000472 74.0000n -0.000479 74.0100n -0.000500 74.0200n -0.000534 74.0300n -0.000580 74.0400n -0.000637 74.0500n -0.000705 74.0600n -0.000781 74.0700n -0.000864 74.0800n -0.000952 74.0900n -0.001043
+ 74.1000n -0.001134 74.1100n -0.001225 74.1200n -0.001313 74.1300n -0.001396 74.1400n -0.001472 74.1500n -0.001540 74.1600n -0.001598 74.1700n -0.001644 74.1800n -0.001679 74.1900n -0.001701 74.2000n -0.001709 74.2100n -0.001703 74.2200n -0.001684 74.2300n -0.001651 74.2400n -0.001606
+ 74.2500n -0.001548 74.2600n -0.001480 74.2700n -0.001401 74.2800n -0.001314 74.2900n -0.001220 74.3000n -0.001120 74.3100n -0.001017 74.3200n -0.000912 74.3300n -0.000806 74.3400n -0.000702 74.3500n -0.000600 74.3600n -0.000503 74.3700n -0.000411 74.3800n -0.000327 74.3900n -0.000251
+ 74.4000n -0.000184 74.4100n -0.000128 74.4200n -0.000082 74.4300n -0.000047 74.4400n -0.000023 74.4500n -0.000011 74.4600n -0.000010 74.4700n -0.000021 74.4800n -0.000042 74.4900n -0.000074 74.5000n -0.000115 74.5100n -0.000165 74.5200n -0.000224 74.5300n -0.000289 74.5400n -0.000362
+ 74.5500n -0.000439 74.5600n -0.000522 74.5700n -0.000608 74.5800n -0.000696 74.5900n -0.000786 74.6000n -0.000877 74.6100n -0.000968 74.6200n -0.001058 74.6300n -0.001146 74.6400n -0.001231 74.6500n -0.001313 74.6600n -0.001390 74.6700n -0.001462 74.6800n -0.001529 74.6900n -0.001589
+ 74.7000n -0.001643 74.7100n -0.001689 74.7200n -0.001726 74.7300n -0.001755 74.7400n -0.001775 74.7500n -0.001786 74.7600n -0.001786 74.7700n -0.001777 74.7800n -0.001757 74.7900n -0.001726 74.8000n -0.001685 74.8100n -0.001634 74.8200n -0.001572 74.8300n -0.001501 74.8400n -0.001420
+ 74.8500n -0.001330 74.8600n -0.001233 74.8700n -0.001128 74.8800n -0.001018 74.8900n -0.000903 74.9000n -0.000784 74.9100n -0.000664 74.9200n -0.000543 74.9300n -0.000423 74.9400n -0.000306 74.9500n -0.000195 74.9600n -0.000089 74.9700n 0.000008 74.9800n 0.000095 74.9900n 0.000171
+ 75.0000n 0.000233 75.0100n 0.000281 75.0200n 0.000314 75.0300n 0.000330 75.0400n 0.000329 75.0500n 0.000311 75.0600n 0.000275 75.0700n 0.000221 75.0800n 0.000151 75.0900n 0.000065 75.1000n -0.000037 75.1100n -0.000151 75.1200n -0.000278 75.1300n -0.000414 75.1400n -0.000558
+ 75.1500n -0.000707 75.1600n -0.000858 75.1700n -0.001009 75.1800n -0.001156 75.1900n -0.001298 75.2000n -0.001430 75.2100n -0.001551 75.2200n -0.001657 75.2300n -0.001747 75.2400n -0.001818 75.2500n -0.001868 75.2600n -0.001896 75.2700n -0.001900 75.2800n -0.001879 75.2900n -0.001834
+ 75.3000n -0.001764 75.3100n -0.001670 75.3200n -0.001552 75.3300n -0.001413 75.3400n -0.001254 75.3500n -0.001076 75.3600n -0.000883 75.3700n -0.000677 75.3800n -0.000462 75.3900n -0.000241 75.4000n -0.000017 75.4100n 0.000207 75.4200n 0.000426 75.4300n 0.000637 75.4400n 0.000838
+ 75.4500n 0.001024 75.4600n 0.001192 75.4700n 0.001341 75.4800n 0.001467 75.4900n 0.001569 75.5000n 0.001646 75.5100n 0.001695 75.5200n 0.001717 75.5300n 0.001712 75.5400n 0.001679 75.5500n 0.001619 75.5600n 0.001535 75.5700n 0.001427 75.5800n 0.001297 75.5900n 0.001148
+ 75.6000n 0.000982 75.6100n 0.000802 75.6200n 0.000612 75.6300n 0.000414 75.6400n 0.000211 75.6500n 0.000007 75.6600n -0.000195 75.6700n -0.000393 75.6800n -0.000584 75.6900n -0.000766 75.7000n -0.000936 75.7100n -0.001093 75.7200n -0.001234 75.7300n -0.001361 75.7400n -0.001470
+ 75.7500n -0.001563 75.7600n -0.001640 75.7700n -0.001700 75.7800n -0.001745 75.7900n -0.001776 75.8000n -0.001794 75.8100n -0.001801 75.8200n -0.001798 75.8300n -0.001787 75.8400n -0.001771 75.8500n -0.001751 75.8600n -0.001728 75.8700n -0.001705 75.8800n -0.001683 75.8900n -0.001664
+ 75.9000n -0.001647 75.9100n -0.001635 75.9200n -0.001627 75.9300n -0.001624 75.9400n -0.001626 75.9500n -0.001631 75.9600n -0.001639 75.9700n -0.001650 75.9800n -0.001661 75.9900n -0.001670 76.0000n -0.001677 76.0100n -0.001679 76.0200n -0.001674 76.0300n -0.001660 76.0400n -0.001635
+ 76.0500n -0.001597 76.0600n -0.001544 76.0700n -0.001475 76.0800n -0.001389 76.0900n -0.001284 76.1000n -0.001160 76.1100n -0.001017 76.1200n -0.000854 76.1300n -0.000673 76.1400n -0.000475 76.1500n -0.000260 76.1600n -0.000032 76.1700n 0.000209 76.1800n 0.000459 76.1900n 0.000715
+ 76.2000n 0.000974 76.2100n 0.001233 76.2200n 0.001487 76.2300n 0.001735 76.2400n 0.001970 76.2500n 0.002192 76.2600n 0.002394 76.2700n 0.002575 76.2800n 0.002732 76.2900n 0.002861 76.3000n 0.002961 76.3100n 0.003030 76.3200n 0.003066 76.3300n 0.003069 76.3400n 0.003038
+ 76.3500n 0.002974 76.3600n 0.002878 76.3700n 0.002750 76.3800n 0.002594 76.3900n 0.002410 76.4000n 0.002203 76.4100n 0.001975 76.4200n 0.001730 76.4300n 0.001472 76.4400n 0.001205 76.4500n 0.000932 76.4600n 0.000659 76.4700n 0.000390 76.4800n 0.000128 76.4900n -0.000122
+ 76.5000n -0.000356 76.5100n -0.000572 76.5200n -0.000766 76.5300n -0.000935 76.5400n -0.001078 76.5500n -0.001192 76.5600n -0.001277 76.5700n -0.001332 76.5800n -0.001356 76.5900n -0.001351 76.6000n -0.001316 76.6100n -0.001254 76.6200n -0.001167 76.6300n -0.001055 76.6400n -0.000923
+ 76.6500n -0.000773 76.6600n -0.000608 76.6700n -0.000432 76.6800n -0.000247 76.6900n -0.000058 76.7000n 0.000133 76.7100n 0.000322 76.7200n 0.000506 76.7300n 0.000681 76.7400n 0.000845 76.7500n 0.000996 76.7600n 0.001132 76.7700n 0.001250 76.7800n 0.001350 76.7900n 0.001429
+ 76.8000n 0.001489 76.8100n 0.001528 76.8200n 0.001546 76.8300n 0.001545 76.8400n 0.001524 76.8500n 0.001485 76.8600n 0.001429 76.8700n 0.001358 76.8800n 0.001274 76.8900n 0.001178 76.9000n 0.001073 76.9100n 0.000960 76.9200n 0.000841 76.9300n 0.000720 76.9400n 0.000596
+ 76.9500n 0.000473 76.9600n 0.000353 76.9700n 0.000235 76.9800n 0.000123 76.9900n 0.000017 77.0000n -0.000082 77.0100n -0.000173 77.0200n -0.000256 77.0300n -0.000330 77.0400n -0.000394 77.0500n -0.000449 77.0600n -0.000496 77.0700n -0.000533 77.0800n -0.000562 77.0900n -0.000583
+ 77.1000n -0.000597 77.1100n -0.000603 77.1200n -0.000604 77.1300n -0.000598 77.1400n -0.000588 77.1500n -0.000573 77.1600n -0.000554 77.1700n -0.000532 77.1800n -0.000506 77.1900n -0.000478 77.2000n -0.000448 77.2100n -0.000416 77.2200n -0.000381 77.2300n -0.000346 77.2400n -0.000308
+ 77.2500n -0.000270 77.2600n -0.000230 77.2700n -0.000189 77.2800n -0.000146 77.2900n -0.000103 77.3000n -0.000060 77.3100n -0.000015 77.3200n 0.000030 77.3300n 0.000074 77.3400n 0.000119 77.3500n 0.000163 77.3600n 0.000205 77.3700n 0.000246 77.3800n 0.000286 77.3900n 0.000322
+ 77.4000n 0.000356 77.4100n 0.000385 77.4200n 0.000411 77.4300n 0.000432 77.4400n 0.000449 77.4500n 0.000459 77.4600n 0.000465 77.4700n 0.000464 77.4800n 0.000458 77.4900n 0.000446 77.5000n 0.000429 77.5100n 0.000406 77.5200n 0.000379 77.5300n 0.000347 77.5400n 0.000311
+ 77.5500n 0.000273 77.5600n 0.000233 77.5700n 0.000191 77.5800n 0.000150 77.5900n 0.000109 77.6000n 0.000071 77.6100n 0.000036 77.6200n 0.000005 77.6300n -0.000021 77.6400n -0.000040 77.6500n -0.000053 77.6600n -0.000057 77.6700n -0.000054 77.6800n -0.000041 77.6900n -0.000020
+ 77.7000n 0.000011 77.7100n 0.000051 77.7200n 0.000100 77.7300n 0.000158 77.7400n 0.000224 77.7500n 0.000298 77.7600n 0.000378 77.7700n 0.000463 77.7800n 0.000553 77.7900n 0.000647 77.8000n 0.000742 77.8100n 0.000839 77.8200n 0.000936 77.8300n 0.001030 77.8400n 0.001123
+ 77.8500n 0.001211 77.8600n 0.001294 77.8700n 0.001372 77.8800n 0.001443 77.8900n 0.001507 77.9000n 0.001563 77.9100n 0.001611 77.9200n 0.001651 77.9300n 0.001682 77.9400n 0.001706 77.9500n 0.001721 77.9600n 0.001729 77.9700n 0.001730 77.9800n 0.001724 77.9900n 0.001713
+ 78.0000n 0.001697 78.0100n 0.001676 78.0200n 0.001653 78.0300n 0.001626 78.0400n 0.001598 78.0500n 0.001569 78.0600n 0.001538 78.0700n 0.001508 78.0800n 0.001478 78.0900n 0.001449 78.1000n 0.001420 78.1100n 0.001392 78.1200n 0.001365 78.1300n 0.001339 78.1400n 0.001312
+ 78.1500n 0.001286 78.1600n 0.001259 78.1700n 0.001230 78.1800n 0.001201 78.1900n 0.001168 78.2000n 0.001134 78.2100n 0.001095 78.2200n 0.001053 78.2300n 0.001007 78.2400n 0.000956 78.2500n 0.000900 78.2600n 0.000840 78.2700n 0.000774 78.2800n 0.000704 78.2900n 0.000629
+ 78.3000n 0.000551 78.3100n 0.000469 78.3200n 0.000384 78.3300n 0.000298 78.3400n 0.000210 78.3500n 0.000123 78.3600n 0.000037 78.3700n -0.000047 78.3800n -0.000128 78.3900n -0.000204 78.4000n -0.000275 78.4100n -0.000340 78.4200n -0.000397 78.4300n -0.000447 78.4400n -0.000488
+ 78.4500n -0.000520 78.4600n -0.000544 78.4700n -0.000558 78.4800n -0.000563 78.4900n -0.000559 78.5000n -0.000547 78.5100n -0.000528 78.5200n -0.000501 78.5300n -0.000469 78.5400n -0.000432 78.5500n -0.000391 78.5600n -0.000347 78.5700n -0.000302 78.5800n -0.000257 78.5900n -0.000213
+ 78.6000n -0.000171 78.6100n -0.000132 78.6200n -0.000097 78.6300n -0.000066 78.6400n -0.000041 78.6500n -0.000021 78.6600n -0.000006 78.6700n 0.000002 78.6800n 0.000006 78.6900n 0.000004 78.7000n -0.000002 78.7100n -0.000012 78.7200n -0.000024 78.7300n -0.000037 78.7400n -0.000051
+ 78.7500n -0.000064 78.7600n -0.000075 78.7700n -0.000082 78.7800n -0.000085 78.7900n -0.000083 78.8000n -0.000074 78.8100n -0.000057 78.8200n -0.000033 78.8300n 0.000000 78.8400n 0.000041 78.8500n 0.000091 78.8600n 0.000149 78.8700n 0.000214 78.8800n 0.000286 78.8900n 0.000363
+ 78.9000n 0.000444 78.9100n 0.000528 78.9200n 0.000612 78.9300n 0.000696 78.9400n 0.000776 78.9500n 0.000851 78.9600n 0.000920 78.9700n 0.000979 78.9800n 0.001028 78.9900n 0.001065 79.0000n 0.001088 79.0100n 0.001095 79.0200n 0.001087 79.0300n 0.001062 79.0400n 0.001021
+ 79.0500n 0.000963 79.0600n 0.000889 79.0700n 0.000800 79.0800n 0.000696 79.0900n 0.000581 79.1000n 0.000455 79.1100n 0.000322 79.1200n 0.000183 79.1300n 0.000041 79.1400n -0.000100 79.1500n -0.000237 79.1600n -0.000368 79.1700n -0.000490 79.1800n -0.000599 79.1900n -0.000692
+ 79.2000n -0.000768 79.2100n -0.000823 79.2200n -0.000856 79.2300n -0.000866 79.2400n -0.000851 79.2500n -0.000810 79.2600n -0.000745 79.2700n -0.000654 79.2800n -0.000540 79.2900n -0.000403 79.3000n -0.000247 79.3100n -0.000073 79.3200n 0.000116 79.3300n 0.000316 79.3400n 0.000523
+ 79.3500n 0.000734 79.3600n 0.000944 79.3700n 0.001149 79.3800n 0.001344 79.3900n 0.001526 79.4000n 0.001691 79.4100n 0.001834 79.4200n 0.001951 79.4300n 0.002041 79.4400n 0.002099 79.4500n 0.002124 79.4600n 0.002115 79.4700n 0.002070 79.4800n 0.001989 79.4900n 0.001872
+ 79.5000n 0.001720 79.5100n 0.001535 79.5200n 0.001319 79.5300n 0.001075 79.5400n 0.000806 79.5500n 0.000516 79.5600n 0.000209 79.5700n -0.000110 79.5800n -0.000436 79.5900n -0.000765 79.6000n -0.001091 79.6100n -0.001409 79.6200n -0.001715 79.6300n -0.002004 79.6400n -0.002272
+ 79.6500n -0.002514 79.6600n -0.002727 79.6700n -0.002908 79.6800n -0.003054 79.6900n -0.003165 79.7000n -0.003238 79.7100n -0.003273 79.7200n -0.003270 79.7300n -0.003231 79.7400n -0.003155 79.7500n -0.003047 79.7600n -0.002907 79.7700n -0.002739 79.7800n -0.002547 79.7900n -0.002334
+ 79.8000n -0.002104 79.8100n -0.001862 79.8200n -0.001612 79.8300n -0.001357 79.8400n -0.001103 79.8500n -0.000853 79.8600n -0.000611 79.8700n -0.000381 79.8800n -0.000166 79.8900n 0.000031 79.9000n 0.000209 79.9100n 0.000365 79.9200n 0.000499 79.9300n 0.000608 79.9400n 0.000694
+ 79.9500n 0.000757 79.9600n 0.000797 79.9700n 0.000816 79.9800n 0.000815 79.9900n 0.000796 80.0000n 0.000761 80.0100n 0.000714 80.0200n 0.000656 80.0300n 0.000591 80.0400n 0.000521 80.0500n 0.000448 80.0600n 0.000377 80.0700n 0.000308 80.0800n 0.000244 80.0900n 0.000187
+ 80.1000n 0.000139 80.1100n 0.000100 80.1200n 0.000073 80.1300n 0.000056 80.1400n 0.000051 80.1500n 0.000057 80.1600n 0.000074 80.1700n 0.000100 80.1800n 0.000135 80.1900n 0.000176 80.2000n 0.000223 80.2100n 0.000272 80.2200n 0.000323 80.2300n 0.000374 80.2400n 0.000421
+ 80.2500n 0.000464 80.2600n 0.000501 80.2700n 0.000529 80.2800n 0.000548 80.2900n 0.000557 80.3000n 0.000553 80.3100n 0.000538 80.3200n 0.000509 80.3300n 0.000469 80.3400n 0.000416 80.3500n 0.000352 80.3600n 0.000278 80.3700n 0.000194 80.3800n 0.000104 80.3900n 0.000007
+ 80.4000n -0.000093 80.4100n -0.000196 80.4200n -0.000297 80.4300n -0.000397 80.4400n -0.000491 80.4500n -0.000579 80.4600n -0.000658 80.4700n -0.000727 80.4800n -0.000784 80.4900n -0.000827 80.5000n -0.000856 80.5100n -0.000870 80.5200n -0.000868 80.5300n -0.000850 80.5400n -0.000816
+ 80.5500n -0.000767 80.5600n -0.000703 80.5700n -0.000626 80.5800n -0.000535 80.5900n -0.000434 80.6000n -0.000323 80.6100n -0.000204 80.6200n -0.000078 80.6300n 0.000052 80.6400n 0.000184 80.6500n 0.000318 80.6600n 0.000452 80.6700n 0.000583 80.6800n 0.000710 80.6900n 0.000833
+ 80.7000n 0.000951 80.7100n 0.001061 80.7200n 0.001165 80.7300n 0.001261 80.7400n 0.001350 80.7500n 0.001431 80.7600n 0.001505 80.7700n 0.001571 80.7800n 0.001632 80.7900n 0.001686 80.8000n 0.001735 80.8100n 0.001780 80.8200n 0.001822 80.8300n 0.001860 80.8400n 0.001896
+ 80.8500n 0.001931 80.8600n 0.001964 80.8700n 0.001996 80.8800n 0.002028 80.8900n 0.002059 80.9000n 0.002089 80.9100n 0.002117 80.9200n 0.002144 80.9300n 0.002169 80.9400n 0.002190 80.9500n 0.002206 80.9600n 0.002218 80.9700n 0.002223 80.9800n 0.002220 80.9900n 0.002209
+ 81.0000n 0.002188 81.0100n 0.002157 81.0200n 0.002114 81.0300n 0.002059 81.0400n 0.001991 81.0500n 0.001911 81.0600n 0.001817 81.0700n 0.001712 81.0800n 0.001594 81.0900n 0.001465 81.1000n 0.001326 81.1100n 0.001178 81.1200n 0.001023 81.1300n 0.000864 81.1400n 0.000701
+ 81.1500n 0.000537 81.1600n 0.000375 81.1700n 0.000217 81.1800n 0.000065 81.1900n -0.000078 81.2000n -0.000211 81.2100n -0.000330 81.2200n -0.000434 81.2300n -0.000521 81.2400n -0.000590 81.2500n -0.000640 81.2600n -0.000670 81.2700n -0.000679 81.2800n -0.000669 81.2900n -0.000638
+ 81.3000n -0.000589 81.3100n -0.000521 81.3200n -0.000438 81.3300n -0.000342 81.3400n -0.000233 81.3500n -0.000116 81.3600n 0.000007 81.3700n 0.000133 81.3800n 0.000259 81.3900n 0.000382 81.4000n 0.000498 81.4100n 0.000604 81.4200n 0.000697 81.4300n 0.000776 81.4400n 0.000836
+ 81.4500n 0.000877 81.4600n 0.000896 81.4700n 0.000892 81.4800n 0.000865 81.4900n 0.000813 81.5000n 0.000738 81.5100n 0.000639 81.5200n 0.000519 81.5300n 0.000378 81.5400n 0.000219 81.5500n 0.000044 81.5600n -0.000144 81.5700n -0.000342 81.5800n -0.000546 81.5900n -0.000753
+ 81.6000n -0.000960 81.6100n -0.001162 81.6200n -0.001356 81.6300n -0.001538 81.6400n -0.001705 81.6500n -0.001855 81.6600n -0.001983 81.6700n -0.002088 81.6800n -0.002168 81.6900n -0.002222 81.7000n -0.002248 81.7100n -0.002245 81.7200n -0.002215 81.7300n -0.002158 81.7400n -0.002074
+ 81.7500n -0.001965 81.7600n -0.001835 81.7700n -0.001684 81.7800n -0.001516 81.7900n -0.001334 81.8000n -0.001142 81.8100n -0.000943 81.8200n -0.000741 81.8300n -0.000540 81.8400n -0.000343 81.8500n -0.000155 81.8600n 0.000022 81.8700n 0.000184 81.8800n 0.000328 81.8900n 0.000451
+ 81.9000n 0.000552 81.9100n 0.000629 81.9200n 0.000680 81.9300n 0.000705 81.9400n 0.000703 81.9500n 0.000675 81.9600n 0.000621 81.9700n 0.000542 81.9800n 0.000441 81.9900n 0.000319 82.0000n 0.000179 82.0100n 0.000022 82.0200n -0.000147 82.0300n -0.000326 82.0400n -0.000512
+ 82.0500n -0.000701 82.0600n -0.000891 82.0700n -0.001077 82.0800n -0.001257 82.0900n -0.001428 82.1000n -0.001587 82.1100n -0.001733 82.1200n -0.001862 82.1300n -0.001973 82.1400n -0.002065 82.1500n -0.002136 82.1600n -0.002187 82.1700n -0.002216 82.1800n -0.002224 82.1900n -0.002211
+ 82.2000n -0.002179 82.2100n -0.002127 82.2200n -0.002059 82.2300n -0.001974 82.2400n -0.001875 82.2500n -0.001764 82.2600n -0.001642 82.2700n -0.001513 82.2800n -0.001377 82.2900n -0.001237 82.3000n -0.001095 82.3100n -0.000953 82.3200n -0.000812 82.3300n -0.000674 82.3400n -0.000541
+ 82.3500n -0.000413 82.3600n -0.000292 82.3700n -0.000178 82.3800n -0.000072 82.3900n 0.000026 82.4000n 0.000115 82.4100n 0.000196 82.4200n 0.000269 82.4300n 0.000334 82.4400n 0.000392 82.4500n 0.000442 82.4600n 0.000486 82.4700n 0.000525 82.4800n 0.000559 82.4900n 0.000588
+ 82.5000n 0.000614 82.5100n 0.000636 82.5200n 0.000656 82.5300n 0.000674 82.5400n 0.000690 82.5500n 0.000704 82.5600n 0.000717 82.5700n 0.000728 82.5800n 0.000738 82.5900n 0.000745 82.6000n 0.000751 82.6100n 0.000755 82.6200n 0.000756 82.6300n 0.000753 82.6400n 0.000747
+ 82.6500n 0.000738 82.6600n 0.000723 82.6700n 0.000704 82.6800n 0.000680 82.6900n 0.000650 82.7000n 0.000615 82.7100n 0.000574 82.7200n 0.000526 82.7300n 0.000473 82.7400n 0.000414 82.7500n 0.000350 82.7600n 0.000280 82.7700n 0.000206 82.7800n 0.000128 82.7900n 0.000046
+ 82.8000n -0.000039 82.8100n -0.000127 82.8200n -0.000216 82.8300n -0.000305 82.8400n -0.000395 82.8500n -0.000484 82.8600n -0.000572 82.8700n -0.000657 82.8800n -0.000740 82.8900n -0.000819 82.9000n -0.000894 82.9100n -0.000965 82.9200n -0.001031 82.9300n -0.001092 82.9400n -0.001147
+ 82.9500n -0.001198 82.9600n -0.001243 82.9700n -0.001283 82.9800n -0.001317 82.9900n -0.001347 83.0000n -0.001372 83.0100n -0.001392 83.0200n -0.001409 83.0300n -0.001422 83.0400n -0.001431 83.0500n -0.001438 83.0600n -0.001443 83.0700n -0.001445 83.0800n -0.001447 83.0900n -0.001447
+ 83.1000n -0.001446 83.1100n -0.001445 83.1200n -0.001445 83.1300n -0.001445 83.1400n -0.001446 83.1500n -0.001448 83.1600n -0.001452 83.1700n -0.001458 83.1800n -0.001466 83.1900n -0.001476 83.2000n -0.001489 83.2100n -0.001505 83.2200n -0.001524 83.2300n -0.001546 83.2400n -0.001572
+ 83.2500n -0.001602 83.2600n -0.001636 83.2700n -0.001674 83.2800n -0.001716 83.2900n -0.001762 83.3000n -0.001812 83.3100n -0.001867 83.3200n -0.001925 83.3300n -0.001987 83.3400n -0.002053 83.3500n -0.002122 83.3600n -0.002193 83.3700n -0.002265 83.3800n -0.002339 83.3900n -0.002414
+ 83.4000n -0.002487 83.4100n -0.002559 83.4200n -0.002628 83.4300n -0.002693 83.4400n -0.002753 83.4500n -0.002806 83.4600n -0.002851 83.4700n -0.002887 83.4800n -0.002912 83.4900n -0.002925 83.5000n -0.002926 83.5100n -0.002912 83.5200n -0.002883 83.5300n -0.002839 83.5400n -0.002778
+ 83.5500n -0.002700 83.5600n -0.002605 83.5700n -0.002494 83.5800n -0.002366 83.5900n -0.002223 83.6000n -0.002065 83.6100n -0.001893 83.6200n -0.001710 83.6300n -0.001516 83.6400n -0.001313 83.6500n -0.001105 83.6600n -0.000893 83.6700n -0.000680 83.6800n -0.000468 83.6900n -0.000261
+ 83.7000n -0.000060 83.7100n 0.000130 83.7200n 0.000308 83.7300n 0.000471 83.7400n 0.000617 83.7500n 0.000744 83.7600n 0.000849 83.7700n 0.000932 83.7800n 0.000990 83.7900n 0.001023 83.8000n 0.001032 83.8100n 0.001015 83.8200n 0.000973 83.8300n 0.000907 83.8400n 0.000819
+ 83.8500n 0.000710 83.8600n 0.000582 83.8700n 0.000438 83.8800n 0.000280 83.8900n 0.000112 83.9000n -0.000063 83.9100n -0.000242 83.9200n -0.000421 83.9300n -0.000597 83.9400n -0.000765 83.9500n -0.000924 83.9600n -0.001068 83.9700n -0.001196 83.9800n -0.001305 83.9900n -0.001392
+ 84.0000n -0.001455 84.0100n -0.001493 84.0200n -0.001504 84.0300n -0.001488 84.0400n -0.001446 84.0500n -0.001377 84.0600n -0.001282 84.0700n -0.001164 84.0800n -0.001023 84.0900n -0.000863 84.1000n -0.000686 84.1100n -0.000495 84.1200n -0.000294 84.1300n -0.000087 84.1400n 0.000123
+ 84.1500n 0.000332 84.1600n 0.000536 84.1700n 0.000731 84.1800n 0.000914 84.1900n 0.001081 84.2000n 0.001229 84.2100n 0.001355 84.2200n 0.001458 84.2300n 0.001534 84.2400n 0.001584 84.2500n 0.001606 84.2600n 0.001600 84.2700n 0.001566 84.2800n 0.001505 84.2900n 0.001419
+ 84.3000n 0.001310 84.3100n 0.001180 84.3200n 0.001032 84.3300n 0.000869 84.3400n 0.000695 84.3500n 0.000514 84.3600n 0.000329 84.3700n 0.000146 84.3800n -0.000033 84.3900n -0.000203 84.4000n -0.000360 84.4100n -0.000500 84.4200n -0.000620 84.4300n -0.000717 84.4400n -0.000789
+ 84.4500n -0.000833 84.4600n -0.000848 84.4700n -0.000833 84.4800n -0.000787 84.4900n -0.000711 84.5000n -0.000605 84.5100n -0.000471 84.5200n -0.000310 84.5300n -0.000125 84.5400n 0.000081 84.5500n 0.000306 84.5600n 0.000545 84.5700n 0.000794 84.5800n 0.001049 84.5900n 0.001307
+ 84.6000n 0.001562 84.6100n 0.001810 84.6200n 0.002048 84.6300n 0.002270 84.6400n 0.002474 84.6500n 0.002655 84.6600n 0.002811 84.6700n 0.002938 84.6800n 0.003035 84.6900n 0.003099 84.7000n 0.003130 84.7100n 0.003127 84.7200n 0.003089 84.7300n 0.003018 84.7400n 0.002913
+ 84.7500n 0.002778 84.7600n 0.002613 84.7700n 0.002421 84.7800n 0.002205 84.7900n 0.001968 84.8000n 0.001714 84.8100n 0.001447 84.8200n 0.001169 84.8300n 0.000886 84.8400n 0.000602 84.8500n 0.000320 84.8600n 0.000044 84.8700n -0.000222 84.8800n -0.000475 84.8900n -0.000710
+ 84.9000n -0.000926 84.9100n -0.001120 84.9200n -0.001289 84.9300n -0.001431 84.9400n -0.001546 84.9500n -0.001632 84.9600n -0.001689 84.9700n -0.001716 84.9800n -0.001714 84.9900n -0.001683 85.0000n -0.001625 85.0100n -0.001542 85.0200n -0.001433 85.0300n -0.001303 85.0400n -0.001152
+ 85.0500n -0.000984 85.0600n -0.000800 85.0700n -0.000604 85.0800n -0.000398 85.0900n -0.000185 85.1000n 0.000033 85.1100n 0.000252 85.1200n 0.000470 85.1300n 0.000685 85.1400n 0.000894 85.1500n 0.001096 85.1600n 0.001287 85.1700n 0.001467 85.1800n 0.001635 85.1900n 0.001787
+ 85.2000n 0.001924 85.2100n 0.002045 85.2200n 0.002149 85.2300n 0.002235 85.2400n 0.002304 85.2500n 0.002354 85.2600n 0.002387 85.2700n 0.002403 85.2800n 0.002402 85.2900n 0.002385 85.3000n 0.002352 85.3100n 0.002305 85.3200n 0.002244 85.3300n 0.002170 85.3400n 0.002085
+ 85.3500n 0.001990 85.3600n 0.001886 85.3700n 0.001774 85.3800n 0.001655 85.3900n 0.001531 85.4000n 0.001404 85.4100n 0.001274 85.4200n 0.001142 85.4300n 0.001011 85.4400n 0.000881 85.4500n 0.000753 85.4600n 0.000629 85.4700n 0.000509 85.4800n 0.000395 85.4900n 0.000287
+ 85.5000n 0.000187 85.5100n 0.000095 85.5200n 0.000012 85.5300n -0.000062 85.5400n -0.000125 85.5500n -0.000178 85.5600n -0.000220 85.5700n -0.000251 85.5800n -0.000271 85.5900n -0.000279 85.6000n -0.000277 85.6100n -0.000263 85.6200n -0.000239 85.6300n -0.000204 85.6400n -0.000160
+ 85.6500n -0.000106 85.6600n -0.000043 85.6700n 0.000028 85.6800n 0.000107 85.6900n 0.000192 85.7000n 0.000283 85.7100n 0.000380 85.7200n 0.000480 85.7300n 0.000585 85.7400n 0.000692 85.7500n 0.000801 85.7600n 0.000912 85.7700n 0.001023 85.7800n 0.001135 85.7900n 0.001245
+ 85.8000n 0.001355 85.8100n 0.001462 85.8200n 0.001568 85.8300n 0.001671 85.8400n 0.001770 85.8500n 0.001867 85.8600n 0.001959 85.8700n 0.002048 85.8800n 0.002132 85.8900n 0.002212 85.9000n 0.002286 85.9100n 0.002356 85.9200n 0.002420 85.9300n 0.002479 85.9400n 0.002531
+ 85.9500n 0.002577 85.9600n 0.002617 85.9700n 0.002649 85.9800n 0.002673 85.9900n 0.002690 86.0000n 0.002698 86.0100n 0.002696 86.0200n 0.002686 86.0300n 0.002665 86.0400n 0.002634 86.0500n 0.002591 86.0600n 0.002538 86.0700n 0.002473 86.0800n 0.002397 86.0900n 0.002308
+ 86.1000n 0.002208 86.1100n 0.002096 86.1200n 0.001973 86.1300n 0.001838 86.1400n 0.001694 86.1500n 0.001539 86.1600n 0.001376 86.1700n 0.001206 86.1800n 0.001028 86.1900n 0.000846 86.2000n 0.000660 86.2100n 0.000472 86.2200n 0.000284 86.2300n 0.000097 86.2400n -0.000086
+ 86.2500n -0.000264 86.2600n -0.000434 86.2700n -0.000596 86.2800n -0.000747 86.2900n -0.000886 86.3000n -0.001010 86.3100n -0.001119 86.3200n -0.001211 86.3300n -0.001286 86.3400n -0.001342 86.3500n -0.001379 86.3600n -0.001396 86.3700n -0.001394 86.3800n -0.001373 86.3900n -0.001333
+ 86.4000n -0.001274 86.4100n -0.001199 86.4200n -0.001108 86.4300n -0.001003 86.4400n -0.000885 86.4500n -0.000756 86.4600n -0.000619 86.4700n -0.000474 86.4800n -0.000325 86.4900n -0.000174 86.5000n -0.000022 86.5100n 0.000128 86.5200n 0.000275 86.5300n 0.000415 86.5400n 0.000548
+ 86.5500n 0.000671 86.5600n 0.000784 86.5700n 0.000884 86.5800n 0.000972 86.5900n 0.001045 86.6000n 0.001105 86.6100n 0.001149 86.6200n 0.001179 86.6300n 0.001194 86.6400n 0.001195 86.6500n 0.001181 86.6600n 0.001155 86.6700n 0.001117 86.6800n 0.001067 86.6900n 0.001008
+ 86.7000n 0.000939 86.7100n 0.000862 86.7200n 0.000779 86.7300n 0.000690 86.7400n 0.000597 86.7500n 0.000500 86.7600n 0.000400 86.7700n 0.000299 86.7800n 0.000196 86.7900n 0.000093 86.8000n -0.000011 86.8100n -0.000114 86.8200n -0.000217 86.8300n -0.000321 86.8400n -0.000424
+ 86.8500n -0.000527 86.8600n -0.000630 86.8700n -0.000734 86.8800n -0.000838 86.8900n -0.000944 86.9000n -0.001051 86.9100n -0.001160 86.9200n -0.001270 86.9300n -0.001381 86.9400n -0.001494 86.9500n -0.001607 86.9600n -0.001721 86.9700n -0.001835 86.9800n -0.001948 86.9900n -0.002059
+ 87.0000n -0.002166 87.0100n -0.002270 87.0200n -0.002368 87.0300n -0.002458 87.0400n -0.002540 87.0500n -0.002612 87.0600n -0.002672 87.0700n -0.002719 87.0800n -0.002752 87.0900n -0.002768 87.1000n -0.002768 87.1100n -0.002749 87.1200n -0.002712 87.1300n -0.002656 87.1400n -0.002580
+ 87.1500n -0.002485 87.1600n -0.002372 87.1700n -0.002240 87.1800n -0.002092 87.1900n -0.001928 87.2000n -0.001750 87.2100n -0.001561 87.2200n -0.001362 87.2300n -0.001155 87.2400n -0.000945 87.2500n -0.000732 87.2600n -0.000521 87.2700n -0.000313 87.2800n -0.000113 87.2900n 0.000078
+ 87.3000n 0.000256 87.3100n 0.000420 87.3200n 0.000567 87.3300n 0.000694 87.3400n 0.000801 87.3500n 0.000886 87.3600n 0.000947 87.3700n 0.000985 87.3800n 0.001000 87.3900n 0.000991 87.4000n 0.000960 87.4100n 0.000907 87.4200n 0.000835 87.4300n 0.000745 87.4400n 0.000639
+ 87.4500n 0.000520 87.4600n 0.000390 87.4700n 0.000253 87.4800n 0.000111 87.4900n -0.000032 87.5000n -0.000174 87.5100n -0.000311 87.5200n -0.000441 87.5300n -0.000561 87.5400n -0.000668 87.5500n -0.000761 87.5600n -0.000837 87.5700n -0.000895 87.5800n -0.000935 87.5900n -0.000955
+ 87.6000n -0.000956 87.6100n -0.000937 87.6200n -0.000900 87.6300n -0.000846 87.6400n -0.000775 87.6500n -0.000691 87.6600n -0.000594 87.6700n -0.000488 87.6800n -0.000374 87.6900n -0.000256 87.7000n -0.000136 87.7100n -0.000018 87.7200n 0.000097 87.7300n 0.000206 87.7400n 0.000306
+ 87.7500n 0.000396 87.7600n 0.000472 87.7700n 0.000534 87.7800n 0.000581 87.7900n 0.000611 87.8000n 0.000625 87.8100n 0.000622 87.8200n 0.000602 87.8300n 0.000568 87.8400n 0.000518 87.8500n 0.000457 87.8600n 0.000384 87.8700n 0.000303 87.8800n 0.000215 87.8900n 0.000124
+ 87.9000n 0.000032 87.9100n -0.000058 87.9200n -0.000144 87.9300n -0.000222 87.9400n -0.000291 87.9500n -0.000347 87.9600n -0.000390 87.9700n -0.000416 87.9800n -0.000425 87.9900n -0.000416 88.0000n -0.000387 88.0100n -0.000338 88.0200n -0.000270 88.0300n -0.000183 88.0400n -0.000077
+ 88.0500n 0.000045 88.0600n 0.000182 88.0700n 0.000332 88.0800n 0.000494 88.0900n 0.000663 88.1000n 0.000839 88.1100n 0.001017 88.1200n 0.001196 88.1300n 0.001371 88.1400n 0.001542 88.1500n 0.001704 88.1600n 0.001855 88.1700n 0.001994 88.1800n 0.002117 88.1900n 0.002224
+ 88.2000n 0.002313 88.2100n 0.002383 88.2200n 0.002434 88.2300n 0.002465 88.2400n 0.002476 88.2500n 0.002468 88.2600n 0.002441 88.2700n 0.002398 88.2800n 0.002339 88.2900n 0.002266 88.3000n 0.002182 88.3100n 0.002087 88.3200n 0.001986 88.3300n 0.001879 88.3400n 0.001769
+ 88.3500n 0.001659 88.3600n 0.001550 88.3700n 0.001445 88.3800n 0.001345 88.3900n 0.001253 88.4000n 0.001169 88.4100n 0.001094 88.4200n 0.001030 88.4300n 0.000976 88.4400n 0.000933 88.4500n 0.000902 88.4600n 0.000880 88.4700n 0.000869 88.4800n 0.000866 88.4900n 0.000871
+ 88.5000n 0.000882 88.5100n 0.000898 88.5200n 0.000917 88.5300n 0.000938 88.5400n 0.000959 88.5500n 0.000978 88.5600n 0.000994 88.5700n 0.001005 88.5800n 0.001010 88.5900n 0.001008 88.6000n 0.000997 88.6100n 0.000979 88.6200n 0.000950 88.6300n 0.000913 88.6400n 0.000866
+ 88.6500n 0.000810 88.6600n 0.000746 88.6700n 0.000674 88.6800n 0.000595 88.6900n 0.000510 88.7000n 0.000421 88.7100n 0.000328 88.7200n 0.000234 88.7300n 0.000139 88.7400n 0.000046 88.7500n -0.000045 88.7600n -0.000133 88.7700n -0.000215 88.7800n -0.000291 88.7900n -0.000361
+ 88.8000n -0.000423 88.8100n -0.000477 88.8200n -0.000523 88.8300n -0.000560 88.8400n -0.000589 88.8500n -0.000610 88.8600n -0.000624 88.8700n -0.000631 88.8800n -0.000632 88.8900n -0.000629 88.9000n -0.000621 88.9100n -0.000612 88.9200n -0.000600 88.9300n -0.000589 88.9400n -0.000578
+ 88.9500n -0.000569 88.9600n -0.000563 88.9700n -0.000561 88.9800n -0.000563 88.9900n -0.000570 89.0000n -0.000582 89.0100n -0.000599 89.0200n -0.000621 89.0300n -0.000648 89.0400n -0.000680 89.0500n -0.000715 89.0600n -0.000753 89.0700n -0.000793 89.0800n -0.000835 89.0900n -0.000876
+ 89.1000n -0.000915 89.1100n -0.000952 89.1200n -0.000986 89.1300n -0.001015 89.1400n -0.001037 89.1500n -0.001053 89.1600n -0.001062 89.1700n -0.001062 89.1800n -0.001054 89.1900n -0.001037 89.2000n -0.001011 89.2100n -0.000977 89.2200n -0.000935 89.2300n -0.000886 89.2400n -0.000830
+ 89.2500n -0.000769 89.2600n -0.000704 89.2700n -0.000637 89.2800n -0.000568 89.2900n -0.000500 89.3000n -0.000433 89.3100n -0.000371 89.3200n -0.000314 89.3300n -0.000264 89.3400n -0.000222 89.3500n -0.000189 89.3600n -0.000168 89.3700n -0.000158 89.3800n -0.000160 89.3900n -0.000174
+ 89.4000n -0.000202 89.4100n -0.000242 89.4200n -0.000295 89.4300n -0.000359 89.4400n -0.000434 89.4500n -0.000520 89.4600n -0.000613 89.4700n -0.000714 89.4800n -0.000820 89.4900n -0.000929 89.5000n -0.001041 89.5100n -0.001152 89.5200n -0.001261 89.5300n -0.001367 89.5400n -0.001466
+ 89.5500n -0.001559 89.5600n -0.001643 89.5700n -0.001717 89.5800n -0.001780 89.5900n -0.001831 89.6000n -0.001869 89.6100n -0.001893 89.6200n -0.001905 89.6300n -0.001904 89.6400n -0.001890 89.6500n -0.001863 89.6600n -0.001826 89.6700n -0.001778 89.6800n -0.001721 89.6900n -0.001656
+ 89.7000n -0.001586 89.7100n -0.001510 89.7200n -0.001432 89.7300n -0.001351 89.7400n -0.001271 89.7500n -0.001193 89.7600n -0.001117 89.7700n -0.001045 89.7800n -0.000979 89.7900n -0.000919 89.8000n -0.000866 89.8100n -0.000820 89.8200n -0.000782 89.8300n -0.000751 89.8400n -0.000728
+ 89.8500n -0.000713 89.8600n -0.000705 89.8700n -0.000702 89.8800n -0.000705 89.8900n -0.000712 89.9000n -0.000723 89.9100n -0.000735 89.9200n -0.000748 89.9300n -0.000761 89.9400n -0.000772 89.9500n -0.000781 89.9600n -0.000786 89.9700n -0.000786 89.9800n -0.000780 89.9900n -0.000768
+ 90.0000n -0.000750 90.0100n -0.000723 90.0200n -0.000690 90.0300n -0.000649 90.0400n -0.000600 90.0500n -0.000544 90.0600n -0.000482 90.0700n -0.000413 90.0800n -0.000339 90.0900n -0.000261 90.1000n -0.000179 90.1100n -0.000095 90.1200n -0.000009 90.1300n 0.000077 90.1400n 0.000162
+ 90.1500n 0.000245 90.1600n 0.000326 90.1700n 0.000403 90.1800n 0.000476 90.1900n 0.000543 90.2000n 0.000604 90.2100n 0.000658 90.2200n 0.000706 90.2300n 0.000746 90.2400n 0.000779 90.2500n 0.000804 90.2600n 0.000821 90.2700n 0.000832 90.2800n 0.000835 90.2900n 0.000831
+ 90.3000n 0.000821 90.3100n 0.000805 90.3200n 0.000783 90.3300n 0.000756 90.3400n 0.000724 90.3500n 0.000688 90.3600n 0.000647 90.3700n 0.000604 90.3800n 0.000556 90.3900n 0.000506 90.4000n 0.000453 90.4100n 0.000398 90.4200n 0.000340 90.4300n 0.000279 90.4400n 0.000217
+ 90.4500n 0.000152 90.4600n 0.000085 90.4700n 0.000015 90.4800n -0.000056 90.4900n -0.000130 90.5000n -0.000206 90.5100n -0.000284 90.5200n -0.000364 90.5300n -0.000445 90.5400n -0.000527 90.5500n -0.000611 90.5600n -0.000695 90.5700n -0.000779 90.5800n -0.000862 90.5900n -0.000944
+ 90.6000n -0.001024 90.6100n -0.001101 90.6200n -0.001175 90.6300n -0.001244 90.6400n -0.001309 90.6500n -0.001368 90.6600n -0.001420 90.6700n -0.001465 90.6800n -0.001502 90.6900n -0.001531 90.7000n -0.001552 90.7100n -0.001563 90.7200n -0.001565 90.7300n -0.001558 90.7400n -0.001542
+ 90.7500n -0.001517 90.7600n -0.001484 90.7700n -0.001443 90.7800n -0.001394 90.7900n -0.001339 90.8000n -0.001278 90.8100n -0.001213 90.8200n -0.001143 90.8300n -0.001071 90.8400n -0.000997 90.8500n -0.000923 90.8600n -0.000849 90.8700n -0.000776 90.8800n -0.000706 90.8900n -0.000638
+ 90.9000n -0.000574 90.9100n -0.000514 90.9200n -0.000459 90.9300n -0.000409 90.9400n -0.000363 90.9500n -0.000323 90.9600n -0.000287 90.9700n -0.000255 90.9800n -0.000227 90.9900n -0.000202 91.0000n -0.000180 91.0100n -0.000160 91.0200n -0.000140 91.0300n -0.000120 91.0400n -0.000100
+ 91.0500n -0.000078 91.0600n -0.000053 91.0700n -0.000026 91.0800n 0.000006 91.0900n 0.000042 91.1000n 0.000082 91.1100n 0.000127 91.1200n 0.000177 91.1300n 0.000232 91.1400n 0.000292 91.1500n 0.000355 91.1600n 0.000422 91.1700n 0.000492 91.1800n 0.000563 91.1900n 0.000635
+ 91.2000n 0.000708 91.2100n 0.000778 91.2200n 0.000847 91.2300n 0.000912 91.2400n 0.000972 91.2500n 0.001026 91.2600n 0.001074 91.2700n 0.001115 91.2800n 0.001147 91.2900n 0.001171 91.3000n 0.001186 91.3100n 0.001193 91.3200n 0.001190 91.3300n 0.001179 91.3400n 0.001160
+ 91.3500n 0.001134 91.3600n 0.001102 91.3700n 0.001064 91.3800n 0.001023 91.3900n 0.000979 91.4000n 0.000933 91.4100n 0.000888 91.4200n 0.000844 91.4300n 0.000803 91.4400n 0.000767 91.4500n 0.000736 91.4600n 0.000711 91.4700n 0.000694 91.4800n 0.000685 91.4900n 0.000685
+ 91.5000n 0.000693 91.5100n 0.000709 91.5200n 0.000734 91.5300n 0.000766 91.5400n 0.000805 91.5500n 0.000849 91.5600n 0.000897 91.5700n 0.000947 91.5800n 0.000998 91.5900n 0.001047 91.6000n 0.001094 91.6100n 0.001135 91.6200n 0.001168 91.6300n 0.001193 91.6400n 0.001206
+ 91.6500n 0.001207 91.6600n 0.001194 91.6700n 0.001165 91.6800n 0.001120 91.6900n 0.001059 91.7000n 0.000981 91.7100n 0.000886 91.7200n 0.000775 91.7300n 0.000648 91.7400n 0.000508 91.7500n 0.000355 91.7600n 0.000192 91.7700n 0.000021 91.7800n -0.000155 91.7900n -0.000335
+ 91.8000n -0.000514 91.8100n -0.000691 91.8200n -0.000862 91.8300n -0.001024 91.8400n -0.001174 91.8500n -0.001310 91.8600n -0.001430 91.8700n -0.001532 91.8800n -0.001613 91.8900n -0.001672 91.9000n -0.001709 91.9100n -0.001723 91.9200n -0.001715 91.9300n -0.001684 91.9400n -0.001632
+ 91.9500n -0.001560 91.9600n -0.001470 91.9700n -0.001365 91.9800n -0.001246 91.9900n -0.001118 92.0000n -0.000984 92.0100n -0.000846 92.0200n -0.000708 92.0300n -0.000574 92.0400n -0.000448 92.0500n -0.000332 92.0600n -0.000229 92.0700n -0.000143 92.0800n -0.000076 92.0900n -0.000030
+ 92.1000n -0.000006 92.1100n -0.000006 92.1200n -0.000029 92.1300n -0.000077 92.1400n -0.000148 92.1500n -0.000240 92.1600n -0.000353 92.1700n -0.000484 92.1800n -0.000630 92.1900n -0.000787 92.2000n -0.000953 92.2100n -0.001123 92.2200n -0.001294 92.2300n -0.001461 92.2400n -0.001620
+ 92.2500n -0.001768 92.2600n -0.001899 92.2700n -0.002010 92.2800n -0.002099 92.2900n -0.002161 92.3000n -0.002195 92.3100n -0.002199 92.3200n -0.002171 92.3300n -0.002111 92.3400n -0.002018 92.3500n -0.001894 92.3600n -0.001740 92.3700n -0.001557 92.3800n -0.001348 92.3900n -0.001116
+ 92.4000n -0.000865 92.4100n -0.000600 92.4200n -0.000323 92.4300n -0.000041 92.4400n 0.000242 92.4500n 0.000522 92.4600n 0.000793 92.4700n 0.001051 92.4800n 0.001291 92.4900n 0.001509 92.5000n 0.001701 92.5100n 0.001865 92.5200n 0.001997 92.5300n 0.002095 92.5400n 0.002159
+ 92.5500n 0.002187 92.5600n 0.002179 92.5700n 0.002137 92.5800n 0.002062 92.5900n 0.001955 92.6000n 0.001820 92.6100n 0.001660 92.6200n 0.001479 92.6300n 0.001281 92.6400n 0.001071 92.6500n 0.000853 92.6600n 0.000632 92.6700n 0.000413 92.6800n 0.000201 92.6900n 0.000001
+ 92.7000n -0.000184 92.7100n -0.000349 92.7200n -0.000490 92.7300n -0.000606 92.7400n -0.000693 92.7500n -0.000750 92.7600n -0.000776 92.7700n -0.000770 92.7800n -0.000734 92.7900n -0.000667 92.8000n -0.000573 92.8100n -0.000453 92.8200n -0.000311 92.8300n -0.000149 92.8400n 0.000028
+ 92.8500n 0.000215 92.8600n 0.000409 92.8700n 0.000605 92.8800n 0.000797 92.8900n 0.000982 92.9000n 0.001155 92.9100n 0.001311 92.9200n 0.001446 92.9300n 0.001558 92.9400n 0.001643 92.9500n 0.001698 92.9600n 0.001721 92.9700n 0.001713 92.9800n 0.001671 92.9900n 0.001596
+ 93.0000n 0.001488 93.0100n 0.001350 93.0200n 0.001183 93.0300n 0.000990 93.0400n 0.000774 93.0500n 0.000538 93.0600n 0.000286 93.0700n 0.000023 93.0800n -0.000248 93.0900n -0.000521 93.1000n -0.000792 93.1100n -0.001058 93.1200n -0.001312 93.1300n -0.001553 93.1400n -0.001775
+ 93.1500n -0.001976 93.1600n -0.002153 93.1700n -0.002303 93.1800n -0.002425 93.1900n -0.002516 93.2000n -0.002577 93.2100n -0.002608 93.2200n -0.002607 93.2300n -0.002577 93.2400n -0.002519 93.2500n -0.002434 93.2600n -0.002324 93.2700n -0.002192 93.2800n -0.002040 93.2900n -0.001872
+ 93.3000n -0.001690 93.3100n -0.001497 93.3200n -0.001296 93.3300n -0.001090 93.3400n -0.000882 93.3500n -0.000675 93.3600n -0.000471 93.3700n -0.000271 93.3800n -0.000078 93.3900n 0.000106 93.4000n 0.000282 93.4100n 0.000447 93.4200n 0.000602 93.4300n 0.000745 93.4400n 0.000878
+ 93.4500n 0.001001 93.4600n 0.001114 93.4700n 0.001218 93.4800n 0.001313 93.4900n 0.001401 93.5000n 0.001482 93.5100n 0.001557 93.5200n 0.001628 93.5300n 0.001695 93.5400n 0.001757 93.5500n 0.001817 93.5600n 0.001874 93.5700n 0.001928 93.5800n 0.001978 93.5900n 0.002025
+ 93.6000n 0.002068 93.6100n 0.002106 93.6200n 0.002138 93.6300n 0.002163 93.6400n 0.002180 93.6500n 0.002188 93.6600n 0.002185 93.6700n 0.002170 93.6800n 0.002143 93.6900n 0.002102 93.7000n 0.002046 93.7100n 0.001976 93.7200n 0.001890 93.7300n 0.001790 93.7400n 0.001674
+ 93.7500n 0.001544 93.7600n 0.001401 93.7700n 0.001246 93.7800n 0.001081 93.7900n 0.000907 93.8000n 0.000728 93.8100n 0.000545 93.8200n 0.000361 93.8300n 0.000179 93.8400n 0.000002 93.8500n -0.000167 93.8600n -0.000326 93.8700n -0.000471 93.8800n -0.000600 93.8900n -0.000710
+ 93.9000n -0.000800 93.9100n -0.000867 93.9200n -0.000911 93.9300n -0.000929 93.9400n -0.000922 93.9500n -0.000890 93.9600n -0.000833 93.9700n -0.000751 93.9800n -0.000647 93.9900n -0.000522 94.0000n -0.000379 94.0100n -0.000220 94.0200n -0.000047 94.0300n 0.000134 94.0400n 0.000322
+ 94.0500n 0.000513 94.0600n 0.000702 94.0700n 0.000887 94.0800n 0.001063 94.0900n 0.001227 94.1000n 0.001377 94.1100n 0.001509 94.1200n 0.001620 94.1300n 0.001710 94.1400n 0.001776 94.1500n 0.001817 94.1600n 0.001832 94.1700n 0.001822 94.1800n 0.001788 94.1900n 0.001730
+ 94.2000n 0.001649 94.2100n 0.001549 94.2200n 0.001431 94.2300n 0.001298 94.2400n 0.001153 94.2500n 0.001000 94.2600n 0.000842 94.2700n 0.000682 94.2800n 0.000525 94.2900n 0.000374 94.3000n 0.000231 94.3100n 0.000101 94.3200n -0.000015 94.3300n -0.000113 94.3400n -0.000193
+ 94.3500n -0.000252 94.3600n -0.000291 94.3700n -0.000307 94.3800n -0.000301 94.3900n -0.000275 94.4000n -0.000229 94.4100n -0.000165 94.4200n -0.000085 94.4300n 0.000008 94.4400n 0.000112 94.4500n 0.000224 94.4600n 0.000340 94.4700n 0.000456 94.4800n 0.000570 94.4900n 0.000678
+ 94.5000n 0.000777 94.5100n 0.000863 94.5200n 0.000935 94.5300n 0.000988 94.5400n 0.001023 94.5500n 0.001036 94.5600n 0.001027 94.5700n 0.000996 94.5800n 0.000942 94.5900n 0.000867 94.6000n 0.000770 94.6100n 0.000655 94.6200n 0.000522 94.6300n 0.000375 94.6400n 0.000217
+ 94.6500n 0.000050 94.6600n -0.000121 94.6700n -0.000293 94.6800n -0.000463 94.6900n -0.000627 94.7000n -0.000780 94.7100n -0.000920 94.7200n -0.001044 94.7300n -0.001148 94.7400n -0.001230 94.7500n -0.001288 94.7600n -0.001321 94.7700n -0.001327 94.7800n -0.001306 94.7900n -0.001259
+ 94.8000n -0.001185 94.8100n -0.001087 94.8200n -0.000966 94.8300n -0.000825 94.8400n -0.000666 94.8500n -0.000492 94.8600n -0.000307 94.8700n -0.000115 94.8800n 0.000080 94.8900n 0.000275 94.9000n 0.000465 94.9100n 0.000646 94.9200n 0.000815 94.9300n 0.000969 94.9400n 0.001103
+ 94.9500n 0.001216 94.9600n 0.001304 94.9700n 0.001367 94.9800n 0.001403 94.9900n 0.001410 95.0000n 0.001390 95.0100n 0.001342 95.0200n 0.001268 95.0300n 0.001169 95.0400n 0.001047 95.0500n 0.000905 95.0600n 0.000746 95.0700n 0.000573 95.0800n 0.000389 95.0900n 0.000199
+ 95.1000n 0.000006 95.1100n -0.000185 95.1200n -0.000371 95.1300n -0.000549 95.1400n -0.000714 95.1500n -0.000863 95.1600n -0.000993 95.1700n -0.001102 95.1800n -0.001188 95.1900n -0.001249 95.2000n -0.001284 95.2100n -0.001293 95.2200n -0.001276 95.2300n -0.001232 95.2400n -0.001164
+ 95.2500n -0.001072 95.2600n -0.000960 95.2700n -0.000828 95.2800n -0.000681 95.2900n -0.000521 95.3000n -0.000351 95.3100n -0.000175 95.3200n 0.000003 95.3300n 0.000181 95.3400n 0.000354 95.3500n 0.000520 95.3600n 0.000675 95.3700n 0.000816 95.3800n 0.000940 95.3900n 0.001047
+ 95.4000n 0.001133 95.4100n 0.001197 95.4200n 0.001238 95.4300n 0.001257 95.4400n 0.001252 95.4500n 0.001224 95.4600n 0.001175 95.4700n 0.001104 95.4800n 0.001014 95.4900n 0.000907 95.5000n 0.000784 95.5100n 0.000648 95.5200n 0.000501 95.5300n 0.000346 95.5400n 0.000186
+ 95.5500n 0.000024 95.5600n -0.000140 95.5700n -0.000300 95.5800n -0.000457 95.5900n -0.000607 95.6000n -0.000748 95.6100n -0.000879 95.6200n -0.000999 95.6300n -0.001106 95.6400n -0.001201 95.6500n -0.001281 95.6600n -0.001348 95.6700n -0.001401 95.6800n -0.001441 95.6900n -0.001468
+ 95.7000n -0.001483 95.7100n -0.001486 95.7200n -0.001480 95.7300n -0.001465 95.7400n -0.001442 95.7500n -0.001412 95.7600n -0.001377 95.7700n -0.001338 95.7800n -0.001295 95.7900n -0.001249 95.8000n -0.001202 95.8100n -0.001154 95.8200n -0.001105 95.8300n -0.001056 95.8400n -0.001006
+ 95.8500n -0.000955 95.8600n -0.000904 95.8700n -0.000852 95.8800n -0.000798 95.8900n -0.000742 95.9000n -0.000683 95.9100n -0.000620 95.9200n -0.000553 95.9300n -0.000481 95.9400n -0.000404 95.9500n -0.000321 95.9600n -0.000231 95.9700n -0.000134 95.9800n -0.000030 95.9900n 0.000081
+ 96.0000n 0.000198 96.0100n 0.000321 96.0200n 0.000450 96.0300n 0.000584 96.0400n 0.000721 96.0500n 0.000861 96.0600n 0.001002 96.0700n 0.001143 96.0800n 0.001282 96.0900n 0.001417 96.1000n 0.001548 96.1100n 0.001671 96.1200n 0.001785 96.1300n 0.001889 96.1400n 0.001982
+ 96.1500n 0.002061 96.1600n 0.002125 96.1700n 0.002174 96.1800n 0.002206 96.1900n 0.002221 96.2000n 0.002219 96.2100n 0.002199 96.2200n 0.002162 96.2300n 0.002108 96.2400n 0.002037 96.2500n 0.001951 96.2600n 0.001851 96.2700n 0.001738 96.2800n 0.001613 96.2900n 0.001480
+ 96.3000n 0.001338 96.3100n 0.001192 96.3200n 0.001041 96.3300n 0.000890 96.3400n 0.000740 96.3500n 0.000592 96.3600n 0.000449 96.3700n 0.000314 96.3800n 0.000186 96.3900n 0.000069 96.4000n -0.000036 96.4100n -0.000129 96.4200n -0.000207 96.4300n -0.000272 96.4400n -0.000321
+ 96.4500n -0.000356 96.4600n -0.000375 96.4700n -0.000380 96.4800n -0.000371 96.4900n -0.000348 96.5000n -0.000313 96.5100n -0.000267 96.5200n -0.000211 96.5300n -0.000147 96.5400n -0.000076 96.5500n -0.000001 96.5600n 0.000078 96.5700n 0.000159 96.5800n 0.000239 96.5900n 0.000318
+ 96.6000n 0.000392 96.6100n 0.000462 96.6200n 0.000526 96.6300n 0.000581 96.6400n 0.000628 96.6500n 0.000665 96.6600n 0.000692 96.6700n 0.000708 96.6800n 0.000712 96.6900n 0.000705 96.7000n 0.000686 96.7100n 0.000657 96.7200n 0.000616 96.7300n 0.000566 96.7400n 0.000505
+ 96.7500n 0.000437 96.7600n 0.000361 96.7700n 0.000279 96.7800n 0.000192 96.7900n 0.000101 96.8000n 0.000008 96.8100n -0.000086 96.8200n -0.000180 96.8300n -0.000271 96.8400n -0.000360 96.8500n -0.000444 96.8600n -0.000523 96.8700n -0.000595 96.8800n -0.000660 96.8900n -0.000716
+ 96.9000n -0.000763 96.9100n -0.000800 96.9200n -0.000827 96.9300n -0.000845 96.9400n -0.000852 96.9500n -0.000849 96.9600n -0.000837 96.9700n -0.000815 96.9800n -0.000785 96.9900n -0.000747 97.0000n -0.000703 97.0100n -0.000652 97.0200n -0.000598 97.0300n -0.000540 97.0400n -0.000481
+ 97.0500n -0.000421 97.0600n -0.000362 97.0700n -0.000305 97.0800n -0.000253 97.0900n -0.000206 97.1000n -0.000166 97.1100n -0.000134 97.1200n -0.000110 97.1300n -0.000097 97.1400n -0.000095 97.1500n -0.000105 97.1600n -0.000126 97.1700n -0.000160 97.1800n -0.000207 97.1900n -0.000266
+ 97.2000n -0.000337 97.2100n -0.000420 97.2200n -0.000513 97.2300n -0.000616 97.2400n -0.000728 97.2500n -0.000847 97.2600n -0.000971 97.2700n -0.001099 97.2800n -0.001229 97.2900n -0.001359 97.3000n -0.001487 97.3100n -0.001611 97.3200n -0.001729 97.3300n -0.001839 97.3400n -0.001940
+ 97.3500n -0.002028 97.3600n -0.002103 97.3700n -0.002163 97.3800n -0.002206 97.3900n -0.002232 97.4000n -0.002240 97.4100n -0.002229 97.4200n -0.002199 97.4300n -0.002149 97.4400n -0.002081 97.4500n -0.001995 97.4600n -0.001891 97.4700n -0.001770 97.4800n -0.001635 97.4900n -0.001487
+ 97.5000n -0.001327 97.5100n -0.001158 97.5200n -0.000982 97.5300n -0.000801 97.5400n -0.000618 97.5500n -0.000435 97.5600n -0.000254 97.5700n -0.000079 97.5800n 0.000090 97.5900n 0.000249 97.6000n 0.000398 97.6100n 0.000533 97.6200n 0.000654 97.6300n 0.000760 97.6400n 0.000849
+ 97.6500n 0.000921 97.6600n 0.000976 97.6700n 0.001013 97.6800n 0.001034 97.6900n 0.001038 97.7000n 0.001027 97.7100n 0.001003 97.7200n 0.000966 97.7300n 0.000918 97.7400n 0.000861 97.7500n 0.000798 97.7600n 0.000730 97.7700n 0.000659 97.7800n 0.000589 97.7900n 0.000520
+ 97.8000n 0.000455 97.8100n 0.000396 97.8200n 0.000345 97.8300n 0.000303 97.8400n 0.000271 97.8500n 0.000251 97.8600n 0.000244 97.8700n 0.000249 97.8800n 0.000267 97.8900n 0.000299 97.9000n 0.000343 97.9100n 0.000399 97.9200n 0.000465 97.9300n 0.000541 97.9400n 0.000626
+ 97.9500n 0.000717 97.9600n 0.000813 97.9700n 0.000912 97.9800n 0.001012 97.9900n 0.001111 98.0000n 0.001207 98.0100n 0.001299 98.0200n 0.001384 98.0300n 0.001462 98.0400n 0.001531 98.0500n 0.001589 98.0600n 0.001636 98.0700n 0.001671 98.0800n 0.001694 98.0900n 0.001705
+ 98.1000n 0.001704 98.1100n 0.001690 98.1200n 0.001666 98.1300n 0.001632 98.1400n 0.001588 98.1500n 0.001536 98.1600n 0.001478 98.1700n 0.001415 98.1800n 0.001349 98.1900n 0.001280 98.2000n 0.001210 98.2100n 0.001142 98.2200n 0.001075 98.2300n 0.001012 98.2400n 0.000953
+ 98.2500n 0.000898 98.2600n 0.000849 98.2700n 0.000806 98.2800n 0.000768 98.2900n 0.000735 98.3000n 0.000707 98.3100n 0.000683 98.3200n 0.000661 98.3300n 0.000642 98.3400n 0.000622 98.3500n 0.000602 98.3600n 0.000579 98.3700n 0.000551 98.3800n 0.000518 98.3900n 0.000478
+ 98.4000n 0.000428 98.4100n 0.000369 98.4200n 0.000298 98.4300n 0.000216 98.4400n 0.000120 98.4500n 0.000012 98.4600n -0.000108 98.4700n -0.000242 98.4800n -0.000386 98.4900n -0.000542 98.5000n -0.000706 98.5100n -0.000878 98.5200n -0.001055 98.5300n -0.001236 98.5400n -0.001416
+ 98.5500n -0.001595 98.5600n -0.001769 98.5700n -0.001934 98.5800n -0.002090 98.5900n -0.002231 98.6000n -0.002357 98.6100n -0.002464 98.6200n -0.002550 98.6300n -0.002613 98.6400n -0.002652 98.6500n -0.002665 98.6600n -0.002652 98.6700n -0.002612 98.6800n -0.002545 98.6900n -0.002453
+ 98.7000n -0.002336 98.7100n -0.002196 98.7200n -0.002034 98.7300n -0.001855 98.7400n -0.001659 98.7500n -0.001451 98.7600n -0.001235 98.7700n -0.001013 98.7800n -0.000789 98.7900n -0.000568 98.8000n -0.000354 98.8100n -0.000150 98.8200n 0.000040 98.8300n 0.000212 98.8400n 0.000364
+ 98.8500n 0.000493 98.8600n 0.000595 98.8700n 0.000670 98.8800n 0.000715 98.8900n 0.000730 98.9000n 0.000715 98.9100n 0.000670 98.9200n 0.000595 98.9300n 0.000492 98.9400n 0.000363 98.9500n 0.000210 98.9600n 0.000035 98.9700n -0.000157 98.9800n -0.000364 98.9900n -0.000581
+ 99.0000n -0.000806 99.0100n -0.001034 99.0200n -0.001260 99.0300n -0.001481 99.0400n -0.001694 99.0500n -0.001893 99.0600n -0.002077 99.0700n -0.002242 99.0800n -0.002386 99.0900n -0.002506 99.1000n -0.002600 99.1100n -0.002668 99.1200n -0.002709 99.1300n -0.002723 99.1400n -0.002710
+ 99.1500n -0.002671 99.1600n -0.002608 99.1700n -0.002522 99.1800n -0.002416 99.1900n -0.002293 99.2000n -0.002154 99.2100n -0.002004 99.2200n -0.001846 99.2300n -0.001683 99.2400n -0.001518 99.2500n -0.001355 99.2600n -0.001196 99.2700n -0.001045 99.2800n -0.000905 99.2900n -0.000777
+ 99.3000n -0.000663 99.3100n -0.000566 99.3200n -0.000486 99.3300n -0.000423 99.3400n -0.000378 99.3500n -0.000351 99.3600n -0.000341 99.3700n -0.000347 99.3800n -0.000367 99.3900n -0.000399 99.4000n -0.000441 99.4100n -0.000491 99.4200n -0.000546 99.4300n -0.000603 99.4400n -0.000659
+ 99.4500n -0.000713 99.4600n -0.000760 99.4700n -0.000799 99.4800n -0.000827 99.4900n -0.000843 99.5000n -0.000844 99.5100n -0.000829 99.5200n -0.000797 99.5300n -0.000748 99.5400n -0.000681 99.5500n -0.000597 99.5600n -0.000497 99.5700n -0.000381 99.5800n -0.000252 99.5900n -0.000111
+ 99.6000n 0.000039 99.6100n 0.000196 99.6200n 0.000356 99.6300n 0.000518 99.6400n 0.000678 99.6500n 0.000833 99.6600n 0.000980 99.6700n 0.001116 99.6800n 0.001239 99.6900n 0.001345 99.7000n 0.001432 99.7100n 0.001499 99.7200n 0.001544 99.7300n 0.001566 99.7400n 0.001565
+ 99.7500n 0.001539 99.7600n 0.001489 99.7700n 0.001416 99.7800n 0.001321 99.7900n 0.001206 99.8000n 0.001072 99.8100n 0.000922 99.8200n 0.000758 99.8300n 0.000583 99.8400n 0.000401 99.8500n 0.000215 99.8600n 0.000028 99.8700n -0.000157 99.8800n -0.000336 99.8900n -0.000507
+ 99.9000n -0.000665 99.9100n -0.000809 99.9200n -0.000936 99.9300n -0.001043 99.9400n -0.001130 99.9500n -0.001194 99.9600n -0.001235 99.9700n -0.001251 99.9800n -0.001244 99.9900n -0.001214 100.0000n -0.001161 100.0100n -0.001086 100.0200n -0.000993 100.0300n -0.000881 100.0400n -0.000755
+ 100.0500n -0.000616 100.0600n -0.000468 100.0700n -0.000313 100.0800n -0.000155 100.0900n 0.000003 100.1000n 0.000157 100.1100n 0.000306 100.1200n 0.000446 100.1300n 0.000573 100.1400n 0.000687 100.1500n 0.000783 100.1600n 0.000861 100.1700n 0.000919 100.1800n 0.000956 100.1900n 0.000971
+ 100.2000n 0.000964 100.2100n 0.000935 100.2200n 0.000885 100.2300n 0.000814 100.2400n 0.000725 100.2500n 0.000619 100.2600n 0.000498 100.2700n 0.000364 100.2800n 0.000221 100.2900n 0.000071 100.3000n -0.000082 100.3100n -0.000236 100.3200n -0.000388 100.3300n -0.000533 100.3400n -0.000669
+ 100.3500n -0.000793 100.3600n -0.000903 100.3700n -0.000994 100.3800n -0.001066 100.3900n -0.001116 100.4000n -0.001143 100.4100n -0.001145 100.4200n -0.001122 100.4300n -0.001073 100.4400n -0.000998 100.4500n -0.000897 100.4600n -0.000772 100.4700n -0.000624 100.4800n -0.000454 100.4900n -0.000266
+ 100.5000n -0.000060 100.5100n 0.000160 100.5200n 0.000391 100.5300n 0.000629 100.5400n 0.000872 100.5500n 0.001116 100.5600n 0.001357 100.5700n 0.001592 100.5800n 0.001816 100.5900n 0.002027 100.6000n 0.002221 100.6100n 0.002396 100.6200n 0.002548 100.6300n 0.002674 100.6400n 0.002773
+ 100.6500n 0.002843 100.6600n 0.002882 100.6700n 0.002890 100.6800n 0.002866 100.6900n 0.002809 100.7000n 0.002721 100.7100n 0.002602 100.7200n 0.002454 100.7300n 0.002277 100.7400n 0.002076 100.7500n 0.001851 100.7600n 0.001606 100.7700n 0.001345 100.7800n 0.001070 100.7900n 0.000785
+ 100.8000n 0.000494 100.8100n 0.000202 100.8200n -0.000090 100.8300n -0.000375 100.8400n -0.000651 100.8500n -0.000914 100.8600n -0.001161 100.8700n -0.001388 100.8800n -0.001592 100.8900n -0.001772 100.9000n -0.001925 100.9100n -0.002049 100.9200n -0.002143 100.9300n -0.002207 100.9400n -0.002241
+ 100.9500n -0.002244 100.9600n -0.002217 100.9700n -0.002163 100.9800n -0.002081 100.9900n -0.001975 101.0000n -0.001847 101.0100n -0.001700 101.0200n -0.001537 101.0300n -0.001361 101.0400n -0.001177 101.0500n -0.000987 101.0600n -0.000795 101.0700n -0.000606 101.0800n -0.000422 101.0900n -0.000248
+ 101.1000n -0.000086 101.1100n 0.000060 101.1200n 0.000188 101.1300n 0.000296 101.1400n 0.000381 101.1500n 0.000442 101.1600n 0.000479 101.1700n 0.000491 101.1800n 0.000477 101.1900n 0.000439 101.2000n 0.000377 101.2100n 0.000294 101.2200n 0.000191 101.2300n 0.000071 101.2400n -0.000063
+ 101.2500n -0.000209 101.2600n -0.000363 101.2700n -0.000520 101.2800n -0.000678 101.2900n -0.000832 101.3000n -0.000979 101.3100n -0.001114 101.3200n -0.001235 101.3300n -0.001338 101.3400n -0.001419 101.3500n -0.001477 101.3600n -0.001509 101.3700n -0.001512 101.3800n -0.001487 101.3900n -0.001431
+ 101.4000n -0.001345 101.4100n -0.001228 101.4200n -0.001083 101.4300n -0.000910 101.4400n -0.000711 101.4500n -0.000488 101.4600n -0.000245 101.4700n 0.000016 101.4800n 0.000290 101.4900n 0.000574 101.5000n 0.000863 101.5100n 0.001155 101.5200n 0.001443 101.5300n 0.001724 101.5400n 0.001994
+ 101.5500n 0.002248 101.5600n 0.002484 101.5700n 0.002697 101.5800n 0.002884 101.5900n 0.003043 101.6000n 0.003172 101.6100n 0.003268 101.6200n 0.003332 101.6300n 0.003361 101.6400n 0.003357 101.6500n 0.003319 101.6600n 0.003249 101.6700n 0.003149 101.6800n 0.003020 101.6900n 0.002864
+ 101.7000n 0.002686 101.7100n 0.002488 101.7200n 0.002273 101.7300n 0.002045 101.7400n 0.001809 101.7500n 0.001567 101.7600n 0.001324 101.7700n 0.001084 101.7800n 0.000849 101.7900n 0.000624 101.8000n 0.000412 101.8100n 0.000215 101.8200n 0.000035 101.8300n -0.000124 101.8400n -0.000263
+ 101.8500n -0.000380 101.8600n -0.000473 101.8700n -0.000544 101.8800n -0.000591 101.8900n -0.000617 101.9000n -0.000622 101.9100n -0.000608 101.9200n -0.000576 101.9300n -0.000528 101.9400n -0.000468 101.9500n -0.000397 101.9600n -0.000317 101.9700n -0.000233 101.9800n -0.000146 101.9900n -0.000059
+ 102.0000n 0.000026 102.0100n 0.000106 102.0200n 0.000179 102.0300n 0.000244 102.0400n 0.000298 102.0500n 0.000341 102.0600n 0.000371 102.0700n 0.000389 102.0800n 0.000393 102.0900n 0.000384 102.1000n 0.000362 102.1100n 0.000329 102.1200n 0.000284 102.1300n 0.000230 102.1400n 0.000167
+ 102.1500n 0.000098 102.1600n 0.000024 102.1700n -0.000054 102.1800n -0.000132 102.1900n -0.000209 102.2000n -0.000284 102.2100n -0.000354 102.2200n -0.000417 102.2300n -0.000473 102.2400n -0.000520 102.2500n -0.000557 102.2600n -0.000582 102.2700n -0.000595 102.2800n -0.000596 102.2900n -0.000584
+ 102.3000n -0.000560 102.3100n -0.000523 102.3200n -0.000474 102.3300n -0.000414 102.3400n -0.000344 102.3500n -0.000265 102.3600n -0.000177 102.3700n -0.000082 102.3800n 0.000018 102.3900n 0.000123 102.4000n 0.000230 102.4100n 0.000340 102.4200n 0.000449 102.4300n 0.000557 102.4400n 0.000663
+ 102.4500n 0.000766 102.4600n 0.000864 102.4700n 0.000957 102.4800n 0.001045 102.4900n 0.001125 102.5000n 0.001199 102.5100n 0.001265 102.5200n 0.001324 102.5300n 0.001374 102.5400n 0.001417 102.5500n 0.001452 102.5600n 0.001479 102.5700n 0.001498 102.5800n 0.001511 102.5900n 0.001516
+ 102.6000n 0.001514 102.6100n 0.001505 102.6200n 0.001491 102.6300n 0.001470 102.6400n 0.001444 102.6500n 0.001413 102.6600n 0.001377 102.6700n 0.001336 102.6800n 0.001292 102.6900n 0.001243 102.7000n 0.001191 102.7100n 0.001136 102.7200n 0.001079 102.7300n 0.001020 102.7400n 0.000960
+ 102.7500n 0.000899 102.7600n 0.000838 102.7700n 0.000778 102.7800n 0.000719 102.7900n 0.000664 102.8000n 0.000611 102.8100n 0.000564 102.8200n 0.000521 102.8300n 0.000486 102.8400n 0.000457 102.8500n 0.000438 102.8600n 0.000427 102.8700n 0.000427 102.8800n 0.000437 102.8900n 0.000459
+ 102.9000n 0.000492 102.9100n 0.000537 102.9200n 0.000595 102.9300n 0.000663 102.9400n 0.000743 102.9500n 0.000834 102.9600n 0.000934 102.9700n 0.001042 102.9800n 0.001157 102.9900n 0.001276 103.0000n 0.001399 103.0100n 0.001523 103.0200n 0.001645 103.0300n 0.001763 103.0400n 0.001874
+ 103.0500n 0.001977 103.0600n 0.002068 103.0700n 0.002144 103.0800n 0.002204 103.0900n 0.002245 103.1000n 0.002264 103.1100n 0.002261 103.1200n 0.002234 103.1300n 0.002181 103.1400n 0.002101 103.1500n 0.001995 103.1600n 0.001862 103.1700n 0.001703 103.1800n 0.001519 103.1900n 0.001311
+ 103.2000n 0.001081 103.2100n 0.000832 103.2200n 0.000566 103.2300n 0.000286 103.2400n -0.000004 103.2500n -0.000301 103.2600n -0.000602 103.2700n -0.000901 103.2800n -0.001195 103.2900n -0.001481 103.3000n -0.001753 103.3100n -0.002010 103.3200n -0.002246 103.3300n -0.002459 103.3400n -0.002646
+ 103.3500n -0.002805 103.3600n -0.002934 103.3700n -0.003031 103.3800n -0.003095 103.3900n -0.003127 103.4000n -0.003126 103.4100n -0.003094 103.4200n -0.003031 103.4300n -0.002939 103.4400n -0.002822 103.4500n -0.002680 103.4600n -0.002519 103.4700n -0.002341 103.4800n -0.002150 103.4900n -0.001949
+ 103.5000n -0.001744 103.5100n -0.001536 103.5200n -0.001332 103.5300n -0.001133 103.5400n -0.000944 103.5500n -0.000768 103.5600n -0.000606 103.5700n -0.000463 103.5800n -0.000339 103.5900n -0.000236 103.6000n -0.000155 103.6100n -0.000095 103.6200n -0.000056 103.6300n -0.000039 103.6400n -0.000040
+ 103.6500n -0.000059 103.6600n -0.000094 103.6700n -0.000141 103.6800n -0.000198 103.6900n -0.000261 103.7000n -0.000328 103.7100n -0.000395 103.7200n -0.000460 103.7300n -0.000518 103.7400n -0.000567 103.7500n -0.000605 103.7600n -0.000628 103.7700n -0.000636 103.7800n -0.000627 103.7900n -0.000600
+ 103.8000n -0.000554 103.8100n -0.000490 103.8200n -0.000408 103.8300n -0.000310 103.8400n -0.000198 103.8500n -0.000073 103.8600n 0.000062 103.8700n 0.000204 103.8800n 0.000348 103.8900n 0.000493 103.9000n 0.000633 103.9100n 0.000766 103.9200n 0.000887 103.9300n 0.000994 103.9400n 0.001081
+ 103.9500n 0.001148 103.9600n 0.001190 103.9700n 0.001207 103.9800n 0.001195 103.9900n 0.001154 104.0000n 0.001083 104.0100n 0.000983 104.0200n 0.000854 104.0300n 0.000698 104.0400n 0.000517 104.0500n 0.000313 104.0600n 0.000089 104.0700n -0.000150 104.0800n -0.000401 104.0900n -0.000659
+ 104.1000n -0.000920 104.1100n -0.001179 104.1200n -0.001431 104.1300n -0.001672 104.1400n -0.001896 104.1500n -0.002099 104.1600n -0.002278 104.1700n -0.002428 104.1800n -0.002548 104.1900n -0.002633 104.2000n -0.002683 104.2100n -0.002696 104.2200n -0.002671 104.2300n -0.002610 104.2400n -0.002513
+ 104.2500n -0.002382 104.2600n -0.002219 104.2700n -0.002026 104.2800n -0.001809 104.2900n -0.001570 104.3000n -0.001314 104.3100n -0.001045 104.3200n -0.000769 104.3300n -0.000491 104.3400n -0.000215 104.3500n 0.000053 104.3600n 0.000310 104.3700n 0.000550 104.3800n 0.000770 104.3900n 0.000966
+ 104.4000n 0.001136 104.4100n 0.001277 104.4200n 0.001388 104.4300n 0.001467 104.4400n 0.001515 104.4500n 0.001531 104.4600n 0.001517 104.4700n 0.001475 104.4800n 0.001407 104.4900n 0.001315 104.5000n 0.001204 104.5100n 0.001076 104.5200n 0.000936 104.5300n 0.000787 104.5400n 0.000635
+ 104.5500n 0.000482 104.5600n 0.000334 104.5700n 0.000194 104.5800n 0.000065 104.5900n -0.000049 104.6000n -0.000145 104.6100n -0.000222 104.6200n -0.000277 104.6300n -0.000310 104.6400n -0.000321 104.6500n -0.000309 104.6600n -0.000275 104.6700n -0.000220 104.6800n -0.000147 104.6900n -0.000058
+ 104.7000n 0.000044 104.7100n 0.000156 104.7200n 0.000275 104.7300n 0.000397 104.7400n 0.000518 104.7500n 0.000634 104.7600n 0.000742 104.7700n 0.000839 104.7800n 0.000921 104.7900n 0.000986 104.8000n 0.001030 104.8100n 0.001053 104.8200n 0.001053 104.8300n 0.001030 104.8400n 0.000982
+ 104.8500n 0.000911 104.8600n 0.000817 104.8700n 0.000703 104.8800n 0.000570 104.8900n 0.000420 104.9000n 0.000258 104.9100n 0.000086 104.9200n -0.000092 104.9300n -0.000273 104.9400n -0.000452 104.9500n -0.000625 104.9600n -0.000789 104.9700n -0.000941 104.9800n -0.001076 104.9900n -0.001192
+ 105.0000n -0.001287 105.0100n -0.001358 105.0200n -0.001405 105.0300n -0.001425 105.0400n -0.001420 105.0500n -0.001389 105.0600n -0.001333 105.0700n -0.001254 105.0800n -0.001154 105.0900n -0.001036 105.1000n -0.000902 105.1100n -0.000756 105.1200n -0.000602 105.1300n -0.000443 105.1400n -0.000283
+ 105.1500n -0.000127 105.1600n 0.000022 105.1700n 0.000160 105.1800n 0.000283 105.1900n 0.000389 105.2000n 0.000476 105.2100n 0.000540 105.2200n 0.000581 105.2300n 0.000597 105.2400n 0.000588 105.2500n 0.000555 105.2600n 0.000499 105.2700n 0.000420 105.2800n 0.000322 105.2900n 0.000206
+ 105.3000n 0.000077 105.3100n -0.000063 105.3200n -0.000210 105.3300n -0.000360 105.3400n -0.000508 105.3500n -0.000650 105.3600n -0.000783 105.3700n -0.000903 105.3800n -0.001005 105.3900n -0.001087 105.4000n -0.001146 105.4100n -0.001180 105.4200n -0.001186 105.4300n -0.001165 105.4400n -0.001115
+ 105.4500n -0.001038 105.4600n -0.000933 105.4700n -0.000803 105.4800n -0.000651 105.4900n -0.000478 105.5000n -0.000290 105.5100n -0.000088 105.5200n 0.000121 105.5300n 0.000334 105.5400n 0.000545 105.5500n 0.000751 105.5600n 0.000945 105.5700n 0.001124 105.5800n 0.001283 105.5900n 0.001418
+ 105.6000n 0.001525 105.6100n 0.001601 105.6200n 0.001644 105.6300n 0.001651 105.6400n 0.001623 105.6500n 0.001558 105.6600n 0.001457 105.6700n 0.001322 105.6800n 0.001153 105.6900n 0.000955 105.7000n 0.000729 105.7100n 0.000481 105.7200n 0.000214 105.7300n -0.000067 105.7400n -0.000356
+ 105.7500n -0.000648 105.7600n -0.000938 105.7700n -0.001220 105.7800n -0.001489 105.7900n -0.001739 105.8000n -0.001966 105.8100n -0.002165 105.8200n -0.002334 105.8300n -0.002468 105.8400n -0.002564 105.8500n -0.002623 105.8600n -0.002641 105.8700n -0.002620 105.8800n -0.002559 105.8900n -0.002461
+ 105.9000n -0.002327 105.9100n -0.002160 105.9200n -0.001963 105.9300n -0.001742 105.9400n -0.001500 105.9500n -0.001242 105.9600n -0.000973 105.9700n -0.000700 105.9800n -0.000427 105.9900n -0.000160 106.0000n 0.000096 106.0100n 0.000336 106.0200n 0.000555 106.0300n 0.000748 106.0400n 0.000912
+ 106.0500n 0.001045 106.0600n 0.001143 106.0700n 0.001204 106.0800n 0.001229 106.0900n 0.001215 106.1000n 0.001165 106.1100n 0.001078 106.1200n 0.000957 106.1300n 0.000805 106.1400n 0.000623 106.1500n 0.000417 106.1600n 0.000189 106.1700n -0.000056 106.1800n -0.000313 106.1900n -0.000578
+ 106.2000n -0.000846 106.2100n -0.001112 106.2200n -0.001371 106.2300n -0.001620 106.2400n -0.001854 106.2500n -0.002069 106.2600n -0.002263 106.2700n -0.002431 106.2800n -0.002573 106.2900n -0.002686 106.3000n -0.002769 106.3100n -0.002821 106.3200n -0.002843 106.3300n -0.002834 106.3400n -0.002797
+ 106.3500n -0.002732 106.3600n -0.002641 106.3700n -0.002527 106.3800n -0.002391 106.3900n -0.002238 106.4000n -0.002069 106.4100n -0.001887 106.4200n -0.001696 106.4300n -0.001499 106.4400n -0.001298 106.4500n -0.001096 106.4600n -0.000896 106.4700n -0.000699 106.4800n -0.000508 106.4900n -0.000325
+ 106.5000n -0.000150 106.5100n 0.000016 106.5200n 0.000171 106.5300n 0.000316 106.5400n 0.000450 106.5500n 0.000574 106.5600n 0.000687 106.5700n 0.000792 106.5800n 0.000889 106.5900n 0.000978 106.6000n 0.001060 106.6100n 0.001137 106.6200n 0.001210 106.6300n 0.001279 106.6400n 0.001345
+ 106.6500n 0.001410 106.6600n 0.001472 106.6700n 0.001533 106.6800n 0.001592 106.6900n 0.001650 106.7000n 0.001706 106.7100n 0.001760 106.7200n 0.001810 106.7300n 0.001856 106.7400n 0.001897 106.7500n 0.001932 106.7600n 0.001959 106.7700n 0.001977 106.7800n 0.001985 106.7900n 0.001982
+ 106.8000n 0.001966 106.8100n 0.001938 106.8200n 0.001895 106.8300n 0.001839 106.8400n 0.001768 106.8500n 0.001682 106.8600n 0.001582 106.8700n 0.001469 106.8800n 0.001342 106.8900n 0.001205 106.9000n 0.001058 106.9100n 0.000902 106.9200n 0.000740 106.9300n 0.000575 106.9400n 0.000408
+ 106.9500n 0.000242 106.9600n 0.000079 106.9700n -0.000078 106.9800n -0.000226 106.9900n -0.000363 107.0000n -0.000487 107.0100n -0.000596 107.0200n -0.000687 107.0300n -0.000759 107.0400n -0.000812 107.0500n -0.000844 107.0600n -0.000854 107.0700n -0.000843 107.0800n -0.000810 107.0900n -0.000756
+ 107.1000n -0.000683 107.1100n -0.000592 107.1200n -0.000483 107.1300n -0.000360 107.1400n -0.000225 107.1500n -0.000080 107.1600n 0.000072 107.1700n 0.000229 107.1800n 0.000388 107.1900n 0.000546 107.2000n 0.000699 107.2100n 0.000847 107.2200n 0.000985 107.2300n 0.001112 107.2400n 0.001225
+ 107.2500n 0.001324 107.2600n 0.001406 107.2700n 0.001471 107.2800n 0.001517 107.2900n 0.001545 107.3000n 0.001555 107.3100n 0.001547 107.3200n 0.001522 107.3300n 0.001480 107.3400n 0.001424 107.3500n 0.001356 107.3600n 0.001276 107.3700n 0.001188 107.3800n 0.001094 107.3900n 0.000995
+ 107.4000n 0.000895 107.4100n 0.000796 107.4200n 0.000699 107.4300n 0.000609 107.4400n 0.000525 107.4500n 0.000452 107.4600n 0.000389 107.4700n 0.000339 107.4800n 0.000302 107.4900n 0.000280 107.5000n 0.000273 107.5100n 0.000281 107.5200n 0.000304 107.5300n 0.000341 107.5400n 0.000393
+ 107.5500n 0.000458 107.5600n 0.000534 107.5700n 0.000620 107.5800n 0.000715 107.5900n 0.000816 107.6000n 0.000922 107.6100n 0.001030 107.6200n 0.001140 107.6300n 0.001247 107.6400n 0.001351 107.6500n 0.001450 107.6600n 0.001541 107.6700n 0.001623 107.6800n 0.001695 107.6900n 0.001754
+ 107.7000n 0.001800 107.7100n 0.001832 107.7200n 0.001849 107.7300n 0.001851 107.7400n 0.001837 107.7500n 0.001807 107.7600n 0.001762 107.7700n 0.001702 107.7800n 0.001627 107.7900n 0.001539 107.8000n 0.001438 107.8100n 0.001326 107.8200n 0.001204 107.8300n 0.001072 107.8400n 0.000934
+ 107.8500n 0.000790 107.8600n 0.000641 107.8700n 0.000490 107.8800n 0.000338 107.8900n 0.000187 107.9000n 0.000038 107.9100n -0.000106 107.9200n -0.000246 107.9300n -0.000378 107.9400n -0.000501 107.9500n -0.000616 107.9600n -0.000719 107.9700n -0.000810 107.9800n -0.000888 107.9900n -0.000952
+ 108.0000n -0.001001 108.0100n -0.001035 108.0200n -0.001053 108.0300n -0.001055 108.0400n -0.001041 108.0500n -0.001010 108.0600n -0.000964 108.0700n -0.000901 108.0800n -0.000823 108.0900n -0.000731 108.1000n -0.000625 108.1100n -0.000506 108.1200n -0.000376 108.1300n -0.000237 108.1400n -0.000089
+ 108.1500n 0.000066 108.1600n 0.000224 108.1700n 0.000385 108.1800n 0.000546 108.1900n 0.000705 108.2000n 0.000859 108.2100n 0.001006 108.2200n 0.001143 108.2300n 0.001268 108.2400n 0.001379 108.2500n 0.001472 108.2600n 0.001546 108.2700n 0.001600 108.2800n 0.001630 108.2900n 0.001635
+ 108.3000n 0.001615 108.3100n 0.001568 108.3200n 0.001493 108.3300n 0.001391 108.3400n 0.001262 108.3500n 0.001105 108.3600n 0.000922 108.3700n 0.000715 108.3800n 0.000486 108.3900n 0.000236 108.4000n -0.000032 108.4100n -0.000314 108.4200n -0.000608 108.4300n -0.000909 108.4400n -0.001214
+ 108.4500n -0.001518 108.4600n -0.001818 108.4700n -0.002108 108.4800n -0.002386 108.4900n -0.002646 108.5000n -0.002885 108.5100n -0.003098 108.5200n -0.003283 108.5300n -0.003436 108.5400n -0.003554 108.5500n -0.003634 108.5600n -0.003676 108.5700n -0.003678 108.5800n -0.003639 108.5900n -0.003560
+ 108.6000n -0.003440 108.6100n -0.003281 108.6200n -0.003086 108.6300n -0.002855 108.6400n -0.002593 108.6500n -0.002303 108.6600n -0.001989 108.6700n -0.001655 108.6800n -0.001305 108.6900n -0.000946 108.7000n -0.000582 108.7100n -0.000218 108.7200n 0.000141 108.7300n 0.000488 108.7400n 0.000821
+ 108.7500n 0.001133 108.7600n 0.001420 108.7700n 0.001678 108.7800n 0.001905 108.7900n 0.002096 108.8000n 0.002251 108.8100n 0.002366 108.8200n 0.002442 108.8300n 0.002477 108.8400n 0.002473 108.8500n 0.002430 108.8600n 0.002350 108.8700n 0.002236 108.8800n 0.002090 108.8900n 0.001915
+ 108.9000n 0.001717 108.9100n 0.001498 108.9200n 0.001264 108.9300n 0.001020 108.9400n 0.000770 108.9500n 0.000519 108.9600n 0.000273 108.9700n 0.000035 108.9800n -0.000189 108.9900n -0.000395 109.0000n -0.000579 109.0100n -0.000739 109.0200n -0.000871 109.0300n -0.000973 109.0400n -0.001043
+ 109.0500n -0.001080 109.0600n -0.001085 109.0700n -0.001057 109.0800n -0.000997 109.0900n -0.000907 109.1000n -0.000789 109.1100n -0.000645 109.1200n -0.000479 109.1300n -0.000294 109.1400n -0.000094 109.1500n 0.000117 109.1600n 0.000334 109.1700n 0.000553 109.1800n 0.000770 109.1900n 0.000979
+ 109.2000n 0.001178 109.2100n 0.001361 109.2200n 0.001526 109.2300n 0.001669 109.2400n 0.001786 109.2500n 0.001876 109.2600n 0.001936 109.2700n 0.001965 109.2800n 0.001962 109.2900n 0.001928 109.3000n 0.001861 109.3100n 0.001764 109.3200n 0.001637 109.3300n 0.001482 109.3400n 0.001302
+ 109.3500n 0.001099 109.3600n 0.000877 109.3700n 0.000639 109.3800n 0.000388 109.3900n 0.000128 109.4000n -0.000137 109.4100n -0.000404 109.4200n -0.000667 109.4300n -0.000925 109.4400n -0.001172 109.4500n -0.001407 109.4600n -0.001626 109.4700n -0.001826 109.4800n -0.002006 109.4900n -0.002163
+ 109.5000n -0.002296 109.5100n -0.002404 109.5200n -0.002487 109.5300n -0.002544 109.5400n -0.002576 109.5500n -0.002584 109.5600n -0.002568 109.5700n -0.002530 109.5800n -0.002471 109.5900n -0.002395 109.6000n -0.002303 109.6100n -0.002197 109.6200n -0.002079 109.6300n -0.001953 109.6400n -0.001822
+ 109.6500n -0.001686 109.6600n -0.001550 109.6700n -0.001415 109.6800n -0.001283 109.6900n -0.001157 109.7000n -0.001038 109.7100n -0.000927 109.7200n -0.000826 109.7300n -0.000736 109.7400n -0.000658 109.7500n -0.000592 109.7600n -0.000537 109.7700n -0.000495 109.7800n -0.000464 109.7900n -0.000444
+ 109.8000n -0.000434 109.8100n -0.000433 109.8200n -0.000441 109.8300n -0.000456 109.8400n -0.000476 109.8500n -0.000501 109.8600n -0.000529 109.8700n -0.000558 109.8800n -0.000589 109.8900n -0.000619 109.9000n -0.000647 109.9100n -0.000673 109.9200n -0.000696 109.9300n -0.000716 109.9400n -0.000731
+ 109.9500n -0.000741 109.9600n -0.000747 109.9700n -0.000749 109.9800n -0.000746 109.9900n -0.000740 110.0000n -0.000730 110.0100n -0.000717 110.0200n -0.000703 110.0300n -0.000687 110.0400n -0.000671 110.0500n -0.000655 110.0600n -0.000640 110.0700n -0.000628 110.0800n -0.000619 110.0900n -0.000613
+ 110.1000n -0.000611 110.1100n -0.000614 110.1200n -0.000622 110.1300n -0.000636 110.1400n -0.000655 110.1500n -0.000679 110.1600n -0.000708 110.1700n -0.000742 110.1800n -0.000780 110.1900n -0.000822 110.2000n -0.000866 110.2100n -0.000912 110.2200n -0.000958 110.2300n -0.001003 110.2400n -0.001047
+ 110.2500n -0.001087 110.2600n -0.001123 110.2700n -0.001153 110.2800n -0.001176 110.2900n -0.001191 110.3000n -0.001196 110.3100n -0.001192 110.3200n -0.001175 110.3300n -0.001148 110.3400n -0.001107 110.3500n -0.001054 110.3600n -0.000989 110.3700n -0.000911 110.3800n -0.000820 110.3900n -0.000718
+ 110.4000n -0.000605 110.4100n -0.000482 110.4200n -0.000351 110.4300n -0.000213 110.4400n -0.000069 110.4500n 0.000078 110.4600n 0.000226 110.4700n 0.000374 110.4800n 0.000520 110.4900n 0.000661 110.5000n 0.000794 110.5100n 0.000919 110.5200n 0.001032 110.5300n 0.001132 110.5400n 0.001216
+ 110.5500n 0.001284 110.5600n 0.001334 110.5700n 0.001364 110.5800n 0.001374 110.5900n 0.001362 110.6000n 0.001330 110.6100n 0.001275 110.6200n 0.001199 110.6300n 0.001103 110.6400n 0.000987 110.6500n 0.000852 110.6600n 0.000701 110.6700n 0.000535 110.6800n 0.000356 110.6900n 0.000167
+ 110.7000n -0.000029 110.7100n -0.000231 110.7200n -0.000434 110.7300n -0.000636 110.7400n -0.000835 110.7500n -0.001025 110.7600n -0.001206 110.7700n -0.001374 110.7800n -0.001526 110.7900n -0.001660 110.8000n -0.001773 110.8100n -0.001864 110.8200n -0.001931 110.8300n -0.001972 110.8400n -0.001988
+ 110.8500n -0.001976 110.8600n -0.001938 110.8700n -0.001874 110.8800n -0.001783 110.8900n -0.001669 110.9000n -0.001531 110.9100n -0.001371 110.9200n -0.001193 110.9300n -0.000998 110.9400n -0.000789 110.9500n -0.000570 110.9600n -0.000342 110.9700n -0.000109 110.9800n 0.000125 110.9900n 0.000358
+ 111.0000n 0.000587 111.0100n 0.000808 111.0200n 0.001019 111.0300n 0.001217 111.0400n 0.001401 111.0500n 0.001568 111.0600n 0.001717 111.0700n 0.001846 111.0800n 0.001956 111.0900n 0.002045 111.1000n 0.002113 111.1100n 0.002162 111.1200n 0.002191 111.1300n 0.002202 111.1400n 0.002197
+ 111.1500n 0.002177 111.1600n 0.002144 111.1700n 0.002101 111.1800n 0.002050 111.1900n 0.001994 111.2000n 0.001934 111.2100n 0.001873 111.2200n 0.001815 111.2300n 0.001760 111.2400n 0.001712 111.2500n 0.001671 111.2600n 0.001640 111.2700n 0.001619 111.2800n 0.001610 111.2900n 0.001613
+ 111.3000n 0.001628 111.3100n 0.001655 111.3200n 0.001694 111.3300n 0.001742 111.3400n 0.001800 111.3500n 0.001864 111.3600n 0.001934 111.3700n 0.002007 111.3800n 0.002080 111.3900n 0.002151 111.4000n 0.002218 111.4100n 0.002278 111.4200n 0.002328 111.4300n 0.002366 111.4400n 0.002390
+ 111.4500n 0.002397 111.4600n 0.002386 111.4700n 0.002356 111.4800n 0.002305 111.4900n 0.002233 111.5000n 0.002139 111.5100n 0.002023 111.5200n 0.001887 111.5300n 0.001731 111.5400n 0.001557 111.5500n 0.001367 111.5600n 0.001162 111.5700n 0.000946 111.5800n 0.000721 111.5900n 0.000490
+ 111.6000n 0.000257 111.6100n 0.000024 111.6200n -0.000205 111.6300n -0.000426 111.6400n -0.000637 111.6500n -0.000834 111.6600n -0.001014 111.6700n -0.001176 111.6800n -0.001317 111.6900n -0.001436 111.7000n -0.001530 111.7100n -0.001599 111.7200n -0.001643 111.7300n -0.001661 111.7400n -0.001655
+ 111.7500n -0.001625 111.7600n -0.001572 111.7700n -0.001499 111.7800n -0.001408 111.7900n -0.001301 111.8000n -0.001181 111.8100n -0.001051 111.8200n -0.000913 111.8300n -0.000773 111.8400n -0.000631 111.8500n -0.000492 111.8600n -0.000359 111.8700n -0.000234 111.8800n -0.000121 111.8900n -0.000020
+ 111.9000n 0.000066 111.9100n 0.000135 111.9200n 0.000186 111.9300n 0.000219 111.9400n 0.000234 111.9500n 0.000231 111.9600n 0.000210 111.9700n 0.000173 111.9800n 0.000122 111.9900n 0.000057 112.0000n -0.000019 112.0100n -0.000102 112.0200n -0.000192 112.0300n -0.000285 112.0400n -0.000378
+ 112.0500n -0.000469 112.0600n -0.000554 112.0700n -0.000632 112.0800n -0.000700 112.0900n -0.000755 112.1000n -0.000797 112.1100n -0.000823 112.1200n -0.000833 112.1300n -0.000826 112.1400n -0.000802 112.1500n -0.000760 112.1600n -0.000701 112.1700n -0.000627 112.1800n -0.000538 112.1900n -0.000437
+ 112.2000n -0.000324 112.2100n -0.000204 112.2200n -0.000077 112.2300n 0.000053 112.2400n 0.000184 112.2500n 0.000313 112.2600n 0.000437 112.2700n 0.000554 112.2800n 0.000662 112.2900n 0.000758 112.3000n 0.000840 112.3100n 0.000908 112.3200n 0.000958 112.3300n 0.000992 112.3400n 0.001007
+ 112.3500n 0.001005 112.3600n 0.000985 112.3700n 0.000947 112.3800n 0.000894 112.3900n 0.000826 112.4000n 0.000745 112.4100n 0.000653 112.4200n 0.000551 112.4300n 0.000443 112.4400n 0.000330 112.4500n 0.000216 112.4600n 0.000101 112.4700n -0.000011 112.4800n -0.000119 112.4900n -0.000220
+ 112.5000n -0.000313 112.5100n -0.000397 112.5200n -0.000470 112.5300n -0.000531 112.5400n -0.000580 112.5500n -0.000618 112.5600n -0.000644 112.5700n -0.000659 112.5800n -0.000664 112.5900n -0.000660 112.6000n -0.000649 112.6100n -0.000632 112.6200n -0.000611 112.6300n -0.000589 112.6400n -0.000566
+ 112.6500n -0.000546 112.6600n -0.000530 112.6700n -0.000520 112.6800n -0.000517 112.6900n -0.000523 112.7000n -0.000540 112.7100n -0.000566 112.7200n -0.000604 112.7300n -0.000653 112.7400n -0.000714 112.7500n -0.000784 112.7600n -0.000863 112.7700n -0.000950 112.7800n -0.001043 112.7900n -0.001139
+ 112.8000n -0.001237 112.8100n -0.001334 112.8200n -0.001426 112.8300n -0.001513 112.8400n -0.001589 112.8500n -0.001654 112.8600n -0.001704 112.8700n -0.001736 112.8800n -0.001749 112.8900n -0.001741 112.9000n -0.001709 112.9100n -0.001654 112.9200n -0.001573 112.9300n -0.001467 112.9400n -0.001337
+ 112.9500n -0.001181 112.9600n -0.001003 112.9700n -0.000804 112.9800n -0.000585 112.9900n -0.000349 113.0000n -0.000099 113.0100n 0.000161 113.0200n 0.000428 113.0300n 0.000699 113.0400n 0.000970 113.0500n 0.001236 113.0600n 0.001495 113.0700n 0.001741 113.0800n 0.001972 113.0900n 0.002185
+ 113.1000n 0.002376 113.1100n 0.002543 113.1200n 0.002683 113.1300n 0.002795 113.1400n 0.002877 113.1500n 0.002928 113.1600n 0.002949 113.1700n 0.002940 113.1800n 0.002901 113.1900n 0.002834 113.2000n 0.002739 113.2100n 0.002621 113.2200n 0.002480 113.2300n 0.002320 113.2400n 0.002144
+ 113.2500n 0.001955 113.2600n 0.001757 113.2700n 0.001552 113.2800n 0.001345 113.2900n 0.001139 113.3000n 0.000936 113.3100n 0.000740 113.3200n 0.000553 113.3300n 0.000378 113.3400n 0.000217 113.3500n 0.000072 113.3600n -0.000058 113.3700n -0.000170 113.3800n -0.000264 113.3900n -0.000340
+ 113.4000n -0.000399 113.4100n -0.000442 113.4200n -0.000469 113.4300n -0.000482 113.4400n -0.000482 113.4500n -0.000472 113.4600n -0.000452 113.4700n -0.000426 113.4800n -0.000394 113.4900n -0.000359 113.5000n -0.000323 113.5100n -0.000286 113.5200n -0.000251 113.5300n -0.000219 113.5400n -0.000191
+ 113.5500n -0.000166 113.5600n -0.000146 113.5700n -0.000131 113.5800n -0.000120 113.5900n -0.000113 113.6000n -0.000109 113.6100n -0.000107 113.6200n -0.000106 113.6300n -0.000104 113.6400n -0.000100 113.6500n -0.000092 113.6600n -0.000079 113.6700n -0.000060 113.6800n -0.000032 113.6900n 0.000004
+ 113.7000n 0.000051 113.7100n 0.000109 113.7200n 0.000178 113.7300n 0.000258 113.7400n 0.000350 113.7500n 0.000452 113.7600n 0.000565 113.7700n 0.000686 113.7800n 0.000814 113.7900n 0.000948 113.8000n 0.001085 113.8100n 0.001223 113.8200n 0.001359 113.8300n 0.001491 113.8400n 0.001616
+ 113.8500n 0.001731 113.8600n 0.001835 113.8700n 0.001923 113.8800n 0.001995 113.8900n 0.002047 113.9000n 0.002078 113.9100n 0.002087 113.9200n 0.002073 113.9300n 0.002034 113.9400n 0.001971 113.9500n 0.001884 113.9600n 0.001774 113.9700n 0.001642 113.9800n 0.001489 113.9900n 0.001319
+ 114.0000n 0.001132 114.0100n 0.000932 114.0200n 0.000723 114.0300n 0.000506 114.0400n 0.000287 114.0500n 0.000068 114.0600n -0.000146 114.0700n -0.000353 114.0800n -0.000549 114.0900n -0.000730 114.1000n -0.000894 114.1100n -0.001037 114.1200n -0.001158 114.1300n -0.001255 114.1400n -0.001326
+ 114.1500n -0.001370 114.1600n -0.001387 114.1700n -0.001378 114.1800n -0.001341 114.1900n -0.001279 114.2000n -0.001194 114.2100n -0.001086 114.2200n -0.000959 114.2300n -0.000816 114.2400n -0.000658 114.2500n -0.000491 114.2600n -0.000316 114.2700n -0.000137 114.2800n 0.000042 114.2900n 0.000217
+ 114.3000n 0.000387 114.3100n 0.000547 114.3200n 0.000695 114.3300n 0.000828 114.3400n 0.000945 114.3500n 0.001044 114.3600n 0.001124 114.3700n 0.001183 114.3800n 0.001223 114.3900n 0.001242 114.4000n 0.001243 114.4100n 0.001225 114.4200n 0.001190 114.4300n 0.001140 114.4400n 0.001078
+ 114.4500n 0.001006 114.4600n 0.000926 114.4700n 0.000841 114.4800n 0.000754 114.4900n 0.000667 114.5000n 0.000584 114.5100n 0.000507 114.5200n 0.000437 114.5300n 0.000378 114.5400n 0.000331 114.5500n 0.000297 114.5600n 0.000277 114.5700n 0.000273 114.5800n 0.000283 114.5900n 0.000308
+ 114.6000n 0.000347 114.6100n 0.000399 114.6200n 0.000463 114.6300n 0.000537 114.6400n 0.000618 114.6500n 0.000704 114.6600n 0.000793 114.6700n 0.000882 114.6800n 0.000968 114.6900n 0.001049 114.7000n 0.001121 114.7100n 0.001182 114.7200n 0.001229 114.7300n 0.001261 114.7400n 0.001276
+ 114.7500n 0.001271 114.7600n 0.001245 114.7700n 0.001198 114.7800n 0.001130 114.7900n 0.001040 114.8000n 0.000928 114.8100n 0.000796 114.8200n 0.000645 114.8300n 0.000476 114.8400n 0.000292 114.8500n 0.000095 114.8600n -0.000114 114.8700n -0.000329 114.8800n -0.000550 114.8900n -0.000773
+ 114.9000n -0.000995 114.9100n -0.001212 114.9200n -0.001422 114.9300n -0.001622 114.9400n -0.001810 114.9500n -0.001983 114.9600n -0.002139 114.9700n -0.002276 114.9800n -0.002393 114.9900n -0.002489 115.0000n -0.002563 115.0100n -0.002615 115.0200n -0.002646 115.0300n -0.002655 115.0400n -0.002643
+ 115.0500n -0.002613 115.0600n -0.002565 115.0700n -0.002501 115.0800n -0.002423 115.0900n -0.002334 115.1000n -0.002235 115.1100n -0.002130 115.1200n -0.002020 115.1300n -0.001908 115.1400n -0.001796 115.1500n -0.001686 115.1600n -0.001581 115.1700n -0.001482 115.1800n -0.001391 115.1900n -0.001310
+ 115.2000n -0.001238 115.2100n -0.001177 115.2200n -0.001128 115.2300n -0.001091 115.2400n -0.001065 115.2500n -0.001051 115.2600n -0.001047 115.2700n -0.001053 115.2800n -0.001067 115.2900n -0.001089 115.3000n -0.001117 115.3100n -0.001149 115.3200n -0.001184 115.3300n -0.001221 115.3400n -0.001257
+ 115.3500n -0.001291 115.3600n -0.001322 115.3700n -0.001348 115.3800n -0.001369 115.3900n -0.001382 115.4000n -0.001387 115.4100n -0.001384 115.4200n -0.001372 115.4300n -0.001350 115.4400n -0.001319 115.4500n -0.001279 115.4600n -0.001230 115.4700n -0.001172 115.4800n -0.001107 115.4900n -0.001035
+ 115.5000n -0.000957 115.5100n -0.000874 115.5200n -0.000788 115.5300n -0.000699 115.5400n -0.000610 115.5500n -0.000521 115.5600n -0.000434 115.5700n -0.000350 115.5800n -0.000270 115.5900n -0.000195 115.6000n -0.000127 115.6100n -0.000065 115.6200n -0.000012 115.6300n 0.000032 115.6400n 0.000068
+ 115.6500n 0.000094 115.6600n 0.000110 115.6700n 0.000117 115.6800n 0.000114 115.6900n 0.000101 115.7000n 0.000080 115.7100n 0.000051 115.7200n 0.000013 115.7300n -0.000031 115.7400n -0.000082 115.7500n -0.000137 115.7600n -0.000197 115.7700n -0.000260 115.7800n -0.000325 115.7900n -0.000391
+ 115.8000n -0.000457 115.8100n -0.000521 115.8200n -0.000583 115.8300n -0.000640 115.8400n -0.000694 115.8500n -0.000741 115.8600n -0.000781 115.8700n -0.000814 115.8800n -0.000839 115.8900n -0.000854 115.9000n -0.000859 115.9100n -0.000854 115.9200n -0.000839 115.9300n -0.000812 115.9400n -0.000774
+ 115.9500n -0.000726 115.9600n -0.000666 115.9700n -0.000596 115.9800n -0.000515 115.9900n -0.000425 116.0000n -0.000326 116.0100n -0.000219 116.0200n -0.000106 116.0300n 0.000013 116.0400n 0.000136 116.0500n 0.000263 116.0600n 0.000390 116.0700n 0.000517 116.0800n 0.000643 116.0900n 0.000764
+ 116.1000n 0.000880 116.1100n 0.000989 116.1200n 0.001089 116.1300n 0.001178 116.1400n 0.001256 116.1500n 0.001319 116.1600n 0.001369 116.1700n 0.001402 116.1800n 0.001418 116.1900n 0.001417 116.2000n 0.001398 116.2100n 0.001361 116.2200n 0.001306 116.2300n 0.001234 116.2400n 0.001145
+ 116.2500n 0.001040 116.2600n 0.000920 116.2700n 0.000788 116.2800n 0.000644 116.2900n 0.000491 116.3000n 0.000331 116.3100n 0.000167 116.3200n 0.000001 116.3300n -0.000164 116.3400n -0.000326 116.3500n -0.000481 116.3600n -0.000626 116.3700n -0.000760 116.3800n -0.000880 116.3900n -0.000983
+ 116.4000n -0.001067 116.4100n -0.001131 116.4200n -0.001172 116.4300n -0.001190 116.4400n -0.001184 116.4500n -0.001154 116.4600n -0.001099 116.4700n -0.001020 116.4800n -0.000918 116.4900n -0.000794 116.5000n -0.000650 116.5100n -0.000488 116.5200n -0.000310 116.5300n -0.000120 116.5400n 0.000079
+ 116.5500n 0.000286 116.5600n 0.000494 116.5700n 0.000703 116.5800n 0.000907 116.5900n 0.001102 116.6000n 0.001287 116.6100n 0.001456 116.6200n 0.001608 116.6300n 0.001738 116.6400n 0.001845 116.6500n 0.001926 116.6600n 0.001979 116.6700n 0.002004 116.6800n 0.001998 116.6900n 0.001962
+ 116.7000n 0.001895 116.7100n 0.001799 116.7200n 0.001674 116.7300n 0.001522 116.7400n 0.001344 116.7500n 0.001144 116.7600n 0.000924 116.7700n 0.000687 116.7800n 0.000436 116.7900n 0.000176 116.8000n -0.000092 116.8100n -0.000362 116.8200n -0.000631 116.8300n -0.000896 116.8400n -0.001153
+ 116.8500n -0.001398 116.8600n -0.001628 116.8700n -0.001842 116.8800n -0.002036 116.8900n -0.002208 116.9000n -0.002356 116.9100n -0.002480 116.9200n -0.002579 116.9300n -0.002652 116.9400n -0.002700 116.9500n -0.002723 116.9600n -0.002721 116.9700n -0.002697 116.9800n -0.002652 116.9900n -0.002587
+ 117.0000n -0.002505 117.0100n -0.002409 117.0200n -0.002300 117.0300n -0.002181 117.0400n -0.002054 117.0500n -0.001922 117.0600n -0.001788 117.0700n -0.001652 117.0800n -0.001518 117.0900n -0.001387 117.1000n -0.001260 117.1100n -0.001139 117.1200n -0.001024 117.1300n -0.000916 117.1400n -0.000814
+ 117.1500n -0.000720 117.1600n -0.000632 117.1700n -0.000550 117.1800n -0.000473 117.1900n -0.000399 117.2000n -0.000328 117.2100n -0.000258 117.2200n -0.000187 117.2300n -0.000114 117.2400n -0.000039 117.2500n 0.000042 117.2600n 0.000128 117.2700n 0.000222 117.2800n 0.000323 117.2900n 0.000432
+ 117.3000n 0.000549 117.3100n 0.000676 117.3200n 0.000810 117.3300n 0.000951 117.3400n 0.001099 117.3500n 0.001252 117.3600n 0.001409 117.3700n 0.001567 117.3800n 0.001724 117.3900n 0.001879 117.4000n 0.002028 117.4100n 0.002169 117.4200n 0.002300 117.4300n 0.002417 117.4400n 0.002519
+ 117.4500n 0.002603 117.4600n 0.002667 117.4700n 0.002708 117.4800n 0.002725 117.4900n 0.002717 117.5000n 0.002683 117.5100n 0.002621 117.5200n 0.002533 117.5300n 0.002417 117.5400n 0.002275 117.5500n 0.002108 117.5600n 0.001917 117.5700n 0.001704 117.5800n 0.001472 117.5900n 0.001223
+ 117.6000n 0.000960 117.6100n 0.000687 117.6200n 0.000406 117.6300n 0.000122 117.6400n -0.000162 117.6500n -0.000443 117.6600n -0.000716 117.6700n -0.000978 117.6800n -0.001225 117.6900n -0.001456 117.7000n -0.001665 117.7100n -0.001852 117.7200n -0.002013 117.7300n -0.002147 117.7400n -0.002252
+ 117.7500n -0.002327 117.7600n -0.002372 117.7700n -0.002387 117.7800n -0.002371 117.7900n -0.002327 117.8000n -0.002254 117.8100n -0.002155 117.8200n -0.002031 117.8300n -0.001885 117.8400n -0.001720 117.8500n -0.001538 117.8600n -0.001342 117.8700n -0.001135 117.8800n -0.000922 117.8900n -0.000704
+ 117.9000n -0.000486 117.9100n -0.000270 117.9200n -0.000059 117.9300n 0.000142 117.9400n 0.000333 117.9500n 0.000510 117.9600n 0.000671 117.9700n 0.000815 117.9800n 0.000938 117.9900n 0.001042 118.0000n 0.001123 118.0100n 0.001183 118.0200n 0.001220 118.0300n 0.001234 118.0400n 0.001227
+ 118.0500n 0.001199 118.0600n 0.001150 118.0700n 0.001083 118.0800n 0.000998 118.0900n 0.000898 118.1000n 0.000784 118.1100n 0.000658 118.1200n 0.000523 118.1300n 0.000380 118.1400n 0.000233 118.1500n 0.000083 118.1600n -0.000068 118.1700n -0.000216 118.1800n -0.000360 118.1900n -0.000498
+ 118.2000n -0.000628 118.2100n -0.000747 118.2200n -0.000854 118.2300n -0.000948 118.2400n -0.001028 118.2500n -0.001091 118.2600n -0.001137 118.2700n -0.001166 118.2800n -0.001176 118.2900n -0.001168 118.3000n -0.001141 118.3100n -0.001096 118.3200n -0.001033 118.3300n -0.000953 118.3400n -0.000856
+ 118.3500n -0.000743 118.3600n -0.000616 118.3700n -0.000476 118.3800n -0.000325 118.3900n -0.000164 118.4000n 0.000005 118.4100n 0.000180 118.4200n 0.000359 118.4300n 0.000539 118.4400n 0.000719 118.4500n 0.000896 118.4600n 0.001068 118.4700n 0.001233 118.4800n 0.001389 118.4900n 0.001534
+ 118.5000n 0.001665 118.5100n 0.001782 118.5200n 0.001881 118.5300n 0.001963 118.5400n 0.002026 118.5500n 0.002068 118.5600n 0.002090 118.5700n 0.002090 118.5800n 0.002069 118.5900n 0.002027 118.6000n 0.001964 118.6100n 0.001881 118.6200n 0.001779 118.6300n 0.001660 118.6400n 0.001524
+ 118.6500n 0.001375 118.6600n 0.001214 118.6700n 0.001043 118.6800n 0.000865 118.6900n 0.000683 118.7000n 0.000499 118.7100n 0.000316 118.7200n 0.000137 118.7300n -0.000036 118.7400n -0.000199 118.7500n -0.000350 118.7600n -0.000487 118.7700n -0.000607 118.7800n -0.000709 118.7900n -0.000791
+ 118.8000n -0.000852 118.8100n -0.000890 118.8200n -0.000905 118.8300n -0.000896 118.8400n -0.000864 118.8500n -0.000809 118.8600n -0.000732 118.8700n -0.000634 118.8800n -0.000516 118.8900n -0.000381 118.9000n -0.000230 118.9100n -0.000066 118.9200n 0.000109 118.9300n 0.000292 118.9400n 0.000481
+ 118.9500n 0.000673 118.9600n 0.000864 118.9700n 0.001052 118.9800n 0.001234 118.9900n 0.001408 119.0000n 0.001571 119.0100n 0.001722 119.0200n 0.001858 119.0300n 0.001977 119.0400n 0.002079 119.0500n 0.002163 119.0600n 0.002226 119.0700n 0.002271 119.0800n 0.002296 119.0900n 0.002301
+ 119.1000n 0.002288 119.1100n 0.002257 119.1200n 0.002210 119.1300n 0.002148 119.1400n 0.002072 119.1500n 0.001984 119.1600n 0.001887 119.1700n 0.001781 119.1800n 0.001669 119.1900n 0.001553 119.2000n 0.001435 119.2100n 0.001316 119.2200n 0.001198 119.2300n 0.001082 119.2400n 0.000970
+ 119.2500n 0.000863 119.2600n 0.000760 119.2700n 0.000664 119.2800n 0.000574 119.2900n 0.000490 119.3000n 0.000412 119.3100n 0.000340 119.3200n 0.000274 119.3300n 0.000212 119.3400n 0.000154 119.3500n 0.000099 119.3600n 0.000046 119.3700n -0.000006 119.3800n -0.000058 119.3900n -0.000110
+ 119.4000n -0.000165 119.4100n -0.000222 119.4200n -0.000281 119.4300n -0.000345 119.4400n -0.000412 119.4500n -0.000483 119.4600n -0.000557 119.4700n -0.000636 119.4800n -0.000717 119.4900n -0.000801 119.5000n -0.000886 119.5100n -0.000973 119.5200n -0.001059 119.5300n -0.001144 119.5400n -0.001226
+ 119.5500n -0.001304 119.5600n -0.001378 119.5700n -0.001446 119.5800n -0.001507 119.5900n -0.001560 119.6000n -0.001604 119.6100n -0.001639 119.6200n -0.001665 119.6300n -0.001680 119.6400n -0.001686 119.6500n -0.001682 119.6600n -0.001669 119.6700n -0.001647 119.6800n -0.001617 119.6900n -0.001581
+ 119.7000n -0.001539 119.7100n -0.001492 119.7200n -0.001443 119.7300n -0.001392 119.7400n -0.001341 119.7500n -0.001291 119.7600n -0.001244 119.7700n -0.001201 119.7800n -0.001162 119.7900n -0.001130 119.8000n -0.001103 119.8100n -0.001084 119.8200n -0.001072 119.8300n -0.001067 119.8400n -0.001069
+ 119.8500n -0.001077 119.8600n -0.001091 119.8700n -0.001109 119.8800n -0.001130 119.8900n -0.001154 119.9000n -0.001177 119.9100n -0.001198 119.9200n -0.001216 119.9300n -0.001229 119.9400n -0.001235 119.9500n -0.001232 119.9600n -0.001219 119.9700n -0.001194 119.9800n -0.001156 119.9900n -0.001105
+ 120.0000n -0.001039 120.0100n -0.000959 120.0200n -0.000864 120.0300n -0.000755 120.0400n -0.000632 120.0500n -0.000498 120.0600n -0.000353 120.0700n -0.000199 120.0800n -0.000038 120.0900n 0.000127 120.1000n 0.000294 120.1100n 0.000460 120.1200n 0.000622 120.1300n 0.000776 120.1400n 0.000922
+ 120.1500n 0.001055 120.1600n 0.001172 120.1700n 0.001273 120.1800n 0.001353 120.1900n 0.001413 120.2000n 0.001449 120.2100n 0.001462 120.2200n 0.001451 120.2300n 0.001415 120.2400n 0.001356 120.2500n 0.001273 120.2600n 0.001170 120.2700n 0.001047 120.2800n 0.000907 120.2900n 0.000752
+ 120.3000n 0.000587 120.3100n 0.000414 120.3200n 0.000236 120.3300n 0.000059 120.3400n -0.000115 120.3500n -0.000282 120.3600n -0.000438 120.3700n -0.000579 120.3800n -0.000703 120.3900n -0.000805 120.4000n -0.000884 120.4100n -0.000938 120.4200n -0.000965 120.4300n -0.000963 120.4400n -0.000933
+ 120.4500n -0.000874 120.4600n -0.000788 120.4700n -0.000675 120.4800n -0.000538 120.4900n -0.000379 120.5000n -0.000200 120.5100n -0.000006 120.5200n 0.000200 120.5300n 0.000415 120.5400n 0.000632 120.5500n 0.000850 120.5600n 0.001062 120.5700n 0.001264 120.5800n 0.001453 120.5900n 0.001624
+ 120.6000n 0.001773 120.6100n 0.001898 120.6200n 0.001995 120.6300n 0.002062 120.6400n 0.002098 120.6500n 0.002100 120.6600n 0.002070 120.6700n 0.002007 120.6800n 0.001911 120.6900n 0.001785 120.7000n 0.001629 120.7100n 0.001448 120.7200n 0.001244 120.7300n 0.001020 120.7400n 0.000780
+ 120.7500n 0.000529 120.7600n 0.000271 120.7700n 0.000010 120.7800n -0.000249 120.7900n -0.000501 120.8000n -0.000743 120.8100n -0.000970 120.8200n -0.001179 120.8300n -0.001366 120.8400n -0.001528 120.8500n -0.001664 120.8600n -0.001771 120.8700n -0.001849 120.8800n -0.001897 120.8900n -0.001914
+ 120.9000n -0.001902 120.9100n -0.001861 120.9200n -0.001794 120.9300n -0.001702 120.9400n -0.001589 120.9500n -0.001456 120.9600n -0.001309 120.9700n -0.001149 120.9800n -0.000980 120.9900n -0.000807 121.0000n -0.000632 121.0100n -0.000460 121.0200n -0.000293 121.0300n -0.000135 121.0400n 0.000013
+ 121.0500n 0.000146 121.0600n 0.000264 121.0700n 0.000366 121.0800n 0.000449 121.0900n 0.000515 121.1000n 0.000562 121.1100n 0.000592 121.1200n 0.000604 121.1300n 0.000602 121.1400n 0.000586 121.1500n 0.000558 121.1600n 0.000520 121.1700n 0.000476 121.1800n 0.000427 121.1900n 0.000377
+ 121.2000n 0.000327 121.2100n 0.000281 121.2200n 0.000240 121.2300n 0.000207 121.2400n 0.000184 121.2500n 0.000171 121.2600n 0.000170 121.2700n 0.000182 121.2800n 0.000207 121.2900n 0.000245 121.3000n 0.000295 121.3100n 0.000356 121.3200n 0.000428 121.3300n 0.000507 121.3400n 0.000594
+ 121.3500n 0.000684 121.3600n 0.000776 121.3700n 0.000868 121.3800n 0.000956 121.3900n 0.001038 121.4000n 0.001112 121.4100n 0.001176 121.4200n 0.001227 121.4300n 0.001263 121.4400n 0.001284 121.4500n 0.001287 121.4600n 0.001272 121.4700n 0.001239 121.4800n 0.001187 121.4900n 0.001118
+ 121.5000n 0.001032 121.5100n 0.000931 121.5200n 0.000816 121.5300n 0.000690 121.5400n 0.000554 121.5500n 0.000412 121.5600n 0.000266 121.5700n 0.000120 121.5800n -0.000024 121.5900n -0.000162 121.6000n -0.000293 121.6100n -0.000412 121.6200n -0.000517 121.6300n -0.000606 121.6400n -0.000677
+ 121.6500n -0.000729 121.6600n -0.000759 121.6700n -0.000768 121.6800n -0.000755 121.6900n -0.000719 121.7000n -0.000662 121.7100n -0.000585 121.7200n -0.000488 121.7300n -0.000374 121.7400n -0.000244 121.7500n -0.000101 121.7600n 0.000052 121.7700n 0.000214 121.7800n 0.000380 121.7900n 0.000549
+ 121.8000n 0.000717 121.8100n 0.000881 121.8200n 0.001040 121.8300n 0.001191 121.8400n 0.001331 121.8500n 0.001459 121.8600n 0.001574 121.8700n 0.001674 121.8800n 0.001758 121.8900n 0.001827 121.9000n 0.001880 121.9100n 0.001919 121.9200n 0.001942 121.9300n 0.001952 121.9400n 0.001950
+ 121.9500n 0.001938 121.9600n 0.001917 121.9700n 0.001889 121.9800n 0.001856 121.9900n 0.001820 122.0000n 0.001783 122.0100n 0.001747 122.0200n 0.001712 122.0300n 0.001681 122.0400n 0.001655 122.0500n 0.001634 122.0600n 0.001618 122.0700n 0.001609 122.0800n 0.001606 122.0900n 0.001608
+ 122.1000n 0.001615 122.1100n 0.001625 122.1200n 0.001637 122.1300n 0.001649 122.1400n 0.001660 122.1500n 0.001667 122.1600n 0.001669 122.1700n 0.001663 122.1800n 0.001648 122.1900n 0.001622 122.2000n 0.001582 122.2100n 0.001528 122.2200n 0.001459 122.2300n 0.001372 122.2400n 0.001269
+ 122.2500n 0.001149 122.2600n 0.001011 122.2700n 0.000858 122.2800n 0.000690 122.2900n 0.000509 122.3000n 0.000316 122.3100n 0.000115 122.3200n -0.000093 122.3300n -0.000304 122.3400n -0.000515 122.3500n -0.000724 122.3600n -0.000925 122.3700n -0.001117 122.3800n -0.001296 122.3900n -0.001459
+ 122.4000n -0.001603 122.4100n -0.001726 122.4200n -0.001825 122.4300n -0.001899 122.4400n -0.001946 122.4500n -0.001966 122.4600n -0.001959 122.4700n -0.001925 122.4800n -0.001864 122.4900n -0.001779 122.5000n -0.001672 122.5100n -0.001545 122.5200n -0.001401 122.5300n -0.001243 122.5400n -0.001076
+ 122.5500n -0.000903 122.5600n -0.000728 122.5700n -0.000556 122.5800n -0.000391 122.5900n -0.000237 122.6000n -0.000098 122.6100n 0.000022 122.6200n 0.000120 122.6300n 0.000193 122.6400n 0.000238 122.6500n 0.000255 122.6600n 0.000241 122.6700n 0.000196 122.6800n 0.000120 122.6900n 0.000014
+ 122.7000n -0.000121 122.7100n -0.000283 122.7200n -0.000468 122.7300n -0.000675 122.7400n -0.000898 122.7500n -0.001135 122.7600n -0.001380 122.7700n -0.001629 122.7800n -0.001877 122.7900n -0.002119 122.8000n -0.002350 122.8100n -0.002565 122.8200n -0.002760 122.8300n -0.002931 122.8400n -0.003074
+ 122.8500n -0.003186 122.8600n -0.003263 122.8700n -0.003304 122.8800n -0.003308 122.8900n -0.003273 122.9000n -0.003200 122.9100n -0.003089 122.9200n -0.002942 122.9300n -0.002760 122.9400n -0.002547 122.9500n -0.002305 122.9600n -0.002039 122.9700n -0.001752 122.9800n -0.001449 122.9900n -0.001135
+ 123.0000n -0.000814 123.0100n -0.000493 123.0200n -0.000175 123.0300n 0.000134 123.0400n 0.000430 123.0500n 0.000708 123.0600n 0.000965 123.0700n 0.001196 123.0800n 0.001400 123.0900n 0.001572 123.1000n 0.001713 123.1100n 0.001819 123.1200n 0.001892 123.1300n 0.001930 123.1400n 0.001934
+ 123.1500n 0.001907 123.1600n 0.001849 123.1700n 0.001763 123.1800n 0.001651 123.1900n 0.001518 123.2000n 0.001365 123.2100n 0.001198 123.2200n 0.001019 123.2300n 0.000833 123.2400n 0.000643 123.2500n 0.000454 123.2600n 0.000269 123.2700n 0.000091 123.2800n -0.000077 123.2900n -0.000232
+ 123.3000n -0.000371 123.3100n -0.000493 123.3200n -0.000597 123.3300n -0.000681 123.3400n -0.000745 123.3500n -0.000788 123.3600n -0.000812 123.3700n -0.000818 123.3800n -0.000805 123.3900n -0.000777 123.4000n -0.000735 123.4100n -0.000680 123.4200n -0.000616 123.4300n -0.000545 123.4400n -0.000469
+ 123.4500n -0.000390 123.4600n -0.000311 123.4700n -0.000235 123.4800n -0.000163 123.4900n -0.000098 123.5000n -0.000040 123.5100n 0.000008 123.5200n 0.000046 123.5300n 0.000072 123.5400n 0.000088 123.5500n 0.000091 123.5600n 0.000083 123.5700n 0.000064 123.5800n 0.000035 123.5900n -0.000003
+ 123.6000n -0.000050 123.6100n -0.000103 123.6200n -0.000161 123.6300n -0.000223 123.6400n -0.000287 123.6500n -0.000351 123.6600n -0.000414 123.6700n -0.000475 123.6800n -0.000532 123.6900n -0.000584 123.7000n -0.000630 123.7100n -0.000670 123.7200n -0.000702 123.7300n -0.000728 123.7400n -0.000746
+ 123.7500n -0.000756 123.7600n -0.000760 123.7700n -0.000757 123.7800n -0.000749 123.7900n -0.000737 123.8000n -0.000721 123.8100n -0.000702 123.8200n -0.000683 123.8300n -0.000663 123.8400n -0.000645 123.8500n -0.000628 123.8600n -0.000615 123.8700n -0.000606 123.8800n -0.000602 123.8900n -0.000603
+ 123.9000n -0.000611 123.9100n -0.000624 123.9200n -0.000643 123.9300n -0.000669 123.9400n -0.000700 123.9500n -0.000736 123.9600n -0.000776 123.9700n -0.000819 123.9800n -0.000864 123.9900n -0.000911 124.0000n -0.000957 124.0100n -0.001002 124.0200n -0.001044 124.0300n -0.001082 124.0400n -0.001115
+ 124.0500n -0.001142 124.0600n -0.001161 124.0700n -0.001173 124.0800n -0.001175 124.0900n -0.001169 124.1000n -0.001153 124.1100n -0.001128 124.1200n -0.001093 124.1300n -0.001049 124.1400n -0.000996 124.1500n -0.000936 124.1600n -0.000869 124.1700n -0.000797 124.1800n -0.000719 124.1900n -0.000639
+ 124.2000n -0.000557 124.2100n -0.000475 124.2200n -0.000394 124.2300n -0.000316 124.2400n -0.000242 124.2500n -0.000173 124.2600n -0.000111 124.2700n -0.000057 124.2800n -0.000012 124.2900n 0.000023 124.3000n 0.000048 124.3100n 0.000062 124.3200n 0.000065 124.3300n 0.000057 124.3400n 0.000039
+ 124.3500n 0.000009 124.3600n -0.000030 124.3700n -0.000079 124.3800n -0.000137 124.3900n -0.000202 124.4000n -0.000274 124.4100n -0.000352 124.4200n -0.000434 124.4300n -0.000519 124.4400n -0.000606 124.4500n -0.000693 124.4600n -0.000780 124.4700n -0.000866 124.4800n -0.000950 124.4900n -0.001029
+ 124.5000n -0.001105 124.5100n -0.001175 124.5200n -0.001240 124.5300n -0.001299 124.5400n -0.001351 124.5500n -0.001396 124.5600n -0.001435 124.5700n -0.001466 124.5800n -0.001490 124.5900n -0.001507 124.6000n -0.001517 124.6100n -0.001520 124.6200n -0.001516 124.6300n -0.001507 124.6400n -0.001490
+ 124.6500n -0.001468 124.6600n -0.001441 124.6700n -0.001407 124.6800n -0.001368 124.6900n -0.001324 124.7000n -0.001275 124.7100n -0.001220 124.7200n -0.001161 124.7300n -0.001097 124.7400n -0.001028 124.7500n -0.000954 124.7600n -0.000876 124.7700n -0.000794 124.7800n -0.000707 124.7900n -0.000617
+ 124.8000n -0.000523 124.8100n -0.000426 124.8200n -0.000327 124.8300n -0.000225 124.8400n -0.000123 124.8500n -0.000020 124.8600n 0.000083 124.8700n 0.000185 124.8800n 0.000284 124.8900n 0.000380 124.9000n 0.000471 124.9100n 0.000557 124.9200n 0.000636 124.9300n 0.000707 124.9400n 0.000770
+ 124.9500n 0.000822 124.9600n 0.000864 124.9700n 0.000895 124.9800n 0.000913 124.9900n 0.000919 125.0000n 0.000912 125.0100n 0.000893 125.0200n 0.000860 125.0300n 0.000816 125.0400n 0.000760 125.0500n 0.000694 125.0600n 0.000617 125.0700n 0.000533 125.0800n 0.000441 125.0900n 0.000344
+ 125.1000n 0.000244 125.1100n 0.000142 125.1200n 0.000041 125.1300n -0.000057 125.1400n -0.000151 125.1500n -0.000238 125.1600n -0.000316 125.1700n -0.000384 125.1800n -0.000438 125.1900n -0.000479 125.2000n -0.000504 125.2100n -0.000512 125.2200n -0.000502 125.2300n -0.000475 125.2400n -0.000428
+ 125.2500n -0.000363 125.2600n -0.000280 125.2700n -0.000179 125.2800n -0.000062 125.2900n 0.000071 125.3000n 0.000217 125.3100n 0.000376 125.3200n 0.000544 125.3300n 0.000720 125.3400n 0.000901 125.3500n 0.001084 125.3600n 0.001268 125.3700n 0.001449 125.3800n 0.001625 125.3900n 0.001793
+ 125.4000n 0.001952 125.4100n 0.002098 125.4200n 0.002230 125.4300n 0.002346 125.4400n 0.002445 125.4500n 0.002525 125.4600n 0.002586 125.4700n 0.002627 125.4800n 0.002648 125.4900n 0.002649 125.5000n 0.002631 125.5100n 0.002594 125.5200n 0.002540 125.5300n 0.002471 125.5400n 0.002387
+ 125.5500n 0.002291 125.5600n 0.002185 125.5700n 0.002072 125.5800n 0.001953 125.5900n 0.001831 125.6000n 0.001709 125.6100n 0.001588 125.6200n 0.001472 125.6300n 0.001362 125.6400n 0.001261 125.6500n 0.001169 125.6600n 0.001090 125.6700n 0.001023 125.6800n 0.000969 125.6900n 0.000931
+ 125.7000n 0.000907 125.7100n 0.000897 125.7200n 0.000903 125.7300n 0.000922 125.7400n 0.000954 125.7500n 0.000997 125.7600n 0.001051 125.7700n 0.001114 125.7800n 0.001183 125.7900n 0.001258 125.8000n 0.001335 125.8100n 0.001412 125.8200n 0.001488 125.8300n 0.001560 125.8400n 0.001626
+ 125.8500n 0.001684 125.8600n 0.001733 125.8700n 0.001769 125.8800n 0.001793 125.8900n 0.001802 125.9000n 0.001796 125.9100n 0.001774 125.9200n 0.001735 125.9300n 0.001679 125.9400n 0.001606 125.9500n 0.001516 125.9600n 0.001410 125.9700n 0.001289 125.9800n 0.001154 125.9900n 0.001006
+ 126.0000n 0.000846 126.0100n 0.000677 126.0200n 0.000500 126.0300n 0.000317 126.0400n 0.000130 126.0500n -0.000059 126.0600n -0.000247 126.0700n -0.000433 126.0800n -0.000615 126.0900n -0.000791 126.1000n -0.000958 126.1100n -0.001115 126.1200n -0.001261 126.1300n -0.001394 126.1400n -0.001512
+ 126.1500n -0.001615 126.1600n -0.001701 126.1700n -0.001770 126.1800n -0.001822 126.1900n -0.001855 126.2000n -0.001870 126.2100n -0.001867 126.2200n -0.001847 126.2300n -0.001808 126.2400n -0.001754 126.2500n -0.001683 126.2600n -0.001597 126.2700n -0.001497 126.2800n -0.001384 126.2900n -0.001259
+ 126.3000n -0.001125 126.3100n -0.000981 126.3200n -0.000830 126.3300n -0.000673 126.3400n -0.000512 126.3500n -0.000348 126.3600n -0.000183 126.3700n -0.000018 126.3800n 0.000145 126.3900n 0.000305 126.4000n 0.000461 126.4100n 0.000611 126.4200n 0.000754 126.4300n 0.000888 126.4400n 0.001014
+ 126.4500n 0.001129 126.4600n 0.001234 126.4700n 0.001327 126.4800n 0.001408 126.4900n 0.001476 126.5000n 0.001532 126.5100n 0.001575 126.5200n 0.001604 126.5300n 0.001621 126.5400n 0.001625 126.5500n 0.001617 126.5600n 0.001597 126.5700n 0.001566 126.5800n 0.001525 126.5900n 0.001474
+ 126.6000n 0.001415 126.6100n 0.001348 126.6200n 0.001274 126.6300n 0.001195 126.6400n 0.001112 126.6500n 0.001026 126.6600n 0.000938 126.6700n 0.000849 126.6800n 0.000761 126.6900n 0.000675 126.7000n 0.000593 126.7100n 0.000514 126.7200n 0.000440 126.7300n 0.000372 126.7400n 0.000311
+ 126.7500n 0.000258 126.7600n 0.000213 126.7700n 0.000176 126.7800n 0.000148 126.7900n 0.000130 126.8000n 0.000121 126.8100n 0.000121 126.8200n 0.000131 126.8300n 0.000149 126.8400n 0.000176 126.8500n 0.000211 126.8600n 0.000253 126.8700n 0.000302 126.8800n 0.000358 126.8900n 0.000419
+ 126.9000n 0.000484 126.9100n 0.000554 126.9200n 0.000626 126.9300n 0.000701 126.9400n 0.000776 126.9500n 0.000852 126.9600n 0.000928 126.9700n 0.001002 126.9800n 0.001075 126.9900n 0.001145 127.0000n 0.001211 127.0100n 0.001273 127.0200n 0.001331 127.0300n 0.001384 127.0400n 0.001431
+ 127.0500n 0.001472 127.0600n 0.001507 127.0700n 0.001535 127.0800n 0.001557 127.0900n 0.001571 127.1000n 0.001577 127.1100n 0.001576 127.1200n 0.001568 127.1300n 0.001551 127.1400n 0.001526 127.1500n 0.001492 127.1600n 0.001450 127.1700n 0.001400 127.1800n 0.001341 127.1900n 0.001273
+ 127.2000n 0.001197 127.2100n 0.001112 127.2200n 0.001019 127.2300n 0.000917 127.2400n 0.000807 127.2500n 0.000689 127.2600n 0.000563 127.2700n 0.000430 127.2800n 0.000290 127.2900n 0.000144 127.3000n -0.000007 127.3100n -0.000164 127.3200n -0.000323 127.3300n -0.000486 127.3400n -0.000651
+ 127.3500n -0.000816 127.3600n -0.000980 127.3700n -0.001143 127.3800n -0.001302 127.3900n -0.001457 127.4000n -0.001606 127.4100n -0.001747 127.4200n -0.001880 127.4300n -0.002003 127.4400n -0.002114 127.4500n -0.002213 127.4600n -0.002299 127.4700n -0.002370 127.4800n -0.002427 127.4900n -0.002467
+ 127.5000n -0.002491 127.5100n -0.002499 127.5200n -0.002491 127.5300n -0.002466 127.5400n -0.002426 127.5500n -0.002370 127.5600n -0.002301 127.5700n -0.002217 127.5800n -0.002122 127.5900n -0.002015 127.6000n -0.001900 127.6100n -0.001776 127.6200n -0.001647 127.6300n -0.001513 127.6400n -0.001376
+ 127.6500n -0.001239 127.6600n -0.001104 127.6700n -0.000971 127.6800n -0.000842 127.6900n -0.000720 127.7000n -0.000606 127.7100n -0.000501 127.7200n -0.000406 127.7300n -0.000322 127.7400n -0.000250 127.7500n -0.000191 127.7600n -0.000145 127.7700n -0.000112 127.7800n -0.000092 127.7900n -0.000085
+ 127.8000n -0.000090 127.8100n -0.000107 127.8200n -0.000136 127.8300n -0.000174 127.8400n -0.000223 127.8500n -0.000279 127.8600n -0.000343 127.8700n -0.000413 127.8800n -0.000488 127.8900n -0.000566 127.9000n -0.000648 127.9100n -0.000731 127.9200n -0.000814 127.9300n -0.000898 127.9400n -0.000981
+ 127.9500n -0.001062 127.9600n -0.001141 127.9700n -0.001218 127.9800n -0.001292 127.9900n -0.001362 128.0000n -0.001430 128.0100n -0.001494 128.0200n -0.001555 128.0300n -0.001613 128.0400n -0.001667 128.0500n -0.001719 128.0600n -0.001768 128.0700n -0.001813 128.0800n -0.001856 128.0900n -0.001896
+ 128.1000n -0.001934 128.1100n -0.001968 128.1200n -0.001998 128.1300n -0.002025 128.1400n -0.002047 128.1500n -0.002064 128.1600n -0.002076 128.1700n -0.002081 128.1800n -0.002080 128.1900n -0.002070 128.2000n -0.002051 128.2100n -0.002023 128.2200n -0.001985 128.2300n -0.001935 128.2400n -0.001874
+ 128.2500n -0.001800 128.2600n -0.001713 128.2700n -0.001613 128.2800n -0.001501 128.2900n -0.001376 128.3000n -0.001238 128.3100n -0.001089 128.3200n -0.000928 128.3300n -0.000758 128.3400n -0.000580 128.3500n -0.000395 128.3600n -0.000206 128.3700n -0.000013 128.3800n 0.000180 128.3900n 0.000372
+ 128.4000n 0.000560 128.4100n 0.000742 128.4200n 0.000915 128.4300n 0.001077 128.4400n 0.001226 128.4500n 0.001359 128.4600n 0.001475 128.4700n 0.001572 128.4800n 0.001648 128.4900n 0.001703 128.5000n 0.001735 128.5100n 0.001745 128.5200n 0.001731 128.5300n 0.001695 128.5400n 0.001637
+ 128.5500n 0.001558 128.5600n 0.001459 128.5700n 0.001343 128.5800n 0.001211 128.5900n 0.001066 128.6000n 0.000910 128.6100n 0.000747 128.6200n 0.000580 128.6300n 0.000410 128.6400n 0.000243 128.6500n 0.000079 128.6600n -0.000076 128.6700n -0.000221 128.6800n -0.000353 128.6900n -0.000470
+ 128.7000n -0.000569 128.7100n -0.000648 128.7200n -0.000708 128.7300n -0.000745 128.7400n -0.000761 128.7500n -0.000754 128.7600n -0.000726 128.7700n -0.000677 128.7800n -0.000609 128.7900n -0.000523 128.8000n -0.000420 128.8100n -0.000304 128.8200n -0.000177 128.8300n -0.000041 128.8400n 0.000099
+ 128.8500n 0.000242 128.8600n 0.000385 128.8700n 0.000524 128.8800n 0.000656 128.8900n 0.000779 128.9000n 0.000890 128.9100n 0.000987 128.9200n 0.001068 128.9300n 0.001132 128.9400n 0.001177 128.9500n 0.001203 128.9600n 0.001210 128.9700n 0.001197 128.9800n 0.001165 128.9900n 0.001116
+ 129.0000n 0.001051 129.0100n 0.000971 129.0200n 0.000878 129.0300n 0.000776 129.0400n 0.000667 129.0500n 0.000553 129.0600n 0.000437 129.0700n 0.000323 129.0800n 0.000213 129.0900n 0.000110 129.1000n 0.000016 129.1100n -0.000066 129.1200n -0.000133 129.1300n -0.000185 129.1400n -0.000219
+ 129.1500n -0.000235 129.1600n -0.000232 129.1700n -0.000209 129.1800n -0.000168 129.1900n -0.000107 129.2000n -0.000030 129.2100n 0.000063 129.2200n 0.000171 129.2300n 0.000290 129.2400n 0.000419 129.2500n 0.000554 129.2600n 0.000694 129.2700n 0.000835 129.2800n 0.000974 129.2900n 0.001109
+ 129.3000n 0.001236 129.3100n 0.001352 129.3200n 0.001457 129.3300n 0.001546 129.3400n 0.001619 129.3500n 0.001674 129.3600n 0.001709 129.3700n 0.001724 129.3800n 0.001718 129.3900n 0.001692 129.4000n 0.001646 129.4100n 0.001580 129.4200n 0.001496 129.4300n 0.001396 129.4400n 0.001281
+ 129.4500n 0.001153 129.4600n 0.001016 129.4700n 0.000870 129.4800n 0.000719 129.4900n 0.000565 129.5000n 0.000412 129.5100n 0.000260 129.5200n 0.000114 129.5300n -0.000025 129.5400n -0.000155 129.5500n -0.000275 129.5600n -0.000382 129.5700n -0.000476 129.5800n -0.000556 129.5900n -0.000621
+ 129.6000n -0.000672 129.6100n -0.000708 129.6200n -0.000731 129.6300n -0.000741 129.6400n -0.000739 129.6500n -0.000726 129.6600n -0.000706 129.6700n -0.000678 129.6800n -0.000645 129.6900n -0.000609 129.7000n -0.000572 129.7100n -0.000535 129.7200n -0.000501 129.7300n -0.000472 129.7400n -0.000447
+ 129.7500n -0.000430 129.7600n -0.000420 129.7700n -0.000420 129.7800n -0.000428 129.7900n -0.000446 129.8000n -0.000473 129.8100n -0.000509 129.8200n -0.000553 129.8300n -0.000605 129.8400n -0.000663 129.8500n -0.000727 129.8600n -0.000794 129.8700n -0.000863 129.8800n -0.000932 129.8900n -0.001000
+ 129.9000n -0.001065 129.9100n -0.001126 129.9200n -0.001180 129.9300n -0.001227 129.9400n -0.001266 129.9500n -0.001294 129.9600n -0.001312 129.9700n -0.001318 129.9800n -0.001313 129.9900n -0.001296 130.0000n -0.001268 130.0100n -0.001228 130.0200n -0.001178 130.0300n -0.001119 130.0400n -0.001050
+ 130.0500n -0.000974 130.0600n -0.000892 130.0700n -0.000806 130.0800n -0.000716 130.0900n -0.000624 130.1000n -0.000532 130.1100n -0.000441 130.1200n -0.000352 130.1300n -0.000268 130.1400n -0.000187 130.1500n -0.000113 130.1600n -0.000045 130.1700n 0.000016 130.1800n 0.000071 130.1900n 0.000117
+ 130.2000n 0.000157 130.2100n 0.000190 130.2200n 0.000216 130.2300n 0.000237 130.2400n 0.000252 130.2500n 0.000264 130.2600n 0.000271 130.2700n 0.000277 130.2800n 0.000281 130.2900n 0.000284 130.3000n 0.000287 130.3100n 0.000291 130.3200n 0.000297 130.3300n 0.000304 130.3400n 0.000314
+ 130.3500n 0.000326 130.3600n 0.000340 130.3700n 0.000356 130.3800n 0.000373 130.3900n 0.000391 130.4000n 0.000409 130.4100n 0.000426 130.4200n 0.000440 130.4300n 0.000451 130.4400n 0.000457 130.4500n 0.000458 130.4600n 0.000451 130.4700n 0.000436 130.4800n 0.000412 130.4900n 0.000377
+ 130.5000n 0.000330 130.5100n 0.000272 130.5200n 0.000202 130.5300n 0.000120 130.5400n 0.000025 130.5500n -0.000081 130.5600n -0.000198 130.5700n -0.000325 130.5800n -0.000461 130.5900n -0.000604 130.6000n -0.000752 130.6100n -0.000904 130.6200n -0.001057 130.6300n -0.001210 130.6400n -0.001359
+ 130.6500n -0.001502 130.6600n -0.001637 130.6700n -0.001762 130.6800n -0.001875 130.6900n -0.001973 130.7000n -0.002054 130.7100n -0.002118 130.7200n -0.002163 130.7300n -0.002187 130.7400n -0.002190 130.7500n -0.002172 130.7600n -0.002133 130.7700n -0.002073 130.7800n -0.001994 130.7900n -0.001895
+ 130.8000n -0.001779 130.8100n -0.001648 130.8200n -0.001503 130.8300n -0.001347 130.8400n -0.001181 130.8500n -0.001009 130.8600n -0.000834 130.8700n -0.000657 130.8800n -0.000482 130.8900n -0.000310 130.9000n -0.000145 130.9100n 0.000012 130.9200n 0.000159 130.9300n 0.000293 130.9400n 0.000415
+ 130.9500n 0.000521 130.9600n 0.000613 130.9700n 0.000690 130.9800n 0.000751 130.9900n 0.000797 131.0000n 0.000829 131.0100n 0.000847 131.0200n 0.000854 131.0300n 0.000850 131.0400n 0.000838 131.0500n 0.000819 131.0600n 0.000796 131.0700n 0.000770 131.0800n 0.000744 131.0900n 0.000720
+ 131.1000n 0.000700 131.1100n 0.000685 131.1200n 0.000678 131.1300n 0.000680 131.1400n 0.000692 131.1500n 0.000715 131.1600n 0.000750 131.1700n 0.000796 131.1800n 0.000855 131.1900n 0.000925 131.2000n 0.001007 131.2100n 0.001098 131.2200n 0.001198 131.2300n 0.001306 131.2400n 0.001419
+ 131.2500n 0.001536 131.2600n 0.001655 131.2700n 0.001774 131.2800n 0.001891 131.2900n 0.002003 131.3000n 0.002109 131.3100n 0.002206 131.3200n 0.002293 131.3300n 0.002368 131.3400n 0.002430 131.3500n 0.002478 131.3600n 0.002511 131.3700n 0.002528 131.3800n 0.002529 131.3900n 0.002513
+ 131.4000n 0.002482 131.4100n 0.002435 131.4200n 0.002373 131.4300n 0.002298 131.4400n 0.002210 131.4500n 0.002111 131.4600n 0.002003 131.4700n 0.001886 131.4800n 0.001763 131.4900n 0.001635 131.5000n 0.001505 131.5100n 0.001372 131.5200n 0.001240 131.5300n 0.001109 131.5400n 0.000981
+ 131.5500n 0.000856 131.5600n 0.000735 131.5700n 0.000619 131.5800n 0.000509 131.5900n 0.000405 131.6000n 0.000306 131.6100n 0.000213 131.6200n 0.000126 131.6300n 0.000043 131.6400n -0.000036 131.6500n -0.000111 131.6600n -0.000184 131.6700n -0.000254 131.6800n -0.000323 131.6900n -0.000392
+ 131.7000n -0.000461 131.7100n -0.000530 131.7200n -0.000601 131.7300n -0.000673 131.7400n -0.000747 131.7500n -0.000823 131.7600n -0.000900 131.7700n -0.000979 131.7800n -0.001058 131.7900n -0.001137 131.8000n -0.001215 131.8100n -0.001291 131.8200n -0.001365 131.8300n -0.001434 131.8400n -0.001498
+ 131.8500n -0.001555 131.8600n -0.001605 131.8700n -0.001646 131.8800n -0.001676 131.8900n -0.001696 131.9000n -0.001704 131.9100n -0.001699 131.9200n -0.001681 131.9300n -0.001649 131.9400n -0.001604 131.9500n -0.001546 131.9600n -0.001475 131.9700n -0.001391 131.9800n -0.001296 131.9900n -0.001190
+ 132.0000n -0.001075 132.0100n -0.000951 132.0200n -0.000821 132.0300n -0.000686 132.0400n -0.000547 132.0500n -0.000407 132.0600n -0.000266 132.0700n -0.000127 132.0800n 0.000010 132.0900n 0.000142 132.1000n 0.000268 132.1100n 0.000388 132.1200n 0.000500 132.1300n 0.000603 132.1400n 0.000697
+ 132.1500n 0.000782 132.1600n 0.000857 132.1700n 0.000923 132.1800n 0.000980 132.1900n 0.001028 132.2000n 0.001068 132.2100n 0.001101 132.2200n 0.001127 132.2300n 0.001148 132.2400n 0.001165 132.2500n 0.001177 132.2600n 0.001188 132.2700n 0.001196 132.2800n 0.001204 132.2900n 0.001213
+ 132.3000n 0.001221 132.3100n 0.001231 132.3200n 0.001243 132.3300n 0.001256 132.3400n 0.001270 132.3500n 0.001286 132.3600n 0.001303 132.3700n 0.001321 132.3800n 0.001338 132.3900n 0.001354 132.4000n 0.001369 132.4100n 0.001381 132.4200n 0.001389 132.4300n 0.001393 132.4400n 0.001391
+ 132.4500n 0.001383 132.4600n 0.001368 132.4700n 0.001345 132.4800n 0.001314 132.4900n 0.001275 132.5000n 0.001228 132.5100n 0.001173 132.5200n 0.001111 132.5300n 0.001041 132.5400n 0.000965 132.5500n 0.000884 132.5600n 0.000799 132.5700n 0.000712 132.5800n 0.000624 132.5900n 0.000536
+ 132.6000n 0.000451 132.6100n 0.000369 132.6200n 0.000293 132.6300n 0.000224 132.6400n 0.000164 132.6500n 0.000113 132.6600n 0.000074 132.6700n 0.000046 132.6800n 0.000030 132.6900n 0.000026 132.7000n 0.000035 132.7100n 0.000057 132.7200n 0.000090 132.7300n 0.000133 132.7400n 0.000185
+ 132.7500n 0.000246 132.7600n 0.000312 132.7700n 0.000382 132.7800n 0.000454 132.7900n 0.000525 132.8000n 0.000594 132.8100n 0.000657 132.8200n 0.000712 132.8300n 0.000758 132.8400n 0.000792 132.8500n 0.000812 132.8600n 0.000816 132.8700n 0.000804 132.8800n 0.000775 132.8900n 0.000727
+ 132.9000n 0.000660 132.9100n 0.000576 132.9200n 0.000474 132.9300n 0.000356 132.9400n 0.000223 132.9500n 0.000077 132.9600n -0.000080 132.9700n -0.000245 132.9800n -0.000416 132.9900n -0.000589 133.0000n -0.000762 133.0100n -0.000931 133.0200n -0.001093 133.0300n -0.001245 133.0400n -0.001385
+ 133.0500n -0.001509 133.0600n -0.001615 133.0700n -0.001701 133.0800n -0.001766 133.0900n -0.001807 133.1000n -0.001826 133.1100n -0.001820 133.1200n -0.001791 133.1300n -0.001739 133.1400n -0.001666 133.1500n -0.001573 133.1600n -0.001462 133.1700n -0.001336 133.1800n -0.001199 133.1900n -0.001052
+ 133.2000n -0.000899 133.2100n -0.000745 133.2200n -0.000593 133.2300n -0.000445 133.2400n -0.000306 133.2500n -0.000179 133.2600n -0.000067 133.2700n 0.000027 133.2800n 0.000102 133.2900n 0.000156 133.3000n 0.000186 133.3100n 0.000194 133.3200n 0.000178 133.3300n 0.000139 133.3400n 0.000078
+ 133.3500n -0.000003 133.3600n -0.000103 133.3700n -0.000217 133.3800n -0.000345 133.3900n -0.000481 133.4000n -0.000623 133.4100n -0.000766 133.4200n -0.000906 133.4300n -0.001040 133.4400n -0.001162 133.4500n -0.001270 133.4600n -0.001360 133.4700n -0.001428 133.4800n -0.001472 133.4900n -0.001489
+ 133.5000n -0.001477 133.5100n -0.001436 133.5200n -0.001364 133.5300n -0.001263 133.5400n -0.001131 133.5500n -0.000972 133.5600n -0.000787 133.5700n -0.000579 133.5800n -0.000351 133.5900n -0.000106 133.6000n 0.000150 133.6100n 0.000414 133.6200n 0.000681 133.6300n 0.000946 133.6400n 0.001204
+ 133.6500n 0.001450 133.6600n 0.001680 133.6700n 0.001890 133.6800n 0.002074 133.6900n 0.002231 133.7000n 0.002356 133.7100n 0.002447 133.7200n 0.002503 133.7300n 0.002523 133.7400n 0.002506 133.7500n 0.002453 133.7600n 0.002365 133.7700n 0.002243 133.7800n 0.002091 133.7900n 0.001912
+ 133.8000n 0.001709 133.8100n 0.001487 133.8200n 0.001250 133.8300n 0.001003 133.8400n 0.000751 133.8500n 0.000500 133.8600n 0.000253 133.8700n 0.000017 133.8800n -0.000204 133.8900n -0.000406 133.9000n -0.000584 133.9100n -0.000736 133.9200n -0.000859 133.9300n -0.000951 133.9400n -0.001009
+ 133.9500n -0.001035 133.9600n -0.001027 133.9700n -0.000987 133.9800n -0.000916 133.9900n -0.000817 134.0000n -0.000693 134.0100n -0.000546 134.0200n -0.000381 134.0300n -0.000203 134.0400n -0.000016 134.0500n 0.000175 134.0600n 0.000365 134.0700n 0.000549 134.0800n 0.000722 134.0900n 0.000879
+ 134.1000n 0.001017 134.1100n 0.001130 134.1200n 0.001217 134.1300n 0.001274 134.1400n 0.001298 134.1500n 0.001289 134.1600n 0.001245 134.1700n 0.001168 134.1800n 0.001056 134.1900n 0.000912 134.2000n 0.000739 134.2100n 0.000537 134.2200n 0.000312 134.2300n 0.000067 134.2400n -0.000195
+ 134.2500n -0.000468 134.2600n -0.000747 134.2700n -0.001028 134.2800n -0.001306 134.2900n -0.001576 134.3000n -0.001833 134.3100n -0.002073 134.3200n -0.002291 134.3300n -0.002485 134.3400n -0.002651 134.3500n -0.002786 134.3600n -0.002889 134.3700n -0.002958 134.3800n -0.002993 134.3900n -0.002994
+ 134.4000n -0.002962 134.4100n -0.002897 134.4200n -0.002802 134.4300n -0.002679 134.4400n -0.002531 134.4500n -0.002361 134.4600n -0.002174 134.4700n -0.001972 134.4800n -0.001759 134.4900n -0.001541 134.5000n -0.001320 134.5100n -0.001101 134.5200n -0.000887 134.5300n -0.000682 134.5400n -0.000488
+ 134.5500n -0.000309 134.5600n -0.000146 134.5700n -0.000001 134.5800n 0.000124 134.5900n 0.000229 134.6000n 0.000314 134.6100n 0.000378 134.6200n 0.000423 134.6300n 0.000450 134.6400n 0.000460 134.6500n 0.000455 134.6600n 0.000438 134.6700n 0.000411 134.6800n 0.000375 134.6900n 0.000335
+ 134.7000n 0.000291 134.7100n 0.000247 134.7200n 0.000205 134.7300n 0.000168 134.7400n 0.000136 134.7500n 0.000112 134.7600n 0.000096 134.7700n 0.000090 134.7800n 0.000094 134.7900n 0.000109 134.8000n 0.000133 134.8100n 0.000167 134.8200n 0.000210 134.8300n 0.000260 134.8400n 0.000316
+ 134.8500n 0.000377 134.8600n 0.000440 134.8700n 0.000504 134.8800n 0.000566 134.8900n 0.000626 134.9000n 0.000682 134.9100n 0.000731 134.9200n 0.000773 134.9300n 0.000805 134.9400n 0.000829 134.9500n 0.000842 134.9600n 0.000845 134.9700n 0.000838 134.9800n 0.000822 134.9900n 0.000796
+ 135.0000n 0.000764 135.0100n 0.000724 135.0200n 0.000681 135.0300n 0.000635 135.0400n 0.000588 135.0500n 0.000543 135.0600n 0.000502 135.0700n 0.000467 135.0800n 0.000440 135.0900n 0.000424 135.1000n 0.000419 135.1100n 0.000428 135.1200n 0.000451 135.1300n 0.000489 135.1400n 0.000543
+ 135.1500n 0.000612 135.1600n 0.000697 135.1700n 0.000796 135.1800n 0.000908 135.1900n 0.001032 135.2000n 0.001164 135.2100n 0.001303 135.2200n 0.001446 135.2300n 0.001590 135.2400n 0.001732 135.2500n 0.001868 135.2600n 0.001994 135.2700n 0.002109 135.2800n 0.002208 135.2900n 0.002289
+ 135.3000n 0.002349 135.3100n 0.002385 135.3200n 0.002395 135.3300n 0.002378 135.3400n 0.002333 135.3500n 0.002259 135.3600n 0.002156 135.3700n 0.002025 135.3800n 0.001867 135.3900n 0.001683 135.4000n 0.001476 135.4100n 0.001249 135.4200n 0.001004 135.4300n 0.000744 135.4400n 0.000475
+ 135.4500n 0.000199 135.4600n -0.000079 135.4700n -0.000354 135.4800n -0.000624 135.4900n -0.000882 135.5000n -0.001127 135.5100n -0.001353 135.5200n -0.001558 135.5300n -0.001739 135.5400n -0.001894 135.5500n -0.002019 135.5600n -0.002115 135.5700n -0.002181 135.5800n -0.002216 135.5900n -0.002220
+ 135.6000n -0.002196 135.6100n -0.002144 135.6200n -0.002068 135.6300n -0.001968 135.6400n -0.001850 135.6500n -0.001716 135.6600n -0.001569 135.6700n -0.001415 135.6800n -0.001256 135.6900n -0.001098 135.7000n -0.000944 135.7100n -0.000797 135.7200n -0.000663 135.7300n -0.000543 135.7400n -0.000441
+ 135.7500n -0.000360 135.7600n -0.000301 135.7700n -0.000266 135.7800n -0.000256 135.7900n -0.000270 135.8000n -0.000309 135.8100n -0.000372 135.8200n -0.000457 135.8300n -0.000563 135.8400n -0.000686 135.8500n -0.000824 135.8600n -0.000973 135.8700n -0.001130 135.8800n -0.001291 135.8900n -0.001452
+ 135.9000n -0.001610 135.9100n -0.001760 135.9200n -0.001898 135.9300n -0.002021 135.9400n -0.002126 135.9500n -0.002210 135.9600n -0.002270 135.9700n -0.002305 135.9800n -0.002313 135.9900n -0.002293 136.0000n -0.002244 136.0100n -0.002169 136.0200n -0.002066 136.0300n -0.001938 136.0400n -0.001787
+ 136.0500n -0.001615 136.0600n -0.001426 136.0700n -0.001222 136.0800n -0.001008 136.0900n -0.000788 136.1000n -0.000565 136.1100n -0.000344 136.1200n -0.000129 136.1300n 0.000075 136.1400n 0.000266 136.1500n 0.000438 136.1600n 0.000589 136.1700n 0.000716 136.1800n 0.000816 136.1900n 0.000886
+ 136.2000n 0.000927 136.2100n 0.000936 136.2200n 0.000913 136.2300n 0.000858 136.2400n 0.000773 136.2500n 0.000658 136.2600n 0.000515 136.2700n 0.000348 136.2800n 0.000158 136.2900n -0.000050 136.3000n -0.000275 136.3100n -0.000511 136.3200n -0.000754 136.3300n -0.001001 136.3400n -0.001248
+ 136.3500n -0.001489 136.3600n -0.001722 136.3700n -0.001943 136.3800n -0.002148 136.3900n -0.002333 136.4000n -0.002496 136.4100n -0.002635 136.4200n -0.002748 136.4300n -0.002833 136.4400n -0.002888 136.4500n -0.002915 136.4600n -0.002912 136.4700n -0.002881 136.4800n -0.002822 136.4900n -0.002737
+ 136.5000n -0.002627 136.5100n -0.002496 136.5200n -0.002345 136.5300n -0.002178 136.5400n -0.001997 136.5500n -0.001805 136.5600n -0.001607 136.5700n -0.001405 136.5800n -0.001202 136.5900n -0.001003 136.6000n -0.000809 136.6100n -0.000623 136.6200n -0.000450 136.6300n -0.000289 136.6400n -0.000145
+ 136.6500n -0.000017 136.6600n 0.000091 136.6700n 0.000180 136.6800n 0.000248 136.6900n 0.000296 136.7000n 0.000323 136.7100n 0.000330 136.7200n 0.000318 136.7300n 0.000288 136.7400n 0.000241 136.7500n 0.000178 136.7600n 0.000102 136.7700n 0.000014 136.7800n -0.000083 136.7900n -0.000188
+ 136.8000n -0.000298 136.8100n -0.000411 136.8200n -0.000525 136.8300n -0.000638 136.8400n -0.000749 136.8500n -0.000854 136.8600n -0.000953 136.8700n -0.001044 136.8800n -0.001125 136.8900n -0.001196 136.9000n -0.001255 136.9100n -0.001302 136.9200n -0.001336 136.9300n -0.001356 136.9400n -0.001364
+ 136.9500n -0.001357 136.9600n -0.001338 136.9700n -0.001306 136.9800n -0.001261 136.9900n -0.001204 137.0000n -0.001136 137.0100n -0.001057 137.0200n -0.000969 137.0300n -0.000871 137.0400n -0.000765 137.0500n -0.000652 137.0600n -0.000533 137.0700n -0.000408 137.0800n -0.000278 137.0900n -0.000144
+ 137.1000n -0.000007 137.1100n 0.000133 137.1200n 0.000275 137.1300n 0.000418 137.1400n 0.000561 137.1500n 0.000705 137.1600n 0.000848 137.1700n 0.000991 137.1800n 0.001132 137.1900n 0.001271 137.2000n 0.001407 137.2100n 0.001541 137.2200n 0.001671 137.2300n 0.001798 137.2400n 0.001920
+ 137.2500n 0.002038 137.2600n 0.002150 137.2700n 0.002255 137.2800n 0.002355 137.2900n 0.002446 137.3000n 0.002530 137.3100n 0.002605 137.3200n 0.002671 137.3300n 0.002727 137.3400n 0.002772 137.3500n 0.002805 137.3600n 0.002827 137.3700n 0.002836 137.3800n 0.002832 137.3900n 0.002815
+ 137.4000n 0.002784 137.4100n 0.002739 137.4200n 0.002680 137.4300n 0.002607 137.4400n 0.002519 137.4500n 0.002418 137.4600n 0.002304 137.4700n 0.002177 137.4800n 0.002038 137.4900n 0.001887 137.5000n 0.001727 137.5100n 0.001557 137.5200n 0.001381 137.5300n 0.001198 137.5400n 0.001010
+ 137.5500n 0.000820 137.5600n 0.000628 137.5700n 0.000438 137.5800n 0.000250 137.5900n 0.000066 137.6000n -0.000111 137.6100n -0.000279 137.6200n -0.000437 137.6300n -0.000583 137.6400n -0.000716 137.6500n -0.000833 137.6600n -0.000934 137.6700n -0.001017 137.6800n -0.001081 137.6900n -0.001125
+ 137.7000n -0.001150 137.7100n -0.001154 137.7200n -0.001138 137.7300n -0.001102 137.7400n -0.001046 137.7500n -0.000972 137.7600n -0.000880 137.7700n -0.000772 137.7800n -0.000649 137.7900n -0.000513 137.8000n -0.000366 137.8100n -0.000210 137.8200n -0.000048 137.8300n 0.000119 137.8400n 0.000287
+ 137.8500n 0.000455 137.8600n 0.000619 137.8700n 0.000778 137.8800n 0.000929 137.8900n 0.001069 137.9000n 0.001197 137.9100n 0.001311 137.9200n 0.001409 137.9300n 0.001491 137.9400n 0.001554 137.9500n 0.001598 137.9600n 0.001623 137.9700n 0.001629 137.9800n 0.001616 137.9900n 0.001584
+ 138.0000n 0.001535 138.0100n 0.001470 138.0200n 0.001390 138.0300n 0.001297 138.0400n 0.001194 138.0500n 0.001082 138.0600n 0.000964 138.0700n 0.000842 138.0800n 0.000720 138.0900n 0.000600 138.1000n 0.000483 138.1100n 0.000374 138.1200n 0.000274 138.1300n 0.000185 138.1400n 0.000109
+ 138.1500n 0.000048 138.1600n 0.000003 138.1700n -0.000025 138.1800n -0.000035 138.1900n -0.000027 138.2000n -0.000001 138.2100n 0.000042 138.2200n 0.000102 138.2300n 0.000176 138.2400n 0.000264 138.2500n 0.000363 138.2600n 0.000471 138.2700n 0.000585 138.2800n 0.000703 138.2900n 0.000822
+ 138.3000n 0.000939 138.3100n 0.001050 138.3200n 0.001154 138.3300n 0.001247 138.3400n 0.001326 138.3500n 0.001390 138.3600n 0.001435 138.3700n 0.001461 138.3800n 0.001465 138.3900n 0.001447 138.4000n 0.001406 138.4100n 0.001343 138.4200n 0.001257 138.4300n 0.001149 138.4400n 0.001021
+ 138.4500n 0.000874 138.4600n 0.000711 138.4700n 0.000535 138.4800n 0.000348 138.4900n 0.000154 138.5000n -0.000045 138.5100n -0.000243 138.5200n -0.000438 138.5300n -0.000626 138.5400n -0.000803 138.5500n -0.000965 138.5600n -0.001110 138.5700n -0.001233 138.5800n -0.001332 138.5900n -0.001406
+ 138.6000n -0.001451 138.6100n -0.001466 138.6200n -0.001452 138.6300n -0.001406 138.6400n -0.001330 138.6500n -0.001225 138.6600n -0.001091 138.6700n -0.000931 138.6800n -0.000746 138.6900n -0.000541 138.7000n -0.000319 138.7100n -0.000082 138.7200n 0.000165 138.7300n 0.000418 138.7400n 0.000672
+ 138.7500n 0.000923 138.7600n 0.001167 138.7700n 0.001400 138.7800n 0.001617 138.7900n 0.001816 138.8000n 0.001991 138.8100n 0.002142 138.8200n 0.002264 138.8300n 0.002357 138.8400n 0.002418 138.8500n 0.002447 138.8600n 0.002444 138.8700n 0.002409 138.8800n 0.002343 138.8900n 0.002248
+ 138.9000n 0.002126 138.9100n 0.001980 138.9200n 0.001812 138.9300n 0.001626 138.9400n 0.001426 138.9500n 0.001217 138.9600n 0.001001 138.9700n 0.000784 138.9800n 0.000570 138.9900n 0.000363 139.0000n 0.000166 139.0100n -0.000016 139.0200n -0.000180 139.0300n -0.000323 139.0400n -0.000443
+ 139.0500n -0.000537 139.0600n -0.000604 139.0700n -0.000643 139.0800n -0.000653 139.0900n -0.000636 139.1000n -0.000591 139.1100n -0.000520 139.1200n -0.000424 139.1300n -0.000307 139.1400n -0.000171 139.1500n -0.000018 139.1600n 0.000148 139.1700n 0.000323 139.1800n 0.000504 139.1900n 0.000686
+ 139.2000n 0.000867 139.2100n 0.001043 139.2200n 0.001209 139.2300n 0.001363 139.2400n 0.001502 139.2500n 0.001623 139.2600n 0.001725 139.2700n 0.001805 139.2800n 0.001861 139.2900n 0.001894 139.3000n 0.001903 139.3100n 0.001888 139.3200n 0.001849 139.3300n 0.001788 139.3400n 0.001706
+ 139.3500n 0.001605 139.3600n 0.001487 139.3700n 0.001355 139.3800n 0.001210 139.3900n 0.001056 139.4000n 0.000896 139.4100n 0.000732 139.4200n 0.000566 139.4300n 0.000403 139.4400n 0.000243 139.4500n 0.000090 139.4600n -0.000056 139.4700n -0.000191 139.4800n -0.000316 139.4900n -0.000428
+ 139.5000n -0.000527 139.5100n -0.000614 139.5200n -0.000687 139.5300n -0.000748 139.5400n -0.000797 139.5500n -0.000836 139.5600n -0.000864 139.5700n -0.000885 139.5800n -0.000899 139.5900n -0.000907 139.6000n -0.000912 139.6100n -0.000916 139.6200n -0.000919 139.6300n -0.000923 139.6400n -0.000930
+ 139.6500n -0.000940 139.6600n -0.000955 139.6700n -0.000975 139.6800n -0.001000 139.6900n -0.001031 139.7000n -0.001066 139.7100n -0.001107 139.7200n -0.001151 139.7300n -0.001198 139.7400n -0.001247 139.7500n -0.001296 139.7600n -0.001343 139.7700n -0.001388 139.7800n -0.001428 139.7900n -0.001461
+ 139.8000n -0.001487 139.8100n -0.001502 139.8200n -0.001507 139.8300n -0.001500 139.8400n -0.001481 139.8500n -0.001447 139.8600n -0.001400 139.8700n -0.001339 139.8800n -0.001264 139.8900n -0.001177 139.9000n -0.001078 139.9100n -0.000969 139.9200n -0.000852 139.9300n -0.000727 139.9400n -0.000599
+ 139.9500n -0.000468 139.9600n -0.000338 139.9700n -0.000211 139.9800n -0.000090 139.9900n 0.000023 140.0000n 0.000125 140.0100n 0.000213 140.0200n 0.000286 140.0300n 0.000341 140.0400n 0.000378 140.0500n 0.000393 140.0600n 0.000388 140.0700n 0.000361 140.0800n 0.000312 140.0900n 0.000241
+ 140.1000n 0.000150 140.1100n 0.000040 140.1200n -0.000088 140.1300n -0.000231 140.1400n -0.000387 140.1500n -0.000554 140.1600n -0.000728 140.1700n -0.000907 140.1800n -0.001086 140.1900n -0.001264 140.2000n -0.001435 140.2100n -0.001598 140.2200n -0.001749 140.2300n -0.001886 140.2400n -0.002005
+ 140.2500n -0.002105 140.2600n -0.002183 140.2700n -0.002238 140.2800n -0.002269 140.2900n -0.002276 140.3000n -0.002258 140.3100n -0.002216 140.3200n -0.002150 140.3300n -0.002062 140.3400n -0.001954 140.3500n -0.001827 140.3600n -0.001685 140.3700n -0.001530 140.3800n -0.001364 140.3900n -0.001192
+ 140.4000n -0.001015 140.4100n -0.000839 140.4200n -0.000664 140.4300n -0.000496 140.4400n -0.000336 140.4500n -0.000187 140.4600n -0.000053 140.4700n 0.000066 140.4800n 0.000168 140.4900n 0.000250 140.5000n 0.000313 140.5100n 0.000357 140.5200n 0.000380 140.5300n 0.000384 140.5400n 0.000370
+ 140.5500n 0.000339 140.5600n 0.000293 140.5700n 0.000234 140.5800n 0.000164 140.5900n 0.000087 140.6000n 0.000004 140.6100n -0.000081 140.6200n -0.000165 140.6300n -0.000245 140.6400n -0.000318 140.6500n -0.000383 140.6600n -0.000435 140.6700n -0.000474 140.6800n -0.000496 140.6900n -0.000501
+ 140.7000n -0.000487 140.7100n -0.000453 140.7200n -0.000399 140.7300n -0.000325 140.7400n -0.000231 140.7500n -0.000119 140.7600n 0.000010 140.7700n 0.000155 140.7800n 0.000314 140.7900n 0.000484 140.8000n 0.000662 140.8100n 0.000847 140.8200n 0.001036 140.8300n 0.001224 140.8400n 0.001410
+ 140.8500n 0.001590 140.8600n 0.001761 140.8700n 0.001922 140.8800n 0.002069 140.8900n 0.002200 140.9000n 0.002314 140.9100n 0.002408 140.9200n 0.002482 140.9300n 0.002535 140.9400n 0.002565 140.9500n 0.002574 140.9600n 0.002561 140.9700n 0.002527 140.9800n 0.002473 140.9900n 0.002400
+ 141.0000n 0.002310 141.0100n 0.002204 141.0200n 0.002086 141.0300n 0.001956 141.0400n 0.001818 141.0500n 0.001673 141.0600n 0.001525 141.0700n 0.001375 141.0800n 0.001225 141.0900n 0.001079 141.1000n 0.000938 141.1100n 0.000803 141.1200n 0.000677 141.1300n 0.000561 141.1400n 0.000455
+ 141.1500n 0.000362 141.1600n 0.000280 141.1700n 0.000210 141.1800n 0.000153 141.1900n 0.000107 141.2000n 0.000073 141.2100n 0.000049 141.2200n 0.000034 141.2300n 0.000027 141.2400n 0.000027 141.2500n 0.000032 141.2600n 0.000040 141.2700n 0.000050 141.2800n 0.000061 141.2900n 0.000070
+ 141.3000n 0.000077 141.3100n 0.000079 141.3200n 0.000076 141.3300n 0.000066 141.3400n 0.000049 141.3500n 0.000024 141.3600n -0.000009 141.3700n -0.000051 141.3800n -0.000102 141.3900n -0.000162 141.4000n -0.000229 141.4100n -0.000304 141.4200n -0.000386 141.4300n -0.000472 141.4400n -0.000563
+ 141.4500n -0.000657 141.4600n -0.000752 141.4700n -0.000847 141.4800n -0.000940 141.4900n -0.001030 141.5000n -0.001114 141.5100n -0.001192 141.5200n -0.001261 141.5300n -0.001320 141.5400n -0.001369 141.5500n -0.001404 141.5600n -0.001427 141.5700n -0.001435 141.5800n -0.001428 141.5900n -0.001405
+ 141.6000n -0.001367 141.6100n -0.001314 141.6200n -0.001245 141.6300n -0.001161 141.6400n -0.001062 141.6500n -0.000951 141.6600n -0.000827 141.6700n -0.000693 141.6800n -0.000549 141.6900n -0.000398 141.7000n -0.000241 141.7100n -0.000080 141.7200n 0.000083 141.7300n 0.000245 141.7400n 0.000406
+ 141.7500n 0.000561 141.7600n 0.000710 141.7700n 0.000850 141.7800n 0.000979 141.7900n 0.001096 141.8000n 0.001198 141.8100n 0.001284 141.8200n 0.001353 141.8300n 0.001403 141.8400n 0.001433 141.8500n 0.001443 141.8600n 0.001432 141.8700n 0.001399 141.8800n 0.001346 141.8900n 0.001273
+ 141.9000n 0.001179 141.9100n 0.001067 141.9200n 0.000936 141.9300n 0.000790 141.9400n 0.000629 141.9500n 0.000456 141.9600n 0.000273 141.9700n 0.000081 141.9800n -0.000115 141.9900n -0.000314 142.0000n -0.000513 142.0100n -0.000709 142.0200n -0.000899 142.0300n -0.001081 142.0400n -0.001252
+ 142.0500n -0.001410 142.0600n -0.001551 142.0700n -0.001675 142.0800n -0.001779 142.0900n -0.001862 142.1000n -0.001922 142.1100n -0.001958 142.1200n -0.001971 142.1300n -0.001960 142.1400n -0.001925 142.1500n -0.001866 142.1600n -0.001786 142.1700n -0.001684 142.1800n -0.001564 142.1900n -0.001427
+ 142.2000n -0.001276 142.2100n -0.001113 142.2200n -0.000942 142.2300n -0.000764 142.2400n -0.000585 142.2500n -0.000407 142.2600n -0.000233 142.2700n -0.000066 142.2800n 0.000090 142.2900n 0.000232 142.3000n 0.000357 142.3100n 0.000464 142.3200n 0.000549 142.3300n 0.000612 142.3400n 0.000651
+ 142.3500n 0.000664 142.3600n 0.000652 142.3700n 0.000615 142.3800n 0.000553 142.3900n 0.000467 142.4000n 0.000360 142.4100n 0.000233 142.4200n 0.000088 142.4300n -0.000072 142.4400n -0.000243 142.4500n -0.000421 142.4600n -0.000604 142.4700n -0.000787 142.4800n -0.000966 142.4900n -0.001138
+ 142.5000n -0.001298 142.5100n -0.001442 142.5200n -0.001567 142.5300n -0.001670 142.5400n -0.001748 142.5500n -0.001798 142.5600n -0.001819 142.5700n -0.001808 142.5800n -0.001766 142.5900n -0.001690 142.6000n -0.001583 142.6100n -0.001444 142.6200n -0.001276 142.6300n -0.001079 142.6400n -0.000858
+ 142.6500n -0.000614 142.6600n -0.000351 142.6700n -0.000074 142.6800n 0.000214 142.6900n 0.000507 142.7000n 0.000802 142.7100n 0.001093 142.7200n 0.001376 142.7300n 0.001647 142.7400n 0.001899 142.7500n 0.002130 142.7600n 0.002335 142.7700n 0.002512 142.7800n 0.002656 142.7900n 0.002765
+ 142.8000n 0.002838 142.8100n 0.002874 142.8200n 0.002871 142.8300n 0.002829 142.8400n 0.002750 142.8500n 0.002635 142.8600n 0.002485 142.8700n 0.002303 142.8800n 0.002092 142.8900n 0.001856 142.9000n 0.001598 142.9100n 0.001323 142.9200n 0.001036 142.9300n 0.000740 142.9400n 0.000441
+ 142.9500n 0.000143 142.9600n -0.000149 142.9700n -0.000430 142.9800n -0.000697 142.9900n -0.000945 143.0000n -0.001171 143.0100n -0.001372 143.0200n -0.001545 143.0300n -0.001689 143.0400n -0.001803 143.0500n -0.001885 143.0600n -0.001935 143.0700n -0.001954 143.0800n -0.001943 143.0900n -0.001903
+ 143.1000n -0.001837 143.1100n -0.001746 143.1200n -0.001634 143.1300n -0.001505 143.1400n -0.001361 143.1500n -0.001206 143.1600n -0.001044 143.1700n -0.000879 143.1800n -0.000714 143.1900n -0.000554 143.2000n -0.000401 143.2100n -0.000259 143.2200n -0.000131 143.2300n -0.000019 143.2400n 0.000075
+ 143.2500n 0.000149 143.2600n 0.000202 143.2700n 0.000233 143.2800n 0.000242 143.2900n 0.000230 143.3000n 0.000198 143.3100n 0.000145 143.3200n 0.000075 143.3300n -0.000011 143.3400n -0.000110 143.3500n -0.000221 143.3600n -0.000339 143.3700n -0.000463 143.3800n -0.000588 143.3900n -0.000713
+ 143.4000n -0.000833 143.4100n -0.000947 143.4200n -0.001050 143.4300n -0.001142 143.4400n -0.001219 143.4500n -0.001279 143.4600n -0.001321 143.4700n -0.001344 143.4800n -0.001346 143.4900n -0.001327 143.5000n -0.001287 143.5100n -0.001226 143.5200n -0.001145 143.5300n -0.001044 143.5400n -0.000926
+ 143.5500n -0.000791 143.5600n -0.000641 143.5700n -0.000479 143.5800n -0.000306 143.5900n -0.000126 143.6000n 0.000059 143.6100n 0.000248 143.6200n 0.000436 143.6300n 0.000623 143.6400n 0.000804 143.6500n 0.000979 143.6600n 0.001144 143.6700n 0.001298 143.6800n 0.001439 143.6900n 0.001566
+ 143.7000n 0.001677 143.7100n 0.001772 143.7200n 0.001848 143.7300n 0.001907 143.7400n 0.001946 143.7500n 0.001968 143.7600n 0.001971 143.7700n 0.001956 143.7800n 0.001924 143.7900n 0.001875 143.8000n 0.001811 143.8100n 0.001733 143.8200n 0.001641 143.8300n 0.001537 143.8400n 0.001423
+ 143.8500n 0.001300 143.8600n 0.001170 143.8700n 0.001034 143.8800n 0.000894 143.8900n 0.000751 143.9000n 0.000607 143.9100n 0.000464 143.9200n 0.000323 143.9300n 0.000185 143.9400n 0.000052 143.9500n -0.000075 143.9600n -0.000195 143.9700n -0.000306 143.9800n -0.000407 143.9900n -0.000497
+ 144.0000n -0.000576 144.0100n -0.000643 144.0200n -0.000696 144.0300n -0.000736 144.0400n -0.000762 144.0500n -0.000773 144.0600n -0.000770 144.0700n -0.000753 144.0800n -0.000721 144.0900n -0.000676 144.1000n -0.000618 144.1100n -0.000547 144.1200n -0.000464 144.1300n -0.000371 144.1400n -0.000269
+ 144.1500n -0.000158 144.1600n -0.000042 144.1700n 0.000079 144.1800n 0.000203 144.1900n 0.000327 144.2000n 0.000450 144.2100n 0.000569 144.2200n 0.000682 144.2300n 0.000788 144.2400n 0.000883 144.2500n 0.000967 144.2600n 0.001036 144.2700n 0.001089 144.2800n 0.001125 144.2900n 0.001142
+ 144.3000n 0.001139 144.3100n 0.001115 144.3200n 0.001069 144.3300n 0.001001 144.3400n 0.000911 144.3500n 0.000800 144.3600n 0.000667 144.3700n 0.000515 144.3800n 0.000344 144.3900n 0.000157 144.4000n -0.000045 144.4100n -0.000259 144.4200n -0.000482 144.4300n -0.000713 144.4400n -0.000947
+ 144.4500n -0.001182 144.4600n -0.001414 144.4700n -0.001641 144.4800n -0.001859 144.4900n -0.002065 144.5000n -0.002256 144.5100n -0.002430 144.5200n -0.002584 144.5300n -0.002715 144.5400n -0.002823 144.5500n -0.002906 144.5600n -0.002962 144.5700n -0.002990 144.5800n -0.002992 144.5900n -0.002966
+ 144.6000n -0.002914 144.6100n -0.002836 144.6200n -0.002734 144.6300n -0.002610 144.6400n -0.002465 144.6500n -0.002303 144.6600n -0.002125 144.6700n -0.001935 144.6800n -0.001735 144.6900n -0.001528 144.7000n -0.001318 144.7100n -0.001107 144.7200n -0.000898 144.7300n -0.000694 144.7400n -0.000496
+ 144.7500n -0.000308 144.7600n -0.000131 144.7700n 0.000034 144.7800n 0.000184 144.7900n 0.000321 144.8000n 0.000442 144.8100n 0.000549 144.8200n 0.000641 144.8300n 0.000719 144.8400n 0.000783 144.8500n 0.000836 144.8600n 0.000878 144.8700n 0.000912 144.8800n 0.000938 144.8900n 0.000959
+ 144.9000n 0.000976 144.9100n 0.000991 144.9200n 0.001006 144.9300n 0.001023 144.9400n 0.001042 144.9500n 0.001064 144.9600n 0.001091 144.9700n 0.001123 144.9800n 0.001160 144.9900n 0.001202 145.0000n 0.001248 145.0100n 0.001297 145.0200n 0.001348 145.0300n 0.001400 145.0400n 0.001450
+ 145.0500n 0.001498 145.0600n 0.001539 145.0700n 0.001573 145.0800n 0.001597 145.0900n 0.001608 145.1000n 0.001605 145.1100n 0.001585 145.1200n 0.001546 145.1300n 0.001486 145.1400n 0.001404 145.1500n 0.001300 145.1600n 0.001172 145.1700n 0.001021 145.1800n 0.000846 145.1900n 0.000649
+ 145.2000n 0.000431 145.2100n 0.000194 145.2200n -0.000061 145.2300n -0.000330 145.2400n -0.000610 145.2500n -0.000898 145.2600n -0.001190 145.2700n -0.001483 145.2800n -0.001771 145.2900n -0.002051 145.3000n -0.002320 145.3100n -0.002572 145.3200n -0.002803 145.3300n -0.003011 145.3400n -0.003192
+ 145.3500n -0.003343 145.3600n -0.003461 145.3700n -0.003544 145.3800n -0.003592 145.3900n -0.003603 145.4000n -0.003577 145.4100n -0.003514 145.4200n -0.003416 145.4300n -0.003283 145.4400n -0.003119 145.4500n -0.002925 145.4600n -0.002706 145.4700n -0.002464 145.4800n -0.002203 145.4900n -0.001929
+ 145.5000n -0.001644 145.5100n -0.001354 145.5200n -0.001063 145.5300n -0.000776 145.5400n -0.000497 145.5500n -0.000229 145.5600n 0.000022 145.5700n 0.000254 145.5800n 0.000464 145.5900n 0.000650 145.6000n 0.000809 145.6100n 0.000939 145.6200n 0.001041 145.6300n 0.001113 145.6400n 0.001157
+ 145.6500n 0.001172 145.6600n 0.001161 145.6700n 0.001125 145.6800n 0.001066 145.6900n 0.000987 145.7000n 0.000891 145.7100n 0.000781 145.7200n 0.000660 145.7300n 0.000531 145.7400n 0.000398 145.7500n 0.000265 145.7600n 0.000133 145.7700n 0.000006 145.7800n -0.000113 145.7900n -0.000222
+ 145.8000n -0.000319 145.8100n -0.000403 145.8200n -0.000473 145.8300n -0.000527 145.8400n -0.000567 145.8500n -0.000591 145.8600n -0.000600 145.8700n -0.000596 145.8800n -0.000580 145.8900n -0.000553 145.9000n -0.000517 145.9100n -0.000475 145.9200n -0.000427 145.9300n -0.000377 145.9400n -0.000326
+ 145.9500n -0.000276 145.9600n -0.000229 145.9700n -0.000188 145.9800n -0.000153 145.9900n -0.000125 146.0000n -0.000106 146.0100n -0.000096 146.0200n -0.000096 146.0300n -0.000104 146.0400n -0.000121 146.0500n -0.000146 146.0600n -0.000177 146.0700n -0.000214 146.0800n -0.000254 146.0900n -0.000297
+ 146.1000n -0.000339 146.1100n -0.000380 146.1200n -0.000416 146.1300n -0.000447 146.1400n -0.000470 146.1500n -0.000484 146.1600n -0.000488 146.1700n -0.000479 146.1800n -0.000459 146.1900n -0.000425 146.2000n -0.000378 146.2100n -0.000318 146.2200n -0.000246 146.2300n -0.000163 146.2400n -0.000070
+ 146.2500n 0.000031 146.2600n 0.000139 146.2700n 0.000250 146.2800n 0.000362 146.2900n 0.000474 146.3000n 0.000582 146.3100n 0.000683 146.3200n 0.000776 146.3300n 0.000857 146.3400n 0.000924 146.3500n 0.000976 146.3600n 0.001010 146.3700n 0.001026 146.3800n 0.001022 146.3900n 0.000998
+ 146.4000n 0.000955 146.4100n 0.000892 146.4200n 0.000811 146.4300n 0.000712 146.4400n 0.000599 146.4500n 0.000474 146.4600n 0.000338 146.4700n 0.000196 146.4800n 0.000050 146.4900n -0.000096 146.5000n -0.000239 146.5100n -0.000374 146.5200n -0.000499 146.5300n -0.000610 146.5400n -0.000703
+ 146.5500n -0.000776 146.5600n -0.000827 146.5700n -0.000852 146.5800n -0.000852 146.5900n -0.000823 146.6000n -0.000767 146.6100n -0.000683 146.6200n -0.000571 146.6300n -0.000433 146.6400n -0.000272 146.6500n -0.000089 146.6600n 0.000113 146.6700n 0.000331 146.6800n 0.000560 146.6900n 0.000796
+ 146.7000n 0.001036 146.7100n 0.001274 146.7200n 0.001506 146.7300n 0.001729 146.7400n 0.001936 146.7500n 0.002125 146.7600n 0.002291 146.7700n 0.002432 146.7800n 0.002544 146.7900n 0.002625 146.8000n 0.002673 146.8100n 0.002687 146.8200n 0.002667 146.8300n 0.002613 146.8400n 0.002526
+ 146.8500n 0.002408 146.8600n 0.002260 146.8700n 0.002086 146.8800n 0.001888 146.8900n 0.001672 146.9000n 0.001440 146.9100n 0.001199 146.9200n 0.000951 146.9300n 0.000703 146.9400n 0.000459 146.9500n 0.000224 146.9600n 0.000002 146.9700n -0.000202 146.9800n -0.000383 146.9900n -0.000539
+ 147.0000n -0.000667 147.0100n -0.000764 147.0200n -0.000828 147.0300n -0.000858 147.0400n -0.000854 147.0500n -0.000816 147.0600n -0.000744 147.0700n -0.000642 147.0800n -0.000510 147.0900n -0.000352 147.1000n -0.000170 147.1100n 0.000030 147.1200n 0.000245 147.1300n 0.000471 147.1400n 0.000702
+ 147.1500n 0.000934 147.1600n 0.001161 147.1700n 0.001380 147.1800n 0.001586 147.1900n 0.001774 147.2000n 0.001940 147.2100n 0.002081 147.2200n 0.002194 147.2300n 0.002276 147.2400n 0.002326 147.2500n 0.002342 147.2600n 0.002324 147.2700n 0.002271 147.2800n 0.002184 147.2900n 0.002065
+ 147.3000n 0.001915 147.3100n 0.001738 147.3200n 0.001535 147.3300n 0.001310 147.3400n 0.001067 147.3500n 0.000809 147.3600n 0.000541 147.3700n 0.000268 147.3800n -0.000007 147.3900n -0.000280 147.4000n -0.000545 147.4100n -0.000800 147.4200n -0.001040 147.4300n -0.001262 147.4400n -0.001463
+ 147.4500n -0.001641 147.4600n -0.001794 147.4700n -0.001919 147.4800n -0.002015 147.4900n -0.002083 147.5000n -0.002121 147.5100n -0.002130 147.5200n -0.002110 147.5300n -0.002063 147.5400n -0.001991 147.5500n -0.001894 147.5600n -0.001775 147.5700n -0.001636 147.5800n -0.001480 147.5900n -0.001309
+ 147.6000n -0.001125 147.6100n -0.000931 147.6200n -0.000730 147.6300n -0.000524 147.6400n -0.000314 147.6500n -0.000104 147.6600n 0.000104 147.6700n 0.000311 147.6800n 0.000513 147.6900n 0.000709 147.7000n 0.000900 147.7100n 0.001084 147.7200n 0.001260 147.7300n 0.001428 147.7400n 0.001589
+ 147.7500n 0.001742 147.7600n 0.001888 147.7700n 0.002026 147.7800n 0.002158 147.7900n 0.002282 147.8000n 0.002401 147.8100n 0.002513 147.8200n 0.002620 147.8300n 0.002721 147.8400n 0.002817 147.8500n 0.002908 147.8600n 0.002993 147.8700n 0.003072 147.8800n 0.003144 147.8900n 0.003210
+ 147.9000n 0.003269 147.9100n 0.003319 147.9200n 0.003361 147.9300n 0.003393 147.9400n 0.003415 147.9500n 0.003426 147.9600n 0.003425 147.9700n 0.003411 147.9800n 0.003383 147.9900n 0.003343 148.0000n 0.003288 148.0100n 0.003218 148.0200n 0.003135 148.0300n 0.003037 148.0400n 0.002926
+ 148.0500n 0.002802 148.0600n 0.002665 148.0700n 0.002517 148.0800n 0.002359 148.0900n 0.002193 148.1000n 0.002019 148.1100n 0.001839 148.1200n 0.001656 148.1300n 0.001470 148.1400n 0.001284 148.1500n 0.001099 148.1600n 0.000918 148.1700n 0.000742 148.1800n 0.000572 148.1900n 0.000410
+ 148.2000n 0.000258 148.2100n 0.000117 148.2200n -0.000013 148.2300n -0.000131 148.2400n -0.000235 148.2500n -0.000326 148.2600n -0.000403 148.2700n -0.000467 148.2800n -0.000518 148.2900n -0.000555 148.3000n -0.000581 148.3100n -0.000596 148.3200n -0.000600 148.3300n -0.000596 148.3400n -0.000583
+ 148.3500n -0.000564 148.3600n -0.000539 148.3700n -0.000510 148.3800n -0.000477 148.3900n -0.000443 148.4000n -0.000409 148.4100n -0.000374 148.4200n -0.000341 148.4300n -0.000310 148.4400n -0.000282 148.4500n -0.000257 148.4600n -0.000236 148.4700n -0.000218 148.4800n -0.000204 148.4900n -0.000195
+ 148.5000n -0.000189 148.5100n -0.000186 148.5200n -0.000187 148.5300n -0.000191 148.5400n -0.000197 148.5500n -0.000204 148.5600n -0.000213 148.5700n -0.000223 148.5800n -0.000233 148.5900n -0.000243 148.6000n -0.000252 148.6100n -0.000260 148.6200n -0.000267 148.6300n -0.000272 148.6400n -0.000276
+ 148.6500n -0.000277 148.6600n -0.000277 148.6700n -0.000274 148.6800n -0.000270 148.6900n -0.000264 148.7000n -0.000256 148.7100n -0.000247 148.7200n -0.000236 148.7300n -0.000225 148.7400n -0.000212 148.7500n -0.000199 148.7600n -0.000186 148.7700n -0.000172 148.7800n -0.000157 148.7900n -0.000142
+ 148.8000n -0.000127 148.8100n -0.000112 148.8200n -0.000096 148.8300n -0.000079 148.8400n -0.000061 148.8500n -0.000043 148.8600n -0.000024 148.8700n -0.000003 148.8800n 0.000020 148.8900n 0.000043 148.9000n 0.000069 148.9100n 0.000096 148.9200n 0.000125 148.9300n 0.000156 148.9400n 0.000187
+ 148.9500n 0.000220 148.9600n 0.000254 148.9700n 0.000287 148.9800n 0.000321 148.9900n 0.000353 149.0000n 0.000384 149.0100n 0.000413 149.0200n 0.000438 149.0300n 0.000460 149.0400n 0.000477 149.0500n 0.000489 149.0600n 0.000494 149.0700n 0.000494 149.0800n 0.000486 149.0900n 0.000471
+ 149.1000n 0.000448 149.1100n 0.000417 149.1200n 0.000379 149.1300n 0.000334 149.1400n 0.000282 149.1500n 0.000223 149.1600n 0.000160 149.1700n 0.000092 149.1800n 0.000021 149.1900n -0.000052 149.2000n -0.000125 149.2100n -0.000197 149.2200n -0.000265 149.2300n -0.000329 149.2400n -0.000387
+ 149.2500n -0.000437 149.2600n -0.000478 149.2700n -0.000508 149.2800n -0.000527 149.2900n -0.000533 149.3000n -0.000525 149.3100n -0.000504 149.3200n -0.000468 149.3300n -0.000419 149.3400n -0.000357 149.3500n -0.000283 149.3600n -0.000197 149.3700n -0.000103 149.3800n -0.000000 149.3900n 0.000107
+ 149.4000n 0.000217 149.4100n 0.000328 149.4200n 0.000436 149.4300n 0.000538 149.4400n 0.000632 149.4500n 0.000714 149.4600n 0.000782 149.4700n 0.000832 149.4800n 0.000862 149.4900n 0.000869 149.5000n 0.000853 149.5100n 0.000810 149.5200n 0.000740 149.5300n 0.000642 149.5400n 0.000515
+ 149.5500n 0.000360 149.5600n 0.000178 149.5700n -0.000029 149.5800n -0.000261 149.5900n -0.000515 149.6000n -0.000787 149.6100n -0.001075 149.6200n -0.001374 149.6300n -0.001680 149.6400n -0.001990 149.6500n -0.002297 149.6600n -0.002598 149.6700n -0.002888 149.6800n -0.003162 149.6900n -0.003416
+ 149.7000n -0.003644 149.7100n -0.003843 149.7200n -0.004009 149.7300n -0.004139 149.7400n -0.004230 149.7500n -0.004280 149.7600n -0.004287 149.7700n -0.004251 149.7800n -0.004171 149.7900n -0.004049 149.8000n -0.003885 149.8100n -0.003681 149.8200n -0.003440 149.8300n -0.003165 149.8400n -0.002860
+ 149.8500n -0.002530 149.8600n -0.002179 149.8700n -0.001812 149.8800n -0.001435 149.8900n -0.001054 149.9000n -0.000673 149.9100n -0.000299 149.9200n 0.000062 149.9300n 0.000407 149.9400n 0.000729 149.9500n 0.001024 149.9600n 0.001289 149.9700n 0.001519 149.9800n 0.001712 149.9900n 0.001866
+ 150.0000n 0.001979 150.0100n 0.002051 150.0200n 0.002081 150.0300n 0.002070 150.0400n 0.002020 150.0500n 0.001933 150.0600n 0.001811 150.0700n 0.001658 150.0800n 0.001477 150.0900n 0.001273 150.1000n 0.001051 150.1100n 0.000814 150.1200n 0.000569 150.1300n 0.000320 150.1400n 0.000071
+ 150.1500n -0.000171 150.1600n -0.000403 150.1700n -0.000620 150.1800n -0.000818 150.1900n -0.000995 150.2000n -0.001146 150.2100n -0.001270 150.2200n -0.001364 150.2300n -0.001428 150.2400n -0.001461 150.2500n -0.001464 150.2600n -0.001436 150.2700n -0.001380 150.2800n -0.001297 150.2900n -0.001190
+ 150.3000n -0.001062 150.3100n -0.000916 150.3200n -0.000755 150.3300n -0.000584 150.3400n -0.000406 150.3500n -0.000226 150.3600n -0.000047 150.3700n 0.000125 150.3800n 0.000289 150.3900n 0.000438 150.4000n 0.000572 150.4100n 0.000686 150.4200n 0.000777 150.4300n 0.000845 150.4400n 0.000887
+ 150.4500n 0.000902 150.4600n 0.000890 150.4700n 0.000850 150.4800n 0.000784 150.4900n 0.000692 150.5000n 0.000575 150.5100n 0.000436 150.5200n 0.000277 150.5300n 0.000100 150.5400n -0.000091 150.5500n -0.000294 150.5600n -0.000505 150.5700n -0.000721 150.5800n -0.000938 150.5900n -0.001153
+ 150.6000n -0.001363 150.6100n -0.001564 150.6200n -0.001754 150.6300n -0.001931 150.6400n -0.002090 150.6500n -0.002232 150.6600n -0.002353 150.6700n -0.002453 150.6800n -0.002531 150.6900n -0.002586 150.7000n -0.002619 150.7100n -0.002629 150.7200n -0.002618 150.7300n -0.002585 150.7400n -0.002534
+ 150.7500n -0.002464 150.7600n -0.002378 150.7700n -0.002278 150.7800n -0.002166 150.7900n -0.002044 150.8000n -0.001914 150.8100n -0.001779 150.8200n -0.001641 150.8300n -0.001503 150.8400n -0.001365 150.8500n -0.001231 150.8600n -0.001102 150.8700n -0.000979 150.8800n -0.000864 150.8900n -0.000758
+ 150.9000n -0.000661 150.9100n -0.000576 150.9200n -0.000501 150.9300n -0.000438 150.9400n -0.000385 150.9500n -0.000344 150.9600n -0.000313 150.9700n -0.000293 150.9800n -0.000281 150.9900n -0.000278 151.0000n -0.000283 151.0100n -0.000295 151.0200n -0.000312 151.0300n -0.000334 151.0400n -0.000360
+ 151.0500n -0.000388 151.0600n -0.000418 151.0700n -0.000449 151.0800n -0.000481 151.0900n -0.000512 151.1000n -0.000542 151.1100n -0.000571 151.1200n -0.000598 151.1300n -0.000623 151.1400n -0.000645 151.1500n -0.000666 151.1600n -0.000684 151.1700n -0.000701 151.1800n -0.000715 151.1900n -0.000728
+ 151.2000n -0.000740 151.2100n -0.000751 151.2200n -0.000761 151.2300n -0.000771 151.2400n -0.000781 151.2500n -0.000792 151.2600n -0.000803 151.2700n -0.000815 151.2800n -0.000827 151.2900n -0.000841 151.3000n -0.000856 151.3100n -0.000872 151.3200n -0.000888 151.3300n -0.000905 151.3400n -0.000922
+ 151.3500n -0.000939 151.3600n -0.000955 151.3700n -0.000970 151.3800n -0.000983 151.3900n -0.000994 151.4000n -0.001001 151.4100n -0.001005 151.4200n -0.001004 151.4300n -0.000997 151.4400n -0.000985 151.4500n -0.000966 151.4600n -0.000940 151.4700n -0.000905 151.4800n -0.000863 151.4900n -0.000812
+ 151.5000n -0.000751 151.5100n -0.000682 151.5200n -0.000603 151.5300n -0.000515 151.5400n -0.000418 151.5500n -0.000312 151.5600n -0.000197 151.5700n -0.000076 151.5800n 0.000053 151.5900n 0.000188 151.6000n 0.000328 151.6100n 0.000472 151.6200n 0.000618 151.6300n 0.000766 151.6400n 0.000914
+ 151.6500n 0.001060 151.6600n 0.001202 151.6700n 0.001340 151.6800n 0.001470 151.6900n 0.001593 151.7000n 0.001706 151.7100n 0.001808 151.7200n 0.001896 151.7300n 0.001971 151.7400n 0.002030 151.7500n 0.002073 151.7600n 0.002098 151.7700n 0.002105 151.7800n 0.002094 151.7900n 0.002064
+ 151.8000n 0.002016 151.8100n 0.001948 151.8200n 0.001863 151.8300n 0.001761 151.8400n 0.001643 151.8500n 0.001509 151.8600n 0.001363 151.8700n 0.001205 151.8800n 0.001037 151.8900n 0.000862 151.9000n 0.000682 151.9100n 0.000499 151.9200n 0.000315 151.9300n 0.000134 151.9400n -0.000042
+ 151.9500n -0.000211 151.9600n -0.000369 151.9700n -0.000516 151.9800n -0.000649 151.9900n -0.000765 152.0000n -0.000863 152.0100n -0.000941 152.0200n -0.000999 152.0300n -0.001036 152.0400n -0.001050 152.0500n -0.001042 152.0600n -0.001011 152.0700n -0.000960 152.0800n -0.000887 152.0900n -0.000795
+ 152.1000n -0.000686 152.1100n -0.000560 152.1200n -0.000421 152.1300n -0.000270 152.1400n -0.000110 152.1500n 0.000055 152.1600n 0.000225 152.1700n 0.000394 152.1800n 0.000562 152.1900n 0.000724 152.2000n 0.000879 152.2100n 0.001023 152.2200n 0.001155 152.2300n 0.001272 152.2400n 0.001373
+ 152.2500n 0.001457 152.2600n 0.001522 152.2700n 0.001568 152.2800n 0.001594 152.2900n 0.001601 152.3000n 0.001590 152.3100n 0.001561 152.3200n 0.001515 152.3300n 0.001455 152.3400n 0.001382 152.3500n 0.001298 152.3600n 0.001207 152.3700n 0.001110 152.3800n 0.001010 152.3900n 0.000910
+ 152.4000n 0.000812 152.4100n 0.000720 152.4200n 0.000635 152.4300n 0.000560 152.4400n 0.000498 152.4500n 0.000449 152.4600n 0.000415 152.4700n 0.000397 152.4800n 0.000396 152.4900n 0.000412 152.5000n 0.000444 152.5100n 0.000492 152.5200n 0.000554 152.5300n 0.000630 152.5400n 0.000717
+ 152.5500n 0.000813 152.5600n 0.000916 152.5700n 0.001022 152.5800n 0.001129 152.5900n 0.001233 152.6000n 0.001331 152.6100n 0.001421 152.6200n 0.001499 152.6300n 0.001562 152.6400n 0.001609 152.6500n 0.001635 152.6600n 0.001640 152.6700n 0.001621 152.6800n 0.001578 152.6900n 0.001510
+ 152.7000n 0.001416 152.7100n 0.001298 152.7200n 0.001155 152.7300n 0.000990 152.7400n 0.000803 152.7500n 0.000598 152.7600n 0.000377 152.7700n 0.000143 152.7800n -0.000100 152.7900n -0.000349 152.8000n -0.000600 152.8100n -0.000849 152.8200n -0.001092 152.8300n -0.001325 152.8400n -0.001544
+ 152.8500n -0.001746 152.8600n -0.001926 152.8700n -0.002084 152.8800n -0.002215 152.8900n -0.002317 152.9000n -0.002390 152.9100n -0.002432 152.9200n -0.002443 152.9300n -0.002422 152.9400n -0.002371 152.9500n -0.002291 152.9600n -0.002183 152.9700n -0.002050 152.9800n -0.001895 152.9900n -0.001721
+ 153.0000n -0.001532 153.0100n -0.001330 153.0200n -0.001121 153.0300n -0.000909 153.0400n -0.000697 153.0500n -0.000489 153.0600n -0.000291 153.0700n -0.000105 153.0800n 0.000065 153.0900n 0.000216 153.1000n 0.000345 153.1100n 0.000449 153.1200n 0.000528 153.1300n 0.000580 153.1400n 0.000603
+ 153.1500n 0.000599 153.1600n 0.000568 153.1700n 0.000509 153.1800n 0.000426 153.1900n 0.000321 153.2000n 0.000194 153.2100n 0.000050 153.2200n -0.000108 153.2300n -0.000277 153.2400n -0.000454 153.2500n -0.000634 153.2600n -0.000814 153.2700n -0.000991 153.2800n -0.001160 153.2900n -0.001318
+ 153.3000n -0.001463 153.3100n -0.001591 153.3200n -0.001700 153.3300n -0.001788 153.3400n -0.001854 153.3500n -0.001897 153.3600n -0.001915 153.3700n -0.001909 153.3800n -0.001880 153.3900n -0.001827 153.4000n -0.001754 153.4100n -0.001660 153.4200n -0.001549 153.4300n -0.001423 153.4400n -0.001284
+ 153.4500n -0.001135 153.4600n -0.000980 153.4700n -0.000821 153.4800n -0.000661 153.4900n -0.000503 153.5000n -0.000350 153.5100n -0.000205 153.5200n -0.000069 153.5300n 0.000054 153.5400n 0.000164 153.5500n 0.000259 153.5600n 0.000337 153.5700n 0.000398 153.5800n 0.000442 153.5900n 0.000469
+ 153.6000n 0.000480 153.6100n 0.000474 153.6200n 0.000454 153.6300n 0.000421 153.6400n 0.000375 153.6500n 0.000320 153.6600n 0.000257 153.6700n 0.000187 153.6800n 0.000114 153.6900n 0.000039 153.7000n -0.000037 153.7100n -0.000110 153.7200n -0.000179 153.7300n -0.000244 153.7400n -0.000302
+ 153.7500n -0.000352 153.7600n -0.000393 153.7700n -0.000426 153.7800n -0.000449 153.7900n -0.000462 153.8000n -0.000466 153.8100n -0.000461 153.8200n -0.000447 153.8300n -0.000426 153.8400n -0.000398 153.8500n -0.000365 153.8600n -0.000326 153.8700n -0.000285 153.8800n -0.000241 153.8900n -0.000196
+ 153.9000n -0.000150 153.9100n -0.000106 153.9200n -0.000062 153.9300n -0.000022 153.9400n 0.000017 153.9500n 0.000052 153.9600n 0.000084 153.9700n 0.000113 153.9800n 0.000140 153.9900n 0.000164 154.0000n 0.000187 154.0100n 0.000208 154.0200n 0.000230 154.0300n 0.000252 154.0400n 0.000276
+ 154.0500n 0.000303 154.0600n 0.000333 154.0700n 0.000368 154.0800n 0.000409 154.0900n 0.000455 154.1000n 0.000508 154.1100n 0.000567 154.1200n 0.000634 154.1300n 0.000708 154.1400n 0.000788 154.1500n 0.000875 154.1600n 0.000967 154.1700n 0.001063 154.1800n 0.001163 154.1900n 0.001266
+ 154.2000n 0.001368 154.2100n 0.001471 154.2200n 0.001570 154.2300n 0.001666 154.2400n 0.001755 154.2500n 0.001837 154.2600n 0.001910 154.2700n 0.001973 154.2800n 0.002023 154.2900n 0.002060 154.3000n 0.002083 154.3100n 0.002092 154.3200n 0.002084 154.3300n 0.002062 154.3400n 0.002023
+ 154.3500n 0.001970 154.3600n 0.001901 154.3700n 0.001819 154.3800n 0.001724 154.3900n 0.001618 154.4000n 0.001502 154.4100n 0.001377 154.4200n 0.001246 154.4300n 0.001110 154.4400n 0.000971 154.4500n 0.000831 154.4600n 0.000693 154.4700n 0.000557 154.4800n 0.000425 154.4900n 0.000300
+ 154.5000n 0.000182 154.5100n 0.000073 154.5200n -0.000026 154.5300n -0.000116 154.5400n -0.000194 154.5500n -0.000262 154.5600n -0.000318 154.5700n -0.000363 154.5800n -0.000398 154.5900n -0.000423 154.6000n -0.000439 154.6100n -0.000447 154.6200n -0.000448 154.6300n -0.000442 154.6400n -0.000432
+ 154.6500n -0.000417 154.6600n -0.000399 154.6700n -0.000379 154.6800n -0.000358 154.6900n -0.000336 154.7000n -0.000313 154.7100n -0.000291 154.7200n -0.000269 154.7300n -0.000247 154.7400n -0.000225 154.7500n -0.000202 154.7600n -0.000177 154.7700n -0.000150 154.7800n -0.000119 154.7900n -0.000084
+ 154.8000n -0.000043 154.8100n 0.000005 154.8200n 0.000061 154.8300n 0.000127 154.8400n 0.000203 154.8500n 0.000291 154.8600n 0.000391 154.8700n 0.000504 154.8800n 0.000630 154.8900n 0.000769 154.9000n 0.000921 154.9100n 0.001086 154.9200n 0.001262 154.9300n 0.001448 154.9400n 0.001643
+ 154.9500n 0.001845 154.9600n 0.002052 154.9700n 0.002261 154.9800n 0.002470 154.9900n 0.002675 155.0000n 0.002875 155.0100n 0.003066 155.0200n 0.003244 155.0300n 0.003408 155.0400n 0.003554 155.0500n 0.003680 155.0600n 0.003782 155.0700n 0.003860 155.0800n 0.003910 155.0900n 0.003932
+ 155.1000n 0.003924 155.1100n 0.003886 155.1200n 0.003817 155.1300n 0.003718 155.1400n 0.003589 155.1500n 0.003432 155.1600n 0.003248 155.1700n 0.003040 155.1800n 0.002810 155.1900n 0.002560 155.2000n 0.002294 155.2100n 0.002016 155.2200n 0.001728 155.2300n 0.001435 155.2400n 0.001140
+ 155.2500n 0.000847 155.2600n 0.000561 155.2700n 0.000283 155.2800n 0.000018 155.2900n -0.000231 155.3000n -0.000462 155.3100n -0.000672 155.3200n -0.000859 155.3300n -0.001022 155.3400n -0.001159 155.3500n -0.001271 155.3600n -0.001357 155.3700n -0.001417 155.3800n -0.001452 155.3900n -0.001463
+ 155.4000n -0.001453 155.4100n -0.001423 155.4200n -0.001375 155.4300n -0.001312 155.4400n -0.001236 155.4500n -0.001151 155.4600n -0.001058 155.4700n -0.000962 155.4800n -0.000865 155.4900n -0.000769 155.5000n -0.000677 155.5100n -0.000591 155.5200n -0.000514 155.5300n -0.000446 155.5400n -0.000389
+ 155.5500n -0.000343 155.5600n -0.000310 155.5700n -0.000289 155.5800n -0.000281 155.5900n -0.000284 155.6000n -0.000297 155.6100n -0.000319 155.6200n -0.000349 155.6300n -0.000384 155.6400n -0.000423 155.6500n -0.000464 155.6600n -0.000504 155.6700n -0.000542 155.6800n -0.000574 155.6900n -0.000600
+ 155.7000n -0.000616 155.7100n -0.000622 155.7200n -0.000616 155.7300n -0.000597 155.7400n -0.000565 155.7500n -0.000518 155.7600n -0.000456 155.7700n -0.000381 155.7800n -0.000292 155.7900n -0.000192 155.8000n -0.000080 155.8100n 0.000041 155.8200n 0.000169 155.8300n 0.000303 155.8400n 0.000438
+ 155.8500n 0.000574 155.8600n 0.000707 155.8700n 0.000834 155.8800n 0.000953 155.8900n 0.001062 155.9000n 0.001157 155.9100n 0.001236 155.9200n 0.001298 155.9300n 0.001340 155.9400n 0.001362 155.9500n 0.001361 155.9600n 0.001337 155.9700n 0.001291 155.9800n 0.001221 155.9900n 0.001129
+ 156.0000n 0.001014 156.0100n 0.000880 156.0200n 0.000726 156.0300n 0.000555 156.0400n 0.000369 156.0500n 0.000171 156.0600n -0.000036 156.0700n -0.000250 156.0800n -0.000469 156.0900n -0.000688 156.1000n -0.000904 156.1100n -0.001116 156.1200n -0.001319 156.1300n -0.001512 156.1400n -0.001691
+ 156.1500n -0.001854 156.1600n -0.002000 156.1700n -0.002127 156.1800n -0.002233 156.1900n -0.002317 156.2000n -0.002378 156.2100n -0.002417 156.2200n -0.002433 156.2300n -0.002427 156.2400n -0.002399 156.2500n -0.002350 156.2600n -0.002281 156.2700n -0.002195 156.2800n -0.002092 156.2900n -0.001976
+ 156.3000n -0.001846 156.3100n -0.001707 156.3200n -0.001560 156.3300n -0.001407 156.3400n -0.001251 156.3500n -0.001094 156.3600n -0.000937 156.3700n -0.000783 156.3800n -0.000633 156.3900n -0.000490 156.4000n -0.000353 156.4100n -0.000226 156.4200n -0.000108 156.4300n -0.000001 156.4400n 0.000095
+ 156.4500n 0.000180 156.4600n 0.000253 156.4700n 0.000315 156.4800n 0.000365 156.4900n 0.000405 156.5000n 0.000435 156.5100n 0.000455 156.5200n 0.000466 156.5300n 0.000470 156.5400n 0.000467 156.5500n 0.000457 156.5600n 0.000443 156.5700n 0.000425 156.5800n 0.000404 156.5900n 0.000381
+ 156.6000n 0.000357 156.6100n 0.000333 156.6200n 0.000309 156.6300n 0.000285 156.6400n 0.000264 156.6500n 0.000244 156.6600n 0.000226 156.6700n 0.000211 156.6800n 0.000199 156.6900n 0.000189 156.7000n 0.000182 156.7100n 0.000177 156.7200n 0.000175 156.7300n 0.000174 156.7400n 0.000175
+ 156.7500n 0.000178 156.7600n 0.000181 156.7700n 0.000185 156.7800n 0.000189 156.7900n 0.000193 156.8000n 0.000196 156.8100n 0.000199 156.8200n 0.000199 156.8300n 0.000198 156.8400n 0.000196 156.8500n 0.000190 156.8600n 0.000183 156.8700n 0.000173 156.8800n 0.000160 156.8900n 0.000145
+ 156.9000n 0.000127 156.9100n 0.000107 156.9200n 0.000084 156.9300n 0.000060 156.9400n 0.000034 156.9500n 0.000007 156.9600n -0.000022 156.9700n -0.000050 156.9800n -0.000079 156.9900n -0.000106 157.0000n -0.000133 157.0100n -0.000157 157.0200n -0.000179 157.0300n -0.000198 157.0400n -0.000213
+ 157.0500n -0.000223 157.0600n -0.000229 157.0700n -0.000229 157.0800n -0.000223 157.0900n -0.000211 157.1000n -0.000192 157.1100n -0.000166 157.1200n -0.000133 157.1300n -0.000093 157.1400n -0.000045 157.1500n 0.000009 157.1600n 0.000070 157.1700n 0.000137 157.1800n 0.000209 157.1900n 0.000287
+ 157.2000n 0.000368 157.2100n 0.000452 157.2200n 0.000538 157.2300n 0.000625 157.2400n 0.000711 157.2500n 0.000796 157.2600n 0.000877 157.2700n 0.000954 157.2800n 0.001024 157.2900n 0.001088 157.3000n 0.001142 157.3100n 0.001187 157.3200n 0.001221 157.3300n 0.001242 157.3400n 0.001251
+ 157.3500n 0.001247 157.3600n 0.001228 157.3700n 0.001195 157.3800n 0.001148 157.3900n 0.001088 157.4000n 0.001014 157.4100n 0.000927 157.4200n 0.000829 157.4300n 0.000720 157.4400n 0.000603 157.4500n 0.000479 157.4600n 0.000349 157.4700n 0.000217 157.4800n 0.000083 157.4900n -0.000048
+ 157.5000n -0.000177 157.5100n -0.000299 157.5200n -0.000412 157.5300n -0.000515 157.5400n -0.000605 157.5500n -0.000680 157.5600n -0.000739 157.5700n -0.000780 157.5800n -0.000801 157.5900n -0.000802 157.6000n -0.000782 157.6100n -0.000741 157.6200n -0.000680 157.6300n -0.000598 157.6400n -0.000497
+ 157.6500n -0.000379 157.6600n -0.000244 157.6700n -0.000095 157.6800n 0.000065 157.6900n 0.000234 157.7000n 0.000409 157.7100n 0.000587 157.7200n 0.000764 157.7300n 0.000938 157.7400n 0.001104 157.7500n 0.001259 157.7600n 0.001400 157.7700n 0.001524 157.7800n 0.001628 157.7900n 0.001709
+ 157.8000n 0.001765 157.8100n 0.001794 157.8200n 0.001795 157.8300n 0.001766 157.8400n 0.001706 157.8500n 0.001615 157.8600n 0.001495 157.8700n 0.001344 157.8800n 0.001166 157.8900n 0.000961 157.9000n 0.000732 157.9100n 0.000481 157.9200n 0.000212 157.9300n -0.000073 157.9400n -0.000370
+ 157.9500n -0.000676 157.9600n -0.000986 157.9700n -0.001296 157.9800n -0.001603 157.9900n -0.001903 158.0000n -0.002192 158.0100n -0.002467 158.0200n -0.002724 158.0300n -0.002961 158.0400n -0.003176 158.0500n -0.003365 158.0600n -0.003527 158.0700n -0.003662 158.0800n -0.003767 158.0900n -0.003844
+ 158.1000n -0.003891 158.1100n -0.003910 158.1200n -0.003902 158.1300n -0.003867 158.1400n -0.003809 158.1500n -0.003728 158.1600n -0.003627 158.1700n -0.003509 158.1800n -0.003377 158.1900n -0.003233 158.2000n -0.003080 158.2100n -0.002921 158.2200n -0.002759 158.2300n -0.002596 158.2400n -0.002435
+ 158.2500n -0.002278 158.2600n -0.002127 158.2700n -0.001984 158.2800n -0.001849 158.2900n -0.001724 158.3000n -0.001609 158.3100n -0.001505 158.3200n -0.001411 158.3300n -0.001328 158.3400n -0.001254 158.3500n -0.001188 158.3600n -0.001129 158.3700n -0.001077 158.3800n -0.001028 158.3900n -0.000982
+ 158.4000n -0.000937 158.4100n -0.000891 158.4200n -0.000843 158.4300n -0.000790 158.4400n -0.000732 158.4500n -0.000667 158.4600n -0.000594 158.4700n -0.000513 158.4800n -0.000422 158.4900n -0.000322 158.5000n -0.000213 158.5100n -0.000094 158.5200n 0.000032 158.5300n 0.000166 158.5400n 0.000306
+ 158.5500n 0.000451 158.5600n 0.000599 158.5700n 0.000748 158.5800n 0.000896 158.5900n 0.001041 158.6000n 0.001181 158.6100n 0.001314 158.6200n 0.001437 158.6300n 0.001550 158.6400n 0.001649 158.6500n 0.001733 158.6600n 0.001801 158.6700n 0.001851 158.6800n 0.001883 158.6900n 0.001896
+ 158.7000n 0.001889 158.7100n 0.001863 158.7200n 0.001818 158.7300n 0.001754 158.7400n 0.001672 158.7500n 0.001574 158.7600n 0.001460 158.7700n 0.001334 158.7800n 0.001196 158.7900n 0.001049 158.8000n 0.000895 158.8100n 0.000736 158.8200n 0.000575 158.8300n 0.000414 158.8400n 0.000256
+ 158.8500n 0.000103 158.8600n -0.000044 158.8700n -0.000181 158.8800n -0.000308 158.8900n -0.000422 158.9000n -0.000522 158.9100n -0.000607 158.9200n -0.000676 158.9300n -0.000728 158.9400n -0.000763 158.9500n -0.000782 158.9600n -0.000783 158.9700n -0.000768 158.9800n -0.000738 158.9900n -0.000692
+ 159.0000n -0.000633 159.0100n -0.000562 159.0200n -0.000480 159.0300n -0.000389 159.0400n -0.000291 159.0500n -0.000186 159.0600n -0.000078 159.0700n 0.000032 159.0800n 0.000142 159.0900n 0.000251 159.1000n 0.000357 159.1100n 0.000457 159.1200n 0.000551 159.1300n 0.000637 159.1400n 0.000714
+ 159.1500n 0.000780 159.1600n 0.000834 159.1700n 0.000877 159.1800n 0.000906 159.1900n 0.000921 159.2000n 0.000923 159.2100n 0.000910 159.2200n 0.000883 159.2300n 0.000841 159.2400n 0.000786 159.2500n 0.000716 159.2600n 0.000634 159.2700n 0.000539 159.2800n 0.000432 159.2900n 0.000315
+ 159.3000n 0.000188 159.3100n 0.000052 159.3200n -0.000090 159.3300n -0.000238 159.3400n -0.000391 159.3500n -0.000546 159.3600n -0.000702 159.3700n -0.000857 159.3800n -0.001009 159.3900n -0.001157 159.4000n -0.001299 159.4100n -0.001432 159.4200n -0.001555 159.4300n -0.001666 159.4400n -0.001763
+ 159.4500n -0.001845 159.4600n -0.001910 159.4700n -0.001956 159.4800n -0.001982 159.4900n -0.001988 159.5000n -0.001972 159.5100n -0.001933 159.5200n -0.001872 159.5300n -0.001788 159.5400n -0.001682 159.5500n -0.001553 159.5600n -0.001403 159.5700n -0.001232 159.5800n -0.001044 159.5900n -0.000838
+ 159.6000n -0.000617 159.6100n -0.000384 159.6200n -0.000142 159.6300n 0.000108 159.6400n 0.000362 159.6500n 0.000616 159.6600n 0.000867 159.6700n 0.001113 159.6800n 0.001349 159.6900n 0.001572 159.7000n 0.001780 159.7100n 0.001968 159.7200n 0.002135 159.7300n 0.002277 159.7400n 0.002392
+ 159.7500n 0.002479 159.7600n 0.002536 159.7700n 0.002561 159.7800n 0.002555 159.7900n 0.002517 159.8000n 0.002447 159.8100n 0.002347 159.8200n 0.002218 159.8300n 0.002062 159.8400n 0.001881 159.8500n 0.001678 159.8600n 0.001456 159.8700n 0.001218 159.8800n 0.000970 159.8900n 0.000713
+ 159.9000n 0.000454 159.9100n 0.000195 159.9200n -0.000059 159.9300n -0.000303 159.9400n -0.000534 159.9500n -0.000748 159.9600n -0.000941 159.9700n -0.001110 159.9800n -0.001253 159.9900n -0.001367 160.0000n -0.001450 160.0100n -0.001501 160.0200n -0.001519 160.0300n -0.001505 160.0400n -0.001459
+ 160.0500n -0.001381 160.0600n -0.001274 160.0700n -0.001139 160.0800n -0.000979 160.0900n -0.000798 160.1000n -0.000597 160.1100n -0.000382 160.1200n -0.000156 160.1300n 0.000077 160.1400n 0.000312 160.1500n 0.000546 160.1600n 0.000774 160.1700n 0.000993 160.1800n 0.001198 160.1900n 0.001386
+ 160.2000n 0.001554 160.2100n 0.001699 160.2200n 0.001819 160.2300n 0.001912 160.2400n 0.001977 160.2500n 0.002013 160.2600n 0.002020 160.2700n 0.001998 160.2800n 0.001947 160.2900n 0.001869 160.3000n 0.001766 160.3100n 0.001640 160.3200n 0.001493 160.3300n 0.001327 160.3400n 0.001146
+ 160.3500n 0.000952 160.3600n 0.000750 160.3700n 0.000541 160.3800n 0.000329 160.3900n 0.000117 160.4000n -0.000091 160.4100n -0.000295 160.4200n -0.000490 160.4300n -0.000676 160.4400n -0.000850 160.4500n -0.001012 160.4600n -0.001159 160.4700n -0.001292 160.4800n -0.001410 160.4900n -0.001514
+ 160.5000n -0.001603 160.5100n -0.001680 160.5200n -0.001743 160.5300n -0.001796 160.5400n -0.001839 160.5500n -0.001874 160.5600n -0.001902 160.5700n -0.001926 160.5800n -0.001946 160.5900n -0.001964 160.6000n -0.001982 160.6100n -0.002001 160.6200n -0.002021 160.6300n -0.002044 160.6400n -0.002070
+ 160.6500n -0.002100 160.6600n -0.002133 160.6700n -0.002169 160.6800n -0.002208 160.6900n -0.002248 160.7000n -0.002290 160.7100n -0.002331 160.7200n -0.002370 160.7300n -0.002406 160.7400n -0.002438 160.7500n -0.002463 160.7600n -0.002481 160.7700n -0.002491 160.7800n -0.002490 160.7900n -0.002477
+ 160.8000n -0.002453 160.8100n -0.002416 160.8200n -0.002365 160.8300n -0.002302 160.8400n -0.002225 160.8500n -0.002135 160.8600n -0.002034 160.8700n -0.001922 160.8800n -0.001800 160.8900n -0.001670 160.9000n -0.001534 160.9100n -0.001394 160.9200n -0.001251 160.9300n -0.001108 160.9400n -0.000967
+ 160.9500n -0.000829 160.9600n -0.000698 160.9700n -0.000573 160.9800n -0.000458 160.9900n -0.000353 161.0000n -0.000260 161.0100n -0.000180 161.0200n -0.000112 161.0300n -0.000057 161.0400n -0.000016 161.0500n 0.000013 161.0600n 0.000031 161.0700n 0.000039 161.0800n 0.000037 161.0900n 0.000029
+ 161.1000n 0.000015 161.1100n -0.000003 161.1200n -0.000021 161.1300n -0.000038 161.1400n -0.000051 161.1500n -0.000059 161.1600n -0.000060 161.1700n -0.000051 161.1800n -0.000032 161.1900n 0.000000 161.2000n 0.000046 161.2100n 0.000105 161.2200n 0.000178 161.2300n 0.000265 161.2400n 0.000365
+ 161.2500n 0.000478 161.2600n 0.000602 161.2700n 0.000735 161.2800n 0.000876 161.2900n 0.001022 161.3000n 0.001170 161.3100n 0.001318 161.3200n 0.001463 161.3300n 0.001603 161.3400n 0.001734 161.3500n 0.001853 161.3600n 0.001958 161.3700n 0.002048 161.3800n 0.002119 161.3900n 0.002169
+ 161.4000n 0.002199 161.4100n 0.002206 161.4200n 0.002191 161.4300n 0.002153 161.4400n 0.002093 161.4500n 0.002013 161.4600n 0.001913 161.4700n 0.001796 161.4800n 0.001664 161.4900n 0.001520 161.5000n 0.001366 161.5100n 0.001208 161.5200n 0.001047 161.5300n 0.000887 161.5400n 0.000733
+ 161.5500n 0.000588 161.5600n 0.000455 161.5700n 0.000337 161.5800n 0.000238 161.5900n 0.000159 161.6000n 0.000104 161.6100n 0.000074 161.6200n 0.000070 161.6300n 0.000092 161.6400n 0.000141 161.6500n 0.000216 161.6600n 0.000316 161.6700n 0.000439 161.6800n 0.000583 161.6900n 0.000746
+ 161.7000n 0.000924 161.7100n 0.001114 161.7200n 0.001311 161.7300n 0.001513 161.7400n 0.001715 161.7500n 0.001912 161.7600n 0.002101 161.7700n 0.002277 161.7800n 0.002438 161.7900n 0.002578 161.8000n 0.002696 161.8100n 0.002788 161.8200n 0.002852 161.8300n 0.002886 161.8400n 0.002890
+ 161.8500n 0.002863 161.8600n 0.002805 161.8700n 0.002717 161.8800n 0.002600 161.8900n 0.002455 161.9000n 0.002286 161.9100n 0.002094 161.9200n 0.001883 161.9300n 0.001657 161.9400n 0.001419 161.9500n 0.001174 161.9600n 0.000924 161.9700n 0.000675 161.9800n 0.000430 161.9900n 0.000192
+ 162.0000n -0.000034 162.0100n -0.000246 162.0200n -0.000440 162.0300n -0.000615 162.0400n -0.000768 162.0500n -0.000899 162.0600n -0.001005 162.0700n -0.001088 162.0800n -0.001147 162.0900n -0.001182 162.1000n -0.001196 162.1100n -0.001189 162.1200n -0.001164 162.1300n -0.001122 162.1400n -0.001067
+ 162.1500n -0.001002 162.1600n -0.000928 162.1700n -0.000849 162.1800n -0.000769 162.1900n -0.000689 162.2000n -0.000612 162.2100n -0.000541 162.2200n -0.000478 162.2300n -0.000424 162.2400n -0.000382 162.2500n -0.000351 162.2600n -0.000333 162.2700n -0.000327 162.2800n -0.000333 162.2900n -0.000351
+ 162.3000n -0.000379 162.3100n -0.000416 162.3200n -0.000460 162.3300n -0.000509 162.3400n -0.000561 162.3500n -0.000614 162.3600n -0.000665 162.3700n -0.000712 162.3800n -0.000753 162.3900n -0.000785 162.4000n -0.000807 162.4100n -0.000817 162.4200n -0.000813 162.4300n -0.000796 162.4400n -0.000763
+ 162.4500n -0.000716 162.4600n -0.000654 162.4700n -0.000577 162.4800n -0.000488 162.4900n -0.000387 162.5000n -0.000276 162.5100n -0.000157 162.5200n -0.000033 162.5300n 0.000094 162.5400n 0.000221 162.5500n 0.000346 162.5600n 0.000466 162.5700n 0.000578 162.5800n 0.000679 162.5900n 0.000768
+ 162.6000n 0.000843 162.6100n 0.000901 162.6200n 0.000941 162.6300n 0.000963 162.6400n 0.000966 162.6500n 0.000951 162.6600n 0.000916 162.6700n 0.000865 162.6800n 0.000797 162.6900n 0.000715 162.7000n 0.000620 162.7100n 0.000517 162.7200n 0.000406 162.7300n 0.000291 162.7400n 0.000176
+ 162.7500n 0.000063 162.7600n -0.000045 162.7700n -0.000143 162.7800n -0.000231 162.7900n -0.000304 162.8000n -0.000360 162.8100n -0.000398 162.8200n -0.000416 162.8300n -0.000412 162.8400n -0.000386 162.8500n -0.000339 162.8600n -0.000269 162.8700n -0.000179 162.8800n -0.000069 162.8900n 0.000058
+ 162.9000n 0.000201 162.9100n 0.000356 162.9200n 0.000521 162.9300n 0.000693 162.9400n 0.000867 162.9500n 0.001041 162.9600n 0.001211 162.9700n 0.001373 162.9800n 0.001525 162.9900n 0.001662 163.0000n 0.001783 163.0100n 0.001885 163.0200n 0.001965 163.0300n 0.002023 163.0400n 0.002057
+ 163.0500n 0.002066 163.0600n 0.002052 163.0700n 0.002013 163.0800n 0.001952 163.0900n 0.001869 163.1000n 0.001768 163.1100n 0.001650 163.1200n 0.001518 163.1300n 0.001375 163.1400n 0.001225 163.1500n 0.001071 163.1600n 0.000917 163.1700n 0.000765 163.1800n 0.000620 163.1900n 0.000485
+ 163.2000n 0.000361 163.2100n 0.000253 163.2200n 0.000162 163.2300n 0.000090 163.2400n 0.000038 163.2500n 0.000006 163.2600n -0.000005 163.2700n 0.000005 163.2800n 0.000034 163.2900n 0.000081 163.3000n 0.000143 163.3100n 0.000220 163.3200n 0.000307 163.3300n 0.000402 163.3400n 0.000501
+ 163.3500n 0.000602 163.3600n 0.000700 163.3700n 0.000792 163.3800n 0.000875 163.3900n 0.000946 163.4000n 0.001001 163.4100n 0.001039 163.4200n 0.001057 163.4300n 0.001053 163.4400n 0.001026 163.4500n 0.000976 163.4600n 0.000904 163.4700n 0.000808 163.4800n 0.000691 163.4900n 0.000554
+ 163.5000n 0.000399 163.5100n 0.000230 163.5200n 0.000048 163.5300n -0.000142 163.5400n -0.000337 163.5500n -0.000532 163.5600n -0.000725 163.5700n -0.000911 163.5800n -0.001086 163.5900n -0.001247 163.6000n -0.001390 163.6100n -0.001513 163.6200n -0.001612 163.6300n -0.001686 163.6400n -0.001734
+ 163.6500n -0.001754 163.6600n -0.001745 163.6700n -0.001710 163.6800n -0.001647 163.6900n -0.001560 163.7000n -0.001450 163.7100n -0.001319 163.7200n -0.001172 163.7300n -0.001012 163.7400n -0.000842 163.7500n -0.000666 163.7600n -0.000491 163.7700n -0.000318 163.7800n -0.000154 163.7900n -0.000002
+ 163.8000n 0.000135 163.8100n 0.000251 163.8200n 0.000344 163.8300n 0.000412 163.8400n 0.000452 163.8500n 0.000462 163.8600n 0.000443 163.8700n 0.000392 163.8800n 0.000312 163.8900n 0.000203 163.9000n 0.000067 163.9100n -0.000093 163.9200n -0.000275 163.9300n -0.000475 163.9400n -0.000688
+ 163.9500n -0.000910 163.9600n -0.001137 163.9700n -0.001363 163.9800n -0.001584 163.9900n -0.001795 164.0000n -0.001990 164.0100n -0.002166 164.0200n -0.002318 164.0300n -0.002442 164.0400n -0.002536 164.0500n -0.002595 164.0600n -0.002619 164.0700n -0.002606 164.0800n -0.002555 164.0900n -0.002466
+ 164.1000n -0.002341 164.1100n -0.002180 164.1200n -0.001986 164.1300n -0.001761 164.1400n -0.001510 164.1500n -0.001235 164.1600n -0.000942 164.1700n -0.000635 164.1800n -0.000319 164.1900n 0.000002 164.2000n 0.000320 164.2100n 0.000633 164.2200n 0.000934 164.2300n 0.001220 164.2400n 0.001485
+ 164.2500n 0.001726 164.2600n 0.001940 164.2700n 0.002123 164.2800n 0.002274 164.2900n 0.002391 164.3000n 0.002473 164.3100n 0.002520 164.3200n 0.002532 164.3300n 0.002510 164.3400n 0.002457 164.3500n 0.002374 164.3600n 0.002264 164.3700n 0.002131 164.3800n 0.001978 164.3900n 0.001809
+ 164.4000n 0.001629 164.4100n 0.001440 164.4200n 0.001248 164.4300n 0.001056 164.4400n 0.000870 164.4500n 0.000691 164.4600n 0.000524 164.4700n 0.000372 164.4800n 0.000237 164.4900n 0.000121 164.5000n 0.000027 164.5100n -0.000046 164.5200n -0.000096 164.5300n -0.000124 164.5400n -0.000129
+ 164.5500n -0.000115 164.5600n -0.000081 164.5700n -0.000029 164.5800n 0.000037 164.5900n 0.000115 164.6000n 0.000202 164.6100n 0.000296 164.6200n 0.000393 164.6300n 0.000490 164.6400n 0.000584 164.6500n 0.000672 164.6600n 0.000751 164.6700n 0.000819 164.6800n 0.000873 164.6900n 0.000912
+ 164.7000n 0.000934 164.7100n 0.000938 164.7200n 0.000923 164.7300n 0.000890 164.7400n 0.000838 164.7500n 0.000769 164.7600n 0.000682 164.7700n 0.000580 164.7800n 0.000464 164.7900n 0.000336 164.8000n 0.000198 164.8100n 0.000052 164.8200n -0.000098 164.8300n -0.000251 164.8400n -0.000404
+ 164.8500n -0.000555 164.8600n -0.000701 164.8700n -0.000841 164.8800n -0.000973 164.8900n -0.001094 164.9000n -0.001204 164.9100n -0.001301 164.9200n -0.001386 164.9300n -0.001456 164.9400n -0.001514 164.9500n -0.001557 164.9600n -0.001588 164.9700n -0.001607 164.9800n -0.001616 164.9900n -0.001614
+ 165.0000n -0.001604 165.0100n -0.001587 165.0200n -0.001565 165.0300n -0.001540 165.0400n -0.001513 165.0500n -0.001485 165.0600n -0.001459 165.0700n -0.001435 165.0800n -0.001415 165.0900n -0.001399 165.1000n -0.001388 165.1100n -0.001383 165.1200n -0.001384 165.1300n -0.001391 165.1400n -0.001403
+ 165.1500n -0.001421 165.1600n -0.001443 165.1700n -0.001468 165.1800n -0.001495 165.1900n -0.001524 165.2000n -0.001552 165.2100n -0.001578 165.2200n -0.001601 165.2300n -0.001620 165.2400n -0.001633 165.2500n -0.001638 165.2600n -0.001636 165.2700n -0.001624 165.2800n -0.001602 165.2900n -0.001570
+ 165.3000n -0.001527 165.3100n -0.001473 165.3200n -0.001409 165.3300n -0.001334 165.3400n -0.001250 165.3500n -0.001158 165.3600n -0.001058 165.3700n -0.000952 165.3800n -0.000841 165.3900n -0.000728 165.4000n -0.000613 165.4100n -0.000499 165.4200n -0.000387 165.4300n -0.000279 165.4400n -0.000177
+ 165.4500n -0.000081 165.4600n 0.000005 165.4700n 0.000082 165.4800n 0.000149 165.4900n 0.000204 165.5000n 0.000246 165.5100n 0.000277 165.5200n 0.000295 165.5300n 0.000301 165.5400n 0.000295 165.5500n 0.000279 165.5600n 0.000253 165.5700n 0.000219 165.5800n 0.000178 165.5900n 0.000131
+ 165.6000n 0.000081 165.6100n 0.000029 165.6200n -0.000023 165.6300n -0.000074 165.6400n -0.000121 165.6500n -0.000162 165.6600n -0.000196 165.6700n -0.000221 165.6800n -0.000237 165.6900n -0.000241 165.7000n -0.000234 165.7100n -0.000214 165.7200n -0.000180 165.7300n -0.000134 165.7400n -0.000074
+ 165.7500n -0.000001 165.7600n 0.000083 165.7700n 0.000179 165.7800n 0.000285 165.7900n 0.000400 165.8000n 0.000522 165.8100n 0.000650 165.8200n 0.000782 165.8300n 0.000916 165.8400n 0.001051 165.8500n 0.001183 165.8600n 0.001313 165.8700n 0.001437 165.8800n 0.001554 165.8900n 0.001662
+ 165.9000n 0.001760 165.9100n 0.001847 165.9200n 0.001922 165.9300n 0.001983 165.9400n 0.002030 165.9500n 0.002062 165.9600n 0.002080 165.9700n 0.002083 165.9800n 0.002070 165.9900n 0.002044 166.0000n 0.002004 166.0100n 0.001951 166.0200n 0.001885 166.0300n 0.001808 166.0400n 0.001722
+ 166.0500n 0.001626 166.0600n 0.001523 166.0700n 0.001414 166.0800n 0.001300 166.0900n 0.001182 166.1000n 0.001062 166.1100n 0.000941 166.1200n 0.000820 166.1300n 0.000700 166.1400n 0.000582 166.1500n 0.000468 166.1600n 0.000357 166.1700n 0.000251 166.1800n 0.000150 166.1900n 0.000055
+ 166.2000n -0.000034 166.2100n -0.000117 166.2200n -0.000193 166.2300n -0.000264 166.2400n -0.000327 166.2500n -0.000385 166.2600n -0.000436 166.2700n -0.000481 166.2800n -0.000520 166.2900n -0.000553 166.3000n -0.000581 166.3100n -0.000603 166.3200n -0.000620 166.3300n -0.000632 166.3400n -0.000640
+ 166.3500n -0.000642 166.3600n -0.000640 166.3700n -0.000632 166.3800n -0.000620 166.3900n -0.000603 166.4000n -0.000582 166.4100n -0.000555 166.4200n -0.000523 166.4300n -0.000486 166.4400n -0.000443 166.4500n -0.000395 166.4600n -0.000341 166.4700n -0.000282 166.4800n -0.000218 166.4900n -0.000147
+ 166.5000n -0.000072 166.5100n 0.000009 166.5200n 0.000095 166.5300n 0.000186 166.5400n 0.000281 166.5500n 0.000381 166.5600n 0.000483 166.5700n 0.000588 166.5800n 0.000696 166.5900n 0.000805 166.6000n 0.000914 166.6100n 0.001024 166.6200n 0.001132 166.6300n 0.001238 166.6400n 0.001341
+ 166.6500n 0.001440 166.6600n 0.001535 166.6700n 0.001623 166.6800n 0.001705 166.6900n 0.001779 166.7000n 0.001844 166.7100n 0.001901 166.7200n 0.001948 166.7300n 0.001984 166.7400n 0.002009 166.7500n 0.002023 166.7600n 0.002025 166.7700n 0.002016 166.7800n 0.001995 166.7900n 0.001962
+ 166.8000n 0.001918 166.8100n 0.001863 166.8200n 0.001797 166.8300n 0.001721 166.8400n 0.001636 166.8500n 0.001542 166.8600n 0.001441 166.8700n 0.001333 166.8800n 0.001219 166.8900n 0.001101 166.9000n 0.000980 166.9100n 0.000857 166.9200n 0.000733 166.9300n 0.000609 166.9400n 0.000486
+ 166.9500n 0.000366 166.9600n 0.000249 166.9700n 0.000137 166.9800n 0.000030 166.9900n -0.000070 167.0000n -0.000163 167.0100n -0.000250 167.0200n -0.000328 167.0300n -0.000398 167.0400n -0.000460 167.0500n -0.000513 167.0600n -0.000559 167.0700n -0.000597 167.0800n -0.000628 167.0900n -0.000652
+ 167.1000n -0.000671 167.1100n -0.000684 167.1200n -0.000694 167.1300n -0.000700 167.1400n -0.000705 167.1500n -0.000710 167.1600n -0.000714 167.1700n -0.000721 167.1800n -0.000730 167.1900n -0.000743 167.2000n -0.000761 167.2100n -0.000784 167.2200n -0.000815 167.2300n -0.000852 167.2400n -0.000898
+ 167.2500n -0.000951 167.2600n -0.001012 167.2700n -0.001082 167.2800n -0.001160 167.2900n -0.001244 167.3000n -0.001336 167.3100n -0.001433 167.3200n -0.001535 167.3300n -0.001640 167.3400n -0.001747 167.3500n -0.001855 167.3600n -0.001961 167.3700n -0.002064 167.3800n -0.002162 167.3900n -0.002253
+ 167.4000n -0.002336 167.4100n -0.002408 167.4200n -0.002467 167.4300n -0.002513 167.4400n -0.002543 167.4500n -0.002556 167.4600n -0.002551 167.4700n -0.002528 167.4800n -0.002484 167.4900n -0.002420 167.5000n -0.002336 167.5100n -0.002232 167.5200n -0.002108 167.5300n -0.001966 167.5400n -0.001805
+ 167.5500n -0.001628 167.5600n -0.001436 167.5700n -0.001230 167.5800n -0.001014 167.5900n -0.000788 167.6000n -0.000556 167.6100n -0.000320 167.6200n -0.000083 167.6300n 0.000153 167.6400n 0.000386 167.6500n 0.000611 167.6600n 0.000828 167.6700n 0.001034 167.6800n 0.001226 167.6900n 0.001402
+ 167.7000n 0.001562 167.7100n 0.001702 167.7200n 0.001822 167.7300n 0.001922 167.7400n 0.001999 167.7500n 0.002055 167.7600n 0.002089 167.7700n 0.002102 167.7800n 0.002094 167.7900n 0.002066 167.8000n 0.002019 167.8100n 0.001955 167.8200n 0.001876 167.8300n 0.001784 167.8400n 0.001679
+ 167.8500n 0.001566 167.8600n 0.001445 167.8700n 0.001319 167.8800n 0.001191 167.8900n 0.001062 167.9000n 0.000935 167.9100n 0.000811 167.9200n 0.000693 167.9300n 0.000582 167.9400n 0.000479 167.9500n 0.000386 167.9600n 0.000304 167.9700n 0.000232 167.9800n 0.000173 167.9900n 0.000126
+ 168.0000n 0.000090 168.0100n 0.000066 168.0200n 0.000053 168.0300n 0.000051 168.0400n 0.000058 168.0500n 0.000074 168.0600n 0.000097 168.0700n 0.000126 168.0800n 0.000160 168.0900n 0.000197 168.1000n 0.000236 168.1100n 0.000276 168.1200n 0.000315 168.1300n 0.000352 168.1400n 0.000386
+ 168.1500n 0.000417 168.1600n 0.000442 168.1700n 0.000462 168.1800n 0.000476 168.1900n 0.000483 168.2000n 0.000483 168.2100n 0.000476 168.2200n 0.000462 168.2300n 0.000442 168.2400n 0.000415 168.2500n 0.000382 168.2600n 0.000343 168.2700n 0.000299 168.2800n 0.000250 168.2900n 0.000198
+ 168.3000n 0.000142 168.3100n 0.000084 168.3200n 0.000023 168.3300n -0.000039 168.3400n -0.000102 168.3500n -0.000166 168.3600n -0.000230 168.3700n -0.000294 168.3800n -0.000358 168.3900n -0.000421 168.4000n -0.000484 168.4100n -0.000546 168.4200n -0.000607 168.4300n -0.000668 168.4400n -0.000728
+ 168.4500n -0.000787 168.4600n -0.000847 168.4700n -0.000905 168.4800n -0.000963 168.4900n -0.001021 168.5000n -0.001078 168.5100n -0.001135 168.5200n -0.001190 168.5300n -0.001244 168.5400n -0.001297 168.5500n -0.001347 168.5600n -0.001394 168.5700n -0.001438 168.5800n -0.001478 168.5900n -0.001513
+ 168.6000n -0.001543 168.6100n -0.001567 168.6200n -0.001583 168.6300n -0.001592 168.6400n -0.001593 168.6500n -0.001584 168.6600n -0.001566 168.6700n -0.001539 168.6800n -0.001501 168.6900n -0.001454 168.7000n -0.001396 168.7100n -0.001329 168.7200n -0.001253 168.7300n -0.001168 168.7400n -0.001075
+ 168.7500n -0.000976 168.7600n -0.000871 168.7700n -0.000761 168.7800n -0.000649 168.7900n -0.000535 168.8000n -0.000421 168.8100n -0.000310 168.8200n -0.000202 168.8300n -0.000100 168.8400n -0.000005 168.8500n 0.000082 168.8600n 0.000157 168.8700n 0.000222 168.8800n 0.000273 168.8900n 0.000310
+ 168.9000n 0.000332 168.9100n 0.000338 168.9200n 0.000328 168.9300n 0.000301 168.9400n 0.000259 168.9500n 0.000200 168.9600n 0.000126 168.9700n 0.000037 168.9800n -0.000066 168.9900n -0.000181 169.0000n -0.000307 169.0100n -0.000443 169.0200n -0.000587 169.0300n -0.000737 169.0400n -0.000890
+ 169.0500n -0.001047 169.0600n -0.001204 169.0700n -0.001359 169.0800n -0.001511 169.0900n -0.001658 169.1000n -0.001799 169.1100n -0.001932 169.1200n -0.002056 169.1300n -0.002169 169.1400n -0.002271 169.1500n -0.002361 169.1600n -0.002438 169.1700n -0.002502 169.1800n -0.002553 169.1900n -0.002590
+ 169.2000n -0.002614 169.2100n -0.002626 169.2200n -0.002624 169.2300n -0.002611 169.2400n -0.002586 169.2500n -0.002550 169.2600n -0.002504 169.2700n -0.002448 169.2800n -0.002383 169.2900n -0.002309 169.3000n -0.002228 169.3100n -0.002139 169.3200n -0.002043 169.3300n -0.001941 169.3400n -0.001832
+ 169.3500n -0.001717 169.3600n -0.001597 169.3700n -0.001470 169.3800n -0.001338 169.3900n -0.001200 169.4000n -0.001057 169.4100n -0.000909 169.4200n -0.000755 169.4300n -0.000596 169.4400n -0.000432 169.4500n -0.000264 169.4600n -0.000092 169.4700n 0.000083 169.4800n 0.000261 169.4900n 0.000440
+ 169.5000n 0.000620 169.5100n 0.000799 169.5200n 0.000976 169.5300n 0.001149 169.5400n 0.001317 169.5500n 0.001479 169.5600n 0.001631 169.5700n 0.001773 169.5800n 0.001903 169.5900n 0.002018 169.6000n 0.002118 169.6100n 0.002200 169.6200n 0.002264 169.6300n 0.002308 169.6400n 0.002331
+ 169.6500n 0.002332 169.6600n 0.002311 169.6700n 0.002268 169.6800n 0.002202 169.6900n 0.002115 169.7000n 0.002008 169.7100n 0.001881 169.7200n 0.001737 169.7300n 0.001576 169.7400n 0.001403 169.7500n 0.001218 169.7600n 0.001025 169.7700n 0.000827 169.7800n 0.000626 169.7900n 0.000426
+ 169.8000n 0.000231 169.8100n 0.000043 169.8200n -0.000135 169.8300n -0.000300 169.8400n -0.000449 169.8500n -0.000579 169.8600n -0.000689 169.8700n -0.000777 169.8800n -0.000842 169.8900n -0.000882 169.9000n -0.000898 169.9100n -0.000889 169.9200n -0.000856 169.9300n -0.000800 169.9400n -0.000723
+ 169.9500n -0.000626 169.9600n -0.000513 169.9700n -0.000384 169.9800n -0.000244 169.9900n -0.000097 170.0000n 0.000056 170.0100n 0.000210 170.0200n 0.000361 170.0300n 0.000506 170.0400n 0.000642 170.0500n 0.000766 170.0600n 0.000873 170.0700n 0.000962 170.0800n 0.001031 170.0900n 0.001077
+ 170.1000n 0.001099 170.1100n 0.001096 170.1200n 0.001068 170.1300n 0.001015 170.1400n 0.000938 170.1500n 0.000838 170.1600n 0.000717 170.1700n 0.000577 170.1800n 0.000421 170.1900n 0.000252 170.2000n 0.000073 170.2100n -0.000112 170.2200n -0.000299 170.2300n -0.000485 170.2400n -0.000665
+ 170.2500n -0.000835 170.2600n -0.000993 170.2700n -0.001134 170.2800n -0.001255 170.2900n -0.001353 170.3000n -0.001427 170.3100n -0.001474 170.3200n -0.001493 170.3300n -0.001483 170.3400n -0.001444 170.3500n -0.001376 170.3600n -0.001281 170.3700n -0.001160 170.3800n -0.001014 170.3900n -0.000847
+ 170.4000n -0.000661 170.4100n -0.000459 170.4200n -0.000246 170.4300n -0.000025 170.4400n 0.000200 170.4500n 0.000425 170.4600n 0.000645 170.4700n 0.000858 170.4800n 0.001058 170.4900n 0.001243 170.5000n 0.001409 170.5100n 0.001553 170.5200n 0.001674 170.5300n 0.001768 170.5400n 0.001836
+ 170.5500n 0.001875 170.5600n 0.001886 170.5700n 0.001869 170.5800n 0.001824 170.5900n 0.001754 170.6000n 0.001660 170.6100n 0.001543 170.6200n 0.001408 170.6300n 0.001256 170.6400n 0.001091 170.6500n 0.000916 170.6600n 0.000735 170.6700n 0.000552 170.6800n 0.000369 170.6900n 0.000191
+ 170.7000n 0.000020 170.7100n -0.000140 170.7200n -0.000288 170.7300n -0.000420 170.7400n -0.000535 170.7500n -0.000632 170.7600n -0.000709 170.7700n -0.000767 170.7800n -0.000804 170.7900n -0.000822 170.8000n -0.000821 170.8100n -0.000803 170.8200n -0.000769 170.8300n -0.000721 170.8400n -0.000661
+ 170.8500n -0.000592 170.8600n -0.000517 170.8700n -0.000438 170.8800n -0.000357 170.8900n -0.000277 170.9000n -0.000202 170.9100n -0.000132 170.9200n -0.000071 170.9300n -0.000019 170.9400n 0.000021 170.9500n 0.000048 170.9600n 0.000062 170.9700n 0.000062 170.9800n 0.000048 170.9900n 0.000020
+ 171.0000n -0.000020 171.0100n -0.000073 171.0200n -0.000136 171.0300n -0.000208 171.0400n -0.000287 171.0500n -0.000371 171.0600n -0.000457 171.0700n -0.000545 171.0800n -0.000631 171.0900n -0.000712 171.1000n -0.000788 171.1100n -0.000856 171.1200n -0.000914 171.1300n -0.000960 171.1400n -0.000994
+ 171.1500n -0.001013 171.1600n -0.001018 171.1700n -0.001008 171.1800n -0.000983 171.1900n -0.000943 171.2000n -0.000888 171.2100n -0.000820 171.2200n -0.000738 171.2300n -0.000646 171.2400n -0.000543 171.2500n -0.000432 171.2600n -0.000314 171.2700n -0.000191 171.2800n -0.000065 171.2900n 0.000062
+ 171.3000n 0.000189 171.3100n 0.000315 171.3200n 0.000436 171.3300n 0.000554 171.3400n 0.000665 171.3500n 0.000770 171.3600n 0.000867 171.3700n 0.000957 171.3800n 0.001039 171.3900n 0.001114 171.4000n 0.001180 171.4100n 0.001240 171.4200n 0.001292 171.4300n 0.001339 171.4400n 0.001381
+ 171.4500n 0.001418 171.4600n 0.001452 171.4700n 0.001484 171.4800n 0.001513 171.4900n 0.001542 171.5000n 0.001570 171.5100n 0.001598 171.5200n 0.001626 171.5300n 0.001654 171.5400n 0.001682 171.5500n 0.001710 171.5600n 0.001738 171.5700n 0.001763 171.5800n 0.001787 171.5900n 0.001807
+ 171.6000n 0.001822 171.6100n 0.001831 171.6200n 0.001833 171.6300n 0.001826 171.6400n 0.001809 171.6500n 0.001780 171.6600n 0.001740 171.6700n 0.001685 171.6800n 0.001617 171.6900n 0.001533 171.7000n 0.001435 171.7100n 0.001321 171.7200n 0.001192 171.7300n 0.001049 171.7400n 0.000892
+ 171.7500n 0.000724 171.7600n 0.000544 171.7700n 0.000356 171.7800n 0.000161 171.7900n -0.000038 171.8000n -0.000239 171.8100n -0.000440 171.8200n -0.000636 171.8300n -0.000826 171.8400n -0.001007 171.8500n -0.001176 171.8600n -0.001330 171.8700n -0.001468 171.8800n -0.001586 171.8900n -0.001683
+ 171.9000n -0.001758 171.9100n -0.001809 171.9200n -0.001835 171.9300n -0.001837 171.9400n -0.001814 171.9500n -0.001766 171.9600n -0.001695 171.9700n -0.001602 171.9800n -0.001489 171.9900n -0.001358 172.0000n -0.001211 172.0100n -0.001051 172.0200n -0.000880 172.0300n -0.000703 172.0400n -0.000521
+ 172.0500n -0.000338 172.0600n -0.000157 172.0700n 0.000019 172.0800n 0.000186 172.0900n 0.000344 172.1000n 0.000488 172.1100n 0.000618 172.1200n 0.000731 172.1300n 0.000827 172.1400n 0.000904 172.1500n 0.000963 172.1600n 0.001002 172.1700n 0.001023 172.1800n 0.001027 172.1900n 0.001015
+ 172.2000n 0.000988 172.2100n 0.000948 172.2200n 0.000898 172.2300n 0.000840 172.2400n 0.000777 172.2500n 0.000711 172.2600n 0.000645 172.2700n 0.000581 172.2800n 0.000523 172.2900n 0.000471 172.3000n 0.000430 172.3100n 0.000400 172.3200n 0.000383 172.3300n 0.000381 172.3400n 0.000393
+ 172.3500n 0.000422 172.3600n 0.000466 172.3700n 0.000525 172.3800n 0.000600 172.3900n 0.000688 172.4000n 0.000788 172.4100n 0.000898 172.4200n 0.001017 172.4300n 0.001142 172.4400n 0.001271 172.4500n 0.001401 172.4600n 0.001530 172.4700n 0.001655 172.4800n 0.001774 172.4900n 0.001884
+ 172.5000n 0.001983 172.5100n 0.002069 172.5200n 0.002140 172.5300n 0.002196 172.5400n 0.002234 172.5500n 0.002255 172.5600n 0.002257 172.5700n 0.002241 172.5800n 0.002208 172.5900n 0.002157 172.6000n 0.002091 172.6100n 0.002010 172.6200n 0.001916 172.6300n 0.001811 172.6400n 0.001697
+ 172.6500n 0.001577 172.6600n 0.001451 172.6700n 0.001324 172.6800n 0.001196 172.6900n 0.001071 172.7000n 0.000950 172.7100n 0.000835 172.7200n 0.000727 172.7300n 0.000628 172.7400n 0.000540 172.7500n 0.000462 172.7600n 0.000396 172.7700n 0.000342 172.7800n 0.000299 172.7900n 0.000267
+ 172.8000n 0.000246 172.8100n 0.000234 172.8200n 0.000230 172.8300n 0.000233 172.8400n 0.000241 172.8500n 0.000253 172.8600n 0.000267 172.8700n 0.000281 172.8800n 0.000293 172.8900n 0.000303 172.9000n 0.000308 172.9100n 0.000308 172.9200n 0.000301 172.9300n 0.000286 172.9400n 0.000263
+ 172.9500n 0.000232 172.9600n 0.000191 172.9700n 0.000143 172.9800n 0.000086 172.9900n 0.000022 173.0000n -0.000048 173.0100n -0.000123 173.0200n -0.000201 173.0300n -0.000282 173.0400n -0.000363 173.0500n -0.000443 173.0600n -0.000520 173.0700n -0.000592 173.0800n -0.000657 173.0900n -0.000714
+ 173.1000n -0.000762 173.1100n -0.000800 173.1200n -0.000825 173.1300n -0.000838 173.1400n -0.000838 173.1500n -0.000824 173.1600n -0.000797 173.1700n -0.000757 173.1800n -0.000704 173.1900n -0.000639 173.2000n -0.000564 173.2100n -0.000478 173.2200n -0.000384 173.2300n -0.000284 173.2400n -0.000178
+ 173.2500n -0.000069 173.2600n 0.000042 173.2700n 0.000152 173.2800n 0.000261 173.2900n 0.000367 173.3000n 0.000467 173.3100n 0.000561 173.3200n 0.000648 173.3300n 0.000726 173.3400n 0.000795 173.3500n 0.000854 173.3600n 0.000903 173.3700n 0.000942 173.3800n 0.000970 173.3900n 0.000989
+ 173.4000n 0.000998 173.4100n 0.000998 173.4200n 0.000990 173.4300n 0.000976 173.4400n 0.000955 173.4500n 0.000929 173.4600n 0.000899 173.4700n 0.000867 173.4800n 0.000832 173.4900n 0.000796 173.5000n 0.000760 173.5100n 0.000724 173.5200n 0.000689 173.5300n 0.000656 173.5400n 0.000624
+ 173.5500n 0.000594 173.5600n 0.000566 173.5700n 0.000539 173.5800n 0.000514 173.5900n 0.000489 173.6000n 0.000464 173.6100n 0.000439 173.6200n 0.000413 173.6300n 0.000385 173.6400n 0.000355 173.6500n 0.000322 173.6600n 0.000286 173.6700n 0.000246 173.6800n 0.000201 173.6900n 0.000153
+ 173.7000n 0.000100 173.7100n 0.000043 173.7200n -0.000018 173.7300n -0.000081 173.7400n -0.000148 173.7500n -0.000216 173.7600n -0.000284 173.7700n -0.000352 173.7800n -0.000419 173.7900n -0.000482 173.8000n -0.000542 173.8100n -0.000596 173.8200n -0.000644 173.8300n -0.000683 173.8400n -0.000714
+ 173.8500n -0.000736 173.8600n -0.000747 173.8700n -0.000747 173.8800n -0.000736 173.8900n -0.000714 173.9000n -0.000681 173.9100n -0.000638 173.9200n -0.000585 173.9300n -0.000523 173.9400n -0.000454 173.9500n -0.000379 173.9600n -0.000300 173.9700n -0.000218 173.9800n -0.000135 173.9900n -0.000054
+ 174.0000n 0.000024 174.0100n 0.000097 174.0200n 0.000162 174.0300n 0.000219 174.0400n 0.000266 174.0500n 0.000301 174.0600n 0.000322 174.0700n 0.000331 174.0800n 0.000324 174.0900n 0.000304 174.1000n 0.000269 174.1100n 0.000220 174.1200n 0.000158 174.1300n 0.000084 174.1400n -0.000000
+ 174.1500n -0.000094 174.1600n -0.000193 174.1700n -0.000298 174.1800n -0.000404 174.1900n -0.000511 174.2000n -0.000615 174.2100n -0.000713 174.2200n -0.000804 174.2300n -0.000886 174.2400n -0.000955 174.2500n -0.001011 174.2600n -0.001052 174.2700n -0.001076 174.2800n -0.001083 174.2900n -0.001072
+ 174.3000n -0.001044 174.3100n -0.000998 174.3200n -0.000935 174.3300n -0.000858 174.3400n -0.000766 174.3500n -0.000663 174.3600n -0.000551 174.3700n -0.000431 174.3800n -0.000307 174.3900n -0.000181 174.4000n -0.000057 174.4100n 0.000063 174.4200n 0.000176 174.4300n 0.000278 174.4400n 0.000369
+ 174.4500n 0.000444 174.4600n 0.000503 174.4700n 0.000544 174.4800n 0.000565 174.4900n 0.000566 174.5000n 0.000547 174.5100n 0.000508 174.5200n 0.000450 174.5300n 0.000374 174.5400n 0.000282 174.5500n 0.000176 174.5600n 0.000059 174.5700n -0.000067 174.5800n -0.000198 174.5900n -0.000332
+ 174.6000n -0.000464 174.6100n -0.000591 174.6200n -0.000710 174.6300n -0.000816 174.6400n -0.000908 174.6500n -0.000983 174.6600n -0.001037 174.6700n -0.001068 174.6800n -0.001076 174.6900n -0.001058 174.7000n -0.001015 174.7100n -0.000946 174.7200n -0.000853 174.7300n -0.000736 174.7400n -0.000597
+ 174.7500n -0.000438 174.7600n -0.000263 174.7700n -0.000075 174.7800n 0.000122 174.7900n 0.000325 174.8000n 0.000529 174.8100n 0.000731 174.8200n 0.000924 174.8300n 0.001105 174.8400n 0.001271 174.8500n 0.001416 174.8600n 0.001537 174.8700n 0.001631 174.8800n 0.001695 174.8900n 0.001728
+ 174.9000n 0.001727 174.9100n 0.001691 174.9200n 0.001621 174.9300n 0.001516 174.9400n 0.001379 174.9500n 0.001210 174.9600n 0.001013 174.9700n 0.000790 174.9800n 0.000545 174.9900n 0.000283 175.0000n 0.000007 175.0100n -0.000278 175.0200n -0.000565 175.0300n -0.000851 175.0400n -0.001131
+ 175.0500n -0.001398 175.0600n -0.001649 175.0700n -0.001878 175.0800n -0.002083 175.0900n -0.002259 175.1000n -0.002403 175.1100n -0.002512 175.1200n -0.002586 175.1300n -0.002623 175.1400n -0.002622 175.1500n -0.002585 175.1600n -0.002511 175.1700n -0.002404 175.1800n -0.002266 175.1900n -0.002100
+ 175.2000n -0.001909 175.2100n -0.001697 175.2200n -0.001470 175.2300n -0.001231 175.2400n -0.000986 175.2500n -0.000739 175.2600n -0.000496 175.2700n -0.000262 175.2800n -0.000040 175.2900n 0.000164 175.3000n 0.000348 175.3100n 0.000507 175.3200n 0.000639 175.3300n 0.000743 175.3400n 0.000816
+ 175.3500n 0.000857 175.3600n 0.000868 175.3700n 0.000847 175.3800n 0.000797 175.3900n 0.000719 175.4000n 0.000617 175.4100n 0.000492 175.4200n 0.000348 175.4300n 0.000189 175.4400n 0.000019 175.4500n -0.000157 175.4600n -0.000336 175.4700n -0.000513 175.4800n -0.000684 175.4900n -0.000845
+ 175.5000n -0.000992 175.5100n -0.001122 175.5200n -0.001232 175.5300n -0.001320 175.5400n -0.001383 175.5500n -0.001421 175.5600n -0.001432 175.5700n -0.001417 175.5800n -0.001376 175.5900n -0.001311 175.6000n -0.001223 175.6100n -0.001114 175.6200n -0.000987 175.6300n -0.000845 175.6400n -0.000692
+ 175.6500n -0.000531 175.6600n -0.000365 175.6700n -0.000199 175.6800n -0.000037 175.6900n 0.000119 175.7000n 0.000263 175.7100n 0.000394 175.7200n 0.000507 175.7300n 0.000602 175.7400n 0.000674 175.7500n 0.000724 175.7600n 0.000749 175.7700n 0.000750 175.7800n 0.000726 175.7900n 0.000677
+ 175.8000n 0.000606 175.8100n 0.000512 175.8200n 0.000400 175.8300n 0.000270 175.8400n 0.000125 175.8500n -0.000031 175.8600n -0.000196 175.8700n -0.000365 175.8800n -0.000537 175.8900n -0.000707 175.9000n -0.000871 175.9100n -0.001028 175.9200n -0.001174 175.9300n -0.001307 175.9400n -0.001424
+ 175.9500n -0.001524 175.9600n -0.001605 175.9700n -0.001666 175.9800n -0.001706 175.9900n -0.001726 176.0000n -0.001725 176.0100n -0.001705 176.0200n -0.001666 176.0300n -0.001610 176.0400n -0.001539 176.0500n -0.001454 176.0600n -0.001358 176.0700n -0.001253 176.0800n -0.001141 176.0900n -0.001025
+ 176.1000n -0.000907 176.1100n -0.000790 176.1200n -0.000674 176.1300n -0.000563 176.1400n -0.000457 176.1500n -0.000359 176.1600n -0.000268 176.1700n -0.000186 176.1800n -0.000114 176.1900n -0.000050 176.2000n 0.000004 176.2100n 0.000050 176.2200n 0.000089 176.2300n 0.000121 176.2400n 0.000148
+ 176.2500n 0.000170 176.2600n 0.000190 176.2700n 0.000209 176.2800n 0.000229 176.2900n 0.000250 176.3000n 0.000274 176.3100n 0.000302 176.3200n 0.000336 176.3300n 0.000375 176.3400n 0.000421 176.3500n 0.000473 176.3600n 0.000531 176.3700n 0.000594 176.3800n 0.000663 176.3900n 0.000735
+ 176.4000n 0.000809 176.4100n 0.000885 176.4200n 0.000959 176.4300n 0.001031 176.4400n 0.001097 176.4500n 0.001156 176.4600n 0.001206 176.4700n 0.001244 176.4800n 0.001269 176.4900n 0.001278 176.5000n 0.001270 176.5100n 0.001244 176.5200n 0.001199 176.5300n 0.001133 176.5400n 0.001047
+ 176.5500n 0.000940 176.5600n 0.000813 176.5700n 0.000667 176.5800n 0.000504 176.5900n 0.000323 176.6000n 0.000129 176.6100n -0.000077 176.6200n -0.000293 176.6300n -0.000515 176.6400n -0.000740 176.6500n -0.000965 176.6600n -0.001187 176.6700n -0.001403 176.6800n -0.001609 176.6900n -0.001803
+ 176.7000n -0.001981 176.7100n -0.002141 176.7200n -0.002280 176.7300n -0.002398 176.7400n -0.002491 176.7500n -0.002560 176.7600n -0.002604 176.7700n -0.002622 176.7800n -0.002615 176.7900n -0.002584 176.8000n -0.002530 176.8100n -0.002455 176.8200n -0.002362 176.8300n -0.002251 176.8400n -0.002127
+ 176.8500n -0.001993 176.8600n -0.001852 176.8700n -0.001707 176.8800n -0.001561 176.8900n -0.001419 176.9000n -0.001282 176.9100n -0.001156 176.9200n -0.001042 176.9300n -0.000943 176.9400n -0.000861 176.9500n -0.000798 176.9600n -0.000757 176.9700n -0.000736 176.9800n -0.000738 176.9900n -0.000763
+ 177.0000n -0.000809 177.0100n -0.000875 177.0200n -0.000961 177.0300n -0.001065 177.0400n -0.001183 177.0500n -0.001314 177.0600n -0.001455 177.0700n -0.001602 177.0800n -0.001753 177.0900n -0.001903 177.1000n -0.002049 177.1100n -0.002189 177.1200n -0.002319 177.1300n -0.002435 177.1400n -0.002535
+ 177.1500n -0.002616 177.1600n -0.002677 177.1700n -0.002715 177.1800n -0.002729 177.1900n -0.002718 177.2000n -0.002682 177.2100n -0.002621 177.2200n -0.002536 177.2300n -0.002427 177.2400n -0.002296 177.2500n -0.002146 177.2600n -0.001979 177.2700n -0.001796 177.2800n -0.001602 177.2900n -0.001400
+ 177.3000n -0.001192 177.3100n -0.000983 177.3200n -0.000777 177.3300n -0.000575 177.3400n -0.000383 177.3500n -0.000203 177.3600n -0.000038 177.3700n 0.000109 177.3800n 0.000235 177.3900n 0.000339 177.4000n 0.000419 177.4100n 0.000474 177.4200n 0.000504 177.4300n 0.000507 177.4400n 0.000484
+ 177.4500n 0.000437 177.4600n 0.000366 177.4700n 0.000273 177.4800n 0.000160 177.4900n 0.000030 177.5000n -0.000115 177.5100n -0.000271 177.5200n -0.000436 177.5300n -0.000605 177.5400n -0.000776 177.5500n -0.000944 177.5600n -0.001106 177.5700n -0.001259 177.5800n -0.001399 177.5900n -0.001523
+ 177.6000n -0.001628 177.6100n -0.001713 177.6200n -0.001774 177.6300n -0.001810 177.6400n -0.001819 177.6500n -0.001801 177.6600n -0.001755 177.6700n -0.001681 177.6800n -0.001579 177.6900n -0.001451 177.7000n -0.001298 177.7100n -0.001120 177.7200n -0.000922 177.7300n -0.000704 177.7400n -0.000470
+ 177.7500n -0.000222 177.7600n 0.000035 177.7700n 0.000300 177.7800n 0.000567 177.7900n 0.000835 177.8000n 0.001099 177.8100n 0.001356 177.8200n 0.001603 177.8300n 0.001837 177.8400n 0.002054 177.8500n 0.002252 177.8600n 0.002429 177.8700n 0.002583 177.8800n 0.002712 177.8900n 0.002815
+ 177.9000n 0.002891 177.9100n 0.002939 177.9200n 0.002959 177.9300n 0.002952 177.9400n 0.002919 177.9500n 0.002860 177.9600n 0.002777 177.9700n 0.002671 177.9800n 0.002545 177.9900n 0.002401 178.0000n 0.002241 178.0100n 0.002068 178.0200n 0.001885 178.0300n 0.001694 178.0400n 0.001499
+ 178.0500n 0.001303 178.0600n 0.001108 178.0700n 0.000917 178.0800n 0.000734 178.0900n 0.000559 178.1000n 0.000396 178.1100n 0.000247 178.1200n 0.000114 178.1300n -0.000002 178.1400n -0.000100 178.1500n -0.000179 178.1600n -0.000237 178.1700n -0.000275 178.1800n -0.000292 178.1900n -0.000289
+ 178.2000n -0.000267 178.2100n -0.000225 178.2200n -0.000165 178.2300n -0.000088 178.2400n 0.000004 178.2500n 0.000111 178.2600n 0.000230 178.2700n 0.000359 178.2800n 0.000497 178.2900n 0.000642 178.3000n 0.000792 178.3100n 0.000946 178.3200n 0.001101 178.3300n 0.001256 178.3400n 0.001409
+ 178.3500n 0.001560 178.3600n 0.001706 178.3700n 0.001846 178.3800n 0.001980 178.3900n 0.002107 178.4000n 0.002226 178.4100n 0.002336 178.4200n 0.002438 178.4300n 0.002530 178.4400n 0.002613 178.4500n 0.002687 178.4600n 0.002752 178.4700n 0.002808 178.4800n 0.002855 178.4900n 0.002894
+ 178.5000n 0.002925 178.5100n 0.002947 178.5200n 0.002962 178.5300n 0.002970 178.5400n 0.002969 178.5500n 0.002962 178.5600n 0.002947 178.5700n 0.002925 178.5800n 0.002895 178.5900n 0.002857 178.6000n 0.002811 178.6100n 0.002757 178.6200n 0.002694 178.6300n 0.002623 178.6400n 0.002541
+ 178.6500n 0.002450 178.6600n 0.002349 178.6700n 0.002238 178.6800n 0.002117 178.6900n 0.001985 178.7000n 0.001843 178.7100n 0.001692 178.7200n 0.001531 178.7300n 0.001361 178.7400n 0.001184 178.7500n 0.001000 178.7600n 0.000811 178.7700n 0.000618 178.7800n 0.000423 178.7900n 0.000228
+ 178.8000n 0.000034 178.8100n -0.000156 178.8200n -0.000339 178.8300n -0.000515 178.8400n -0.000679 178.8500n -0.000831 178.8600n -0.000967 178.8700n -0.001087 178.8800n -0.001187 178.8900n -0.001266 178.9000n -0.001323 178.9100n -0.001356 178.9200n -0.001364 178.9300n -0.001348 178.9400n -0.001306
+ 178.9500n -0.001240 178.9600n -0.001149 178.9700n -0.001035 178.9800n -0.000899 178.9900n -0.000744 179.0000n -0.000570 179.0100n -0.000382 179.0200n -0.000182 179.0300n 0.000026 179.0400n 0.000241 179.0500n 0.000457 179.0600n 0.000671 179.0700n 0.000879 179.0800n 0.001079 179.0900n 0.001265
+ 179.1000n 0.001435 179.1100n 0.001586 179.1200n 0.001715 179.1300n 0.001820 179.1400n 0.001897 179.1500n 0.001946 179.1600n 0.001967 179.1700n 0.001957 179.1800n 0.001918 179.1900n 0.001849 179.2000n 0.001753 179.2100n 0.001630 179.2200n 0.001484 179.2300n 0.001317 179.2400n 0.001131
+ 179.2500n 0.000932 179.2600n 0.000722 179.2700n 0.000505 179.2800n 0.000287 179.2900n 0.000072 179.3000n -0.000137 179.3100n -0.000334 179.3200n -0.000516 179.3300n -0.000678 179.3400n -0.000818 179.3500n -0.000931 179.3600n -0.001016 179.3700n -0.001070 179.3800n -0.001093 179.3900n -0.001082
+ 179.4000n -0.001038 179.4100n -0.000961 179.4200n -0.000853 179.4300n -0.000716 179.4400n -0.000551 179.4500n -0.000362 179.4600n -0.000152 179.4700n 0.000074 179.4800n 0.000312 179.4900n 0.000558 179.5000n 0.000806 179.5100n 0.001052 179.5200n 0.001291 179.5300n 0.001518 179.5400n 0.001728
+ 179.5500n 0.001917 179.5600n 0.002081 179.5700n 0.002216 179.5800n 0.002319 179.5900n 0.002389 179.6000n 0.002424 179.6100n 0.002422 179.6200n 0.002384 179.6300n 0.002310 179.6400n 0.002202 179.6500n 0.002061 179.6600n 0.001891 179.6700n 0.001694 179.6800n 0.001475 179.6900n 0.001237
+ 179.7000n 0.000987 179.7100n 0.000729 179.7200n 0.000467 179.7300n 0.000208 179.7400n -0.000042 179.7500n -0.000280 179.7600n -0.000499 179.7700n -0.000696 179.7800n -0.000866 179.7900n -0.001006 179.8000n -0.001112 179.8100n -0.001182 179.8200n -0.001215 179.8300n -0.001209 179.8400n -0.001166
+ 179.8500n -0.001086 179.8600n -0.000969 179.8700n -0.000820 179.8800n -0.000640 179.8900n -0.000433 179.9000n -0.000205 179.9100n 0.000041 179.9200n 0.000299 179.9300n 0.000564 179.9400n 0.000831 179.9500n 0.001092 179.9600n 0.001344 179.9700n 0.001579 179.9800n 0.001794 179.9900n 0.001983
+ 180.0000n 0.002143 180.0100n 0.002269 180.0200n 0.002358 180.0300n 0.002408 180.0400n 0.002418 180.0500n 0.002387 180.0600n 0.002316 180.0700n 0.002204 180.0800n 0.002053 180.0900n 0.001868 180.1000n 0.001649 180.1100n 0.001402 180.1200n 0.001131 180.1300n 0.000841 180.1400n 0.000537
+ 180.1500n 0.000225 180.1600n -0.000090 180.1700n -0.000401 180.1800n -0.000704 180.1900n -0.000992 180.2000n -0.001260 180.2100n -0.001504 180.2200n -0.001719 180.2300n -0.001901 180.2400n -0.002048 180.2500n -0.002156 180.2600n -0.002226 180.2700n -0.002255 180.2800n -0.002243 180.2900n -0.002192
+ 180.3000n -0.002103 180.3100n -0.001979 180.3200n -0.001821 180.3300n -0.001635 180.3400n -0.001423 180.3500n -0.001191 180.3600n -0.000943 180.3700n -0.000684 180.3800n -0.000420 180.3900n -0.000156 180.4000n 0.000103 180.4100n 0.000352 180.4200n 0.000587 180.4300n 0.000802 180.4400n 0.000994
+ 180.4500n 0.001160 180.4600n 0.001296 180.4700n 0.001402 180.4800n 0.001474 180.4900n 0.001513 180.5000n 0.001519 180.5100n 0.001491 180.5200n 0.001432 180.5300n 0.001342 180.5400n 0.001225 180.5500n 0.001082 180.5600n 0.000918 180.5700n 0.000736 180.5800n 0.000539 180.5900n 0.000332
+ 180.6000n 0.000119 180.6100n -0.000096 180.6200n -0.000310 180.6300n -0.000518 180.6400n -0.000718 180.6500n -0.000905 180.6600n -0.001077 180.6700n -0.001232 180.6800n -0.001368 180.6900n -0.001483 180.7000n -0.001577 180.7100n -0.001650 180.7200n -0.001701 180.7300n -0.001731 180.7400n -0.001741
+ 180.7500n -0.001733 180.7600n -0.001709 180.7700n -0.001671 180.7800n -0.001620 180.7900n -0.001560 180.8000n -0.001494 180.8100n -0.001423 180.8200n -0.001351 180.8300n -0.001279 180.8400n -0.001211 180.8500n -0.001147 180.8600n -0.001091 180.8700n -0.001043 180.8800n -0.001005 180.8900n -0.000977
+ 180.9000n -0.000959 180.9100n -0.000952 180.9200n -0.000955 180.9300n -0.000967 180.9400n -0.000987 180.9500n -0.001014 180.9600n -0.001047 180.9700n -0.001083 180.9800n -0.001121 180.9900n -0.001158 181.0000n -0.001193 181.0100n -0.001223 181.0200n -0.001248 181.0300n -0.001264 181.0400n -0.001271
+ 181.0500n -0.001267 181.0600n -0.001252 181.0700n -0.001224 181.0800n -0.001184 181.0900n -0.001132 181.1000n -0.001068 181.1100n -0.000992 181.1200n -0.000906 181.1300n -0.000812 181.1400n -0.000710 181.1500n -0.000604 181.1600n -0.000494 181.1700n -0.000383 181.1800n -0.000274 181.1900n -0.000169
+ 181.2000n -0.000069 181.2100n 0.000022 181.2200n 0.000103 181.2300n 0.000172 181.2400n 0.000227 181.2500n 0.000268 181.2600n 0.000293 181.2700n 0.000302 181.2800n 0.000294 181.2900n 0.000271 181.3000n 0.000232 181.3100n 0.000178 181.3200n 0.000111 181.3300n 0.000033 181.3400n -0.000055
+ 181.3500n -0.000150 181.3600n -0.000250 181.3700n -0.000352 181.3800n -0.000453 181.3900n -0.000552 181.4000n -0.000645 181.4100n -0.000729 181.4200n -0.000803 181.4300n -0.000865 181.4400n -0.000911 181.4500n -0.000941 181.4600n -0.000954 181.4700n -0.000949 181.4800n -0.000925 181.4900n -0.000882
+ 181.5000n -0.000821 181.5100n -0.000743 181.5200n -0.000648 181.5300n -0.000540 181.5400n -0.000418 181.5500n -0.000287 181.5600n -0.000148 181.5700n -0.000004 181.5800n 0.000142 181.5900n 0.000287 181.6000n 0.000428 181.6100n 0.000563 181.6200n 0.000688 181.6300n 0.000801 181.6400n 0.000900
+ 181.6500n 0.000982 181.6600n 0.001046 181.6700n 0.001091 181.6800n 0.001115 181.6900n 0.001119 181.7000n 0.001102 181.7100n 0.001064 181.7200n 0.001007 181.7300n 0.000931 181.7400n 0.000839 181.7500n 0.000731 181.7600n 0.000612 181.7700n 0.000483 181.7800n 0.000346 181.7900n 0.000206
+ 181.8000n 0.000065 181.8100n -0.000075 181.8200n -0.000209 181.8300n -0.000335 181.8400n -0.000451 181.8500n -0.000553 181.8600n -0.000640 181.8700n -0.000710 181.8800n -0.000760 181.8900n -0.000791 181.9000n -0.000800 181.9100n -0.000788 181.9200n -0.000754 181.9300n -0.000699 181.9400n -0.000625
+ 181.9500n -0.000531 181.9600n -0.000421 181.9700n -0.000295 181.9800n -0.000156 181.9900n -0.000007 182.0000n 0.000151 182.0100n 0.000314 182.0200n 0.000480 182.0300n 0.000645 182.0400n 0.000808 182.0500n 0.000965 182.0600n 0.001114 182.0700n 0.001252 182.0800n 0.001379 182.0900n 0.001491
+ 182.1000n 0.001588 182.1100n 0.001668 182.1200n 0.001731 182.1300n 0.001776 182.1400n 0.001804 182.1500n 0.001813 182.1600n 0.001806 182.1700n 0.001783 182.1800n 0.001744 182.1900n 0.001692 182.2000n 0.001628 182.2100n 0.001554 182.2200n 0.001471 182.2300n 0.001382 182.2400n 0.001289
+ 182.2500n 0.001193 182.2600n 0.001096 182.2700n 0.001000 182.2800n 0.000908 182.2900n 0.000819 182.3000n 0.000736 182.3100n 0.000659 182.3200n 0.000590 182.3300n 0.000529 182.3400n 0.000477 182.3500n 0.000432 182.3600n 0.000396 182.3700n 0.000368 182.3800n 0.000347 182.3900n 0.000333
+ 182.4000n 0.000324 182.4100n 0.000320 182.4200n 0.000319 182.4300n 0.000321 182.4400n 0.000323 182.4500n 0.000325 182.4600n 0.000325 182.4700n 0.000322 182.4800n 0.000315 182.4900n 0.000303 182.5000n 0.000286 182.5100n 0.000262 182.5200n 0.000231 182.5300n 0.000193 182.5400n 0.000148
+ 182.5500n 0.000095 182.5600n 0.000036 182.5700n -0.000030 182.5800n -0.000102 182.5900n -0.000179 182.6000n -0.000260 182.6100n -0.000344 182.6200n -0.000430 182.6300n -0.000517 182.6400n -0.000603 182.6500n -0.000687 182.6600n -0.000769 182.6700n -0.000846 182.6800n -0.000918 182.6900n -0.000983
+ 182.7000n -0.001041 182.7100n -0.001090 182.7200n -0.001131 182.7300n -0.001162 182.7400n -0.001183 182.7500n -0.001194 182.7600n -0.001195 182.7700n -0.001185 182.7800n -0.001166 182.7900n -0.001138 182.8000n -0.001101 182.8100n -0.001056 182.8200n -0.001004 182.8300n -0.000946 182.8400n -0.000883
+ 182.8500n -0.000816 182.8600n -0.000747 182.8700n -0.000677 182.8800n -0.000607 182.8900n -0.000539 182.9000n -0.000473 182.9100n -0.000412 182.9200n -0.000356 182.9300n -0.000306 182.9400n -0.000264 182.9500n -0.000230 182.9600n -0.000206 182.9700n -0.000192 182.9800n -0.000189 182.9900n -0.000197
+ 183.0000n -0.000217 183.0100n -0.000249 183.0200n -0.000292 183.0300n -0.000347 183.0400n -0.000414 183.0500n -0.000491 183.0600n -0.000579 183.0700n -0.000676 183.0800n -0.000782 183.0900n -0.000895 183.1000n -0.001015 183.1100n -0.001140 183.1200n -0.001270 183.1300n -0.001401 183.1400n -0.001533
+ 183.1500n -0.001665 183.1600n -0.001794 183.1700n -0.001919 183.1800n -0.002039 183.1900n -0.002151 183.2000n -0.002254 183.2100n -0.002347 183.2200n -0.002427 183.2300n -0.002495 183.2400n -0.002548 183.2500n -0.002585 183.2600n -0.002606 183.2700n -0.002610 183.2800n -0.002596 183.2900n -0.002564
+ 183.3000n -0.002514 183.3100n -0.002446 183.3200n -0.002361 183.3300n -0.002259 183.3400n -0.002141 183.3500n -0.002008 183.3600n -0.001862 183.3700n -0.001704 183.3800n -0.001535 183.3900n -0.001359 183.4000n -0.001177 183.4100n -0.000990 183.4200n -0.000802 183.4300n -0.000615 183.4400n -0.000431
+ 183.4500n -0.000253 183.4600n -0.000082 183.4700n 0.000079 183.4800n 0.000228 183.4900n 0.000364 183.5000n 0.000484 183.5100n 0.000588 183.5200n 0.000674 183.5300n 0.000742 183.5400n 0.000791 183.5500n 0.000820 183.5600n 0.000831 183.5700n 0.000824 183.5800n 0.000799 183.5900n 0.000759
+ 183.6000n 0.000704 183.6100n 0.000636 183.6200n 0.000558 183.6300n 0.000472 183.6400n 0.000380 183.6500n 0.000285 183.6600n 0.000189 183.6700n 0.000097 183.6800n 0.000009 183.6900n -0.000071 183.7000n -0.000140 183.7100n -0.000196 183.7200n -0.000238 183.7300n -0.000263 183.7400n -0.000269
+ 183.7500n -0.000257 183.7600n -0.000224 183.7700n -0.000170 183.7800n -0.000097 183.7900n -0.000003 183.8000n 0.000109 183.8100n 0.000239 183.8200n 0.000384 183.8300n 0.000543 183.8400n 0.000712 183.8500n 0.000890 183.8600n 0.001073 183.8700n 0.001257 183.8800n 0.001439 183.8900n 0.001616
+ 183.9000n 0.001784 183.9100n 0.001940 183.9200n 0.002080 183.9300n 0.002202 183.9400n 0.002301 183.9500n 0.002376 183.9600n 0.002425 183.9700n 0.002445 183.9800n 0.002435 183.9900n 0.002395 184.0000n 0.002324 184.0100n 0.002222 184.0200n 0.002090 184.0300n 0.001929 184.0400n 0.001741
+ 184.0500n 0.001528 184.0600n 0.001292 184.0700n 0.001038 184.0800n 0.000767 184.0900n 0.000484 184.1000n 0.000193 184.1100n -0.000102 184.1200n -0.000398 184.1300n -0.000689 184.1400n -0.000973 184.1500n -0.001244 184.1600n -0.001500 184.1700n -0.001737 184.1800n -0.001951 184.1900n -0.002140
+ 184.2000n -0.002301 184.2100n -0.002434 184.2200n -0.002535 184.2300n -0.002606 184.2400n -0.002644 184.2500n -0.002651 184.2600n -0.002628 184.2700n -0.002575 184.2800n -0.002494 184.2900n -0.002388 184.3000n -0.002259 184.3100n -0.002109 184.3200n -0.001943 184.3300n -0.001764 184.3400n -0.001574
+ 184.3500n -0.001378 184.3600n -0.001179 184.3700n -0.000980 184.3800n -0.000786 184.3900n -0.000599 184.4000n -0.000423 184.4100n -0.000259 184.4200n -0.000111 184.4300n 0.000020 184.4400n 0.000132 184.4500n 0.000224 184.4600n 0.000295 184.4700n 0.000346 184.4800n 0.000376 184.4900n 0.000386
+ 184.5000n 0.000377 184.5100n 0.000351 184.5200n 0.000310 184.5300n 0.000255 184.5400n 0.000189 184.5500n 0.000115 184.5600n 0.000034 184.5700n -0.000049 184.5800n -0.000132 184.5900n -0.000213 184.6000n -0.000288 184.6100n -0.000356 184.6200n -0.000413 184.6300n -0.000457 184.6400n -0.000487
+ 184.6500n -0.000501 184.6600n -0.000497 184.6700n -0.000475 184.6800n -0.000434 184.6900n -0.000374 184.7000n -0.000295 184.7100n -0.000197 184.7200n -0.000082 184.7300n 0.000050 184.7400n 0.000198 184.7500n 0.000358 184.7600n 0.000530 184.7700n 0.000711 184.7800n 0.000898 184.7900n 0.001091
+ 184.8000n 0.001284 184.8100n 0.001477 184.8200n 0.001667 184.8300n 0.001851 184.8400n 0.002026 184.8500n 0.002190 184.8600n 0.002342 184.8700n 0.002478 184.8800n 0.002598 184.8900n 0.002700 184.9000n 0.002781 184.9100n 0.002842 184.9200n 0.002881 184.9300n 0.002898 184.9400n 0.002893
+ 184.9500n 0.002865 184.9600n 0.002815 184.9700n 0.002743 184.9800n 0.002650 184.9900n 0.002536 185.0000n 0.002404 185.0100n 0.002255 185.0200n 0.002089 185.0300n 0.001910 185.0400n 0.001717 185.0500n 0.001515 185.0600n 0.001304 185.0700n 0.001086 185.0800n 0.000865 185.0900n 0.000641
+ 185.1000n 0.000418 185.1100n 0.000197 185.1200n -0.000019 185.1300n -0.000229 185.1400n -0.000430 185.1500n -0.000620 185.1600n -0.000798 185.1700n -0.000961 185.1800n -0.001109 185.1900n -0.001240 185.2000n -0.001353 185.2100n -0.001445 185.2200n -0.001518 185.2300n -0.001570 185.2400n -0.001600
+ 185.2500n -0.001609 185.2600n -0.001596 185.2700n -0.001562 185.2800n -0.001507 185.2900n -0.001432 185.3000n -0.001338 185.3100n -0.001226 185.3200n -0.001098 185.3300n -0.000955 185.3400n -0.000799 185.3500n -0.000633 185.3600n -0.000457 185.3700n -0.000276 185.3800n -0.000091 185.3900n 0.000096
+ 185.4000n 0.000281 185.4100n 0.000463 185.4200n 0.000638 185.4300n 0.000804 185.4400n 0.000959 185.4500n 0.001100 185.4600n 0.001225 185.4700n 0.001333 185.4800n 0.001422 185.4900n 0.001489 185.5000n 0.001535 185.5100n 0.001558 185.5200n 0.001558 185.5300n 0.001534 185.5400n 0.001487
+ 185.5500n 0.001417 185.5600n 0.001325 185.5700n 0.001212 185.5800n 0.001080 185.5900n 0.000930 185.6000n 0.000764 185.6100n 0.000585 185.6200n 0.000395 185.6300n 0.000197 185.6400n -0.000007 185.6500n -0.000214 185.6600n -0.000421 185.6700n -0.000625 185.6800n -0.000824 185.6900n -0.001014
+ 185.7000n -0.001194 185.7100n -0.001361 185.7200n -0.001513 185.7300n -0.001649 185.7400n -0.001766 185.7500n -0.001864 185.7600n -0.001941 185.7700n -0.001998 185.7800n -0.002034 185.7900n -0.002049 185.8000n -0.002043 185.8100n -0.002018 185.8200n -0.001974 185.8300n -0.001913 185.8400n -0.001835
+ 185.8500n -0.001744 185.8600n -0.001639 185.8700n -0.001525 185.8800n -0.001401 185.8900n -0.001272 185.9000n -0.001137 185.9100n -0.001000 185.9200n -0.000863 185.9300n -0.000726 185.9400n -0.000593 185.9500n -0.000463 185.9600n -0.000339 185.9700n -0.000220 185.9800n -0.000109 185.9900n -0.000006
+ 186.0000n 0.000089 186.0100n 0.000176 186.0200n 0.000254 186.0300n 0.000325 186.0400n 0.000387 186.0500n 0.000442 186.0600n 0.000491 186.0700n 0.000533 186.0800n 0.000569 186.0900n 0.000601 186.1000n 0.000627 186.1100n 0.000650 186.1200n 0.000669 186.1300n 0.000685 186.1400n 0.000698
+ 186.1500n 0.000708 186.1600n 0.000714 186.1700n 0.000717 186.1800n 0.000715 186.1900n 0.000709 186.2000n 0.000698 186.2100n 0.000680 186.2200n 0.000656 186.2300n 0.000623 186.2400n 0.000581 186.2500n 0.000529 186.2600n 0.000466 186.2700n 0.000391 186.2800n 0.000303 186.2900n 0.000202
+ 186.3000n 0.000087 186.3100n -0.000041 186.3200n -0.000184 186.3300n -0.000340 186.3400n -0.000508 186.3500n -0.000689 186.3600n -0.000880 186.3700n -0.001081 186.3800n -0.001289 186.3900n -0.001502 186.4000n -0.001718 186.4100n -0.001935 186.4200n -0.002150 186.4300n -0.002360 186.4400n -0.002562
+ 186.4500n -0.002754 186.4600n -0.002932 186.4700n -0.003094 186.4800n -0.003238 186.4900n -0.003360 186.5000n -0.003458 186.5100n -0.003532 186.5200n -0.003579 186.5300n -0.003598 186.5400n -0.003588 186.5500n -0.003549 186.5600n -0.003481 186.5700n -0.003385 186.5800n -0.003261 186.5900n -0.003112
+ 186.6000n -0.002939 186.6100n -0.002744 186.6200n -0.002530 186.6300n -0.002299 186.6400n -0.002056 186.6500n -0.001803 186.6600n -0.001543 186.6700n -0.001281 186.6800n -0.001020 186.6900n -0.000763 186.7000n -0.000515 186.7100n -0.000277 186.7200n -0.000054 186.7300n 0.000153 186.7400n 0.000340
+ 186.7500n 0.000506 186.7600n 0.000649 186.7700n 0.000767 186.7800n 0.000861 186.7900n 0.000930 186.8000n 0.000973 186.8100n 0.000992 186.8200n 0.000988 186.8300n 0.000961 186.8400n 0.000914 186.8500n 0.000849 186.8600n 0.000768 186.8700n 0.000673 186.8800n 0.000566 186.8900n 0.000452
+ 186.9000n 0.000332 186.9100n 0.000209 186.9200n 0.000086 186.9300n -0.000034 186.9400n -0.000150 186.9500n -0.000259 186.9600n -0.000360 186.9700n -0.000450 186.9800n -0.000528 186.9900n -0.000594 187.0000n -0.000646 187.0100n -0.000685 187.0200n -0.000710 187.0300n -0.000721 187.0400n -0.000719
+ 187.0500n -0.000705 187.0600n -0.000679 187.0700n -0.000642 187.0800n -0.000597 187.0900n -0.000543 187.1000n -0.000482 187.1100n -0.000415 187.1200n -0.000344 187.1300n -0.000270 187.1400n -0.000193 187.1500n -0.000115 187.1600n -0.000036 187.1700n 0.000042 187.1800n 0.000121 187.1900n 0.000200
+ 187.2000n 0.000278 187.2100n 0.000356 187.2200n 0.000434 187.2300n 0.000513 187.2400n 0.000593 187.2500n 0.000674 187.2600n 0.000759 187.2700n 0.000846 187.2800n 0.000937 187.2900n 0.001032 187.3000n 0.001131 187.3100n 0.001235 187.3200n 0.001344 187.3300n 0.001458 187.3400n 0.001576
+ 187.3500n 0.001697 187.3600n 0.001821 187.3700n 0.001947 187.3800n 0.002073 187.3900n 0.002198 187.4000n 0.002320 187.4100n 0.002437 187.4200n 0.002547 187.4300n 0.002648 187.4400n 0.002738 187.4500n 0.002815 187.4600n 0.002877 187.4700n 0.002922 187.4800n 0.002949 187.4900n 0.002955
+ 187.5000n 0.002941 187.5100n 0.002904 187.5200n 0.002846 187.5300n 0.002765 187.5400n 0.002663 187.5500n 0.002539 187.5600n 0.002396 187.5700n 0.002234 187.5800n 0.002057 187.5900n 0.001867 187.6000n 0.001665 187.6100n 0.001457 187.6200n 0.001245 187.6300n 0.001032 187.6400n 0.000823
+ 187.6500n 0.000621 187.6600n 0.000429 187.6700n 0.000253 187.6800n 0.000094 187.6900n -0.000044 187.7000n -0.000158 187.7100n -0.000245 187.7200n -0.000304 187.7300n -0.000333 187.7400n -0.000331 187.7500n -0.000298 187.7600n -0.000234 187.7700n -0.000141 187.7800n -0.000018 187.7900n 0.000130
+ 187.8000n 0.000303 187.8100n 0.000496 187.8200n 0.000707 187.8300n 0.000930 187.8400n 0.001163 187.8500n 0.001400 187.8600n 0.001637 187.8700n 0.001869 187.8800n 0.002091 187.8900n 0.002299 187.9000n 0.002489 187.9100n 0.002657 187.9200n 0.002799 187.9300n 0.002912 187.9400n 0.002993
+ 187.9500n 0.003042 187.9600n 0.003055 187.9700n 0.003034 187.9800n 0.002977 187.9900n 0.002887 188.0000n 0.002763 188.0100n 0.002610 188.0200n 0.002428 188.0300n 0.002222 188.0400n 0.001995 188.0500n 0.001753 188.0600n 0.001498 188.0700n 0.001237 188.0800n 0.000974 188.0900n 0.000715
+ 188.1000n 0.000464 188.1100n 0.000227 188.1200n 0.000007 188.1300n -0.000191 188.1400n -0.000362 188.1500n -0.000504 188.1600n -0.000614 188.1700n -0.000689 188.1800n -0.000729 188.1900n -0.000732 188.2000n -0.000699 188.2100n -0.000630 188.2200n -0.000527 188.2300n -0.000392 188.2400n -0.000227
+ 188.2500n -0.000037 188.2600n 0.000176 188.2700n 0.000407 188.2800n 0.000651 188.2900n 0.000904 188.3000n 0.001159 188.3100n 0.001413 188.3200n 0.001660 188.3300n 0.001894 188.3400n 0.002112 188.3500n 0.002308 188.3600n 0.002479 188.3700n 0.002621 188.3800n 0.002731 188.3900n 0.002807
+ 188.4000n 0.002846 188.4100n 0.002847 188.4200n 0.002810 188.4300n 0.002735 188.4400n 0.002623 188.4500n 0.002475 188.4600n 0.002294 188.4700n 0.002081 188.4800n 0.001840 188.4900n 0.001574 188.5000n 0.001288 188.5100n 0.000985 188.5200n 0.000669 188.5300n 0.000346 188.5400n 0.000019
+ 188.5500n -0.000307 188.5600n -0.000628 188.5700n -0.000940 188.5800n -0.001238 188.5900n -0.001520 188.6000n -0.001782 188.6100n -0.002021 188.6200n -0.002236 188.6300n -0.002424 188.6400n -0.002583 188.6500n -0.002714 188.6600n -0.002816 188.6700n -0.002888 188.6800n -0.002932 188.6900n -0.002947
+ 188.7000n -0.002936 188.7100n -0.002899 188.7200n -0.002839 188.7300n -0.002757 188.7400n -0.002656 188.7500n -0.002537 188.7600n -0.002403 188.7700n -0.002256 188.7800n -0.002099 188.7900n -0.001934 188.8000n -0.001762 188.8100n -0.001585 188.8200n -0.001406 188.8300n -0.001225 188.8400n -0.001044
+ 188.8500n -0.000865 188.8600n -0.000688 188.8700n -0.000513 188.8800n -0.000342 188.8900n -0.000176 188.9000n -0.000013 188.9100n 0.000145 188.9200n 0.000298 188.9300n 0.000447 188.9400n 0.000590 188.9500n 0.000729 188.9600n 0.000863 188.9700n 0.000992 188.9800n 0.001116 188.9900n 0.001234
+ 189.0000n 0.001346 189.0100n 0.001453 189.0200n 0.001552 189.0300n 0.001644 189.0400n 0.001728 189.0500n 0.001804 189.0600n 0.001871 189.0700n 0.001927 189.0800n 0.001973 189.0900n 0.002007 189.1000n 0.002029 189.1100n 0.002038 189.1200n 0.002034 189.1300n 0.002017 189.1400n 0.001986
+ 189.1500n 0.001941 189.1600n 0.001884 189.1700n 0.001813 189.1800n 0.001729 189.1900n 0.001634 189.2000n 0.001528 189.2100n 0.001413 189.2200n 0.001289 189.2300n 0.001159 189.2400n 0.001023 189.2500n 0.000884 189.2600n 0.000743 189.2700n 0.000602 189.2800n 0.000462 189.2900n 0.000326
+ 189.3000n 0.000195 189.3100n 0.000071 189.3200n -0.000046 189.3300n -0.000154 189.3400n -0.000251 189.3500n -0.000338 189.3600n -0.000413 189.3700n -0.000477 189.3800n -0.000529 189.3900n -0.000569 189.4000n -0.000598 189.4100n -0.000616 189.4200n -0.000625 189.4300n -0.000626 189.4400n -0.000618
+ 189.4500n -0.000605 189.4600n -0.000587 189.4700n -0.000565 189.4800n -0.000542 189.4900n -0.000518 189.5000n -0.000495 189.5100n -0.000474 189.5200n -0.000457 189.5300n -0.000443 189.5400n -0.000435 189.5500n -0.000432 189.5600n -0.000435 189.5700n -0.000443 189.5800n -0.000458 189.5900n -0.000479
+ 189.6000n -0.000504 189.6100n -0.000535 189.6200n -0.000568 189.6300n -0.000604 189.6400n -0.000642 189.6500n -0.000679 189.6600n -0.000716 189.6700n -0.000751 189.6800n -0.000782 189.6900n -0.000809 189.7000n -0.000830 189.7100n -0.000845 189.7200n -0.000854 189.7300n -0.000855 189.7400n -0.000849
+ 189.7500n -0.000835 189.7600n -0.000814 189.7700n -0.000787 189.7800n -0.000754 189.7900n -0.000715 189.8000n -0.000674 189.8100n -0.000630 189.8200n -0.000585 189.8300n -0.000541 189.8400n -0.000499 189.8500n -0.000462 189.8600n -0.000430 189.8700n -0.000406 189.8800n -0.000391 189.8900n -0.000386
+ 189.9000n -0.000391 189.9100n -0.000409 189.9200n -0.000439 189.9300n -0.000482 189.9400n -0.000538 189.9500n -0.000606 189.9600n -0.000685 189.9700n -0.000775 189.9800n -0.000873 189.9900n -0.000979 190.0000n -0.001090 190.0100n -0.001204 190.0200n -0.001319 190.0300n -0.001432 190.0400n -0.001541
+ 190.0500n -0.001642 190.0600n -0.001734 190.0700n -0.001814 190.0800n -0.001880 190.0900n -0.001929 190.1000n -0.001961 190.1100n -0.001972 190.1200n -0.001963 190.1300n -0.001933 190.1400n -0.001880 190.1500n -0.001807 190.1600n -0.001712 190.1700n -0.001597 190.1800n -0.001464 190.1900n -0.001314
+ 190.2000n -0.001150 190.2100n -0.000974 190.2200n -0.000789 190.2300n -0.000599 190.2400n -0.000406 190.2500n -0.000214 190.2600n -0.000025 190.2700n 0.000155 190.2800n 0.000326 190.2900n 0.000482 190.3000n 0.000623 190.3100n 0.000745 190.3200n 0.000846 190.3300n 0.000925 190.3400n 0.000982
+ 190.3500n 0.001014 190.3600n 0.001022 190.3700n 0.001007 190.3800n 0.000970 190.3900n 0.000911 190.4000n 0.000834 190.4100n 0.000739 190.4200n 0.000631 190.4300n 0.000511 190.4400n 0.000383 190.4500n 0.000251 190.4600n 0.000117 190.4700n -0.000014 190.4800n -0.000139 190.4900n -0.000255
+ 190.5000n -0.000359 190.5100n -0.000449 190.5200n -0.000521 190.5300n -0.000575 190.5400n -0.000608 190.5500n -0.000620 190.5600n -0.000610 190.5700n -0.000579 190.5800n -0.000528 190.5900n -0.000458 190.6000n -0.000370 190.6100n -0.000267 190.6200n -0.000153 190.6300n -0.000029 190.6400n 0.000100
+ 190.6500n 0.000230 190.6600n 0.000358 190.6700n 0.000480 190.6800n 0.000591 190.6900n 0.000689 190.7000n 0.000768 190.7100n 0.000827 190.7200n 0.000862 190.7300n 0.000871 190.7400n 0.000851 190.7500n 0.000801 190.7600n 0.000721 190.7700n 0.000611 190.7800n 0.000471 190.7900n 0.000301
+ 190.8000n 0.000105 190.8100n -0.000115 190.8200n -0.000357 190.8300n -0.000616 190.8400n -0.000890 190.8500n -0.001172 190.8600n -0.001459 190.8700n -0.001746 190.8800n -0.002027 190.8900n -0.002297 190.9000n -0.002552 190.9100n -0.002787 190.9200n -0.002997 190.9300n -0.003179 190.9400n -0.003328
+ 190.9500n -0.003442 190.9600n -0.003518 190.9700n -0.003554 190.9800n -0.003550 190.9900n -0.003505 191.0000n -0.003420 191.0100n -0.003296 191.0200n -0.003134 191.0300n -0.002938 191.0400n -0.002710 191.0500n -0.002454 191.0600n -0.002175 191.0700n -0.001878 191.0800n -0.001566 191.0900n -0.001246
+ 191.1000n -0.000924 191.1100n -0.000603 191.1200n -0.000290 191.1300n 0.000010 191.1400n 0.000292 191.1500n 0.000552 191.1600n 0.000787 191.1700n 0.000992 191.1800n 0.001165 191.1900n 0.001303 191.2000n 0.001405 191.2100n 0.001470 191.2200n 0.001499 191.2300n 0.001491 191.2400n 0.001448
+ 191.2500n 0.001373 191.2600n 0.001267 191.2700n 0.001133 191.2800n 0.000976 191.2900n 0.000799 191.3000n 0.000606 191.3100n 0.000403 191.3200n 0.000193 191.3300n -0.000019 191.3400n -0.000228 191.3500n -0.000430 191.3600n -0.000620 191.3700n -0.000796 191.3800n -0.000953 191.3900n -0.001088
+ 191.4000n -0.001199 191.4100n -0.001285 191.4200n -0.001344 191.4300n -0.001375 191.4400n -0.001378 191.4500n -0.001354 191.4600n -0.001304 191.4700n -0.001229 191.4800n -0.001132 191.4900n -0.001015 191.5000n -0.000882 191.5100n -0.000735 191.5200n -0.000578 191.5300n -0.000415 191.5400n -0.000249
+ 191.5500n -0.000085 191.5600n 0.000075 191.5700n 0.000226 191.5800n 0.000366 191.5900n 0.000491 191.6000n 0.000599 191.6100n 0.000687 191.6200n 0.000754 191.6300n 0.000799 191.6400n 0.000821 191.6500n 0.000819 191.6600n 0.000794 191.6700n 0.000746 191.6800n 0.000676 191.6900n 0.000587
+ 191.7000n 0.000480 191.7100n 0.000357 191.7200n 0.000222 191.7300n 0.000076 191.7400n -0.000077 191.7500n -0.000233 191.7600n -0.000391 191.7700n -0.000546 191.7800n -0.000696 191.7900n -0.000837 191.8000n -0.000967 191.8100n -0.001084 191.8200n -0.001185 191.8300n -0.001269 191.8400n -0.001333
+ 191.8500n -0.001377 191.8600n -0.001401 191.8700n -0.001403 191.8800n -0.001384 191.8900n -0.001345 191.9000n -0.001285 191.9100n -0.001207 191.9200n -0.001112 191.9300n -0.001000 191.9400n -0.000875 191.9500n -0.000739 191.9600n -0.000593 191.9700n -0.000440 191.9800n -0.000282 191.9900n -0.000121
+ 192.0000n 0.000039 192.0100n 0.000198 192.0200n 0.000352 192.0300n 0.000500 192.0400n 0.000640 192.0500n 0.000771 192.0600n 0.000892 192.0700n 0.001000 192.0800n 0.001097 192.0900n 0.001180 192.1000n 0.001251 192.1100n 0.001308 192.1200n 0.001352 192.1300n 0.001383 192.1400n 0.001403
+ 192.1500n 0.001411 192.1600n 0.001409 192.1700n 0.001398 192.1800n 0.001378 192.1900n 0.001352 192.2000n 0.001320 192.2100n 0.001283 192.2200n 0.001242 192.2300n 0.001200 192.2400n 0.001156 192.2500n 0.001112 192.2600n 0.001069 192.2700n 0.001027 192.2800n 0.000987 192.2900n 0.000950
+ 192.3000n 0.000916 192.3100n 0.000885 192.3200n 0.000858 192.3300n 0.000834 192.3400n 0.000813 192.3500n 0.000796 192.3600n 0.000781 192.3700n 0.000769 192.3800n 0.000759 192.3900n 0.000751 192.4000n 0.000744 192.4100n 0.000738 192.4200n 0.000731 192.4300n 0.000725 192.4400n 0.000717
+ 192.4500n 0.000709 192.4600n 0.000698 192.4700n 0.000686 192.4800n 0.000671 192.4900n 0.000654 192.5000n 0.000634 192.5100n 0.000611 192.5200n 0.000585 192.5300n 0.000557 192.5400n 0.000526 192.5500n 0.000492 192.5600n 0.000456 192.5700n 0.000418 192.5800n 0.000379 192.5900n 0.000338
+ 192.6000n 0.000296 192.6100n 0.000254 192.6200n 0.000212 192.6300n 0.000171 192.6400n 0.000131 192.6500n 0.000092 192.6600n 0.000055 192.6700n 0.000021 192.6800n -0.000010 192.6900n -0.000038 192.7000n -0.000062 192.7100n -0.000081 192.7200n -0.000096 192.7300n -0.000107 192.7400n -0.000113
+ 192.7500n -0.000113 192.7600n -0.000109 192.7700n -0.000099 192.7800n -0.000085 192.7900n -0.000065 192.8000n -0.000042 192.8100n -0.000014 192.8200n 0.000018 192.8300n 0.000053 192.8400n 0.000091 192.8500n 0.000131 192.8600n 0.000173 192.8700n 0.000215 192.8800n 0.000257 192.8900n 0.000298
+ 192.9000n 0.000337 192.9100n 0.000374 192.9200n 0.000408 192.9300n 0.000437 192.9400n 0.000461 192.9500n 0.000479 192.9600n 0.000491 192.9700n 0.000496 192.9800n 0.000493 192.9900n 0.000483 193.0000n 0.000464 193.0100n 0.000438 193.0200n 0.000403 193.0300n 0.000360 193.0400n 0.000309
+ 193.0500n 0.000252 193.0600n 0.000188 193.0700n 0.000118 193.0800n 0.000044 193.0900n -0.000034 193.1000n -0.000114 193.1100n -0.000195 193.1200n -0.000276 193.1300n -0.000354 193.1400n -0.000430 193.1500n -0.000500 193.1600n -0.000564 193.1700n -0.000621 193.1800n -0.000668 193.1900n -0.000704
+ 193.2000n -0.000729 193.2100n -0.000742 193.2200n -0.000741 193.2300n -0.000727 193.2400n -0.000698 193.2500n -0.000655 193.2600n -0.000598 193.2700n -0.000528 193.2800n -0.000444 193.2900n -0.000348 193.3000n -0.000242 193.3100n -0.000125 193.3200n -0.000001 193.3300n 0.000130 193.3400n 0.000265
+ 193.3500n 0.000403 193.3600n 0.000542 193.3700n 0.000678 193.3800n 0.000811 193.3900n 0.000939 193.4000n 0.001058 193.4100n 0.001169 193.4200n 0.001268 193.4300n 0.001354 193.4400n 0.001426 193.4500n 0.001484 193.4600n 0.001526 193.4700n 0.001552 193.4800n 0.001562 193.4900n 0.001556
+ 193.5000n 0.001534 193.5100n 0.001498 193.5200n 0.001449 193.5300n 0.001387 193.5400n 0.001315 193.5500n 0.001234 193.5600n 0.001146 193.5700n 0.001053 193.5800n 0.000957 193.5900n 0.000861 193.6000n 0.000766 193.6100n 0.000675 193.6200n 0.000590 193.6300n 0.000511 193.6400n 0.000441
+ 193.6500n 0.000382 193.6600n 0.000333 193.6700n 0.000296 193.6800n 0.000270 193.6900n 0.000257 193.7000n 0.000255 193.7100n 0.000265 193.7200n 0.000284 193.7300n 0.000312 193.7400n 0.000346 193.7500n 0.000386 193.7600n 0.000428 193.7700n 0.000471 193.7800n 0.000512 193.7900n 0.000549
+ 193.8000n 0.000579 193.8100n 0.000599 193.8200n 0.000608 193.8300n 0.000603 193.8400n 0.000583 193.8500n 0.000545 193.8600n 0.000489 193.8700n 0.000413 193.8800n 0.000317 193.8900n 0.000201 193.9000n 0.000065 193.9100n -0.000091 193.9200n -0.000264 193.9300n -0.000453 193.9400n -0.000656
+ 193.9500n -0.000871 193.9600n -0.001095 193.9700n -0.001325 193.9800n -0.001557 193.9900n -0.001787 194.0000n -0.002013 194.0100n -0.002230 194.0200n -0.002434 194.0300n -0.002623 194.0400n -0.002792 194.0500n -0.002939 194.0600n -0.003060 194.0700n -0.003154 194.0800n -0.003217 194.0900n -0.003249
+ 194.1000n -0.003249 194.1100n -0.003215 194.1200n -0.003148 194.1300n -0.003048 194.1400n -0.002917 194.1500n -0.002756 194.1600n -0.002568 194.1700n -0.002355 194.1800n -0.002120 194.1900n -0.001867 194.2000n -0.001600 194.2100n -0.001323 194.2200n -0.001041 194.2300n -0.000757 194.2400n -0.000476
+ 194.2500n -0.000203 194.2600n 0.000059 194.2700n 0.000304 194.2800n 0.000530 194.2900n 0.000733 194.3000n 0.000910 194.3100n 0.001058 194.3200n 0.001176 194.3300n 0.001262 194.3400n 0.001315 194.3500n 0.001335 194.3600n 0.001322 194.3700n 0.001278 194.3800n 0.001203 194.3900n 0.001100
+ 194.4000n 0.000971 194.4100n 0.000819 194.4200n 0.000648 194.4300n 0.000460 194.4400n 0.000261 194.4500n 0.000053 194.4600n -0.000158 194.4700n -0.000369 194.4800n -0.000576 194.4900n -0.000774 194.5000n -0.000960 194.5100n -0.001131 194.5200n -0.001284 194.5300n -0.001414 194.5400n -0.001522
+ 194.5500n -0.001604 194.5600n -0.001659 194.5700n -0.001686 194.5800n -0.001686 194.5900n -0.001658 194.6000n -0.001604 194.6100n -0.001523 194.6200n -0.001419 194.6300n -0.001293 194.6400n -0.001148 194.6500n -0.000985 194.6600n -0.000810 194.6700n -0.000623 194.6800n -0.000430 194.6900n -0.000233
+ 194.7000n -0.000036 194.7100n 0.000158 194.7200n 0.000346 194.7300n 0.000525 194.7400n 0.000692 194.7500n 0.000844 194.7600n 0.000980 194.7700n 0.001096 194.7800n 0.001193 194.7900n 0.001269 194.8000n 0.001323 194.8100n 0.001355 194.8200n 0.001365 194.8300n 0.001354 194.8400n 0.001322
+ 194.8500n 0.001271 194.8600n 0.001202 194.8700n 0.001117 194.8800n 0.001019 194.8900n 0.000908 194.9000n 0.000788 194.9100n 0.000661 194.9200n 0.000530 194.9300n 0.000397 194.9400n 0.000264 194.9500n 0.000133 194.9600n 0.000008 194.9700n -0.000110 194.9800n -0.000219 194.9900n -0.000317
+ 195.0000n -0.000403 195.0100n -0.000476 195.0200n -0.000534 195.0300n -0.000577 195.0400n -0.000605 195.0500n -0.000617 195.0600n -0.000613 195.0700n -0.000594 195.0800n -0.000560 195.0900n -0.000512 195.1000n -0.000450 195.1100n -0.000377 195.1200n -0.000292 195.1300n -0.000198 195.1400n -0.000096
+ 195.1500n 0.000013 195.1600n 0.000128 195.1700n 0.000246 195.1800n 0.000366 195.1900n 0.000487 195.2000n 0.000608 195.2100n 0.000726 195.2200n 0.000841 195.2300n 0.000951 195.2400n 0.001056 195.2500n 0.001153 195.2600n 0.001243 195.2700n 0.001324 195.2800n 0.001396 195.2900n 0.001458
+ 195.3000n 0.001510 195.3100n 0.001551 195.3200n 0.001581 195.3300n 0.001600 195.3400n 0.001607 195.3500n 0.001604 195.3600n 0.001591 195.3700n 0.001566 195.3800n 0.001532 195.3900n 0.001489 195.4000n 0.001437 195.4100n 0.001376 195.4200n 0.001308 195.4300n 0.001234 195.4400n 0.001153
+ 195.4500n 0.001068 195.4600n 0.000979 195.4700n 0.000887 195.4800n 0.000793 195.4900n 0.000699 195.5000n 0.000604 195.5100n 0.000510 195.5200n 0.000419 195.5300n 0.000330 195.5400n 0.000245 195.5500n 0.000164 195.5600n 0.000088 195.5700n 0.000018 195.5800n -0.000046 195.5900n -0.000103
+ 195.6000n -0.000154 195.6100n -0.000198 195.6200n -0.000235 195.6300n -0.000266 195.6400n -0.000291 195.6500n -0.000310 195.6600n -0.000324 195.6700n -0.000334 195.6800n -0.000340 195.6900n -0.000343 195.7000n -0.000344 195.7100n -0.000345 195.7200n -0.000345 195.7300n -0.000347 195.7400n -0.000351
+ 195.7500n -0.000358 195.7600n -0.000369 195.7700n -0.000384 195.7800n -0.000405 195.7900n -0.000431 195.8000n -0.000463 195.8100n -0.000501 195.8200n -0.000544 195.8300n -0.000594 195.8400n -0.000648 195.8500n -0.000707 195.8600n -0.000769 195.8700n -0.000833 195.8800n -0.000897 195.8900n -0.000962
+ 195.9000n -0.001023 195.9100n -0.001080 195.9200n -0.001132 195.9300n -0.001175 195.9400n -0.001208 195.9500n -0.001229 195.9600n -0.001237 195.9700n -0.001229 195.9800n -0.001204 195.9900n -0.001161 196.0000n -0.001098 196.0100n -0.001014 196.0200n -0.000910 196.0300n -0.000784 196.0400n -0.000637
+ 196.0500n -0.000469 196.0600n -0.000280 196.0700n -0.000073 196.0800n 0.000151 196.0900n 0.000392 196.1000n 0.000645 196.1100n 0.000910 196.1200n 0.001182 196.1300n 0.001460 196.1400n 0.001740 196.1500n 0.002019 196.1600n 0.002293 196.1700n 0.002558 196.1800n 0.002812 196.1900n 0.003052
+ 196.2000n 0.003273 196.2100n 0.003473 196.2200n 0.003649 196.2300n 0.003799 196.2400n 0.003921 196.2500n 0.004012 196.2600n 0.004072 196.2700n 0.004100 196.2800n 0.004095 196.2900n 0.004057 196.3000n 0.003986 196.3100n 0.003884 196.3200n 0.003752 196.3300n 0.003591 196.3400n 0.003404
+ 196.3500n 0.003192 196.3600n 0.002960 196.3700n 0.002709 196.3800n 0.002443 196.3900n 0.002165 196.4000n 0.001879 196.4100n 0.001587 196.4200n 0.001294 196.4300n 0.001002 196.4400n 0.000715 196.4500n 0.000435 196.4600n 0.000166 196.4700n -0.000091 196.4800n -0.000333 196.4900n -0.000559
+ 196.5000n -0.000766 196.5100n -0.000955 196.5200n -0.001125 196.5300n -0.001274 196.5400n -0.001404 196.5500n -0.001514 196.5600n -0.001606 196.5700n -0.001680 196.5800n -0.001737 196.5900n -0.001779 196.6000n -0.001808 196.6100n -0.001825 196.6200n -0.001831 196.6300n -0.001829 196.6400n -0.001820
+ 196.6500n -0.001806 196.6600n -0.001788 196.6700n -0.001768 196.6800n -0.001747 196.6900n -0.001726 196.7000n -0.001706 196.7100n -0.001687 196.7200n -0.001669 196.7300n -0.001653 196.7400n -0.001638 196.7500n -0.001625 196.7600n -0.001612 196.7700n -0.001598 196.7800n -0.001583 196.7900n -0.001566
+ 196.8000n -0.001545 196.8100n -0.001520 196.8200n -0.001490 196.8300n -0.001452 196.8400n -0.001407 196.8500n -0.001353 196.8600n -0.001290 196.8700n -0.001217 196.8800n -0.001133 196.8900n -0.001039 196.9000n -0.000935 196.9100n -0.000821 196.9200n -0.000697 196.9300n -0.000565 196.9400n -0.000426
+ 196.9500n -0.000280 196.9600n -0.000130 196.9700n 0.000023 196.9800n 0.000177 196.9900n 0.000329 197.0000n 0.000479 197.0100n 0.000623 197.0200n 0.000760 197.0300n 0.000888 197.0400n 0.001004 197.0500n 0.001107 197.0600n 0.001196 197.0700n 0.001268 197.0800n 0.001322 197.0900n 0.001359
+ 197.1000n 0.001376 197.1100n 0.001373 197.1200n 0.001351 197.1300n 0.001309 197.1400n 0.001248 197.1500n 0.001169 197.1600n 0.001072 197.1700n 0.000960 197.1800n 0.000833 197.1900n 0.000694 197.2000n 0.000545 197.2100n 0.000386 197.2200n 0.000222 197.2300n 0.000053 197.2400n -0.000118
+ 197.2500n -0.000288 197.2600n -0.000455 197.2700n -0.000618 197.2800n -0.000774 197.2900n -0.000921 197.3000n -0.001058 197.3100n -0.001183 197.3200n -0.001295 197.3300n -0.001392 197.3400n -0.001475 197.3500n -0.001541 197.3600n -0.001592 197.3700n -0.001626 197.3800n -0.001645 197.3900n -0.001647
+ 197.4000n -0.001634 197.4100n -0.001606 197.4200n -0.001565 197.4300n -0.001510 197.4400n -0.001444 197.4500n -0.001366 197.4600n -0.001279 197.4700n -0.001184 197.4800n -0.001081 197.4900n -0.000972 197.5000n -0.000858 197.5100n -0.000741 197.5200n -0.000621 197.5300n -0.000499 197.5400n -0.000377
+ 197.5500n -0.000254 197.5600n -0.000133 197.5700n -0.000014 197.5800n 0.000103 197.5900n 0.000217 197.6000n 0.000328 197.6100n 0.000434 197.6200n 0.000537 197.6300n 0.000634 197.6400n 0.000726 197.6500n 0.000813 197.6600n 0.000894 197.6700n 0.000969 197.6800n 0.001037 197.6900n 0.001099
+ 197.7000n 0.001153 197.7100n 0.001201 197.7200n 0.001240 197.7300n 0.001271 197.7400n 0.001294 197.7500n 0.001308 197.7600n 0.001314 197.7700n 0.001310 197.7800n 0.001297 197.7900n 0.001274 197.8000n 0.001242 197.8100n 0.001200 197.8200n 0.001148 197.8300n 0.001088 197.8400n 0.001018
+ 197.8500n 0.000940 197.8600n 0.000854 197.8700n 0.000760 197.8800n 0.000660 197.8900n 0.000553 197.9000n 0.000442 197.9100n 0.000326 197.9200n 0.000208 197.9300n 0.000087 197.9400n -0.000034 197.9500n -0.000154 197.9600n -0.000273 197.9700n -0.000388 197.9800n -0.000500 197.9900n -0.000606
+ 198.0000n -0.000706 198.0100n -0.000799 198.0200n -0.000883 198.0300n -0.000959 198.0400n -0.001025 198.0500n -0.001080 198.0600n -0.001125 198.0700n -0.001159 198.0800n -0.001182 198.0900n -0.001194 198.1000n -0.001195 198.1100n -0.001186 198.1200n -0.001167 198.1300n -0.001138 198.1400n -0.001100
+ 198.1500n -0.001053 198.1600n -0.000999 198.1700n -0.000939 198.1800n -0.000872 198.1900n -0.000800 198.2000n -0.000724 198.2100n -0.000645 198.2200n -0.000563 198.2300n -0.000478 198.2400n -0.000393 198.2500n -0.000307 198.2600n -0.000222 198.2700n -0.000137 198.2800n -0.000052 198.2900n 0.000030
+ 198.3000n 0.000111 198.3100n 0.000189 198.3200n 0.000265 198.3300n 0.000339 198.3400n 0.000409 198.3500n 0.000476 198.3600n 0.000540 198.3700n 0.000600 198.3800n 0.000656 198.3900n 0.000707 198.4000n 0.000754 198.4100n 0.000796 198.4200n 0.000833 198.4300n 0.000863 198.4400n 0.000888
+ 198.4500n 0.000905 198.4600n 0.000915 198.4700n 0.000918 198.4800n 0.000911 198.4900n 0.000896 198.5000n 0.000871 198.5100n 0.000837 198.5200n 0.000792 198.5300n 0.000738 198.5400n 0.000672 198.5500n 0.000597 198.5600n 0.000511 198.5700n 0.000416 198.5800n 0.000312 198.5900n 0.000199
+ 198.6000n 0.000078 198.6100n -0.000048 198.6200n -0.000180 198.6300n -0.000315 198.6400n -0.000453 198.6500n -0.000590 198.6600n -0.000726 198.6700n -0.000858 198.6800n -0.000985 198.6900n -0.001104 198.7000n -0.001213 198.7100n -0.001311 198.7200n -0.001395 198.7300n -0.001465 198.7400n -0.001518
+ 198.7500n -0.001553 198.7600n -0.001569 198.7700n -0.001566 198.7800n -0.001543 198.7900n -0.001500 198.8000n -0.001437 198.8100n -0.001355 198.8200n -0.001255 198.8300n -0.001139 198.8400n -0.001007 198.8500n -0.000862 198.8600n -0.000706 198.8700n -0.000541 198.8800n -0.000371 198.8900n -0.000199
+ 198.9000n -0.000027 198.9100n 0.000142 198.9200n 0.000304 198.9300n 0.000456 198.9400n 0.000596 198.9500n 0.000720 198.9600n 0.000827 198.9700n 0.000912 198.9800n 0.000976 198.9900n 0.001016 199.0000n 0.001030 199.0100n 0.001019 199.0200n 0.000981 199.0300n 0.000917 199.0400n 0.000828
+ 199.0500n 0.000714 199.0600n 0.000578 199.0700n 0.000421 199.0800n 0.000245 199.0900n 0.000053 199.1000n -0.000152 199.1100n -0.000367 199.1200n -0.000587 199.1300n -0.000811 199.1400n -0.001033 199.1500n -0.001251 199.1600n -0.001461 199.1700n -0.001659 199.1800n -0.001842 199.1900n -0.002008
+ 199.2000n -0.002154 199.2100n -0.002277 199.2200n -0.002376 199.2300n -0.002450 199.2400n -0.002496 199.2500n -0.002516 199.2600n -0.002509 199.2700n -0.002476 199.2800n -0.002417 199.2900n -0.002335 199.3000n -0.002230 199.3100n -0.002106 199.3200n -0.001964 199.3300n -0.001808 199.3400n -0.001641
+ 199.3500n -0.001465 199.3600n -0.001285 199.3700n -0.001102 199.3800n -0.000922 199.3900n -0.000746 199.4000n -0.000577 199.4100n -0.000418 199.4200n -0.000272 199.4300n -0.000141 199.4400n -0.000025 199.4500n 0.000072 199.4600n 0.000152 199.4700n 0.000212 199.4800n 0.000254 199.4900n 0.000277
+ 199.5000n 0.000282 199.5100n 0.000271 199.5200n 0.000244 199.5300n 0.000204 199.5400n 0.000153 199.5500n 0.000093 199.5600n 0.000026 199.5700n -0.000046 199.5800n -0.000119 199.5900n -0.000191 199.6000n -0.000260 199.6100n -0.000324 199.6200n -0.000380 199.6300n -0.000427 199.6400n -0.000464
+ 199.6500n -0.000488 199.6600n -0.000499 199.6700n -0.000496 199.6800n -0.000479 199.6900n -0.000448 199.7000n -0.000404 199.7100n -0.000347 199.7200n -0.000277 199.7300n -0.000197 199.7400n -0.000108 199.7500n -0.000012 199.7600n 0.000091 199.7700n 0.000196 199.7800n 0.000304 199.7900n 0.000411
+ 199.8000n 0.000516 199.8100n 0.000617 199.8200n 0.000711 199.8300n 0.000798 199.8400n 0.000877 199.8500n 0.000945 199.8600n 0.001001 199.8700n 0.001047 199.8800n 0.001080 199.8900n 0.001101 199.9000n 0.001110 199.9100n 0.001107 199.9200n 0.001094 199.9300n 0.001071 199.9400n 0.001038
+ 199.9500n 0.000999 199.9600n 0.000953 199.9700n 0.000902 199.9800n 0.000849 199.9900n 0.000794 200.0000n 0.000740 )

R1_DAMP b1_src b1_q1 100
R2_DAMP b2_src b2_q2 100
.ends

.subckt p1_noise_amp OUT_P OUT_N IN_P IN_N VCC VSS
* 28 dB (25x) Broadband Preamplifier (2 Cascaded Degenerated HBT Stages)
R_DAMP_IN1 IN_P in_p_q1 100
R_DAMP_IN2 IN_N in_n_q2 100

* Stage 1 (Gain ~ 5.0x)
XQ1 c1_n in_p_q1 e1_1 VSS npn13G2 Nx=2
XQ2 c1_p in_n_q2 e1_2 VSS npn13G2 Nx=2
RE1_1 e1_1 e1_common 15
RE1_2 e1_2 e1_common 15
RC1_1 VCC c1_n 240 m=1
RC1_2 VCC c1_p 240 m=1
R_TAIL1 e1_common VSS 316
C_TAIL_AMP1 e1_common VSS 50f

* Level Shifter 1
XQEF1 VCC c1_p b2_p VSS npn13G2 Nx=1
XQEF2 VCC c1_n b2_n VSS npn13G2 Nx=1
REF1 b2_p VSS 5k m=1
REF2 b2_n VSS 5k m=1

* Stage 2 (Gain ~ 5.0x -> Total Gain = 25x / 28 dB)
XQ3 OUT_N b2_p e2_1 VSS npn13G2 Nx=1
XQ4 OUT_P b2_n e2_2 VSS npn13G2 Nx=1
RE2_1 e2_1 e2_common 15
RE2_2 e2_2 e2_common 15
RC2_1 VCC OUT_N 240 m=1
RC2_2 VCC OUT_P 240 m=1
R_TAIL2 e2_common VSS 316
C_TAIL_AMP2 e2_common VSS 50f
.ends

.subckt p1_comparator PBIT_OUT PBIT_RAW CLK_OUT_DIV IN_P IN_N CLK_P CLK_N VCC_HBT VDD VSS params: trim_val=512
RIN1 IN_P in_p_int 100
RIN2 IN_N in_n_int 100

RCLK1 CLK_P clk_p_int 100
RCLK2 CLK_N clk_n_int 100

* Input Emitter Follower Level Shifter
XQEF_IN1 VCC_HBT in_p_int b_latch_p VSS npn13G2 Nx=1
XQEF_IN2 VCC_HBT in_n_int b_latch_n VSS npn13G2 Nx=1
REF_IN1 b_latch_p VSS 5k m=1
REF_IN2 b_latch_n VSS 5k m=1

* CML Latch
XQCLK_TRACK e_track clk_p_int e_tail VSS npn13G2 Nx=1
XQCLK_LATCH e_latch clk_n_int e_tail VSS npn13G2 Nx=1
ISET e_tail VSS DC 2.0m
C_TAIL_COMP e_tail VSS 50f

* Internal Node Parasitic Capacitances
C_ETRACK e_track VSS 50f
C_ELATCH e_latch VSS 50f

XQ1 c_n b_latch_p e_track VSS npn13G2 Nx=1
XQ2 c_p b_latch_n e_track VSS npn13G2 Nx=1

XQ3 c_n c_p e_latch VSS npn13G2 Nx=1
XQ4 c_p c_n e_latch VSS npn13G2 Nx=1

* 150 Ohm Latch Load Resistors (300 mV CML Swing)
RC1 VCC_HBT c_n 150 m=1
RC2 VCC_HBT c_p 150 m=1

ITRIM_P c_p VSS DC '66.85u + (trim_val - 512) * 0.1307u'
ITRIM_N c_n VSS DC '66.85u - (trim_val - 512) * 0.1307u'

XQEF1 VCC_HBT c_p ef_p VSS npn13G2 Nx=1
XQEF2 VCC_HBT c_n ef_n VSS npn13G2 Nx=1
REF1 ef_p VSS 5k m=1
REF2 ef_n VSS 5k m=1

R1_P ef_p g_p 10k m=1
R2_P g_p VSS 10k m=1
R1_N ef_n g_n 10k m=1
R2_N g_n VSS 10k m=1

XQBUF1 VCC_HBT g_p cml_out_p VSS npn13G2 Nx=1
XQBUF2 VCC_HBT g_n cml_out_n VSS npn13G2 Nx=1
RBUF1 cml_out_p VSS 5k m=1
RBUF2 cml_out_n VSS 5k m=1
.ends

XGEN gen_p gen_n vcc_hbt 0 p1_noise_gen
XAMP amp_p amp_n gen_p gen_n vcc_hbt 0 p1_noise_amp
XCOMP pbit_out raw clk_div amp_p amp_n clk_p clk_n vcc_hbt vdd 0 p1_comparator trim_val=512

VCC_HBT vcc_hbt 0 DC 2.50
VDD vdd 0 DC 1.20

* 5.0 GS/s Clock (T_clk = 200 ps)
VCLK_P clk_p 0 PULSE(0.775 0.925 0p 20p 20p 80p 200p)
VCLK_N clk_n 0 PULSE(0.925 0.775 0p 20p 20p 80p 200p)

.options method=gear reltol=1e-3

.control
op
tran 20p 200n 0 20p
setplot tran1
wrdata run/pbit_stream_swap3_100tone_nyquist.txt v(amp_p) v(amp_n) v(xcomp.c_p) v(xcomp.c_n) v(xcomp.b_latch_p) v(xcomp.b_latch_n)
quit
.endc
.end
