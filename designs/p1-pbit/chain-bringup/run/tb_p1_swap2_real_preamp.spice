* Stage 2 Swap 2: Real HBT Generator + Real HBT Preamplifier (No Clock)
.lib $PDK_ROOT/ihp-sg13g2/libs.tech/ngspice/models/cornerHBT.lib hbt_typ

.subckt p1_noise_gen RAW_NOISE_P RAW_NOISE_N VCC VSS
XQ1 c_n_int b1 e VSS npn13G2 Nx=1
XQ2 c_p_int b2 e VSS npn13G2 Nx=1
RC1 VCC c_n_int 1.0k m=1
RC2 VCC c_p_int 1.0k m=1
R_TAIL e VSS 316

VBM b_cm VSS DC 0.872
R1 b1 b_cm 100
R2 b2 b_cm 100

VN_P RAW_NOISE_P c_p_int DC 0 TRNOISE(5.758m, 20p, 0, 0)
VN_N RAW_NOISE_N c_n_int DC 0 TRNOISE(5.758m, 20p, 0, 0)
.ends

.subckt p1_noise_amp OUT_P OUT_N IN_P IN_N VCC VSS
R_DAMP_IN1 IN_P in_p_q1 100
R_DAMP_IN2 IN_N in_n_q2 100

* Stage 1
XQ1 c1_n in_p_q1 e1_1 VSS npn13G2 Nx=2
XQ2 c1_p in_n_q2 e1_2 VSS npn13G2 Nx=2
RE1_1 e1_1 e1_common 15
RE1_2 e1_2 e1_common 15
RC1_1 VCC c1_n 240 m=1
RC1_2 VCC c1_p 240 m=1
R_TAIL1 e1_common VSS 316

* Level shifter between Stage 1 and Stage 2
XQEF1 VCC c1_p b2_p VSS npn13G2 Nx=1
XQEF2 VCC c1_n b2_n VSS npn13G2 Nx=1
REF1 b2_p VSS 5k m=1
REF2 b2_n VSS 5k m=1

* Stage 2
XQ3 OUT_N b2_p e2_1 VSS npn13G2 Nx=1
XQ4 OUT_P b2_n e2_2 VSS npn13G2 Nx=1
RE2_1 e2_1 e2_common 15
RE2_2 e2_2 e2_common 15
RC2_1 VCC OUT_N 240 m=1
RC2_2 VCC OUT_P 240 m=1
R_TAIL2 e2_common VSS 316
.ends

XGEN gen_p gen_n vcc_hbt 0 p1_noise_gen
XAMP amp_p amp_n gen_p gen_n vcc_hbt 0 p1_noise_amp
VCC_HBT vcc_hbt 0 DC 2.50

.control
op
tran 20p 200n 0 20p
setplot tran1
wrdata run/raw_swap2.txt v(amp_p) v(amp_n) v(gen_p) v(gen_n)
quit
.endc
.end
