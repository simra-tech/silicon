* Stage 2 Swap 1: Real HBT P1_NOISE_GEN + Behavioral Amplifier
.lib $PDK_ROOT/ihp-sg13g2/libs.tech/ngspice/models/cornerHBT.lib hbt_typ

.subckt p1_noise_gen RAW_NOISE_P RAW_NOISE_N VCC VSS
XQ1 c_n_int b1 e VSS npn13G2 Nx=1
XQ2 c_p_int b2 e VSS npn13G2 Nx=1
RC1 VCC c_n_int 1.0k m=1
RC2 VCC c_p_int 1.0k m=1
R_TAIL e VSS 316

VBM b_cm VSS DC 0.872
R1 b1 b_cm 100
R2 b2 b_cm 100

VN_P RAW_NOISE_P c_p_int DC 0 TRNOISE(5.758m, 20p, 0, 0)
VN_N RAW_NOISE_N c_n_int DC 0 TRNOISE(5.758m, 20p, 0, 0)
.ends

XGEN gen_p gen_n vcc_hbt 0 p1_noise_gen
VCC_HBT vcc_hbt 0 DC 2.50

E_AMP amp_diff_raw 0 gen_p gen_n 11.97
R_POLE amp_diff_raw amp_diff_out 100
C_POLE amp_diff_out 0 50.86f

.control
op
tran 20p 200n 0 20p
setplot tran1
wrdata run/raw_swap1.txt v(amp_diff_out) v(gen_p) v(gen_n)
quit
.endc
.end
