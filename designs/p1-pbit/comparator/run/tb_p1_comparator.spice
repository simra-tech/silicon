* P1_COMPARATOR Formal Transient Simulation Deck
.lib $PDK_ROOT/ihp-sg13g2/libs.tech/ngspice/models/cornerHBT.lib hbt_typ
.lib $PDK_ROOT/ihp-sg13g2/libs.tech/ngspice/models/cornerMOSlv.lib mos_tt
.include netlist/schematic/p1_comparator.spice

XCOMP pbit_out pbit_raw in_p in_n clk_p clk_n vcc_hbt vdd 0 p1_comparator

VCC_HBT vcc_hbt 0 DC 2.50
VDD vdd 0 DC 1.20

* 5.0 GS/s Clock Signal (200 ps period)
VCLK_P clk_p 0 PULSE(1.0 1.5 0p 10p 10p 90p 200p)
VCLK_N clk_n 0 PULSE(1.5 1.0 0p 10p 10p 90p 200p)

* 1.25 GHz Differential Input Signal (36.4 mV peak)
VIN_P in_p 0 DC 1.50 SIN(1.50 0.0364 1.25G 0 0)
VIN_N in_n 0 DC 1.50 SIN(1.50 -0.0364 1.25G 0 0)

.control
osdi $PDK_ROOT/ihp-sg13g2/libs.tech/ngspice/osdi/psp103.osdi
op
tran 1p 1.6n

setplot tran1
let vin_diff = v(in_p) - v(in_n)
let vcml_p = v(xcomp.c_p)
let vcml_n = v(xcomp.c_n)
let vcml_diff = vcml_p - vcml_n

print time v(clk_p) vin_diff vcml_diff v(pbit_raw) v(pbit_out)

quit
.endc
.end
