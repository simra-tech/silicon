* 31-Effective-Unit Major-Carry Slice 900uA DC Experiment (Codes 14, 15, 16, 17, w=2.25u)
.lib $PDK_ROOT/libs.tech/ngspice/models/cornerHBT.lib hbt_typ
.lib $PDK_ROOT/libs.tech/ngspice/models/cornerRES.lib res_typ
.lib $PDK_ROOT/libs.tech/ngspice/models/cornerCAP.lib cap_typ
.lib $PDK_ROOT/libs.tech/ngspice/models/cornerMOShv.lib mos_tt
.lib $PDK_ROOT/libs.tech/ngspice/models/cornerMOSlv.lib mos_tt
.lib $PDK_ROOT/libs.tech/ngspice/models/cornerDIO.lib dio_tt

.subckt steer_cell_weighted logic_p logic_n v_ref c_p c_n v_bias VDD VSS PARAMS: n_sink=1 nx_hbt=1
XM_SINK d_sink v_bias VSS VSS sg13_lv_nmos w=2.25u l=1.0u ng=1 m=n_sink
V_SENSE e_st_tail d_sink DC 0.000

XQST_P c_p trim_p_hbt e_st_tail sub! npn13G2 Nx=nx_hbt mm_ok=1
XQST_N c_n trim_n_hbt e_st_tail sub! npn13G2 Nx=nx_hbt mm_ok=1

XR1_P logic_p TRIM_P sub! rppd w=1.0u l=384.6u m=1 b=0 mm_ok=1
XR2_P TRIM_P v_ref sub! rppd w=1.0u l=76.92u m=1 b=0 mm_ok=1

XR1_N logic_n TRIM_N sub! rppd w=1.0u l=384.6u m=1 b=0 mm_ok=1
XR2_N TRIM_N v_ref sub! rppd w=1.0u l=76.92u m=1 b=0 mm_ok=1

V_IB_P TRIM_P trim_p_hbt DC 0.000
V_IB_N TRIM_N trim_n_hbt DC 0.000
.ends

VCC VCC 0 DC 2.500
VDD VDD 0 DC 1.200
VSS VSS 0 DC 0.000

* Explicit Ideal Bias Reference Source (UNIMPLEMENTED in layout)
VREF v_ref 0 DC 0.960

* Gate Bias Voltage for NMOS Sinks
VBIAS v_bias 0 DC 0.25515

* Explicit Shared Collector Common-Mode Voltage Source
VCP c_p 0 DC 2.100
VCN c_n 0 DC 2.100

* Independent Logic Sources for 5 Cells (W16, W8, W4, W2, W1)
VLOGIC_P16 lp16 0 DC 0.000
VLOGIC_N16 ln16 0 DC 1.200

VLOGIC_P8  lp8  0 DC 1.200
VLOGIC_N8  ln8  0 DC 0.000

VLOGIC_P4  lp4  0 DC 1.200
VLOGIC_N4  ln4  0 DC 0.000

VLOGIC_P2  lp2  0 DC 1.200
VLOGIC_N2  ln2  0 DC 0.000

VLOGIC_P1  lp1  0 DC 0.000
VLOGIC_N1  ln1  0 DC 1.200

* Dummy Sweep Source for single-point wrdata
VDUMMY dummy 0 DC 0.0

* Instantiate 5 Cells tied to shared c_p and c_n collectors (No 'PARAMS:' token on instance calls!)
XW16 lp16 ln16 v_ref c_p c_n v_bias VDD VSS steer_cell_weighted n_sink=16 nx_hbt=16
XW8  lp8  ln8  v_ref c_p c_n v_bias VDD VSS steer_cell_weighted n_sink=8  nx_hbt=8
XW4  lp4  ln4  v_ref c_p c_n v_bias VDD VSS steer_cell_weighted n_sink=4  nx_hbt=4
XW2  lp2  ln2  v_ref c_p c_n v_bias VDD VSS steer_cell_weighted n_sink=2  nx_hbt=2
XW1  lp1  ln1  v_ref c_p c_n v_bias VDD VSS steer_cell_weighted n_sink=1  nx_hbt=1

XTAP1 VSS sub! ptap1

.option temp = 27.0
.options rshunt=1e12 method=gear reltol=1e-3 savecurrents

.control
pre_osdi $PDK_ROOT/libs.tech/ngspice/osdi/psp103.osdi
pre_osdi $PDK_ROOT/libs.tech/ngspice/osdi/psp103_nqs.osdi
set filetype=ascii

* --- CODE 14 (P-Units = 14: W8, W4, W2 to P; W16, W1 to N) ---
alter VLOGIC_P16 DC = 0.000
alter VLOGIC_N16 DC = 1.200
alter VLOGIC_P8  DC = 1.200
alter VLOGIC_N8  DC = 0.000
alter VLOGIC_P4  DC = 1.200
alter VLOGIC_N4  DC = 0.000
alter VLOGIC_P2  DC = 1.200
alter VLOGIC_N2  DC = 0.000
alter VLOGIC_P1  DC = 0.000
alter VLOGIC_N1  DC = 1.200
dc VDUMMY 0 0 1
wrdata raw_major_carry_900ua_code14.txt v.xw16.v_sense#branch v.xw8.v_sense#branch v.xw4.v_sense#branch v.xw2.v_sense#branch v.xw1.v_sense#branch vcp#branch vcn#branch vref#branch vlogic_p16#branch vlogic_n16#branch vlogic_p8#branch vlogic_n8#branch vlogic_p4#branch vlogic_n4#branch vlogic_p2#branch vlogic_n2#branch vlogic_p1#branch vlogic_n1#branch v(xw16.trim_p) v(xw16.trim_n) v(xw8.trim_p) v(xw8.trim_n) v(xw4.trim_p) v(xw4.trim_n) v(xw2.trim_p) v(xw2.trim_n) v(xw1.trim_p) v(xw1.trim_n) v(lp16) v(ln16) v(lp8) v(ln8) v(lp4) v(ln4) v(lp2) v(ln2) v(lp1) v(ln1)

* --- CODE 15 (P-Units = 15: W8, W4, W2, W1 to P; W16 to N) ---
alter VLOGIC_P1  DC = 1.200
alter VLOGIC_N1  DC = 0.000
dc VDUMMY 0 0 1
wrdata raw_major_carry_900ua_code15.txt v.xw16.v_sense#branch v.xw8.v_sense#branch v.xw4.v_sense#branch v.xw2.v_sense#branch v.xw1.v_sense#branch vcp#branch vcn#branch vref#branch vlogic_p16#branch vlogic_n16#branch vlogic_p8#branch vlogic_n8#branch vlogic_p4#branch vlogic_n4#branch vlogic_p2#branch vlogic_n2#branch vlogic_p1#branch vlogic_n1#branch v(xw16.trim_p) v(xw16.trim_n) v(xw8.trim_p) v(xw8.trim_n) v(xw4.trim_p) v(xw4.trim_n) v(xw2.trim_p) v(xw2.trim_n) v(xw1.trim_p) v(xw1.trim_n) v(lp16) v(ln16) v(lp8) v(ln8) v(lp4) v(ln4) v(lp2) v(ln2) v(lp1) v(ln1)

* --- CODE 16 (P-Units = 16: W16 to P; W8, W4, W2, W1 to N) ---
alter VLOGIC_P16 DC = 1.200
alter VLOGIC_N16 DC = 0.000
alter VLOGIC_P8  DC = 0.000
alter VLOGIC_N8  DC = 1.200
alter VLOGIC_P4  DC = 0.000
alter VLOGIC_N4  DC = 1.200
alter VLOGIC_P2  DC = 0.000
alter VLOGIC_N2  DC = 1.200
alter VLOGIC_P1  DC = 0.000
alter VLOGIC_N1  DC = 1.200
dc VDUMMY 0 0 1
wrdata raw_major_carry_900ua_code16.txt v.xw16.v_sense#branch v.xw8.v_sense#branch v.xw4.v_sense#branch v.xw2.v_sense#branch v.xw1.v_sense#branch vcp#branch vcn#branch vref#branch vlogic_p16#branch vlogic_n16#branch vlogic_p8#branch vlogic_n8#branch vlogic_p4#branch vlogic_n4#branch vlogic_p2#branch vlogic_n2#branch vlogic_p1#branch vlogic_n1#branch v(xw16.trim_p) v(xw16.trim_n) v(xw8.trim_p) v(xw8.trim_n) v(xw4.trim_p) v(xw4.trim_n) v(xw2.trim_p) v(xw2.trim_n) v(xw1.trim_p) v(xw1.trim_n) v(lp16) v(ln16) v(lp8) v(ln8) v(lp4) v(ln4) v(lp2) v(ln2) v(lp1) v(ln1)

* --- CODE 17 (P-Units = 17: W16, W1 to P; W8, W4, W2 to N) ---
alter VLOGIC_P1  DC = 1.200
alter VLOGIC_N1  DC = 0.000
dc VDUMMY 0 0 1
wrdata raw_major_carry_900ua_code17.txt v.xw16.v_sense#branch v.xw8.v_sense#branch v.xw4.v_sense#branch v.xw2.v_sense#branch v.xw1.v_sense#branch vcp#branch vcn#branch vref#branch vlogic_p16#branch vlogic_n16#branch vlogic_p8#branch vlogic_n8#branch vlogic_p4#branch vlogic_n4#branch vlogic_p2#branch vlogic_n2#branch vlogic_p1#branch vlogic_n1#branch v(xw16.trim_p) v(xw16.trim_n) v(xw8.trim_p) v(xw8.trim_n) v(xw4.trim_p) v(xw4.trim_n) v(xw2.trim_p) v(xw2.trim_n) v(xw1.trim_p) v(xw1.trim_n) v(lp16) v(ln16) v(lp8) v(ln8) v(lp4) v(ln4) v(lp2) v(ln2) v(lp1) v(ln1)

.endc
.end
