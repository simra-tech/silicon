* 33-Point Static Control Curve Differential Current-Steering Trim Experiment (780uA Tail)
.lib $PDK_ROOT/libs.tech/ngspice/models/cornerHBT.lib hbt_typ
.lib $PDK_ROOT/libs.tech/ngspice/models/cornerRES.lib res_typ
.lib $PDK_ROOT/libs.tech/ngspice/models/cornerCAP.lib cap_typ
.lib $PDK_ROOT/libs.tech/ngspice/models/cornerMOShv.lib mos_tt
.lib $PDK_ROOT/libs.tech/ngspice/models/cornerMOSlv.lib mos_tt
.lib $PDK_ROOT/libs.tech/ngspice/models/cornerDIO.lib dio_tt

.include ../p1_noise_amp_export.spice

.subckt p1_comp_33pt_steer PBIT_OUT PBIT_RAW CLK_OUT_DIV IN_P IN_N CLK_P CLK_N TRIM_P TRIM_N VCC_HBT VDD VSS
XRC1 VCC_HBT c_n sub! rppd w=1.0u l=0.838u m=1 b=0 mm_ok=1
XRC2 VCC_HBT c_p sub! rppd w=1.0u l=0.838u m=1 b=0 mm_ok=1
XQ1 c_n IN_P e_track sub! npn13G2 Nx=1 mm_ok=1
XQ2 c_p IN_N e_track sub! npn13G2 Nx=1 mm_ok=1
I_PTAT_TAIL e_track VSS DC 1.958m

XQEF1 VCC_HBT c_p ef_p sub! npn13G2 Nx=1 mm_ok=1
XQEF2 VCC_HBT c_n ef_n sub! npn13G2 Nx=1 mm_ok=1

* Fixed-Tail Differential Current-Steering Trim Cell (Sized I_tail = 0.780 mA)
I_STEER_TAIL e_st_tail VSS DC 0.780m
XQST_P c_p TRIM_P e_st_tail sub! npn13G2 Nx=1 mm_ok=1
XQST_N c_n TRIM_N e_st_tail sub! npn13G2 Nx=1 mm_ok=1

XTAP1 VSS sub! ptap1
.ends

VCC_HBT VCC 0 DC 2.500
VDD VDD 0 DC 1.200
VSS VSS 0 DC 0.000

* Differential Input Driver around 1.440V CM
VCM v_in_cm 0 DC 1.440
VIN_SRC v_in_diff 0 DC 0.0
E_IN_P IN_P v_in_cm v_in_diff 0 +0.5
E_IN_N IN_N v_in_cm v_in_diff 0 -0.5

VCLK_P CLK_P 0 DC 2.500
VCLK_N CLK_N 0 DC 0.000

* Independent Steering Code Base Voltage Sources
VTRIM_P TRIM_P 0 DC 1.000
VTRIM_N TRIM_N 0 DC 1.000

.option temp = 27.0
.options rshunt=1e12 method=gear reltol=1e-3

XCOMP PBIT_OUT PBIT_RAW CLK_OUT_DIV IN_P IN_N CLK_P CLK_N TRIM_P TRIM_N VCC VDD VSS p1_comp_33pt_steer

.control
pre_osdi $PDK_ROOT/libs.tech/ngspice/osdi/psp103.osdi
pre_osdi $PDK_ROOT/libs.tech/ngspice/osdi/psp103_nqs.osdi
set filetype=ascii

* Code 00: VTRIM_DIFF = -0.2000 V
alter VTRIM_P DC = 0.9000
alter VTRIM_N DC = 1.1000
dc VIN_SRC -0.060 0.060 0.0002
wrdata raw_33pt_code_00.txt v(TRIM_P) v(TRIM_N) v(xcomp.c_p) v(xcomp.c_n) v(xcomp.ef_p) v(xcomp.ef_n) i(VCC_HBT)

* Code 01: VTRIM_DIFF = -0.1875 V
alter VTRIM_P DC = 0.9062
alter VTRIM_N DC = 1.0938
dc VIN_SRC -0.060 0.060 0.0002
wrdata raw_33pt_code_01.txt v(TRIM_P) v(TRIM_N) v(xcomp.c_p) v(xcomp.c_n) v(xcomp.ef_p) v(xcomp.ef_n) i(VCC_HBT)

* Code 02: VTRIM_DIFF = -0.1750 V
alter VTRIM_P DC = 0.9125
alter VTRIM_N DC = 1.0875
dc VIN_SRC -0.060 0.060 0.0002
wrdata raw_33pt_code_02.txt v(TRIM_P) v(TRIM_N) v(xcomp.c_p) v(xcomp.c_n) v(xcomp.ef_p) v(xcomp.ef_n) i(VCC_HBT)

* Code 03: VTRIM_DIFF = -0.1625 V
alter VTRIM_P DC = 0.9187
alter VTRIM_N DC = 1.0813
dc VIN_SRC -0.060 0.060 0.0002
wrdata raw_33pt_code_03.txt v(TRIM_P) v(TRIM_N) v(xcomp.c_p) v(xcomp.c_n) v(xcomp.ef_p) v(xcomp.ef_n) i(VCC_HBT)

* Code 04: VTRIM_DIFF = -0.1500 V
alter VTRIM_P DC = 0.9250
alter VTRIM_N DC = 1.0750
dc VIN_SRC -0.060 0.060 0.0002
wrdata raw_33pt_code_04.txt v(TRIM_P) v(TRIM_N) v(xcomp.c_p) v(xcomp.c_n) v(xcomp.ef_p) v(xcomp.ef_n) i(VCC_HBT)

* Code 05: VTRIM_DIFF = -0.1375 V
alter VTRIM_P DC = 0.9313
alter VTRIM_N DC = 1.0688
dc VIN_SRC -0.060 0.060 0.0002
wrdata raw_33pt_code_05.txt v(TRIM_P) v(TRIM_N) v(xcomp.c_p) v(xcomp.c_n) v(xcomp.ef_p) v(xcomp.ef_n) i(VCC_HBT)

* Code 06: VTRIM_DIFF = -0.1250 V
alter VTRIM_P DC = 0.9375
alter VTRIM_N DC = 1.0625
dc VIN_SRC -0.060 0.060 0.0002
wrdata raw_33pt_code_06.txt v(TRIM_P) v(TRIM_N) v(xcomp.c_p) v(xcomp.c_n) v(xcomp.ef_p) v(xcomp.ef_n) i(VCC_HBT)

* Code 07: VTRIM_DIFF = -0.1125 V
alter VTRIM_P DC = 0.9437
alter VTRIM_N DC = 1.0562
dc VIN_SRC -0.060 0.060 0.0002
wrdata raw_33pt_code_07.txt v(TRIM_P) v(TRIM_N) v(xcomp.c_p) v(xcomp.c_n) v(xcomp.ef_p) v(xcomp.ef_n) i(VCC_HBT)

* Code 08: VTRIM_DIFF = -0.1000 V
alter VTRIM_P DC = 0.9500
alter VTRIM_N DC = 1.0500
dc VIN_SRC -0.060 0.060 0.0002
wrdata raw_33pt_code_08.txt v(TRIM_P) v(TRIM_N) v(xcomp.c_p) v(xcomp.c_n) v(xcomp.ef_p) v(xcomp.ef_n) i(VCC_HBT)

* Code 09: VTRIM_DIFF = -0.0875 V
alter VTRIM_P DC = 0.9563
alter VTRIM_N DC = 1.0437
dc VIN_SRC -0.060 0.060 0.0002
wrdata raw_33pt_code_09.txt v(TRIM_P) v(TRIM_N) v(xcomp.c_p) v(xcomp.c_n) v(xcomp.ef_p) v(xcomp.ef_n) i(VCC_HBT)

* Code 10: VTRIM_DIFF = -0.0750 V
alter VTRIM_P DC = 0.9625
alter VTRIM_N DC = 1.0375
dc VIN_SRC -0.060 0.060 0.0002
wrdata raw_33pt_code_10.txt v(TRIM_P) v(TRIM_N) v(xcomp.c_p) v(xcomp.c_n) v(xcomp.ef_p) v(xcomp.ef_n) i(VCC_HBT)

* Code 11: VTRIM_DIFF = -0.0625 V
alter VTRIM_P DC = 0.9688
alter VTRIM_N DC = 1.0312
dc VIN_SRC -0.060 0.060 0.0002
wrdata raw_33pt_code_11.txt v(TRIM_P) v(TRIM_N) v(xcomp.c_p) v(xcomp.c_n) v(xcomp.ef_p) v(xcomp.ef_n) i(VCC_HBT)

* Code 12: VTRIM_DIFF = -0.0500 V
alter VTRIM_P DC = 0.9750
alter VTRIM_N DC = 1.0250
dc VIN_SRC -0.060 0.060 0.0002
wrdata raw_33pt_code_12.txt v(TRIM_P) v(TRIM_N) v(xcomp.c_p) v(xcomp.c_n) v(xcomp.ef_p) v(xcomp.ef_n) i(VCC_HBT)

* Code 13: VTRIM_DIFF = -0.0375 V
alter VTRIM_P DC = 0.9812
alter VTRIM_N DC = 1.0188
dc VIN_SRC -0.060 0.060 0.0002
wrdata raw_33pt_code_13.txt v(TRIM_P) v(TRIM_N) v(xcomp.c_p) v(xcomp.c_n) v(xcomp.ef_p) v(xcomp.ef_n) i(VCC_HBT)

* Code 14: VTRIM_DIFF = -0.0250 V
alter VTRIM_P DC = 0.9875
alter VTRIM_N DC = 1.0125
dc VIN_SRC -0.060 0.060 0.0002
wrdata raw_33pt_code_14.txt v(TRIM_P) v(TRIM_N) v(xcomp.c_p) v(xcomp.c_n) v(xcomp.ef_p) v(xcomp.ef_n) i(VCC_HBT)

* Code 15: VTRIM_DIFF = -0.0125 V
alter VTRIM_P DC = 0.9938
alter VTRIM_N DC = 1.0063
dc VIN_SRC -0.060 0.060 0.0002
wrdata raw_33pt_code_15.txt v(TRIM_P) v(TRIM_N) v(xcomp.c_p) v(xcomp.c_n) v(xcomp.ef_p) v(xcomp.ef_n) i(VCC_HBT)

* Code 16: VTRIM_DIFF = +0.0000 V
alter VTRIM_P DC = 1.0000
alter VTRIM_N DC = 1.0000
dc VIN_SRC -0.060 0.060 0.0002
wrdata raw_33pt_code_16.txt v(TRIM_P) v(TRIM_N) v(xcomp.c_p) v(xcomp.c_n) v(xcomp.ef_p) v(xcomp.ef_n) i(VCC_HBT)

* Code 17: VTRIM_DIFF = +0.0125 V
alter VTRIM_P DC = 1.0063
alter VTRIM_N DC = 0.9938
dc VIN_SRC -0.060 0.060 0.0002
wrdata raw_33pt_code_17.txt v(TRIM_P) v(TRIM_N) v(xcomp.c_p) v(xcomp.c_n) v(xcomp.ef_p) v(xcomp.ef_n) i(VCC_HBT)

* Code 18: VTRIM_DIFF = +0.0250 V
alter VTRIM_P DC = 1.0125
alter VTRIM_N DC = 0.9875
dc VIN_SRC -0.060 0.060 0.0002
wrdata raw_33pt_code_18.txt v(TRIM_P) v(TRIM_N) v(xcomp.c_p) v(xcomp.c_n) v(xcomp.ef_p) v(xcomp.ef_n) i(VCC_HBT)

* Code 19: VTRIM_DIFF = +0.0375 V
alter VTRIM_P DC = 1.0188
alter VTRIM_N DC = 0.9812
dc VIN_SRC -0.060 0.060 0.0002
wrdata raw_33pt_code_19.txt v(TRIM_P) v(TRIM_N) v(xcomp.c_p) v(xcomp.c_n) v(xcomp.ef_p) v(xcomp.ef_n) i(VCC_HBT)

* Code 20: VTRIM_DIFF = +0.0500 V
alter VTRIM_P DC = 1.0250
alter VTRIM_N DC = 0.9750
dc VIN_SRC -0.060 0.060 0.0002
wrdata raw_33pt_code_20.txt v(TRIM_P) v(TRIM_N) v(xcomp.c_p) v(xcomp.c_n) v(xcomp.ef_p) v(xcomp.ef_n) i(VCC_HBT)

* Code 21: VTRIM_DIFF = +0.0625 V
alter VTRIM_P DC = 1.0312
alter VTRIM_N DC = 0.9688
dc VIN_SRC -0.060 0.060 0.0002
wrdata raw_33pt_code_21.txt v(TRIM_P) v(TRIM_N) v(xcomp.c_p) v(xcomp.c_n) v(xcomp.ef_p) v(xcomp.ef_n) i(VCC_HBT)

* Code 22: VTRIM_DIFF = +0.0750 V
alter VTRIM_P DC = 1.0375
alter VTRIM_N DC = 0.9625
dc VIN_SRC -0.060 0.060 0.0002
wrdata raw_33pt_code_22.txt v(TRIM_P) v(TRIM_N) v(xcomp.c_p) v(xcomp.c_n) v(xcomp.ef_p) v(xcomp.ef_n) i(VCC_HBT)

* Code 23: VTRIM_DIFF = +0.0875 V
alter VTRIM_P DC = 1.0437
alter VTRIM_N DC = 0.9563
dc VIN_SRC -0.060 0.060 0.0002
wrdata raw_33pt_code_23.txt v(TRIM_P) v(TRIM_N) v(xcomp.c_p) v(xcomp.c_n) v(xcomp.ef_p) v(xcomp.ef_n) i(VCC_HBT)

* Code 24: VTRIM_DIFF = +0.1000 V
alter VTRIM_P DC = 1.0500
alter VTRIM_N DC = 0.9500
dc VIN_SRC -0.060 0.060 0.0002
wrdata raw_33pt_code_24.txt v(TRIM_P) v(TRIM_N) v(xcomp.c_p) v(xcomp.c_n) v(xcomp.ef_p) v(xcomp.ef_n) i(VCC_HBT)

* Code 25: VTRIM_DIFF = +0.1125 V
alter VTRIM_P DC = 1.0562
alter VTRIM_N DC = 0.9437
dc VIN_SRC -0.060 0.060 0.0002
wrdata raw_33pt_code_25.txt v(TRIM_P) v(TRIM_N) v(xcomp.c_p) v(xcomp.c_n) v(xcomp.ef_p) v(xcomp.ef_n) i(VCC_HBT)

* Code 26: VTRIM_DIFF = +0.1250 V
alter VTRIM_P DC = 1.0625
alter VTRIM_N DC = 0.9375
dc VIN_SRC -0.060 0.060 0.0002
wrdata raw_33pt_code_26.txt v(TRIM_P) v(TRIM_N) v(xcomp.c_p) v(xcomp.c_n) v(xcomp.ef_p) v(xcomp.ef_n) i(VCC_HBT)

* Code 27: VTRIM_DIFF = +0.1375 V
alter VTRIM_P DC = 1.0688
alter VTRIM_N DC = 0.9313
dc VIN_SRC -0.060 0.060 0.0002
wrdata raw_33pt_code_27.txt v(TRIM_P) v(TRIM_N) v(xcomp.c_p) v(xcomp.c_n) v(xcomp.ef_p) v(xcomp.ef_n) i(VCC_HBT)

* Code 28: VTRIM_DIFF = +0.1500 V
alter VTRIM_P DC = 1.0750
alter VTRIM_N DC = 0.9250
dc VIN_SRC -0.060 0.060 0.0002
wrdata raw_33pt_code_28.txt v(TRIM_P) v(TRIM_N) v(xcomp.c_p) v(xcomp.c_n) v(xcomp.ef_p) v(xcomp.ef_n) i(VCC_HBT)

* Code 29: VTRIM_DIFF = +0.1625 V
alter VTRIM_P DC = 1.0813
alter VTRIM_N DC = 0.9187
dc VIN_SRC -0.060 0.060 0.0002
wrdata raw_33pt_code_29.txt v(TRIM_P) v(TRIM_N) v(xcomp.c_p) v(xcomp.c_n) v(xcomp.ef_p) v(xcomp.ef_n) i(VCC_HBT)

* Code 30: VTRIM_DIFF = +0.1750 V
alter VTRIM_P DC = 1.0875
alter VTRIM_N DC = 0.9125
dc VIN_SRC -0.060 0.060 0.0002
wrdata raw_33pt_code_30.txt v(TRIM_P) v(TRIM_N) v(xcomp.c_p) v(xcomp.c_n) v(xcomp.ef_p) v(xcomp.ef_n) i(VCC_HBT)

* Code 31: VTRIM_DIFF = +0.1875 V
alter VTRIM_P DC = 1.0938
alter VTRIM_N DC = 0.9062
dc VIN_SRC -0.060 0.060 0.0002
wrdata raw_33pt_code_31.txt v(TRIM_P) v(TRIM_N) v(xcomp.c_p) v(xcomp.c_n) v(xcomp.ef_p) v(xcomp.ef_n) i(VCC_HBT)

* Code 32: VTRIM_DIFF = +0.2000 V
alter VTRIM_P DC = 1.1000
alter VTRIM_N DC = 0.9000
dc VIN_SRC -0.060 0.060 0.0002
wrdata raw_33pt_code_32.txt v(TRIM_P) v(TRIM_N) v(xcomp.c_p) v(xcomp.c_n) v(xcomp.ef_p) v(xcomp.ef_n) i(VCC_HBT)

.endc
.end
