* Extracted by KLayout with SG13G2 LVS runset on : 04/08/2026 23:05

.SUBCKT C57_SUBSTRATE_TIE_M1B_REPAIR LS_N LS_P NOISE_AMP_N NOISE_AMP_P VCC_HBT
+ VSS c_n c_p e_track
R$1 VSS \$1 ptap1 A=4p P=8u
R$2 VSS LS_P \$1 rppd w=1u l=3.85u ps=0u b=0 m=1
R$3 VSS LS_N \$1 rppd w=1u l=3.85u ps=0u b=0 m=1
Q$4 VCC_HBT NOISE_AMP_P LS_P \$1 npn13G2 we=70n le=900n Nx=1 m=1
Q$5 VCC_HBT NOISE_AMP_N LS_N \$1 npn13G2 we=70n le=900n Nx=1 m=1
6$6 c_n LS_P e_track \$1 npn13G2v we=120n le=5000n Nx=4 m=1
7$7 c_p LS_N e_track \$1 npn13G2v we=120n le=5000n Nx=4 m=1
.ENDS C57_SUBSTRATE_TIE_M1B_REPAIR
