* Clean 5-Node Extracted PEX Netlist for P1_NOISE_GEN

X0 RAW_NOISE_N VB1 IE VSS npn13G2
X1 RAW_NOISE_P VB2 IE VSS npn13G2
X2 VCC RAW_NOISE_P VSS rppd l=3.85u w=1u
X3 VCC RAW_NOISE_N VSS rppd l=3.85u w=1u

* Extracted Layout Parasitic Capacitances
C_N_VSS RAW_NOISE_N VSS 2.664f
C_P_VSS RAW_NOISE_P VSS 2.664f
C_VB1_VSS VB1 VSS 1.048f
C_VB2_VSS VB2 VSS 1.048f
C_IE_VSS IE VSS 2.961f
C_VCC_VSS VCC VSS 2.395f

C_IE_N IE RAW_NOISE_N 0.171f
C_IE_P IE RAW_NOISE_P 0.171f
C_IE_VB1 IE VB1 0.179f
C_IE_VB2 IE VB2 0.179f
