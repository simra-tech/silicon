* Permanent PVT COLD BCS Corner Simulation Testbench
.lib $PDK_ROOT/ihp-sg13g2/libs.tech/ngspice/models/cornerHBT.lib hbt_bcs
.lib $PDK_ROOT/ihp-sg13g2/libs.tech/ngspice/models/cornerRES.lib res_bcs
.lib $PDK_ROOT/ihp-sg13g2/libs.tech/ngspice/models/cornerCAP.lib cap_bcs

.options rshunt = 1e12

VCC VCC 0 DC 2.625
VSS VSS 0 DC 0.00

VIN_P in_p 0 DC 1.44 AC 0.5
VIN_N in_n 0 DC 1.44 AC -0.5

RS1 in_p RAW_NOISE_P 1059.0
RS2 in_n RAW_NOISE_N 1059.0

.include ./p1_noise_amp_clean.spice

XAMP NOISE_AMP_P NOISE_AMP_N RAW_NOISE_P RAW_NOISE_N VCC VSS p1_noise_amp

.control
set temp = -40
alter xamp.xrbias1.r1 = 1050.0
alter xamp.xrbias2.r1 = 1050.0
op
ac dec 20 1k 100g
let vdiff = v(noise_amp_p) - v(noise_amp_n)
let gain = mag(vdiff)
let db_gain = 20*log10(gain)
print gain[100] db_gain[100]
meas ac f3db when gain=gain[100]/sqrt(2) fall=1
.endc
.end
