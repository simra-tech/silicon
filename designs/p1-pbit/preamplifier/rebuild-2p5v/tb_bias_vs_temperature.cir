* Loaded PVT Corner Sweep Testbench for P1_NOISE_AMP
.lib $PDK_ROOT/ihp-sg13g2/libs.tech/ngspice/models/cornerHBT.lib hbt_typ
.lib $PDK_ROOT/ihp-sg13g2/libs.tech/ngspice/models/cornerRES.lib res_typ
.lib $PDK_ROOT/ihp-sg13g2/libs.tech/ngspice/models/cornerCAP.lib cap_typ

.options rshunt = 1e12

* Supply Voltage 2.50V (Nominal)
VCC VCC 0 DC 2.50
VSS VSS 0 DC 0.00

* Differential AC Input Excitation with Rs = 1059 Ohm Driving Resistance
VIN_P in_p 0 DC 1.44 AC 0.5
VIN_N in_n 0 DC 1.44 AC -0.5

RS1 in_p RAW_NOISE_P 1059.0
RS2 in_n RAW_NOISE_N 1059.0

.include ./p1_noise_amp_clean.spice

XAMP NOISE_AMP_P NOISE_AMP_N RAW_NOISE_P RAW_NOISE_N VCC VSS p1_noise_amp

.control
alter VCC = 2.50
set temp = 27
op
print (2.50-v(xamp.c1_n))/255.0 v(xamp.e1_common) v(xamp.c1_n)
set temp = 125
op
print (2.50-v(xamp.c1_n))/255.0 v(xamp.e1_common) v(xamp.c1_n)
set temp = -40
op
print (2.50-v(xamp.c1_n))/255.0 v(xamp.e1_common) v(xamp.c1_n)
.endc
.end
