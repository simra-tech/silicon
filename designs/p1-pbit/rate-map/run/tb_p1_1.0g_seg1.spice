* Un-Guarded Rate-Scaled Nyquist Rate Map Segment Rate 1.0 GS/s Seg 1 (Seed 1001)
.lib $PDK_ROOT/ihp-sg13g2/libs.tech/ngspice/models/cornerHBT.lib hbt_typ
.lib $PDK_ROOT/ihp-sg13g2/libs.tech/ngspice/models/cornerMOSlv.lib mos_tt

.subckt p1_noise_gen RAW_NOISE_P RAW_NOISE_N VCC VSS
XQ1 RAW_NOISE_N b1_q1 e VSS npn13G2 Nx=1
XQ2 RAW_NOISE_P b2_q2 e VSS npn13G2 Nx=1
RC1 VCC RAW_NOISE_N 1.0k m=1
RC2 VCC RAW_NOISE_P 1.0k m=1
R_TAIL e VSS 316

VBM b_cm VSS DC 0.872

* 1,000-Tone Physical Noise Source (UN-GUARDED, Nyquist = 0.50 GHz)
V_NOISE_P b2_src b_cm DC 0 PWL ( 0.0000n 0.001153 0.0100n 0.001132 0.0200n 0.001109 0.0300n 0.001087 0.0400n 0.001064 0.0500n 0.001040 0.0600n 0.001016 0.0700n 0.000992 0.0800n 0.000967 0.0900n 0.000942 0.1000n 0.000917 0.1100n 0.000891 0.1200n 0.000866 0.1300n 0.000839 0.1400n 0.000813
+ 0.1500n 0.000786 0.1600n 0.000759 0.1700n 0.000732 0.1800n 0.000705 0.1900n 0.000678 0.2000n 0.000650 0.2100n 0.000622 0.2200n 0.000595 0.2300n 0.000567 0.2400n 0.000539 0.2500n 0.000511 0.2600n 0.000483 0.2700n 0.000455 0.2800n 0.000427 0.2900n 0.000399
+ 0.3000n 0.000371 0.3100n 0.000343 0.3200n 0.000315 0.3300n 0.000287 0.3400n 0.000260 0.3500n 0.000232 0.3600n 0.000205 0.3700n 0.000178 0.3800n 0.000151 0.3900n 0.000124 0.4000n 0.000098 0.4100n 0.000071 0.4200n 0.000045 0.4300n 0.000020 0.4400n -0.000006
+ 0.4500n -0.000031 0.4600n -0.000055 0.4700n -0.000080 0.4800n -0.000104 0.4900n -0.000127 0.5000n -0.000150 0.5100n -0.000173 0.5200n -0.000196 0.5300n -0.000218 0.5400n -0.000239 0.5500n -0.000260 0.5600n -0.000280 0.5700n -0.000300 0.5800n -0.000320 0.5900n -0.000339
+ 0.6000n -0.000357 0.6100n -0.000375 0.6200n -0.000392 0.6300n -0.000409 0.6400n -0.000425 0.6500n -0.000441 0.6600n -0.000456 0.6700n -0.000470 0.6800n -0.000484 0.6900n -0.000497 0.7000n -0.000509 0.7100n -0.000521 0.7200n -0.000532 0.7300n -0.000543 0.7400n -0.000553
+ 0.7500n -0.000562 0.7600n -0.000571 0.7700n -0.000578 0.7800n -0.000586 0.7900n -0.000592 0.8000n -0.000598 0.8100n -0.000603 0.8200n -0.000608 0.8300n -0.000612 0.8400n -0.000615 0.8500n -0.000618 0.8600n -0.000620 0.8700n -0.000621 0.8800n -0.000621 0.8900n -0.000621
+ 0.9000n -0.000620 0.9100n -0.000619 0.9200n -0.000617 0.9300n -0.000614 0.9400n -0.000611 0.9500n -0.000607 0.9600n -0.000602 0.9700n -0.000597 0.9800n -0.000591 0.9900n -0.000585 1.0000n -0.000578 1.0100n -0.000570 1.0200n -0.000562 1.0300n -0.000553 1.0400n -0.000544
+ 1.0500n -0.000534 1.0600n -0.000524 1.0700n -0.000513 1.0800n -0.000502 1.0900n -0.000490 1.1000n -0.000478 1.1100n -0.000465 1.1200n -0.000452 1.1300n -0.000438 1.1400n -0.000424 1.1500n -0.000410 1.1600n -0.000395 1.1700n -0.000380 1.1800n -0.000364 1.1900n -0.000349
+ 1.2000n -0.000332 1.2100n -0.000316 1.2200n -0.000299 1.2300n -0.000282 1.2400n -0.000265 1.2500n -0.000247 1.2600n -0.000230 1.2700n -0.000212 1.2800n -0.000194 1.2900n -0.000175 1.3000n -0.000157 1.3100n -0.000139 1.3200n -0.000120 1.3300n -0.000101 1.3400n -0.000083
+ 1.3500n -0.000064 1.3600n -0.000045 1.3700n -0.000026 1.3800n -0.000007 1.3900n 0.000011 1.4000n 0.000030 1.4100n 0.000049 1.4200n 0.000067 1.4300n 0.000086 1.4400n 0.000104 1.4500n 0.000122 1.4600n 0.000140 1.4700n 0.000158 1.4800n 0.000176 1.4900n 0.000193
+ 1.5000n 0.000211 1.5100n 0.000228 1.5200n 0.000245 1.5300n 0.000261 1.5400n 0.000277 1.5500n 0.000293 1.5600n 0.000309 1.5700n 0.000324 1.5800n 0.000339 1.5900n 0.000353 1.6000n 0.000368 1.6100n 0.000381 1.6200n 0.000395 1.6300n 0.000408 1.6400n 0.000420
+ 1.6500n 0.000432 1.6600n 0.000444 1.6700n 0.000455 1.6800n 0.000466 1.6900n 0.000476 1.7000n 0.000486 1.7100n 0.000495 1.7200n 0.000504 1.7300n 0.000512 1.7400n 0.000519 1.7500n 0.000527 1.7600n 0.000533 1.7700n 0.000539 1.7800n 0.000545 1.7900n 0.000550
+ 1.8000n 0.000554 1.8100n 0.000558 1.8200n 0.000562 1.8300n 0.000564 1.8400n 0.000567 1.8500n 0.000568 1.8600n 0.000569 1.8700n 0.000570 1.8800n 0.000570 1.8900n 0.000569 1.9000n 0.000568 1.9100n 0.000567 1.9200n 0.000564 1.9300n 0.000562 1.9400n 0.000558
+ 1.9500n 0.000554 1.9600n 0.000550 1.9700n 0.000545 1.9800n 0.000540 1.9900n 0.000534 2.0000n 0.000527 2.0100n 0.000520 2.0200n 0.000513 2.0300n 0.000505 2.0400n 0.000497 2.0500n 0.000488 2.0600n 0.000478 2.0700n 0.000469 2.0800n 0.000459 2.0900n 0.000448
+ 2.1000n 0.000437 2.1100n 0.000426 2.1200n 0.000414 2.1300n 0.000402 2.1400n 0.000389 2.1500n 0.000377 2.1600n 0.000364 2.1700n 0.000350 2.1800n 0.000336 2.1900n 0.000322 2.2000n 0.000308 2.2100n 0.000294 2.2200n 0.000279 2.2300n 0.000264 2.2400n 0.000249
+ 2.2500n 0.000234 2.2600n 0.000219 2.2700n 0.000203 2.2800n 0.000188 2.2900n 0.000172 2.3000n 0.000156 2.3100n 0.000140 2.3200n 0.000124 2.3300n 0.000108 2.3400n 0.000092 2.3500n 0.000076 2.3600n 0.000061 2.3700n 0.000045 2.3800n 0.000029 2.3900n 0.000013
+ 2.4000n -0.000002 2.4100n -0.000018 2.4200n -0.000033 2.4300n -0.000048 2.4400n -0.000063 2.4500n -0.000078 2.4600n -0.000092 2.4700n -0.000107 2.4800n -0.000121 2.4900n -0.000135 2.5000n -0.000148 2.5100n -0.000161 2.5200n -0.000174 2.5300n -0.000187 2.5400n -0.000199
+ 2.5500n -0.000211 2.5600n -0.000222 2.5700n -0.000233 2.5800n -0.000244 2.5900n -0.000254 2.6000n -0.000264 2.6100n -0.000273 2.6200n -0.000282 2.6300n -0.000291 2.6400n -0.000299 2.6500n -0.000306 2.6600n -0.000313 2.6700n -0.000319 2.6800n -0.000325 2.6900n -0.000330
+ 2.7000n -0.000335 2.7100n -0.000339 2.7200n -0.000343 2.7300n -0.000346 2.7400n -0.000348 2.7500n -0.000350 2.7600n -0.000352 2.7700n -0.000352 2.7800n -0.000352 2.7900n -0.000352 2.8000n -0.000351 2.8100n -0.000349 2.8200n -0.000347 2.8300n -0.000344 2.8400n -0.000340
+ 2.8500n -0.000336 2.8600n -0.000331 2.8700n -0.000326 2.8800n -0.000320 2.8900n -0.000313 2.9000n -0.000306 2.9100n -0.000298 2.9200n -0.000290 2.9300n -0.000281 2.9400n -0.000271 2.9500n -0.000261 2.9600n -0.000251 2.9700n -0.000239 2.9800n -0.000228 2.9900n -0.000215
+ 3.0000n -0.000202 3.0100n -0.000189 3.0200n -0.000175 3.0300n -0.000161 3.0400n -0.000146 3.0500n -0.000131 3.0600n -0.000115 3.0700n -0.000099 3.0800n -0.000082 3.0900n -0.000065 3.1000n -0.000047 3.1100n -0.000029 3.1200n -0.000011 3.1300n 0.000007 3.1400n 0.000026
+ 3.1500n 0.000045 3.1600n 0.000065 3.1700n 0.000085 3.1800n 0.000105 3.1900n 0.000125 3.2000n 0.000146 3.2100n 0.000166 3.2200n 0.000187 3.2300n 0.000208 3.2400n 0.000229 3.2500n 0.000251 3.2600n 0.000272 3.2700n 0.000294 3.2800n 0.000315 3.2900n 0.000337
+ 3.3000n 0.000358 3.3100n 0.000380 3.3200n 0.000401 3.3300n 0.000422 3.3400n 0.000444 3.3500n 0.000465 3.3600n 0.000486 3.3700n 0.000507 3.3800n 0.000527 3.3900n 0.000548 3.4000n 0.000568 3.4100n 0.000588 3.4200n 0.000608 3.4300n 0.000627 3.4400n 0.000647
+ 3.4500n 0.000665 3.4600n 0.000684 3.4700n 0.000702 3.4800n 0.000719 3.4900n 0.000737 3.5000n 0.000753 3.5100n 0.000770 3.5200n 0.000785 3.5300n 0.000801 3.5400n 0.000815 3.5500n 0.000829 3.5600n 0.000843 3.5700n 0.000856 3.5800n 0.000868 3.5900n 0.000880
+ 3.6000n 0.000891 3.6100n 0.000902 3.6200n 0.000911 3.6300n 0.000920 3.6400n 0.000929 3.6500n 0.000936 3.6600n 0.000943 3.6700n 0.000949 3.6800n 0.000954 3.6900n 0.000959 3.7000n 0.000963 3.7100n 0.000966 3.7200n 0.000968 3.7300n 0.000969 3.7400n 0.000969
+ 3.7500n 0.000969 3.7600n 0.000968 3.7700n 0.000965 3.7800n 0.000962 3.7900n 0.000959 3.8000n 0.000954 3.8100n 0.000948 3.8200n 0.000942 3.8300n 0.000934 3.8400n 0.000926 3.8500n 0.000917 3.8600n 0.000906 3.8700n 0.000895 3.8800n 0.000884 3.8900n 0.000871
+ 3.9000n 0.000857 3.9100n 0.000842 3.9200n 0.000827 3.9300n 0.000811 3.9400n 0.000793 3.9500n 0.000775 3.9600n 0.000757 3.9700n 0.000737 3.9800n 0.000716 3.9900n 0.000695 4.0000n 0.000672 4.0100n 0.000649 4.0200n 0.000626 4.0300n 0.000601 4.0400n 0.000576
+ 4.0500n 0.000550 4.0600n 0.000523 4.0700n 0.000495 4.0800n 0.000467 4.0900n 0.000438 4.1000n 0.000408 4.1100n 0.000378 4.1200n 0.000347 4.1300n 0.000316 4.1400n 0.000283 4.1500n 0.000251 4.1600n 0.000218 4.1700n 0.000184 4.1800n 0.000150 4.1900n 0.000115
+ 4.2000n 0.000080 4.2100n 0.000044 4.2200n 0.000009 4.2300n -0.000028 4.2400n -0.000064 4.2500n -0.000101 4.2600n -0.000139 4.2700n -0.000176 4.2800n -0.000214 4.2900n -0.000252 4.3000n -0.000290 4.3100n -0.000328 4.3200n -0.000366 4.3300n -0.000405 4.3400n -0.000443
+ 4.3500n -0.000482 4.3600n -0.000520 4.3700n -0.000559 4.3800n -0.000597 4.3900n -0.000636 4.4000n -0.000674 4.4100n -0.000712 4.4200n -0.000750 4.4300n -0.000787 4.4400n -0.000825 4.4500n -0.000862 4.4600n -0.000899 4.4700n -0.000935 4.4800n -0.000971 4.4900n -0.001007
+ 4.5000n -0.001042 4.5100n -0.001077 4.5200n -0.001111 4.5300n -0.001145 4.5400n -0.001178 4.5500n -0.001210 4.5600n -0.001242 4.5700n -0.001274 4.5800n -0.001304 4.5900n -0.001334 4.6000n -0.001363 4.6100n -0.001392 4.6200n -0.001420 4.6300n -0.001446 4.6400n -0.001473
+ 4.6500n -0.001498 4.6600n -0.001522 4.6700n -0.001546 4.6800n -0.001568 4.6900n -0.001590 4.7000n -0.001610 4.7100n -0.001630 4.7200n -0.001648 4.7300n -0.001666 4.7400n -0.001683 4.7500n -0.001698 4.7600n -0.001713 4.7700n -0.001726 4.7800n -0.001738 4.7900n -0.001749
+ 4.8000n -0.001759 4.8100n -0.001768 4.8200n -0.001775 4.8300n -0.001782 4.8400n -0.001787 4.8500n -0.001791 4.8600n -0.001794 4.8700n -0.001796 4.8800n -0.001796 4.8900n -0.001795 4.9000n -0.001793 4.9100n -0.001790 4.9200n -0.001786 4.9300n -0.001780 4.9400n -0.001773
+ 4.9500n -0.001765 4.9600n -0.001755 4.9700n -0.001745 4.9800n -0.001733 4.9900n -0.001720 5.0000n -0.001705 5.0100n -0.001690 5.0200n -0.001673 5.0300n -0.001655 5.0400n -0.001636 5.0500n -0.001616 5.0600n -0.001594 5.0700n -0.001572 5.0800n -0.001548 5.0900n -0.001523
+ 5.1000n -0.001497 5.1100n -0.001470 5.1200n -0.001441 5.1300n -0.001412 5.1400n -0.001382 5.1500n -0.001350 5.1600n -0.001318 5.1700n -0.001284 5.1800n -0.001250 5.1900n -0.001215 5.2000n -0.001178 5.2100n -0.001141 5.2200n -0.001103 5.2300n -0.001064 5.2400n -0.001025
+ 5.2500n -0.000984 5.2600n -0.000943 5.2700n -0.000901 5.2800n -0.000858 5.2900n -0.000815 5.3000n -0.000771 5.3100n -0.000726 5.3200n -0.000681 5.3300n -0.000635 5.3400n -0.000589 5.3500n -0.000542 5.3600n -0.000495 5.3700n -0.000447 5.3800n -0.000399 5.3900n -0.000351
+ 5.4000n -0.000302 5.4100n -0.000253 5.4200n -0.000203 5.4300n -0.000154 5.4400n -0.000104 5.4500n -0.000054 5.4600n -0.000004 5.4700n 0.000046 5.4800n 0.000096 5.4900n 0.000146 5.5000n 0.000196 5.5100n 0.000246 5.5200n 0.000296 5.5300n 0.000345 5.5400n 0.000395
+ 5.5500n 0.000444 5.5600n 0.000493 5.5700n 0.000542 5.5800n 0.000590 5.5900n 0.000638 5.6000n 0.000686 5.6100n 0.000733 5.6200n 0.000780 5.6300n 0.000826 5.6400n 0.000872 5.6500n 0.000917 5.6600n 0.000962 5.6700n 0.001006 5.6800n 0.001049 5.6900n 0.001092
+ 5.7000n 0.001133 5.7100n 0.001174 5.7200n 0.001215 5.7300n 0.001254 5.7400n 0.001293 5.7500n 0.001330 5.7600n 0.001367 5.7700n 0.001403 5.7800n 0.001438 5.7900n 0.001472 5.8000n 0.001505 5.8100n 0.001537 5.8200n 0.001568 5.8300n 0.001597 5.8400n 0.001626
+ 5.8500n 0.001654 5.8600n 0.001680 5.8700n 0.001705 5.8800n 0.001729 5.8900n 0.001752 5.9000n 0.001774 5.9100n 0.001794 5.9200n 0.001813 5.9300n 0.001831 5.9400n 0.001848 5.9500n 0.001863 5.9600n 0.001877 5.9700n 0.001890 5.9800n 0.001902 5.9900n 0.001912
+ 6.0000n 0.001921 6.0100n 0.001929 6.0200n 0.001935 6.0300n 0.001940 6.0400n 0.001943 6.0500n 0.001946 6.0600n 0.001947 6.0700n 0.001946 6.0800n 0.001945 6.0900n 0.001942 6.1000n 0.001937 6.1100n 0.001932 6.1200n 0.001925 6.1300n 0.001916 6.1400n 0.001907
+ 6.1500n 0.001896 6.1600n 0.001884 6.1700n 0.001871 6.1800n 0.001856 6.1900n 0.001841 6.2000n 0.001824 6.2100n 0.001806 6.2200n 0.001786 6.2300n 0.001766 6.2400n 0.001744 6.2500n 0.001721 6.2600n 0.001698 6.2700n 0.001673 6.2800n 0.001647 6.2900n 0.001620
+ 6.3000n 0.001592 6.3100n 0.001563 6.3200n 0.001533 6.3300n 0.001502 6.3400n 0.001470 6.3500n 0.001438 6.3600n 0.001404 6.3700n 0.001370 6.3800n 0.001335 6.3900n 0.001299 6.4000n 0.001262 6.4100n 0.001225 6.4200n 0.001187 6.4300n 0.001149 6.4400n 0.001109
+ 6.4500n 0.001070 6.4600n 0.001030 6.4700n 0.000989 6.4800n 0.000948 6.4900n 0.000906 6.5000n 0.000864 6.5100n 0.000822 6.5200n 0.000779 6.5300n 0.000736 6.5400n 0.000693 6.5500n 0.000650 6.5600n 0.000606 6.5700n 0.000562 6.5800n 0.000519 6.5900n 0.000475
+ 6.6000n 0.000431 6.6100n 0.000387 6.6200n 0.000343 6.6300n 0.000300 6.6400n 0.000256 6.6500n 0.000213 6.6600n 0.000170 6.6700n 0.000127 6.6800n 0.000084 6.6900n 0.000042 6.7000n -0.000000 6.7100n -0.000042 6.7200n -0.000083 6.7300n -0.000124 6.7400n -0.000164
+ 6.7500n -0.000204 6.7600n -0.000243 6.7700n -0.000282 6.7800n -0.000320 6.7900n -0.000357 6.8000n -0.000394 6.8100n -0.000430 6.8200n -0.000465 6.8300n -0.000500 6.8400n -0.000533 6.8500n -0.000566 6.8600n -0.000598 6.8700n -0.000629 6.8800n -0.000660 6.8900n -0.000689
+ 6.9000n -0.000717 6.9100n -0.000745 6.9200n -0.000771 6.9300n -0.000796 6.9400n -0.000821 6.9500n -0.000844 6.9600n -0.000866 6.9700n -0.000887 6.9800n -0.000907 6.9900n -0.000926 7.0000n -0.000944 7.0100n -0.000960 7.0200n -0.000976 7.0300n -0.000990 7.0400n -0.001003
+ 7.0500n -0.001015 7.0600n -0.001025 7.0700n -0.001035 7.0800n -0.001043 7.0900n -0.001050 7.1000n -0.001055 7.1100n -0.001060 7.1200n -0.001063 7.1300n -0.001065 7.1400n -0.001066 7.1500n -0.001065 7.1600n -0.001063 7.1700n -0.001060 7.1800n -0.001056 7.1900n -0.001051
+ 7.2000n -0.001044 7.2100n -0.001036 7.2200n -0.001027 7.2300n -0.001016 7.2400n -0.001005 7.2500n -0.000992 7.2600n -0.000978 7.2700n -0.000963 7.2800n -0.000947 7.2900n -0.000930 7.3000n -0.000911 7.3100n -0.000892 7.3200n -0.000871 7.3300n -0.000850 7.3400n -0.000827
+ 7.3500n -0.000803 7.3600n -0.000779 7.3700n -0.000753 7.3800n -0.000726 7.3900n -0.000699 7.4000n -0.000670 7.4100n -0.000641 7.4200n -0.000611 7.4300n -0.000580 7.4400n -0.000548 7.4500n -0.000515 7.4600n -0.000482 7.4700n -0.000448 7.4800n -0.000413 7.4900n -0.000378
+ 7.5000n -0.000342 7.5100n -0.000305 7.5200n -0.000268 7.5300n -0.000230 7.5400n -0.000192 7.5500n -0.000153 7.5600n -0.000114 7.5700n -0.000075 7.5800n -0.000035 7.5900n 0.000005 7.6000n 0.000046 7.6100n 0.000086 7.6200n 0.000127 7.6300n 0.000169 7.6400n 0.000210
+ 7.6500n 0.000251 7.6600n 0.000293 7.6700n 0.000334 7.6800n 0.000376 7.6900n 0.000417 7.7000n 0.000459 7.7100n 0.000500 7.7200n 0.000542 7.7300n 0.000583 7.7400n 0.000624 7.7500n 0.000664 7.7600n 0.000705 7.7700n 0.000745 7.7800n 0.000785 7.7900n 0.000824
+ 7.8000n 0.000863 7.8100n 0.000902 7.8200n 0.000940 7.8300n 0.000977 7.8400n 0.001014 7.8500n 0.001051 7.8600n 0.001087 7.8700n 0.001122 7.8800n 0.001157 7.8900n 0.001191 7.9000n 0.001224 7.9100n 0.001256 7.9200n 0.001288 7.9300n 0.001319 7.9400n 0.001349
+ 7.9500n 0.001378 7.9600n 0.001407 7.9700n 0.001434 7.9800n 0.001461 7.9900n 0.001487 8.0000n 0.001512 8.0100n 0.001535 8.0200n 0.001558 8.0300n 0.001580 8.0400n 0.001601 8.0500n 0.001620 8.0600n 0.001639 8.0700n 0.001657 8.0800n 0.001673 8.0900n 0.001688
+ 8.1000n 0.001703 8.1100n 0.001716 8.1200n 0.001728 8.1300n 0.001739 8.1400n 0.001748 8.1500n 0.001757 8.1600n 0.001764 8.1700n 0.001770 8.1800n 0.001775 8.1900n 0.001779 8.2000n 0.001782 8.2100n 0.001783 8.2200n 0.001784 8.2300n 0.001783 8.2400n 0.001781
+ 8.2500n 0.001777 8.2600n 0.001773 8.2700n 0.001767 8.2800n 0.001761 8.2900n 0.001753 8.3000n 0.001744 8.3100n 0.001733 8.3200n 0.001722 8.3300n 0.001709 8.3400n 0.001696 8.3500n 0.001681 8.3600n 0.001665 8.3700n 0.001649 8.3800n 0.001631 8.3900n 0.001612
+ 8.4000n 0.001592 8.4100n 0.001571 8.4200n 0.001549 8.4300n 0.001526 8.4400n 0.001502 8.4500n 0.001477 8.4600n 0.001451 8.4700n 0.001425 8.4800n 0.001397 8.4900n 0.001369 8.5000n 0.001340 8.5100n 0.001310 8.5200n 0.001279 8.5300n 0.001248 8.5400n 0.001216
+ 8.5500n 0.001183 8.5600n 0.001150 8.5700n 0.001115 8.5800n 0.001081 8.5900n 0.001045 8.6000n 0.001010 8.6100n 0.000973 8.6200n 0.000937 8.6300n 0.000899 8.6400n 0.000862 8.6500n 0.000824 8.6600n 0.000785 8.6700n 0.000747 8.6800n 0.000708 8.6900n 0.000668
+ 8.7000n 0.000629 8.7100n 0.000589 8.7200n 0.000549 8.7300n 0.000510 8.7400n 0.000470 8.7500n 0.000429 8.7600n 0.000389 8.7700n 0.000349 8.7800n 0.000309 8.7900n 0.000269 8.8000n 0.000229 8.8100n 0.000189 8.8200n 0.000150 8.8300n 0.000111 8.8400n 0.000071
+ 8.8500n 0.000033 8.8600n -0.000006 8.8700n -0.000044 8.8800n -0.000082 8.8900n -0.000120 8.9000n -0.000157 8.9100n -0.000193 8.9200n -0.000229 8.9300n -0.000265 8.9400n -0.000300 8.9500n -0.000335 8.9600n -0.000369 8.9700n -0.000402 8.9800n -0.000435 8.9900n -0.000467
+ 9.0000n -0.000498 9.0100n -0.000528 9.0200n -0.000558 9.0300n -0.000587 9.0400n -0.000615 9.0500n -0.000643 9.0600n -0.000669 9.0700n -0.000695 9.0800n -0.000720 9.0900n -0.000744 9.1000n -0.000767 9.1100n -0.000789 9.1200n -0.000810 9.1300n -0.000830 9.1400n -0.000850
+ 9.1500n -0.000868 9.1600n -0.000885 9.1700n -0.000901 9.1800n -0.000916 9.1900n -0.000930 9.2000n -0.000943 9.2100n -0.000955 9.2200n -0.000966 9.2300n -0.000976 9.2400n -0.000985 9.2500n -0.000992 9.2600n -0.000999 9.2700n -0.001004 9.2800n -0.001008 9.2900n -0.001012
+ 9.3000n -0.001014 9.3100n -0.001015 9.3200n -0.001014 9.3300n -0.001013 9.3400n -0.001011 9.3500n -0.001007 9.3600n -0.001003 9.3700n -0.000997 9.3800n -0.000990 9.3900n -0.000982 9.4000n -0.000973 9.4100n -0.000963 9.4200n -0.000952 9.4300n -0.000940 9.4400n -0.000927
+ 9.4500n -0.000912 9.4600n -0.000897 9.4700n -0.000881 9.4800n -0.000864 9.4900n -0.000845 9.5000n -0.000826 9.5100n -0.000806 9.5200n -0.000785 9.5300n -0.000763 9.5400n -0.000740 9.5500n -0.000716 9.5600n -0.000691 9.5700n -0.000665 9.5800n -0.000639 9.5900n -0.000612
+ 9.6000n -0.000584 9.6100n -0.000555 9.6200n -0.000525 9.6300n -0.000495 9.6400n -0.000464 9.6500n -0.000432 9.6600n -0.000400 9.6700n -0.000367 9.6800n -0.000334 9.6900n -0.000299 9.7000n -0.000265 9.7100n -0.000229 9.7200n -0.000194 9.7300n -0.000157 9.7400n -0.000121
+ 9.7500n -0.000084 9.7600n -0.000046 9.7700n -0.000008 9.7800n 0.000030 9.7900n 0.000069 9.8000n 0.000108 9.8100n 0.000147 9.8200n 0.000187 9.8300n 0.000226 9.8400n 0.000266 9.8500n 0.000306 9.8600n 0.000346 9.8700n 0.000387 9.8800n 0.000427 9.8900n 0.000468
+ 9.9000n 0.000508 9.9100n 0.000549 9.9200n 0.000589 9.9300n 0.000630 9.9400n 0.000670 9.9500n 0.000711 9.9600n 0.000751 9.9700n 0.000791 9.9800n 0.000831 9.9900n 0.000871 10.0000n 0.000910 10.0100n 0.000950 10.0200n 0.000989 10.0300n 0.001027 10.0400n 0.001066
+ 10.0500n 0.001104 10.0600n 0.001142 10.0700n 0.001179 10.0800n 0.001217 10.0900n 0.001253 10.1000n 0.001290 10.1100n 0.001325 10.1200n 0.001361 10.1300n 0.001396 10.1400n 0.001430 10.1500n 0.001464 10.1600n 0.001497 10.1700n 0.001530 10.1800n 0.001563 10.1900n 0.001594
+ 10.2000n 0.001626 10.2100n 0.001656 10.2200n 0.001686 10.2300n 0.001715 10.2400n 0.001744 10.2500n 0.001772 10.2600n 0.001800 10.2700n 0.001827 10.2800n 0.001853 10.2900n 0.001878 10.3000n 0.001903 10.3100n 0.001927 10.3200n 0.001950 10.3300n 0.001973 10.3400n 0.001995
+ 10.3500n 0.002017 10.3600n 0.002037 10.3700n 0.002057 10.3800n 0.002076 10.3900n 0.002095 10.4000n 0.002113 10.4100n 0.002130 10.4200n 0.002146 10.4300n 0.002162 10.4400n 0.002177 10.4500n 0.002191 10.4600n 0.002204 10.4700n 0.002217 10.4800n 0.002229 10.4900n 0.002241
+ 10.5000n 0.002252 10.5100n 0.002262 10.5200n 0.002271 10.5300n 0.002280 10.5400n 0.002288 10.5500n 0.002296 10.5600n 0.002303 10.5700n 0.002309 10.5800n 0.002315 10.5900n 0.002320 10.6000n 0.002324 10.6100n 0.002328 10.6200n 0.002331 10.6300n 0.002334 10.6400n 0.002336
+ 10.6500n 0.002338 10.6600n 0.002339 10.6700n 0.002339 10.6800n 0.002339 10.6900n 0.002339 10.7000n 0.002338 10.7100n 0.002337 10.7200n 0.002335 10.7300n 0.002333 10.7400n 0.002330 10.7500n 0.002327 10.7600n 0.002324 10.7700n 0.002320 10.7800n 0.002316 10.7900n 0.002312
+ 10.8000n 0.002307 10.8100n 0.002302 10.8200n 0.002297 10.8300n 0.002291 10.8400n 0.002285 10.8500n 0.002279 10.8600n 0.002273 10.8700n 0.002266 10.8800n 0.002259 10.8900n 0.002253 10.9000n 0.002245 10.9100n 0.002238 10.9200n 0.002231 10.9300n 0.002224 10.9400n 0.002216
+ 10.9500n 0.002208 10.9600n 0.002201 10.9700n 0.002193 10.9800n 0.002185 10.9900n 0.002177 11.0000n 0.002169 11.0100n 0.002162 11.0200n 0.002154 11.0300n 0.002146 11.0400n 0.002138 11.0500n 0.002131 11.0600n 0.002123 11.0700n 0.002116 11.0800n 0.002108 11.0900n 0.002101
+ 11.1000n 0.002093 11.1100n 0.002086 11.1200n 0.002079 11.1300n 0.002072 11.1400n 0.002066 11.1500n 0.002059 11.1600n 0.002053 11.1700n 0.002047 11.1800n 0.002041 11.1900n 0.002035 11.2000n 0.002029 11.2100n 0.002024 11.2200n 0.002018 11.2300n 0.002013 11.2400n 0.002008
+ 11.2500n 0.002004 11.2600n 0.001999 11.2700n 0.001995 11.2800n 0.001991 11.2900n 0.001988 11.3000n 0.001984 11.3100n 0.001981 11.3200n 0.001978 11.3300n 0.001975 11.3400n 0.001973 11.3500n 0.001970 11.3600n 0.001968 11.3700n 0.001966 11.3800n 0.001965 11.3900n 0.001963
+ 11.4000n 0.001962 11.4100n 0.001961 11.4200n 0.001960 11.4300n 0.001960 11.4400n 0.001960 11.4500n 0.001959 11.4600n 0.001959 11.4700n 0.001960 11.4800n 0.001960 11.4900n 0.001961 11.5000n 0.001961 11.5100n 0.001962 11.5200n 0.001963 11.5300n 0.001964 11.5400n 0.001966
+ 11.5500n 0.001967 11.5600n 0.001969 11.5700n 0.001970 11.5800n 0.001972 11.5900n 0.001974 11.6000n 0.001976 11.6100n 0.001978 11.6200n 0.001980 11.6300n 0.001982 11.6400n 0.001984 11.6500n 0.001986 11.6600n 0.001988 11.6700n 0.001990 11.6800n 0.001992 11.6900n 0.001994
+ 11.7000n 0.001996 11.7100n 0.001998 11.7200n 0.001999 11.7300n 0.002001 11.7400n 0.002003 11.7500n 0.002004 11.7600n 0.002006 11.7700n 0.002007 11.7800n 0.002008 11.7900n 0.002009 11.8000n 0.002009 11.8100n 0.002010 11.8200n 0.002010 11.8300n 0.002010 11.8400n 0.002010
+ 11.8500n 0.002010 11.8600n 0.002009 11.8700n 0.002008 11.8800n 0.002007 11.8900n 0.002005 11.9000n 0.002003 11.9100n 0.002001 11.9200n 0.001999 11.9300n 0.001996 11.9400n 0.001993 11.9500n 0.001989 11.9600n 0.001985 11.9700n 0.001981 11.9800n 0.001976 11.9900n 0.001971
+ 12.0000n 0.001965 12.0100n 0.001959 12.0200n 0.001953 12.0300n 0.001946 12.0400n 0.001939 12.0500n 0.001931 12.0600n 0.001923 12.0700n 0.001914 12.0800n 0.001905 12.0900n 0.001895 12.1000n 0.001885 12.1100n 0.001874 12.1200n 0.001863 12.1300n 0.001851 12.1400n 0.001839
+ 12.1500n 0.001826 12.1600n 0.001813 12.1700n 0.001799 12.1800n 0.001785 12.1900n 0.001770 12.2000n 0.001754 12.2100n 0.001738 12.2200n 0.001722 12.2300n 0.001705 12.2400n 0.001687 12.2500n 0.001669 12.2600n 0.001651 12.2700n 0.001632 12.2800n 0.001612 12.2900n 0.001592
+ 12.3000n 0.001571 12.3100n 0.001550 12.3200n 0.001528 12.3300n 0.001506 12.3400n 0.001484 12.3500n 0.001460 12.3600n 0.001437 12.3700n 0.001413 12.3800n 0.001388 12.3900n 0.001363 12.4000n 0.001337 12.4100n 0.001311 12.4200n 0.001285 12.4300n 0.001258 12.4400n 0.001231
+ 12.4500n 0.001203 12.4600n 0.001175 12.4700n 0.001147 12.4800n 0.001118 12.4900n 0.001089 12.5000n 0.001059 12.5100n 0.001029 12.5200n 0.000999 12.5300n 0.000968 12.5400n 0.000938 12.5500n 0.000907 12.5600n 0.000875 12.5700n 0.000844 12.5800n 0.000812 12.5900n 0.000780
+ 12.6000n 0.000747 12.6100n 0.000715 12.6200n 0.000682 12.6300n 0.000649 12.6400n 0.000616 12.6500n 0.000583 12.6600n 0.000550 12.6700n 0.000516 12.6800n 0.000483 12.6900n 0.000449 12.7000n 0.000416 12.7100n 0.000382 12.7200n 0.000349 12.7300n 0.000315 12.7400n 0.000281
+ 12.7500n 0.000248 12.7600n 0.000214 12.7700n 0.000181 12.7800n 0.000148 12.7900n 0.000114 12.8000n 0.000081 12.8100n 0.000048 12.8200n 0.000015 12.8300n -0.000017 12.8400n -0.000050 12.8500n -0.000082 12.8600n -0.000114 12.8700n -0.000146 12.8800n -0.000178 12.8900n -0.000209
+ 12.9000n -0.000240 12.9100n -0.000271 12.9200n -0.000301 12.9300n -0.000332 12.9400n -0.000361 12.9500n -0.000391 12.9600n -0.000420 12.9700n -0.000449 12.9800n -0.000477 12.9900n -0.000505 13.0000n -0.000532 13.0100n -0.000559 13.0200n -0.000586 13.0300n -0.000612 13.0400n -0.000638
+ 13.0500n -0.000663 13.0600n -0.000688 13.0700n -0.000712 13.0800n -0.000736 13.0900n -0.000759 13.1000n -0.000782 13.1100n -0.000804 13.1200n -0.000826 13.1300n -0.000847 13.1400n -0.000868 13.1500n -0.000888 13.1600n -0.000907 13.1700n -0.000926 13.1800n -0.000945 13.1900n -0.000962
+ 13.2000n -0.000980 13.2100n -0.000996 13.2200n -0.001012 13.2300n -0.001028 13.2400n -0.001043 13.2500n -0.001057 13.2600n -0.001071 13.2700n -0.001084 13.2800n -0.001097 13.2900n -0.001109 13.3000n -0.001120 13.3100n -0.001131 13.3200n -0.001141 13.3300n -0.001151 13.3400n -0.001160
+ 13.3500n -0.001168 13.3600n -0.001176 13.3700n -0.001184 13.3800n -0.001191 13.3900n -0.001197 13.4000n -0.001203 13.4100n -0.001208 13.4200n -0.001213 13.4300n -0.001217 13.4400n -0.001221 13.4500n -0.001224 13.4600n -0.001227 13.4700n -0.001229 13.4800n -0.001231 13.4900n -0.001233
+ 13.5000n -0.001233 13.5100n -0.001234 13.5200n -0.001234 13.5300n -0.001234 13.5400n -0.001233 13.5500n -0.001232 13.5600n -0.001230 13.5700n -0.001228 13.5800n -0.001226 13.5900n -0.001224 13.6000n -0.001221 13.6100n -0.001218 13.6200n -0.001214 13.6300n -0.001210 13.6400n -0.001207
+ 13.6500n -0.001202 13.6600n -0.001198 13.6700n -0.001193 13.6800n -0.001188 13.6900n -0.001183 13.7000n -0.001178 13.7100n -0.001173 13.7200n -0.001167 13.7300n -0.001161 13.7400n -0.001156 13.7500n -0.001150 13.7600n -0.001144 13.7700n -0.001138 13.7800n -0.001132 13.7900n -0.001126
+ 13.8000n -0.001120 13.8100n -0.001114 13.8200n -0.001108 13.8300n -0.001102 13.8400n -0.001096 13.8500n -0.001090 13.8600n -0.001084 13.8700n -0.001078 13.8800n -0.001073 13.8900n -0.001067 13.9000n -0.001062 13.9100n -0.001057 13.9200n -0.001052 13.9300n -0.001047 13.9400n -0.001043
+ 13.9500n -0.001038 13.9600n -0.001034 13.9700n -0.001030 13.9800n -0.001027 13.9900n -0.001023 14.0000n -0.001020 14.0100n -0.001017 14.0200n -0.001015 14.0300n -0.001012 14.0400n -0.001010 14.0500n -0.001009 14.0600n -0.001008 14.0700n -0.001007 14.0800n -0.001006 14.0900n -0.001006
+ 14.1000n -0.001006 14.1100n -0.001007 14.1200n -0.001007 14.1300n -0.001009 14.1400n -0.001011 14.1500n -0.001013 14.1600n -0.001015 14.1700n -0.001018 14.1800n -0.001021 14.1900n -0.001025 14.2000n -0.001029 14.2100n -0.001034 14.2200n -0.001039 14.2300n -0.001044 14.2400n -0.001050
+ 14.2500n -0.001057 14.2600n -0.001063 14.2700n -0.001070 14.2800n -0.001078 14.2900n -0.001086 14.3000n -0.001094 14.3100n -0.001103 14.3200n -0.001113 14.3300n -0.001122 14.3400n -0.001132 14.3500n -0.001143 14.3600n -0.001154 14.3700n -0.001165 14.3800n -0.001177 14.3900n -0.001189
+ 14.4000n -0.001201 14.4100n -0.001214 14.4200n -0.001227 14.4300n -0.001241 14.4400n -0.001255 14.4500n -0.001269 14.4600n -0.001283 14.4700n -0.001298 14.4800n -0.001313 14.4900n -0.001329 14.5000n -0.001344 14.5100n -0.001360 14.5200n -0.001377 14.5300n -0.001393 14.5400n -0.001410
+ 14.5500n -0.001427 14.5600n -0.001444 14.5700n -0.001461 14.5800n -0.001479 14.5900n -0.001496 14.6000n -0.001514 14.6100n -0.001532 14.6200n -0.001550 14.6300n -0.001568 14.6400n -0.001587 14.6500n -0.001605 14.6600n -0.001624 14.6700n -0.001642 14.6800n -0.001661 14.6900n -0.001679
+ 14.7000n -0.001698 14.7100n -0.001716 14.7200n -0.001735 14.7300n -0.001753 14.7400n -0.001771 14.7500n -0.001790 14.7600n -0.001808 14.7700n -0.001826 14.7800n -0.001844 14.7900n -0.001862 14.8000n -0.001879 14.8100n -0.001897 14.8200n -0.001914 14.8300n -0.001931 14.8400n -0.001948
+ 14.8500n -0.001964 14.8600n -0.001980 14.8700n -0.001996 14.8800n -0.002012 14.8900n -0.002027 14.9000n -0.002043 14.9100n -0.002057 14.9200n -0.002072 14.9300n -0.002086 14.9400n -0.002099 14.9500n -0.002112 14.9600n -0.002125 14.9700n -0.002138 14.9800n -0.002150 14.9900n -0.002161
+ 15.0000n -0.002172 15.0100n -0.002183 15.0200n -0.002193 15.0300n -0.002202 15.0400n -0.002211 15.0500n -0.002220 15.0600n -0.002228 15.0700n -0.002235 15.0800n -0.002242 15.0900n -0.002249 15.1000n -0.002254 15.1100n -0.002260 15.1200n -0.002264 15.1300n -0.002268 15.1400n -0.002272
+ 15.1500n -0.002275 15.1600n -0.002277 15.1700n -0.002279 15.1800n -0.002280 15.1900n -0.002280 15.2000n -0.002280 15.2100n -0.002279 15.2200n -0.002277 15.2300n -0.002275 15.2400n -0.002272 15.2500n -0.002269 15.2600n -0.002265 15.2700n -0.002260 15.2800n -0.002255 15.2900n -0.002249
+ 15.3000n -0.002242 15.3100n -0.002235 15.3200n -0.002227 15.3300n -0.002218 15.3400n -0.002209 15.3500n -0.002199 15.3600n -0.002189 15.3700n -0.002178 15.3800n -0.002166 15.3900n -0.002153 15.4000n -0.002141 15.4100n -0.002127 15.4200n -0.002113 15.4300n -0.002098 15.4400n -0.002083
+ 15.4500n -0.002067 15.4600n -0.002051 15.4700n -0.002034 15.4800n -0.002016 15.4900n -0.001998 15.5000n -0.001980 15.5100n -0.001961 15.5200n -0.001941 15.5300n -0.001921 15.5400n -0.001901 15.5500n -0.001880 15.5600n -0.001858 15.5700n -0.001836 15.5800n -0.001814 15.5900n -0.001791
+ 15.6000n -0.001768 15.6100n -0.001744 15.6200n -0.001721 15.6300n -0.001696 15.6400n -0.001672 15.6500n -0.001647 15.6600n -0.001621 15.6700n -0.001596 15.6800n -0.001570 15.6900n -0.001544 15.7000n -0.001518 15.7100n -0.001491 15.7200n -0.001464 15.7300n -0.001437 15.7400n -0.001410
+ 15.7500n -0.001383 15.7600n -0.001355 15.7700n -0.001327 15.7800n -0.001299 15.7900n -0.001272 15.8000n -0.001244 15.8100n -0.001215 15.8200n -0.001187 15.8300n -0.001159 15.8400n -0.001131 15.8500n -0.001103 15.8600n -0.001074 15.8700n -0.001046 15.8800n -0.001018 15.8900n -0.000990
+ 15.9000n -0.000962 15.9100n -0.000934 15.9200n -0.000906 15.9300n -0.000878 15.9400n -0.000850 15.9500n -0.000823 15.9600n -0.000795 15.9700n -0.000768 15.9800n -0.000741 15.9900n -0.000714 16.0000n -0.000688 16.0100n -0.000661 16.0200n -0.000635 16.0300n -0.000609 16.0400n -0.000584
+ 16.0500n -0.000558 16.0600n -0.000533 16.0700n -0.000508 16.0800n -0.000484 16.0900n -0.000460 16.1000n -0.000436 16.1100n -0.000412 16.1200n -0.000389 16.1300n -0.000366 16.1400n -0.000344 16.1500n -0.000322 16.1600n -0.000300 16.1700n -0.000279 16.1800n -0.000258 16.1900n -0.000237
+ 16.2000n -0.000217 16.2100n -0.000198 16.2200n -0.000178 16.2300n -0.000159 16.2400n -0.000141 16.2500n -0.000123 16.2600n -0.000105 16.2700n -0.000088 16.2800n -0.000071 16.2900n -0.000055 16.3000n -0.000039 16.3100n -0.000024 16.3200n -0.000009 16.3300n 0.000006 16.3400n 0.000020
+ 16.3500n 0.000034 16.3600n 0.000047 16.3700n 0.000059 16.3800n 0.000072 16.3900n 0.000084 16.4000n 0.000095 16.4100n 0.000106 16.4200n 0.000117 16.4300n 0.000127 16.4400n 0.000137 16.4500n 0.000146 16.4600n 0.000155 16.4700n 0.000164 16.4800n 0.000172 16.4900n 0.000180
+ 16.5000n 0.000187 16.5100n 0.000194 16.5200n 0.000201 16.5300n 0.000207 16.5400n 0.000213 16.5500n 0.000218 16.5600n 0.000223 16.5700n 0.000228 16.5800n 0.000233 16.5900n 0.000237 16.6000n 0.000241 16.6100n 0.000245 16.6200n 0.000248 16.6300n 0.000251 16.6400n 0.000254
+ 16.6500n 0.000257 16.6600n 0.000259 16.6700n 0.000261 16.6800n 0.000263 16.6900n 0.000265 16.7000n 0.000266 16.7100n 0.000267 16.7200n 0.000269 16.7300n 0.000269 16.7400n 0.000270 16.7500n 0.000271 16.7600n 0.000271 16.7700n 0.000272 16.7800n 0.000272 16.7900n 0.000272
+ 16.8000n 0.000272 16.8100n 0.000272 16.8200n 0.000272 16.8300n 0.000272 16.8400n 0.000272 16.8500n 0.000272 16.8600n 0.000272 16.8700n 0.000272 16.8800n 0.000272 16.8900n 0.000271 16.9000n 0.000271 16.9100n 0.000271 16.9200n 0.000271 16.9300n 0.000271 16.9400n 0.000271
+ 16.9500n 0.000271 16.9600n 0.000272 16.9700n 0.000272 16.9800n 0.000272 16.9900n 0.000273 17.0000n 0.000274 17.0100n 0.000274 17.0200n 0.000275 17.0300n 0.000276 17.0400n 0.000278 17.0500n 0.000279 17.0600n 0.000281 17.0700n 0.000282 17.0800n 0.000284 17.0900n 0.000286
+ 17.1000n 0.000289 17.1100n 0.000291 17.1200n 0.000294 17.1300n 0.000297 17.1400n 0.000300 17.1500n 0.000303 17.1600n 0.000307 17.1700n 0.000310 17.1800n 0.000314 17.1900n 0.000318 17.2000n 0.000323 17.2100n 0.000327 17.2200n 0.000332 17.2300n 0.000337 17.2400n 0.000343
+ 17.2500n 0.000348 17.2600n 0.000354 17.2700n 0.000360 17.2800n 0.000366 17.2900n 0.000372 17.3000n 0.000379 17.3100n 0.000386 17.3200n 0.000393 17.3300n 0.000400 17.3400n 0.000408 17.3500n 0.000415 17.3600n 0.000423 17.3700n 0.000431 17.3800n 0.000440 17.3900n 0.000448
+ 17.4000n 0.000457 17.4100n 0.000465 17.4200n 0.000474 17.4300n 0.000484 17.4400n 0.000493 17.4500n 0.000502 17.4600n 0.000512 17.4700n 0.000521 17.4800n 0.000531 17.4900n 0.000541 17.5000n 0.000551 17.5100n 0.000561 17.5200n 0.000571 17.5300n 0.000581 17.5400n 0.000591
+ 17.5500n 0.000602 17.5600n 0.000612 17.5700n 0.000622 17.5800n 0.000633 17.5900n 0.000643 17.6000n 0.000653 17.6100n 0.000664 17.6200n 0.000674 17.6300n 0.000684 17.6400n 0.000695 17.6500n 0.000705 17.6600n 0.000715 17.6700n 0.000725 17.6800n 0.000735 17.6900n 0.000744
+ 17.7000n 0.000754 17.7100n 0.000763 17.7200n 0.000773 17.7300n 0.000782 17.7400n 0.000791 17.7500n 0.000800 17.7600n 0.000808 17.7700n 0.000817 17.7800n 0.000825 17.7900n 0.000833 17.8000n 0.000840 17.8100n 0.000848 17.8200n 0.000855 17.8300n 0.000862 17.8400n 0.000868
+ 17.8500n 0.000874 17.8600n 0.000880 17.8700n 0.000886 17.8800n 0.000891 17.8900n 0.000896 17.9000n 0.000900 17.9100n 0.000904 17.9200n 0.000908 17.9300n 0.000911 17.9400n 0.000914 17.9500n 0.000917 17.9600n 0.000919 17.9700n 0.000921 17.9800n 0.000922 17.9900n 0.000923
+ 18.0000n 0.000923 18.0100n 0.000923 18.0200n 0.000922 18.0300n 0.000921 18.0400n 0.000919 18.0500n 0.000917 18.0600n 0.000915 18.0700n 0.000912 18.0800n 0.000908 18.0900n 0.000904 18.1000n 0.000900 18.1100n 0.000895 18.1200n 0.000889 18.1300n 0.000883 18.1400n 0.000876
+ 18.1500n 0.000869 18.1600n 0.000861 18.1700n 0.000853 18.1800n 0.000844 18.1900n 0.000835 18.2000n 0.000825 18.2100n 0.000815 18.2200n 0.000804 18.2300n 0.000793 18.2400n 0.000781 18.2500n 0.000769 18.2600n 0.000756 18.2700n 0.000742 18.2800n 0.000728 18.2900n 0.000714
+ 18.3000n 0.000699 18.3100n 0.000684 18.3200n 0.000668 18.3300n 0.000651 18.3400n 0.000634 18.3500n 0.000617 18.3600n 0.000599 18.3700n 0.000581 18.3800n 0.000562 18.3900n 0.000543 18.4000n 0.000524 18.4100n 0.000504 18.4200n 0.000484 18.4300n 0.000463 18.4400n 0.000442
+ 18.4500n 0.000420 18.4600n 0.000399 18.4700n 0.000376 18.4800n 0.000354 18.4900n 0.000331 18.5000n 0.000308 18.5100n 0.000284 18.5200n 0.000261 18.5300n 0.000237 18.5400n 0.000213 18.5500n 0.000188 18.5600n 0.000163 18.5700n 0.000138 18.5800n 0.000113 18.5900n 0.000088
+ 18.6000n 0.000063 18.6100n 0.000037 18.6200n 0.000011 18.6300n -0.000015 18.6400n -0.000041 18.6500n -0.000067 18.6600n -0.000093 18.6700n -0.000119 18.6800n -0.000145 18.6900n -0.000172 18.7000n -0.000198 18.7100n -0.000224 18.7200n -0.000251 18.7300n -0.000277 18.7400n -0.000303
+ 18.7500n -0.000329 18.7600n -0.000355 18.7700n -0.000381 18.7800n -0.000407 18.7900n -0.000432 18.8000n -0.000458 18.8100n -0.000483 18.8200n -0.000508 18.8300n -0.000533 18.8400n -0.000557 18.8500n -0.000582 18.8600n -0.000606 18.8700n -0.000630 18.8800n -0.000654 18.8900n -0.000677
+ 18.9000n -0.000700 18.9100n -0.000723 18.9200n -0.000745 18.9300n -0.000767 18.9400n -0.000789 18.9500n -0.000810 18.9600n -0.000831 18.9700n -0.000851 18.9800n -0.000871 18.9900n -0.000891 19.0000n -0.000910 19.0100n -0.000929 19.0200n -0.000947 19.0300n -0.000965 19.0400n -0.000982
+ 19.0500n -0.000999 19.0600n -0.001015 19.0700n -0.001031 19.0800n -0.001046 19.0900n -0.001061 19.1000n -0.001075 19.1100n -0.001089 19.1200n -0.001102 19.1300n -0.001114 19.1400n -0.001126 19.1500n -0.001137 19.1600n -0.001148 19.1700n -0.001159 19.1800n -0.001168 19.1900n -0.001177
+ 19.2000n -0.001186 19.2100n -0.001194 19.2200n -0.001201 19.2300n -0.001207 19.2400n -0.001214 19.2500n -0.001219 19.2600n -0.001224 19.2700n -0.001228 19.2800n -0.001232 19.2900n -0.001235 19.3000n -0.001237 19.3100n -0.001239 19.3200n -0.001240 19.3300n -0.001241 19.3400n -0.001241
+ 19.3500n -0.001241 19.3600n -0.001240 19.3700n -0.001238 19.3800n -0.001236 19.3900n -0.001233 19.4000n -0.001230 19.4100n -0.001226 19.4200n -0.001221 19.4300n -0.001216 19.4400n -0.001211 19.4500n -0.001205 19.4600n -0.001198 19.4700n -0.001191 19.4800n -0.001184 19.4900n -0.001176
+ 19.5000n -0.001167 19.5100n -0.001158 19.5200n -0.001149 19.5300n -0.001139 19.5400n -0.001129 19.5500n -0.001118 19.5600n -0.001107 19.5700n -0.001096 19.5800n -0.001084 19.5900n -0.001071 19.6000n -0.001059 19.6100n -0.001046 19.6200n -0.001032 19.6300n -0.001019 19.6400n -0.001005
+ 19.6500n -0.000991 19.6600n -0.000976 19.6700n -0.000961 19.6800n -0.000946 19.6900n -0.000931 19.7000n -0.000916 19.7100n -0.000900 19.7200n -0.000884 19.7300n -0.000868 19.7400n -0.000852 19.7500n -0.000836 19.7600n -0.000819 19.7700n -0.000802 19.7800n -0.000786 19.7900n -0.000769
+ 19.8000n -0.000752 19.8100n -0.000735 19.8200n -0.000718 19.8300n -0.000701 19.8400n -0.000684 19.8500n -0.000667 19.8600n -0.000650 19.8700n -0.000633 19.8800n -0.000616 19.8900n -0.000599 19.9000n -0.000582 19.9100n -0.000566 19.9200n -0.000549 19.9300n -0.000533 19.9400n -0.000516
+ 19.9500n -0.000500 19.9600n -0.000484 19.9700n -0.000468 19.9800n -0.000452 19.9900n -0.000436 20.0000n -0.000421 20.0100n -0.000406 20.0200n -0.000391 20.0300n -0.000376 20.0400n -0.000361 20.0500n -0.000347 20.0600n -0.000333 20.0700n -0.000319 20.0800n -0.000306 20.0900n -0.000292
+ 20.1000n -0.000279 20.1100n -0.000267 20.1200n -0.000254 20.1300n -0.000242 20.1400n -0.000230 20.1500n -0.000219 20.1600n -0.000208 20.1700n -0.000197 20.1800n -0.000186 20.1900n -0.000176 20.2000n -0.000167 20.2100n -0.000157 20.2200n -0.000148 20.2300n -0.000139 20.2400n -0.000131
+ 20.2500n -0.000123 20.2600n -0.000115 20.2700n -0.000108 20.2800n -0.000101 20.2900n -0.000094 20.3000n -0.000088 20.3100n -0.000082 20.3200n -0.000076 20.3300n -0.000071 20.3400n -0.000066 20.3500n -0.000061 20.3600n -0.000057 20.3700n -0.000053 20.3800n -0.000050 20.3900n -0.000046
+ 20.4000n -0.000044 20.4100n -0.000041 20.4200n -0.000039 20.4300n -0.000037 20.4400n -0.000035 20.4500n -0.000034 20.4600n -0.000032 20.4700n -0.000032 20.4800n -0.000031 20.4900n -0.000031 20.5000n -0.000031 20.5100n -0.000031 20.5200n -0.000031 20.5300n -0.000032 20.5400n -0.000033
+ 20.5500n -0.000034 20.5600n -0.000035 20.5700n -0.000037 20.5800n -0.000038 20.5900n -0.000040 20.6000n -0.000042 20.6100n -0.000044 20.6200n -0.000047 20.6300n -0.000049 20.6400n -0.000051 20.6500n -0.000054 20.6600n -0.000057 20.6700n -0.000059 20.6800n -0.000062 20.6900n -0.000065
+ 20.7000n -0.000068 20.7100n -0.000071 20.7200n -0.000074 20.7300n -0.000077 20.7400n -0.000080 20.7500n -0.000082 20.7600n -0.000085 20.7700n -0.000088 20.7800n -0.000091 20.7900n -0.000094 20.8000n -0.000096 20.8100n -0.000099 20.8200n -0.000101 20.8300n -0.000103 20.8400n -0.000105
+ 20.8500n -0.000107 20.8600n -0.000109 20.8700n -0.000111 20.8800n -0.000112 20.8900n -0.000114 20.9000n -0.000115 20.9100n -0.000116 20.9200n -0.000116 20.9300n -0.000117 20.9400n -0.000117 20.9500n -0.000117 20.9600n -0.000116 20.9700n -0.000116 20.9800n -0.000115 20.9900n -0.000114
+ 21.0000n -0.000112 21.0100n -0.000110 21.0200n -0.000108 21.0300n -0.000106 21.0400n -0.000103 21.0500n -0.000100 21.0600n -0.000097 21.0700n -0.000093 21.0800n -0.000089 21.0900n -0.000084 21.1000n -0.000079 21.1100n -0.000074 21.1200n -0.000069 21.1300n -0.000063 21.1400n -0.000056
+ 21.1500n -0.000050 21.1600n -0.000043 21.1700n -0.000035 21.1800n -0.000027 21.1900n -0.000019 21.2000n -0.000010 21.2100n -0.000001 21.2200n 0.000008 21.2300n 0.000018 21.2400n 0.000028 21.2500n 0.000038 21.2600n 0.000049 21.2700n 0.000061 21.2800n 0.000072 21.2900n 0.000085
+ 21.3000n 0.000097 21.3100n 0.000110 21.3200n 0.000123 21.3300n 0.000136 21.3400n 0.000150 21.3500n 0.000165 21.3600n 0.000179 21.3700n 0.000194 21.3800n 0.000209 21.3900n 0.000225 21.4000n 0.000241 21.4100n 0.000257 21.4200n 0.000273 21.4300n 0.000290 21.4400n 0.000307
+ 21.4500n 0.000325 21.4600n 0.000342 21.4700n 0.000360 21.4800n 0.000378 21.4900n 0.000396 21.5000n 0.000415 21.5100n 0.000433 21.5200n 0.000452 21.5300n 0.000472 21.5400n 0.000491 21.5500n 0.000510 21.5600n 0.000530 21.5700n 0.000549 21.5800n 0.000569 21.5900n 0.000589
+ 21.6000n 0.000609 21.6100n 0.000629 21.6200n 0.000650 21.6300n 0.000670 21.6400n 0.000690 21.6500n 0.000710 21.6600n 0.000731 21.6700n 0.000751 21.6800n 0.000771 21.6900n 0.000792 21.7000n 0.000812 21.7100n 0.000832 21.7200n 0.000852 21.7300n 0.000872 21.7400n 0.000892
+ 21.7500n 0.000912 21.7600n 0.000932 21.7700n 0.000951 21.7800n 0.000970 21.7900n 0.000990 21.8000n 0.001009 21.8100n 0.001027 21.8200n 0.001046 21.8300n 0.001064 21.8400n 0.001083 21.8500n 0.001100 21.8600n 0.001118 21.8700n 0.001135 21.8800n 0.001152 21.8900n 0.001169
+ 21.9000n 0.001185 21.9100n 0.001201 21.9200n 0.001217 21.9300n 0.001233 21.9400n 0.001248 21.9500n 0.001262 21.9600n 0.001276 21.9700n 0.001290 21.9800n 0.001304 21.9900n 0.001317 22.0000n 0.001329 22.0100n 0.001341 22.0200n 0.001353 22.0300n 0.001364 22.0400n 0.001375
+ 22.0500n 0.001385 22.0600n 0.001395 22.0700n 0.001405 22.0800n 0.001413 22.0900n 0.001422 22.1000n 0.001430 22.1100n 0.001437 22.1200n 0.001444 22.1300n 0.001450 22.1400n 0.001456 22.1500n 0.001461 22.1600n 0.001466 22.1700n 0.001470 22.1800n 0.001474 22.1900n 0.001477
+ 22.2000n 0.001479 22.2100n 0.001482 22.2200n 0.001483 22.2300n 0.001484 22.2400n 0.001484 22.2500n 0.001484 22.2600n 0.001484 22.2700n 0.001483 22.2800n 0.001481 22.2900n 0.001479 22.3000n 0.001476 22.3100n 0.001473 22.3200n 0.001469 22.3300n 0.001465 22.3400n 0.001460
+ 22.3500n 0.001455 22.3600n 0.001449 22.3700n 0.001443 22.3800n 0.001436 22.3900n 0.001429 22.4000n 0.001421 22.4100n 0.001413 22.4200n 0.001404 22.4300n 0.001395 22.4400n 0.001386 22.4500n 0.001376 22.4600n 0.001366 22.4700n 0.001355 22.4800n 0.001344 22.4900n 0.001333
+ 22.5000n 0.001321 22.5100n 0.001309 22.5200n 0.001296 22.5300n 0.001283 22.5400n 0.001270 22.5500n 0.001257 22.5600n 0.001243 22.5700n 0.001229 22.5800n 0.001215 22.5900n 0.001200 22.6000n 0.001185 22.6100n 0.001170 22.6200n 0.001155 22.6300n 0.001139 22.6400n 0.001124
+ 22.6500n 0.001108 22.6600n 0.001092 22.6700n 0.001076 22.6800n 0.001060 22.6900n 0.001043 22.7000n 0.001027 22.7100n 0.001011 22.7200n 0.000994 22.7300n 0.000977 22.7400n 0.000961 22.7500n 0.000944 22.7600n 0.000927 22.7700n 0.000911 22.7800n 0.000894 22.7900n 0.000878
+ 22.8000n 0.000861 22.8100n 0.000845 22.8200n 0.000828 22.8300n 0.000812 22.8400n 0.000796 22.8500n 0.000780 22.8600n 0.000764 22.8700n 0.000748 22.8800n 0.000733 22.8900n 0.000717 22.9000n 0.000702 22.9100n 0.000687 22.9200n 0.000673 22.9300n 0.000658 22.9400n 0.000644
+ 22.9500n 0.000630 22.9600n 0.000616 22.9700n 0.000603 22.9800n 0.000590 22.9900n 0.000577 23.0000n 0.000565 23.0100n 0.000553 23.0200n 0.000541 23.0300n 0.000530 23.0400n 0.000518 23.0500n 0.000508 23.0600n 0.000497 23.0700n 0.000488 23.0800n 0.000478 23.0900n 0.000469
+ 23.1000n 0.000460 23.1100n 0.000452 23.1200n 0.000444 23.1300n 0.000437 23.1400n 0.000429 23.1500n 0.000423 23.1600n 0.000417 23.1700n 0.000411 23.1800n 0.000406 23.1900n 0.000401 23.2000n 0.000397 23.2100n 0.000393 23.2200n 0.000389 23.2300n 0.000386 23.2400n 0.000384
+ 23.2500n 0.000382 23.2600n 0.000380 23.2700n 0.000379 23.2800n 0.000378 23.2900n 0.000378 23.3000n 0.000378 23.3100n 0.000379 23.3200n 0.000380 23.3300n 0.000382 23.3400n 0.000384 23.3500n 0.000386 23.3600n 0.000389 23.3700n 0.000392 23.3800n 0.000396 23.3900n 0.000400
+ 23.4000n 0.000405 23.4100n 0.000410 23.4200n 0.000415 23.4300n 0.000421 23.4400n 0.000427 23.4500n 0.000433 23.4600n 0.000440 23.4700n 0.000447 23.4800n 0.000455 23.4900n 0.000463 23.5000n 0.000471 23.5100n 0.000480 23.5200n 0.000488 23.5300n 0.000498 23.5400n 0.000507
+ 23.5500n 0.000517 23.5600n 0.000527 23.5700n 0.000537 23.5800n 0.000547 23.5900n 0.000558 23.6000n 0.000569 23.6100n 0.000580 23.6200n 0.000591 23.6300n 0.000603 23.6400n 0.000614 23.6500n 0.000626 23.6600n 0.000638 23.6700n 0.000650 23.6800n 0.000662 23.6900n 0.000674
+ 23.7000n 0.000686 23.7100n 0.000699 23.7200n 0.000711 23.7300n 0.000724 23.7400n 0.000736 23.7500n 0.000748 23.7600n 0.000761 23.7700n 0.000773 23.7800n 0.000786 23.7900n 0.000798 23.8000n 0.000810 23.8100n 0.000823 23.8200n 0.000835 23.8300n 0.000847 23.8400n 0.000859
+ 23.8500n 0.000871 23.8600n 0.000882 23.8700n 0.000894 23.8800n 0.000905 23.8900n 0.000916 23.9000n 0.000927 23.9100n 0.000938 23.9200n 0.000949 23.9300n 0.000959 23.9400n 0.000969 23.9500n 0.000979 23.9600n 0.000989 23.9700n 0.000998 23.9800n 0.001007 23.9900n 0.001016
+ 24.0000n 0.001024 24.0100n 0.001032 24.0200n 0.001040 24.0300n 0.001048 24.0400n 0.001055 24.0500n 0.001062 24.0600n 0.001068 24.0700n 0.001075 24.0800n 0.001080 24.0900n 0.001086 24.1000n 0.001091 24.1100n 0.001096 24.1200n 0.001100 24.1300n 0.001104 24.1400n 0.001107
+ 24.1500n 0.001111 24.1600n 0.001113 24.1700n 0.001116 24.1800n 0.001118 24.1900n 0.001119 24.2000n 0.001120 24.2100n 0.001121 24.2200n 0.001122 24.2300n 0.001121 24.2400n 0.001121 24.2500n 0.001120 24.2600n 0.001119 24.2700n 0.001117 24.2800n 0.001115 24.2900n 0.001113
+ 24.3000n 0.001110 24.3100n 0.001107 24.3200n 0.001103 24.3300n 0.001099 24.3400n 0.001094 24.3500n 0.001090 24.3600n 0.001085 24.3700n 0.001079 24.3800n 0.001073 24.3900n 0.001067 24.4000n 0.001060 24.4100n 0.001054 24.4200n 0.001046 24.4300n 0.001039 24.4400n 0.001031
+ 24.4500n 0.001023 24.4600n 0.001014 24.4700n 0.001006 24.4800n 0.000997 24.4900n 0.000987 24.5000n 0.000978 24.5100n 0.000968 24.5200n 0.000958 24.5300n 0.000948 24.5400n 0.000938 24.5500n 0.000927 24.5600n 0.000916 24.5700n 0.000905 24.5800n 0.000894 24.5900n 0.000883
+ 24.6000n 0.000872 24.6100n 0.000860 24.6200n 0.000849 24.6300n 0.000837 24.6400n 0.000825 24.6500n 0.000813 24.6600n 0.000801 24.6700n 0.000790 24.6800n 0.000778 24.6900n 0.000766 24.7000n 0.000754 24.7100n 0.000742 24.7200n 0.000730 24.7300n 0.000718 24.7400n 0.000706
+ 24.7500n 0.000694 24.7600n 0.000683 24.7700n 0.000671 24.7800n 0.000660 24.7900n 0.000649 24.8000n 0.000637 24.8100n 0.000626 24.8200n 0.000616 24.8300n 0.000605 24.8400n 0.000594 24.8500n 0.000584 24.8600n 0.000574 24.8700n 0.000564 24.8800n 0.000555 24.8900n 0.000546
+ 24.9000n 0.000536 24.9100n 0.000528 24.9200n 0.000519 24.9300n 0.000511 24.9400n 0.000503 24.9500n 0.000496 24.9600n 0.000488 24.9700n 0.000482 24.9800n 0.000475 24.9900n 0.000469 25.0000n 0.000463 25.0100n 0.000458 25.0200n 0.000453 25.0300n 0.000448 25.0400n 0.000444
+ 25.0500n 0.000440 25.0600n 0.000436 25.0700n 0.000433 25.0800n 0.000431 25.0900n 0.000428 25.1000n 0.000427 25.1100n 0.000425 25.1200n 0.000424 25.1300n 0.000424 25.1400n 0.000424 25.1500n 0.000424 25.1600n 0.000425 25.1700n 0.000427 25.1800n 0.000428 25.1900n 0.000431
+ 25.2000n 0.000433 25.2100n 0.000437 25.2200n 0.000440 25.2300n 0.000444 25.2400n 0.000449 25.2500n 0.000454 25.2600n 0.000459 25.2700n 0.000465 25.2800n 0.000471 25.2900n 0.000478 25.3000n 0.000485 25.3100n 0.000492 25.3200n 0.000500 25.3300n 0.000509 25.3400n 0.000518
+ 25.3500n 0.000527 25.3600n 0.000536 25.3700n 0.000546 25.3800n 0.000557 25.3900n 0.000567 25.4000n 0.000578 25.4100n 0.000590 25.4200n 0.000601 25.4300n 0.000613 25.4400n 0.000626 25.4500n 0.000638 25.4600n 0.000651 25.4700n 0.000665 25.4800n 0.000678 25.4900n 0.000692
+ 25.5000n 0.000706 25.5100n 0.000720 25.5200n 0.000735 25.5300n 0.000749 25.5400n 0.000764 25.5500n 0.000779 25.5600n 0.000795 25.5700n 0.000810 25.5800n 0.000826 25.5900n 0.000841 25.6000n 0.000857 25.6100n 0.000873 25.6200n 0.000889 25.6300n 0.000905 25.6400n 0.000921
+ 25.6500n 0.000937 25.6600n 0.000954 25.6700n 0.000970 25.6800n 0.000986 25.6900n 0.001002 25.7000n 0.001018 25.7100n 0.001034 25.7200n 0.001050 25.7300n 0.001066 25.7400n 0.001082 25.7500n 0.001098 25.7600n 0.001113 25.7700n 0.001129 25.7800n 0.001144 25.7900n 0.001159
+ 25.8000n 0.001174 25.8100n 0.001189 25.8200n 0.001203 25.8300n 0.001217 25.8400n 0.001231 25.8500n 0.001245 25.8600n 0.001258 25.8700n 0.001272 25.8800n 0.001285 25.8900n 0.001297 25.9000n 0.001309 25.9100n 0.001321 25.9200n 0.001333 25.9300n 0.001344 25.9400n 0.001355
+ 25.9500n 0.001365 25.9600n 0.001375 25.9700n 0.001385 25.9800n 0.001394 25.9900n 0.001403 26.0000n 0.001412 26.0100n 0.001419 26.0200n 0.001427 26.0300n 0.001434 26.0400n 0.001441 26.0500n 0.001447 26.0600n 0.001452 26.0700n 0.001457 26.0800n 0.001462 26.0900n 0.001466
+ 26.1000n 0.001470 26.1100n 0.001473 26.1200n 0.001476 26.1300n 0.001478 26.1400n 0.001480 26.1500n 0.001481 26.1600n 0.001481 26.1700n 0.001481 26.1800n 0.001481 26.1900n 0.001480 26.2000n 0.001478 26.2100n 0.001476 26.2200n 0.001474 26.2300n 0.001471 26.2400n 0.001467
+ 26.2500n 0.001463 26.2600n 0.001459 26.2700n 0.001454 26.2800n 0.001448 26.2900n 0.001442 26.3000n 0.001436 26.3100n 0.001429 26.3200n 0.001421 26.3300n 0.001413 26.3400n 0.001405 26.3500n 0.001396 26.3600n 0.001386 26.3700n 0.001377 26.3800n 0.001366 26.3900n 0.001356
+ 26.4000n 0.001345 26.4100n 0.001333 26.4200n 0.001321 26.4300n 0.001309 26.4400n 0.001297 26.4500n 0.001284 26.4600n 0.001270 26.4700n 0.001257 26.4800n 0.001243 26.4900n 0.001229 26.5000n 0.001214 26.5100n 0.001199 26.5200n 0.001184 26.5300n 0.001169 26.5400n 0.001153
+ 26.5500n 0.001137 26.5600n 0.001121 26.5700n 0.001105 26.5800n 0.001089 26.5900n 0.001072 26.6000n 0.001056 26.6100n 0.001039 26.6200n 0.001022 26.6300n 0.001005 26.6400n 0.000988 26.6500n 0.000971 26.6600n 0.000954 26.6700n 0.000936 26.6800n 0.000919 26.6900n 0.000902
+ 26.7000n 0.000885 26.7100n 0.000867 26.7200n 0.000850 26.7300n 0.000833 26.7400n 0.000816 26.7500n 0.000799 26.7600n 0.000783 26.7700n 0.000766 26.7800n 0.000749 26.7900n 0.000733 26.8000n 0.000717 26.8100n 0.000701 26.8200n 0.000685 26.8300n 0.000670 26.8400n 0.000655
+ 26.8500n 0.000640 26.8600n 0.000625 26.8700n 0.000610 26.8800n 0.000596 26.8900n 0.000582 26.9000n 0.000569 26.9100n 0.000556 26.9200n 0.000543 26.9300n 0.000531 26.9400n 0.000518 26.9500n 0.000507 26.9600n 0.000496 26.9700n 0.000485 26.9800n 0.000474 26.9900n 0.000464
+ 27.0000n 0.000455 27.0100n 0.000445 27.0200n 0.000437 27.0300n 0.000428 27.0400n 0.000421 27.0500n 0.000413 27.0600n 0.000407 27.0700n 0.000400 27.0800n 0.000395 27.0900n 0.000389 27.1000n 0.000384 27.1100n 0.000380 27.1200n 0.000376 27.1300n 0.000373 27.1400n 0.000370
+ 27.1500n 0.000368 27.1600n 0.000366 27.1700n 0.000365 27.1800n 0.000365 27.1900n 0.000365 27.2000n 0.000365 27.2100n 0.000366 27.2200n 0.000367 27.2300n 0.000369 27.2400n 0.000372 27.2500n 0.000375 27.2600n 0.000378 27.2700n 0.000382 27.2800n 0.000386 27.2900n 0.000391
+ 27.3000n 0.000397 27.3100n 0.000403 27.3200n 0.000409 27.3300n 0.000416 27.3400n 0.000423 27.3500n 0.000431 27.3600n 0.000439 27.3700n 0.000447 27.3800n 0.000456 27.3900n 0.000466 27.4000n 0.000475 27.4100n 0.000485 27.4200n 0.000496 27.4300n 0.000507 27.4400n 0.000518
+ 27.4500n 0.000529 27.4600n 0.000541 27.4700n 0.000553 27.4800n 0.000565 27.4900n 0.000578 27.5000n 0.000591 27.5100n 0.000604 27.5200n 0.000617 27.5300n 0.000630 27.5400n 0.000644 27.5500n 0.000658 27.5600n 0.000672 27.5700n 0.000686 27.5800n 0.000700 27.5900n 0.000714
+ 27.6000n 0.000728 27.6100n 0.000743 27.6200n 0.000757 27.6300n 0.000771 27.6400n 0.000786 27.6500n 0.000800 27.6600n 0.000814 27.6700n 0.000829 27.6800n 0.000843 27.6900n 0.000857 27.7000n 0.000871 27.7100n 0.000884 27.7200n 0.000898 27.7300n 0.000911 27.7400n 0.000925
+ 27.7500n 0.000938 27.7600n 0.000950 27.7700n 0.000963 27.7800n 0.000975 27.7900n 0.000987 27.8000n 0.000998 27.8100n 0.001010 27.8200n 0.001021 27.8300n 0.001031 27.8400n 0.001041 27.8500n 0.001051 27.8600n 0.001060 27.8700n 0.001069 27.8800n 0.001077 27.8900n 0.001085
+ 27.9000n 0.001092 27.9100n 0.001099 27.9200n 0.001106 27.9300n 0.001111 27.9400n 0.001117 27.9500n 0.001121 27.9600n 0.001125 27.9700n 0.001129 27.9800n 0.001132 27.9900n 0.001134 28.0000n 0.001135 28.0100n 0.001136 28.0200n 0.001137 28.0300n 0.001136 28.0400n 0.001135
+ 28.0500n 0.001133 28.0600n 0.001131 28.0700n 0.001128 28.0800n 0.001124 28.0900n 0.001119 28.1000n 0.001114 28.1100n 0.001108 28.1200n 0.001101 28.1300n 0.001094 28.1400n 0.001085 28.1500n 0.001076 28.1600n 0.001067 28.1700n 0.001056 28.1800n 0.001045 28.1900n 0.001033
+ 28.2000n 0.001020 28.2100n 0.001006 28.2200n 0.000992 28.2300n 0.000977 28.2400n 0.000961 28.2500n 0.000944 28.2600n 0.000927 28.2700n 0.000909 28.2800n 0.000890 28.2900n 0.000871 28.3000n 0.000851 28.3100n 0.000830 28.3200n 0.000808 28.3300n 0.000785 28.3400n 0.000762
+ 28.3500n 0.000739 28.3600n 0.000714 28.3700n 0.000689 28.3800n 0.000663 28.3900n 0.000637 28.4000n 0.000610 28.4100n 0.000582 28.4200n 0.000554 28.4300n 0.000525 28.4400n 0.000496 28.4500n 0.000466 28.4600n 0.000435 28.4700n 0.000404 28.4800n 0.000373 28.4900n 0.000341
+ 28.5000n 0.000308 28.5100n 0.000275 28.5200n 0.000242 28.5300n 0.000208 28.5400n 0.000174 28.5500n 0.000139 28.5600n 0.000104 28.5700n 0.000069 28.5800n 0.000033 28.5900n -0.000003 28.6000n -0.000039 28.6100n -0.000075 28.6200n -0.000112 28.6300n -0.000149 28.6400n -0.000186
+ 28.6500n -0.000223 28.6600n -0.000261 28.6700n -0.000298 28.6800n -0.000336 28.6900n -0.000374 28.7000n -0.000412 28.7100n -0.000449 28.7200n -0.000487 28.7300n -0.000525 28.7400n -0.000563 28.7500n -0.000601 28.7600n -0.000638 28.7700n -0.000676 28.7800n -0.000713 28.7900n -0.000751
+ 28.8000n -0.000788 28.8100n -0.000825 28.8200n -0.000861 28.8300n -0.000898 28.8400n -0.000934 28.8500n -0.000970 28.8600n -0.001005 28.8700n -0.001041 28.8800n -0.001076 28.8900n -0.001110 28.9000n -0.001144 28.9100n -0.001178 28.9200n -0.001211 28.9300n -0.001244 28.9400n -0.001276
+ 28.9500n -0.001308 28.9600n -0.001340 28.9700n -0.001371 28.9800n -0.001401 28.9900n -0.001431 29.0000n -0.001460 29.0100n -0.001488 29.0200n -0.001516 29.0300n -0.001543 29.0400n -0.001570 29.0500n -0.001596 29.0600n -0.001621 29.0700n -0.001646 29.0800n -0.001670 29.0900n -0.001693
+ 29.1000n -0.001716 29.1100n -0.001737 29.1200n -0.001758 29.1300n -0.001779 29.1400n -0.001798 29.1500n -0.001817 29.1600n -0.001835 29.1700n -0.001852 29.1800n -0.001869 29.1900n -0.001884 29.2000n -0.001899 29.2100n -0.001913 29.2200n -0.001926 29.2300n -0.001939 29.2400n -0.001950
+ 29.2500n -0.001961 29.2600n -0.001971 29.2700n -0.001980 29.2800n -0.001988 29.2900n -0.001996 29.3000n -0.002002 29.3100n -0.002008 29.3200n -0.002013 29.3300n -0.002017 29.3400n -0.002021 29.3500n -0.002023 29.3600n -0.002025 29.3700n -0.002026 29.3800n -0.002026 29.3900n -0.002026
+ 29.4000n -0.002024 29.4100n -0.002022 29.4200n -0.002020 29.4300n -0.002016 29.4400n -0.002012 29.4500n -0.002007 29.4600n -0.002001 29.4700n -0.001995 29.4800n -0.001988 29.4900n -0.001980 29.5000n -0.001972 29.5100n -0.001963 29.5200n -0.001953 29.5300n -0.001943 29.5400n -0.001932
+ 29.5500n -0.001921 29.5600n -0.001909 29.5700n -0.001897 29.5800n -0.001884 29.5900n -0.001870 29.6000n -0.001856 29.6100n -0.001842 29.6200n -0.001827 29.6300n -0.001812 29.6400n -0.001796 29.6500n -0.001780 29.6600n -0.001763 29.6700n -0.001746 29.6800n -0.001729 29.6900n -0.001712
+ 29.7000n -0.001694 29.7100n -0.001676 29.7200n -0.001658 29.7300n -0.001639 29.7400n -0.001621 29.7500n -0.001602 29.7600n -0.001583 29.7700n -0.001564 29.7800n -0.001544 29.7900n -0.001525 29.8000n -0.001506 29.8100n -0.001486 29.8200n -0.001467 29.8300n -0.001447 29.8400n -0.001428
+ 29.8500n -0.001408 29.8600n -0.001389 29.8700n -0.001369 29.8800n -0.001350 29.8900n -0.001331 29.9000n -0.001312 29.9100n -0.001293 29.9200n -0.001275 29.9300n -0.001256 29.9400n -0.001238 29.9500n -0.001220 29.9600n -0.001202 29.9700n -0.001185 29.9800n -0.001167 29.9900n -0.001150
+ 30.0000n -0.001134 30.0100n -0.001117 30.0200n -0.001102 30.0300n -0.001086 30.0400n -0.001071 30.0500n -0.001056 30.0600n -0.001042 30.0700n -0.001028 30.0800n -0.001014 30.0900n -0.001001 30.1000n -0.000988 30.1100n -0.000976 30.1200n -0.000964 30.1300n -0.000953 30.1400n -0.000943
+ 30.1500n -0.000932 30.1600n -0.000923 30.1700n -0.000913 30.1800n -0.000905 30.1900n -0.000897 30.2000n -0.000889 30.2100n -0.000882 30.2200n -0.000876 30.2300n -0.000870 30.2400n -0.000864 30.2500n -0.000859 30.2600n -0.000855 30.2700n -0.000851 30.2800n -0.000848 30.2900n -0.000845
+ 30.3000n -0.000843 30.3100n -0.000842 30.3200n -0.000841 30.3300n -0.000840 30.3400n -0.000840 30.3500n -0.000841 30.3600n -0.000842 30.3700n -0.000844 30.3800n -0.000846 30.3900n -0.000849 30.4000n -0.000852 30.4100n -0.000855 30.4200n -0.000860 30.4300n -0.000864 30.4400n -0.000869
+ 30.4500n -0.000875 30.4600n -0.000881 30.4700n -0.000887 30.4800n -0.000894 30.4900n -0.000901 30.5000n -0.000909 30.5100n -0.000917 30.5200n -0.000925 30.5300n -0.000933 30.5400n -0.000942 30.5500n -0.000952 30.5600n -0.000961 30.5700n -0.000971 30.5800n -0.000981 30.5900n -0.000991
+ 30.6000n -0.001002 30.6100n -0.001013 30.6200n -0.001023 30.6300n -0.001035 30.6400n -0.001046 30.6500n -0.001057 30.6600n -0.001068 30.6700n -0.001080 30.6800n -0.001091 30.6900n -0.001103 30.7000n -0.001115 30.7100n -0.001126 30.7200n -0.001138 30.7300n -0.001149 30.7400n -0.001161
+ 30.7500n -0.001172 30.7600n -0.001183 30.7700n -0.001194 30.7800n -0.001205 30.7900n -0.001216 30.8000n -0.001226 30.8100n -0.001236 30.8200n -0.001246 30.8300n -0.001256 30.8400n -0.001266 30.8500n -0.001275 30.8600n -0.001284 30.8700n -0.001292 30.8800n -0.001300 30.8900n -0.001308
+ 30.9000n -0.001315 30.9100n -0.001322 30.9200n -0.001328 30.9300n -0.001334 30.9400n -0.001339 30.9500n -0.001344 30.9600n -0.001348 30.9700n -0.001352 30.9800n -0.001355 30.9900n -0.001358 31.0000n -0.001360 31.0100n -0.001361 31.0200n -0.001362 31.0300n -0.001362 31.0400n -0.001361
+ 31.0500n -0.001360 31.0600n -0.001358 31.0700n -0.001355 31.0800n -0.001352 31.0900n -0.001348 31.1000n -0.001343 31.1100n -0.001337 31.1200n -0.001331 31.1300n -0.001323 31.1400n -0.001315 31.1500n -0.001307 31.1600n -0.001297 31.1700n -0.001287 31.1800n -0.001275 31.1900n -0.001263
+ 31.2000n -0.001250 31.2100n -0.001237 31.2200n -0.001222 31.2300n -0.001207 31.2400n -0.001191 31.2500n -0.001174 31.2600n -0.001156 31.2700n -0.001137 31.2800n -0.001118 31.2900n -0.001097 31.3000n -0.001076 31.3100n -0.001054 31.3200n -0.001031 31.3300n -0.001008 31.3400n -0.000983
+ 31.3500n -0.000958 31.3600n -0.000932 31.3700n -0.000905 31.3800n -0.000878 31.3900n -0.000849 31.4000n -0.000820 31.4100n -0.000790 31.4200n -0.000760 31.4300n -0.000728 31.4400n -0.000696 31.4500n -0.000664 31.4600n -0.000630 31.4700n -0.000596 31.4800n -0.000562 31.4900n -0.000527
+ 31.5000n -0.000491 31.5100n -0.000454 31.5200n -0.000417 31.5300n -0.000380 31.5400n -0.000341 31.5500n -0.000303 31.5600n -0.000264 31.5700n -0.000224 31.5800n -0.000184 31.5900n -0.000144 31.6000n -0.000103 31.6100n -0.000062 31.6200n -0.000020 31.6300n 0.000022 31.6400n 0.000064
+ 31.6500n 0.000106 31.6600n 0.000149 31.6700n 0.000192 31.6800n 0.000235 31.6900n 0.000278 31.7000n 0.000322 31.7100n 0.000365 31.7200n 0.000409 31.7300n 0.000452 31.7400n 0.000496 31.7500n 0.000540 31.7600n 0.000583 31.7700n 0.000627 31.7800n 0.000670 31.7900n 0.000714
+ 31.8000n 0.000757 31.8100n 0.000800 31.8200n 0.000843 31.8300n 0.000885 31.8400n 0.000927 31.8500n 0.000969 31.8600n 0.001011 31.8700n 0.001052 31.8800n 0.001093 31.8900n 0.001134 31.9000n 0.001174 31.9100n 0.001214 31.9200n 0.001253 31.9300n 0.001291 31.9400n 0.001329
+ 31.9500n 0.001367 31.9600n 0.001404 31.9700n 0.001440 31.9800n 0.001476 31.9900n 0.001511 32.0000n 0.001545 32.0100n 0.001578 32.0200n 0.001611 32.0300n 0.001643 32.0400n 0.001674 32.0500n 0.001704 32.0600n 0.001734 32.0700n 0.001762 32.0800n 0.001790 32.0900n 0.001817
+ 32.1000n 0.001842 32.1100n 0.001867 32.1200n 0.001891 32.1300n 0.001914 32.1400n 0.001936 32.1500n 0.001957 32.1600n 0.001977 32.1700n 0.001995 32.1800n 0.002013 32.1900n 0.002030 32.2000n 0.002045 32.2100n 0.002059 32.2200n 0.002073 32.2300n 0.002085 32.2400n 0.002096
+ 32.2500n 0.002105 32.2600n 0.002114 32.2700n 0.002122 32.2800n 0.002128 32.2900n 0.002133 32.3000n 0.002137 32.3100n 0.002140 32.3200n 0.002141 32.3300n 0.002141 32.3400n 0.002141 32.3500n 0.002139 32.3600n 0.002135 32.3700n 0.002131 32.3800n 0.002125 32.3900n 0.002118
+ 32.4000n 0.002110 32.4100n 0.002101 32.4200n 0.002090 32.4300n 0.002079 32.4400n 0.002066 32.4500n 0.002052 32.4600n 0.002037 32.4700n 0.002021 32.4800n 0.002003 32.4900n 0.001985 32.5000n 0.001965 32.5100n 0.001944 32.5200n 0.001923 32.5300n 0.001900 32.5400n 0.001876
+ 32.5500n 0.001851 32.5600n 0.001825 32.5700n 0.001798 32.5800n 0.001770 32.5900n 0.001741 32.6000n 0.001711 32.6100n 0.001680 32.6200n 0.001648 32.6300n 0.001615 32.6400n 0.001582 32.6500n 0.001547 32.6600n 0.001512 32.6700n 0.001476 32.6800n 0.001439 32.6900n 0.001402
+ 32.7000n 0.001364 32.7100n 0.001325 32.7200n 0.001285 32.7300n 0.001245 32.7400n 0.001204 32.7500n 0.001162 32.7600n 0.001120 32.7700n 0.001078 32.7800n 0.001034 32.7900n 0.000991 32.8000n 0.000947 32.8100n 0.000902 32.8200n 0.000857 32.8300n 0.000812 32.8400n 0.000767
+ 32.8500n 0.000721 32.8600n 0.000674 32.8700n 0.000628 32.8800n 0.000581 32.8900n 0.000535 32.9000n 0.000488 32.9100n 0.000441 32.9200n 0.000393 32.9300n 0.000346 32.9400n 0.000299 32.9500n 0.000252 32.9600n 0.000204 32.9700n 0.000157 32.9800n 0.000110 32.9900n 0.000063
+ 33.0000n 0.000016 33.0100n -0.000030 33.0200n -0.000077 33.0300n -0.000123 33.0400n -0.000169 33.0500n -0.000215 33.0600n -0.000260 33.0700n -0.000305 33.0800n -0.000350 33.0900n -0.000394 33.1000n -0.000438 33.1100n -0.000481 33.1200n -0.000524 33.1300n -0.000566 33.1400n -0.000608
+ 33.1500n -0.000649 33.1600n -0.000690 33.1700n -0.000730 33.1800n -0.000770 33.1900n -0.000808 33.2000n -0.000847 33.2100n -0.000884 33.2200n -0.000921 33.2300n -0.000957 33.2400n -0.000992 33.2500n -0.001027 33.2600n -0.001061 33.2700n -0.001094 33.2800n -0.001126 33.2900n -0.001157
+ 33.3000n -0.001188 33.3100n -0.001218 33.3200n -0.001247 33.3300n -0.001275 33.3400n -0.001302 33.3500n -0.001328 33.3600n -0.001353 33.3700n -0.001378 33.3800n -0.001401 33.3900n -0.001424 33.4000n -0.001445 33.4100n -0.001466 33.4200n -0.001486 33.4300n -0.001504 33.4400n -0.001522
+ 33.4500n -0.001539 33.4600n -0.001555 33.4700n -0.001570 33.4800n -0.001584 33.4900n -0.001596 33.5000n -0.001609 33.5100n -0.001620 33.5200n -0.001630 33.5300n -0.001639 33.5400n -0.001647 33.5500n -0.001654 33.5600n -0.001660 33.5700n -0.001666 33.5800n -0.001670 33.5900n -0.001674
+ 33.6000n -0.001676 33.6100n -0.001678 33.6200n -0.001679 33.6300n -0.001679 33.6400n -0.001678 33.6500n -0.001676 33.6600n -0.001673 33.6700n -0.001670 33.6800n -0.001665 33.6900n -0.001660 33.7000n -0.001654 33.7100n -0.001648 33.7200n -0.001640 33.7300n -0.001632 33.7400n -0.001623
+ 33.7500n -0.001613 33.7600n -0.001603 33.7700n -0.001592 33.7800n -0.001580 33.7900n -0.001568 33.8000n -0.001555 33.8100n -0.001541 33.8200n -0.001527 33.8300n -0.001513 33.8400n -0.001497 33.8500n -0.001482 33.8600n -0.001465 33.8700n -0.001449 33.8800n -0.001431 33.8900n -0.001414
+ 33.9000n -0.001396 33.9100n -0.001377 33.9200n -0.001358 33.9300n -0.001339 33.9400n -0.001320 33.9500n -0.001300 33.9600n -0.001280 33.9700n -0.001260 33.9800n -0.001239 33.9900n -0.001218 34.0000n -0.001197 34.0100n -0.001176 34.0200n -0.001155 34.0300n -0.001133 34.0400n -0.001112
+ 34.0500n -0.001090 34.0600n -0.001068 34.0700n -0.001047 34.0800n -0.001025 34.0900n -0.001003 34.1000n -0.000982 34.1100n -0.000960 34.1200n -0.000938 34.1300n -0.000917 34.1400n -0.000895 34.1500n -0.000874 34.1600n -0.000853 34.1700n -0.000832 34.1800n -0.000811 34.1900n -0.000790
+ 34.2000n -0.000770 34.2100n -0.000750 34.2200n -0.000730 34.2300n -0.000710 34.2400n -0.000691 34.2500n -0.000672 34.2600n -0.000653 34.2700n -0.000635 34.2800n -0.000617 34.2900n -0.000599 34.3000n -0.000581 34.3100n -0.000564 34.3200n -0.000548 34.3300n -0.000532 34.3400n -0.000516
+ 34.3500n -0.000500 34.3600n -0.000485 34.3700n -0.000471 34.3800n -0.000457 34.3900n -0.000443 34.4000n -0.000430 34.4100n -0.000417 34.4200n -0.000405 34.4300n -0.000393 34.4400n -0.000382 34.4500n -0.000371 34.4600n -0.000361 34.4700n -0.000351 34.4800n -0.000341 34.4900n -0.000333
+ 34.5000n -0.000324 34.5100n -0.000316 34.5200n -0.000309 34.5300n -0.000302 34.5400n -0.000296 34.5500n -0.000290 34.5600n -0.000284 34.5700n -0.000279 34.5800n -0.000275 34.5900n -0.000271 34.6000n -0.000268 34.6100n -0.000265 34.6200n -0.000262 34.6300n -0.000260 34.6400n -0.000258
+ 34.6500n -0.000257 34.6600n -0.000256 34.6700n -0.000256 34.6800n -0.000256 34.6900n -0.000256 34.7000n -0.000257 34.7100n -0.000258 34.7200n -0.000260 34.7300n -0.000262 34.7400n -0.000264 34.7500n -0.000267 34.7600n -0.000270 34.7700n -0.000273 34.7800n -0.000277 34.7900n -0.000281
+ 34.8000n -0.000285 34.8100n -0.000289 34.8200n -0.000294 34.8300n -0.000299 34.8400n -0.000304 34.8500n -0.000310 34.8600n -0.000315 34.8700n -0.000321 34.8800n -0.000327 34.8900n -0.000333 34.9000n -0.000339 34.9100n -0.000346 34.9200n -0.000352 34.9300n -0.000359 34.9400n -0.000365
+ 34.9500n -0.000372 34.9600n -0.000379 34.9700n -0.000386 34.9800n -0.000392 34.9900n -0.000399 35.0000n -0.000406 35.0100n -0.000413 35.0200n -0.000419 35.0300n -0.000426 35.0400n -0.000433 35.0500n -0.000439 35.0600n -0.000446 35.0700n -0.000452 35.0800n -0.000458 35.0900n -0.000464
+ 35.1000n -0.000470 35.1100n -0.000476 35.1200n -0.000481 35.1300n -0.000487 35.1400n -0.000492 35.1500n -0.000497 35.1600n -0.000502 35.1700n -0.000506 35.1800n -0.000511 35.1900n -0.000515 35.2000n -0.000518 35.2100n -0.000522 35.2200n -0.000525 35.2300n -0.000528 35.2400n -0.000531
+ 35.2500n -0.000533 35.2600n -0.000535 35.2700n -0.000537 35.2800n -0.000538 35.2900n -0.000539 35.3000n -0.000540 35.3100n -0.000541 35.3200n -0.000541 35.3300n -0.000540 35.3400n -0.000540 35.3500n -0.000539 35.3600n -0.000538 35.3700n -0.000536 35.3800n -0.000534 35.3900n -0.000532
+ 35.4000n -0.000529 35.4100n -0.000526 35.4200n -0.000523 35.4300n -0.000519 35.4400n -0.000515 35.4500n -0.000511 35.4600n -0.000506 35.4700n -0.000501 35.4800n -0.000496 35.4900n -0.000490 35.5000n -0.000484 35.5100n -0.000478 35.5200n -0.000471 35.5300n -0.000464 35.5400n -0.000457
+ 35.5500n -0.000450 35.5600n -0.000442 35.5700n -0.000434 35.5800n -0.000426 35.5900n -0.000418 35.6000n -0.000409 35.6100n -0.000401 35.6200n -0.000392 35.6300n -0.000382 35.6400n -0.000373 35.6500n -0.000364 35.6600n -0.000354 35.6700n -0.000344 35.6800n -0.000334 35.6900n -0.000324
+ 35.7000n -0.000314 35.7100n -0.000304 35.7200n -0.000294 35.7300n -0.000284 35.7400n -0.000273 35.7500n -0.000263 35.7600n -0.000253 35.7700n -0.000243 35.7800n -0.000233 35.7900n -0.000223 35.8000n -0.000213 35.8100n -0.000203 35.8200n -0.000193 35.8300n -0.000183 35.8400n -0.000174
+ 35.8500n -0.000164 35.8600n -0.000155 35.8700n -0.000146 35.8800n -0.000138 35.8900n -0.000129 35.9000n -0.000121 35.9100n -0.000113 35.9200n -0.000106 35.9300n -0.000098 35.9400n -0.000092 35.9500n -0.000085 35.9600n -0.000079 35.9700n -0.000073 35.9800n -0.000068 35.9900n -0.000063
+ 36.0000n -0.000058 36.0100n -0.000054 36.0200n -0.000051 36.0300n -0.000047 36.0400n -0.000045 36.0500n -0.000043 36.0600n -0.000041 36.0700n -0.000040 36.0800n -0.000040 36.0900n -0.000040 36.1000n -0.000041 36.1100n -0.000042 36.1200n -0.000044 36.1300n -0.000047 36.1400n -0.000050
+ 36.1500n -0.000054 36.1600n -0.000059 36.1700n -0.000064 36.1800n -0.000070 36.1900n -0.000077 36.2000n -0.000085 36.2100n -0.000093 36.2200n -0.000102 36.2300n -0.000111 36.2400n -0.000122 36.2500n -0.000133 36.2600n -0.000144 36.2700n -0.000157 36.2800n -0.000170 36.2900n -0.000185
+ 36.3000n -0.000199 36.3100n -0.000215 36.3200n -0.000232 36.3300n -0.000249 36.3400n -0.000267 36.3500n -0.000286 36.3600n -0.000305 36.3700n -0.000325 36.3800n -0.000346 36.3900n -0.000368 36.4000n -0.000391 36.4100n -0.000414 36.4200n -0.000438 36.4300n -0.000463 36.4400n -0.000489
+ 36.4500n -0.000515 36.4600n -0.000542 36.4700n -0.000570 36.4800n -0.000598 36.4900n -0.000627 36.5000n -0.000657 36.5100n -0.000687 36.5200n -0.000719 36.5300n -0.000750 36.5400n -0.000783 36.5500n -0.000816 36.5600n -0.000849 36.5700n -0.000883 36.5800n -0.000918 36.5900n -0.000953
+ 36.6000n -0.000989 36.6100n -0.001026 36.6200n -0.001062 36.6300n -0.001100 36.6400n -0.001137 36.6500n -0.001176 36.6600n -0.001214 36.6700n -0.001253 36.6800n -0.001293 36.6900n -0.001332 36.7000n -0.001372 36.7100n -0.001413 36.7200n -0.001453 36.7300n -0.001494 36.7400n -0.001535
+ 36.7500n -0.001577 36.7600n -0.001618 36.7700n -0.001660 36.7800n -0.001702 36.7900n -0.001744 36.8000n -0.001786 36.8100n -0.001828 36.8200n -0.001870 36.8300n -0.001912 36.8400n -0.001954 36.8500n -0.001996 36.8600n -0.002038 36.8700n -0.002079 36.8800n -0.002121 36.8900n -0.002162
+ 36.9000n -0.002204 36.9100n -0.002245 36.9200n -0.002286 36.9300n -0.002326 36.9400n -0.002366 36.9500n -0.002406 36.9600n -0.002446 36.9700n -0.002485 36.9800n -0.002523 36.9900n -0.002562 37.0000n -0.002599 37.0100n -0.002637 37.0200n -0.002673 37.0300n -0.002710 37.0400n -0.002745
+ 37.0500n -0.002780 37.0600n -0.002815 37.0700n -0.002848 37.0800n -0.002881 37.0900n -0.002914 37.1000n -0.002945 37.1100n -0.002976 37.1200n -0.003006 37.1300n -0.003035 37.1400n -0.003064 37.1500n -0.003091 37.1600n -0.003118 37.1700n -0.003144 37.1800n -0.003169 37.1900n -0.003193
+ 37.2000n -0.003216 37.2100n -0.003238 37.2200n -0.003259 37.2300n -0.003279 37.2400n -0.003298 37.2500n -0.003316 37.2600n -0.003333 37.2700n -0.003349 37.2800n -0.003364 37.2900n -0.003378 37.3000n -0.003391 37.3100n -0.003402 37.3200n -0.003413 37.3300n -0.003422 37.3400n -0.003430
+ 37.3500n -0.003437 37.3600n -0.003443 37.3700n -0.003448 37.3800n -0.003451 37.3900n -0.003453 37.4000n -0.003455 37.4100n -0.003455 37.4200n -0.003453 37.4300n -0.003451 37.4400n -0.003447 37.4500n -0.003442 37.4600n -0.003436 37.4700n -0.003429 37.4800n -0.003421 37.4900n -0.003411
+ 37.5000n -0.003400 37.5100n -0.003388 37.5200n -0.003375 37.5300n -0.003361 37.5400n -0.003346 37.5500n -0.003329 37.5600n -0.003311 37.5700n -0.003292 37.5800n -0.003272 37.5900n -0.003251 37.6000n -0.003229 37.6100n -0.003206 37.6200n -0.003182 37.6300n -0.003156 37.6400n -0.003130
+ 37.6500n -0.003102 37.6600n -0.003074 37.6700n -0.003044 37.6800n -0.003014 37.6900n -0.002982 37.7000n -0.002950 37.7100n -0.002917 37.7200n -0.002883 37.7300n -0.002847 37.7400n -0.002812 37.7500n -0.002775 37.7600n -0.002737 37.7700n -0.002699 37.7800n -0.002660 37.7900n -0.002620
+ 37.8000n -0.002580 37.8100n -0.002539 37.8200n -0.002497 37.8300n -0.002454 37.8400n -0.002411 37.8500n -0.002368 37.8600n -0.002323 37.8700n -0.002279 37.8800n -0.002233 37.8900n -0.002188 37.9000n -0.002142 37.9100n -0.002095 37.9200n -0.002048 37.9300n -0.002001 37.9400n -0.001954
+ 37.9500n -0.001906 37.9600n -0.001858 37.9700n -0.001810 37.9800n -0.001761 37.9900n -0.001713 38.0000n -0.001664 38.0100n -0.001615 38.0200n -0.001566 38.0300n -0.001517 38.0400n -0.001468 38.0500n -0.001420 38.0600n -0.001371 38.0700n -0.001322 38.0800n -0.001273 38.0900n -0.001225
+ 38.1000n -0.001177 38.1100n -0.001129 38.1200n -0.001081 38.1300n -0.001033 38.1400n -0.000986 38.1500n -0.000939 38.1600n -0.000892 38.1700n -0.000846 38.1800n -0.000800 38.1900n -0.000755 38.2000n -0.000710 38.2100n -0.000666 38.2200n -0.000622 38.2300n -0.000579 38.2400n -0.000536
+ 38.2500n -0.000494 38.2600n -0.000452 38.2700n -0.000411 38.2800n -0.000371 38.2900n -0.000332 38.3000n -0.000293 38.3100n -0.000255 38.3200n -0.000218 38.3300n -0.000181 38.3400n -0.000145 38.3500n -0.000111 38.3600n -0.000076 38.3700n -0.000043 38.3800n -0.000011 38.3900n 0.000021
+ 38.4000n 0.000051 38.4100n 0.000081 38.4200n 0.000110 38.4300n 0.000137 38.4400n 0.000164 38.4500n 0.000190 38.4600n 0.000215 38.4700n 0.000239 38.4800n 0.000262 38.4900n 0.000284 38.5000n 0.000305 38.5100n 0.000324 38.5200n 0.000343 38.5300n 0.000361 38.5400n 0.000378
+ 38.5500n 0.000394 38.5600n 0.000408 38.5700n 0.000422 38.5800n 0.000435 38.5900n 0.000446 38.6000n 0.000457 38.6100n 0.000466 38.6200n 0.000475 38.6300n 0.000482 38.6400n 0.000488 38.6500n 0.000494 38.6600n 0.000498 38.6700n 0.000501 38.6800n 0.000504 38.6900n 0.000505
+ 38.7000n 0.000505 38.7100n 0.000504 38.7200n 0.000503 38.7300n 0.000500 38.7400n 0.000496 38.7500n 0.000492 38.7600n 0.000486 38.7700n 0.000480 38.7800n 0.000472 38.7900n 0.000464 38.8000n 0.000455 38.8100n 0.000445 38.8200n 0.000434 38.8300n 0.000422 38.8400n 0.000410
+ 38.8500n 0.000397 38.8600n 0.000383 38.8700n 0.000368 38.8800n 0.000352 38.8900n 0.000336 38.9000n 0.000319 38.9100n 0.000301 38.9200n 0.000283 38.9300n 0.000264 38.9400n 0.000244 38.9500n 0.000224 38.9600n 0.000203 38.9700n 0.000182 38.9800n 0.000160 38.9900n 0.000138
+ 39.0000n 0.000115 39.0100n 0.000092 39.0200n 0.000068 39.0300n 0.000044 39.0400n 0.000019 39.0500n -0.000006 39.0600n -0.000031 39.0700n -0.000057 39.0800n -0.000082 39.0900n -0.000109 39.1000n -0.000135 39.1100n -0.000161 39.1200n -0.000188 39.1300n -0.000215 39.1400n -0.000242
+ 39.1500n -0.000269 39.1600n -0.000296 39.1700n -0.000324 39.1800n -0.000351 39.1900n -0.000379 39.2000n -0.000406 39.2100n -0.000433 39.2200n -0.000461 39.2300n -0.000488 39.2400n -0.000515 39.2500n -0.000542 39.2600n -0.000569 39.2700n -0.000595 39.2800n -0.000622 39.2900n -0.000648
+ 39.3000n -0.000674 39.3100n -0.000700 39.3200n -0.000725 39.3300n -0.000751 39.3400n -0.000776 39.3500n -0.000800 39.3600n -0.000824 39.3700n -0.000848 39.3800n -0.000872 39.3900n -0.000895 39.4000n -0.000917 39.4100n -0.000940 39.4200n -0.000961 39.4300n -0.000983 39.4400n -0.001004
+ 39.4500n -0.001024 39.4600n -0.001044 39.4700n -0.001063 39.4800n -0.001082 39.4900n -0.001100 39.5000n -0.001118 39.5100n -0.001135 39.5200n -0.001151 39.5300n -0.001167 39.5400n -0.001183 39.5500n -0.001197 39.5600n -0.001211 39.5700n -0.001225 39.5800n -0.001238 39.5900n -0.001250
+ 39.6000n -0.001262 39.6100n -0.001273 39.6200n -0.001283 39.6300n -0.001293 39.6400n -0.001302 39.6500n -0.001310 39.6600n -0.001318 39.6700n -0.001325 39.6800n -0.001332 39.6900n -0.001338 39.7000n -0.001343 39.7100n -0.001347 39.7200n -0.001351 39.7300n -0.001355 39.7400n -0.001357
+ 39.7500n -0.001359 39.7600n -0.001361 39.7700n -0.001361 39.7800n -0.001362 39.7900n -0.001361 39.8000n -0.001360 39.8100n -0.001359 39.8200n -0.001356 39.8300n -0.001354 39.8400n -0.001350 39.8500n -0.001346 39.8600n -0.001342 39.8700n -0.001337 39.8800n -0.001332 39.8900n -0.001326
+ 39.9000n -0.001319 39.9100n -0.001312 39.9200n -0.001305 39.9300n -0.001297 39.9400n -0.001289 39.9500n -0.001280 39.9600n -0.001271 39.9700n -0.001261 39.9800n -0.001251 39.9900n -0.001241 40.0000n -0.001230 40.0100n -0.001219 40.0200n -0.001208 40.0300n -0.001196 40.0400n -0.001184
+ 40.0500n -0.001172 40.0600n -0.001159 40.0700n -0.001147 40.0800n -0.001134 40.0900n -0.001120 40.1000n -0.001107 40.1100n -0.001093 40.1200n -0.001080 40.1300n -0.001066 40.1400n -0.001052 40.1500n -0.001038 40.1600n -0.001024 40.1700n -0.001009 40.1800n -0.000995 40.1900n -0.000981
+ 40.2000n -0.000966 40.2100n -0.000952 40.2200n -0.000937 40.2300n -0.000923 40.2400n -0.000909 40.2500n -0.000895 40.2600n -0.000880 40.2700n -0.000866 40.2800n -0.000852 40.2900n -0.000838 40.3000n -0.000825 40.3100n -0.000811 40.3200n -0.000797 40.3300n -0.000784 40.3400n -0.000771
+ 40.3500n -0.000758 40.3600n -0.000746 40.3700n -0.000733 40.3800n -0.000721 40.3900n -0.000709 40.4000n -0.000697 40.4100n -0.000686 40.4200n -0.000675 40.4300n -0.000664 40.4400n -0.000653 40.4500n -0.000643 40.4600n -0.000633 40.4700n -0.000623 40.4800n -0.000614 40.4900n -0.000605
+ 40.5000n -0.000597 40.5100n -0.000589 40.5200n -0.000581 40.5300n -0.000573 40.5400n -0.000566 40.5500n -0.000560 40.5600n -0.000553 40.5700n -0.000547 40.5800n -0.000542 40.5900n -0.000537 40.6000n -0.000532 40.6100n -0.000528 40.6200n -0.000524 40.6300n -0.000520 40.6400n -0.000517
+ 40.6500n -0.000514 40.6600n -0.000512 40.6700n -0.000510 40.6800n -0.000508 40.6900n -0.000507 40.7000n -0.000506 40.7100n -0.000506 40.7200n -0.000506 40.7300n -0.000506 40.7400n -0.000507 40.7500n -0.000508 40.7600n -0.000510 40.7700n -0.000512 40.7800n -0.000514 40.7900n -0.000517
+ 40.8000n -0.000519 40.8100n -0.000523 40.8200n -0.000526 40.8300n -0.000530 40.8400n -0.000534 40.8500n -0.000539 40.8600n -0.000543 40.8700n -0.000549 40.8800n -0.000554 40.8900n -0.000559 40.9000n -0.000565 40.9100n -0.000571 40.9200n -0.000577 40.9300n -0.000584 40.9400n -0.000591
+ 40.9500n -0.000597 40.9600n -0.000604 40.9700n -0.000612 40.9800n -0.000619 40.9900n -0.000626 41.0000n -0.000634 41.0100n -0.000642 41.0200n -0.000650 41.0300n -0.000657 41.0400n -0.000665 41.0500n -0.000673 41.0600n -0.000682 41.0700n -0.000690 41.0800n -0.000698 41.0900n -0.000706
+ 41.1000n -0.000714 41.1100n -0.000722 41.1200n -0.000730 41.1300n -0.000738 41.1400n -0.000746 41.1500n -0.000754 41.1600n -0.000761 41.1700n -0.000769 41.1800n -0.000777 41.1900n -0.000784 41.2000n -0.000791 41.2100n -0.000798 41.2200n -0.000805 41.2300n -0.000812 41.2400n -0.000818
+ 41.2500n -0.000824 41.2600n -0.000831 41.2700n -0.000836 41.2800n -0.000842 41.2900n -0.000847 41.3000n -0.000852 41.3100n -0.000857 41.3200n -0.000862 41.3300n -0.000866 41.3400n -0.000870 41.3500n -0.000873 41.3600n -0.000876 41.3700n -0.000879 41.3800n -0.000882 41.3900n -0.000884
+ 41.4000n -0.000886 41.4100n -0.000887 41.4200n -0.000889 41.4300n -0.000889 41.4400n -0.000890 41.4500n -0.000890 41.4600n -0.000889 41.4700n -0.000888 41.4800n -0.000887 41.4900n -0.000886 41.5000n -0.000884 41.5100n -0.000881 41.5200n -0.000878 41.5300n -0.000875 41.5400n -0.000871
+ 41.5500n -0.000867 41.5600n -0.000863 41.5700n -0.000858 41.5800n -0.000853 41.5900n -0.000847 41.6000n -0.000841 41.6100n -0.000834 41.6200n -0.000827 41.6300n -0.000820 41.6400n -0.000812 41.6500n -0.000804 41.6600n -0.000796 41.6700n -0.000787 41.6800n -0.000778 41.6900n -0.000768
+ 41.7000n -0.000758 41.7100n -0.000748 41.7200n -0.000737 41.7300n -0.000726 41.7400n -0.000715 41.7500n -0.000703 41.7600n -0.000691 41.7700n -0.000679 41.7800n -0.000666 41.7900n -0.000653 41.8000n -0.000640 41.8100n -0.000627 41.8200n -0.000613 41.8300n -0.000599 41.8400n -0.000585
+ 41.8500n -0.000571 41.8600n -0.000556 41.8700n -0.000542 41.8800n -0.000527 41.8900n -0.000512 41.9000n -0.000497 41.9100n -0.000482 41.9200n -0.000466 41.9300n -0.000451 41.9400n -0.000435 41.9500n -0.000419 41.9600n -0.000404 41.9700n -0.000388 41.9800n -0.000372 41.9900n -0.000357
+ 42.0000n -0.000341 42.0100n -0.000325 42.0200n -0.000309 42.0300n -0.000294 42.0400n -0.000278 42.0500n -0.000263 42.0600n -0.000247 42.0700n -0.000232 42.0800n -0.000217 42.0900n -0.000202 42.1000n -0.000188 42.1100n -0.000173 42.1200n -0.000159 42.1300n -0.000145 42.1400n -0.000131
+ 42.1500n -0.000117 42.1600n -0.000104 42.1700n -0.000091 42.1800n -0.000078 42.1900n -0.000065 42.2000n -0.000053 42.2100n -0.000041 42.2200n -0.000030 42.2300n -0.000019 42.2400n -0.000008 42.2500n 0.000002 42.2600n 0.000012 42.2700n 0.000021 42.2800n 0.000030 42.2900n 0.000039
+ 42.3000n 0.000047 42.3100n 0.000055 42.3200n 0.000062 42.3300n 0.000068 42.3400n 0.000074 42.3500n 0.000080 42.3600n 0.000085 42.3700n 0.000090 42.3800n 0.000094 42.3900n 0.000097 42.4000n 0.000100 42.4100n 0.000102 42.4200n 0.000104 42.4300n 0.000105 42.4400n 0.000106
+ 42.4500n 0.000106 42.4600n 0.000105 42.4700n 0.000104 42.4800n 0.000102 42.4900n 0.000099 42.5000n 0.000096 42.5100n 0.000093 42.5200n 0.000088 42.5300n 0.000083 42.5400n 0.000078 42.5500n 0.000072 42.5600n 0.000065 42.5700n 0.000058 42.5800n 0.000049 42.5900n 0.000041
+ 42.6000n 0.000032 42.6100n 0.000022 42.6200n 0.000011 42.6300n 0.000000 42.6400n -0.000011 42.6500n -0.000023 42.6600n -0.000036 42.6700n -0.000050 42.6800n -0.000064 42.6900n -0.000078 42.7000n -0.000093 42.7100n -0.000109 42.7200n -0.000125 42.7300n -0.000141 42.7400n -0.000159
+ 42.7500n -0.000176 42.7600n -0.000194 42.7700n -0.000213 42.7800n -0.000232 42.7900n -0.000252 42.8000n -0.000272 42.8100n -0.000292 42.8200n -0.000313 42.8300n -0.000334 42.8400n -0.000356 42.8500n -0.000377 42.8600n -0.000400 42.8700n -0.000422 42.8800n -0.000445 42.8900n -0.000469
+ 42.9000n -0.000492 42.9100n -0.000516 42.9200n -0.000540 42.9300n -0.000564 42.9400n -0.000589 42.9500n -0.000613 42.9600n -0.000638 42.9700n -0.000663 42.9800n -0.000688 42.9900n -0.000713 43.0000n -0.000739 43.0100n -0.000764 43.0200n -0.000790 43.0300n -0.000815 43.0400n -0.000841
+ 43.0500n -0.000866 43.0600n -0.000892 43.0700n -0.000917 43.0800n -0.000942 43.0900n -0.000968 43.1000n -0.000993 43.1100n -0.001018 43.1200n -0.001043 43.1300n -0.001067 43.1400n -0.001092 43.1500n -0.001116 43.1600n -0.001140 43.1700n -0.001164 43.1800n -0.001187 43.1900n -0.001211
+ 43.2000n -0.001234 43.2100n -0.001256 43.2200n -0.001278 43.2300n -0.001300 43.2400n -0.001322 43.2500n -0.001343 43.2600n -0.001363 43.2700n -0.001384 43.2800n -0.001403 43.2900n -0.001422 43.3000n -0.001441 43.3100n -0.001459 43.3200n -0.001477 43.3300n -0.001494 43.3400n -0.001511
+ 43.3500n -0.001527 43.3600n -0.001542 43.3700n -0.001557 43.3800n -0.001571 43.3900n -0.001585 43.4000n -0.001598 43.4100n -0.001610 43.4200n -0.001622 43.4300n -0.001633 43.4400n -0.001643 43.4500n -0.001652 43.4600n -0.001661 43.4700n -0.001669 43.4800n -0.001677 43.4900n -0.001683
+ 43.5000n -0.001689 43.5100n -0.001694 43.5200n -0.001699 43.5300n -0.001702 43.5400n -0.001705 43.5500n -0.001707 43.5600n -0.001708 43.5700n -0.001709 43.5800n -0.001709 43.5900n -0.001708 43.6000n -0.001706 43.6100n -0.001703 43.6200n -0.001700 43.6300n -0.001695 43.6400n -0.001690
+ 43.6500n -0.001685 43.6600n -0.001678 43.6700n -0.001671 43.6800n -0.001663 43.6900n -0.001654 43.7000n -0.001644 43.7100n -0.001634 43.7200n -0.001623 43.7300n -0.001611 43.7400n -0.001598 43.7500n -0.001585 43.7600n -0.001571 43.7700n -0.001556 43.7800n -0.001541 43.7900n -0.001524
+ 43.8000n -0.001508 43.8100n -0.001490 43.8200n -0.001472 43.8300n -0.001453 43.8400n -0.001434 43.8500n -0.001414 43.8600n -0.001393 43.8700n -0.001372 43.8800n -0.001350 43.8900n -0.001328 43.9000n -0.001305 43.9100n -0.001281 43.9200n -0.001257 43.9300n -0.001233 43.9400n -0.001208
+ 43.9500n -0.001183 43.9600n -0.001157 43.9700n -0.001131 43.9800n -0.001104 43.9900n -0.001077 44.0000n -0.001050 44.0100n -0.001023 44.0200n -0.000995 44.0300n -0.000966 44.0400n -0.000938 44.0500n -0.000909 44.0600n -0.000880 44.0700n -0.000851 44.0800n -0.000822 44.0900n -0.000792
+ 44.1000n -0.000762 44.1100n -0.000733 44.1200n -0.000703 44.1300n -0.000673 44.1400n -0.000643 44.1500n -0.000613 44.1600n -0.000583 44.1700n -0.000553 44.1800n -0.000523 44.1900n -0.000493 44.2000n -0.000463 44.2100n -0.000434 44.2200n -0.000404 44.2300n -0.000375 44.2400n -0.000345
+ 44.2500n -0.000316 44.2600n -0.000288 44.2700n -0.000259 44.2800n -0.000231 44.2900n -0.000203 44.3000n -0.000175 44.3100n -0.000148 44.3200n -0.000121 44.3300n -0.000094 44.3400n -0.000068 44.3500n -0.000042 44.3600n -0.000017 44.3700n 0.000008 44.3800n 0.000033 44.3900n 0.000057
+ 44.4000n 0.000080 44.4100n 0.000103 44.4200n 0.000125 44.4300n 0.000147 44.4400n 0.000168 44.4500n 0.000189 44.4600n 0.000209 44.4700n 0.000229 44.4800n 0.000247 44.4900n 0.000266 44.5000n 0.000283 44.5100n 0.000300 44.5200n 0.000316 44.5300n 0.000332 44.5400n 0.000346
+ 44.5500n 0.000360 44.5600n 0.000374 44.5700n 0.000386 44.5800n 0.000398 44.5900n 0.000409 44.6000n 0.000419 44.6100n 0.000429 44.6200n 0.000437 44.6300n 0.000445 44.6400n 0.000452 44.6500n 0.000459 44.6600n 0.000464 44.6700n 0.000469 44.6800n 0.000473 44.6900n 0.000476
+ 44.7000n 0.000479 44.7100n 0.000480 44.7200n 0.000481 44.7300n 0.000481 44.7400n 0.000480 44.7500n 0.000478 44.7600n 0.000476 44.7700n 0.000473 44.7800n 0.000469 44.7900n 0.000464 44.8000n 0.000458 44.8100n 0.000452 44.8200n 0.000445 44.8300n 0.000437 44.8400n 0.000428
+ 44.8500n 0.000419 44.8600n 0.000409 44.8700n 0.000398 44.8800n 0.000386 44.8900n 0.000374 44.9000n 0.000361 44.9100n 0.000347 44.9200n 0.000333 44.9300n 0.000318 44.9400n 0.000303 44.9500n 0.000286 44.9600n 0.000270 44.9700n 0.000252 44.9800n 0.000234 44.9900n 0.000216
+ 45.0000n 0.000196 45.0100n 0.000177 45.0200n 0.000157 45.0300n 0.000136 45.0400n 0.000115 45.0500n 0.000093 45.0600n 0.000071 45.0700n 0.000049 45.0800n 0.000026 45.0900n 0.000003 45.1000n -0.000021 45.1100n -0.000044 45.1200n -0.000069 45.1300n -0.000093 45.1400n -0.000118
+ 45.1500n -0.000143 45.1600n -0.000168 45.1700n -0.000193 45.1800n -0.000219 45.1900n -0.000245 45.2000n -0.000271 45.2100n -0.000297 45.2200n -0.000323 45.2300n -0.000349 45.2400n -0.000375 45.2500n -0.000401 45.2600n -0.000428 45.2700n -0.000454 45.2800n -0.000480 45.2900n -0.000506
+ 45.3000n -0.000532 45.3100n -0.000558 45.3200n -0.000584 45.3300n -0.000609 45.3400n -0.000635 45.3500n -0.000660 45.3600n -0.000685 45.3700n -0.000709 45.3800n -0.000734 45.3900n -0.000758 45.4000n -0.000782 45.4100n -0.000805 45.4200n -0.000828 45.4300n -0.000851 45.4400n -0.000873
+ 45.4500n -0.000895 45.4600n -0.000916 45.4700n -0.000937 45.4800n -0.000958 45.4900n -0.000978 45.5000n -0.000997 45.5100n -0.001016 45.5200n -0.001034 45.5300n -0.001052 45.5400n -0.001069 45.5500n -0.001086 45.5600n -0.001102 45.5700n -0.001117 45.5800n -0.001131 45.5900n -0.001145
+ 45.6000n -0.001158 45.6100n -0.001171 45.6200n -0.001183 45.6300n -0.001194 45.6400n -0.001204 45.6500n -0.001214 45.6600n -0.001223 45.6700n -0.001231 45.6800n -0.001238 45.6900n -0.001244 45.7000n -0.001250 45.7100n -0.001255 45.7200n -0.001259 45.7300n -0.001262 45.7400n -0.001264
+ 45.7500n -0.001266 45.7600n -0.001266 45.7700n -0.001266 45.7800n -0.001265 45.7900n -0.001263 45.8000n -0.001260 45.8100n -0.001257 45.8200n -0.001252 45.8300n -0.001247 45.8400n -0.001240 45.8500n -0.001233 45.8600n -0.001225 45.8700n -0.001216 45.8800n -0.001207 45.8900n -0.001196
+ 45.9000n -0.001185 45.9100n -0.001172 45.9200n -0.001159 45.9300n -0.001145 45.9400n -0.001130 45.9500n -0.001114 45.9600n -0.001098 45.9700n -0.001081 45.9800n -0.001062 45.9900n -0.001043 46.0000n -0.001024 46.0100n -0.001003 46.0200n -0.000982 46.0300n -0.000960 46.0400n -0.000937
+ 46.0500n -0.000913 46.0600n -0.000889 46.0700n -0.000864 46.0800n -0.000838 46.0900n -0.000811 46.1000n -0.000784 46.1100n -0.000756 46.1200n -0.000728 46.1300n -0.000699 46.1400n -0.000669 46.1500n -0.000639 46.1600n -0.000608 46.1700n -0.000576 46.1800n -0.000544 46.1900n -0.000511
+ 46.2000n -0.000478 46.2100n -0.000444 46.2200n -0.000410 46.2300n -0.000376 46.2400n -0.000341 46.2500n -0.000305 46.2600n -0.000269 46.2700n -0.000233 46.2800n -0.000196 46.2900n -0.000159 46.3000n -0.000122 46.3100n -0.000084 46.3200n -0.000046 46.3300n -0.000008 46.3400n 0.000031
+ 46.3500n 0.000070 46.3600n 0.000109 46.3700n 0.000148 46.3800n 0.000187 46.3900n 0.000227 46.4000n 0.000266 46.4100n 0.000306 46.4200n 0.000346 46.4300n 0.000386 46.4400n 0.000426 46.4500n 0.000466 46.4600n 0.000506 46.4700n 0.000546 46.4800n 0.000585 46.4900n 0.000625
+ 46.5000n 0.000665 46.5100n 0.000705 46.5200n 0.000744 46.5300n 0.000784 46.5400n 0.000823 46.5500n 0.000862 46.5600n 0.000901 46.5700n 0.000939 46.5800n 0.000978 46.5900n 0.001016 46.6000n 0.001054 46.6100n 0.001091 46.6200n 0.001129 46.6300n 0.001166 46.6400n 0.001202
+ 46.6500n 0.001239 46.6600n 0.001274 46.6700n 0.001310 46.6800n 0.001345 46.6900n 0.001379 46.7000n 0.001414 46.7100n 0.001447 46.7200n 0.001480 46.7300n 0.001513 46.7400n 0.001545 46.7500n 0.001577 46.7600n 0.001608 46.7700n 0.001639 46.7800n 0.001669 46.7900n 0.001698
+ 46.8000n 0.001727 46.8100n 0.001756 46.8200n 0.001783 46.8300n 0.001810 46.8400n 0.001837 46.8500n 0.001862 46.8600n 0.001888 46.8700n 0.001912 46.8800n 0.001936 46.8900n 0.001959 46.9000n 0.001982 46.9100n 0.002003 46.9200n 0.002024 46.9300n 0.002045 46.9400n 0.002064
+ 46.9500n 0.002083 46.9600n 0.002101 46.9700n 0.002119 46.9800n 0.002136 46.9900n 0.002152 47.0000n 0.002167 47.0100n 0.002182 47.0200n 0.002195 47.0300n 0.002208 47.0400n 0.002221 47.0500n 0.002232 47.0600n 0.002243 47.0700n 0.002253 47.0800n 0.002262 47.0900n 0.002271
+ 47.1000n 0.002279 47.1100n 0.002286 47.1200n 0.002292 47.1300n 0.002297 47.1400n 0.002302 47.1500n 0.002306 47.1600n 0.002310 47.1700n 0.002312 47.1800n 0.002314 47.1900n 0.002315 47.2000n 0.002316 47.2100n 0.002315 47.2200n 0.002314 47.2300n 0.002312 47.2400n 0.002310
+ 47.2500n 0.002307 47.2600n 0.002303 47.2700n 0.002298 47.2800n 0.002293 47.2900n 0.002287 47.3000n 0.002281 47.3100n 0.002273 47.3200n 0.002265 47.3300n 0.002257 47.3400n 0.002248 47.3500n 0.002238 47.3600n 0.002227 47.3700n 0.002216 47.3800n 0.002205 47.3900n 0.002193
+ 47.4000n 0.002180 47.4100n 0.002166 47.4200n 0.002152 47.4300n 0.002138 47.4400n 0.002123 47.4500n 0.002107 47.4600n 0.002091 47.4700n 0.002074 47.4800n 0.002057 47.4900n 0.002040 47.5000n 0.002021 47.5100n 0.002003 47.5200n 0.001984 47.5300n 0.001964 47.5400n 0.001944
+ 47.5500n 0.001924 47.5600n 0.001903 47.5700n 0.001882 47.5800n 0.001860 47.5900n 0.001838 47.6000n 0.001815 47.6100n 0.001793 47.6200n 0.001769 47.6300n 0.001746 47.6400n 0.001722 47.6500n 0.001698 47.6600n 0.001673 47.6700n 0.001648 47.6800n 0.001623 47.6900n 0.001598
+ 47.7000n 0.001572 47.7100n 0.001546 47.7200n 0.001520 47.7300n 0.001493 47.7400n 0.001467 47.7500n 0.001440 47.7600n 0.001412 47.7700n 0.001385 47.7800n 0.001358 47.7900n 0.001330 47.8000n 0.001302 47.8100n 0.001274 47.8200n 0.001245 47.8300n 0.001217 47.8400n 0.001188
+ 47.8500n 0.001159 47.8600n 0.001130 47.8700n 0.001101 47.8800n 0.001072 47.8900n 0.001043 47.9000n 0.001014 47.9100n 0.000984 47.9200n 0.000955 47.9300n 0.000925 47.9400n 0.000895 47.9500n 0.000866 47.9600n 0.000836 47.9700n 0.000806 47.9800n 0.000776 47.9900n 0.000746
+ 48.0000n 0.000716 48.0100n 0.000686 48.0200n 0.000656 48.0300n 0.000626 48.0400n 0.000596 48.0500n 0.000566 48.0600n 0.000536 48.0700n 0.000506 48.0800n 0.000476 48.0900n 0.000446 48.1000n 0.000416 48.1100n 0.000386 48.1200n 0.000356 48.1300n 0.000326 48.1400n 0.000296
+ 48.1500n 0.000266 48.1600n 0.000236 48.1700n 0.000206 48.1800n 0.000177 48.1900n 0.000147 48.2000n 0.000117 48.2100n 0.000088 48.2200n 0.000058 48.2300n 0.000029 48.2400n -0.000000 48.2500n -0.000030 48.2600n -0.000059 48.2700n -0.000088 48.2800n -0.000117 48.2900n -0.000146
+ 48.3000n -0.000175 48.3100n -0.000204 48.3200n -0.000232 48.3300n -0.000261 48.3400n -0.000289 48.3500n -0.000318 48.3600n -0.000346 48.3700n -0.000374 48.3800n -0.000402 48.3900n -0.000430 48.4000n -0.000458 48.4100n -0.000485 48.4200n -0.000513 48.4300n -0.000540 48.4400n -0.000568
+ 48.4500n -0.000595 48.4600n -0.000622 48.4700n -0.000649 48.4800n -0.000676 48.4900n -0.000703 48.5000n -0.000729 48.5100n -0.000756 48.5200n -0.000782 48.5300n -0.000808 48.5400n -0.000834 48.5500n -0.000860 48.5600n -0.000885 48.5700n -0.000911 48.5800n -0.000936 48.5900n -0.000961
+ 48.6000n -0.000986 48.6100n -0.001011 48.6200n -0.001036 48.6300n -0.001061 48.6400n -0.001085 48.6500n -0.001109 48.6600n -0.001133 48.6700n -0.001157 48.6800n -0.001180 48.6900n -0.001204 48.7000n -0.001227 48.7100n -0.001250 48.7200n -0.001273 48.7300n -0.001295 48.7400n -0.001318
+ 48.7500n -0.001340 48.7600n -0.001362 48.7700n -0.001384 48.7800n -0.001405 48.7900n -0.001426 48.8000n -0.001448 48.8100n -0.001468 48.8200n -0.001489 48.8300n -0.001509 48.8400n -0.001529 48.8500n -0.001549 48.8600n -0.001568 48.8700n -0.001588 48.8800n -0.001607 48.8900n -0.001625
+ 48.9000n -0.001644 48.9100n -0.001662 48.9200n -0.001680 48.9300n -0.001697 48.9400n -0.001714 48.9500n -0.001731 48.9600n -0.001748 48.9700n -0.001764 48.9800n -0.001780 48.9900n -0.001795 49.0000n -0.001811 49.0100n -0.001826 49.0200n -0.001840 49.0300n -0.001854 49.0400n -0.001868
+ 49.0500n -0.001881 49.0600n -0.001894 49.0700n -0.001907 49.0800n -0.001919 49.0900n -0.001931 49.1000n -0.001943 49.1100n -0.001954 49.1200n -0.001964 49.1300n -0.001975 49.1400n -0.001984 49.1500n -0.001994 49.1600n -0.002003 49.1700n -0.002011 49.1800n -0.002019 49.1900n -0.002027
+ 49.2000n -0.002034 49.2100n -0.002041 49.2200n -0.002047 49.2300n -0.002052 49.2400n -0.002058 49.2500n -0.002062 49.2600n -0.002067 49.2700n -0.002070 49.2800n -0.002074 49.2900n -0.002076 49.3000n -0.002078 49.3100n -0.002080 49.3200n -0.002081 49.3300n -0.002082 49.3400n -0.002082
+ 49.3500n -0.002082 49.3600n -0.002081 49.3700n -0.002079 49.3800n -0.002077 49.3900n -0.002075 49.4000n -0.002071 49.4100n -0.002068 49.4200n -0.002063 49.4300n -0.002059 49.4400n -0.002053 49.4500n -0.002047 49.4600n -0.002041 49.4700n -0.002034 49.4800n -0.002026 49.4900n -0.002018
+ 49.5000n -0.002009 49.5100n -0.002000 49.5200n -0.001990 49.5300n -0.001979 49.5400n -0.001968 49.5500n -0.001956 49.5600n -0.001944 49.5700n -0.001931 49.5800n -0.001918 49.5900n -0.001904 49.6000n -0.001889 49.6100n -0.001874 49.6200n -0.001858 49.6300n -0.001842 49.6400n -0.001825
+ 49.6500n -0.001808 49.6600n -0.001790 49.6700n -0.001771 49.6800n -0.001752 49.6900n -0.001732 49.7000n -0.001712 49.7100n -0.001691 49.7200n -0.001670 49.7300n -0.001648 49.7400n -0.001626 49.7500n -0.001603 49.7600n -0.001579 49.7700n -0.001555 49.7800n -0.001531 49.7900n -0.001506
+ 49.8000n -0.001480 49.8100n -0.001454 49.8200n -0.001428 49.8300n -0.001401 49.8400n -0.001374 49.8500n -0.001346 49.8600n -0.001317 49.8700n -0.001289 49.8800n -0.001259 49.8900n -0.001230 49.9000n -0.001200 49.9100n -0.001169 49.9200n -0.001138 49.9300n -0.001107 49.9400n -0.001075
+ 49.9500n -0.001043 49.9600n -0.001011 49.9700n -0.000978 49.9800n -0.000945 49.9900n -0.000912 50.0000n -0.000878 50.0100n -0.000844 50.0200n -0.000809 50.0300n -0.000775 50.0400n -0.000740 50.0500n -0.000704 50.0600n -0.000669 50.0700n -0.000633 50.0800n -0.000597 50.0900n -0.000561
+ 50.1000n -0.000525 50.1100n -0.000488 50.1200n -0.000451 50.1300n -0.000415 50.1400n -0.000377 50.1500n -0.000340 50.1600n -0.000303 50.1700n -0.000265 50.1800n -0.000228 50.1900n -0.000190 50.2000n -0.000153 50.2100n -0.000115 50.2200n -0.000077 50.2300n -0.000039 50.2400n -0.000001
+ 50.2500n 0.000037 50.2600n 0.000075 50.2700n 0.000113 50.2800n 0.000150 50.2900n 0.000188 50.3000n 0.000226 50.3100n 0.000264 50.3200n 0.000301 50.3300n 0.000339 50.3400n 0.000376 50.3500n 0.000413 50.3600n 0.000450 50.3700n 0.000487 50.3800n 0.000524 50.3900n 0.000561
+ 50.4000n 0.000597 50.4100n 0.000634 50.4200n 0.000670 50.4300n 0.000705 50.4400n 0.000741 50.4500n 0.000776 50.4600n 0.000811 50.4700n 0.000846 50.4800n 0.000881 50.4900n 0.000915 50.5000n 0.000949 50.5100n 0.000982 50.5200n 0.001016 50.5300n 0.001049 50.5400n 0.001081
+ 50.5500n 0.001113 50.5600n 0.001145 50.5700n 0.001177 50.5800n 0.001208 50.5900n 0.001238 50.6000n 0.001269 50.6100n 0.001298 50.6200n 0.001328 50.6300n 0.001357 50.6400n 0.001385 50.6500n 0.001413 50.6600n 0.001441 50.6700n 0.001468 50.6800n 0.001495 50.6900n 0.001521
+ 50.7000n 0.001547 50.7100n 0.001572 50.7200n 0.001597 50.7300n 0.001621 50.7400n 0.001645 50.7500n 0.001668 50.7600n 0.001691 50.7700n 0.001713 50.7800n 0.001734 50.7900n 0.001756 50.8000n 0.001776 50.8100n 0.001796 50.8200n 0.001816 50.8300n 0.001835 50.8400n 0.001853
+ 50.8500n 0.001871 50.8600n 0.001888 50.8700n 0.001905 50.8800n 0.001921 50.8900n 0.001937 50.9000n 0.001952 50.9100n 0.001966 50.9200n 0.001980 50.9300n 0.001994 50.9400n 0.002007 50.9500n 0.002019 50.9600n 0.002031 50.9700n 0.002042 50.9800n 0.002052 50.9900n 0.002063
+ 51.0000n 0.002072 51.0100n 0.002081 51.0200n 0.002090 51.0300n 0.002098 51.0400n 0.002105 51.0500n 0.002112 51.0600n 0.002118 51.0700n 0.002124 51.0800n 0.002129 51.0900n 0.002134 51.1000n 0.002138 51.1100n 0.002142 51.1200n 0.002146 51.1300n 0.002148 51.1400n 0.002151
+ 51.1500n 0.002153 51.1600n 0.002154 51.1700n 0.002155 51.1800n 0.002155 51.1900n 0.002155 51.2000n 0.002155 51.2100n 0.002154 51.2200n 0.002152 51.2300n 0.002151 51.2400n 0.002148 51.2500n 0.002146 51.2600n 0.002143 51.2700n 0.002139 51.2800n 0.002136 51.2900n 0.002131
+ 51.3000n 0.002127 51.3100n 0.002122 51.3200n 0.002117 51.3300n 0.002111 51.3400n 0.002105 51.3500n 0.002099 51.3600n 0.002092 51.3700n 0.002085 51.3800n 0.002078 51.3900n 0.002070 51.4000n 0.002063 51.4100n 0.002055 51.4200n 0.002046 51.4300n 0.002038 51.4400n 0.002029
+ 51.4500n 0.002020 51.4600n 0.002010 51.4700n 0.002001 51.4800n 0.001991 51.4900n 0.001981 51.5000n 0.001971 51.5100n 0.001961 51.5200n 0.001950 51.5300n 0.001939 51.5400n 0.001929 51.5500n 0.001918 51.5600n 0.001906 51.5700n 0.001895 51.5800n 0.001884 51.5900n 0.001872
+ 51.6000n 0.001861 51.6100n 0.001849 51.6200n 0.001837 51.6300n 0.001825 51.6400n 0.001813 51.6500n 0.001801 51.6600n 0.001789 51.6700n 0.001777 51.6800n 0.001765 51.6900n 0.001752 51.7000n 0.001740 51.7100n 0.001728 51.7200n 0.001716 51.7300n 0.001703 51.7400n 0.001691
+ 51.7500n 0.001679 51.7600n 0.001666 51.7700n 0.001654 51.7800n 0.001642 51.7900n 0.001629 51.8000n 0.001617 51.8100n 0.001605 51.8200n 0.001593 51.8300n 0.001581 51.8400n 0.001568 51.8500n 0.001556 51.8600n 0.001544 51.8700n 0.001533 51.8800n 0.001521 51.8900n 0.001509
+ 51.9000n 0.001497 51.9100n 0.001486 51.9200n 0.001474 51.9300n 0.001462 51.9400n 0.001451 51.9500n 0.001440 51.9600n 0.001428 51.9700n 0.001417 51.9800n 0.001406 51.9900n 0.001395 52.0000n 0.001384 52.0100n 0.001373 52.0200n 0.001363 52.0300n 0.001352 52.0400n 0.001342
+ 52.0500n 0.001331 52.0600n 0.001321 52.0700n 0.001310 52.0800n 0.001300 52.0900n 0.001290 52.1000n 0.001280 52.1100n 0.001270 52.1200n 0.001260 52.1300n 0.001251 52.1400n 0.001241 52.1500n 0.001231 52.1600n 0.001222 52.1700n 0.001212 52.1800n 0.001203 52.1900n 0.001194
+ 52.2000n 0.001185 52.2100n 0.001175 52.2200n 0.001166 52.2300n 0.001157 52.2400n 0.001148 52.2500n 0.001139 52.2600n 0.001130 52.2700n 0.001121 52.2800n 0.001113 52.2900n 0.001104 52.3000n 0.001095 52.3100n 0.001086 52.3200n 0.001077 52.3300n 0.001069 52.3400n 0.001060
+ 52.3500n 0.001051 52.3600n 0.001042 52.3700n 0.001034 52.3800n 0.001025 52.3900n 0.001016 52.4000n 0.001007 52.4100n 0.000999 52.4200n 0.000990 52.4300n 0.000981 52.4400n 0.000972 52.4500n 0.000963 52.4600n 0.000954 52.4700n 0.000945 52.4800n 0.000935 52.4900n 0.000926
+ 52.5000n 0.000917 52.5100n 0.000907 52.5200n 0.000898 52.5300n 0.000888 52.5400n 0.000878 52.5500n 0.000868 52.5600n 0.000858 52.5700n 0.000848 52.5800n 0.000838 52.5900n 0.000828 52.6000n 0.000817 52.6100n 0.000806 52.6200n 0.000796 52.6300n 0.000785 52.6400n 0.000773
+ 52.6500n 0.000762 52.6600n 0.000751 52.6700n 0.000739 52.6800n 0.000727 52.6900n 0.000715 52.7000n 0.000703 52.7100n 0.000690 52.7200n 0.000677 52.7300n 0.000664 52.7400n 0.000651 52.7500n 0.000638 52.7600n 0.000624 52.7700n 0.000610 52.7800n 0.000596 52.7900n 0.000582
+ 52.8000n 0.000567 52.8100n 0.000553 52.8200n 0.000538 52.8300n 0.000522 52.8400n 0.000507 52.8500n 0.000491 52.8600n 0.000475 52.8700n 0.000458 52.8800n 0.000441 52.8900n 0.000424 52.9000n 0.000407 52.9100n 0.000390 52.9200n 0.000372 52.9300n 0.000354 52.9400n 0.000335
+ 52.9500n 0.000317 52.9600n 0.000298 52.9700n 0.000278 52.9800n 0.000259 52.9900n 0.000239 53.0000n 0.000219 53.0100n 0.000198 53.0200n 0.000177 53.0300n 0.000156 53.0400n 0.000135 53.0500n 0.000113 53.0600n 0.000091 53.0700n 0.000069 53.0800n 0.000047 53.0900n 0.000024
+ 53.1000n 0.000001 53.1100n -0.000023 53.1200n -0.000047 53.1300n -0.000071 53.1400n -0.000095 53.1500n -0.000120 53.1600n -0.000144 53.1700n -0.000170 53.1800n -0.000195 53.1900n -0.000221 53.2000n -0.000247 53.2100n -0.000273 53.2200n -0.000300 53.2300n -0.000326 53.2400n -0.000353
+ 53.2500n -0.000381 53.2600n -0.000408 53.2700n -0.000436 53.2800n -0.000464 53.2900n -0.000492 53.3000n -0.000521 53.3100n -0.000549 53.3200n -0.000578 53.3300n -0.000607 53.3400n -0.000637 53.3500n -0.000666 53.3600n -0.000696 53.3700n -0.000726 53.3800n -0.000756 53.3900n -0.000786
+ 53.4000n -0.000817 53.4100n -0.000847 53.4200n -0.000878 53.4300n -0.000909 53.4400n -0.000940 53.4500n -0.000971 53.4600n -0.001002 53.4700n -0.001034 53.4800n -0.001065 53.4900n -0.001097 53.5000n -0.001129 53.5100n -0.001160 53.5200n -0.001192 53.5300n -0.001224 53.5400n -0.001256
+ 53.5500n -0.001288 53.5600n -0.001320 53.5700n -0.001352 53.5800n -0.001384 53.5900n -0.001416 53.6000n -0.001448 53.6100n -0.001480 53.6200n -0.001512 53.6300n -0.001544 53.6400n -0.001576 53.6500n -0.001608 53.6600n -0.001640 53.6700n -0.001671 53.6800n -0.001703 53.6900n -0.001735
+ 53.7000n -0.001766 53.7100n -0.001798 53.7200n -0.001829 53.7300n -0.001860 53.7400n -0.001891 53.7500n -0.001922 53.7600n -0.001952 53.7700n -0.001983 53.7800n -0.002013 53.7900n -0.002043 53.8000n -0.002073 53.8100n -0.002103 53.8200n -0.002132 53.8300n -0.002162 53.8400n -0.002191
+ 53.8500n -0.002219 53.8600n -0.002248 53.8700n -0.002276 53.8800n -0.002304 53.8900n -0.002331 53.9000n -0.002359 53.9100n -0.002386 53.9200n -0.002412 53.9300n -0.002439 53.9400n -0.002465 53.9500n -0.002490 53.9600n -0.002516 53.9700n -0.002541 53.9800n -0.002565 53.9900n -0.002589
+ 54.0000n -0.002613 54.0100n -0.002636 54.0200n -0.002659 54.0300n -0.002682 54.0400n -0.002704 54.0500n -0.002725 54.0600n -0.002746 54.0700n -0.002767 54.0800n -0.002787 54.0900n -0.002807 54.1000n -0.002826 54.1100n -0.002845 54.1200n -0.002863 54.1300n -0.002881 54.1400n -0.002898
+ 54.1500n -0.002915 54.1600n -0.002931 54.1700n -0.002947 54.1800n -0.002962 54.1900n -0.002976 54.2000n -0.002990 54.2100n -0.003004 54.2200n -0.003016 54.2300n -0.003029 54.2400n -0.003040 54.2500n -0.003052 54.2600n -0.003062 54.2700n -0.003072 54.2800n -0.003081 54.2900n -0.003090
+ 54.3000n -0.003098 54.3100n -0.003106 54.3200n -0.003113 54.3300n -0.003119 54.3400n -0.003125 54.3500n -0.003130 54.3600n -0.003134 54.3700n -0.003138 54.3800n -0.003141 54.3900n -0.003143 54.4000n -0.003145 54.4100n -0.003146 54.4200n -0.003147 54.4300n -0.003147 54.4400n -0.003146
+ 54.4500n -0.003145 54.4600n -0.003143 54.4700n -0.003140 54.4800n -0.003137 54.4900n -0.003133 54.5000n -0.003128 54.5100n -0.003123 54.5200n -0.003117 54.5300n -0.003110 54.5400n -0.003103 54.5500n -0.003095 54.5600n -0.003087 54.5700n -0.003078 54.5800n -0.003068 54.5900n -0.003058
+ 54.6000n -0.003047 54.6100n -0.003035 54.6200n -0.003023 54.6300n -0.003010 54.6400n -0.002996 54.6500n -0.002982 54.6600n -0.002967 54.6700n -0.002952 54.6800n -0.002936 54.6900n -0.002919 54.7000n -0.002902 54.7100n -0.002885 54.7200n -0.002866 54.7300n -0.002847 54.7400n -0.002828
+ 54.7500n -0.002808 54.7600n -0.002787 54.7700n -0.002766 54.7800n -0.002744 54.7900n -0.002722 54.8000n -0.002699 54.8100n -0.002676 54.8200n -0.002652 54.8300n -0.002628 54.8400n -0.002603 54.8500n -0.002578 54.8600n -0.002552 54.8700n -0.002526 54.8800n -0.002499 54.8900n -0.002472
+ 54.9000n -0.002445 54.9100n -0.002417 54.9200n -0.002388 54.9300n -0.002359 54.9400n -0.002330 54.9500n -0.002300 54.9600n -0.002270 54.9700n -0.002240 54.9800n -0.002209 54.9900n -0.002178 55.0000n -0.002147 55.0100n -0.002115 55.0200n -0.002083 55.0300n -0.002050 55.0400n -0.002018
+ 55.0500n -0.001985 55.0600n -0.001951 55.0700n -0.001918 55.0800n -0.001884 55.0900n -0.001850 55.1000n -0.001816 55.1100n -0.001782 55.1200n -0.001747 55.1300n -0.001712 55.1400n -0.001677 55.1500n -0.001642 55.1600n -0.001607 55.1700n -0.001572 55.1800n -0.001536 55.1900n -0.001500
+ 55.2000n -0.001465 55.2100n -0.001429 55.2200n -0.001393 55.2300n -0.001357 55.2400n -0.001321 55.2500n -0.001286 55.2600n -0.001250 55.2700n -0.001214 55.2800n -0.001178 55.2900n -0.001142 55.3000n -0.001106 55.3100n -0.001070 55.3200n -0.001035 55.3300n -0.000999 55.3400n -0.000964
+ 55.3500n -0.000928 55.3600n -0.000893 55.3700n -0.000858 55.3800n -0.000823 55.3900n -0.000788 55.4000n -0.000753 55.4100n -0.000719 55.4200n -0.000685 55.4300n -0.000651 55.4400n -0.000617 55.4500n -0.000584 55.4600n -0.000550 55.4700n -0.000517 55.4800n -0.000485 55.4900n -0.000452
+ 55.5000n -0.000420 55.5100n -0.000388 55.5200n -0.000357 55.5300n -0.000326 55.5400n -0.000295 55.5500n -0.000265 55.5600n -0.000235 55.5700n -0.000205 55.5800n -0.000176 55.5900n -0.000147 55.6000n -0.000119 55.6100n -0.000091 55.6200n -0.000063 55.6300n -0.000036 55.6400n -0.000010
+ 55.6500n 0.000017 55.6600n 0.000042 55.6700n 0.000067 55.6800n 0.000092 55.6900n 0.000116 55.7000n 0.000140 55.7100n 0.000163 55.7200n 0.000185 55.7300n 0.000207 55.7400n 0.000229 55.7500n 0.000250 55.7600n 0.000270 55.7700n 0.000290 55.7800n 0.000309 55.7900n 0.000328
+ 55.8000n 0.000346 55.8100n 0.000364 55.8200n 0.000380 55.8300n 0.000397 55.8400n 0.000412 55.8500n 0.000427 55.8600n 0.000442 55.8700n 0.000456 55.8800n 0.000469 55.8900n 0.000482 55.9000n 0.000494 55.9100n 0.000505 55.9200n 0.000516 55.9300n 0.000526 55.9400n 0.000535
+ 55.9500n 0.000544 55.9600n 0.000552 55.9700n 0.000560 55.9800n 0.000567 55.9900n 0.000573 56.0000n 0.000579 56.0100n 0.000584 56.0200n 0.000588 56.0300n 0.000592 56.0400n 0.000595 56.0500n 0.000598 56.0600n 0.000599 56.0700n 0.000601 56.0800n 0.000601 56.0900n 0.000601
+ 56.1000n 0.000601 56.1100n 0.000600 56.1200n 0.000598 56.1300n 0.000596 56.1400n 0.000593 56.1500n 0.000589 56.1600n 0.000585 56.1700n 0.000581 56.1800n 0.000575 56.1900n 0.000570 56.2000n 0.000563 56.2100n 0.000556 56.2200n 0.000549 56.2300n 0.000541 56.2400n 0.000533
+ 56.2500n 0.000524 56.2600n 0.000514 56.2700n 0.000504 56.2800n 0.000494 56.2900n 0.000483 56.3000n 0.000472 56.3100n 0.000460 56.3200n 0.000448 56.3300n 0.000435 56.3400n 0.000422 56.3500n 0.000409 56.3600n 0.000395 56.3700n 0.000380 56.3800n 0.000366 56.3900n 0.000351
+ 56.4000n 0.000335 56.4100n 0.000320 56.4200n 0.000304 56.4300n 0.000288 56.4400n 0.000271 56.4500n 0.000254 56.4600n 0.000237 56.4700n 0.000220 56.4800n 0.000202 56.4900n 0.000184 56.5000n 0.000166 56.5100n 0.000148 56.5200n 0.000129 56.5300n 0.000111 56.5400n 0.000092
+ 56.5500n 0.000073 56.5600n 0.000054 56.5700n 0.000035 56.5800n 0.000016 56.5900n -0.000003 56.6000n -0.000023 56.6100n -0.000042 56.6200n -0.000062 56.6300n -0.000081 56.6400n -0.000101 56.6500n -0.000120 56.6600n -0.000139 56.6700n -0.000159 56.6800n -0.000178 56.6900n -0.000197
+ 56.7000n -0.000217 56.7100n -0.000236 56.7200n -0.000255 56.7300n -0.000273 56.7400n -0.000292 56.7500n -0.000311 56.7600n -0.000329 56.7700n -0.000347 56.7800n -0.000365 56.7900n -0.000383 56.8000n -0.000400 56.8100n -0.000417 56.8200n -0.000434 56.8300n -0.000451 56.8400n -0.000467
+ 56.8500n -0.000484 56.8600n -0.000499 56.8700n -0.000515 56.8800n -0.000530 56.8900n -0.000545 56.9000n -0.000559 56.9100n -0.000573 56.9200n -0.000587 56.9300n -0.000600 56.9400n -0.000613 56.9500n -0.000625 56.9600n -0.000637 56.9700n -0.000648 56.9800n -0.000659 56.9900n -0.000670
+ 57.0000n -0.000680 57.0100n -0.000690 57.0200n -0.000699 57.0300n -0.000707 57.0400n -0.000715 57.0500n -0.000723 57.0600n -0.000730 57.0700n -0.000737 57.0800n -0.000742 57.0900n -0.000748 57.1000n -0.000753 57.1100n -0.000757 57.1200n -0.000761 57.1300n -0.000764 57.1400n -0.000766
+ 57.1500n -0.000768 57.1600n -0.000769 57.1700n -0.000770 57.1800n -0.000770 57.1900n -0.000770 57.2000n -0.000769 57.2100n -0.000767 57.2200n -0.000764 57.2300n -0.000761 57.2400n -0.000758 57.2500n -0.000754 57.2600n -0.000749 57.2700n -0.000743 57.2800n -0.000737 57.2900n -0.000730
+ 57.3000n -0.000723 57.3100n -0.000715 57.3200n -0.000707 57.3300n -0.000697 57.3400n -0.000687 57.3500n -0.000677 57.3600n -0.000666 57.3700n -0.000654 57.3800n -0.000642 57.3900n -0.000629 57.4000n -0.000616 57.4100n -0.000601 57.4200n -0.000587 57.4300n -0.000571 57.4400n -0.000556
+ 57.4500n -0.000539 57.4600n -0.000522 57.4700n -0.000504 57.4800n -0.000486 57.4900n -0.000468 57.5000n -0.000448 57.5100n -0.000429 57.5200n -0.000408 57.5300n -0.000388 57.5400n -0.000366 57.5500n -0.000344 57.5600n -0.000322 57.5700n -0.000299 57.5800n -0.000276 57.5900n -0.000252
+ 57.6000n -0.000228 57.6100n -0.000203 57.6200n -0.000178 57.6300n -0.000153 57.6400n -0.000127 57.6500n -0.000101 57.6600n -0.000074 57.6700n -0.000047 57.6800n -0.000020 57.6900n 0.000008 57.7000n 0.000036 57.7100n 0.000064 57.7200n 0.000093 57.7300n 0.000122 57.7400n 0.000151
+ 57.7500n 0.000181 57.7600n 0.000211 57.7700n 0.000241 57.7800n 0.000271 57.7900n 0.000301 57.8000n 0.000332 57.8100n 0.000363 57.8200n 0.000394 57.8300n 0.000425 57.8400n 0.000456 57.8500n 0.000488 57.8600n 0.000519 57.8700n 0.000551 57.8800n 0.000582 57.8900n 0.000614
+ 57.9000n 0.000646 57.9100n 0.000678 57.9200n 0.000710 57.9300n 0.000742 57.9400n 0.000773 57.9500n 0.000805 57.9600n 0.000837 57.9700n 0.000869 57.9800n 0.000901 57.9900n 0.000932 58.0000n 0.000964 58.0100n 0.000995 58.0200n 0.001026 58.0300n 0.001057 58.0400n 0.001088
+ 58.0500n 0.001119 58.0600n 0.001150 58.0700n 0.001180 58.0800n 0.001210 58.0900n 0.001240 58.1000n 0.001270 58.1100n 0.001300 58.1200n 0.001329 58.1300n 0.001358 58.1400n 0.001386 58.1500n 0.001415 58.1600n 0.001443 58.1700n 0.001471 58.1800n 0.001498 58.1900n 0.001525
+ 58.2000n 0.001552 58.2100n 0.001578 58.2200n 0.001604 58.2300n 0.001629 58.2400n 0.001655 58.2500n 0.001679 58.2600n 0.001704 58.2700n 0.001727 58.2800n 0.001751 58.2900n 0.001774 58.3000n 0.001796 58.3100n 0.001818 58.3200n 0.001840 58.3300n 0.001861 58.3400n 0.001882
+ 58.3500n 0.001902 58.3600n 0.001921 58.3700n 0.001940 58.3800n 0.001959 58.3900n 0.001977 58.4000n 0.001994 58.4100n 0.002011 58.4200n 0.002028 58.4300n 0.002044 58.4400n 0.002059 58.4500n 0.002074 58.4600n 0.002088 58.4700n 0.002102 58.4800n 0.002115 58.4900n 0.002127
+ 58.5000n 0.002139 58.5100n 0.002150 58.5200n 0.002161 58.5300n 0.002171 58.5400n 0.002181 58.5500n 0.002190 58.5600n 0.002198 58.5700n 0.002206 58.5800n 0.002214 58.5900n 0.002220 58.6000n 0.002226 58.6100n 0.002232 58.6200n 0.002237 58.6300n 0.002241 58.6400n 0.002245
+ 58.6500n 0.002248 58.6600n 0.002251 58.6700n 0.002253 58.6800n 0.002255 58.6900n 0.002256 58.7000n 0.002256 58.7100n 0.002256 58.7200n 0.002255 58.7300n 0.002254 58.7400n 0.002252 58.7500n 0.002250 58.7600n 0.002247 58.7700n 0.002244 58.7800n 0.002240 58.7900n 0.002235
+ 58.8000n 0.002230 58.8100n 0.002225 58.8200n 0.002219 58.8300n 0.002213 58.8400n 0.002206 58.8500n 0.002198 58.8600n 0.002191 58.8700n 0.002182 58.8800n 0.002174 58.8900n 0.002164 58.9000n 0.002155 58.9100n 0.002145 58.9200n 0.002134 58.9300n 0.002123 58.9400n 0.002112
+ 58.9500n 0.002100 58.9600n 0.002088 58.9700n 0.002076 58.9800n 0.002063 58.9900n 0.002050 59.0000n 0.002036 59.0100n 0.002023 59.0200n 0.002008 59.0300n 0.001994 59.0400n 0.001979 59.0500n 0.001964 59.0600n 0.001949 59.0700n 0.001933 59.0800n 0.001917 59.0900n 0.001901
+ 59.1000n 0.001884 59.1100n 0.001868 59.1200n 0.001851 59.1300n 0.001833 59.1400n 0.001816 59.1500n 0.001799 59.1600n 0.001781 59.1700n 0.001763 59.1800n 0.001745 59.1900n 0.001726 59.2000n 0.001708 59.2100n 0.001689 59.2200n 0.001671 59.2300n 0.001652 59.2400n 0.001633
+ 59.2500n 0.001614 59.2600n 0.001595 59.2700n 0.001576 59.2800n 0.001556 59.2900n 0.001537 59.3000n 0.001518 59.3100n 0.001498 59.3200n 0.001479 59.3300n 0.001459 59.3400n 0.001440 59.3500n 0.001420 59.3600n 0.001401 59.3700n 0.001381 59.3800n 0.001362 59.3900n 0.001342
+ 59.4000n 0.001323 59.4100n 0.001303 59.4200n 0.001284 59.4300n 0.001264 59.4400n 0.001245 59.4500n 0.001226 59.4600n 0.001207 59.4700n 0.001188 59.4800n 0.001169 59.4900n 0.001150 59.5000n 0.001131 59.5100n 0.001113 59.5200n 0.001094 59.5300n 0.001076 59.5400n 0.001057
+ 59.5500n 0.001039 59.5600n 0.001021 59.5700n 0.001003 59.5800n 0.000985 59.5900n 0.000968 59.6000n 0.000950 59.6100n 0.000933 59.6200n 0.000916 59.6300n 0.000899 59.6400n 0.000882 59.6500n 0.000866 59.6600n 0.000849 59.6700n 0.000833 59.6800n 0.000817 59.6900n 0.000801
+ 59.7000n 0.000785 59.7100n 0.000770 59.7200n 0.000755 59.7300n 0.000739 59.7400n 0.000725 59.7500n 0.000710 59.7600n 0.000695 59.7700n 0.000681 59.7800n 0.000667 59.7900n 0.000653 59.8000n 0.000639 59.8100n 0.000626 59.8200n 0.000613 59.8300n 0.000600 59.8400n 0.000587
+ 59.8500n 0.000574 59.8600n 0.000562 59.8700n 0.000549 59.8800n 0.000537 59.8900n 0.000526 59.9000n 0.000514 59.9100n 0.000503 59.9200n 0.000491 59.9300n 0.000480 59.9400n 0.000470 59.9500n 0.000459 59.9600n 0.000449 59.9700n 0.000439 59.9800n 0.000429 59.9900n 0.000419
+ 60.0000n 0.000409 60.0100n 0.000400 60.0200n 0.000391 60.0300n 0.000382 60.0400n 0.000373 60.0500n 0.000364 60.0600n 0.000355 60.0700n 0.000347 60.0800n 0.000339 60.0900n 0.000331 60.1000n 0.000323 60.1100n 0.000316 60.1200n 0.000308 60.1300n 0.000301 60.1400n 0.000294
+ 60.1500n 0.000287 60.1600n 0.000280 60.1700n 0.000273 60.1800n 0.000267 60.1900n 0.000260 60.2000n 0.000254 60.2100n 0.000248 60.2200n 0.000242 60.2300n 0.000236 60.2400n 0.000230 60.2500n 0.000224 60.2600n 0.000219 60.2700n 0.000213 60.2800n 0.000208 60.2900n 0.000203
+ 60.3000n 0.000198 60.3100n 0.000193 60.3200n 0.000188 60.3300n 0.000183 60.3400n 0.000179 60.3500n 0.000174 60.3600n 0.000169 60.3700n 0.000165 60.3800n 0.000161 60.3900n 0.000156 60.4000n 0.000152 60.4100n 0.000148 60.4200n 0.000144 60.4300n 0.000140 60.4400n 0.000136
+ 60.4500n 0.000132 60.4600n 0.000128 60.4700n 0.000125 60.4800n 0.000121 60.4900n 0.000117 60.5000n 0.000114 60.5100n 0.000110 60.5200n 0.000106 60.5300n 0.000103 60.5400n 0.000099 60.5500n 0.000096 60.5600n 0.000093 60.5700n 0.000089 60.5800n 0.000086 60.5900n 0.000083
+ 60.6000n 0.000079 60.6100n 0.000076 60.6200n 0.000073 60.6300n 0.000069 60.6400n 0.000066 60.6500n 0.000063 60.6600n 0.000060 60.6700n 0.000057 60.6800n 0.000053 60.6900n 0.000050 60.7000n 0.000047 60.7100n 0.000044 60.7200n 0.000041 60.7300n 0.000038 60.7400n 0.000035
+ 60.7500n 0.000032 60.7600n 0.000028 60.7700n 0.000025 60.7800n 0.000022 60.7900n 0.000019 60.8000n 0.000016 60.8100n 0.000013 60.8200n 0.000010 60.8300n 0.000007 60.8400n 0.000003 60.8500n 0.000000 60.8600n -0.000003 60.8700n -0.000006 60.8800n -0.000009 60.8900n -0.000012
+ 60.9000n -0.000015 60.9100n -0.000018 60.9200n -0.000022 60.9300n -0.000025 60.9400n -0.000028 60.9500n -0.000031 60.9600n -0.000034 60.9700n -0.000037 60.9800n -0.000041 60.9900n -0.000044 61.0000n -0.000047 61.0100n -0.000050 61.0200n -0.000053 61.0300n -0.000056 61.0400n -0.000060
+ 61.0500n -0.000063 61.0600n -0.000066 61.0700n -0.000069 61.0800n -0.000072 61.0900n -0.000075 61.1000n -0.000079 61.1100n -0.000082 61.1200n -0.000085 61.1300n -0.000088 61.1400n -0.000091 61.1500n -0.000094 61.1600n -0.000097 61.1700n -0.000101 61.1800n -0.000104 61.1900n -0.000107
+ 61.2000n -0.000110 61.2100n -0.000113 61.2200n -0.000116 61.2300n -0.000119 61.2400n -0.000122 61.2500n -0.000126 61.2600n -0.000129 61.2700n -0.000132 61.2800n -0.000135 61.2900n -0.000138 61.3000n -0.000141 61.3100n -0.000144 61.3200n -0.000147 61.3300n -0.000150 61.3400n -0.000153
+ 61.3500n -0.000156 61.3600n -0.000159 61.3700n -0.000162 61.3800n -0.000165 61.3900n -0.000168 61.4000n -0.000171 61.4100n -0.000174 61.4200n -0.000177 61.4300n -0.000180 61.4400n -0.000183 61.4500n -0.000186 61.4600n -0.000189 61.4700n -0.000192 61.4800n -0.000195 61.4900n -0.000198
+ 61.5000n -0.000201 61.5100n -0.000204 61.5200n -0.000207 61.5300n -0.000210 61.5400n -0.000213 61.5500n -0.000217 61.5600n -0.000220 61.5700n -0.000223 61.5800n -0.000226 61.5900n -0.000229 61.6000n -0.000232 61.6100n -0.000235 61.6200n -0.000238 61.6300n -0.000241 61.6400n -0.000244
+ 61.6500n -0.000247 61.6600n -0.000251 61.6700n -0.000254 61.6800n -0.000257 61.6900n -0.000260 61.7000n -0.000263 61.7100n -0.000267 61.7200n -0.000270 61.7300n -0.000273 61.7400n -0.000277 61.7500n -0.000280 61.7600n -0.000284 61.7700n -0.000287 61.7800n -0.000291 61.7900n -0.000294
+ 61.8000n -0.000298 61.8100n -0.000301 61.8200n -0.000305 61.8300n -0.000309 61.8400n -0.000313 61.8500n -0.000316 61.8600n -0.000320 61.8700n -0.000324 61.8800n -0.000328 61.8900n -0.000332 61.9000n -0.000336 61.9100n -0.000340 61.9200n -0.000344 61.9300n -0.000349 61.9400n -0.000353
+ 61.9500n -0.000357 61.9600n -0.000362 61.9700n -0.000366 61.9800n -0.000371 61.9900n -0.000375 62.0000n -0.000380 62.0100n -0.000385 62.0200n -0.000390 62.0300n -0.000395 62.0400n -0.000400 62.0500n -0.000405 62.0600n -0.000410 62.0700n -0.000415 62.0800n -0.000420 62.0900n -0.000426
+ 62.1000n -0.000431 62.1100n -0.000436 62.1200n -0.000442 62.1300n -0.000448 62.1400n -0.000453 62.1500n -0.000459 62.1600n -0.000465 62.1700n -0.000471 62.1800n -0.000477 62.1900n -0.000483 62.2000n -0.000489 62.2100n -0.000495 62.2200n -0.000502 62.2300n -0.000508 62.2400n -0.000514
+ 62.2500n -0.000521 62.2600n -0.000528 62.2700n -0.000534 62.2800n -0.000541 62.2900n -0.000548 62.3000n -0.000555 62.3100n -0.000562 62.3200n -0.000569 62.3300n -0.000576 62.3400n -0.000583 62.3500n -0.000590 62.3600n -0.000597 62.3700n -0.000604 62.3800n -0.000612 62.3900n -0.000619
+ 62.4000n -0.000627 62.4100n -0.000634 62.4200n -0.000642 62.4300n -0.000649 62.4400n -0.000657 62.4500n -0.000665 62.4600n -0.000672 62.4700n -0.000680 62.4800n -0.000688 62.4900n -0.000696 62.5000n -0.000703 62.5100n -0.000711 62.5200n -0.000719 62.5300n -0.000727 62.5400n -0.000735
+ 62.5500n -0.000743 62.5600n -0.000750 62.5700n -0.000758 62.5800n -0.000766 62.5900n -0.000774 62.6000n -0.000782 62.6100n -0.000790 62.6200n -0.000798 62.6300n -0.000805 62.6400n -0.000813 62.6500n -0.000821 62.6600n -0.000829 62.6700n -0.000836 62.6800n -0.000844 62.6900n -0.000852
+ 62.7000n -0.000859 62.7100n -0.000867 62.7200n -0.000874 62.7300n -0.000881 62.7400n -0.000889 62.7500n -0.000896 62.7600n -0.000903 62.7700n -0.000910 62.7800n -0.000917 62.7900n -0.000924 62.8000n -0.000931 62.8100n -0.000937 62.8200n -0.000944 62.8300n -0.000950 62.8400n -0.000957
+ 62.8500n -0.000963 62.8600n -0.000969 62.8700n -0.000975 62.8800n -0.000981 62.8900n -0.000987 62.9000n -0.000992 62.9100n -0.000998 62.9200n -0.001003 62.9300n -0.001008 62.9400n -0.001013 62.9500n -0.001018 62.9600n -0.001023 62.9700n -0.001027 62.9800n -0.001032 62.9900n -0.001036
+ 63.0000n -0.001040 63.0100n -0.001043 63.0200n -0.001047 63.0300n -0.001050 63.0400n -0.001054 63.0500n -0.001057 63.0600n -0.001059 63.0700n -0.001062 63.0800n -0.001064 63.0900n -0.001067 63.1000n -0.001069 63.1100n -0.001070 63.1200n -0.001072 63.1300n -0.001073 63.1400n -0.001074
+ 63.1500n -0.001075 63.1600n -0.001076 63.1700n -0.001076 63.1800n -0.001076 63.1900n -0.001076 63.2000n -0.001076 63.2100n -0.001075 63.2200n -0.001074 63.2300n -0.001073 63.2400n -0.001072 63.2500n -0.001070 63.2600n -0.001069 63.2700n -0.001067 63.2800n -0.001064 63.2900n -0.001062
+ 63.3000n -0.001059 63.3100n -0.001056 63.3200n -0.001053 63.3300n -0.001049 63.3400n -0.001045 63.3500n -0.001041 63.3600n -0.001037 63.3700n -0.001032 63.3800n -0.001027 63.3900n -0.001022 63.4000n -0.001017 63.4100n -0.001011 63.4200n -0.001006 63.4300n -0.001000 63.4400n -0.000993
+ 63.4500n -0.000987 63.4600n -0.000980 63.4700n -0.000973 63.4800n -0.000966 63.4900n -0.000958 63.5000n -0.000950 63.5100n -0.000942 63.5200n -0.000934 63.5300n -0.000926 63.5400n -0.000917 63.5500n -0.000908 63.5600n -0.000899 63.5700n -0.000890 63.5800n -0.000880 63.5900n -0.000871
+ 63.6000n -0.000861 63.6100n -0.000851 63.6200n -0.000840 63.6300n -0.000830 63.6400n -0.000819 63.6500n -0.000808 63.6600n -0.000797 63.6700n -0.000786 63.6800n -0.000775 63.6900n -0.000763 63.7000n -0.000751 63.7100n -0.000740 63.7200n -0.000728 63.7300n -0.000715 63.7400n -0.000703
+ 63.7500n -0.000691 63.7600n -0.000678 63.7700n -0.000666 63.7800n -0.000653 63.7900n -0.000640 63.8000n -0.000627 63.8100n -0.000614 63.8200n -0.000601 63.8300n -0.000587 63.8400n -0.000574 63.8500n -0.000560 63.8600n -0.000547 63.8700n -0.000533 63.8800n -0.000520 63.8900n -0.000506
+ 63.9000n -0.000492 63.9100n -0.000479 63.9200n -0.000465 63.9300n -0.000451 63.9400n -0.000437 63.9500n -0.000423 63.9600n -0.000409 63.9700n -0.000396 63.9800n -0.000382 63.9900n -0.000368 64.0000n -0.000354 64.0100n -0.000340 64.0200n -0.000326 64.0300n -0.000313 64.0400n -0.000299
+ 64.0500n -0.000285 64.0600n -0.000272 64.0700n -0.000258 64.0800n -0.000245 64.0900n -0.000232 64.1000n -0.000218 64.1100n -0.000205 64.1200n -0.000192 64.1300n -0.000179 64.1400n -0.000166 64.1500n -0.000153 64.1600n -0.000141 64.1700n -0.000128 64.1800n -0.000116 64.1900n -0.000103
+ 64.2000n -0.000091 64.2100n -0.000079 64.2200n -0.000067 64.2300n -0.000056 64.2400n -0.000044 64.2500n -0.000033 64.2600n -0.000022 64.2700n -0.000011 64.2800n 0.000000 64.2900n 0.000011 64.3000n 0.000021 64.3100n 0.000032 64.3200n 0.000042 64.3300n 0.000051 64.3400n 0.000061
+ 64.3500n 0.000070 64.3600n 0.000080 64.3700n 0.000089 64.3800n 0.000097 64.3900n 0.000106 64.4000n 0.000114 64.4100n 0.000122 64.4200n 0.000130 64.4300n 0.000138 64.4400n 0.000145 64.4500n 0.000152 64.4600n 0.000159 64.4700n 0.000166 64.4800n 0.000172 64.4900n 0.000178
+ 64.5000n 0.000184 64.5100n 0.000190 64.5200n 0.000195 64.5300n 0.000200 64.5400n 0.000205 64.5500n 0.000209 64.5600n 0.000214 64.5700n 0.000218 64.5800n 0.000221 64.5900n 0.000225 64.6000n 0.000228 64.6100n 0.000231 64.6200n 0.000234 64.6300n 0.000236 64.6400n 0.000238
+ 64.6500n 0.000240 64.6600n 0.000242 64.6700n 0.000243 64.6800n 0.000244 64.6900n 0.000245 64.7000n 0.000245 64.7100n 0.000245 64.7200n 0.000245 64.7300n 0.000245 64.7400n 0.000245 64.7500n 0.000244 64.7600n 0.000243 64.7700n 0.000241 64.7800n 0.000240 64.7900n 0.000238
+ 64.8000n 0.000236 64.8100n 0.000234 64.8200n 0.000231 64.8300n 0.000228 64.8400n 0.000225 64.8500n 0.000222 64.8600n 0.000218 64.8700n 0.000214 64.8800n 0.000210 64.8900n 0.000206 64.9000n 0.000202 64.9100n 0.000197 64.9200n 0.000192 64.9300n 0.000187 64.9400n 0.000182
+ 64.9500n 0.000176 64.9600n 0.000170 64.9700n 0.000165 64.9800n 0.000158 64.9900n 0.000152 65.0000n 0.000146 65.0100n 0.000139 65.0200n 0.000132 65.0300n 0.000125 65.0400n 0.000118 65.0500n 0.000110 65.0600n 0.000103 65.0700n 0.000095 65.0800n 0.000087 65.0900n 0.000080
+ 65.1000n 0.000071 65.1100n 0.000063 65.1200n 0.000055 65.1300n 0.000046 65.1400n 0.000038 65.1500n 0.000029 65.1600n 0.000020 65.1700n 0.000011 65.1800n 0.000002 65.1900n -0.000007 65.2000n -0.000016 65.2100n -0.000026 65.2200n -0.000035 65.2300n -0.000044 65.2400n -0.000054
+ 65.2500n -0.000064 65.2600n -0.000073 65.2700n -0.000083 65.2800n -0.000093 65.2900n -0.000102 65.3000n -0.000112 65.3100n -0.000122 65.3200n -0.000132 65.3300n -0.000142 65.3400n -0.000152 65.3500n -0.000162 65.3600n -0.000172 65.3700n -0.000182 65.3800n -0.000192 65.3900n -0.000201
+ 65.4000n -0.000211 65.4100n -0.000221 65.4200n -0.000231 65.4300n -0.000241 65.4400n -0.000251 65.4500n -0.000260 65.4600n -0.000270 65.4700n -0.000280 65.4800n -0.000289 65.4900n -0.000299 65.5000n -0.000308 65.5100n -0.000318 65.5200n -0.000327 65.5300n -0.000336 65.5400n -0.000345
+ 65.5500n -0.000354 65.5600n -0.000363 65.5700n -0.000372 65.5800n -0.000381 65.5900n -0.000390 65.6000n -0.000398 65.6100n -0.000407 65.6200n -0.000415 65.6300n -0.000423 65.6400n -0.000431 65.6500n -0.000439 65.6600n -0.000447 65.6700n -0.000455 65.6800n -0.000462 65.6900n -0.000469
+ 65.7000n -0.000477 65.7100n -0.000484 65.7200n -0.000491 65.7300n -0.000497 65.7400n -0.000504 65.7500n -0.000510 65.7600n -0.000517 65.7700n -0.000523 65.7800n -0.000529 65.7900n -0.000534 65.8000n -0.000540 65.8100n -0.000545 65.8200n -0.000550 65.8300n -0.000555 65.8400n -0.000560
+ 65.8500n -0.000565 65.8600n -0.000569 65.8700n -0.000573 65.8800n -0.000577 65.8900n -0.000581 65.9000n -0.000584 65.9100n -0.000588 65.9200n -0.000591 65.9300n -0.000594 65.9400n -0.000596 65.9500n -0.000599 65.9600n -0.000601 65.9700n -0.000603 65.9800n -0.000605 65.9900n -0.000607
+ 66.0000n -0.000608 66.0100n -0.000609 66.0200n -0.000610 66.0300n -0.000611 66.0400n -0.000611 66.0500n -0.000612 66.0600n -0.000612 66.0700n -0.000611 66.0800n -0.000611 66.0900n -0.000610 66.1000n -0.000609 66.1100n -0.000608 66.1200n -0.000607 66.1300n -0.000605 66.1400n -0.000604
+ 66.1500n -0.000602 66.1600n -0.000599 66.1700n -0.000597 66.1800n -0.000594 66.1900n -0.000591 66.2000n -0.000588 66.2100n -0.000585 66.2200n -0.000581 66.2300n -0.000577 66.2400n -0.000573 66.2500n -0.000569 66.2600n -0.000564 66.2700n -0.000559 66.2800n -0.000554 66.2900n -0.000549
+ 66.3000n -0.000544 66.3100n -0.000538 66.3200n -0.000532 66.3300n -0.000526 66.3400n -0.000520 66.3500n -0.000514 66.3600n -0.000507 66.3700n -0.000500 66.3800n -0.000493 66.3900n -0.000486 66.4000n -0.000478 66.4100n -0.000470 66.4200n -0.000462 66.4300n -0.000454 66.4400n -0.000446
+ 66.4500n -0.000438 66.4600n -0.000429 66.4700n -0.000420 66.4800n -0.000411 66.4900n -0.000402 66.5000n -0.000393 66.5100n -0.000383 66.5200n -0.000373 66.5300n -0.000364 66.5400n -0.000354 66.5500n -0.000343 66.5600n -0.000333 66.5700n -0.000323 66.5800n -0.000312 66.5900n -0.000301
+ 66.6000n -0.000290 66.6100n -0.000279 66.6200n -0.000268 66.6300n -0.000257 66.6400n -0.000245 66.6500n -0.000234 66.6600n -0.000222 66.6700n -0.000210 66.6800n -0.000198 66.6900n -0.000187 66.7000n -0.000174 66.7100n -0.000162 66.7200n -0.000150 66.7300n -0.000138 66.7400n -0.000125
+ 66.7500n -0.000113 66.7600n -0.000100 66.7700n -0.000087 66.7800n -0.000075 66.7900n -0.000062 66.8000n -0.000049 66.8100n -0.000036 66.8200n -0.000023 66.8300n -0.000010 66.8400n 0.000003 66.8500n 0.000016 66.8600n 0.000029 66.8700n 0.000042 66.8800n 0.000055 66.8900n 0.000068
+ 66.9000n 0.000081 66.9100n 0.000094 66.9200n 0.000107 66.9300n 0.000120 66.9400n 0.000133 66.9500n 0.000146 66.9600n 0.000159 66.9700n 0.000172 66.9800n 0.000185 66.9900n 0.000198 67.0000n 0.000211 67.0100n 0.000224 67.0200n 0.000237 67.0300n 0.000249 67.0400n 0.000262
+ 67.0500n 0.000275 67.0600n 0.000287 67.0700n 0.000300 67.0800n 0.000312 67.0900n 0.000324 67.1000n 0.000336 67.1100n 0.000348 67.1200n 0.000360 67.1300n 0.000372 67.1400n 0.000384 67.1500n 0.000395 67.1600n 0.000407 67.1700n 0.000418 67.1800n 0.000430 67.1900n 0.000441
+ 67.2000n 0.000452 67.2100n 0.000462 67.2200n 0.000473 67.2300n 0.000484 67.2400n 0.000494 67.2500n 0.000504 67.2600n 0.000514 67.2700n 0.000524 67.2800n 0.000534 67.2900n 0.000544 67.3000n 0.000553 67.3100n 0.000562 67.3200n 0.000571 67.3300n 0.000580 67.3400n 0.000589
+ 67.3500n 0.000597 67.3600n 0.000605 67.3700n 0.000613 67.3800n 0.000621 67.3900n 0.000629 67.4000n 0.000636 67.4100n 0.000644 67.4200n 0.000651 67.4300n 0.000658 67.4400n 0.000664 67.4500n 0.000671 67.4600n 0.000677 67.4700n 0.000683 67.4800n 0.000689 67.4900n 0.000694
+ 67.5000n 0.000700 67.5100n 0.000705 67.5200n 0.000710 67.5300n 0.000714 67.5400n 0.000719 67.5500n 0.000723 67.5600n 0.000727 67.5700n 0.000731 67.5800n 0.000735 67.5900n 0.000738 67.6000n 0.000741 67.6100n 0.000744 67.6200n 0.000747 67.6300n 0.000750 67.6400n 0.000752
+ 67.6500n 0.000754 67.6600n 0.000756 67.6700n 0.000758 67.6800n 0.000759 67.6900n 0.000761 67.7000n 0.000762 67.7100n 0.000763 67.7200n 0.000763 67.7300n 0.000764 67.7400n 0.000764 67.7500n 0.000764 67.7600n 0.000764 67.7700n 0.000764 67.7800n 0.000764 67.7900n 0.000763
+ 67.8000n 0.000763 67.8100n 0.000762 67.8200n 0.000761 67.8300n 0.000760 67.8400n 0.000759 67.8500n 0.000757 67.8600n 0.000756 67.8700n 0.000754 67.8800n 0.000752 67.8900n 0.000750 67.9000n 0.000748 67.9100n 0.000746 67.9200n 0.000744 67.9300n 0.000741 67.9400n 0.000739
+ 67.9500n 0.000736 67.9600n 0.000734 67.9700n 0.000731 67.9800n 0.000728 67.9900n 0.000726 68.0000n 0.000723 68.0100n 0.000720 68.0200n 0.000717 68.0300n 0.000714 68.0400n 0.000711 68.0500n 0.000708 68.0600n 0.000705 68.0700n 0.000702 68.0800n 0.000699 68.0900n 0.000696
+ 68.1000n 0.000694 68.1100n 0.000691 68.1200n 0.000688 68.1300n 0.000685 68.1400n 0.000682 68.1500n 0.000680 68.1600n 0.000677 68.1700n 0.000675 68.1800n 0.000672 68.1900n 0.000670 68.2000n 0.000668 68.2100n 0.000666 68.2200n 0.000664 68.2300n 0.000662 68.2400n 0.000660
+ 68.2500n 0.000659 68.2600n 0.000658 68.2700n 0.000656 68.2800n 0.000655 68.2900n 0.000654 68.3000n 0.000654 68.3100n 0.000653 68.3200n 0.000653 68.3300n 0.000653 68.3400n 0.000653 68.3500n 0.000654 68.3600n 0.000654 68.3700n 0.000655 68.3800n 0.000656 68.3900n 0.000658
+ 68.4000n 0.000659 68.4100n 0.000661 68.4200n 0.000663 68.4300n 0.000666 68.4400n 0.000669 68.4500n 0.000672 68.4600n 0.000675 68.4700n 0.000679 68.4800n 0.000683 68.4900n 0.000687 68.5000n 0.000692 68.5100n 0.000697 68.5200n 0.000702 68.5300n 0.000707 68.5400n 0.000713
+ 68.5500n 0.000720 68.5600n 0.000726 68.5700n 0.000733 68.5800n 0.000741 68.5900n 0.000748 68.6000n 0.000757 68.6100n 0.000765 68.6200n 0.000774 68.6300n 0.000783 68.6400n 0.000793 68.6500n 0.000803 68.6600n 0.000813 68.6700n 0.000824 68.6800n 0.000835 68.6900n 0.000846
+ 68.7000n 0.000858 68.7100n 0.000871 68.7200n 0.000883 68.7300n 0.000896 68.7400n 0.000910 68.7500n 0.000924 68.7600n 0.000938 68.7700n 0.000952 68.7800n 0.000967 68.7900n 0.000983 68.8000n 0.000998 68.8100n 0.001014 68.8200n 0.001031 68.8300n 0.001048 68.8400n 0.001065
+ 68.8500n 0.001082 68.8600n 0.001100 68.8700n 0.001118 68.8800n 0.001137 68.8900n 0.001156 68.9000n 0.001175 68.9100n 0.001195 68.9200n 0.001215 68.9300n 0.001235 68.9400n 0.001255 68.9500n 0.001276 68.9600n 0.001297 68.9700n 0.001319 68.9800n 0.001341 68.9900n 0.001363
+ 69.0000n 0.001385 69.0100n 0.001407 69.0200n 0.001430 69.0300n 0.001453 69.0400n 0.001476 69.0500n 0.001500 69.0600n 0.001523 69.0700n 0.001547 69.0800n 0.001571 69.0900n 0.001595 69.1000n 0.001620 69.1100n 0.001644 69.1200n 0.001669 69.1300n 0.001694 69.1400n 0.001719
+ 69.1500n 0.001744 69.1600n 0.001769 69.1700n 0.001794 69.1800n 0.001820 69.1900n 0.001845 69.2000n 0.001870 69.2100n 0.001896 69.2200n 0.001921 69.2300n 0.001947 69.2400n 0.001972 69.2500n 0.001998 69.2600n 0.002023 69.2700n 0.002048 69.2800n 0.002074 69.2900n 0.002099
+ 69.3000n 0.002124 69.3100n 0.002149 69.3200n 0.002174 69.3300n 0.002199 69.3400n 0.002224 69.3500n 0.002248 69.3600n 0.002272 69.3700n 0.002296 69.3800n 0.002320 69.3900n 0.002344 69.4000n 0.002368 69.4100n 0.002391 69.4200n 0.002414 69.4300n 0.002436 69.4400n 0.002459
+ 69.4500n 0.002481 69.4600n 0.002503 69.4700n 0.002524 69.4800n 0.002545 69.4900n 0.002566 69.5000n 0.002586 69.5100n 0.002606 69.5200n 0.002626 69.5300n 0.002645 69.5400n 0.002664 69.5500n 0.002682 69.5600n 0.002700 69.5700n 0.002717 69.5800n 0.002734 69.5900n 0.002750
+ 69.6000n 0.002766 69.6100n 0.002782 69.6200n 0.002796 69.6300n 0.002811 69.6400n 0.002824 69.6500n 0.002837 69.6600n 0.002850 69.6700n 0.002862 69.6800n 0.002873 69.6900n 0.002884 69.7000n 0.002894 69.7100n 0.002904 69.7200n 0.002913 69.7300n 0.002921 69.7400n 0.002929
+ 69.7500n 0.002935 69.7600n 0.002942 69.7700n 0.002947 69.7800n 0.002952 69.7900n 0.002956 69.8000n 0.002960 69.8100n 0.002963 69.8200n 0.002965 69.8300n 0.002966 69.8400n 0.002967 69.8500n 0.002967 69.8600n 0.002966 69.8700n 0.002964 69.8800n 0.002962 69.8900n 0.002959
+ 69.9000n 0.002955 69.9100n 0.002951 69.9200n 0.002946 69.9300n 0.002939 69.9400n 0.002933 69.9500n 0.002925 69.9600n 0.002917 69.9700n 0.002908 69.9800n 0.002898 69.9900n 0.002888 70.0000n 0.002876 70.0100n 0.002864 70.0200n 0.002852 70.0300n 0.002838 70.0400n 0.002824
+ 70.0500n 0.002809 70.0600n 0.002793 70.0700n 0.002777 70.0800n 0.002760 70.0900n 0.002742 70.1000n 0.002723 70.1100n 0.002704 70.1200n 0.002684 70.1300n 0.002663 70.1400n 0.002642 70.1500n 0.002620 70.1600n 0.002597 70.1700n 0.002574 70.1800n 0.002550 70.1900n 0.002525
+ 70.2000n 0.002500 70.2100n 0.002474 70.2200n 0.002447 70.2300n 0.002420 70.2400n 0.002392 70.2500n 0.002364 70.2600n 0.002335 70.2700n 0.002306 70.2800n 0.002276 70.2900n 0.002245 70.3000n 0.002214 70.3100n 0.002182 70.3200n 0.002150 70.3300n 0.002118 70.3400n 0.002085
+ 70.3500n 0.002051 70.3600n 0.002018 70.3700n 0.001983 70.3800n 0.001949 70.3900n 0.001913 70.4000n 0.001878 70.4100n 0.001842 70.4200n 0.001806 70.4300n 0.001769 70.4400n 0.001733 70.4500n 0.001695 70.4600n 0.001658 70.4700n 0.001620 70.4800n 0.001582 70.4900n 0.001544
+ 70.5000n 0.001506 70.5100n 0.001467 70.5200n 0.001428 70.5300n 0.001390 70.5400n 0.001351 70.5500n 0.001311 70.5600n 0.001272 70.5700n 0.001233 70.5800n 0.001193 70.5900n 0.001154 70.6000n 0.001114 70.6100n 0.001074 70.6200n 0.001035 70.6300n 0.000995 70.6400n 0.000956
+ 70.6500n 0.000916 70.6600n 0.000877 70.6700n 0.000837 70.6800n 0.000798 70.6900n 0.000759 70.7000n 0.000720 70.7100n 0.000681 70.7200n 0.000642 70.7300n 0.000604 70.7400n 0.000565 70.7500n 0.000527 70.7600n 0.000489 70.7700n 0.000452 70.7800n 0.000414 70.7900n 0.000377
+ 70.8000n 0.000340 70.8100n 0.000304 70.8200n 0.000267 70.8300n 0.000231 70.8400n 0.000196 70.8500n 0.000161 70.8600n 0.000126 70.8700n 0.000091 70.8800n 0.000057 70.8900n 0.000024 70.9000n -0.000010 70.9100n -0.000042 70.9200n -0.000075 70.9300n -0.000107 70.9400n -0.000138
+ 70.9500n -0.000169 70.9600n -0.000199 70.9700n -0.000229 70.9800n -0.000259 70.9900n -0.000288 71.0000n -0.000316 71.0100n -0.000344 71.0200n -0.000372 71.0300n -0.000398 71.0400n -0.000425 71.0500n -0.000450 71.0600n -0.000475 71.0700n -0.000500 71.0800n -0.000524 71.0900n -0.000547
+ 71.1000n -0.000570 71.1100n -0.000592 71.1200n -0.000614 71.1300n -0.000635 71.1400n -0.000655 71.1500n -0.000675 71.1600n -0.000694 71.1700n -0.000712 71.1800n -0.000730 71.1900n -0.000748 71.2000n -0.000764 71.2100n -0.000780 71.2200n -0.000796 71.2300n -0.000811 71.2400n -0.000825
+ 71.2500n -0.000838 71.2600n -0.000851 71.2700n -0.000864 71.2800n -0.000876 71.2900n -0.000887 71.3000n -0.000897 71.3100n -0.000907 71.3200n -0.000916 71.3300n -0.000925 71.3400n -0.000933 71.3500n -0.000941 71.3600n -0.000948 71.3700n -0.000954 71.3800n -0.000960 71.3900n -0.000965
+ 71.4000n -0.000970 71.4100n -0.000974 71.4200n -0.000978 71.4300n -0.000981 71.4400n -0.000983 71.4500n -0.000985 71.4600n -0.000987 71.4700n -0.000988 71.4800n -0.000989 71.4900n -0.000989 71.5000n -0.000988 71.5100n -0.000987 71.5200n -0.000986 71.5300n -0.000984 71.5400n -0.000982
+ 71.5500n -0.000979 71.5600n -0.000976 71.5700n -0.000972 71.5800n -0.000968 71.5900n -0.000964 71.6000n -0.000960 71.6100n -0.000954 71.6200n -0.000949 71.6300n -0.000943 71.6400n -0.000937 71.6500n -0.000931 71.6600n -0.000924 71.6700n -0.000917 71.6800n -0.000910 71.6900n -0.000902
+ 71.7000n -0.000894 71.7100n -0.000886 71.7200n -0.000878 71.7300n -0.000870 71.7400n -0.000861 71.7500n -0.000852 71.7600n -0.000843 71.7700n -0.000833 71.7800n -0.000824 71.7900n -0.000814 71.8000n -0.000805 71.8100n -0.000795 71.8200n -0.000785 71.8300n -0.000774 71.8400n -0.000764
+ 71.8500n -0.000754 71.8600n -0.000743 71.8700n -0.000733 71.8800n -0.000722 71.8900n -0.000712 71.9000n -0.000701 71.9100n -0.000691 71.9200n -0.000680 71.9300n -0.000669 71.9400n -0.000659 71.9500n -0.000648 71.9600n -0.000638 71.9700n -0.000627 71.9800n -0.000617 71.9900n -0.000606
+ 72.0000n -0.000596 72.0100n -0.000585 72.0200n -0.000575 72.0300n -0.000565 72.0400n -0.000555 72.0500n -0.000545 72.0600n -0.000535 72.0700n -0.000526 72.0800n -0.000516 72.0900n -0.000507 72.1000n -0.000497 72.1100n -0.000488 72.1200n -0.000479 72.1300n -0.000471 72.1400n -0.000462
+ 72.1500n -0.000453 72.1600n -0.000445 72.1700n -0.000437 72.1800n -0.000429 72.1900n -0.000421 72.2000n -0.000414 72.2100n -0.000406 72.2200n -0.000399 72.2300n -0.000392 72.2400n -0.000385 72.2500n -0.000379 72.2600n -0.000373 72.2700n -0.000366 72.2800n -0.000361 72.2900n -0.000355
+ 72.3000n -0.000349 72.3100n -0.000344 72.3200n -0.000339 72.3300n -0.000334 72.3400n -0.000330 72.3500n -0.000325 72.3600n -0.000321 72.3700n -0.000317 72.3800n -0.000313 72.3900n -0.000310 72.4000n -0.000307 72.4100n -0.000304 72.4200n -0.000301 72.4300n -0.000298 72.4400n -0.000296
+ 72.4500n -0.000294 72.4600n -0.000291 72.4700n -0.000290 72.4800n -0.000288 72.4900n -0.000287 72.5000n -0.000285 72.5100n -0.000284 72.5200n -0.000284 72.5300n -0.000283 72.5400n -0.000283 72.5500n -0.000282 72.5600n -0.000282 72.5700n -0.000282 72.5800n -0.000282 72.5900n -0.000283
+ 72.6000n -0.000283 72.6100n -0.000284 72.6200n -0.000285 72.6300n -0.000286 72.6400n -0.000287 72.6500n -0.000288 72.6600n -0.000290 72.6700n -0.000291 72.6800n -0.000293 72.6900n -0.000295 72.7000n -0.000297 72.7100n -0.000299 72.7200n -0.000301 72.7300n -0.000303 72.7400n -0.000305
+ 72.7500n -0.000308 72.7600n -0.000310 72.7700n -0.000313 72.7800n -0.000315 72.7900n -0.000318 72.8000n -0.000321 72.8100n -0.000324 72.8200n -0.000326 72.8300n -0.000329 72.8400n -0.000332 72.8500n -0.000335 72.8600n -0.000338 72.8700n -0.000341 72.8800n -0.000345 72.8900n -0.000348
+ 72.9000n -0.000351 72.9100n -0.000354 72.9200n -0.000357 72.9300n -0.000361 72.9400n -0.000364 72.9500n -0.000367 72.9600n -0.000370 72.9700n -0.000373 72.9800n -0.000377 72.9900n -0.000380 73.0000n -0.000383 73.0100n -0.000386 73.0200n -0.000390 73.0300n -0.000393 73.0400n -0.000396
+ 73.0500n -0.000399 73.0600n -0.000402 73.0700n -0.000405 73.0800n -0.000409 73.0900n -0.000412 73.1000n -0.000415 73.1100n -0.000418 73.1200n -0.000421 73.1300n -0.000424 73.1400n -0.000427 73.1500n -0.000430 73.1600n -0.000433 73.1700n -0.000436 73.1800n -0.000439 73.1900n -0.000441
+ 73.2000n -0.000444 73.2100n -0.000447 73.2200n -0.000450 73.2300n -0.000453 73.2400n -0.000456 73.2500n -0.000459 73.2600n -0.000461 73.2700n -0.000464 73.2800n -0.000467 73.2900n -0.000470 73.3000n -0.000472 73.3100n -0.000475 73.3200n -0.000478 73.3300n -0.000481 73.3400n -0.000484
+ 73.3500n -0.000487 73.3600n -0.000489 73.3700n -0.000492 73.3800n -0.000495 73.3900n -0.000498 73.4000n -0.000501 73.4100n -0.000504 73.4200n -0.000507 73.4300n -0.000510 73.4400n -0.000514 73.4500n -0.000517 73.4600n -0.000520 73.4700n -0.000524 73.4800n -0.000527 73.4900n -0.000531
+ 73.5000n -0.000534 73.5100n -0.000538 73.5200n -0.000542 73.5300n -0.000545 73.5400n -0.000549 73.5500n -0.000553 73.5600n -0.000558 73.5700n -0.000562 73.5800n -0.000566 73.5900n -0.000571 73.6000n -0.000575 73.6100n -0.000580 73.6200n -0.000585 73.6300n -0.000590 73.6400n -0.000595
+ 73.6500n -0.000601 73.6600n -0.000606 73.6700n -0.000612 73.6800n -0.000617 73.6900n -0.000623 73.7000n -0.000629 73.7100n -0.000636 73.7200n -0.000642 73.7300n -0.000649 73.7400n -0.000655 73.7500n -0.000662 73.7600n -0.000670 73.7700n -0.000677 73.7800n -0.000684 73.7900n -0.000692
+ 73.8000n -0.000700 73.8100n -0.000708 73.8200n -0.000716 73.8300n -0.000725 73.8400n -0.000733 73.8500n -0.000742 73.8600n -0.000751 73.8700n -0.000760 73.8800n -0.000770 73.8900n -0.000780 73.9000n -0.000789 73.9100n -0.000799 73.9200n -0.000810 73.9300n -0.000820 73.9400n -0.000830
+ 73.9500n -0.000841 73.9600n -0.000852 73.9700n -0.000863 73.9800n -0.000875 73.9900n -0.000886 74.0000n -0.000898 74.0100n -0.000910 74.0200n -0.000922 74.0300n -0.000934 74.0400n -0.000946 74.0500n -0.000959 74.0600n -0.000971 74.0700n -0.000984 74.0800n -0.000997 74.0900n -0.001010
+ 74.1000n -0.001023 74.1100n -0.001036 74.1200n -0.001050 74.1300n -0.001063 74.1400n -0.001077 74.1500n -0.001090 74.1600n -0.001104 74.1700n -0.001118 74.1800n -0.001132 74.1900n -0.001146 74.2000n -0.001160 74.2100n -0.001174 74.2200n -0.001188 74.2300n -0.001202 74.2400n -0.001216
+ 74.2500n -0.001231 74.2600n -0.001245 74.2700n -0.001259 74.2800n -0.001273 74.2900n -0.001287 74.3000n -0.001301 74.3100n -0.001315 74.3200n -0.001329 74.3300n -0.001343 74.3400n -0.001356 74.3500n -0.001370 74.3600n -0.001383 74.3700n -0.001397 74.3800n -0.001410 74.3900n -0.001423
+ 74.4000n -0.001436 74.4100n -0.001449 74.4200n -0.001461 74.4300n -0.001474 74.4400n -0.001486 74.4500n -0.001498 74.4600n -0.001509 74.4700n -0.001521 74.4800n -0.001532 74.4900n -0.001543 74.5000n -0.001553 74.5100n -0.001564 74.5200n -0.001574 74.5300n -0.001583 74.5400n -0.001593
+ 74.5500n -0.001602 74.5600n -0.001610 74.5700n -0.001619 74.5800n -0.001626 74.5900n -0.001634 74.6000n -0.001641 74.6100n -0.001647 74.6200n -0.001654 74.6300n -0.001659 74.6400n -0.001665 74.6500n -0.001669 74.6600n -0.001674 74.6700n -0.001678 74.6800n -0.001681 74.6900n -0.001684
+ 74.7000n -0.001686 74.7100n -0.001688 74.7200n -0.001689 74.7300n -0.001690 74.7400n -0.001690 74.7500n -0.001690 74.7600n -0.001689 74.7700n -0.001687 74.7800n -0.001685 74.7900n -0.001682 74.8000n -0.001679 74.8100n -0.001675 74.8200n -0.001670 74.8300n -0.001665 74.8400n -0.001660
+ 74.8500n -0.001653 74.8600n -0.001646 74.8700n -0.001638 74.8800n -0.001630 74.8900n -0.001621 74.9000n -0.001611 74.9100n -0.001601 74.9200n -0.001590 74.9300n -0.001579 74.9400n -0.001566 74.9500n -0.001553 74.9600n -0.001540 74.9700n -0.001526 74.9800n -0.001511 74.9900n -0.001495
+ 75.0000n -0.001479 75.0100n -0.001462 75.0200n -0.001445 75.0300n -0.001427 75.0400n -0.001408 75.0500n -0.001389 75.0600n -0.001369 75.0700n -0.001348 75.0800n -0.001327 75.0900n -0.001305 75.1000n -0.001283 75.1100n -0.001260 75.1200n -0.001236 75.1300n -0.001212 75.1400n -0.001187
+ 75.1500n -0.001162 75.1600n -0.001136 75.1700n -0.001110 75.1800n -0.001083 75.1900n -0.001055 75.2000n -0.001027 75.2100n -0.000999 75.2200n -0.000970 75.2300n -0.000941 75.2400n -0.000911 75.2500n -0.000880 75.2600n -0.000850 75.2700n -0.000819 75.2800n -0.000787 75.2900n -0.000755
+ 75.3000n -0.000723 75.3100n -0.000690 75.3200n -0.000657 75.3300n -0.000624 75.3400n -0.000590 75.3500n -0.000556 75.3600n -0.000522 75.3700n -0.000488 75.3800n -0.000453 75.3900n -0.000418 75.4000n -0.000383 75.4100n -0.000348 75.4200n -0.000313 75.4300n -0.000277 75.4400n -0.000241
+ 75.4500n -0.000206 75.4600n -0.000170 75.4700n -0.000134 75.4800n -0.000098 75.4900n -0.000062 75.5000n -0.000027 75.5100n 0.000009 75.5200n 0.000045 75.5300n 0.000081 75.5400n 0.000116 75.5500n 0.000152 75.5600n 0.000187 75.5700n 0.000222 75.5800n 0.000257 75.5900n 0.000292
+ 75.6000n 0.000326 75.6100n 0.000361 75.6200n 0.000395 75.6300n 0.000428 75.6400n 0.000462 75.6500n 0.000495 75.6600n 0.000528 75.6700n 0.000560 75.6800n 0.000592 75.6900n 0.000623 75.7000n 0.000655 75.7100n 0.000685 75.7200n 0.000715 75.7300n 0.000745 75.7400n 0.000774
+ 75.7500n 0.000803 75.7600n 0.000831 75.7700n 0.000858 75.7800n 0.000885 75.7900n 0.000912 75.8000n 0.000937 75.8100n 0.000962 75.8200n 0.000987 75.8300n 0.001010 75.8400n 0.001033 75.8500n 0.001056 75.8600n 0.001077 75.8700n 0.001098 75.8800n 0.001118 75.8900n 0.001137
+ 75.9000n 0.001156 75.9100n 0.001174 75.9200n 0.001191 75.9300n 0.001207 75.9400n 0.001222 75.9500n 0.001237 75.9600n 0.001251 75.9700n 0.001263 75.9800n 0.001275 75.9900n 0.001286 76.0000n 0.001297 76.0100n 0.001306 76.0200n 0.001315 76.0300n 0.001322 76.0400n 0.001329
+ 76.0500n 0.001335 76.0600n 0.001340 76.0700n 0.001344 76.0800n 0.001347 76.0900n 0.001349 76.1000n 0.001350 76.1100n 0.001350 76.1200n 0.001350 76.1300n 0.001349 76.1400n 0.001346 76.1500n 0.001343 76.1600n 0.001339 76.1700n 0.001334 76.1800n 0.001328 76.1900n 0.001321
+ 76.2000n 0.001313 76.2100n 0.001305 76.2200n 0.001295 76.2300n 0.001285 76.2400n 0.001274 76.2500n 0.001262 76.2600n 0.001249 76.2700n 0.001236 76.2800n 0.001221 76.2900n 0.001206 76.3000n 0.001190 76.3100n 0.001173 76.3200n 0.001156 76.3300n 0.001137 76.3400n 0.001118
+ 76.3500n 0.001099 76.3600n 0.001078 76.3700n 0.001057 76.3800n 0.001036 76.3900n 0.001013 76.4000n 0.000990 76.4100n 0.000967 76.4200n 0.000943 76.4300n 0.000918 76.4400n 0.000893 76.4500n 0.000867 76.4600n 0.000841 76.4700n 0.000814 76.4800n 0.000787 76.4900n 0.000759
+ 76.5000n 0.000731 76.5100n 0.000702 76.5200n 0.000674 76.5300n 0.000644 76.5400n 0.000615 76.5500n 0.000585 76.5600n 0.000555 76.5700n 0.000525 76.5800n 0.000494 76.5900n 0.000464 76.6000n 0.000433 76.6100n 0.000402 76.6200n 0.000371 76.6300n 0.000339 76.6400n 0.000308
+ 76.6500n 0.000277 76.6600n 0.000246 76.6700n 0.000214 76.6800n 0.000183 76.6900n 0.000152 76.7000n 0.000121 76.7100n 0.000090 76.7200n 0.000059 76.7300n 0.000028 76.7400n -0.000002 76.7500n -0.000032 76.7600n -0.000062 76.7700n -0.000092 76.7800n -0.000121 76.7900n -0.000150
+ 76.8000n -0.000179 76.8100n -0.000207 76.8200n -0.000235 76.8300n -0.000263 76.8400n -0.000290 76.8500n -0.000316 76.8600n -0.000342 76.8700n -0.000368 76.8800n -0.000393 76.8900n -0.000417 76.9000n -0.000441 76.9100n -0.000464 76.9200n -0.000487 76.9300n -0.000509 76.9400n -0.000530
+ 76.9500n -0.000550 76.9600n -0.000570 76.9700n -0.000589 76.9800n -0.000608 76.9900n -0.000625 77.0000n -0.000642 77.0100n -0.000658 77.0200n -0.000673 77.0300n -0.000688 77.0400n -0.000701 77.0500n -0.000714 77.0600n -0.000725 77.0700n -0.000736 77.0800n -0.000746 77.0900n -0.000755
+ 77.1000n -0.000764 77.1100n -0.000771 77.1200n -0.000777 77.1300n -0.000782 77.1400n -0.000787 77.1500n -0.000790 77.1600n -0.000793 77.1700n -0.000794 77.1800n -0.000795 77.1900n -0.000794 77.2000n -0.000793 77.2100n -0.000790 77.2200n -0.000787 77.2300n -0.000783 77.2400n -0.000777
+ 77.2500n -0.000771 77.2600n -0.000763 77.2700n -0.000755 77.2800n -0.000746 77.2900n -0.000735 77.3000n -0.000724 77.3100n -0.000712 77.3200n -0.000699 77.3300n -0.000685 77.3400n -0.000670 77.3500n -0.000654 77.3600n -0.000637 77.3700n -0.000619 77.3800n -0.000600 77.3900n -0.000581
+ 77.4000n -0.000560 77.4100n -0.000539 77.4200n -0.000517 77.4300n -0.000494 77.4400n -0.000470 77.4500n -0.000445 77.4600n -0.000420 77.4700n -0.000394 77.4800n -0.000367 77.4900n -0.000339 77.5000n -0.000311 77.5100n -0.000281 77.5200n -0.000252 77.5300n -0.000221 77.5400n -0.000190
+ 77.5500n -0.000159 77.5600n -0.000126 77.5700n -0.000094 77.5800n -0.000060 77.5900n -0.000026 77.6000n 0.000008 77.6100n 0.000043 77.6200n 0.000078 77.6300n 0.000114 77.6400n 0.000150 77.6500n 0.000186 77.6600n 0.000223 77.6700n 0.000260 77.6800n 0.000297 77.6900n 0.000335
+ 77.7000n 0.000373 77.7100n 0.000411 77.7200n 0.000449 77.7300n 0.000487 77.7400n 0.000525 77.7500n 0.000564 77.7600n 0.000603 77.7700n 0.000641 77.7800n 0.000680 77.7900n 0.000718 77.8000n 0.000757 77.8100n 0.000795 77.8200n 0.000833 77.8300n 0.000872 77.8400n 0.000909
+ 77.8500n 0.000947 77.8600n 0.000985 77.8700n 0.001022 77.8800n 0.001059 77.8900n 0.001096 77.9000n 0.001132 77.9100n 0.001168 77.9200n 0.001203 77.9300n 0.001238 77.9400n 0.001273 77.9500n 0.001307 77.9600n 0.001341 77.9700n 0.001374 77.9800n 0.001406 77.9900n 0.001438
+ 78.0000n 0.001469 78.0100n 0.001500 78.0200n 0.001530 78.0300n 0.001560 78.0400n 0.001588 78.0500n 0.001616 78.0600n 0.001643 78.0700n 0.001670 78.0800n 0.001695 78.0900n 0.001720 78.1000n 0.001744 78.1100n 0.001767 78.1200n 0.001789 78.1300n 0.001811 78.1400n 0.001831
+ 78.1500n 0.001851 78.1600n 0.001869 78.1700n 0.001887 78.1800n 0.001903 78.1900n 0.001919 78.2000n 0.001934 78.2100n 0.001948 78.2200n 0.001960 78.2300n 0.001972 78.2400n 0.001982 78.2500n 0.001992 78.2600n 0.002001 78.2700n 0.002008 78.2800n 0.002015 78.2900n 0.002020
+ 78.3000n 0.002024 78.3100n 0.002027 78.3200n 0.002029 78.3300n 0.002030 78.3400n 0.002030 78.3500n 0.002029 78.3600n 0.002027 78.3700n 0.002024 78.3800n 0.002019 78.3900n 0.002014 78.4000n 0.002007 78.4100n 0.002000 78.4200n 0.001991 78.4300n 0.001981 78.4400n 0.001970
+ 78.4500n 0.001958 78.4600n 0.001946 78.4700n 0.001932 78.4800n 0.001917 78.4900n 0.001901 78.5000n 0.001884 78.5100n 0.001866 78.5200n 0.001847 78.5300n 0.001827 78.5400n 0.001806 78.5500n 0.001784 78.5600n 0.001762 78.5700n 0.001738 78.5800n 0.001713 78.5900n 0.001688
+ 78.6000n 0.001662 78.6100n 0.001635 78.6200n 0.001607 78.6300n 0.001578 78.6400n 0.001549 78.6500n 0.001519 78.6600n 0.001488 78.6700n 0.001456 78.6800n 0.001424 78.6900n 0.001391 78.7000n 0.001358 78.7100n 0.001324 78.7200n 0.001289 78.7300n 0.001254 78.7400n 0.001218
+ 78.7500n 0.001181 78.7600n 0.001145 78.7700n 0.001107 78.7800n 0.001070 78.7900n 0.001031 78.8000n 0.000993 78.8100n 0.000954 78.8200n 0.000915 78.8300n 0.000876 78.8400n 0.000836 78.8500n 0.000796 78.8600n 0.000756 78.8700n 0.000716 78.8800n 0.000675 78.8900n 0.000635
+ 78.9000n 0.000594 78.9100n 0.000553 78.9200n 0.000512 78.9300n 0.000472 78.9400n 0.000431 78.9500n 0.000390 78.9600n 0.000350 78.9700n 0.000309 78.9800n 0.000269 78.9900n 0.000229 79.0000n 0.000189 79.0100n 0.000149 79.0200n 0.000110 79.0300n 0.000071 79.0400n 0.000032
+ 79.0500n -0.000007 79.0600n -0.000045 79.0700n -0.000083 79.0800n -0.000120 79.0900n -0.000157 79.1000n -0.000194 79.1100n -0.000230 79.1200n -0.000265 79.1300n -0.000300 79.1400n -0.000334 79.1500n -0.000368 79.1600n -0.000401 79.1700n -0.000434 79.1800n -0.000466 79.1900n -0.000497
+ 79.2000n -0.000527 79.2100n -0.000557 79.2200n -0.000586 79.2300n -0.000615 79.2400n -0.000642 79.2500n -0.000669 79.2600n -0.000695 79.2700n -0.000720 79.2800n -0.000745 79.2900n -0.000768 79.3000n -0.000791 79.3100n -0.000812 79.3200n -0.000833 79.3300n -0.000853 79.3400n -0.000872
+ 79.3500n -0.000891 79.3600n -0.000908 79.3700n -0.000924 79.3800n -0.000939 79.3900n -0.000954 79.4000n -0.000967 79.4100n -0.000980 79.4200n -0.000991 79.4300n -0.001002 79.4400n -0.001011 79.4500n -0.001020 79.4600n -0.001027 79.4700n -0.001034 79.4800n -0.001040 79.4900n -0.001044
+ 79.5000n -0.001048 79.5100n -0.001051 79.5200n -0.001052 79.5300n -0.001053 79.5400n -0.001053 79.5500n -0.001051 79.5600n -0.001049 79.5700n -0.001046 79.5800n -0.001042 79.5900n -0.001037 79.6000n -0.001031 79.6100n -0.001024 79.6200n -0.001017 79.6300n -0.001008 79.6400n -0.000998
+ 79.6500n -0.000988 79.6600n -0.000977 79.6700n -0.000964 79.6800n -0.000951 79.6900n -0.000938 79.7000n -0.000923 79.7100n -0.000908 79.7200n -0.000891 79.7300n -0.000874 79.7400n -0.000857 79.7500n -0.000838 79.7600n -0.000819 79.7700n -0.000799 79.7800n -0.000779 79.7900n -0.000758
+ 79.8000n -0.000736 79.8100n -0.000714 79.8200n -0.000691 79.8300n -0.000667 79.8400n -0.000643 79.8500n -0.000619 79.8600n -0.000594 79.8700n -0.000568 79.8800n -0.000542 79.8900n -0.000516 79.9000n -0.000489 79.9100n -0.000461 79.9200n -0.000434 79.9300n -0.000406 79.9400n -0.000378
+ 79.9500n -0.000349 79.9600n -0.000320 79.9700n -0.000291 79.9800n -0.000262 79.9900n -0.000233 80.0000n -0.000203 80.0100n -0.000173 80.0200n -0.000143 80.0300n -0.000113 80.0400n -0.000083 80.0500n -0.000053 80.0600n -0.000023 80.0700n 0.000007 80.0800n 0.000037 80.0900n 0.000067
+ 80.1000n 0.000097 80.1100n 0.000127 80.1200n 0.000157 80.1300n 0.000187 80.1400n 0.000216 80.1500n 0.000245 80.1600n 0.000274 80.1700n 0.000303 80.1800n 0.000332 80.1900n 0.000360 80.2000n 0.000388 80.2100n 0.000416 80.2200n 0.000443 80.2300n 0.000470 80.2400n 0.000496
+ 80.2500n 0.000523 80.2600n 0.000548 80.2700n 0.000574 80.2800n 0.000599 80.2900n 0.000623 80.3000n 0.000647 80.3100n 0.000671 80.3200n 0.000694 80.3300n 0.000716 80.3400n 0.000738 80.3500n 0.000759 80.3600n 0.000780 80.3700n 0.000800 80.3800n 0.000820 80.3900n 0.000839
+ 80.4000n 0.000857 80.4100n 0.000875 80.4200n 0.000892 80.4300n 0.000908 80.4400n 0.000924 80.4500n 0.000939 80.4600n 0.000954 80.4700n 0.000968 80.4800n 0.000981 80.4900n 0.000993 80.5000n 0.001005 80.5100n 0.001016 80.5200n 0.001026 80.5300n 0.001036 80.5400n 0.001045
+ 80.5500n 0.001053 80.5600n 0.001061 80.5700n 0.001068 80.5800n 0.001074 80.5900n 0.001079 80.6000n 0.001084 80.6100n 0.001088 80.6200n 0.001091 80.6300n 0.001094 80.6400n 0.001096 80.6500n 0.001097 80.6600n 0.001098 80.6700n 0.001098 80.6800n 0.001097 80.6900n 0.001096
+ 80.7000n 0.001094 80.7100n 0.001091 80.7200n 0.001088 80.7300n 0.001084 80.7400n 0.001080 80.7500n 0.001074 80.7600n 0.001069 80.7700n 0.001063 80.7800n 0.001056 80.7900n 0.001048 80.8000n 0.001040 80.8100n 0.001032 80.8200n 0.001023 80.8300n 0.001014 80.8400n 0.001004
+ 80.8500n 0.000993 80.8600n 0.000983 80.8700n 0.000971 80.8800n 0.000960 80.8900n 0.000948 80.9000n 0.000935 80.9100n 0.000922 80.9200n 0.000909 80.9300n 0.000895 80.9400n 0.000882 80.9500n 0.000867 80.9600n 0.000853 80.9700n 0.000838 80.9800n 0.000823 80.9900n 0.000808
+ 81.0000n 0.000793 81.0100n 0.000777 81.0200n 0.000762 81.0300n 0.000746 81.0400n 0.000730 81.0500n 0.000713 81.0600n 0.000697 81.0700n 0.000681 81.0800n 0.000664 81.0900n 0.000648 81.1000n 0.000632 81.1100n 0.000615 81.1200n 0.000599 81.1300n 0.000582 81.1400n 0.000566
+ 81.1500n 0.000550 81.1600n 0.000533 81.1700n 0.000517 81.1800n 0.000501 81.1900n 0.000486 81.2000n 0.000470 81.2100n 0.000454 81.2200n 0.000439 81.2300n 0.000424 81.2400n 0.000409 81.2500n 0.000394 81.2600n 0.000380 81.2700n 0.000366 81.2800n 0.000352 81.2900n 0.000338
+ 81.3000n 0.000325 81.3100n 0.000312 81.3200n 0.000300 81.3300n 0.000287 81.3400n 0.000275 81.3500n 0.000264 81.3600n 0.000253 81.3700n 0.000242 81.3800n 0.000232 81.3900n 0.000222 81.4000n 0.000212 81.4100n 0.000203 81.4200n 0.000194 81.4300n 0.000186 81.4400n 0.000179
+ 81.4500n 0.000171 81.4600n 0.000164 81.4700n 0.000158 81.4800n 0.000152 81.4900n 0.000147 81.5000n 0.000142 81.5100n 0.000138 81.5200n 0.000134 81.5300n 0.000130 81.5400n 0.000127 81.5500n 0.000125 81.5600n 0.000123 81.5700n 0.000121 81.5800n 0.000121 81.5900n 0.000120
+ 81.6000n 0.000120 81.6100n 0.000121 81.6200n 0.000122 81.6300n 0.000123 81.6400n 0.000125 81.6500n 0.000128 81.6600n 0.000131 81.6700n 0.000134 81.6800n 0.000138 81.6900n 0.000143 81.7000n 0.000147 81.7100n 0.000153 81.7200n 0.000158 81.7300n 0.000164 81.7400n 0.000171
+ 81.7500n 0.000178 81.7600n 0.000185 81.7700n 0.000193 81.7800n 0.000201 81.7900n 0.000210 81.8000n 0.000219 81.8100n 0.000228 81.8200n 0.000237 81.8300n 0.000247 81.8400n 0.000257 81.8500n 0.000268 81.8600n 0.000279 81.8700n 0.000290 81.8800n 0.000301 81.8900n 0.000313
+ 81.9000n 0.000324 81.9100n 0.000336 81.9200n 0.000348 81.9300n 0.000361 81.9400n 0.000373 81.9500n 0.000386 81.9600n 0.000399 81.9700n 0.000412 81.9800n 0.000425 81.9900n 0.000438 82.0000n 0.000451 82.0100n 0.000464 82.0200n 0.000477 82.0300n 0.000491 82.0400n 0.000504
+ 82.0500n 0.000517 82.0600n 0.000531 82.0700n 0.000544 82.0800n 0.000557 82.0900n 0.000570 82.1000n 0.000583 82.1100n 0.000596 82.1200n 0.000608 82.1300n 0.000621 82.1400n 0.000633 82.1500n 0.000646 82.1600n 0.000658 82.1700n 0.000669 82.1800n 0.000681 82.1900n 0.000692
+ 82.2000n 0.000703 82.2100n 0.000714 82.2200n 0.000725 82.2300n 0.000735 82.2400n 0.000745 82.2500n 0.000754 82.2600n 0.000763 82.2700n 0.000772 82.2800n 0.000781 82.2900n 0.000789 82.3000n 0.000797 82.3100n 0.000804 82.3200n 0.000811 82.3300n 0.000817 82.3400n 0.000823
+ 82.3500n 0.000829 82.3600n 0.000834 82.3700n 0.000838 82.3800n 0.000842 82.3900n 0.000846 82.4000n 0.000849 82.4100n 0.000852 82.4200n 0.000854 82.4300n 0.000855 82.4400n 0.000856 82.4500n 0.000857 82.4600n 0.000857 82.4700n 0.000856 82.4800n 0.000855 82.4900n 0.000854
+ 82.5000n 0.000851 82.5100n 0.000849 82.5200n 0.000845 82.5300n 0.000841 82.5400n 0.000837 82.5500n 0.000832 82.5600n 0.000826 82.5700n 0.000820 82.5800n 0.000813 82.5900n 0.000806 82.6000n 0.000798 82.6100n 0.000790 82.6200n 0.000781 82.6300n 0.000771 82.6400n 0.000761
+ 82.6500n 0.000751 82.6600n 0.000740 82.6700n 0.000728 82.6800n 0.000716 82.6900n 0.000703 82.7000n 0.000690 82.7100n 0.000676 82.7200n 0.000662 82.7300n 0.000647 82.7400n 0.000632 82.7500n 0.000617 82.7600n 0.000601 82.7700n 0.000584 82.7800n 0.000567 82.7900n 0.000550
+ 82.8000n 0.000532 82.8100n 0.000514 82.8200n 0.000495 82.8300n 0.000476 82.8400n 0.000457 82.8500n 0.000437 82.8600n 0.000417 82.8700n 0.000397 82.8800n 0.000376 82.8900n 0.000355 82.9000n 0.000334 82.9100n 0.000313 82.9200n 0.000291 82.9300n 0.000269 82.9400n 0.000247
+ 82.9500n 0.000225 82.9600n 0.000202 82.9700n 0.000179 82.9800n 0.000156 82.9900n 0.000134 83.0000n 0.000110 83.0100n 0.000087 83.0200n 0.000064 83.0300n 0.000041 83.0400n 0.000017 83.0500n -0.000006 83.0600n -0.000029 83.0700n -0.000053 83.0800n -0.000076 83.0900n -0.000099
+ 83.1000n -0.000122 83.1100n -0.000146 83.1200n -0.000169 83.1300n -0.000192 83.1400n -0.000214 83.1500n -0.000237 83.1600n -0.000259 83.1700n -0.000282 83.1800n -0.000304 83.1900n -0.000326 83.2000n -0.000347 83.2100n -0.000369 83.2200n -0.000390 83.2300n -0.000411 83.2400n -0.000431
+ 83.2500n -0.000451 83.2600n -0.000471 83.2700n -0.000491 83.2800n -0.000510 83.2900n -0.000529 83.3000n -0.000547 83.3100n -0.000565 83.3200n -0.000583 83.3300n -0.000600 83.3400n -0.000617 83.3500n -0.000633 83.3600n -0.000649 83.3700n -0.000664 83.3800n -0.000679 83.3900n -0.000693
+ 83.4000n -0.000707 83.4100n -0.000721 83.4200n -0.000734 83.4300n -0.000746 83.4400n -0.000758 83.4500n -0.000769 83.4600n -0.000780 83.4700n -0.000790 83.4800n -0.000799 83.4900n -0.000808 83.5000n -0.000817 83.5100n -0.000825 83.5200n -0.000832 83.5300n -0.000839 83.5400n -0.000845
+ 83.5500n -0.000850 83.5600n -0.000855 83.5700n -0.000860 83.5800n -0.000864 83.5900n -0.000867 83.6000n -0.000869 83.6100n -0.000871 83.6200n -0.000873 83.6300n -0.000874 83.6400n -0.000874 83.6500n -0.000874 83.6600n -0.000873 83.6700n -0.000872 83.6800n -0.000870 83.6900n -0.000867
+ 83.7000n -0.000864 83.7100n -0.000860 83.7200n -0.000856 83.7300n -0.000852 83.7400n -0.000847 83.7500n -0.000841 83.7600n -0.000835 83.7700n -0.000828 83.7800n -0.000821 83.7900n -0.000813 83.8000n -0.000805 83.8100n -0.000797 83.8200n -0.000788 83.8300n -0.000779 83.8400n -0.000769
+ 83.8500n -0.000759 83.8600n -0.000749 83.8700n -0.000738 83.8800n -0.000727 83.8900n -0.000715 83.9000n -0.000703 83.9100n -0.000691 83.9200n -0.000679 83.9300n -0.000666 83.9400n -0.000654 83.9500n -0.000641 83.9600n -0.000627 83.9700n -0.000614 83.9800n -0.000600 83.9900n -0.000586
+ 84.0000n -0.000572 84.0100n -0.000558 84.0200n -0.000544 84.0300n -0.000530 84.0400n -0.000516 84.0500n -0.000501 84.0600n -0.000487 84.0700n -0.000473 84.0800n -0.000458 84.0900n -0.000444 84.1000n -0.000430 84.1100n -0.000416 84.1200n -0.000402 84.1300n -0.000388 84.1400n -0.000374
+ 84.1500n -0.000360 84.1600n -0.000347 84.1700n -0.000334 84.1800n -0.000321 84.1900n -0.000308 84.2000n -0.000295 84.2100n -0.000283 84.2200n -0.000271 84.2300n -0.000259 84.2400n -0.000248 84.2500n -0.000237 84.2600n -0.000226 84.2700n -0.000216 84.2800n -0.000206 84.2900n -0.000197
+ 84.3000n -0.000188 84.3100n -0.000179 84.3200n -0.000171 84.3300n -0.000163 84.3400n -0.000156 84.3500n -0.000150 84.3600n -0.000144 84.3700n -0.000138 84.3800n -0.000133 84.3900n -0.000129 84.4000n -0.000125 84.4100n -0.000122 84.4200n -0.000119 84.4300n -0.000117 84.4400n -0.000116
+ 84.4500n -0.000115 84.4600n -0.000115 84.4700n -0.000116 84.4800n -0.000117 84.4900n -0.000119 84.5000n -0.000122 84.5100n -0.000125 84.5200n -0.000129 84.5300n -0.000134 84.5400n -0.000139 84.5500n -0.000145 84.5600n -0.000152 84.5700n -0.000160 84.5800n -0.000168 84.5900n -0.000177
+ 84.6000n -0.000187 84.6100n -0.000198 84.6200n -0.000209 84.6300n -0.000221 84.6400n -0.000234 84.6500n -0.000247 84.6600n -0.000262 84.6700n -0.000277 84.6800n -0.000292 84.6900n -0.000309 84.7000n -0.000326 84.7100n -0.000344 84.7200n -0.000362 84.7300n -0.000382 84.7400n -0.000402
+ 84.7500n -0.000423 84.7600n -0.000444 84.7700n -0.000466 84.7800n -0.000489 84.7900n -0.000512 84.8000n -0.000536 84.8100n -0.000561 84.8200n -0.000586 84.8300n -0.000612 84.8400n -0.000639 84.8500n -0.000666 84.8600n -0.000694 84.8700n -0.000722 84.8800n -0.000751 84.8900n -0.000780
+ 84.9000n -0.000810 84.9100n -0.000841 84.9200n -0.000872 84.9300n -0.000903 84.9400n -0.000935 84.9500n -0.000967 84.9600n -0.001000 84.9700n -0.001033 84.9800n -0.001066 84.9900n -0.001100 85.0000n -0.001134 85.0100n -0.001169 85.0200n -0.001203 85.0300n -0.001238 85.0400n -0.001274
+ 85.0500n -0.001309 85.0600n -0.001345 85.0700n -0.001381 85.0800n -0.001417 85.0900n -0.001454 85.1000n -0.001490 85.1100n -0.001527 85.1200n -0.001563 85.1300n -0.001600 85.1400n -0.001637 85.1500n -0.001673 85.1600n -0.001710 85.1700n -0.001747 85.1800n -0.001783 85.1900n -0.001820
+ 85.2000n -0.001856 85.2100n -0.001893 85.2200n -0.001929 85.2300n -0.001965 85.2400n -0.002000 85.2500n -0.002036 85.2600n -0.002071 85.2700n -0.002106 85.2800n -0.002141 85.2900n -0.002176 85.3000n -0.002210 85.3100n -0.002243 85.3200n -0.002277 85.3300n -0.002310 85.3400n -0.002342
+ 85.3500n -0.002374 85.3600n -0.002406 85.3700n -0.002437 85.3800n -0.002468 85.3900n -0.002498 85.4000n -0.002527 85.4100n -0.002556 85.4200n -0.002584 85.4300n -0.002612 85.4400n -0.002639 85.4500n -0.002665 85.4600n -0.002691 85.4700n -0.002716 85.4800n -0.002741 85.4900n -0.002764
+ 85.5000n -0.002787 85.5100n -0.002809 85.5200n -0.002830 85.5300n -0.002851 85.5400n -0.002871 85.5500n -0.002890 85.5600n -0.002908 85.5700n -0.002925 85.5800n -0.002941 85.5900n -0.002957 85.6000n -0.002971 85.6100n -0.002985 85.6200n -0.002998 85.6300n -0.003010 85.6400n -0.003021
+ 85.6500n -0.003031 85.6600n -0.003040 85.6700n -0.003048 85.6800n -0.003055 85.6900n -0.003061 85.7000n -0.003066 85.7100n -0.003071 85.7200n -0.003074 85.7300n -0.003076 85.7400n -0.003078 85.7500n -0.003078 85.7600n -0.003077 85.7700n -0.003075 85.7800n -0.003073 85.7900n -0.003069
+ 85.8000n -0.003064 85.8100n -0.003059 85.8200n -0.003052 85.8300n -0.003044 85.8400n -0.003036 85.8500n -0.003026 85.8600n -0.003016 85.8700n -0.003004 85.8800n -0.002991 85.8900n -0.002978 85.9000n -0.002963 85.9100n -0.002948 85.9200n -0.002932 85.9300n -0.002914 85.9400n -0.002896
+ 85.9500n -0.002877 85.9600n -0.002857 85.9700n -0.002836 85.9800n -0.002814 85.9900n -0.002791 86.0000n -0.002768 86.0100n -0.002743 86.0200n -0.002718 86.0300n -0.002692 86.0400n -0.002665 86.0500n -0.002637 86.0600n -0.002609 86.0700n -0.002580 86.0800n -0.002550 86.0900n -0.002519
+ 86.1000n -0.002487 86.1100n -0.002455 86.1200n -0.002422 86.1300n -0.002389 86.1400n -0.002355 86.1500n -0.002320 86.1600n -0.002284 86.1700n -0.002248 86.1800n -0.002212 86.1900n -0.002175 86.2000n -0.002137 86.2100n -0.002099 86.2200n -0.002060 86.2300n -0.002021 86.2400n -0.001981
+ 86.2500n -0.001941 86.2600n -0.001901 86.2700n -0.001860 86.2800n -0.001819 86.2900n -0.001777 86.3000n -0.001735 86.3100n -0.001693 86.3200n -0.001651 86.3300n -0.001608 86.3400n -0.001565 86.3500n -0.001522 86.3600n -0.001478 86.3700n -0.001435 86.3800n -0.001391 86.3900n -0.001347
+ 86.4000n -0.001303 86.4100n -0.001259 86.4200n -0.001215 86.4300n -0.001171 86.4400n -0.001127 86.4500n -0.001082 86.4600n -0.001038 86.4700n -0.000994 86.4800n -0.000950 86.4900n -0.000906 86.5000n -0.000862 86.5100n -0.000818 86.5200n -0.000775 86.5300n -0.000731 86.5400n -0.000688
+ 86.5500n -0.000645 86.5600n -0.000602 86.5700n -0.000559 86.5800n -0.000517 86.5900n -0.000475 86.6000n -0.000433 86.6100n -0.000392 86.6200n -0.000350 86.6300n -0.000310 86.6400n -0.000269 86.6500n -0.000229 86.6600n -0.000189 86.6700n -0.000150 86.6800n -0.000111 86.6900n -0.000073
+ 86.7000n -0.000035 86.7100n 0.000003 86.7200n 0.000040 86.7300n 0.000076 86.7400n 0.000112 86.7500n 0.000148 86.7600n 0.000183 86.7700n 0.000217 86.7800n 0.000251 86.7900n 0.000284 86.8000n 0.000317 86.8100n 0.000349 86.8200n 0.000381 86.8300n 0.000412 86.8400n 0.000442
+ 86.8500n 0.000472 86.8600n 0.000501 86.8700n 0.000529 86.8800n 0.000557 86.8900n 0.000584 86.9000n 0.000611 86.9100n 0.000637 86.9200n 0.000662 86.9300n 0.000687 86.9400n 0.000711 86.9500n 0.000734 86.9600n 0.000756 86.9700n 0.000778 86.9800n 0.000800 86.9900n 0.000820
+ 87.0000n 0.000840 87.0100n 0.000859 87.0200n 0.000878 87.0300n 0.000896 87.0400n 0.000913 87.0500n 0.000929 87.0600n 0.000945 87.0700n 0.000960 87.0800n 0.000975 87.0900n 0.000989 87.1000n 0.001002 87.1100n 0.001015 87.1200n 0.001027 87.1300n 0.001038 87.1400n 0.001049
+ 87.1500n 0.001059 87.1600n 0.001068 87.1700n 0.001077 87.1800n 0.001085 87.1900n 0.001092 87.2000n 0.001099 87.2100n 0.001106 87.2200n 0.001112 87.2300n 0.001117 87.2400n 0.001121 87.2500n 0.001126 87.2600n 0.001129 87.2700n 0.001132 87.2800n 0.001135 87.2900n 0.001137
+ 87.3000n 0.001138 87.3100n 0.001139 87.3200n 0.001139 87.3300n 0.001139 87.3400n 0.001139 87.3500n 0.001138 87.3600n 0.001137 87.3700n 0.001135 87.3800n 0.001133 87.3900n 0.001130 87.4000n 0.001127 87.4100n 0.001124 87.4200n 0.001120 87.4300n 0.001116 87.4400n 0.001111
+ 87.4500n 0.001106 87.4600n 0.001101 87.4700n 0.001096 87.4800n 0.001090 87.4900n 0.001084 87.5000n 0.001078 87.5100n 0.001071 87.5200n 0.001064 87.5300n 0.001057 87.5400n 0.001050 87.5500n 0.001042 87.5600n 0.001035 87.5700n 0.001027 87.5800n 0.001019 87.5900n 0.001011
+ 87.6000n 0.001002 87.6100n 0.000994 87.6200n 0.000985 87.6300n 0.000976 87.6400n 0.000967 87.6500n 0.000958 87.6600n 0.000949 87.6700n 0.000940 87.6800n 0.000931 87.6900n 0.000922 87.7000n 0.000913 87.7100n 0.000903 87.7200n 0.000894 87.7300n 0.000885 87.7400n 0.000876
+ 87.7500n 0.000866 87.7600n 0.000857 87.7700n 0.000848 87.7800n 0.000839 87.7900n 0.000830 87.8000n 0.000821 87.8100n 0.000812 87.8200n 0.000803 87.8300n 0.000794 87.8400n 0.000785 87.8500n 0.000777 87.8600n 0.000768 87.8700n 0.000760 87.8800n 0.000751 87.8900n 0.000743
+ 87.9000n 0.000735 87.9100n 0.000727 87.9200n 0.000720 87.9300n 0.000712 87.9400n 0.000705 87.9500n 0.000698 87.9600n 0.000691 87.9700n 0.000684 87.9800n 0.000677 87.9900n 0.000671 88.0000n 0.000664 88.0100n 0.000658 88.0200n 0.000653 88.0300n 0.000647 88.0400n 0.000641
+ 88.0500n 0.000636 88.0600n 0.000631 88.0700n 0.000626 88.0800n 0.000622 88.0900n 0.000617 88.1000n 0.000613 88.1100n 0.000609 88.1200n 0.000605 88.1300n 0.000602 88.1400n 0.000598 88.1500n 0.000595 88.1600n 0.000593 88.1700n 0.000590 88.1800n 0.000588 88.1900n 0.000585
+ 88.2000n 0.000583 88.2100n 0.000582 88.2200n 0.000580 88.2300n 0.000579 88.2400n 0.000578 88.2500n 0.000577 88.2600n 0.000576 88.2700n 0.000576 88.2800n 0.000576 88.2900n 0.000576 88.3000n 0.000576 88.3100n 0.000576 88.3200n 0.000577 88.3300n 0.000578 88.3400n 0.000579
+ 88.3500n 0.000580 88.3600n 0.000581 88.3700n 0.000583 88.3800n 0.000585 88.3900n 0.000587 88.4000n 0.000589 88.4100n 0.000591 88.4200n 0.000593 88.4300n 0.000596 88.4400n 0.000599 88.4500n 0.000602 88.4600n 0.000605 88.4700n 0.000608 88.4800n 0.000612 88.4900n 0.000615
+ 88.5000n 0.000619 88.5100n 0.000623 88.5200n 0.000626 88.5300n 0.000631 88.5400n 0.000635 88.5500n 0.000639 88.5600n 0.000643 88.5700n 0.000648 88.5800n 0.000653 88.5900n 0.000657 88.6000n 0.000662 88.6100n 0.000667 88.6200n 0.000672 88.6300n 0.000677 88.6400n 0.000682
+ 88.6500n 0.000688 88.6600n 0.000693 88.6700n 0.000698 88.6800n 0.000704 88.6900n 0.000709 88.7000n 0.000715 88.7100n 0.000720 88.7200n 0.000726 88.7300n 0.000732 88.7400n 0.000737 88.7500n 0.000743 88.7600n 0.000749 88.7700n 0.000755 88.7800n 0.000760 88.7900n 0.000766
+ 88.8000n 0.000772 88.8100n 0.000778 88.8200n 0.000784 88.8300n 0.000790 88.8400n 0.000796 88.8500n 0.000802 88.8600n 0.000808 88.8700n 0.000814 88.8800n 0.000820 88.8900n 0.000826 88.9000n 0.000832 88.9100n 0.000837 88.9200n 0.000843 88.9300n 0.000849 88.9400n 0.000855
+ 88.9500n 0.000861 88.9600n 0.000867 88.9700n 0.000873 88.9800n 0.000878 88.9900n 0.000884 89.0000n 0.000890 89.0100n 0.000896 89.0200n 0.000901 89.0300n 0.000907 89.0400n 0.000913 89.0500n 0.000918 89.0600n 0.000924 89.0700n 0.000929 89.0800n 0.000935 89.0900n 0.000940
+ 89.1000n 0.000946 89.1100n 0.000951 89.1200n 0.000957 89.1300n 0.000962 89.1400n 0.000967 89.1500n 0.000973 89.1600n 0.000978 89.1700n 0.000983 89.1800n 0.000988 89.1900n 0.000993 89.2000n 0.000999 89.2100n 0.001004 89.2200n 0.001009 89.2300n 0.001014 89.2400n 0.001019
+ 89.2500n 0.001024 89.2600n 0.001029 89.2700n 0.001033 89.2800n 0.001038 89.2900n 0.001043 89.3000n 0.001048 89.3100n 0.001053 89.3200n 0.001057 89.3300n 0.001062 89.3400n 0.001067 89.3500n 0.001071 89.3600n 0.001076 89.3700n 0.001080 89.3800n 0.001085 89.3900n 0.001089
+ 89.4000n 0.001094 89.4100n 0.001098 89.4200n 0.001103 89.4300n 0.001107 89.4400n 0.001112 89.4500n 0.001116 89.4600n 0.001120 89.4700n 0.001124 89.4800n 0.001129 89.4900n 0.001133 89.5000n 0.001137 89.5100n 0.001141 89.5200n 0.001146 89.5300n 0.001150 89.5400n 0.001154
+ 89.5500n 0.001158 89.5600n 0.001162 89.5700n 0.001166 89.5800n 0.001170 89.5900n 0.001174 89.6000n 0.001178 89.6100n 0.001182 89.6200n 0.001185 89.6300n 0.001189 89.6400n 0.001193 89.6500n 0.001197 89.6600n 0.001200 89.6700n 0.001204 89.6800n 0.001208 89.6900n 0.001211
+ 89.7000n 0.001215 89.7100n 0.001218 89.7200n 0.001222 89.7300n 0.001225 89.7400n 0.001229 89.7500n 0.001232 89.7600n 0.001235 89.7700n 0.001238 89.7800n 0.001241 89.7900n 0.001244 89.8000n 0.001247 89.8100n 0.001250 89.8200n 0.001253 89.8300n 0.001256 89.8400n 0.001259
+ 89.8500n 0.001261 89.8600n 0.001264 89.8700n 0.001267 89.8800n 0.001269 89.8900n 0.001271 89.9000n 0.001273 89.9100n 0.001276 89.9200n 0.001278 89.9300n 0.001280 89.9400n 0.001281 89.9500n 0.001283 89.9600n 0.001285 89.9700n 0.001286 89.9800n 0.001288 89.9900n 0.001289
+ 90.0000n 0.001290 90.0100n 0.001291 90.0200n 0.001292 90.0300n 0.001292 90.0400n 0.001293 90.0500n 0.001293 90.0600n 0.001294 90.0700n 0.001294 90.0800n 0.001294 90.0900n 0.001294 90.1000n 0.001293 90.1100n 0.001293 90.1200n 0.001292 90.1300n 0.001291 90.1400n 0.001290
+ 90.1500n 0.001289 90.1600n 0.001288 90.1700n 0.001286 90.1800n 0.001284 90.1900n 0.001283 90.2000n 0.001280 90.2100n 0.001278 90.2200n 0.001275 90.2300n 0.001273 90.2400n 0.001270 90.2500n 0.001267 90.2600n 0.001263 90.2700n 0.001260 90.2800n 0.001256 90.2900n 0.001252
+ 90.3000n 0.001247 90.3100n 0.001243 90.3200n 0.001238 90.3300n 0.001233 90.3400n 0.001228 90.3500n 0.001222 90.3600n 0.001217 90.3700n 0.001211 90.3800n 0.001204 90.3900n 0.001198 90.4000n 0.001191 90.4100n 0.001184 90.4200n 0.001177 90.4300n 0.001170 90.4400n 0.001162
+ 90.4500n 0.001154 90.4600n 0.001146 90.4700n 0.001137 90.4800n 0.001128 90.4900n 0.001119 90.5000n 0.001110 90.5100n 0.001101 90.5200n 0.001091 90.5300n 0.001081 90.5400n 0.001070 90.5500n 0.001060 90.5600n 0.001049 90.5700n 0.001038 90.5800n 0.001027 90.5900n 0.001015
+ 90.6000n 0.001003 90.6100n 0.000991 90.6200n 0.000979 90.6300n 0.000967 90.6400n 0.000954 90.6500n 0.000941 90.6600n 0.000928 90.6700n 0.000914 90.6800n 0.000900 90.6900n 0.000886 90.7000n 0.000872 90.7100n 0.000858 90.7200n 0.000843 90.7300n 0.000829 90.7400n 0.000814
+ 90.7500n 0.000798 90.7600n 0.000783 90.7700n 0.000767 90.7800n 0.000752 90.7900n 0.000736 90.8000n 0.000719 90.8100n 0.000703 90.8200n 0.000687 90.8300n 0.000670 90.8400n 0.000653 90.8500n 0.000636 90.8600n 0.000619 90.8700n 0.000602 90.8800n 0.000585 90.8900n 0.000567
+ 90.9000n 0.000549 90.9100n 0.000532 90.9200n 0.000514 90.9300n 0.000496 90.9400n 0.000478 90.9500n 0.000460 90.9600n 0.000442 90.9700n 0.000423 90.9800n 0.000405 90.9900n 0.000387 91.0000n 0.000368 91.0100n 0.000350 91.0200n 0.000331 91.0300n 0.000313 91.0400n 0.000294
+ 91.0500n 0.000276 91.0600n 0.000257 91.0700n 0.000239 91.0800n 0.000220 91.0900n 0.000202 91.1000n 0.000184 91.1100n 0.000165 91.1200n 0.000147 91.1300n 0.000129 91.1400n 0.000110 91.1500n 0.000092 91.1600n 0.000074 91.1700n 0.000056 91.1800n 0.000038 91.1900n 0.000021
+ 91.2000n 0.000003 91.2100n -0.000014 91.2200n -0.000032 91.2300n -0.000049 91.2400n -0.000066 91.2500n -0.000083 91.2600n -0.000100 91.2700n -0.000116 91.2800n -0.000133 91.2900n -0.000149 91.3000n -0.000165 91.3100n -0.000181 91.3200n -0.000196 91.3300n -0.000212 91.3400n -0.000227
+ 91.3500n -0.000242 91.3600n -0.000257 91.3700n -0.000271 91.3800n -0.000285 91.3900n -0.000299 91.4000n -0.000313 91.4100n -0.000326 91.4200n -0.000339 91.4300n -0.000352 91.4400n -0.000365 91.4500n -0.000377 91.4600n -0.000389 91.4700n -0.000400 91.4800n -0.000412 91.4900n -0.000423
+ 91.5000n -0.000433 91.5100n -0.000444 91.5200n -0.000454 91.5300n -0.000463 91.5400n -0.000473 91.5500n -0.000482 91.5600n -0.000490 91.5700n -0.000499 91.5800n -0.000507 91.5900n -0.000514 91.6000n -0.000521 91.6100n -0.000528 91.6200n -0.000535 91.6300n -0.000541 91.6400n -0.000547
+ 91.6500n -0.000552 91.6600n -0.000557 91.6700n -0.000562 91.6800n -0.000566 91.6900n -0.000570 91.7000n -0.000574 91.7100n -0.000577 91.7200n -0.000580 91.7300n -0.000582 91.7400n -0.000584 91.7500n -0.000586 91.7600n -0.000588 91.7700n -0.000589 91.7800n -0.000589 91.7900n -0.000589
+ 91.8000n -0.000589 91.8100n -0.000589 91.8200n -0.000588 91.8300n -0.000587 91.8400n -0.000585 91.8500n -0.000583 91.8600n -0.000581 91.8700n -0.000579 91.8800n -0.000576 91.8900n -0.000573 91.9000n -0.000569 91.9100n -0.000565 91.9200n -0.000561 91.9300n -0.000556 91.9400n -0.000551
+ 91.9500n -0.000546 91.9600n -0.000541 91.9700n -0.000535 91.9800n -0.000529 91.9900n -0.000523 92.0000n -0.000516 92.0100n -0.000509 92.0200n -0.000502 92.0300n -0.000495 92.0400n -0.000487 92.0500n -0.000479 92.0600n -0.000471 92.0700n -0.000462 92.0800n -0.000454 92.0900n -0.000445
+ 92.1000n -0.000436 92.1100n -0.000426 92.1200n -0.000417 92.1300n -0.000407 92.1400n -0.000397 92.1500n -0.000387 92.1600n -0.000377 92.1700n -0.000367 92.1800n -0.000356 92.1900n -0.000345 92.2000n -0.000335 92.2100n -0.000324 92.2200n -0.000313 92.2300n -0.000301 92.2400n -0.000290
+ 92.2500n -0.000279 92.2600n -0.000267 92.2700n -0.000255 92.2800n -0.000244 92.2900n -0.000232 92.3000n -0.000220 92.3100n -0.000208 92.3200n -0.000196 92.3300n -0.000184 92.3400n -0.000172 92.3500n -0.000160 92.3600n -0.000148 92.3700n -0.000136 92.3800n -0.000124 92.3900n -0.000112
+ 92.4000n -0.000100 92.4100n -0.000088 92.4200n -0.000076 92.4300n -0.000064 92.4400n -0.000052 92.4500n -0.000040 92.4600n -0.000029 92.4700n -0.000017 92.4800n -0.000005 92.4900n 0.000006 92.5000n 0.000018 92.5100n 0.000029 92.5200n 0.000041 92.5300n 0.000052 92.5400n 0.000063
+ 92.5500n 0.000074 92.5600n 0.000085 92.5700n 0.000096 92.5800n 0.000107 92.5900n 0.000117 92.6000n 0.000128 92.6100n 0.000138 92.6200n 0.000148 92.6300n 0.000158 92.6400n 0.000168 92.6500n 0.000177 92.6600n 0.000187 92.6700n 0.000196 92.6800n 0.000206 92.6900n 0.000215
+ 92.7000n 0.000223 92.7100n 0.000232 92.7200n 0.000241 92.7300n 0.000249 92.7400n 0.000257 92.7500n 0.000265 92.7600n 0.000273 92.7700n 0.000280 92.7800n 0.000288 92.7900n 0.000295 92.8000n 0.000302 92.8100n 0.000309 92.8200n 0.000315 92.8300n 0.000322 92.8400n 0.000328
+ 92.8500n 0.000334 92.8600n 0.000340 92.8700n 0.000345 92.8800n 0.000351 92.8900n 0.000356 92.9000n 0.000361 92.9100n 0.000366 92.9200n 0.000371 92.9300n 0.000375 92.9400n 0.000380 92.9500n 0.000384 92.9600n 0.000388 92.9700n 0.000391 92.9800n 0.000395 92.9900n 0.000398
+ 93.0000n 0.000401 93.0100n 0.000404 93.0200n 0.000407 93.0300n 0.000410 93.0400n 0.000413 93.0500n 0.000415 93.0600n 0.000417 93.0700n 0.000419 93.0800n 0.000421 93.0900n 0.000423 93.1000n 0.000424 93.1100n 0.000426 93.1200n 0.000427 93.1300n 0.000428 93.1400n 0.000429
+ 93.1500n 0.000430 93.1600n 0.000431 93.1700n 0.000432 93.1800n 0.000432 93.1900n 0.000433 93.2000n 0.000433 93.2100n 0.000433 93.2200n 0.000433 93.2300n 0.000433 93.2400n 0.000433 93.2500n 0.000433 93.2600n 0.000433 93.2700n 0.000432 93.2800n 0.000432 93.2900n 0.000431
+ 93.3000n 0.000431 93.3100n 0.000430 93.3200n 0.000430 93.3300n 0.000429 93.3400n 0.000428 93.3500n 0.000427 93.3600n 0.000426 93.3700n 0.000426 93.3800n 0.000425 93.3900n 0.000424 93.4000n 0.000423 93.4100n 0.000422 93.4200n 0.000421 93.4300n 0.000420 93.4400n 0.000418
+ 93.4500n 0.000417 93.4600n 0.000416 93.4700n 0.000415 93.4800n 0.000414 93.4900n 0.000413 93.5000n 0.000412 93.5100n 0.000411 93.5200n 0.000410 93.5300n 0.000409 93.5400n 0.000408 93.5500n 0.000407 93.5600n 0.000406 93.5700n 0.000405 93.5800n 0.000404 93.5900n 0.000403
+ 93.6000n 0.000403 93.6100n 0.000402 93.6200n 0.000401 93.6300n 0.000400 93.6400n 0.000400 93.6500n 0.000399 93.6600n 0.000398 93.6700n 0.000398 93.6800n 0.000397 93.6900n 0.000397 93.7000n 0.000396 93.7100n 0.000396 93.7200n 0.000396 93.7300n 0.000395 93.7400n 0.000395
+ 93.7500n 0.000395 93.7600n 0.000395 93.7700n 0.000395 93.7800n 0.000395 93.7900n 0.000395 93.8000n 0.000395 93.8100n 0.000395 93.8200n 0.000395 93.8300n 0.000395 93.8400n 0.000395 93.8500n 0.000395 93.8600n 0.000395 93.8700n 0.000395 93.8800n 0.000396 93.8900n 0.000396
+ 93.9000n 0.000396 93.9100n 0.000397 93.9200n 0.000397 93.9300n 0.000397 93.9400n 0.000398 93.9500n 0.000398 93.9600n 0.000398 93.9700n 0.000399 93.9800n 0.000399 93.9900n 0.000400 94.0000n 0.000400 94.0100n 0.000400 94.0200n 0.000401 94.0300n 0.000401 94.0400n 0.000401
+ 94.0500n 0.000401 94.0600n 0.000402 94.0700n 0.000402 94.0800n 0.000402 94.0900n 0.000402 94.1000n 0.000402 94.1100n 0.000402 94.1200n 0.000402 94.1300n 0.000402 94.1400n 0.000402 94.1500n 0.000401 94.1600n 0.000401 94.1700n 0.000401 94.1800n 0.000400 94.1900n 0.000400
+ 94.2000n 0.000399 94.2100n 0.000398 94.2200n 0.000397 94.2300n 0.000396 94.2400n 0.000395 94.2500n 0.000394 94.2600n 0.000393 94.2700n 0.000391 94.2800n 0.000390 94.2900n 0.000388 94.3000n 0.000386 94.3100n 0.000384 94.3200n 0.000382 94.3300n 0.000379 94.3400n 0.000377
+ 94.3500n 0.000374 94.3600n 0.000372 94.3700n 0.000369 94.3800n 0.000366 94.3900n 0.000362 94.4000n 0.000359 94.4100n 0.000355 94.4200n 0.000351 94.4300n 0.000347 94.4400n 0.000343 94.4500n 0.000339 94.4600n 0.000334 94.4700n 0.000330 94.4800n 0.000325 94.4900n 0.000320
+ 94.5000n 0.000314 94.5100n 0.000309 94.5200n 0.000303 94.5300n 0.000297 94.5400n 0.000291 94.5500n 0.000284 94.5600n 0.000278 94.5700n 0.000271 94.5800n 0.000264 94.5900n 0.000257 94.6000n 0.000250 94.6100n 0.000242 94.6200n 0.000234 94.6300n 0.000226 94.6400n 0.000218
+ 94.6500n 0.000209 94.6600n 0.000201 94.6700n 0.000192 94.6800n 0.000183 94.6900n 0.000174 94.7000n 0.000164 94.7100n 0.000155 94.7200n 0.000145 94.7300n 0.000135 94.7400n 0.000124 94.7500n 0.000114 94.7600n 0.000103 94.7700n 0.000093 94.7800n 0.000082 94.7900n 0.000071
+ 94.8000n 0.000059 94.8100n 0.000048 94.8200n 0.000036 94.8300n 0.000024 94.8400n 0.000013 94.8500n 0.000000 94.8600n -0.000012 94.8700n -0.000024 94.8800n -0.000037 94.8900n -0.000049 94.9000n -0.000062 94.9100n -0.000075 94.9200n -0.000088 94.9300n -0.000101 94.9400n -0.000114
+ 94.9500n -0.000127 94.9600n -0.000140 94.9700n -0.000154 94.9800n -0.000167 94.9900n -0.000181 95.0000n -0.000194 95.0100n -0.000208 95.0200n -0.000221 95.0300n -0.000235 95.0400n -0.000249 95.0500n -0.000262 95.0600n -0.000276 95.0700n -0.000290 95.0800n -0.000303 95.0900n -0.000317
+ 95.1000n -0.000331 95.1100n -0.000344 95.1200n -0.000358 95.1300n -0.000371 95.1400n -0.000384 95.1500n -0.000398 95.1600n -0.000411 95.1700n -0.000424 95.1800n -0.000437 95.1900n -0.000450 95.2000n -0.000463 95.2100n -0.000475 95.2200n -0.000488 95.2300n -0.000500 95.2400n -0.000512
+ 95.2500n -0.000524 95.2600n -0.000536 95.2700n -0.000547 95.2800n -0.000559 95.2900n -0.000570 95.3000n -0.000581 95.3100n -0.000592 95.3200n -0.000602 95.3300n -0.000612 95.3400n -0.000622 95.3500n -0.000632 95.3600n -0.000641 95.3700n -0.000650 95.3800n -0.000659 95.3900n -0.000668
+ 95.4000n -0.000676 95.4100n -0.000684 95.4200n -0.000691 95.4300n -0.000698 95.4400n -0.000705 95.4500n -0.000711 95.4600n -0.000718 95.4700n -0.000723 95.4800n -0.000728 95.4900n -0.000733 95.5000n -0.000738 95.5100n -0.000742 95.5200n -0.000746 95.5300n -0.000749 95.5400n -0.000752
+ 95.5500n -0.000754 95.5600n -0.000756 95.5700n -0.000757 95.5800n -0.000758 95.5900n -0.000759 95.6000n -0.000759 95.6100n -0.000759 95.6200n -0.000758 95.6300n -0.000756 95.6400n -0.000754 95.6500n -0.000752 95.6600n -0.000749 95.6700n -0.000746 95.6800n -0.000742 95.6900n -0.000737
+ 95.7000n -0.000732 95.7100n -0.000727 95.7200n -0.000721 95.7300n -0.000714 95.7400n -0.000707 95.7500n -0.000700 95.7600n -0.000691 95.7700n -0.000683 95.7800n -0.000673 95.7900n -0.000664 95.8000n -0.000653 95.8100n -0.000642 95.8200n -0.000631 95.8300n -0.000619 95.8400n -0.000606
+ 95.8500n -0.000593 95.8600n -0.000580 95.8700n -0.000565 95.8800n -0.000551 95.8900n -0.000535 95.9000n -0.000519 95.9100n -0.000503 95.9200n -0.000486 95.9300n -0.000469 95.9400n -0.000450 95.9500n -0.000432 95.9600n -0.000413 95.9700n -0.000393 95.9800n -0.000373 95.9900n -0.000352
+ 96.0000n -0.000331 96.0100n -0.000309 96.0200n -0.000287 96.0300n -0.000264 96.0400n -0.000241 96.0500n -0.000217 96.0600n -0.000193 96.0700n -0.000168 96.0800n -0.000143 96.0900n -0.000117 96.1000n -0.000091 96.1100n -0.000064 96.1200n -0.000037 96.1300n -0.000010 96.1400n 0.000018
+ 96.1500n 0.000047 96.1600n 0.000075 96.1700n 0.000105 96.1800n 0.000134 96.1900n 0.000164 96.2000n 0.000195 96.2100n 0.000226 96.2200n 0.000257 96.2300n 0.000289 96.2400n 0.000321 96.2500n 0.000353 96.2600n 0.000385 96.2700n 0.000418 96.2800n 0.000452 96.2900n 0.000485
+ 96.3000n 0.000519 96.3100n 0.000553 96.3200n 0.000588 96.3300n 0.000623 96.3400n 0.000658 96.3500n 0.000693 96.3600n 0.000728 96.3700n 0.000764 96.3800n 0.000800 96.3900n 0.000836 96.4000n 0.000872 96.4100n 0.000909 96.4200n 0.000945 96.4300n 0.000982 96.4400n 0.001019
+ 96.4500n 0.001056 96.4600n 0.001094 96.4700n 0.001131 96.4800n 0.001168 96.4900n 0.001206 96.5000n 0.001243 96.5100n 0.001281 96.5200n 0.001319 96.5300n 0.001356 96.5400n 0.001394 96.5500n 0.001432 96.5600n 0.001470 96.5700n 0.001507 96.5800n 0.001545 96.5900n 0.001583
+ 96.6000n 0.001620 96.6100n 0.001658 96.6200n 0.001695 96.6300n 0.001733 96.6400n 0.001770 96.6500n 0.001807 96.6600n 0.001844 96.6700n 0.001881 96.6800n 0.001918 96.6900n 0.001955 96.7000n 0.001991 96.7100n 0.002027 96.7200n 0.002063 96.7300n 0.002099 96.7400n 0.002135
+ 96.7500n 0.002170 96.7600n 0.002206 96.7700n 0.002241 96.7800n 0.002275 96.7900n 0.002310 96.8000n 0.002344 96.8100n 0.002378 96.8200n 0.002411 96.8300n 0.002444 96.8400n 0.002477 96.8500n 0.002510 96.8600n 0.002542 96.8700n 0.002574 96.8800n 0.002605 96.8900n 0.002637
+ 96.9000n 0.002667 96.9100n 0.002698 96.9200n 0.002727 96.9300n 0.002757 96.9400n 0.002786 96.9500n 0.002815 96.9600n 0.002843 96.9700n 0.002871 96.9800n 0.002898 96.9900n 0.002925 97.0000n 0.002951 97.0100n 0.002977 97.0200n 0.003002 97.0300n 0.003027 97.0400n 0.003051
+ 97.0500n 0.003075 97.0600n 0.003098 97.0700n 0.003121 97.0800n 0.003143 97.0900n 0.003165 97.1000n 0.003186 97.1100n 0.003206 97.1200n 0.003226 97.1300n 0.003246 97.1400n 0.003264 97.1500n 0.003283 97.1600n 0.003300 97.1700n 0.003317 97.1800n 0.003334 97.1900n 0.003349
+ 97.2000n 0.003364 97.2100n 0.003379 97.2200n 0.003393 97.2300n 0.003406 97.2400n 0.003419 97.2500n 0.003431 97.2600n 0.003442 97.2700n 0.003453 97.2800n 0.003463 97.2900n 0.003472 97.3000n 0.003481 97.3100n 0.003489 97.3200n 0.003497 97.3300n 0.003503 97.3400n 0.003509
+ 97.3500n 0.003515 97.3600n 0.003519 97.3700n 0.003523 97.3800n 0.003527 97.3900n 0.003530 97.4000n 0.003532 97.4100n 0.003533 97.4200n 0.003533 97.4300n 0.003533 97.4400n 0.003533 97.4500n 0.003531 97.4600n 0.003529 97.4700n 0.003526 97.4800n 0.003523 97.4900n 0.003518
+ 97.5000n 0.003513 97.5100n 0.003508 97.5200n 0.003502 97.5300n 0.003495 97.5400n 0.003487 97.5500n 0.003478 97.5600n 0.003469 97.5700n 0.003460 97.5800n 0.003449 97.5900n 0.003438 97.6000n 0.003426 97.6100n 0.003414 97.6200n 0.003401 97.6300n 0.003387 97.6400n 0.003372
+ 97.6500n 0.003357 97.6600n 0.003341 97.6700n 0.003325 97.6800n 0.003308 97.6900n 0.003290 97.7000n 0.003271 97.7100n 0.003252 97.7200n 0.003232 97.7300n 0.003212 97.7400n 0.003191 97.7500n 0.003169 97.7600n 0.003147 97.7700n 0.003124 97.7800n 0.003100 97.7900n 0.003076
+ 97.8000n 0.003051 97.8100n 0.003026 97.8200n 0.003000 97.8300n 0.002973 97.8400n 0.002946 97.8500n 0.002918 97.8600n 0.002890 97.8700n 0.002861 97.8800n 0.002831 97.8900n 0.002801 97.9000n 0.002770 97.9100n 0.002739 97.9200n 0.002708 97.9300n 0.002675 97.9400n 0.002643
+ 97.9500n 0.002609 97.9600n 0.002576 97.9700n 0.002541 97.9800n 0.002506 97.9900n 0.002471 98.0000n 0.002436 98.0100n 0.002399 98.0200n 0.002363 98.0300n 0.002326 98.0400n 0.002288 98.0500n 0.002250 98.0600n 0.002212 98.0700n 0.002173 98.0800n 0.002134 98.0900n 0.002094
+ 98.1000n 0.002054 98.1100n 0.002014 98.1200n 0.001973 98.1300n 0.001932 98.1400n 0.001891 98.1500n 0.001849 98.1600n 0.001807 98.1700n 0.001765 98.1800n 0.001722 98.1900n 0.001679 98.2000n 0.001636 98.2100n 0.001593 98.2200n 0.001549 98.2300n 0.001505 98.2400n 0.001461
+ 98.2500n 0.001417 98.2600n 0.001372 98.2700n 0.001328 98.2800n 0.001283 98.2900n 0.001238 98.3000n 0.001192 98.3100n 0.001147 98.3200n 0.001102 98.3300n 0.001056 98.3400n 0.001010 98.3500n 0.000965 98.3600n 0.000919 98.3700n 0.000873 98.3800n 0.000827 98.3900n 0.000781
+ 98.4000n 0.000735 98.4100n 0.000689 98.4200n 0.000643 98.4300n 0.000597 98.4400n 0.000551 98.4500n 0.000506 98.4600n 0.000460 98.4700n 0.000414 98.4800n 0.000369 98.4900n 0.000323 98.5000n 0.000278 98.5100n 0.000233 98.5200n 0.000188 98.5300n 0.000143 98.5400n 0.000098
+ 98.5500n 0.000054 98.5600n 0.000009 98.5700n -0.000035 98.5800n -0.000078 98.5900n -0.000122 98.6000n -0.000165 98.6100n -0.000208 98.6200n -0.000251 98.6300n -0.000293 98.6400n -0.000335 98.6500n -0.000377 98.6600n -0.000418 98.6700n -0.000459 98.6800n -0.000500 98.6900n -0.000540
+ 98.7000n -0.000579 98.7100n -0.000619 98.7200n -0.000658 98.7300n -0.000696 98.7400n -0.000734 98.7500n -0.000771 98.7600n -0.000808 98.7700n -0.000845 98.7800n -0.000881 98.7900n -0.000916 98.8000n -0.000951 98.8100n -0.000985 98.8200n -0.001018 98.8300n -0.001052 98.8400n -0.001084
+ 98.8500n -0.001116 98.8600n -0.001147 98.8700n -0.001178 98.8800n -0.001207 98.8900n -0.001237 98.9000n -0.001265 98.9100n -0.001293 98.9200n -0.001320 98.9300n -0.001347 98.9400n -0.001372 98.9500n -0.001397 98.9600n -0.001422 98.9700n -0.001445 98.9800n -0.001468 98.9900n -0.001490
+ 99.0000n -0.001511 99.0100n -0.001531 99.0200n -0.001551 99.0300n -0.001570 99.0400n -0.001588 99.0500n -0.001605 99.0600n -0.001621 99.0700n -0.001637 99.0800n -0.001651 99.0900n -0.001665 99.1000n -0.001678 99.1100n -0.001690 99.1200n -0.001701 99.1300n -0.001712 99.1400n -0.001721
+ 99.1500n -0.001730 99.1600n -0.001737 99.1700n -0.001744 99.1800n -0.001750 99.1900n -0.001755 99.2000n -0.001759 99.2100n -0.001763 99.2200n -0.001765 99.2300n -0.001766 99.2400n -0.001767 99.2500n -0.001766 99.2600n -0.001765 99.2700n -0.001763 99.2800n -0.001760 99.2900n -0.001756
+ 99.3000n -0.001751 99.3100n -0.001745 99.3200n -0.001739 99.3300n -0.001731 99.3400n -0.001722 99.3500n -0.001713 99.3600n -0.001703 99.3700n -0.001692 99.3800n -0.001680 99.3900n -0.001667 99.4000n -0.001653 99.4100n -0.001638 99.4200n -0.001623 99.4300n -0.001606 99.4400n -0.001589
+ 99.4500n -0.001571 99.4600n -0.001552 99.4700n -0.001533 99.4800n -0.001512 99.4900n -0.001491 99.5000n -0.001469 99.5100n -0.001446 99.5200n -0.001423 99.5300n -0.001398 99.5400n -0.001373 99.5500n -0.001347 99.5600n -0.001321 99.5700n -0.001293 99.5800n -0.001265 99.5900n -0.001237
+ 99.6000n -0.001207 99.6100n -0.001177 99.6200n -0.001146 99.6300n -0.001115 99.6400n -0.001083 99.6500n -0.001050 99.6600n -0.001017 99.6700n -0.000984 99.6800n -0.000949 99.6900n -0.000914 99.7000n -0.000879 99.7100n -0.000843 99.7200n -0.000807 99.7300n -0.000770 99.7400n -0.000732
+ 99.7500n -0.000695 99.7600n -0.000656 99.7700n -0.000618 99.7800n -0.000579 99.7900n -0.000539 99.8000n -0.000499 99.8100n -0.000459 99.8200n -0.000419 99.8300n -0.000378 99.8400n -0.000337 99.8500n -0.000296 99.8600n -0.000254 99.8700n -0.000213 99.8800n -0.000171 99.8900n -0.000129
+ 99.9000n -0.000086 99.9100n -0.000044 99.9200n -0.000002 99.9300n 0.000041 99.9400n 0.000084 99.9500n 0.000127 99.9600n 0.000169 99.9700n 0.000212 99.9800n 0.000255 99.9900n 0.000298 100.0000n 0.000341 100.0100n 0.000383 100.0200n 0.000426 100.0300n 0.000468 100.0400n 0.000511
+ 100.0500n 0.000553 100.0600n 0.000595 100.0700n 0.000637 100.0800n 0.000679 100.0900n 0.000720 100.1000n 0.000762 100.1100n 0.000803 100.1200n 0.000843 100.1300n 0.000884 100.1400n 0.000924 100.1500n 0.000963 100.1600n 0.001003 100.1700n 0.001042 100.1800n 0.001080 100.1900n 0.001119
+ 100.2000n 0.001156 100.2100n 0.001194 100.2200n 0.001231 100.2300n 0.001267 100.2400n 0.001303 100.2500n 0.001338 100.2600n 0.001373 100.2700n 0.001407 100.2800n 0.001441 100.2900n 0.001474 100.3000n 0.001507 100.3100n 0.001539 100.3200n 0.001570 100.3300n 0.001601 100.3400n 0.001631
+ 100.3500n 0.001660 100.3600n 0.001689 100.3700n 0.001717 100.3800n 0.001744 100.3900n 0.001771 100.4000n 0.001797 100.4100n 0.001822 100.4200n 0.001847 100.4300n 0.001870 100.4400n 0.001893 100.4500n 0.001915 100.4600n 0.001937 100.4700n 0.001957 100.4800n 0.001977 100.4900n 0.001996
+ 100.5000n 0.002014 100.5100n 0.002031 100.5200n 0.002048 100.5300n 0.002064 100.5400n 0.002079 100.5500n 0.002093 100.5600n 0.002106 100.5700n 0.002118 100.5800n 0.002130 100.5900n 0.002140 100.6000n 0.002150 100.6100n 0.002159 100.6200n 0.002167 100.6300n 0.002175 100.6400n 0.002181
+ 100.6500n 0.002186 100.6600n 0.002191 100.6700n 0.002195 100.6800n 0.002198 100.6900n 0.002200 100.7000n 0.002201 100.7100n 0.002202 100.7200n 0.002201 100.7300n 0.002200 100.7400n 0.002198 100.7500n 0.002195 100.7600n 0.002192 100.7700n 0.002187 100.7800n 0.002182 100.7900n 0.002176
+ 100.8000n 0.002169 100.8100n 0.002161 100.8200n 0.002153 100.8300n 0.002143 100.8400n 0.002133 100.8500n 0.002123 100.8600n 0.002111 100.8700n 0.002099 100.8800n 0.002086 100.8900n 0.002072 100.9000n 0.002058 100.9100n 0.002043 100.9200n 0.002027 100.9300n 0.002011 100.9400n 0.001994
+ 100.9500n 0.001976 100.9600n 0.001958 100.9700n 0.001939 100.9800n 0.001919 100.9900n 0.001899 101.0000n 0.001878 101.0100n 0.001857 101.0200n 0.001835 101.0300n 0.001813 101.0400n 0.001790 101.0500n 0.001767 101.0600n 0.001743 101.0700n 0.001718 101.0800n 0.001694 101.0900n 0.001668
+ 101.1000n 0.001643 101.1100n 0.001617 101.1200n 0.001590 101.1300n 0.001564 101.1400n 0.001536 101.1500n 0.001509 101.1600n 0.001481 101.1700n 0.001453 101.1800n 0.001425 101.1900n 0.001396 101.2000n 0.001367 101.2100n 0.001338 101.2200n 0.001308 101.2300n 0.001279 101.2400n 0.001249
+ 101.2500n 0.001219 101.2600n 0.001189 101.2700n 0.001159 101.2800n 0.001128 101.2900n 0.001098 101.3000n 0.001067 101.3100n 0.001037 101.3200n 0.001006 101.3300n 0.000975 101.3400n 0.000944 101.3500n 0.000914 101.3600n 0.000883 101.3700n 0.000852 101.3800n 0.000821 101.3900n 0.000791
+ 101.4000n 0.000760 101.4100n 0.000730 101.4200n 0.000699 101.4300n 0.000669 101.4400n 0.000639 101.4500n 0.000609 101.4600n 0.000579 101.4700n 0.000549 101.4800n 0.000520 101.4900n 0.000490 101.5000n 0.000461 101.5100n 0.000432 101.5200n 0.000404 101.5300n 0.000375 101.5400n 0.000347
+ 101.5500n 0.000319 101.5600n 0.000292 101.5700n 0.000264 101.5800n 0.000237 101.5900n 0.000210 101.6000n 0.000184 101.6100n 0.000158 101.6200n 0.000132 101.6300n 0.000107 101.6400n 0.000081 101.6500n 0.000057 101.6600n 0.000032 101.6700n 0.000008 101.6800n -0.000015 101.6900n -0.000039
+ 101.7000n -0.000062 101.7100n -0.000084 101.7200n -0.000106 101.7300n -0.000128 101.7400n -0.000149 101.7500n -0.000170 101.7600n -0.000191 101.7700n -0.000211 101.7800n -0.000230 101.7900n -0.000249 101.8000n -0.000268 101.8100n -0.000287 101.8200n -0.000305 101.8300n -0.000322 101.8400n -0.000339
+ 101.8500n -0.000356 101.8600n -0.000372 101.8700n -0.000388 101.8800n -0.000403 101.8900n -0.000418 101.9000n -0.000433 101.9100n -0.000447 101.9200n -0.000461 101.9300n -0.000474 101.9400n -0.000487 101.9500n -0.000500 101.9600n -0.000512 101.9700n -0.000524 101.9800n -0.000535 101.9900n -0.000546
+ 102.0000n -0.000557 102.0100n -0.000567 102.0200n -0.000577 102.0300n -0.000586 102.0400n -0.000596 102.0500n -0.000604 102.0600n -0.000613 102.0700n -0.000621 102.0800n -0.000629 102.0900n -0.000636 102.1000n -0.000643 102.1100n -0.000650 102.1200n -0.000657 102.1300n -0.000663 102.1400n -0.000669
+ 102.1500n -0.000675 102.1600n -0.000680 102.1700n -0.000686 102.1800n -0.000691 102.1900n -0.000695 102.2000n -0.000700 102.2100n -0.000704 102.2200n -0.000709 102.2300n -0.000712 102.2400n -0.000716 102.2500n -0.000720 102.2600n -0.000723 102.2700n -0.000727 102.2800n -0.000730 102.2900n -0.000733
+ 102.3000n -0.000736 102.3100n -0.000738 102.3200n -0.000741 102.3300n -0.000744 102.3400n -0.000746 102.3500n -0.000748 102.3600n -0.000751 102.3700n -0.000753 102.3800n -0.000755 102.3900n -0.000758 102.4000n -0.000760 102.4100n -0.000762 102.4200n -0.000764 102.4300n -0.000766 102.4400n -0.000769
+ 102.4500n -0.000771 102.4600n -0.000773 102.4700n -0.000775 102.4800n -0.000778 102.4900n -0.000780 102.5000n -0.000783 102.5100n -0.000785 102.5200n -0.000788 102.5300n -0.000791 102.5400n -0.000793 102.5500n -0.000796 102.5600n -0.000799 102.5700n -0.000803 102.5800n -0.000806 102.5900n -0.000809
+ 102.6000n -0.000813 102.6100n -0.000817 102.6200n -0.000820 102.6300n -0.000825 102.6400n -0.000829 102.6500n -0.000833 102.6600n -0.000838 102.6700n -0.000842 102.6800n -0.000847 102.6900n -0.000852 102.7000n -0.000857 102.7100n -0.000863 102.7200n -0.000868 102.7300n -0.000874 102.7400n -0.000880
+ 102.7500n -0.000886 102.7600n -0.000893 102.7700n -0.000899 102.7800n -0.000906 102.7900n -0.000913 102.8000n -0.000920 102.8100n -0.000928 102.8200n -0.000935 102.8300n -0.000943 102.8400n -0.000951 102.8500n -0.000959 102.8600n -0.000968 102.8700n -0.000976 102.8800n -0.000985 102.8900n -0.000994
+ 102.9000n -0.001003 102.9100n -0.001012 102.9200n -0.001022 102.9300n -0.001031 102.9400n -0.001041 102.9500n -0.001051 102.9600n -0.001061 102.9700n -0.001071 102.9800n -0.001082 102.9900n -0.001092 103.0000n -0.001103 103.0100n -0.001114 103.0200n -0.001125 103.0300n -0.001136 103.0400n -0.001147
+ 103.0500n -0.001158 103.0600n -0.001169 103.0700n -0.001181 103.0800n -0.001192 103.0900n -0.001204 103.1000n -0.001216 103.1100n -0.001227 103.1200n -0.001239 103.1300n -0.001251 103.1400n -0.001263 103.1500n -0.001274 103.1600n -0.001286 103.1700n -0.001298 103.1800n -0.001310 103.1900n -0.001322
+ 103.2000n -0.001333 103.2100n -0.001345 103.2200n -0.001357 103.2300n -0.001368 103.2400n -0.001380 103.2500n -0.001391 103.2600n -0.001403 103.2700n -0.001414 103.2800n -0.001425 103.2900n -0.001436 103.3000n -0.001447 103.3100n -0.001458 103.3200n -0.001468 103.3300n -0.001479 103.3400n -0.001489
+ 103.3500n -0.001499 103.3600n -0.001509 103.3700n -0.001518 103.3800n -0.001528 103.3900n -0.001537 103.4000n -0.001546 103.4100n -0.001555 103.4200n -0.001563 103.4300n -0.001571 103.4400n -0.001579 103.4500n -0.001587 103.4600n -0.001594 103.4700n -0.001601 103.4800n -0.001608 103.4900n -0.001614
+ 103.5000n -0.001620 103.5100n -0.001626 103.5200n -0.001631 103.5300n -0.001636 103.5400n -0.001641 103.5500n -0.001645 103.5600n -0.001649 103.5700n -0.001653 103.5800n -0.001656 103.5900n -0.001659 103.6000n -0.001661 103.6100n -0.001663 103.6200n -0.001665 103.6300n -0.001666 103.6400n -0.001666
+ 103.6500n -0.001667 103.6600n -0.001667 103.6700n -0.001666 103.6800n -0.001665 103.6900n -0.001663 103.7000n -0.001662 103.7100n -0.001659 103.7200n -0.001656 103.7300n -0.001653 103.7400n -0.001649 103.7500n -0.001645 103.7600n -0.001640 103.7700n -0.001635 103.7800n -0.001630 103.7900n -0.001624
+ 103.8000n -0.001617 103.8100n -0.001610 103.8200n -0.001603 103.8300n -0.001595 103.8400n -0.001587 103.8500n -0.001578 103.8600n -0.001569 103.8700n -0.001559 103.8800n -0.001549 103.8900n -0.001539 103.9000n -0.001528 103.9100n -0.001517 103.9200n -0.001505 103.9300n -0.001493 103.9400n -0.001480
+ 103.9500n -0.001467 103.9600n -0.001454 103.9700n -0.001440 103.9800n -0.001426 103.9900n -0.001411 104.0000n -0.001396 104.0100n -0.001381 104.0200n -0.001366 104.0300n -0.001350 104.0400n -0.001333 104.0500n -0.001317 104.0600n -0.001300 104.0700n -0.001283 104.0800n -0.001265 104.0900n -0.001247
+ 104.1000n -0.001229 104.1100n -0.001211 104.1200n -0.001192 104.1300n -0.001173 104.1400n -0.001154 104.1500n -0.001135 104.1600n -0.001116 104.1700n -0.001096 104.1800n -0.001076 104.1900n -0.001056 104.2000n -0.001036 104.2100n -0.001016 104.2200n -0.000995 104.2300n -0.000975 104.2400n -0.000954
+ 104.2500n -0.000934 104.2600n -0.000913 104.2700n -0.000892 104.2800n -0.000871 104.2900n -0.000850 104.3000n -0.000830 104.3100n -0.000809 104.3200n -0.000788 104.3300n -0.000767 104.3400n -0.000746 104.3500n -0.000725 104.3600n -0.000705 104.3700n -0.000684 104.3800n -0.000664 104.3900n -0.000643
+ 104.4000n -0.000623 104.4100n -0.000603 104.4200n -0.000583 104.4300n -0.000564 104.4400n -0.000544 104.4500n -0.000525 104.4600n -0.000506 104.4700n -0.000487 104.4800n -0.000468 104.4900n -0.000450 104.5000n -0.000432 104.5100n -0.000414 104.5200n -0.000396 104.5300n -0.000379 104.5400n -0.000362
+ 104.5500n -0.000346 104.5600n -0.000329 104.5700n -0.000314 104.5800n -0.000298 104.5900n -0.000283 104.6000n -0.000268 104.6100n -0.000254 104.6200n -0.000240 104.6300n -0.000227 104.6400n -0.000214 104.6500n -0.000201 104.6600n -0.000189 104.6700n -0.000177 104.6800n -0.000166 104.6900n -0.000155
+ 104.7000n -0.000145 104.7100n -0.000136 104.7200n -0.000126 104.7300n -0.000118 104.7400n -0.000110 104.7500n -0.000102 104.7600n -0.000095 104.7700n -0.000088 104.7800n -0.000082 104.7900n -0.000077 104.8000n -0.000072 104.8100n -0.000067 104.8200n -0.000064 104.8300n -0.000060 104.8400n -0.000058
+ 104.8500n -0.000055 104.8600n -0.000054 104.8700n -0.000053 104.8800n -0.000052 104.8900n -0.000053 104.9000n -0.000053 104.9100n -0.000055 104.9200n -0.000056 104.9300n -0.000059 104.9400n -0.000062 104.9500n -0.000065 104.9600n -0.000069 104.9700n -0.000074 104.9800n -0.000079 104.9900n -0.000085
+ 105.0000n -0.000091 105.0100n -0.000098 105.0200n -0.000105 105.0300n -0.000113 105.0400n -0.000121 105.0500n -0.000130 105.0600n -0.000140 105.0700n -0.000150 105.0800n -0.000160 105.0900n -0.000171 105.1000n -0.000182 105.1100n -0.000194 105.1200n -0.000207 105.1300n -0.000219 105.1400n -0.000232
+ 105.1500n -0.000246 105.1600n -0.000260 105.1700n -0.000274 105.1800n -0.000289 105.1900n -0.000304 105.2000n -0.000320 105.2100n -0.000336 105.2200n -0.000352 105.2300n -0.000369 105.2400n -0.000386 105.2500n -0.000403 105.2600n -0.000421 105.2700n -0.000438 105.2800n -0.000456 105.2900n -0.000475
+ 105.3000n -0.000493 105.3100n -0.000512 105.3200n -0.000531 105.3300n -0.000550 105.3400n -0.000570 105.3500n -0.000589 105.3600n -0.000609 105.3700n -0.000629 105.3800n -0.000649 105.3900n -0.000669 105.4000n -0.000689 105.4100n -0.000709 105.4200n -0.000729 105.4300n -0.000749 105.4400n -0.000769
+ 105.4500n -0.000790 105.4600n -0.000810 105.4700n -0.000830 105.4800n -0.000850 105.4900n -0.000870 105.5000n -0.000890 105.5100n -0.000910 105.5200n -0.000930 105.5300n -0.000950 105.5400n -0.000969 105.5500n -0.000989 105.5600n -0.001008 105.5700n -0.001027 105.5800n -0.001046 105.5900n -0.001064
+ 105.6000n -0.001083 105.6100n -0.001101 105.6200n -0.001119 105.6300n -0.001136 105.6400n -0.001154 105.6500n -0.001171 105.6600n -0.001187 105.6700n -0.001204 105.6800n -0.001220 105.6900n -0.001235 105.7000n -0.001250 105.7100n -0.001265 105.7200n -0.001280 105.7300n -0.001294 105.7400n -0.001307
+ 105.7500n -0.001321 105.7600n -0.001333 105.7700n -0.001346 105.7800n -0.001357 105.7900n -0.001369 105.8000n -0.001380 105.8100n -0.001390 105.8200n -0.001400 105.8300n -0.001409 105.8400n -0.001418 105.8500n -0.001427 105.8600n -0.001434 105.8700n -0.001442 105.8800n -0.001449 105.8900n -0.001455
+ 105.9000n -0.001460 105.9100n -0.001465 105.9200n -0.001470 105.9300n -0.001474 105.9400n -0.001477 105.9500n -0.001480 105.9600n -0.001482 105.9700n -0.001484 105.9800n -0.001485 105.9900n -0.001486 106.0000n -0.001486 106.0100n -0.001485 106.0200n -0.001484 106.0300n -0.001482 106.0400n -0.001480
+ 106.0500n -0.001477 106.0600n -0.001473 106.0700n -0.001469 106.0800n -0.001464 106.0900n -0.001459 106.1000n -0.001453 106.1100n -0.001447 106.1200n -0.001440 106.1300n -0.001433 106.1400n -0.001425 106.1500n -0.001416 106.1600n -0.001407 106.1700n -0.001398 106.1800n -0.001388 106.1900n -0.001377
+ 106.2000n -0.001366 106.2100n -0.001354 106.2200n -0.001342 106.2300n -0.001330 106.2400n -0.001317 106.2500n -0.001304 106.2600n -0.001290 106.2700n -0.001275 106.2800n -0.001261 106.2900n -0.001246 106.3000n -0.001230 106.3100n -0.001214 106.3200n -0.001198 106.3300n -0.001181 106.3400n -0.001164
+ 106.3500n -0.001147 106.3600n -0.001129 106.3700n -0.001112 106.3800n -0.001093 106.3900n -0.001075 106.4000n -0.001056 106.4100n -0.001037 106.4200n -0.001018 106.4300n -0.000999 106.4400n -0.000979 106.4500n -0.000959 106.4600n -0.000939 106.4700n -0.000919 106.4800n -0.000899 106.4900n -0.000878
+ 106.5000n -0.000858 106.5100n -0.000837 106.5200n -0.000817 106.5300n -0.000796 106.5400n -0.000775 106.5500n -0.000754 106.5600n -0.000733 106.5700n -0.000713 106.5800n -0.000692 106.5900n -0.000671 106.6000n -0.000650 106.6100n -0.000630 106.6200n -0.000609 106.6300n -0.000589 106.6400n -0.000568
+ 106.6500n -0.000548 106.6600n -0.000528 106.6700n -0.000508 106.6800n -0.000488 106.6900n -0.000469 106.7000n -0.000450 106.7100n -0.000430 106.7200n -0.000412 106.7300n -0.000393 106.7400n -0.000375 106.7500n -0.000356 106.7600n -0.000339 106.7700n -0.000321 106.7800n -0.000304 106.7900n -0.000287
+ 106.8000n -0.000271 106.8100n -0.000255 106.8200n -0.000239 106.8300n -0.000223 106.8400n -0.000208 106.8500n -0.000194 106.8600n -0.000179 106.8700n -0.000166 106.8800n -0.000152 106.8900n -0.000139 106.9000n -0.000127 106.9100n -0.000115 106.9200n -0.000103 106.9300n -0.000092 106.9400n -0.000082
+ 106.9500n -0.000071 106.9600n -0.000062 106.9700n -0.000053 106.9800n -0.000044 106.9900n -0.000036 107.0000n -0.000028 107.0100n -0.000021 107.0200n -0.000014 107.0300n -0.000008 107.0400n -0.000003 107.0500n 0.000002 107.0600n 0.000007 107.0700n 0.000011 107.0800n 0.000014 107.0900n 0.000017
+ 107.1000n 0.000020 107.1100n 0.000022 107.1200n 0.000023 107.1300n 0.000024 107.1400n 0.000024 107.1500n 0.000024 107.1600n 0.000023 107.1700n 0.000022 107.1800n 0.000020 107.1900n 0.000018 107.2000n 0.000015 107.2100n 0.000011 107.2200n 0.000008 107.2300n 0.000003 107.2400n -0.000001
+ 107.2500n -0.000007 107.2600n -0.000012 107.2700n -0.000018 107.2800n -0.000025 107.2900n -0.000032 107.3000n -0.000040 107.3100n -0.000047 107.3200n -0.000056 107.3300n -0.000064 107.3400n -0.000074 107.3500n -0.000083 107.3600n -0.000093 107.3700n -0.000103 107.3800n -0.000114 107.3900n -0.000125
+ 107.4000n -0.000136 107.4100n -0.000147 107.4200n -0.000159 107.4300n -0.000171 107.4400n -0.000184 107.4500n -0.000196 107.4600n -0.000209 107.4700n -0.000222 107.4800n -0.000235 107.4900n -0.000249 107.5000n -0.000263 107.5100n -0.000276 107.5200n -0.000290 107.5300n -0.000305 107.5400n -0.000319
+ 107.5500n -0.000333 107.5600n -0.000348 107.5700n -0.000362 107.5800n -0.000377 107.5900n -0.000391 107.6000n -0.000406 107.6100n -0.000421 107.6200n -0.000435 107.6300n -0.000450 107.6400n -0.000464 107.6500n -0.000479 107.6600n -0.000493 107.6700n -0.000508 107.6800n -0.000522 107.6900n -0.000536
+ 107.7000n -0.000550 107.7100n -0.000564 107.7200n -0.000578 107.7300n -0.000591 107.7400n -0.000604 107.7500n -0.000617 107.7600n -0.000630 107.7700n -0.000643 107.7800n -0.000655 107.7900n -0.000667 107.8000n -0.000679 107.8100n -0.000690 107.8200n -0.000701 107.8300n -0.000712 107.8400n -0.000722
+ 107.8500n -0.000733 107.8600n -0.000742 107.8700n -0.000752 107.8800n -0.000760 107.8900n -0.000769 107.9000n -0.000777 107.9100n -0.000785 107.9200n -0.000792 107.9300n -0.000799 107.9400n -0.000805 107.9500n -0.000811 107.9600n -0.000816 107.9700n -0.000821 107.9800n -0.000825 107.9900n -0.000829
+ 108.0000n -0.000832 108.0100n -0.000835 108.0200n -0.000837 108.0300n -0.000839 108.0400n -0.000840 108.0500n -0.000840 108.0600n -0.000840 108.0700n -0.000840 108.0800n -0.000839 108.0900n -0.000837 108.1000n -0.000835 108.1100n -0.000832 108.1200n -0.000829 108.1300n -0.000825 108.1400n -0.000820
+ 108.1500n -0.000815 108.1600n -0.000809 108.1700n -0.000803 108.1800n -0.000796 108.1900n -0.000789 108.2000n -0.000781 108.2100n -0.000772 108.2200n -0.000763 108.2300n -0.000753 108.2400n -0.000743 108.2500n -0.000732 108.2600n -0.000720 108.2700n -0.000708 108.2800n -0.000696 108.2900n -0.000683
+ 108.3000n -0.000669 108.3100n -0.000655 108.3200n -0.000640 108.3300n -0.000625 108.3400n -0.000609 108.3500n -0.000593 108.3600n -0.000577 108.3700n -0.000560 108.3800n -0.000542 108.3900n -0.000524 108.4000n -0.000505 108.4100n -0.000487 108.4200n -0.000467 108.4300n -0.000447 108.4400n -0.000427
+ 108.4500n -0.000407 108.4600n -0.000386 108.4700n -0.000365 108.4800n -0.000343 108.4900n -0.000321 108.5000n -0.000299 108.5100n -0.000276 108.5200n -0.000254 108.5300n -0.000231 108.5400n -0.000207 108.5500n -0.000184 108.5600n -0.000160 108.5700n -0.000136 108.5800n -0.000112 108.5900n -0.000088
+ 108.6000n -0.000063 108.6100n -0.000039 108.6200n -0.000014 108.6300n 0.000011 108.6400n 0.000036 108.6500n 0.000061 108.6600n 0.000086 108.6700n 0.000111 108.6800n 0.000136 108.6900n 0.000161 108.7000n 0.000186 108.7100n 0.000211 108.7200n 0.000235 108.7300n 0.000260 108.7400n 0.000285
+ 108.7500n 0.000309 108.7600n 0.000334 108.7700n 0.000358 108.7800n 0.000382 108.7900n 0.000406 108.8000n 0.000430 108.8100n 0.000453 108.8200n 0.000476 108.8300n 0.000499 108.8400n 0.000522 108.8500n 0.000544 108.8600n 0.000566 108.8700n 0.000588 108.8800n 0.000610 108.8900n 0.000631
+ 108.9000n 0.000651 108.9100n 0.000672 108.9200n 0.000691 108.9300n 0.000711 108.9400n 0.000730 108.9500n 0.000748 108.9600n 0.000766 108.9700n 0.000784 108.9800n 0.000801 108.9900n 0.000818 109.0000n 0.000834 109.0100n 0.000849 109.0200n 0.000864 109.0300n 0.000879 109.0400n 0.000892
+ 109.0500n 0.000906 109.0600n 0.000918 109.0700n 0.000931 109.0800n 0.000942 109.0900n 0.000953 109.1000n 0.000963 109.1100n 0.000973 109.1200n 0.000982 109.1300n 0.000990 109.1400n 0.000998 109.1500n 0.001005 109.1600n 0.001011 109.1700n 0.001017 109.1800n 0.001022 109.1900n 0.001026
+ 109.2000n 0.001030 109.2100n 0.001033 109.2200n 0.001035 109.2300n 0.001037 109.2400n 0.001038 109.2500n 0.001038 109.2600n 0.001038 109.2700n 0.001037 109.2800n 0.001035 109.2900n 0.001033 109.3000n 0.001029 109.3100n 0.001026 109.3200n 0.001021 109.3300n 0.001016 109.3400n 0.001010
+ 109.3500n 0.001004 109.3600n 0.000997 109.3700n 0.000989 109.3800n 0.000980 109.3900n 0.000971 109.4000n 0.000962 109.4100n 0.000951 109.4200n 0.000941 109.4300n 0.000929 109.4400n 0.000917 109.4500n 0.000904 109.4600n 0.000891 109.4700n 0.000877 109.4800n 0.000863 109.4900n 0.000848
+ 109.5000n 0.000833 109.5100n 0.000817 109.5200n 0.000800 109.5300n 0.000784 109.5400n 0.000766 109.5500n 0.000749 109.5600n 0.000730 109.5700n 0.000712 109.5800n 0.000693 109.5900n 0.000673 109.6000n 0.000653 109.6100n 0.000633 109.6200n 0.000613 109.6300n 0.000592 109.6400n 0.000571
+ 109.6500n 0.000550 109.6600n 0.000528 109.6700n 0.000506 109.6800n 0.000484 109.6900n 0.000462 109.7000n 0.000439 109.7100n 0.000417 109.7200n 0.000394 109.7300n 0.000371 109.7400n 0.000348 109.7500n 0.000325 109.7600n 0.000301 109.7700n 0.000278 109.7800n 0.000255 109.7900n 0.000232
+ 109.8000n 0.000208 109.8100n 0.000185 109.8200n 0.000162 109.8300n 0.000139 109.8400n 0.000116 109.8500n 0.000093 109.8600n 0.000070 109.8700n 0.000048 109.8800n 0.000025 109.8900n 0.000003 109.9000n -0.000019 109.9100n -0.000041 109.9200n -0.000062 109.9300n -0.000084 109.9400n -0.000104
+ 109.9500n -0.000125 109.9600n -0.000145 109.9700n -0.000165 109.9800n -0.000185 109.9900n -0.000204 110.0000n -0.000223 110.0100n -0.000241 110.0200n -0.000259 110.0300n -0.000276 110.0400n -0.000293 110.0500n -0.000310 110.0600n -0.000325 110.0700n -0.000341 110.0800n -0.000356 110.0900n -0.000370
+ 110.1000n -0.000384 110.1100n -0.000397 110.1200n -0.000409 110.1300n -0.000421 110.1400n -0.000432 110.1500n -0.000443 110.1600n -0.000453 110.1700n -0.000462 110.1800n -0.000471 110.1900n -0.000479 110.2000n -0.000486 110.2100n -0.000493 110.2200n -0.000499 110.2300n -0.000504 110.2400n -0.000508
+ 110.2500n -0.000512 110.2600n -0.000515 110.2700n -0.000517 110.2800n -0.000519 110.2900n -0.000519 110.3000n -0.000519 110.3100n -0.000518 110.3200n -0.000517 110.3300n -0.000514 110.3400n -0.000511 110.3500n -0.000507 110.3600n -0.000503 110.3700n -0.000497 110.3800n -0.000491 110.3900n -0.000484
+ 110.4000n -0.000476 110.4100n -0.000468 110.4200n -0.000458 110.4300n -0.000448 110.4400n -0.000438 110.4500n -0.000426 110.4600n -0.000414 110.4700n -0.000401 110.4800n -0.000387 110.4900n -0.000373 110.5000n -0.000357 110.5100n -0.000342 110.5200n -0.000325 110.5300n -0.000308 110.5400n -0.000290
+ 110.5500n -0.000271 110.5600n -0.000252 110.5700n -0.000232 110.5800n -0.000212 110.5900n -0.000191 110.6000n -0.000169 110.6100n -0.000147 110.6200n -0.000124 110.6300n -0.000100 110.6400n -0.000076 110.6500n -0.000052 110.6600n -0.000027 110.6700n -0.000001 110.6800n 0.000024 110.6900n 0.000051
+ 110.7000n 0.000078 110.7100n 0.000105 110.7200n 0.000132 110.7300n 0.000160 110.7400n 0.000189 110.7500n 0.000217 110.7600n 0.000246 110.7700n 0.000276 110.7800n 0.000305 110.7900n 0.000335 110.8000n 0.000365 110.8100n 0.000395 110.8200n 0.000426 110.8300n 0.000456 110.8400n 0.000487
+ 110.8500n 0.000518 110.8600n 0.000549 110.8700n 0.000580 110.8800n 0.000611 110.8900n 0.000642 110.9000n 0.000673 110.9100n 0.000704 110.9200n 0.000734 110.9300n 0.000765 110.9400n 0.000796 110.9500n 0.000827 110.9600n 0.000857 110.9700n 0.000887 110.9800n 0.000918 110.9900n 0.000947
+ 111.0000n 0.000977 111.0100n 0.001006 111.0200n 0.001035 111.0300n 0.001064 111.0400n 0.001093 111.0500n 0.001121 111.0600n 0.001148 111.0700n 0.001176 111.0800n 0.001202 111.0900n 0.001229 111.1000n 0.001255 111.1100n 0.001280 111.1200n 0.001305 111.1300n 0.001329 111.1400n 0.001353
+ 111.1500n 0.001376 111.1600n 0.001399 111.1700n 0.001421 111.1800n 0.001442 111.1900n 0.001463 111.2000n 0.001483 111.2100n 0.001502 111.2200n 0.001521 111.2300n 0.001539 111.2400n 0.001556 111.2500n 0.001572 111.2600n 0.001588 111.2700n 0.001602 111.2800n 0.001616 111.2900n 0.001629
+ 111.3000n 0.001642 111.3100n 0.001653 111.3200n 0.001664 111.3300n 0.001673 111.3400n 0.001682 111.3500n 0.001690 111.3600n 0.001697 111.3700n 0.001703 111.3800n 0.001708 111.3900n 0.001713 111.4000n 0.001716 111.4100n 0.001718 111.4200n 0.001720 111.4300n 0.001720 111.4400n 0.001719
+ 111.4500n 0.001718 111.4600n 0.001715 111.4700n 0.001712 111.4800n 0.001707 111.4900n 0.001702 111.5000n 0.001695 111.5100n 0.001688 111.5200n 0.001679 111.5300n 0.001670 111.5400n 0.001660 111.5500n 0.001648 111.5600n 0.001636 111.5700n 0.001623 111.5800n 0.001608 111.5900n 0.001593
+ 111.6000n 0.001577 111.6100n 0.001560 111.6200n 0.001541 111.6300n 0.001522 111.6400n 0.001502 111.6500n 0.001481 111.6600n 0.001460 111.6700n 0.001437 111.6800n 0.001413 111.6900n 0.001389 111.7000n 0.001363 111.7100n 0.001337 111.7200n 0.001310 111.7300n 0.001282 111.7400n 0.001254
+ 111.7500n 0.001224 111.7600n 0.001194 111.7700n 0.001163 111.7800n 0.001131 111.7900n 0.001098 111.8000n 0.001065 111.8100n 0.001031 111.8200n 0.000997 111.8300n 0.000961 111.8400n 0.000926 111.8500n 0.000889 111.8600n 0.000852 111.8700n 0.000814 111.8800n 0.000776 111.8900n 0.000737
+ 111.9000n 0.000698 111.9100n 0.000658 111.9200n 0.000618 111.9300n 0.000578 111.9400n 0.000537 111.9500n 0.000495 111.9600n 0.000453 111.9700n 0.000411 111.9800n 0.000369 111.9900n 0.000326 112.0000n 0.000283 112.0100n 0.000240 112.0200n 0.000196 112.0300n 0.000153 112.0400n 0.000109
+ 112.0500n 0.000065 112.0600n 0.000021 112.0700n -0.000023 112.0800n -0.000067 112.0900n -0.000111 112.1000n -0.000156 112.1100n -0.000200 112.1200n -0.000244 112.1300n -0.000288 112.1400n -0.000332 112.1500n -0.000376 112.1600n -0.000419 112.1700n -0.000463 112.1800n -0.000506 112.1900n -0.000549
+ 112.2000n -0.000592 112.2100n -0.000634 112.2200n -0.000677 112.2300n -0.000718 112.2400n -0.000760 112.2500n -0.000801 112.2600n -0.000842 112.2700n -0.000882 112.2800n -0.000922 112.2900n -0.000961 112.3000n -0.001000 112.3100n -0.001038 112.3200n -0.001076 112.3300n -0.001113 112.3400n -0.001149
+ 112.3500n -0.001185 112.3600n -0.001220 112.3700n -0.001255 112.3800n -0.001289 112.3900n -0.001322 112.4000n -0.001354 112.4100n -0.001386 112.4200n -0.001417 112.4300n -0.001447 112.4400n -0.001477 112.4500n -0.001505 112.4600n -0.001533 112.4700n -0.001560 112.4800n -0.001586 112.4900n -0.001611
+ 112.5000n -0.001636 112.5100n -0.001659 112.5200n -0.001682 112.5300n -0.001703 112.5400n -0.001724 112.5500n -0.001743 112.5600n -0.001762 112.5700n -0.001780 112.5800n -0.001797 112.5900n -0.001812 112.6000n -0.001827 112.6100n -0.001841 112.6200n -0.001854 112.6300n -0.001866 112.6400n -0.001876
+ 112.6500n -0.001886 112.6600n -0.001895 112.6700n -0.001903 112.6800n -0.001909 112.6900n -0.001915 112.7000n -0.001919 112.7100n -0.001923 112.7200n -0.001925 112.7300n -0.001927 112.7400n -0.001927 112.7500n -0.001927 112.7600n -0.001925 112.7700n -0.001923 112.7800n -0.001919 112.7900n -0.001914
+ 112.8000n -0.001909 112.8100n -0.001902 112.8200n -0.001894 112.8300n -0.001886 112.8400n -0.001876 112.8500n -0.001866 112.8600n -0.001854 112.8700n -0.001841 112.8800n -0.001828 112.8900n -0.001814 112.9000n -0.001798 112.9100n -0.001782 112.9200n -0.001765 112.9300n -0.001747 112.9400n -0.001728
+ 112.9500n -0.001709 112.9600n -0.001688 112.9700n -0.001667 112.9800n -0.001645 112.9900n -0.001622 113.0000n -0.001598 113.0100n -0.001574 113.0200n -0.001549 113.0300n -0.001523 113.0400n -0.001496 113.0500n -0.001469 113.0600n -0.001441 113.0700n -0.001413 113.0800n -0.001383 113.0900n -0.001354
+ 113.1000n -0.001323 113.1100n -0.001293 113.1200n -0.001261 113.1300n -0.001229 113.1400n -0.001197 113.1500n -0.001164 113.1600n -0.001131 113.1700n -0.001097 113.1800n -0.001063 113.1900n -0.001028 113.2000n -0.000994 113.2100n -0.000958 113.2200n -0.000923 113.2300n -0.000887 113.2400n -0.000851
+ 113.2500n -0.000815 113.2600n -0.000778 113.2700n -0.000742 113.2800n -0.000705 113.2900n -0.000668 113.3000n -0.000631 113.3100n -0.000594 113.3200n -0.000557 113.3300n -0.000519 113.3400n -0.000482 113.3500n -0.000445 113.3600n -0.000408 113.3700n -0.000371 113.3800n -0.000333 113.3900n -0.000297
+ 113.4000n -0.000260 113.4100n -0.000223 113.4200n -0.000186 113.4300n -0.000150 113.4400n -0.000114 113.4500n -0.000078 113.4600n -0.000042 113.4700n -0.000007 113.4800n 0.000028 113.4900n 0.000063 113.5000n 0.000097 113.5100n 0.000131 113.5200n 0.000165 113.5300n 0.000198 113.5400n 0.000231
+ 113.5500n 0.000263 113.5600n 0.000295 113.5700n 0.000327 113.5800n 0.000358 113.5900n 0.000388 113.6000n 0.000418 113.6100n 0.000448 113.6200n 0.000477 113.6300n 0.000505 113.6400n 0.000533 113.6500n 0.000560 113.6600n 0.000586 113.6700n 0.000612 113.6800n 0.000637 113.6900n 0.000662
+ 113.7000n 0.000686 113.7100n 0.000709 113.7200n 0.000732 113.7300n 0.000753 113.7400n 0.000775 113.7500n 0.000795 113.7600n 0.000815 113.7700n 0.000834 113.7800n 0.000852 113.7900n 0.000870 113.8000n 0.000886 113.8100n 0.000902 113.8200n 0.000918 113.8300n 0.000932 113.8400n 0.000946
+ 113.8500n 0.000959 113.8600n 0.000971 113.8700n 0.000982 113.8800n 0.000993 113.8900n 0.001003 113.9000n 0.001012 113.9100n 0.001020 113.9200n 0.001028 113.9300n 0.001035 113.9400n 0.001041 113.9500n 0.001046 113.9600n 0.001050 113.9700n 0.001054 113.9800n 0.001057 113.9900n 0.001059
+ 114.0000n 0.001061 114.0100n 0.001061 114.0200n 0.001061 114.0300n 0.001060 114.0400n 0.001059 114.0500n 0.001057 114.0600n 0.001054 114.0700n 0.001050 114.0800n 0.001046 114.0900n 0.001041 114.1000n 0.001035 114.1100n 0.001029 114.1200n 0.001022 114.1300n 0.001014 114.1400n 0.001006
+ 114.1500n 0.000997 114.1600n 0.000987 114.1700n 0.000977 114.1800n 0.000967 114.1900n 0.000956 114.2000n 0.000944 114.2100n 0.000932 114.2200n 0.000919 114.2300n 0.000905 114.2400n 0.000892 114.2500n 0.000877 114.2600n 0.000863 114.2700n 0.000847 114.2800n 0.000832 114.2900n 0.000816
+ 114.3000n 0.000799 114.3100n 0.000783 114.3200n 0.000765 114.3300n 0.000748 114.3400n 0.000730 114.3500n 0.000712 114.3600n 0.000694 114.3700n 0.000675 114.3800n 0.000656 114.3900n 0.000637 114.4000n 0.000617 114.4100n 0.000598 114.4200n 0.000578 114.4300n 0.000558 114.4400n 0.000538
+ 114.4500n 0.000518 114.4600n 0.000497 114.4700n 0.000477 114.4800n 0.000456 114.4900n 0.000436 114.5000n 0.000415 114.5100n 0.000394 114.5200n 0.000374 114.5300n 0.000353 114.5400n 0.000333 114.5500n 0.000312 114.5600n 0.000291 114.5700n 0.000271 114.5800n 0.000251 114.5900n 0.000230
+ 114.6000n 0.000210 114.6100n 0.000190 114.6200n 0.000170 114.6300n 0.000151 114.6400n 0.000131 114.6500n 0.000112 114.6600n 0.000093 114.6700n 0.000074 114.6800n 0.000056 114.6900n 0.000038 114.7000n 0.000020 114.7100n 0.000002 114.7200n -0.000016 114.7300n -0.000033 114.7400n -0.000049
+ 114.7500n -0.000066 114.7600n -0.000082 114.7700n -0.000098 114.7800n -0.000113 114.7900n -0.000128 114.8000n -0.000142 114.8100n -0.000157 114.8200n -0.000170 114.8300n -0.000184 114.8400n -0.000197 114.8500n -0.000209 114.8600n -0.000221 114.8700n -0.000233 114.8800n -0.000244 114.8900n -0.000254
+ 114.9000n -0.000264 114.9100n -0.000274 114.9200n -0.000283 114.9300n -0.000292 114.9400n -0.000300 114.9500n -0.000308 114.9600n -0.000315 114.9700n -0.000322 114.9800n -0.000328 114.9900n -0.000334 115.0000n -0.000339 115.0100n -0.000343 115.0200n -0.000348 115.0300n -0.000351 115.0400n -0.000354
+ 115.0500n -0.000357 115.0600n -0.000359 115.0700n -0.000361 115.0800n -0.000362 115.0900n -0.000362 115.1000n -0.000362 115.1100n -0.000362 115.1200n -0.000361 115.1300n -0.000359 115.1400n -0.000358 115.1500n -0.000355 115.1600n -0.000352 115.1700n -0.000349 115.1800n -0.000345 115.1900n -0.000341
+ 115.2000n -0.000336 115.2100n -0.000331 115.2200n -0.000325 115.2300n -0.000319 115.2400n -0.000312 115.2500n -0.000305 115.2600n -0.000298 115.2700n -0.000290 115.2800n -0.000282 115.2900n -0.000273 115.3000n -0.000264 115.3100n -0.000255 115.3200n -0.000245 115.3300n -0.000235 115.3400n -0.000225
+ 115.3500n -0.000214 115.3600n -0.000203 115.3700n -0.000191 115.3800n -0.000180 115.3900n -0.000168 115.4000n -0.000156 115.4100n -0.000143 115.4200n -0.000130 115.4300n -0.000117 115.4400n -0.000104 115.4500n -0.000090 115.4600n -0.000077 115.4700n -0.000063 115.4800n -0.000049 115.4900n -0.000035
+ 115.5000n -0.000020 115.5100n -0.000006 115.5200n 0.000009 115.5300n 0.000024 115.5400n 0.000039 115.5500n 0.000054 115.5600n 0.000069 115.5700n 0.000084 115.5800n 0.000099 115.5900n 0.000114 115.6000n 0.000130 115.6100n 0.000145 115.6200n 0.000160 115.6300n 0.000176 115.6400n 0.000191
+ 115.6500n 0.000206 115.6600n 0.000222 115.6700n 0.000237 115.6800n 0.000252 115.6900n 0.000267 115.7000n 0.000282 115.7100n 0.000297 115.7200n 0.000312 115.7300n 0.000326 115.7400n 0.000341 115.7500n 0.000355 115.7600n 0.000370 115.7700n 0.000384 115.7800n 0.000398 115.7900n 0.000412
+ 115.8000n 0.000425 115.8100n 0.000438 115.8200n 0.000452 115.8300n 0.000465 115.8400n 0.000477 115.8500n 0.000490 115.8600n 0.000502 115.8700n 0.000514 115.8800n 0.000526 115.8900n 0.000537 115.9000n 0.000549 115.9100n 0.000560 115.9200n 0.000570 115.9300n 0.000581 115.9400n 0.000591
+ 115.9500n 0.000600 115.9600n 0.000610 115.9700n 0.000619 115.9800n 0.000628 115.9900n 0.000637 116.0000n 0.000645 116.0100n 0.000653 116.0200n 0.000660 116.0300n 0.000667 116.0400n 0.000674 116.0500n 0.000681 116.0600n 0.000687 116.0700n 0.000693 116.0800n 0.000698 116.0900n 0.000704
+ 116.1000n 0.000708 116.1100n 0.000713 116.1200n 0.000717 116.1300n 0.000721 116.1400n 0.000724 116.1500n 0.000727 116.1600n 0.000730 116.1700n 0.000732 116.1800n 0.000734 116.1900n 0.000736 116.2000n 0.000738 116.2100n 0.000739 116.2200n 0.000739 116.2300n 0.000740 116.2400n 0.000740
+ 116.2500n 0.000739 116.2600n 0.000739 116.2700n 0.000738 116.2800n 0.000736 116.2900n 0.000735 116.3000n 0.000733 116.3100n 0.000731 116.3200n 0.000728 116.3300n 0.000725 116.3400n 0.000722 116.3500n 0.000719 116.3600n 0.000715 116.3700n 0.000711 116.3800n 0.000707 116.3900n 0.000702
+ 116.4000n 0.000698 116.4100n 0.000693 116.4200n 0.000687 116.4300n 0.000682 116.4400n 0.000676 116.4500n 0.000670 116.4600n 0.000664 116.4700n 0.000658 116.4800n 0.000651 116.4900n 0.000645 116.5000n 0.000638 116.5100n 0.000631 116.5200n 0.000623 116.5300n 0.000616 116.5400n 0.000608
+ 116.5500n 0.000601 116.5600n 0.000593 116.5700n 0.000585 116.5800n 0.000577 116.5900n 0.000568 116.6000n 0.000560 116.6100n 0.000552 116.6200n 0.000543 116.6300n 0.000535 116.6400n 0.000526 116.6500n 0.000517 116.6600n 0.000508 116.6700n 0.000499 116.6800n 0.000491 116.6900n 0.000482
+ 116.7000n 0.000473 116.7100n 0.000464 116.7200n 0.000455 116.7300n 0.000446 116.7400n 0.000437 116.7500n 0.000428 116.7600n 0.000419 116.7700n 0.000410 116.7800n 0.000401 116.7900n 0.000392 116.8000n 0.000383 116.8100n 0.000374 116.8200n 0.000366 116.8300n 0.000357 116.8400n 0.000348
+ 116.8500n 0.000340 116.8600n 0.000331 116.8700n 0.000323 116.8800n 0.000315 116.8900n 0.000307 116.9000n 0.000299 116.9100n 0.000291 116.9200n 0.000283 116.9300n 0.000275 116.9400n 0.000268 116.9500n 0.000260 116.9600n 0.000253 116.9700n 0.000246 116.9800n 0.000239 116.9900n 0.000232
+ 117.0000n 0.000225 117.0100n 0.000218 117.0200n 0.000212 117.0300n 0.000206 117.0400n 0.000200 117.0500n 0.000194 117.0600n 0.000188 117.0700n 0.000182 117.0800n 0.000177 117.0900n 0.000171 117.1000n 0.000166 117.1100n 0.000161 117.1200n 0.000157 117.1300n 0.000152 117.1400n 0.000147
+ 117.1500n 0.000143 117.1600n 0.000139 117.1700n 0.000135 117.1800n 0.000131 117.1900n 0.000128 117.2000n 0.000124 117.2100n 0.000121 117.2200n 0.000118 117.2300n 0.000115 117.2400n 0.000113 117.2500n 0.000110 117.2600n 0.000108 117.2700n 0.000105 117.2800n 0.000103 117.2900n 0.000102
+ 117.3000n 0.000100 117.3100n 0.000098 117.3200n 0.000097 117.3300n 0.000095 117.3400n 0.000094 117.3500n 0.000093 117.3600n 0.000092 117.3700n 0.000092 117.3800n 0.000091 117.3900n 0.000091 117.4000n 0.000090 117.4100n 0.000090 117.4200n 0.000090 117.4300n 0.000090 117.4400n 0.000090
+ 117.4500n 0.000090 117.4600n 0.000091 117.4700n 0.000091 117.4800n 0.000092 117.4900n 0.000092 117.5000n 0.000093 117.5100n 0.000094 117.5200n 0.000095 117.5300n 0.000096 117.5400n 0.000097 117.5500n 0.000098 117.5600n 0.000099 117.5700n 0.000100 117.5800n 0.000101 117.5900n 0.000102
+ 117.6000n 0.000104 117.6100n 0.000105 117.6200n 0.000106 117.6300n 0.000108 117.6400n 0.000109 117.6500n 0.000110 117.6600n 0.000112 117.6700n 0.000113 117.6800n 0.000115 117.6900n 0.000116 117.7000n 0.000117 117.7100n 0.000119 117.7200n 0.000120 117.7300n 0.000122 117.7400n 0.000123
+ 117.7500n 0.000124 117.7600n 0.000125 117.7700n 0.000127 117.7800n 0.000128 117.7900n 0.000129 117.8000n 0.000130 117.8100n 0.000131 117.8200n 0.000132 117.8300n 0.000133 117.8400n 0.000134 117.8500n 0.000135 117.8600n 0.000135 117.8700n 0.000136 117.8800n 0.000137 117.8900n 0.000137
+ 117.9000n 0.000137 117.9100n 0.000138 117.9200n 0.000138 117.9300n 0.000138 117.9400n 0.000138 117.9500n 0.000138 117.9600n 0.000138 117.9700n 0.000138 117.9800n 0.000138 117.9900n 0.000138 118.0000n 0.000137 118.0100n 0.000137 118.0200n 0.000136 118.0300n 0.000136 118.0400n 0.000135
+ 118.0500n 0.000134 118.0600n 0.000133 118.0700n 0.000132 118.0800n 0.000131 118.0900n 0.000130 118.1000n 0.000129 118.1100n 0.000127 118.1200n 0.000126 118.1300n 0.000124 118.1400n 0.000123 118.1500n 0.000121 118.1600n 0.000119 118.1700n 0.000118 118.1800n 0.000116 118.1900n 0.000114
+ 118.2000n 0.000112 118.2100n 0.000110 118.2200n 0.000108 118.2300n 0.000105 118.2400n 0.000103 118.2500n 0.000101 118.2600n 0.000099 118.2700n 0.000096 118.2800n 0.000094 118.2900n 0.000092 118.3000n 0.000089 118.3100n 0.000087 118.3200n 0.000084 118.3300n 0.000082 118.3400n 0.000079
+ 118.3500n 0.000077 118.3600n 0.000074 118.3700n 0.000072 118.3800n 0.000070 118.3900n 0.000067 118.4000n 0.000065 118.4100n 0.000062 118.4200n 0.000060 118.4300n 0.000058 118.4400n 0.000055 118.4500n 0.000053 118.4600n 0.000051 118.4700n 0.000049 118.4800n 0.000047 118.4900n 0.000045
+ 118.5000n 0.000043 118.5100n 0.000042 118.5200n 0.000040 118.5300n 0.000038 118.5400n 0.000037 118.5500n 0.000036 118.5600n 0.000035 118.5700n 0.000033 118.5800n 0.000033 118.5900n 0.000032 118.6000n 0.000031 118.6100n 0.000031 118.6200n 0.000030 118.6300n 0.000030 118.6400n 0.000030
+ 118.6500n 0.000030 118.6600n 0.000030 118.6700n 0.000031 118.6800n 0.000032 118.6900n 0.000033 118.7000n 0.000034 118.7100n 0.000035 118.7200n 0.000036 118.7300n 0.000038 118.7400n 0.000040 118.7500n 0.000042 118.7600n 0.000045 118.7700n 0.000047 118.7800n 0.000050 118.7900n 0.000053
+ 118.8000n 0.000057 118.8100n 0.000060 118.8200n 0.000064 118.8300n 0.000068 118.8400n 0.000073 118.8500n 0.000078 118.8600n 0.000083 118.8700n 0.000088 118.8800n 0.000093 118.8900n 0.000099 118.9000n 0.000105 118.9100n 0.000112 118.9200n 0.000118 118.9300n 0.000125 118.9400n 0.000132
+ 118.9500n 0.000140 118.9600n 0.000148 118.9700n 0.000156 118.9800n 0.000165 118.9900n 0.000173 119.0000n 0.000182 119.0100n 0.000192 119.0200n 0.000201 119.0300n 0.000211 119.0400n 0.000222 119.0500n 0.000232 119.0600n 0.000243 119.0700n 0.000254 119.0800n 0.000266 119.0900n 0.000278
+ 119.1000n 0.000290 119.1100n 0.000302 119.1200n 0.000315 119.1300n 0.000328 119.1400n 0.000342 119.1500n 0.000355 119.1600n 0.000369 119.1700n 0.000383 119.1800n 0.000398 119.1900n 0.000413 119.2000n 0.000428 119.2100n 0.000443 119.2200n 0.000459 119.2300n 0.000475 119.2400n 0.000491
+ 119.2500n 0.000507 119.2600n 0.000524 119.2700n 0.000541 119.2800n 0.000558 119.2900n 0.000576 119.3000n 0.000594 119.3100n 0.000612 119.3200n 0.000630 119.3300n 0.000648 119.3400n 0.000667 119.3500n 0.000686 119.3600n 0.000705 119.3700n 0.000724 119.3800n 0.000744 119.3900n 0.000763
+ 119.4000n 0.000783 119.4100n 0.000803 119.4200n 0.000824 119.4300n 0.000844 119.4400n 0.000865 119.4500n 0.000885 119.4600n 0.000906 119.4700n 0.000927 119.4800n 0.000948 119.4900n 0.000970 119.5000n 0.000991 119.5100n 0.001012 119.5200n 0.001034 119.5300n 0.001056 119.5400n 0.001078
+ 119.5500n 0.001099 119.5600n 0.001121 119.5700n 0.001143 119.5800n 0.001165 119.5900n 0.001187 119.6000n 0.001210 119.6100n 0.001232 119.6200n 0.001254 119.6300n 0.001276 119.6400n 0.001298 119.6500n 0.001321 119.6600n 0.001343 119.6700n 0.001365 119.6800n 0.001387 119.6900n 0.001409
+ 119.7000n 0.001431 119.7100n 0.001453 119.7200n 0.001475 119.7300n 0.001497 119.7400n 0.001519 119.7500n 0.001541 119.7600n 0.001562 119.7700n 0.001584 119.7800n 0.001605 119.7900n 0.001626 119.8000n 0.001648 119.8100n 0.001669 119.8200n 0.001689 119.8300n 0.001710 119.8400n 0.001731
+ 119.8500n 0.001751 119.8600n 0.001771 119.8700n 0.001791 119.8800n 0.001811 119.8900n 0.001831 119.9000n 0.001850 119.9100n 0.001869 119.9200n 0.001888 119.9300n 0.001907 119.9400n 0.001926 119.9500n 0.001944 119.9600n 0.001962 119.9700n 0.001980 119.9800n 0.001997 119.9900n 0.002015
+ 120.0000n 0.002032 120.0100n 0.002048 120.0200n 0.002065 120.0300n 0.002081 120.0400n 0.002097 120.0500n 0.002112 120.0600n 0.002127 120.0700n 0.002142 120.0800n 0.002157 120.0900n 0.002171 120.1000n 0.002185 120.1100n 0.002199 120.1200n 0.002212 120.1300n 0.002225 120.1400n 0.002237
+ 120.1500n 0.002249 120.1600n 0.002261 120.1700n 0.002273 120.1800n 0.002284 120.1900n 0.002294 120.2000n 0.002305 120.2100n 0.002315 120.2200n 0.002324 120.2300n 0.002334 120.2400n 0.002342 120.2500n 0.002351 120.2600n 0.002359 120.2700n 0.002367 120.2800n 0.002374 120.2900n 0.002381
+ 120.3000n 0.002387 120.3100n 0.002393 120.3200n 0.002399 120.3300n 0.002404 120.3400n 0.002409 120.3500n 0.002413 120.3600n 0.002417 120.3700n 0.002421 120.3800n 0.002424 120.3900n 0.002427 120.4000n 0.002429 120.4100n 0.002431 120.4200n 0.002433 120.4300n 0.002434 120.4400n 0.002435
+ 120.4500n 0.002435 120.4600n 0.002435 120.4700n 0.002434 120.4800n 0.002433 120.4900n 0.002432 120.5000n 0.002430 120.5100n 0.002428 120.5200n 0.002426 120.5300n 0.002423 120.5400n 0.002419 120.5500n 0.002415 120.5600n 0.002411 120.5700n 0.002406 120.5800n 0.002401 120.5900n 0.002396
+ 120.6000n 0.002390 120.6100n 0.002384 120.6200n 0.002377 120.6300n 0.002370 120.6400n 0.002363 120.6500n 0.002355 120.6600n 0.002347 120.6700n 0.002338 120.6800n 0.002329 120.6900n 0.002320 120.7000n 0.002310 120.7100n 0.002300 120.7200n 0.002290 120.7300n 0.002279 120.7400n 0.002268
+ 120.7500n 0.002256 120.7600n 0.002244 120.7700n 0.002232 120.7800n 0.002219 120.7900n 0.002206 120.8000n 0.002193 120.8100n 0.002179 120.8200n 0.002165 120.8300n 0.002151 120.8400n 0.002136 120.8500n 0.002121 120.8600n 0.002106 120.8700n 0.002090 120.8800n 0.002074 120.8900n 0.002058
+ 120.9000n 0.002041 120.9100n 0.002024 120.9200n 0.002007 120.9300n 0.001989 120.9400n 0.001972 120.9500n 0.001953 120.9600n 0.001935 120.9700n 0.001916 120.9800n 0.001897 120.9900n 0.001878 121.0000n 0.001859 121.0100n 0.001839 121.0200n 0.001819 121.0300n 0.001798 121.0400n 0.001778
+ 121.0500n 0.001757 121.0600n 0.001736 121.0700n 0.001714 121.0800n 0.001693 121.0900n 0.001671 121.1000n 0.001649 121.1100n 0.001626 121.1200n 0.001604 121.1300n 0.001581 121.1400n 0.001558 121.1500n 0.001535 121.1600n 0.001512 121.1700n 0.001488 121.1800n 0.001464 121.1900n 0.001440
+ 121.2000n 0.001416 121.2100n 0.001392 121.2200n 0.001367 121.2300n 0.001343 121.2400n 0.001318 121.2500n 0.001293 121.2600n 0.001267 121.2700n 0.001242 121.2800n 0.001216 121.2900n 0.001191 121.3000n 0.001165 121.3100n 0.001139 121.3200n 0.001113 121.3300n 0.001087 121.3400n 0.001060
+ 121.3500n 0.001034 121.3600n 0.001007 121.3700n 0.000981 121.3800n 0.000954 121.3900n 0.000927 121.4000n 0.000900 121.4100n 0.000873 121.4200n 0.000846 121.4300n 0.000819 121.4400n 0.000791 121.4500n 0.000764 121.4600n 0.000736 121.4700n 0.000709 121.4800n 0.000681 121.4900n 0.000654
+ 121.5000n 0.000626 121.5100n 0.000598 121.5200n 0.000571 121.5300n 0.000543 121.5400n 0.000515 121.5500n 0.000487 121.5600n 0.000460 121.5700n 0.000432 121.5800n 0.000404 121.5900n 0.000376 121.6000n 0.000349 121.6100n 0.000321 121.6200n 0.000293 121.6300n 0.000266 121.6400n 0.000238
+ 121.6500n 0.000210 121.6600n 0.000183 121.6700n 0.000155 121.6800n 0.000128 121.6900n 0.000101 121.7000n 0.000073 121.7100n 0.000046 121.7200n 0.000019 121.7300n -0.000008 121.7400n -0.000035 121.7500n -0.000062 121.7600n -0.000088 121.7700n -0.000115 121.7800n -0.000141 121.7900n -0.000167
+ 121.8000n -0.000194 121.8100n -0.000220 121.8200n -0.000245 121.8300n -0.000271 121.8400n -0.000297 121.8500n -0.000322 121.8600n -0.000347 121.8700n -0.000372 121.8800n -0.000397 121.8900n -0.000421 121.9000n -0.000446 121.9100n -0.000470 121.9200n -0.000494 121.9300n -0.000517 121.9400n -0.000541
+ 121.9500n -0.000564 121.9600n -0.000587 121.9700n -0.000609 121.9800n -0.000632 121.9900n -0.000654 122.0000n -0.000676 122.0100n -0.000697 122.0200n -0.000719 122.0300n -0.000740 122.0400n -0.000760 122.0500n -0.000781 122.0600n -0.000801 122.0700n -0.000820 122.0800n -0.000840 122.0900n -0.000859
+ 122.1000n -0.000877 122.1100n -0.000896 122.1200n -0.000914 122.1300n -0.000931 122.1400n -0.000949 122.1500n -0.000965 122.1600n -0.000982 122.1700n -0.000998 122.1800n -0.001014 122.1900n -0.001029 122.2000n -0.001044 122.2100n -0.001058 122.2200n -0.001072 122.2300n -0.001086 122.2400n -0.001099
+ 122.2500n -0.001112 122.2600n -0.001124 122.2700n -0.001136 122.2800n -0.001148 122.2900n -0.001159 122.3000n -0.001169 122.3100n -0.001179 122.3200n -0.001189 122.3300n -0.001198 122.3400n -0.001207 122.3500n -0.001215 122.3600n -0.001223 122.3700n -0.001230 122.3800n -0.001237 122.3900n -0.001243
+ 122.4000n -0.001249 122.4100n -0.001254 122.4200n -0.001259 122.4300n -0.001263 122.4400n -0.001267 122.4500n -0.001270 122.4600n -0.001273 122.4700n -0.001275 122.4800n -0.001277 122.4900n -0.001278 122.5000n -0.001279 122.5100n -0.001279 122.5200n -0.001279 122.5300n -0.001278 122.5400n -0.001277
+ 122.5500n -0.001275 122.5600n -0.001273 122.5700n -0.001270 122.5800n -0.001267 122.5900n -0.001263 122.6000n -0.001259 122.6100n -0.001254 122.6200n -0.001249 122.6300n -0.001243 122.6400n -0.001237 122.6500n -0.001230 122.6600n -0.001223 122.6700n -0.001215 122.6800n -0.001207 122.6900n -0.001198
+ 122.7000n -0.001189 122.7100n -0.001179 122.7200n -0.001169 122.7300n -0.001158 122.7400n -0.001147 122.7500n -0.001136 122.7600n -0.001124 122.7700n -0.001112 122.7800n -0.001099 122.7900n -0.001086 122.8000n -0.001072 122.8100n -0.001058 122.8200n -0.001044 122.8300n -0.001029 122.8400n -0.001014
+ 122.8500n -0.000998 122.8600n -0.000982 122.8700n -0.000966 122.8800n -0.000949 122.8900n -0.000933 122.9000n -0.000915 122.9100n -0.000898 122.9200n -0.000880 122.9300n -0.000861 122.9400n -0.000843 122.9500n -0.000824 122.9600n -0.000805 122.9700n -0.000786 122.9800n -0.000766 122.9900n -0.000746
+ 123.0000n -0.000726 123.0100n -0.000706 123.0200n -0.000685 123.0300n -0.000664 123.0400n -0.000644 123.0500n -0.000622 123.0600n -0.000601 123.0700n -0.000580 123.0800n -0.000558 123.0900n -0.000537 123.1000n -0.000515 123.1100n -0.000493 123.1200n -0.000471 123.1300n -0.000449 123.1400n -0.000427
+ 123.1500n -0.000405 123.1600n -0.000383 123.1700n -0.000361 123.1800n -0.000338 123.1900n -0.000316 123.2000n -0.000294 123.2100n -0.000272 123.2200n -0.000250 123.2300n -0.000228 123.2400n -0.000206 123.2500n -0.000184 123.2600n -0.000162 123.2700n -0.000141 123.2800n -0.000119 123.2900n -0.000098
+ 123.3000n -0.000077 123.3100n -0.000056 123.3200n -0.000035 123.3300n -0.000014 123.3400n 0.000006 123.3500n 0.000027 123.3600n 0.000047 123.3700n 0.000066 123.3800n 0.000086 123.3900n 0.000105 123.4000n 0.000124 123.4100n 0.000143 123.4200n 0.000161 123.4300n 0.000179 123.4400n 0.000197
+ 123.4500n 0.000214 123.4600n 0.000231 123.4700n 0.000248 123.4800n 0.000264 123.4900n 0.000280 123.5000n 0.000296 123.5100n 0.000311 123.5200n 0.000325 123.5300n 0.000340 123.5400n 0.000353 123.5500n 0.000367 123.5600n 0.000380 123.5700n 0.000392 123.5800n 0.000404 123.5900n 0.000416
+ 123.6000n 0.000427 123.6100n 0.000437 123.6200n 0.000447 123.6300n 0.000457 123.6400n 0.000465 123.6500n 0.000474 123.6600n 0.000482 123.6700n 0.000489 123.6800n 0.000496 123.6900n 0.000502 123.7000n 0.000508 123.7100n 0.000513 123.7200n 0.000518 123.7300n 0.000522 123.7400n 0.000525
+ 123.7500n 0.000528 123.7600n 0.000530 123.7700n 0.000532 123.7800n 0.000533 123.7900n 0.000534 123.8000n 0.000534 123.8100n 0.000533 123.8200n 0.000532 123.8300n 0.000530 123.8400n 0.000528 123.8500n 0.000525 123.8600n 0.000522 123.8700n 0.000518 123.8800n 0.000513 123.8900n 0.000508
+ 123.9000n 0.000502 123.9100n 0.000496 123.9200n 0.000489 123.9300n 0.000481 123.9400n 0.000473 123.9500n 0.000465 123.9600n 0.000456 123.9700n 0.000446 123.9800n 0.000436 123.9900n 0.000425 124.0000n 0.000414 124.0100n 0.000402 124.0200n 0.000390 124.0300n 0.000377 124.0400n 0.000364
+ 124.0500n 0.000350 124.0600n 0.000336 124.0700n 0.000321 124.0800n 0.000306 124.0900n 0.000290 124.1000n 0.000274 124.1100n 0.000258 124.1200n 0.000241 124.1300n 0.000224 124.1400n 0.000206 124.1500n 0.000188 124.1600n 0.000169 124.1700n 0.000151 124.1800n 0.000132 124.1900n 0.000112
+ 124.2000n 0.000092 124.2100n 0.000072 124.2200n 0.000052 124.2300n 0.000031 124.2400n 0.000011 124.2500n -0.000011 124.2600n -0.000032 124.2700n -0.000054 124.2800n -0.000075 124.2900n -0.000097 124.3000n -0.000119 124.3100n -0.000142 124.3200n -0.000164 124.3300n -0.000187 124.3400n -0.000209
+ 124.3500n -0.000232 124.3600n -0.000255 124.3700n -0.000278 124.3800n -0.000301 124.3900n -0.000324 124.4000n -0.000347 124.4100n -0.000370 124.4200n -0.000393 124.4300n -0.000416 124.4400n -0.000438 124.4500n -0.000461 124.4600n -0.000484 124.4700n -0.000506 124.4800n -0.000529 124.4900n -0.000551
+ 124.5000n -0.000573 124.5100n -0.000595 124.5200n -0.000617 124.5300n -0.000639 124.5400n -0.000660 124.5500n -0.000681 124.5600n -0.000702 124.5700n -0.000723 124.5800n -0.000743 124.5900n -0.000763 124.6000n -0.000783 124.6100n -0.000802 124.6200n -0.000821 124.6300n -0.000840 124.6400n -0.000858
+ 124.6500n -0.000876 124.6600n -0.000894 124.6700n -0.000911 124.6800n -0.000927 124.6900n -0.000944 124.7000n -0.000959 124.7100n -0.000975 124.7200n -0.000989 124.7300n -0.001004 124.7400n -0.001017 124.7500n -0.001031 124.7600n -0.001043 124.7700n -0.001055 124.7800n -0.001067 124.7900n -0.001078
+ 124.8000n -0.001088 124.8100n -0.001098 124.8200n -0.001107 124.8300n -0.001116 124.8400n -0.001124 124.8500n -0.001131 124.8600n -0.001138 124.8700n -0.001144 124.8800n -0.001149 124.8900n -0.001154 124.9000n -0.001158 124.9100n -0.001161 124.9200n -0.001164 124.9300n -0.001166 124.9400n -0.001168
+ 124.9500n -0.001168 124.9600n -0.001168 124.9700n -0.001167 124.9800n -0.001166 124.9900n -0.001164 125.0000n -0.001161 125.0100n -0.001157 125.0200n -0.001153 125.0300n -0.001148 125.0400n -0.001142 125.0500n -0.001135 125.0600n -0.001128 125.0700n -0.001120 125.0800n -0.001112 125.0900n -0.001102
+ 125.1000n -0.001092 125.1100n -0.001081 125.1200n -0.001070 125.1300n -0.001058 125.1400n -0.001045 125.1500n -0.001031 125.1600n -0.001017 125.1700n -0.001002 125.1800n -0.000986 125.1900n -0.000970 125.2000n -0.000953 125.2100n -0.000935 125.2200n -0.000917 125.2300n -0.000898 125.2400n -0.000878
+ 125.2500n -0.000858 125.2600n -0.000837 125.2700n -0.000815 125.2800n -0.000793 125.2900n -0.000770 125.3000n -0.000747 125.3100n -0.000723 125.3200n -0.000698 125.3300n -0.000673 125.3400n -0.000648 125.3500n -0.000622 125.3600n -0.000595 125.3700n -0.000568 125.3800n -0.000540 125.3900n -0.000512
+ 125.4000n -0.000484 125.4100n -0.000455 125.4200n -0.000425 125.4300n -0.000395 125.4400n -0.000365 125.4500n -0.000334 125.4600n -0.000303 125.4700n -0.000272 125.4800n -0.000240 125.4900n -0.000208 125.5000n -0.000176 125.5100n -0.000143 125.5200n -0.000110 125.5300n -0.000077 125.5400n -0.000043
+ 125.5500n -0.000009 125.5600n 0.000025 125.5700n 0.000059 125.5800n 0.000093 125.5900n 0.000128 125.6000n 0.000162 125.6100n 0.000197 125.6200n 0.000232 125.6300n 0.000267 125.6400n 0.000302 125.6500n 0.000337 125.6600n 0.000372 125.6700n 0.000407 125.6800n 0.000443 125.6900n 0.000478
+ 125.7000n 0.000513 125.7100n 0.000548 125.7200n 0.000583 125.7300n 0.000618 125.7400n 0.000653 125.7500n 0.000688 125.7600n 0.000722 125.7700n 0.000756 125.7800n 0.000791 125.7900n 0.000825 125.8000n 0.000859 125.8100n 0.000892 125.8200n 0.000926 125.8300n 0.000959 125.8400n 0.000991
+ 125.8500n 0.001024 125.8600n 0.001056 125.8700n 0.001088 125.8800n 0.001120 125.8900n 0.001151 125.9000n 0.001182 125.9100n 0.001212 125.9200n 0.001242 125.9300n 0.001272 125.9400n 0.001301 125.9500n 0.001330 125.9600n 0.001358 125.9700n 0.001386 125.9800n 0.001413 125.9900n 0.001440
+ 126.0000n 0.001466 126.0100n 0.001492 126.0200n 0.001517 126.0300n 0.001541 126.0400n 0.001565 126.0500n 0.001589 126.0600n 0.001612 126.0700n 0.001634 126.0800n 0.001656 126.0900n 0.001677 126.1000n 0.001697 126.1100n 0.001717 126.1200n 0.001736 126.1300n 0.001755 126.1400n 0.001772
+ 126.1500n 0.001789 126.1600n 0.001806 126.1700n 0.001822 126.1800n 0.001837 126.1900n 0.001851 126.2000n 0.001865 126.2100n 0.001878 126.2200n 0.001890 126.2300n 0.001901 126.2400n 0.001912 126.2500n 0.001922 126.2600n 0.001931 126.2700n 0.001940 126.2800n 0.001947 126.2900n 0.001954
+ 126.3000n 0.001961 126.3100n 0.001966 126.3200n 0.001971 126.3300n 0.001975 126.3400n 0.001978 126.3500n 0.001980 126.3600n 0.001982 126.3700n 0.001983 126.3800n 0.001983 126.3900n 0.001982 126.4000n 0.001981 126.4100n 0.001979 126.4200n 0.001976 126.4300n 0.001972 126.4400n 0.001968
+ 126.4500n 0.001963 126.4600n 0.001957 126.4700n 0.001950 126.4800n 0.001943 126.4900n 0.001935 126.5000n 0.001926 126.5100n 0.001917 126.5200n 0.001906 126.5300n 0.001895 126.5400n 0.001884 126.5500n 0.001871 126.5600n 0.001858 126.5700n 0.001844 126.5800n 0.001830 126.5900n 0.001815
+ 126.6000n 0.001799 126.6100n 0.001783 126.6200n 0.001766 126.6300n 0.001748 126.6400n 0.001730 126.6500n 0.001711 126.6600n 0.001691 126.6700n 0.001671 126.6800n 0.001650 126.6900n 0.001629 126.7000n 0.001607 126.7100n 0.001585 126.7200n 0.001562 126.7300n 0.001538 126.7400n 0.001514
+ 126.7500n 0.001489 126.7600n 0.001464 126.7700n 0.001439 126.7800n 0.001413 126.7900n 0.001386 126.8000n 0.001359 126.8100n 0.001332 126.8200n 0.001304 126.8300n 0.001275 126.8400n 0.001247 126.8500n 0.001217 126.8600n 0.001188 126.8700n 0.001158 126.8800n 0.001128 126.8900n 0.001097
+ 126.9000n 0.001066 126.9100n 0.001035 126.9200n 0.001004 126.9300n 0.000972 126.9400n 0.000940 126.9500n 0.000907 126.9600n 0.000875 126.9700n 0.000842 126.9800n 0.000809 126.9900n 0.000775 127.0000n 0.000742 127.0100n 0.000708 127.0200n 0.000674 127.0300n 0.000640 127.0400n 0.000606
+ 127.0500n 0.000572 127.0600n 0.000537 127.0700n 0.000503 127.0800n 0.000468 127.0900n 0.000433 127.1000n 0.000399 127.1100n 0.000364 127.1200n 0.000329 127.1300n 0.000294 127.1400n 0.000259 127.1500n 0.000224 127.1600n 0.000189 127.1700n 0.000154 127.1800n 0.000119 127.1900n 0.000085
+ 127.2000n 0.000050 127.2100n 0.000015 127.2200n -0.000020 127.2300n -0.000054 127.2400n -0.000089 127.2500n -0.000123 127.2600n -0.000157 127.2700n -0.000191 127.2800n -0.000225 127.2900n -0.000259 127.3000n -0.000292 127.3100n -0.000326 127.3200n -0.000359 127.3300n -0.000392 127.3400n -0.000425
+ 127.3500n -0.000457 127.3600n -0.000489 127.3700n -0.000521 127.3800n -0.000553 127.3900n -0.000585 127.4000n -0.000616 127.4100n -0.000647 127.4200n -0.000678 127.4300n -0.000708 127.4400n -0.000738 127.4500n -0.000768 127.4600n -0.000797 127.4700n -0.000827 127.4800n -0.000855 127.4900n -0.000884
+ 127.5000n -0.000912 127.5100n -0.000940 127.5200n -0.000967 127.5300n -0.000994 127.5400n -0.001021 127.5500n -0.001047 127.5600n -0.001073 127.5700n -0.001098 127.5800n -0.001123 127.5900n -0.001148 127.6000n -0.001172 127.6100n -0.001195 127.6200n -0.001219 127.6300n -0.001242 127.6400n -0.001264
+ 127.6500n -0.001286 127.6600n -0.001307 127.6700n -0.001329 127.6800n -0.001349 127.6900n -0.001369 127.7000n -0.001389 127.7100n -0.001408 127.7200n -0.001427 127.7300n -0.001445 127.7400n -0.001463 127.7500n -0.001480 127.7600n -0.001497 127.7700n -0.001514 127.7800n -0.001529 127.7900n -0.001545
+ 127.8000n -0.001560 127.8100n -0.001574 127.8200n -0.001588 127.8300n -0.001601 127.8400n -0.001614 127.8500n -0.001626 127.8600n -0.001638 127.8700n -0.001650 127.8800n -0.001660 127.8900n -0.001671 127.9000n -0.001681 127.9100n -0.001690 127.9200n -0.001699 127.9300n -0.001707 127.9400n -0.001715
+ 127.9500n -0.001722 127.9600n -0.001729 127.9700n -0.001735 127.9800n -0.001741 127.9900n -0.001747 128.0000n -0.001751 128.0100n -0.001756 128.0200n -0.001760 128.0300n -0.001763 128.0400n -0.001766 128.0500n -0.001768 128.0600n -0.001770 128.0700n -0.001771 128.0800n -0.001772 128.0900n -0.001773
+ 128.1000n -0.001773 128.1100n -0.001772 128.1200n -0.001771 128.1300n -0.001769 128.1400n -0.001768 128.1500n -0.001765 128.1600n -0.001762 128.1700n -0.001759 128.1800n -0.001755 128.1900n -0.001751 128.2000n -0.001746 128.2100n -0.001741 128.2200n -0.001736 128.2300n -0.001730 128.2400n -0.001723
+ 128.2500n -0.001717 128.2600n -0.001709 128.2700n -0.001702 128.2800n -0.001694 128.2900n -0.001685 128.3000n -0.001676 128.3100n -0.001667 128.3200n -0.001658 128.3300n -0.001648 128.3400n -0.001637 128.3500n -0.001627 128.3600n -0.001616 128.3700n -0.001604 128.3800n -0.001593 128.3900n -0.001581
+ 128.4000n -0.001568 128.4100n -0.001555 128.4200n -0.001542 128.4300n -0.001529 128.4400n -0.001515 128.4500n -0.001501 128.4600n -0.001487 128.4700n -0.001473 128.4800n -0.001458 128.4900n -0.001443 128.5000n -0.001427 128.5100n -0.001412 128.5200n -0.001396 128.5300n -0.001380 128.5400n -0.001364
+ 128.5500n -0.001347 128.5600n -0.001331 128.5700n -0.001314 128.5800n -0.001297 128.5900n -0.001279 128.6000n -0.001262 128.6100n -0.001244 128.6200n -0.001227 128.6300n -0.001209 128.6400n -0.001191 128.6500n -0.001173 128.6600n -0.001154 128.6700n -0.001136 128.6800n -0.001117 128.6900n -0.001099
+ 128.7000n -0.001080 128.7100n -0.001062 128.7200n -0.001043 128.7300n -0.001024 128.7400n -0.001005 128.7500n -0.000986 128.7600n -0.000967 128.7700n -0.000948 128.7800n -0.000929 128.7900n -0.000911 128.8000n -0.000892 128.8100n -0.000873 128.8200n -0.000854 128.8300n -0.000835 128.8400n -0.000816
+ 128.8500n -0.000798 128.8600n -0.000779 128.8700n -0.000761 128.8800n -0.000742 128.8900n -0.000724 128.9000n -0.000706 128.9100n -0.000688 128.9200n -0.000670 128.9300n -0.000653 128.9400n -0.000635 128.9500n -0.000618 128.9600n -0.000601 128.9700n -0.000584 128.9800n -0.000567 128.9900n -0.000550
+ 129.0000n -0.000534 129.0100n -0.000518 129.0200n -0.000502 129.0300n -0.000487 129.0400n -0.000471 129.0500n -0.000456 129.0600n -0.000441 129.0700n -0.000427 129.0800n -0.000413 129.0900n -0.000399 129.1000n -0.000386 129.1100n -0.000372 129.1200n -0.000360 129.1300n -0.000347 129.1400n -0.000335
+ 129.1500n -0.000323 129.1600n -0.000312 129.1700n -0.000301 129.1800n -0.000290 129.1900n -0.000280 129.2000n -0.000270 129.2100n -0.000261 129.2200n -0.000252 129.2300n -0.000243 129.2400n -0.000235 129.2500n -0.000228 129.2600n -0.000220 129.2700n -0.000214 129.2800n -0.000208 129.2900n -0.000202
+ 129.3000n -0.000196 129.3100n -0.000192 129.3200n -0.000187 129.3300n -0.000184 129.3400n -0.000180 129.3500n -0.000177 129.3600n -0.000175 129.3700n -0.000173 129.3800n -0.000172 129.3900n -0.000171 129.4000n -0.000171 129.4100n -0.000171 129.4200n -0.000172 129.4300n -0.000174 129.4400n -0.000176
+ 129.4500n -0.000178 129.4600n -0.000181 129.4700n -0.000185 129.4800n -0.000189 129.4900n -0.000194 129.5000n -0.000199 129.5100n -0.000205 129.5200n -0.000211 129.5300n -0.000218 129.5400n -0.000225 129.5500n -0.000233 129.5600n -0.000242 129.5700n -0.000251 129.5800n -0.000260 129.5900n -0.000270
+ 129.6000n -0.000281 129.6100n -0.000292 129.6200n -0.000304 129.6300n -0.000316 129.6400n -0.000329 129.6500n -0.000343 129.6600n -0.000356 129.6700n -0.000371 129.6800n -0.000386 129.6900n -0.000401 129.7000n -0.000417 129.7100n -0.000433 129.7200n -0.000450 129.7300n -0.000468 129.7400n -0.000485
+ 129.7500n -0.000504 129.7600n -0.000522 129.7700n -0.000542 129.7800n -0.000561 129.7900n -0.000581 129.8000n -0.000602 129.8100n -0.000623 129.8200n -0.000644 129.8300n -0.000666 129.8400n -0.000688 129.8500n -0.000710 129.8600n -0.000733 129.8700n -0.000756 129.8800n -0.000780 129.8900n -0.000804
+ 129.9000n -0.000828 129.9100n -0.000852 129.9200n -0.000877 129.9300n -0.000902 129.9400n -0.000927 129.9500n -0.000953 129.9600n -0.000979 129.9700n -0.001005 129.9800n -0.001031 129.9900n -0.001057 130.0000n -0.001084 130.0100n -0.001111 130.0200n -0.001138 130.0300n -0.001165 130.0400n -0.001192
+ 130.0500n -0.001219 130.0600n -0.001247 130.0700n -0.001274 130.0800n -0.001302 130.0900n -0.001330 130.1000n -0.001357 130.1100n -0.001385 130.1200n -0.001413 130.1300n -0.001440 130.1400n -0.001468 130.1500n -0.001495 130.1600n -0.001523 130.1700n -0.001550 130.1800n -0.001578 130.1900n -0.001605
+ 130.2000n -0.001632 130.2100n -0.001659 130.2200n -0.001686 130.2300n -0.001712 130.2400n -0.001739 130.2500n -0.001765 130.2600n -0.001791 130.2700n -0.001817 130.2800n -0.001842 130.2900n -0.001867 130.3000n -0.001892 130.3100n -0.001917 130.3200n -0.001941 130.3300n -0.001965 130.3400n -0.001989
+ 130.3500n -0.002012 130.3600n -0.002035 130.3700n -0.002057 130.3800n -0.002079 130.3900n -0.002100 130.4000n -0.002122 130.4100n -0.002142 130.4200n -0.002162 130.4300n -0.002182 130.4400n -0.002201 130.4500n -0.002220 130.4600n -0.002238 130.4700n -0.002255 130.4800n -0.002272 130.4900n -0.002289
+ 130.5000n -0.002305 130.5100n -0.002320 130.5200n -0.002335 130.5300n -0.002349 130.5400n -0.002362 130.5500n -0.002375 130.5600n -0.002387 130.5700n -0.002399 130.5800n -0.002409 130.5900n -0.002419 130.6000n -0.002429 130.6100n -0.002438 130.6200n -0.002446 130.6300n -0.002453 130.6400n -0.002460
+ 130.6500n -0.002466 130.6600n -0.002471 130.6700n -0.002475 130.6800n -0.002479 130.6900n -0.002482 130.7000n -0.002484 130.7100n -0.002486 130.7200n -0.002487 130.7300n -0.002487 130.7400n -0.002486 130.7500n -0.002485 130.7600n -0.002482 130.7700n -0.002479 130.7800n -0.002476 130.7900n -0.002471
+ 130.8000n -0.002466 130.8100n -0.002460 130.8200n -0.002453 130.8300n -0.002445 130.8400n -0.002437 130.8500n -0.002428 130.8600n -0.002418 130.8700n -0.002408 130.8800n -0.002397 130.8900n -0.002385 130.9000n -0.002372 130.9100n -0.002358 130.9200n -0.002344 130.9300n -0.002329 130.9400n -0.002314
+ 130.9500n -0.002298 130.9600n -0.002281 130.9700n -0.002263 130.9800n -0.002245 130.9900n -0.002226 131.0000n -0.002207 131.0100n -0.002186 131.0200n -0.002166 131.0300n -0.002144 131.0400n -0.002122 131.0500n -0.002100 131.0600n -0.002077 131.0700n -0.002053 131.0800n -0.002029 131.0900n -0.002004
+ 131.1000n -0.001979 131.1100n -0.001953 131.1200n -0.001927 131.1300n -0.001900 131.1400n -0.001873 131.1500n -0.001845 131.1600n -0.001818 131.1700n -0.001789 131.1800n -0.001760 131.1900n -0.001731 131.2000n -0.001702 131.2100n -0.001672 131.2200n -0.001642 131.2300n -0.001611 131.2400n -0.001581
+ 131.2500n -0.001550 131.2600n -0.001518 131.2700n -0.001487 131.2800n -0.001455 131.2900n -0.001424 131.3000n -0.001392 131.3100n -0.001360 131.3200n -0.001327 131.3300n -0.001295 131.3400n -0.001263 131.3500n -0.001230 131.3600n -0.001198 131.3700n -0.001165 131.3800n -0.001133 131.3900n -0.001100
+ 131.4000n -0.001068 131.4100n -0.001036 131.4200n -0.001003 131.4300n -0.000971 131.4400n -0.000939 131.4500n -0.000907 131.4600n -0.000876 131.4700n -0.000844 131.4800n -0.000813 131.4900n -0.000782 131.5000n -0.000751 131.5100n -0.000720 131.5200n -0.000690 131.5300n -0.000660 131.5400n -0.000630
+ 131.5500n -0.000601 131.5600n -0.000572 131.5700n -0.000543 131.5800n -0.000515 131.5900n -0.000487 131.6000n -0.000460 131.6100n -0.000433 131.6200n -0.000407 131.6300n -0.000381 131.6400n -0.000355 131.6500n -0.000330 131.6600n -0.000306 131.6700n -0.000282 131.6800n -0.000258 131.6900n -0.000236
+ 131.7000n -0.000213 131.7100n -0.000192 131.7200n -0.000171 131.7300n -0.000150 131.7400n -0.000130 131.7500n -0.000111 131.7600n -0.000093 131.7700n -0.000075 131.7800n -0.000058 131.7900n -0.000041 131.8000n -0.000025 131.8100n -0.000010 131.8200n 0.000004 131.8300n 0.000018 131.8400n 0.000031
+ 131.8500n 0.000043 131.8600n 0.000054 131.8700n 0.000065 131.8800n 0.000075 131.8900n 0.000085 131.9000n 0.000093 131.9100n 0.000101 131.9200n 0.000108 131.9300n 0.000114 131.9400n 0.000120 131.9500n 0.000125 131.9600n 0.000129 131.9700n 0.000132 131.9800n 0.000135 131.9900n 0.000136
+ 132.0000n 0.000138 132.0100n 0.000138 132.0200n 0.000137 132.0300n 0.000136 132.0400n 0.000135 132.0500n 0.000132 132.0600n 0.000129 132.0700n 0.000125 132.0800n 0.000120 132.0900n 0.000115 132.1000n 0.000109 132.1100n 0.000102 132.1200n 0.000094 132.1300n 0.000086 132.1400n 0.000078
+ 132.1500n 0.000068 132.1600n 0.000058 132.1700n 0.000048 132.1800n 0.000037 132.1900n 0.000025 132.2000n 0.000013 132.2100n -0.000000 132.2200n -0.000014 132.2300n -0.000027 132.2400n -0.000042 132.2500n -0.000057 132.2600n -0.000072 132.2700n -0.000088 132.2800n -0.000104 132.2900n -0.000121
+ 132.3000n -0.000138 132.3100n -0.000156 132.3200n -0.000174 132.3300n -0.000192 132.3400n -0.000210 132.3500n -0.000229 132.3600n -0.000248 132.3700n -0.000268 132.3800n -0.000288 132.3900n -0.000308 132.4000n -0.000328 132.4100n -0.000348 132.4200n -0.000369 132.4300n -0.000389 132.4400n -0.000410
+ 132.4500n -0.000431 132.4600n -0.000452 132.4700n -0.000473 132.4800n -0.000494 132.4900n -0.000515 132.5000n -0.000537 132.5100n -0.000558 132.5200n -0.000579 132.5300n -0.000600 132.5400n -0.000621 132.5500n -0.000642 132.5600n -0.000662 132.5700n -0.000683 132.5800n -0.000703 132.5900n -0.000724
+ 132.6000n -0.000744 132.6100n -0.000763 132.6200n -0.000783 132.6300n -0.000802 132.6400n -0.000821 132.6500n -0.000840 132.6600n -0.000858 132.6700n -0.000876 132.6800n -0.000894 132.6900n -0.000911 132.7000n -0.000928 132.7100n -0.000944 132.7200n -0.000960 132.7300n -0.000976 132.7400n -0.000991
+ 132.7500n -0.001005 132.7600n -0.001019 132.7700n -0.001033 132.7800n -0.001046 132.7900n -0.001058 132.8000n -0.001070 132.8100n -0.001081 132.8200n -0.001092 132.8300n -0.001102 132.8400n -0.001111 132.8500n -0.001120 132.8600n -0.001128 132.8700n -0.001136 132.8800n -0.001143 132.8900n -0.001149
+ 132.9000n -0.001154 132.9100n -0.001159 132.9200n -0.001163 132.9300n -0.001167 132.9400n -0.001169 132.9500n -0.001171 132.9600n -0.001173 132.9700n -0.001173 132.9800n -0.001173 132.9900n -0.001172 133.0000n -0.001170 133.0100n -0.001168 133.0200n -0.001165 133.0300n -0.001161 133.0400n -0.001156
+ 133.0500n -0.001151 133.0600n -0.001145 133.0700n -0.001138 133.0800n -0.001131 133.0900n -0.001122 133.1000n -0.001113 133.1100n -0.001104 133.1200n -0.001093 133.1300n -0.001082 133.1400n -0.001070 133.1500n -0.001058 133.1600n -0.001044 133.1700n -0.001030 133.1800n -0.001016 133.1900n -0.001001
+ 133.2000n -0.000985 133.2100n -0.000968 133.2200n -0.000951 133.2300n -0.000933 133.2400n -0.000915 133.2500n -0.000896 133.2600n -0.000877 133.2700n -0.000857 133.2800n -0.000836 133.2900n -0.000815 133.3000n -0.000793 133.3100n -0.000771 133.3200n -0.000748 133.3300n -0.000725 133.3400n -0.000702
+ 133.3500n -0.000678 133.3600n -0.000654 133.3700n -0.000629 133.3800n -0.000604 133.3900n -0.000579 133.4000n -0.000553 133.4100n -0.000527 133.4200n -0.000501 133.4300n -0.000474 133.4400n -0.000447 133.4500n -0.000420 133.4600n -0.000393 133.4700n -0.000366 133.4800n -0.000338 133.4900n -0.000311
+ 133.5000n -0.000283 133.5100n -0.000256 133.5200n -0.000228 133.5300n -0.000200 133.5400n -0.000172 133.5500n -0.000145 133.5600n -0.000117 133.5700n -0.000089 133.5800n -0.000062 133.5900n -0.000035 133.6000n -0.000008 133.6100n 0.000019 133.6200n 0.000046 133.6300n 0.000073 133.6400n 0.000099
+ 133.6500n 0.000125 133.6600n 0.000150 133.6700n 0.000176 133.6800n 0.000201 133.6900n 0.000225 133.7000n 0.000249 133.7100n 0.000273 133.7200n 0.000296 133.7300n 0.000319 133.7400n 0.000341 133.7500n 0.000363 133.7600n 0.000384 133.7700n 0.000404 133.7800n 0.000424 133.7900n 0.000443
+ 133.8000n 0.000462 133.8100n 0.000480 133.8200n 0.000497 133.8300n 0.000514 133.8400n 0.000530 133.8500n 0.000545 133.8600n 0.000559 133.8700n 0.000573 133.8800n 0.000586 133.8900n 0.000597 133.9000n 0.000608 133.9100n 0.000619 133.9200n 0.000628 133.9300n 0.000637 133.9400n 0.000644
+ 133.9500n 0.000651 133.9600n 0.000656 133.9700n 0.000661 133.9800n 0.000665 133.9900n 0.000668 134.0000n 0.000670 134.0100n 0.000671 134.0200n 0.000671 134.0300n 0.000669 134.0400n 0.000667 134.0500n 0.000664 134.0600n 0.000660 134.0700n 0.000655 134.0800n 0.000649 134.0900n 0.000641
+ 134.1000n 0.000633 134.1100n 0.000624 134.1200n 0.000613 134.1300n 0.000602 134.1400n 0.000589 134.1500n 0.000576 134.1600n 0.000561 134.1700n 0.000545 134.1800n 0.000529 134.1900n 0.000511 134.2000n 0.000492 134.2100n 0.000472 134.2200n 0.000451 134.2300n 0.000430 134.2400n 0.000407
+ 134.2500n 0.000383 134.2600n 0.000358 134.2700n 0.000332 134.2800n 0.000305 134.2900n 0.000278 134.3000n 0.000249 134.3100n 0.000219 134.3200n 0.000189 134.3300n 0.000157 134.3400n 0.000125 134.3500n 0.000092 134.3600n 0.000058 134.3700n 0.000023 134.3800n -0.000013 134.3900n -0.000050
+ 134.4000n -0.000087 134.4100n -0.000125 134.4200n -0.000164 134.4300n -0.000203 134.4400n -0.000244 134.4500n -0.000285 134.4600n -0.000326 134.4700n -0.000368 134.4800n -0.000411 134.4900n -0.000455 134.5000n -0.000499 134.5100n -0.000543 134.5200n -0.000588 134.5300n -0.000633 134.5400n -0.000679
+ 134.5500n -0.000726 134.5600n -0.000772 134.5700n -0.000820 134.5800n -0.000867 134.5900n -0.000915 134.6000n -0.000963 134.6100n -0.001011 134.6200n -0.001059 134.6300n -0.001108 134.6400n -0.001157 134.6500n -0.001206 134.6600n -0.001255 134.6700n -0.001304 134.6800n -0.001353 134.6900n -0.001402
+ 134.7000n -0.001451 134.7100n -0.001500 134.7200n -0.001549 134.7300n -0.001598 134.7400n -0.001647 134.7500n -0.001695 134.7600n -0.001743 134.7700n -0.001791 134.7800n -0.001839 134.7900n -0.001887 134.8000n -0.001934 134.8100n -0.001980 134.8200n -0.002027 134.8300n -0.002072 134.8400n -0.002118
+ 134.8500n -0.002163 134.8600n -0.002207 134.8700n -0.002251 134.8800n -0.002294 134.8900n -0.002336 134.9000n -0.002378 134.9100n -0.002419 134.9200n -0.002460 134.9300n -0.002500 134.9400n -0.002539 134.9500n -0.002577 134.9600n -0.002614 134.9700n -0.002651 134.9800n -0.002687 134.9900n -0.002721
+ 135.0000n -0.002755 135.0100n -0.002788 135.0200n -0.002820 135.0300n -0.002851 135.0400n -0.002881 135.0500n -0.002910 135.0600n -0.002938 135.0700n -0.002965 135.0800n -0.002991 135.0900n -0.003016 135.1000n -0.003039 135.1100n -0.003062 135.1200n -0.003083 135.1300n -0.003103 135.1400n -0.003122
+ 135.1500n -0.003140 135.1600n -0.003156 135.1700n -0.003171 135.1800n -0.003185 135.1900n -0.003198 135.2000n -0.003210 135.2100n -0.003220 135.2200n -0.003229 135.2300n -0.003237 135.2400n -0.003243 135.2500n -0.003248 135.2600n -0.003252 135.2700n -0.003254 135.2800n -0.003256 135.2900n -0.003256
+ 135.3000n -0.003254 135.3100n -0.003251 135.3200n -0.003247 135.3300n -0.003242 135.3400n -0.003235 135.3500n -0.003227 135.3600n -0.003218 135.3700n -0.003207 135.3800n -0.003196 135.3900n -0.003182 135.4000n -0.003168 135.4100n -0.003152 135.4200n -0.003135 135.4300n -0.003117 135.4400n -0.003098
+ 135.4500n -0.003077 135.4600n -0.003055 135.4700n -0.003032 135.4800n -0.003008 135.4900n -0.002982 135.5000n -0.002956 135.5100n -0.002928 135.5200n -0.002899 135.5300n -0.002869 135.5400n -0.002838 135.5500n -0.002806 135.5600n -0.002772 135.5700n -0.002738 135.5800n -0.002703 135.5900n -0.002667
+ 135.6000n -0.002630 135.6100n -0.002591 135.6200n -0.002552 135.6300n -0.002512 135.6400n -0.002472 135.6500n -0.002430 135.6600n -0.002387 135.6700n -0.002344 135.6800n -0.002300 135.6900n -0.002255 135.7000n -0.002210 135.7100n -0.002164 135.7200n -0.002117 135.7300n -0.002070 135.7400n -0.002022
+ 135.7500n -0.001973 135.7600n -0.001924 135.7700n -0.001874 135.7800n -0.001824 135.7900n -0.001774 135.8000n -0.001723 135.8100n -0.001672 135.8200n -0.001620 135.8300n -0.001568 135.8400n -0.001516 135.8500n -0.001463 135.8600n -0.001411 135.8700n -0.001358 135.8800n -0.001305 135.8900n -0.001252
+ 135.9000n -0.001199 135.9100n -0.001146 135.9200n -0.001092 135.9300n -0.001039 135.9400n -0.000986 135.9500n -0.000933 135.9600n -0.000880 135.9700n -0.000827 135.9800n -0.000774 135.9900n -0.000722 136.0000n -0.000670 136.0100n -0.000618 136.0200n -0.000566 136.0300n -0.000515 136.0400n -0.000464
+ 136.0500n -0.000414 136.0600n -0.000364 136.0700n -0.000314 136.0800n -0.000265 136.0900n -0.000216 136.1000n -0.000168 136.1100n -0.000121 136.1200n -0.000074 136.1300n -0.000027 136.1400n 0.000018 136.1500n 0.000063 136.1600n 0.000108 136.1700n 0.000151 136.1800n 0.000194 136.1900n 0.000236
+ 136.2000n 0.000277 136.2100n 0.000318 136.2200n 0.000357 136.2300n 0.000396 136.2400n 0.000434 136.2500n 0.000471 136.2600n 0.000507 136.2700n 0.000542 136.2800n 0.000576 136.2900n 0.000609 136.3000n 0.000642 136.3100n 0.000673 136.3200n 0.000703 136.3300n 0.000732 136.3400n 0.000760
+ 136.3500n 0.000787 136.3600n 0.000813 136.3700n 0.000838 136.3800n 0.000862 136.3900n 0.000885 136.4000n 0.000907 136.4100n 0.000927 136.4200n 0.000947 136.4300n 0.000965 136.4400n 0.000982 136.4500n 0.000999 136.4600n 0.001013 136.4700n 0.001027 136.4800n 0.001040 136.4900n 0.001052
+ 136.5000n 0.001062 136.5100n 0.001071 136.5200n 0.001080 136.5300n 0.001087 136.5400n 0.001093 136.5500n 0.001098 136.5600n 0.001101 136.5700n 0.001104 136.5800n 0.001106 136.5900n 0.001106 136.6000n 0.001105 136.6100n 0.001104 136.6200n 0.001101 136.6300n 0.001097 136.6400n 0.001092
+ 136.6500n 0.001086 136.6600n 0.001079 136.6700n 0.001072 136.6800n 0.001063 136.6900n 0.001053 136.7000n 0.001042 136.7100n 0.001030 136.7200n 0.001018 136.7300n 0.001004 136.7400n 0.000990 136.7500n 0.000974 136.7600n 0.000958 136.7700n 0.000941 136.7800n 0.000924 136.7900n 0.000905
+ 136.8000n 0.000886 136.8100n 0.000866 136.8200n 0.000845 136.8300n 0.000823 136.8400n 0.000801 136.8500n 0.000779 136.8600n 0.000755 136.8700n 0.000731 136.8800n 0.000707 136.8900n 0.000682 136.9000n 0.000656 136.9100n 0.000630 136.9200n 0.000603 136.9300n 0.000576 136.9400n 0.000549
+ 136.9500n 0.000521 136.9600n 0.000493 136.9700n 0.000464 136.9800n 0.000436 136.9900n 0.000406 137.0000n 0.000377 137.0100n 0.000348 137.0200n 0.000318 137.0300n 0.000288 137.0400n 0.000258 137.0500n 0.000228 137.0600n 0.000198 137.0700n 0.000167 137.0800n 0.000137 137.0900n 0.000107
+ 137.1000n 0.000076 137.1100n 0.000046 137.1200n 0.000016 137.1300n -0.000014 137.1400n -0.000044 137.1500n -0.000073 137.1600n -0.000103 137.1700n -0.000132 137.1800n -0.000161 137.1900n -0.000190 137.2000n -0.000218 137.2100n -0.000246 137.2200n -0.000274 137.2300n -0.000301 137.2400n -0.000328
+ 137.2500n -0.000355 137.2600n -0.000381 137.2700n -0.000407 137.2800n -0.000432 137.2900n -0.000457 137.3000n -0.000481 137.3100n -0.000504 137.3200n -0.000527 137.3300n -0.000550 137.3400n -0.000571 137.3500n -0.000592 137.3600n -0.000613 137.3700n -0.000633 137.3800n -0.000652 137.3900n -0.000670
+ 137.4000n -0.000688 137.4100n -0.000705 137.4200n -0.000721 137.4300n -0.000737 137.4400n -0.000751 137.4500n -0.000765 137.4600n -0.000778 137.4700n -0.000791 137.4800n -0.000802 137.4900n -0.000813 137.5000n -0.000823 137.5100n -0.000832 137.5200n -0.000840 137.5300n -0.000847 137.5400n -0.000853
+ 137.5500n -0.000859 137.5600n -0.000864 137.5700n -0.000867 137.5800n -0.000870 137.5900n -0.000872 137.6000n -0.000873 137.6100n -0.000874 137.6200n -0.000873 137.6300n -0.000871 137.6400n -0.000869 137.6500n -0.000866 137.6600n -0.000861 137.6700n -0.000856 137.6800n -0.000850 137.6900n -0.000843
+ 137.7000n -0.000836 137.7100n -0.000827 137.7200n -0.000818 137.7300n -0.000808 137.7400n -0.000797 137.7500n -0.000785 137.7600n -0.000772 137.7700n -0.000758 137.7800n -0.000744 137.7900n -0.000729 137.8000n -0.000713 137.8100n -0.000696 137.8200n -0.000679 137.8300n -0.000661 137.8400n -0.000642
+ 137.8500n -0.000623 137.8600n -0.000602 137.8700n -0.000582 137.8800n -0.000560 137.8900n -0.000538 137.9000n -0.000515 137.9100n -0.000492 137.9200n -0.000468 137.9300n -0.000443 137.9400n -0.000418 137.9500n -0.000393 137.9600n -0.000367 137.9700n -0.000340 137.9800n -0.000313 137.9900n -0.000286
+ 138.0000n -0.000258 138.0100n -0.000230 138.0200n -0.000201 138.0300n -0.000172 138.0400n -0.000143 138.0500n -0.000113 138.0600n -0.000083 138.0700n -0.000053 138.0800n -0.000023 138.0900n 0.000008 138.1000n 0.000039 138.1100n 0.000069 138.1200n 0.000100 138.1300n 0.000132 138.1400n 0.000163
+ 138.1500n 0.000194 138.1600n 0.000225 138.1700n 0.000257 138.1800n 0.000288 138.1900n 0.000319 138.2000n 0.000351 138.2100n 0.000382 138.2200n 0.000413 138.2300n 0.000444 138.2400n 0.000474 138.2500n 0.000505 138.2600n 0.000535 138.2700n 0.000565 138.2800n 0.000595 138.2900n 0.000625
+ 138.3000n 0.000654 138.3100n 0.000683 138.3200n 0.000711 138.3300n 0.000740 138.3400n 0.000767 138.3500n 0.000795 138.3600n 0.000822 138.3700n 0.000848 138.3800n 0.000874 138.3900n 0.000900 138.4000n 0.000925 138.4100n 0.000950 138.4200n 0.000974 138.4300n 0.000997 138.4400n 0.001020
+ 138.4500n 0.001042 138.4600n 0.001064 138.4700n 0.001085 138.4800n 0.001105 138.4900n 0.001124 138.5000n 0.001143 138.5100n 0.001162 138.5200n 0.001179 138.5300n 0.001196 138.5400n 0.001212 138.5500n 0.001227 138.5600n 0.001242 138.5700n 0.001256 138.5800n 0.001269 138.5900n 0.001281
+ 138.6000n 0.001292 138.6100n 0.001303 138.6200n 0.001312 138.6300n 0.001321 138.6400n 0.001329 138.6500n 0.001337 138.6600n 0.001343 138.6700n 0.001348 138.6800n 0.001353 138.6900n 0.001357 138.7000n 0.001360 138.7100n 0.001362 138.7200n 0.001363 138.7300n 0.001364 138.7400n 0.001363
+ 138.7500n 0.001362 138.7600n 0.001359 138.7700n 0.001356 138.7800n 0.001352 138.7900n 0.001348 138.8000n 0.001342 138.8100n 0.001335 138.8200n 0.001328 138.8300n 0.001320 138.8400n 0.001311 138.8500n 0.001301 138.8600n 0.001290 138.8700n 0.001278 138.8800n 0.001266 138.8900n 0.001253
+ 138.9000n 0.001239 138.9100n 0.001224 138.9200n 0.001209 138.9300n 0.001193 138.9400n 0.001176 138.9500n 0.001158 138.9600n 0.001140 138.9700n 0.001120 138.9800n 0.001101 138.9900n 0.001080 139.0000n 0.001059 139.0100n 0.001037 139.0200n 0.001015 139.0300n 0.000992 139.0400n 0.000968
+ 139.0500n 0.000944 139.0600n 0.000919 139.0700n 0.000894 139.0800n 0.000868 139.0900n 0.000842 139.1000n 0.000815 139.1100n 0.000787 139.1200n 0.000760 139.1300n 0.000731 139.1400n 0.000703 139.1500n 0.000674 139.1600n 0.000644 139.1700n 0.000615 139.1800n 0.000584 139.1900n 0.000554
+ 139.2000n 0.000523 139.2100n 0.000492 139.2200n 0.000461 139.2300n 0.000430 139.2400n 0.000398 139.2500n 0.000367 139.2600n 0.000335 139.2700n 0.000302 139.2800n 0.000270 139.2900n 0.000238 139.3000n 0.000206 139.3100n 0.000173 139.3200n 0.000141 139.3300n 0.000108 139.3400n 0.000076
+ 139.3500n 0.000044 139.3600n 0.000011 139.3700n -0.000021 139.3800n -0.000053 139.3900n -0.000085 139.4000n -0.000117 139.4100n -0.000148 139.4200n -0.000180 139.4300n -0.000211 139.4400n -0.000242 139.4500n -0.000273 139.4600n -0.000303 139.4700n -0.000333 139.4800n -0.000363 139.4900n -0.000393
+ 139.5000n -0.000422 139.5100n -0.000451 139.5200n -0.000479 139.5300n -0.000507 139.5400n -0.000534 139.5500n -0.000562 139.5600n -0.000588 139.5700n -0.000614 139.5800n -0.000640 139.5900n -0.000665 139.6000n -0.000690 139.6100n -0.000714 139.6200n -0.000737 139.6300n -0.000760 139.6400n -0.000782
+ 139.6500n -0.000804 139.6600n -0.000825 139.6700n -0.000846 139.6800n -0.000865 139.6900n -0.000885 139.7000n -0.000903 139.7100n -0.000921 139.7200n -0.000938 139.7300n -0.000954 139.7400n -0.000970 139.7500n -0.000985 139.7600n -0.000999 139.7700n -0.001013 139.7800n -0.001026 139.7900n -0.001038
+ 139.8000n -0.001049 139.8100n -0.001060 139.8200n -0.001069 139.8300n -0.001078 139.8400n -0.001087 139.8500n -0.001094 139.8600n -0.001101 139.8700n -0.001107 139.8800n -0.001112 139.8900n -0.001116 139.9000n -0.001120 139.9100n -0.001123 139.9200n -0.001125 139.9300n -0.001126 139.9400n -0.001126
+ 139.9500n -0.001126 139.9600n -0.001125 139.9700n -0.001123 139.9800n -0.001121 139.9900n -0.001117 140.0000n -0.001113 140.0100n -0.001108 140.0200n -0.001102 140.0300n -0.001096 140.0400n -0.001089 140.0500n -0.001081 140.0600n -0.001072 140.0700n -0.001063 140.0800n -0.001053 140.0900n -0.001042
+ 140.1000n -0.001031 140.1100n -0.001019 140.1200n -0.001006 140.1300n -0.000992 140.1400n -0.000978 140.1500n -0.000964 140.1600n -0.000948 140.1700n -0.000932 140.1800n -0.000916 140.1900n -0.000899 140.2000n -0.000881 140.2100n -0.000863 140.2200n -0.000844 140.2300n -0.000824 140.2400n -0.000804
+ 140.2500n -0.000784 140.2600n -0.000763 140.2700n -0.000742 140.2800n -0.000720 140.2900n -0.000698 140.3000n -0.000675 140.3100n -0.000652 140.3200n -0.000628 140.3300n -0.000605 140.3400n -0.000580 140.3500n -0.000556 140.3600n -0.000531 140.3700n -0.000506 140.3800n -0.000480 140.3900n -0.000454
+ 140.4000n -0.000428 140.4100n -0.000402 140.4200n -0.000376 140.4300n -0.000349 140.4400n -0.000322 140.4500n -0.000295 140.4600n -0.000268 140.4700n -0.000240 140.4800n -0.000213 140.4900n -0.000185 140.5000n -0.000158 140.5100n -0.000130 140.5200n -0.000102 140.5300n -0.000074 140.5400n -0.000047
+ 140.5500n -0.000019 140.5600n 0.000009 140.5700n 0.000037 140.5800n 0.000064 140.5900n 0.000092 140.6000n 0.000119 140.6100n 0.000147 140.6200n 0.000174 140.6300n 0.000201 140.6400n 0.000228 140.6500n 0.000255 140.6600n 0.000281 140.6700n 0.000308 140.6800n 0.000334 140.6900n 0.000360
+ 140.7000n 0.000385 140.7100n 0.000411 140.7200n 0.000436 140.7300n 0.000461 140.7400n 0.000485 140.7500n 0.000510 140.7600n 0.000533 140.7700n 0.000557 140.7800n 0.000580 140.7900n 0.000603 140.8000n 0.000625 140.8100n 0.000647 140.8200n 0.000669 140.8300n 0.000690 140.8400n 0.000711
+ 140.8500n 0.000731 140.8600n 0.000751 140.8700n 0.000770 140.8800n 0.000789 140.8900n 0.000807 140.9000n 0.000825 140.9100n 0.000843 140.9200n 0.000860 140.9300n 0.000876 140.9400n 0.000892 140.9500n 0.000907 140.9600n 0.000922 140.9700n 0.000937 140.9800n 0.000950 140.9900n 0.000964
+ 141.0000n 0.000976 141.0100n 0.000988 141.0200n 0.001000 141.0300n 0.001011 141.0400n 0.001021 141.0500n 0.001031 141.0600n 0.001041 141.0700n 0.001049 141.0800n 0.001057 141.0900n 0.001065 141.1000n 0.001072 141.1100n 0.001078 141.1200n 0.001084 141.1300n 0.001090 141.1400n 0.001094
+ 141.1500n 0.001098 141.1600n 0.001102 141.1700n 0.001105 141.1800n 0.001107 141.1900n 0.001109 141.2000n 0.001111 141.2100n 0.001111 141.2200n 0.001111 141.2300n 0.001111 141.2400n 0.001110 141.2500n 0.001109 141.2600n 0.001107 141.2700n 0.001104 141.2800n 0.001101 141.2900n 0.001097
+ 141.3000n 0.001093 141.3100n 0.001089 141.3200n 0.001084 141.3300n 0.001078 141.3400n 0.001072 141.3500n 0.001065 141.3600n 0.001058 141.3700n 0.001051 141.3800n 0.001043 141.3900n 0.001035 141.4000n 0.001026 141.4100n 0.001016 141.4200n 0.001007 141.4300n 0.000997 141.4400n 0.000986
+ 141.4500n 0.000975 141.4600n 0.000964 141.4700n 0.000952 141.4800n 0.000940 141.4900n 0.000928 141.5000n 0.000915 141.5100n 0.000902 141.5200n 0.000889 141.5300n 0.000875 141.5400n 0.000861 141.5500n 0.000847 141.5600n 0.000832 141.5700n 0.000818 141.5800n 0.000803 141.5900n 0.000787
+ 141.6000n 0.000772 141.6100n 0.000756 141.6200n 0.000740 141.6300n 0.000724 141.6400n 0.000708 141.6500n 0.000691 141.6600n 0.000674 141.6700n 0.000658 141.6800n 0.000641 141.6900n 0.000624 141.7000n 0.000606 141.7100n 0.000589 141.7200n 0.000572 141.7300n 0.000554 141.7400n 0.000537
+ 141.7500n 0.000519 141.7600n 0.000501 141.7700n 0.000484 141.7800n 0.000466 141.7900n 0.000448 141.8000n 0.000430 141.8100n 0.000413 141.8200n 0.000395 141.8300n 0.000377 141.8400n 0.000360 141.8500n 0.000342 141.8600n 0.000324 141.8700n 0.000307 141.8800n 0.000290 141.8900n 0.000272
+ 141.9000n 0.000255 141.9100n 0.000238 141.9200n 0.000221 141.9300n 0.000204 141.9400n 0.000187 141.9500n 0.000171 141.9600n 0.000154 141.9700n 0.000138 141.9800n 0.000122 141.9900n 0.000106 142.0000n 0.000090 142.0100n 0.000074 142.0200n 0.000059 142.0300n 0.000044 142.0400n 0.000029
+ 142.0500n 0.000014 142.0600n -0.000000 142.0700n -0.000015 142.0800n -0.000029 142.0900n -0.000043 142.1000n -0.000056 142.1100n -0.000070 142.1200n -0.000083 142.1300n -0.000096 142.1400n -0.000108 142.1500n -0.000120 142.1600n -0.000132 142.1700n -0.000144 142.1800n -0.000156 142.1900n -0.000167
+ 142.2000n -0.000178 142.2100n -0.000188 142.2200n -0.000199 142.2300n -0.000209 142.2400n -0.000218 142.2500n -0.000228 142.2600n -0.000237 142.2700n -0.000245 142.2800n -0.000254 142.2900n -0.000262 142.3000n -0.000270 142.3100n -0.000278 142.3200n -0.000285 142.3300n -0.000292 142.3400n -0.000298
+ 142.3500n -0.000305 142.3600n -0.000311 142.3700n -0.000316 142.3800n -0.000322 142.3900n -0.000327 142.4000n -0.000331 142.4100n -0.000336 142.4200n -0.000340 142.4300n -0.000344 142.4400n -0.000347 142.4500n -0.000351 142.4600n -0.000354 142.4700n -0.000356 142.4800n -0.000358 142.4900n -0.000361
+ 142.5000n -0.000362 142.5100n -0.000364 142.5200n -0.000365 142.5300n -0.000366 142.5400n -0.000366 142.5500n -0.000367 142.5600n -0.000367 142.5700n -0.000367 142.5800n -0.000366 142.5900n -0.000365 142.6000n -0.000364 142.6100n -0.000363 142.6200n -0.000362 142.6300n -0.000360 142.6400n -0.000358
+ 142.6500n -0.000356 142.6600n -0.000354 142.6700n -0.000351 142.6800n -0.000348 142.6900n -0.000345 142.7000n -0.000342 142.7100n -0.000338 142.7200n -0.000334 142.7300n -0.000331 142.7400n -0.000326 142.7500n -0.000322 142.7600n -0.000318 142.7700n -0.000313 142.7800n -0.000308 142.7900n -0.000303
+ 142.8000n -0.000298 142.8100n -0.000293 142.8200n -0.000288 142.8300n -0.000282 142.8400n -0.000276 142.8500n -0.000271 142.8600n -0.000265 142.8700n -0.000258 142.8800n -0.000252 142.8900n -0.000246 142.9000n -0.000240 142.9100n -0.000233 142.9200n -0.000226 142.9300n -0.000220 142.9400n -0.000213
+ 142.9500n -0.000206 142.9600n -0.000199 142.9700n -0.000192 142.9800n -0.000185 142.9900n -0.000178 143.0000n -0.000171 143.0100n -0.000164 143.0200n -0.000156 143.0300n -0.000149 143.0400n -0.000142 143.0500n -0.000134 143.0600n -0.000127 143.0700n -0.000120 143.0800n -0.000112 143.0900n -0.000105
+ 143.1000n -0.000097 143.1100n -0.000090 143.1200n -0.000083 143.1300n -0.000075 143.1400n -0.000068 143.1500n -0.000060 143.1600n -0.000053 143.1700n -0.000046 143.1800n -0.000038 143.1900n -0.000031 143.2000n -0.000024 143.2100n -0.000017 143.2200n -0.000010 143.2300n -0.000003 143.2400n 0.000004
+ 143.2500n 0.000011 143.2600n 0.000018 143.2700n 0.000025 143.2800n 0.000032 143.2900n 0.000038 143.3000n 0.000045 143.3100n 0.000052 143.3200n 0.000058 143.3300n 0.000064 143.3400n 0.000071 143.3500n 0.000077 143.3600n 0.000083 143.3700n 0.000089 143.3800n 0.000095 143.3900n 0.000101
+ 143.4000n 0.000107 143.4100n 0.000112 143.4200n 0.000118 143.4300n 0.000123 143.4400n 0.000128 143.4500n 0.000133 143.4600n 0.000139 143.4700n 0.000143 143.4800n 0.000148 143.4900n 0.000153 143.5000n 0.000158 143.5100n 0.000162 143.5200n 0.000166 143.5300n 0.000171 143.5400n 0.000175
+ 143.5500n 0.000179 143.5600n 0.000182 143.5700n 0.000186 143.5800n 0.000190 143.5900n 0.000193 143.6000n 0.000196 143.6100n 0.000199 143.6200n 0.000202 143.6300n 0.000205 143.6400n 0.000208 143.6500n 0.000211 143.6600n 0.000213 143.6700n 0.000215 143.6800n 0.000218 143.6900n 0.000220
+ 143.7000n 0.000222 143.7100n 0.000223 143.7200n 0.000225 143.7300n 0.000226 143.7400n 0.000228 143.7500n 0.000229 143.7600n 0.000230 143.7700n 0.000231 143.7800n 0.000231 143.7900n 0.000232 143.8000n 0.000233 143.8100n 0.000233 143.8200n 0.000233 143.8300n 0.000233 143.8400n 0.000233
+ 143.8500n 0.000233 143.8600n 0.000232 143.8700n 0.000232 143.8800n 0.000231 143.8900n 0.000230 143.9000n 0.000229 143.9100n 0.000228 143.9200n 0.000227 143.9300n 0.000225 143.9400n 0.000224 143.9500n 0.000222 143.9600n 0.000220 143.9700n 0.000218 143.9800n 0.000216 143.9900n 0.000214
+ 144.0000n 0.000211 144.0100n 0.000209 144.0200n 0.000206 144.0300n 0.000203 144.0400n 0.000200 144.0500n 0.000197 144.0600n 0.000194 144.0700n 0.000191 144.0800n 0.000187 144.0900n 0.000184 144.1000n 0.000180 144.1100n 0.000176 144.1200n 0.000172 144.1300n 0.000168 144.1400n 0.000164
+ 144.1500n 0.000159 144.1600n 0.000155 144.1700n 0.000150 144.1800n 0.000145 144.1900n 0.000140 144.2000n 0.000135 144.2100n 0.000130 144.2200n 0.000125 144.2300n 0.000120 144.2400n 0.000114 144.2500n 0.000109 144.2600n 0.000103 144.2700n 0.000097 144.2800n 0.000091 144.2900n 0.000085
+ 144.3000n 0.000079 144.3100n 0.000073 144.3200n 0.000066 144.3300n 0.000060 144.3400n 0.000053 144.3500n 0.000046 144.3600n 0.000040 144.3700n 0.000033 144.3800n 0.000026 144.3900n 0.000019 144.4000n 0.000011 144.4100n 0.000004 144.4200n -0.000003 144.4300n -0.000011 144.4400n -0.000018
+ 144.4500n -0.000026 144.4600n -0.000033 144.4700n -0.000041 144.4800n -0.000049 144.4900n -0.000057 144.5000n -0.000065 144.5100n -0.000073 144.5200n -0.000081 144.5300n -0.000090 144.5400n -0.000098 144.5500n -0.000106 144.5600n -0.000115 144.5700n -0.000123 144.5800n -0.000132 144.5900n -0.000140
+ 144.6000n -0.000149 144.6100n -0.000158 144.6200n -0.000166 144.6300n -0.000175 144.6400n -0.000184 144.6500n -0.000193 144.6600n -0.000202 144.6700n -0.000211 144.6800n -0.000220 144.6900n -0.000229 144.7000n -0.000238 144.7100n -0.000247 144.7200n -0.000256 144.7300n -0.000265 144.7400n -0.000274
+ 144.7500n -0.000283 144.7600n -0.000292 144.7700n -0.000301 144.7800n -0.000311 144.7900n -0.000320 144.8000n -0.000329 144.8100n -0.000338 144.8200n -0.000347 144.8300n -0.000356 144.8400n -0.000365 144.8500n -0.000374 144.8600n -0.000383 144.8700n -0.000392 144.8800n -0.000401 144.8900n -0.000410
+ 144.9000n -0.000419 144.9100n -0.000428 144.9200n -0.000436 144.9300n -0.000445 144.9400n -0.000454 144.9500n -0.000462 144.9600n -0.000471 144.9700n -0.000479 144.9800n -0.000488 144.9900n -0.000496 145.0000n -0.000504 145.0100n -0.000512 145.0200n -0.000520 145.0300n -0.000528 145.0400n -0.000536
+ 145.0500n -0.000544 145.0600n -0.000552 145.0700n -0.000559 145.0800n -0.000567 145.0900n -0.000574 145.1000n -0.000581 145.1100n -0.000588 145.1200n -0.000595 145.1300n -0.000602 145.1400n -0.000609 145.1500n -0.000616 145.1600n -0.000622 145.1700n -0.000628 145.1800n -0.000634 145.1900n -0.000641
+ 145.2000n -0.000646 145.2100n -0.000652 145.2200n -0.000658 145.2300n -0.000663 145.2400n -0.000668 145.2500n -0.000673 145.2600n -0.000678 145.2700n -0.000683 145.2800n -0.000688 145.2900n -0.000692 145.3000n -0.000696 145.3100n -0.000700 145.3200n -0.000704 145.3300n -0.000707 145.3400n -0.000711
+ 145.3500n -0.000714 145.3600n -0.000717 145.3700n -0.000720 145.3800n -0.000722 145.3900n -0.000725 145.4000n -0.000727 145.4100n -0.000729 145.4200n -0.000731 145.4300n -0.000732 145.4400n -0.000734 145.4500n -0.000735 145.4600n -0.000736 145.4700n -0.000736 145.4800n -0.000737 145.4900n -0.000737
+ 145.5000n -0.000737 145.5100n -0.000737 145.5200n -0.000736 145.5300n -0.000736 145.5400n -0.000735 145.5500n -0.000734 145.5600n -0.000732 145.5700n -0.000731 145.5800n -0.000729 145.5900n -0.000727 145.6000n -0.000724 145.6100n -0.000722 145.6200n -0.000719 145.6300n -0.000716 145.6400n -0.000713
+ 145.6500n -0.000709 145.6600n -0.000706 145.6700n -0.000702 145.6800n -0.000697 145.6900n -0.000693 145.7000n -0.000689 145.7100n -0.000684 145.7200n -0.000679 145.7300n -0.000673 145.7400n -0.000668 145.7500n -0.000662 145.7600n -0.000656 145.7700n -0.000650 145.7800n -0.000644 145.7900n -0.000637
+ 145.8000n -0.000631 145.8100n -0.000624 145.8200n -0.000616 145.8300n -0.000609 145.8400n -0.000601 145.8500n -0.000594 145.8600n -0.000586 145.8700n -0.000578 145.8800n -0.000569 145.8900n -0.000561 145.9000n -0.000552 145.9100n -0.000544 145.9200n -0.000535 145.9300n -0.000525 145.9400n -0.000516
+ 145.9500n -0.000507 145.9600n -0.000497 145.9700n -0.000487 145.9800n -0.000478 145.9900n -0.000468 146.0000n -0.000457 146.0100n -0.000447 146.0200n -0.000437 146.0300n -0.000426 146.0400n -0.000416 146.0500n -0.000405 146.0600n -0.000394 146.0700n -0.000383 146.0800n -0.000372 146.0900n -0.000361
+ 146.1000n -0.000350 146.1100n -0.000339 146.1200n -0.000328 146.1300n -0.000316 146.1400n -0.000305 146.1500n -0.000294 146.1600n -0.000282 146.1700n -0.000271 146.1800n -0.000259 146.1900n -0.000248 146.2000n -0.000236 146.2100n -0.000225 146.2200n -0.000213 146.2300n -0.000201 146.2400n -0.000190
+ 146.2500n -0.000178 146.2600n -0.000167 146.2700n -0.000155 146.2800n -0.000144 146.2900n -0.000133 146.3000n -0.000121 146.3100n -0.000110 146.3200n -0.000099 146.3300n -0.000088 146.3400n -0.000077 146.3500n -0.000066 146.3600n -0.000055 146.3700n -0.000044 146.3800n -0.000033 146.3900n -0.000023
+ 146.4000n -0.000012 146.4100n -0.000002 146.4200n 0.000009 146.4300n 0.000019 146.4400n 0.000029 146.4500n 0.000039 146.4600n 0.000048 146.4700n 0.000058 146.4800n 0.000067 146.4900n 0.000076 146.5000n 0.000085 146.5100n 0.000094 146.5200n 0.000103 146.5300n 0.000112 146.5400n 0.000120
+ 146.5500n 0.000128 146.5600n 0.000136 146.5700n 0.000144 146.5800n 0.000151 146.5900n 0.000159 146.6000n 0.000166 146.6100n 0.000173 146.6200n 0.000179 146.6300n 0.000186 146.6400n 0.000192 146.6500n 0.000198 146.6600n 0.000203 146.6700n 0.000209 146.6800n 0.000214 146.6900n 0.000219
+ 146.7000n 0.000224 146.7100n 0.000228 146.7200n 0.000233 146.7300n 0.000236 146.7400n 0.000240 146.7500n 0.000244 146.7600n 0.000247 146.7700n 0.000250 146.7800n 0.000252 146.7900n 0.000255 146.8000n 0.000257 146.8100n 0.000258 146.8200n 0.000260 146.8300n 0.000261 146.8400n 0.000262
+ 146.8500n 0.000263 146.8600n 0.000263 146.8700n 0.000264 146.8800n 0.000263 146.8900n 0.000263 146.9000n 0.000262 146.9100n 0.000261 146.9200n 0.000260 146.9300n 0.000259 146.9400n 0.000257 146.9500n 0.000255 146.9600n 0.000253 146.9700n 0.000250 146.9800n 0.000247 146.9900n 0.000244
+ 147.0000n 0.000241 147.0100n 0.000237 147.0200n 0.000233 147.0300n 0.000229 147.0400n 0.000225 147.0500n 0.000220 147.0600n 0.000216 147.0700n 0.000210 147.0800n 0.000205 147.0900n 0.000200 147.1000n 0.000194 147.1100n 0.000188 147.1200n 0.000182 147.1300n 0.000175 147.1400n 0.000169
+ 147.1500n 0.000162 147.1600n 0.000155 147.1700n 0.000147 147.1800n 0.000140 147.1900n 0.000132 147.2000n 0.000125 147.2100n 0.000117 147.2200n 0.000109 147.2300n 0.000100 147.2400n 0.000092 147.2500n 0.000083 147.2600n 0.000074 147.2700n 0.000065 147.2800n 0.000056 147.2900n 0.000047
+ 147.3000n 0.000038 147.3100n 0.000028 147.3200n 0.000019 147.3300n 0.000009 147.3400n -0.000000 147.3500n -0.000010 147.3600n -0.000020 147.3700n -0.000030 147.3800n -0.000040 147.3900n -0.000050 147.4000n -0.000061 147.4100n -0.000071 147.4200n -0.000081 147.4300n -0.000091 147.4400n -0.000102
+ 147.4500n -0.000112 147.4600n -0.000123 147.4700n -0.000133 147.4800n -0.000143 147.4900n -0.000154 147.5000n -0.000164 147.5100n -0.000175 147.5200n -0.000185 147.5300n -0.000195 147.5400n -0.000206 147.5500n -0.000216 147.5600n -0.000226 147.5700n -0.000236 147.5800n -0.000246 147.5900n -0.000257
+ 147.6000n -0.000266 147.6100n -0.000276 147.6200n -0.000286 147.6300n -0.000296 147.6400n -0.000306 147.6500n -0.000315 147.6600n -0.000325 147.6700n -0.000334 147.6800n -0.000343 147.6900n -0.000352 147.7000n -0.000361 147.7100n -0.000370 147.7200n -0.000378 147.7300n -0.000387 147.7400n -0.000395
+ 147.7500n -0.000404 147.7600n -0.000412 147.7700n -0.000420 147.7800n -0.000427 147.7900n -0.000435 147.8000n -0.000442 147.8100n -0.000450 147.8200n -0.000457 147.8300n -0.000463 147.8400n -0.000470 147.8500n -0.000477 147.8600n -0.000483 147.8700n -0.000489 147.8800n -0.000495 147.8900n -0.000501
+ 147.9000n -0.000506 147.9100n -0.000511 147.9200n -0.000516 147.9300n -0.000521 147.9400n -0.000526 147.9500n -0.000530 147.9600n -0.000535 147.9700n -0.000539 147.9800n -0.000542 147.9900n -0.000546 148.0000n -0.000549 148.0100n -0.000553 148.0200n -0.000556 148.0300n -0.000558 148.0400n -0.000561
+ 148.0500n -0.000563 148.0600n -0.000565 148.0700n -0.000567 148.0800n -0.000569 148.0900n -0.000570 148.1000n -0.000572 148.1100n -0.000573 148.1200n -0.000574 148.1300n -0.000574 148.1400n -0.000575 148.1500n -0.000575 148.1600n -0.000575 148.1700n -0.000575 148.1800n -0.000575 148.1900n -0.000574
+ 148.2000n -0.000573 148.2100n -0.000573 148.2200n -0.000571 148.2300n -0.000570 148.2400n -0.000569 148.2500n -0.000567 148.2600n -0.000566 148.2700n -0.000564 148.2800n -0.000562 148.2900n -0.000560 148.3000n -0.000557 148.3100n -0.000555 148.3200n -0.000552 148.3300n -0.000549 148.3400n -0.000547
+ 148.3500n -0.000544 148.3600n -0.000540 148.3700n -0.000537 148.3800n -0.000534 148.3900n -0.000531 148.4000n -0.000527 148.4100n -0.000523 148.4200n -0.000520 148.4300n -0.000516 148.4400n -0.000512 148.4500n -0.000508 148.4600n -0.000504 148.4700n -0.000500 148.4800n -0.000496 148.4900n -0.000492
+ 148.5000n -0.000488 148.5100n -0.000484 148.5200n -0.000480 148.5300n -0.000475 148.5400n -0.000471 148.5500n -0.000467 148.5600n -0.000463 148.5700n -0.000459 148.5800n -0.000454 148.5900n -0.000450 148.6000n -0.000446 148.6100n -0.000442 148.6200n -0.000438 148.6300n -0.000433 148.6400n -0.000429
+ 148.6500n -0.000425 148.6600n -0.000421 148.6700n -0.000418 148.6800n -0.000414 148.6900n -0.000410 148.7000n -0.000406 148.7100n -0.000403 148.7200n -0.000399 148.7300n -0.000396 148.7400n -0.000392 148.7500n -0.000389 148.7600n -0.000386 148.7700n -0.000383 148.7800n -0.000380 148.7900n -0.000377
+ 148.8000n -0.000375 148.8100n -0.000372 148.8200n -0.000370 148.8300n -0.000367 148.8400n -0.000365 148.8500n -0.000363 148.8600n -0.000361 148.8700n -0.000359 148.8800n -0.000358 148.8900n -0.000356 148.9000n -0.000355 148.9100n -0.000354 148.9200n -0.000353 148.9300n -0.000352 148.9400n -0.000351
+ 148.9500n -0.000351 148.9600n -0.000350 148.9700n -0.000350 148.9800n -0.000350 148.9900n -0.000350 149.0000n -0.000350 149.0100n -0.000351 149.0200n -0.000351 149.0300n -0.000352 149.0400n -0.000353 149.0500n -0.000354 149.0600n -0.000355 149.0700n -0.000356 149.0800n -0.000358 149.0900n -0.000360
+ 149.1000n -0.000361 149.1100n -0.000363 149.1200n -0.000365 149.1300n -0.000368 149.1400n -0.000370 149.1500n -0.000373 149.1600n -0.000375 149.1700n -0.000378 149.1800n -0.000381 149.1900n -0.000384 149.2000n -0.000387 149.2100n -0.000390 149.2200n -0.000394 149.2300n -0.000397 149.2400n -0.000401
+ 149.2500n -0.000405 149.2600n -0.000408 149.2700n -0.000412 149.2800n -0.000416 149.2900n -0.000420 149.3000n -0.000424 149.3100n -0.000429 149.3200n -0.000433 149.3300n -0.000437 149.3400n -0.000441 149.3500n -0.000446 149.3600n -0.000450 149.3700n -0.000455 149.3800n -0.000459 149.3900n -0.000464
+ 149.4000n -0.000468 149.4100n -0.000473 149.4200n -0.000477 149.4300n -0.000481 149.4400n -0.000486 149.4500n -0.000490 149.4600n -0.000495 149.4700n -0.000499 149.4800n -0.000503 149.4900n -0.000507 149.5000n -0.000512 149.5100n -0.000516 149.5200n -0.000520 149.5300n -0.000523 149.5400n -0.000527
+ 149.5500n -0.000531 149.5600n -0.000534 149.5700n -0.000538 149.5800n -0.000541 149.5900n -0.000544 149.6000n -0.000547 149.6100n -0.000550 149.6200n -0.000552 149.6300n -0.000555 149.6400n -0.000557 149.6500n -0.000559 149.6600n -0.000561 149.6700n -0.000563 149.6800n -0.000564 149.6900n -0.000565
+ 149.7000n -0.000566 149.7100n -0.000567 149.7200n -0.000568 149.7300n -0.000568 149.7400n -0.000568 149.7500n -0.000568 149.7600n -0.000567 149.7700n -0.000566 149.7800n -0.000565 149.7900n -0.000564 149.8000n -0.000562 149.8100n -0.000560 149.8200n -0.000557 149.8300n -0.000555 149.8400n -0.000551
+ 149.8500n -0.000548 149.8600n -0.000544 149.8700n -0.000540 149.8800n -0.000536 149.8900n -0.000531 149.9000n -0.000526 149.9100n -0.000520 149.9200n -0.000514 149.9300n -0.000508 149.9400n -0.000501 149.9500n -0.000494 149.9600n -0.000487 149.9700n -0.000479 149.9800n -0.000471 149.9900n -0.000462
+ 150.0000n -0.000453 150.0100n -0.000443 150.0200n -0.000434 150.0300n -0.000423 150.0400n -0.000413 150.0500n -0.000402 150.0600n -0.000390 150.0700n -0.000378 150.0800n -0.000366 150.0900n -0.000353 150.1000n -0.000340 150.1100n -0.000326 150.1200n -0.000312 150.1300n -0.000298 150.1400n -0.000283
+ 150.1500n -0.000268 150.1600n -0.000252 150.1700n -0.000236 150.1800n -0.000220 150.1900n -0.000203 150.2000n -0.000186 150.2100n -0.000168 150.2200n -0.000150 150.2300n -0.000132 150.2400n -0.000113 150.2500n -0.000094 150.2600n -0.000074 150.2700n -0.000054 150.2800n -0.000034 150.2900n -0.000013
+ 150.3000n 0.000008 150.3100n 0.000029 150.3200n 0.000051 150.3300n 0.000073 150.3400n 0.000095 150.3500n 0.000118 150.3600n 0.000141 150.3700n 0.000164 150.3800n 0.000188 150.3900n 0.000212 150.4000n 0.000236 150.4100n 0.000261 150.4200n 0.000285 150.4300n 0.000310 150.4400n 0.000336
+ 150.4500n 0.000361 150.4600n 0.000387 150.4700n 0.000413 150.4800n 0.000439 150.4900n 0.000465 150.5000n 0.000492 150.5100n 0.000519 150.5200n 0.000545 150.5300n 0.000572 150.5400n 0.000600 150.5500n 0.000627 150.5600n 0.000654 150.5700n 0.000682 150.5800n 0.000710 150.5900n 0.000738
+ 150.6000n 0.000765 150.6100n 0.000793 150.6200n 0.000821 150.6300n 0.000849 150.6400n 0.000877 150.6500n 0.000906 150.6600n 0.000934 150.6700n 0.000962 150.6800n 0.000990 150.6900n 0.001018 150.7000n 0.001046 150.7100n 0.001074 150.7200n 0.001102 150.7300n 0.001130 150.7400n 0.001157
+ 150.7500n 0.001185 150.7600n 0.001213 150.7700n 0.001240 150.7800n 0.001267 150.7900n 0.001294 150.8000n 0.001321 150.8100n 0.001348 150.8200n 0.001375 150.8300n 0.001401 150.8400n 0.001427 150.8500n 0.001453 150.8600n 0.001479 150.8700n 0.001505 150.8800n 0.001530 150.8900n 0.001555
+ 150.9000n 0.001580 150.9100n 0.001604 150.9200n 0.001628 150.9300n 0.001652 150.9400n 0.001675 150.9500n 0.001699 150.9600n 0.001721 150.9700n 0.001744 150.9800n 0.001766 150.9900n 0.001788 151.0000n 0.001809 151.0100n 0.001830 151.0200n 0.001851 151.0300n 0.001871 151.0400n 0.001891
+ 151.0500n 0.001910 151.0600n 0.001929 151.0700n 0.001947 151.0800n 0.001965 151.0900n 0.001983 151.1000n 0.002000 151.1100n 0.002017 151.1200n 0.002033 151.1300n 0.002048 151.1400n 0.002064 151.1500n 0.002078 151.1600n 0.002093 151.1700n 0.002106 151.1800n 0.002119 151.1900n 0.002132
+ 151.2000n 0.002144 151.2100n 0.002156 151.2200n 0.002167 151.2300n 0.002178 151.2400n 0.002188 151.2500n 0.002197 151.2600n 0.002206 151.2700n 0.002215 151.2800n 0.002223 151.2900n 0.002230 151.3000n 0.002237 151.3100n 0.002243 151.3200n 0.002249 151.3300n 0.002254 151.3400n 0.002259
+ 151.3500n 0.002263 151.3600n 0.002267 151.3700n 0.002270 151.3800n 0.002272 151.3900n 0.002274 151.4000n 0.002276 151.4100n 0.002277 151.4200n 0.002277 151.4300n 0.002277 151.4400n 0.002276 151.4500n 0.002275 151.4600n 0.002273 151.4700n 0.002271 151.4800n 0.002268 151.4900n 0.002264
+ 151.5000n 0.002261 151.5100n 0.002256 151.5200n 0.002251 151.5300n 0.002246 151.5400n 0.002240 151.5500n 0.002234 151.5600n 0.002227 151.5700n 0.002220 151.5800n 0.002212 151.5900n 0.002204 151.6000n 0.002195 151.6100n 0.002186 151.6200n 0.002176 151.6300n 0.002166 151.6400n 0.002156
+ 151.6500n 0.002145 151.6600n 0.002134 151.6700n 0.002122 151.6800n 0.002110 151.6900n 0.002097 151.7000n 0.002085 151.7100n 0.002071 151.7200n 0.002058 151.7300n 0.002044 151.7400n 0.002029 151.7500n 0.002015 151.7600n 0.002000 151.7700n 0.001984 151.7800n 0.001968 151.7900n 0.001952
+ 151.8000n 0.001936 151.8100n 0.001919 151.8200n 0.001903 151.8300n 0.001885 151.8400n 0.001868 151.8500n 0.001850 151.8600n 0.001832 151.8700n 0.001814 151.8800n 0.001795 151.8900n 0.001777 151.9000n 0.001758 151.9100n 0.001738 151.9200n 0.001719 151.9300n 0.001699 151.9400n 0.001680
+ 151.9500n 0.001660 151.9600n 0.001639 151.9700n 0.001619 151.9800n 0.001599 151.9900n 0.001578 152.0000n 0.001557 152.0100n 0.001536 152.0200n 0.001515 152.0300n 0.001494 152.0400n 0.001472 152.0500n 0.001451 152.0600n 0.001429 152.0700n 0.001407 152.0800n 0.001386 152.0900n 0.001364
+ 152.1000n 0.001342 152.1100n 0.001320 152.1200n 0.001297 152.1300n 0.001275 152.1400n 0.001253 152.1500n 0.001230 152.1600n 0.001208 152.1700n 0.001185 152.1800n 0.001163 152.1900n 0.001140 152.2000n 0.001117 152.2100n 0.001095 152.2200n 0.001072 152.2300n 0.001049 152.2400n 0.001026
+ 152.2500n 0.001003 152.2600n 0.000980 152.2700n 0.000957 152.2800n 0.000934 152.2900n 0.000911 152.3000n 0.000888 152.3100n 0.000865 152.3200n 0.000842 152.3300n 0.000818 152.3400n 0.000795 152.3500n 0.000772 152.3600n 0.000749 152.3700n 0.000725 152.3800n 0.000702 152.3900n 0.000678
+ 152.4000n 0.000655 152.4100n 0.000631 152.4200n 0.000608 152.4300n 0.000584 152.4400n 0.000561 152.4500n 0.000537 152.4600n 0.000513 152.4700n 0.000489 152.4800n 0.000466 152.4900n 0.000442 152.5000n 0.000418 152.5100n 0.000394 152.5200n 0.000370 152.5300n 0.000345 152.5400n 0.000321
+ 152.5500n 0.000297 152.5600n 0.000272 152.5700n 0.000248 152.5800n 0.000223 152.5900n 0.000198 152.6000n 0.000173 152.6100n 0.000148 152.6200n 0.000123 152.6300n 0.000098 152.6400n 0.000072 152.6500n 0.000047 152.6600n 0.000021 152.6700n -0.000005 152.6800n -0.000031 152.6900n -0.000057
+ 152.7000n -0.000083 152.7100n -0.000109 152.7200n -0.000136 152.7300n -0.000163 152.7400n -0.000190 152.7500n -0.000217 152.7600n -0.000245 152.7700n -0.000272 152.7800n -0.000300 152.7900n -0.000328 152.8000n -0.000356 152.8100n -0.000385 152.8200n -0.000413 152.8300n -0.000442 152.8400n -0.000472
+ 152.8500n -0.000501 152.8600n -0.000531 152.8700n -0.000561 152.8800n -0.000591 152.8900n -0.000621 152.9000n -0.000652 152.9100n -0.000683 152.9200n -0.000714 152.9300n -0.000746 152.9400n -0.000778 152.9500n -0.000810 152.9600n -0.000842 152.9700n -0.000875 152.9800n -0.000908 152.9900n -0.000941
+ 153.0000n -0.000975 153.0100n -0.001009 153.0200n -0.001043 153.0300n -0.001077 153.0400n -0.001112 153.0500n -0.001147 153.0600n -0.001182 153.0700n -0.001218 153.0800n -0.001254 153.0900n -0.001290 153.1000n -0.001326 153.1100n -0.001363 153.1200n -0.001400 153.1300n -0.001438 153.1400n -0.001475
+ 153.1500n -0.001513 153.1600n -0.001551 153.1700n -0.001590 153.1800n -0.001628 153.1900n -0.001667 153.2000n -0.001706 153.2100n -0.001746 153.2200n -0.001786 153.2300n -0.001825 153.2400n -0.001866 153.2500n -0.001906 153.2600n -0.001946 153.2700n -0.001987 153.2800n -0.002028 153.2900n -0.002069
+ 153.3000n -0.002110 153.3100n -0.002152 153.3200n -0.002193 153.3300n -0.002235 153.3400n -0.002277 153.3500n -0.002319 153.3600n -0.002361 153.3700n -0.002403 153.3800n -0.002445 153.3900n -0.002488 153.4000n -0.002530 153.4100n -0.002572 153.4200n -0.002615 153.4300n -0.002657 153.4400n -0.002700
+ 153.4500n -0.002742 153.4600n -0.002784 153.4700n -0.002826 153.4800n -0.002869 153.4900n -0.002911 153.5000n -0.002952 153.5100n -0.002994 153.5200n -0.003036 153.5300n -0.003077 153.5400n -0.003119 153.5500n -0.003160 153.5600n -0.003201 153.5700n -0.003241 153.5800n -0.003282 153.5900n -0.003322
+ 153.6000n -0.003361 153.6100n -0.003401 153.6200n -0.003440 153.6300n -0.003478 153.6400n -0.003517 153.6500n -0.003555 153.6600n -0.003592 153.6700n -0.003629 153.6800n -0.003665 153.6900n -0.003701 153.7000n -0.003737 153.7100n -0.003772 153.7200n -0.003806 153.7300n -0.003840 153.7400n -0.003873
+ 153.7500n -0.003905 153.7600n -0.003937 153.7700n -0.003968 153.7800n -0.003999 153.7900n -0.004028 153.8000n -0.004057 153.8100n -0.004085 153.8200n -0.004113 153.8300n -0.004139 153.8400n -0.004165 153.8500n -0.004190 153.8600n -0.004214 153.8700n -0.004237 153.8800n -0.004259 153.8900n -0.004280
+ 153.9000n -0.004300 153.9100n -0.004319 153.9200n -0.004338 153.9300n -0.004355 153.9400n -0.004371 153.9500n -0.004386 153.9600n -0.004400 153.9700n -0.004413 153.9800n -0.004424 153.9900n -0.004435 154.0000n -0.004444 154.0100n -0.004453 154.0200n -0.004460 154.0300n -0.004465 154.0400n -0.004470
+ 154.0500n -0.004473 154.0600n -0.004476 154.0700n -0.004476 154.0800n -0.004476 154.0900n -0.004474 154.1000n -0.004471 154.1100n -0.004467 154.1200n -0.004461 154.1300n -0.004454 154.1400n -0.004445 154.1500n -0.004436 154.1600n -0.004424 154.1700n -0.004412 154.1800n -0.004398 154.1900n -0.004382
+ 154.2000n -0.004366 154.2100n -0.004348 154.2200n -0.004328 154.2300n -0.004307 154.2400n -0.004285 154.2500n -0.004261 154.2600n -0.004235 154.2700n -0.004209 154.2800n -0.004181 154.2900n -0.004151 154.3000n -0.004120 154.3100n -0.004088 154.3200n -0.004054 154.3300n -0.004019 154.3400n -0.003982
+ 154.3500n -0.003944 154.3600n -0.003904 154.3700n -0.003864 154.3800n -0.003821 154.3900n -0.003778 154.4000n -0.003733 154.4100n -0.003687 154.4200n -0.003639 154.4300n -0.003590 154.4400n -0.003540 154.4500n -0.003488 154.4600n -0.003435 154.4700n -0.003381 154.4800n -0.003325 154.4900n -0.003269
+ 154.5000n -0.003211 154.5100n -0.003152 154.5200n -0.003091 154.5300n -0.003030 154.5400n -0.002967 154.5500n -0.002903 154.5600n -0.002839 154.5700n -0.002773 154.5800n -0.002706 154.5900n -0.002638 154.6000n -0.002569 154.6100n -0.002499 154.6200n -0.002428 154.6300n -0.002356 154.6400n -0.002283
+ 154.6500n -0.002209 154.6600n -0.002135 154.6700n -0.002060 154.6800n -0.001984 154.6900n -0.001907 154.7000n -0.001829 154.7100n -0.001751 154.7200n -0.001672 154.7300n -0.001593 154.7400n -0.001513 154.7500n -0.001432 154.7600n -0.001351 154.7700n -0.001270 154.7800n -0.001188 154.7900n -0.001106
+ 154.8000n -0.001023 154.8100n -0.000940 154.8200n -0.000857 154.8300n -0.000773 154.8400n -0.000689 154.8500n -0.000605 154.8600n -0.000521 154.8700n -0.000437 154.8800n -0.000353 154.8900n -0.000269 154.9000n -0.000185 154.9100n -0.000101 154.9200n -0.000017 154.9300n 0.000067 154.9400n 0.000151
+ 154.9500n 0.000234 154.9600n 0.000317 154.9700n 0.000400 154.9800n 0.000482 154.9900n 0.000564 155.0000n 0.000646 155.0100n 0.000727 155.0200n 0.000807 155.0300n 0.000887 155.0400n 0.000967 155.0500n 0.001046 155.0600n 0.001124 155.0700n 0.001201 155.0800n 0.001277 155.0900n 0.001353
+ 155.1000n 0.001428 155.1100n 0.001502 155.1200n 0.001575 155.1300n 0.001647 155.1400n 0.001718 155.1500n 0.001789 155.1600n 0.001858 155.1700n 0.001926 155.1800n 0.001992 155.1900n 0.002058 155.2000n 0.002122 155.2100n 0.002185 155.2200n 0.002247 155.2300n 0.002308 155.2400n 0.002367
+ 155.2500n 0.002425 155.2600n 0.002481 155.2700n 0.002536 155.2800n 0.002590 155.2900n 0.002642 155.3000n 0.002692 155.3100n 0.002741 155.3200n 0.002789 155.3300n 0.002834 155.3400n 0.002878 155.3500n 0.002921 155.3600n 0.002962 155.3700n 0.003001 155.3800n 0.003038 155.3900n 0.003074
+ 155.4000n 0.003108 155.4100n 0.003140 155.4200n 0.003170 155.4300n 0.003199 155.4400n 0.003226 155.4500n 0.003250 155.4600n 0.003274 155.4700n 0.003295 155.4800n 0.003314 155.4900n 0.003331 155.5000n 0.003347 155.5100n 0.003361 155.5200n 0.003372 155.5300n 0.003382 155.5400n 0.003390
+ 155.5500n 0.003396 155.5600n 0.003400 155.5700n 0.003402 155.5800n 0.003402 155.5900n 0.003401 155.6000n 0.003397 155.6100n 0.003391 155.6200n 0.003384 155.6300n 0.003375 155.6400n 0.003363 155.6500n 0.003350 155.6600n 0.003335 155.6700n 0.003318 155.6800n 0.003299 155.6900n 0.003279
+ 155.7000n 0.003256 155.7100n 0.003232 155.7200n 0.003206 155.7300n 0.003178 155.7400n 0.003148 155.7500n 0.003116 155.7600n 0.003083 155.7700n 0.003048 155.7800n 0.003012 155.7900n 0.002973 155.8000n 0.002933 155.8100n 0.002892 155.8200n 0.002848 155.8300n 0.002804 155.8400n 0.002757
+ 155.8500n 0.002709 155.8600n 0.002660 155.8700n 0.002609 155.8800n 0.002557 155.8900n 0.002503 155.9000n 0.002448 155.9100n 0.002392 155.9200n 0.002334 155.9300n 0.002275 155.9400n 0.002215 155.9500n 0.002153 155.9600n 0.002091 155.9700n 0.002027 155.9800n 0.001962 155.9900n 0.001897
+ 156.0000n 0.001830 156.0100n 0.001762 156.0200n 0.001693 156.0300n 0.001623 156.0400n 0.001553 156.0500n 0.001482 156.0600n 0.001410 156.0700n 0.001337 156.0800n 0.001263 156.0900n 0.001189 156.1000n 0.001114 156.1100n 0.001039 156.1200n 0.000963 156.1300n 0.000887 156.1400n 0.000810
+ 156.1500n 0.000733 156.1600n 0.000656 156.1700n 0.000578 156.1800n 0.000501 156.1900n 0.000422 156.2000n 0.000344 156.2100n 0.000266 156.2200n 0.000187 156.2300n 0.000109 156.2400n 0.000031 156.2500n -0.000048 156.2600n -0.000126 156.2700n -0.000204 156.2800n -0.000282 156.2900n -0.000359
+ 156.3000n -0.000436 156.3100n -0.000513 156.3200n -0.000590 156.3300n -0.000666 156.3400n -0.000742 156.3500n -0.000817 156.3600n -0.000891 156.3700n -0.000965 156.3800n -0.001039 156.3900n -0.001111 156.4000n -0.001183 156.4100n -0.001254 156.4200n -0.001325 156.4300n -0.001394 156.4400n -0.001463
+ 156.4500n -0.001531 156.4600n -0.001598 156.4700n -0.001664 156.4800n -0.001728 156.4900n -0.001792 156.5000n -0.001855 156.5100n -0.001917 156.5200n -0.001977 156.5300n -0.002036 156.5400n -0.002094 156.5500n -0.002151 156.5600n -0.002207 156.5700n -0.002261 156.5800n -0.002314 156.5900n -0.002366
+ 156.6000n -0.002416 156.6100n -0.002465 156.6200n -0.002512 156.6300n -0.002558 156.6400n -0.002603 156.6500n -0.002646 156.6600n -0.002688 156.6700n -0.002728 156.6800n -0.002766 156.6900n -0.002803 156.7000n -0.002839 156.7100n -0.002872 156.7200n -0.002905 156.7300n -0.002935 156.7400n -0.002964
+ 156.7500n -0.002992 156.7600n -0.003018 156.7700n -0.003042 156.7800n -0.003064 156.7900n -0.003085 156.8000n -0.003104 156.8100n -0.003122 156.8200n -0.003138 156.8300n -0.003152 156.8400n -0.003165 156.8500n -0.003176 156.8600n -0.003185 156.8700n -0.003193 156.8800n -0.003199 156.8900n -0.003203
+ 156.9000n -0.003206 156.9100n -0.003207 156.9200n -0.003206 156.9300n -0.003204 156.9400n -0.003200 156.9500n -0.003195 156.9600n -0.003188 156.9700n -0.003180 156.9800n -0.003170 156.9900n -0.003158 157.0000n -0.003145 157.0100n -0.003130 157.0200n -0.003114 157.0300n -0.003097 157.0400n -0.003078
+ 157.0500n -0.003058 157.0600n -0.003036 157.0700n -0.003013 157.0800n -0.002988 157.0900n -0.002962 157.1000n -0.002935 157.1100n -0.002907 157.1200n -0.002877 157.1300n -0.002846 157.1400n -0.002814 157.1500n -0.002781 157.1600n -0.002746 157.1700n -0.002711 157.1800n -0.002674 157.1900n -0.002636
+ 157.2000n -0.002597 157.2100n -0.002558 157.2200n -0.002517 157.2300n -0.002475 157.2400n -0.002433 157.2500n -0.002389 157.2600n -0.002345 157.2700n -0.002300 157.2800n -0.002254 157.2900n -0.002208 157.3000n -0.002161 157.3100n -0.002113 157.3200n -0.002064 157.3300n -0.002015 157.3400n -0.001966
+ 157.3500n -0.001915 157.3600n -0.001865 157.3700n -0.001814 157.3800n -0.001762 157.3900n -0.001710 157.4000n -0.001658 157.4100n -0.001605 157.4200n -0.001553 157.4300n -0.001500 157.4400n -0.001446 157.4500n -0.001393 157.4600n -0.001339 157.4700n -0.001286 157.4800n -0.001232 157.4900n -0.001178
+ 157.5000n -0.001125 157.5100n -0.001071 157.5200n -0.001018 157.5300n -0.000964 157.5400n -0.000911 157.5500n -0.000858 157.5600n -0.000805 157.5700n -0.000752 157.5800n -0.000700 157.5900n -0.000648 157.6000n -0.000596 157.6100n -0.000544 157.6200n -0.000493 157.6300n -0.000443 157.6400n -0.000393
+ 157.6500n -0.000343 157.6600n -0.000294 157.6700n -0.000245 157.6800n -0.000197 157.6900n -0.000150 157.7000n -0.000103 157.7100n -0.000057 157.7200n -0.000012 157.7300n 0.000033 157.7400n 0.000077 157.7500n 0.000121 157.7600n 0.000163 157.7700n 0.000205 157.7800n 0.000246 157.7900n 0.000287
+ 157.8000n 0.000326 157.8100n 0.000365 157.8200n 0.000403 157.8300n 0.000440 157.8400n 0.000476 157.8500n 0.000511 157.8600n 0.000545 157.8700n 0.000578 157.8800n 0.000611 157.8900n 0.000642 157.9000n 0.000672 157.9100n 0.000702 157.9200n 0.000730 157.9300n 0.000758 157.9400n 0.000785
+ 157.9500n 0.000810 157.9600n 0.000835 157.9700n 0.000858 157.9800n 0.000881 157.9900n 0.000903 158.0000n 0.000923 158.0100n 0.000943 158.0200n 0.000962 158.0300n 0.000979 158.0400n 0.000996 158.0500n 0.001011 158.0600n 0.001026 158.0700n 0.001040 158.0800n 0.001052 158.0900n 0.001064
+ 158.1000n 0.001075 158.1100n 0.001085 158.1200n 0.001094 158.1300n 0.001102 158.1400n 0.001109 158.1500n 0.001115 158.1600n 0.001120 158.1700n 0.001124 158.1800n 0.001128 158.1900n 0.001130 158.2000n 0.001132 158.2100n 0.001133 158.2200n 0.001133 158.2300n 0.001132 158.2400n 0.001130
+ 158.2500n 0.001128 158.2600n 0.001125 158.2700n 0.001121 158.2800n 0.001117 158.2900n 0.001111 158.3000n 0.001105 158.3100n 0.001099 158.3200n 0.001091 158.3300n 0.001084 158.3400n 0.001075 158.3500n 0.001066 158.3600n 0.001057 158.3700n 0.001046 158.3800n 0.001036 158.3900n 0.001025
+ 158.4000n 0.001013 158.4100n 0.001001 158.4200n 0.000989 158.4300n 0.000976 158.4400n 0.000962 158.4500n 0.000949 158.4600n 0.000935 158.4700n 0.000921 158.4800n 0.000906 158.4900n 0.000891 158.5000n 0.000876 158.5100n 0.000861 158.5200n 0.000846 158.5300n 0.000830 158.5400n 0.000815
+ 158.5500n 0.000799 158.5600n 0.000783 158.5700n 0.000767 158.5800n 0.000751 158.5900n 0.000735 158.6000n 0.000719 158.6100n 0.000703 158.6200n 0.000687 158.6300n 0.000671 158.6400n 0.000655 158.6500n 0.000640 158.6600n 0.000624 158.6700n 0.000609 158.6800n 0.000594 158.6900n 0.000579
+ 158.7000n 0.000564 158.7100n 0.000549 158.7200n 0.000535 158.7300n 0.000521 158.7400n 0.000507 158.7500n 0.000494 158.7600n 0.000481 158.7700n 0.000468 158.7800n 0.000456 158.7900n 0.000444 158.8000n 0.000433 158.8100n 0.000421 158.8200n 0.000411 158.8300n 0.000401 158.8400n 0.000391
+ 158.8500n 0.000381 158.8600n 0.000373 158.8700n 0.000364 158.8800n 0.000356 158.8900n 0.000349 158.9000n 0.000342 158.9100n 0.000336 158.9200n 0.000330 158.9300n 0.000325 158.9400n 0.000321 158.9500n 0.000317 158.9600n 0.000313 158.9700n 0.000311 158.9800n 0.000308 158.9900n 0.000307
+ 159.0000n 0.000306 159.0100n 0.000305 159.0200n 0.000305 159.0300n 0.000306 159.0400n 0.000307 159.0500n 0.000309 159.0600n 0.000312 159.0700n 0.000315 159.0800n 0.000319 159.0900n 0.000323 159.1000n 0.000328 159.1100n 0.000334 159.1200n 0.000340 159.1300n 0.000347 159.1400n 0.000354
+ 159.1500n 0.000362 159.1600n 0.000370 159.1700n 0.000379 159.1800n 0.000389 159.1900n 0.000399 159.2000n 0.000410 159.2100n 0.000421 159.2200n 0.000433 159.2300n 0.000445 159.2400n 0.000458 159.2500n 0.000471 159.2600n 0.000485 159.2700n 0.000499 159.2800n 0.000514 159.2900n 0.000529
+ 159.3000n 0.000545 159.3100n 0.000561 159.3200n 0.000577 159.3300n 0.000594 159.3400n 0.000611 159.3500n 0.000628 159.3600n 0.000646 159.3700n 0.000665 159.3800n 0.000683 159.3900n 0.000702 159.4000n 0.000721 159.4100n 0.000740 159.4200n 0.000760 159.4300n 0.000780 159.4400n 0.000800
+ 159.4500n 0.000820 159.4600n 0.000841 159.4700n 0.000861 159.4800n 0.000882 159.4900n 0.000903 159.5000n 0.000924 159.5100n 0.000945 159.5200n 0.000966 159.5300n 0.000987 159.5400n 0.001008 159.5500n 0.001029 159.5600n 0.001051 159.5700n 0.001072 159.5800n 0.001093 159.5900n 0.001114
+ 159.6000n 0.001135 159.6100n 0.001156 159.6200n 0.001176 159.6300n 0.001197 159.6400n 0.001217 159.6500n 0.001238 159.6600n 0.001258 159.6700n 0.001278 159.6800n 0.001297 159.6900n 0.001317 159.7000n 0.001336 159.7100n 0.001355 159.7200n 0.001373 159.7300n 0.001391 159.7400n 0.001409
+ 159.7500n 0.001427 159.7600n 0.001444 159.7700n 0.001461 159.7800n 0.001477 159.7900n 0.001493 159.8000n 0.001509 159.8100n 0.001524 159.8200n 0.001539 159.8300n 0.001553 159.8400n 0.001567 159.8500n 0.001581 159.8600n 0.001593 159.8700n 0.001606 159.8800n 0.001618 159.8900n 0.001629
+ 159.9000n 0.001640 159.9100n 0.001650 159.9200n 0.001660 159.9300n 0.001669 159.9400n 0.001677 159.9500n 0.001685 159.9600n 0.001693 159.9700n 0.001699 159.9800n 0.001706 159.9900n 0.001711 160.0000n 0.001716 160.0100n 0.001721 160.0200n 0.001724 160.0300n 0.001728 160.0400n 0.001730
+ 160.0500n 0.001732 160.0600n 0.001733 160.0700n 0.001734 160.0800n 0.001734 160.0900n 0.001733 160.1000n 0.001732 160.1100n 0.001730 160.1200n 0.001728 160.1300n 0.001725 160.1400n 0.001721 160.1500n 0.001717 160.1600n 0.001712 160.1700n 0.001706 160.1800n 0.001700 160.1900n 0.001693
+ 160.2000n 0.001686 160.2100n 0.001678 160.2200n 0.001669 160.2300n 0.001660 160.2400n 0.001651 160.2500n 0.001640 160.2600n 0.001629 160.2700n 0.001618 160.2800n 0.001606 160.2900n 0.001594 160.3000n 0.001581 160.3100n 0.001567 160.3200n 0.001554 160.3300n 0.001539 160.3400n 0.001524
+ 160.3500n 0.001509 160.3600n 0.001493 160.3700n 0.001477 160.3800n 0.001460 160.3900n 0.001443 160.4000n 0.001426 160.4100n 0.001408 160.4200n 0.001389 160.4300n 0.001371 160.4400n 0.001352 160.4500n 0.001333 160.4600n 0.001313 160.4700n 0.001293 160.4800n 0.001273 160.4900n 0.001252
+ 160.5000n 0.001232 160.5100n 0.001211 160.5200n 0.001189 160.5300n 0.001168 160.5400n 0.001146 160.5500n 0.001124 160.5600n 0.001102 160.5700n 0.001080 160.5800n 0.001058 160.5900n 0.001036 160.6000n 0.001013 160.6100n 0.000991 160.6200n 0.000968 160.6300n 0.000945 160.6400n 0.000922
+ 160.6500n 0.000900 160.6600n 0.000877 160.6700n 0.000854 160.6800n 0.000831 160.6900n 0.000809 160.7000n 0.000786 160.7100n 0.000763 160.7200n 0.000741 160.7300n 0.000718 160.7400n 0.000696 160.7500n 0.000674 160.7600n 0.000652 160.7700n 0.000630 160.7800n 0.000608 160.7900n 0.000586
+ 160.8000n 0.000565 160.8100n 0.000544 160.8200n 0.000523 160.8300n 0.000502 160.8400n 0.000481 160.8500n 0.000461 160.8600n 0.000441 160.8700n 0.000421 160.8800n 0.000401 160.8900n 0.000382 160.9000n 0.000363 160.9100n 0.000345 160.9200n 0.000326 160.9300n 0.000308 160.9400n 0.000291
+ 160.9500n 0.000273 160.9600n 0.000256 160.9700n 0.000240 160.9800n 0.000223 160.9900n 0.000208 161.0000n 0.000192 161.0100n 0.000177 161.0200n 0.000162 161.0300n 0.000148 161.0400n 0.000134 161.0500n 0.000120 161.0600n 0.000107 161.0700n 0.000094 161.0800n 0.000082 161.0900n 0.000070
+ 161.1000n 0.000058 161.1100n 0.000047 161.1200n 0.000036 161.1300n 0.000026 161.1400n 0.000016 161.1500n 0.000006 161.1600n -0.000003 161.1700n -0.000011 161.1800n -0.000020 161.1900n -0.000028 161.2000n -0.000035 161.2100n -0.000042 161.2200n -0.000049 161.2300n -0.000055 161.2400n -0.000061
+ 161.2500n -0.000067 161.2600n -0.000072 161.2700n -0.000077 161.2800n -0.000081 161.2900n -0.000085 161.3000n -0.000089 161.3100n -0.000092 161.3200n -0.000096 161.3300n -0.000098 161.3400n -0.000101 161.3500n -0.000103 161.3600n -0.000104 161.3700n -0.000106 161.3800n -0.000107 161.3900n -0.000108
+ 161.4000n -0.000108 161.4100n -0.000109 161.4200n -0.000109 161.4300n -0.000108 161.4400n -0.000108 161.4500n -0.000107 161.4600n -0.000106 161.4700n -0.000105 161.4800n -0.000104 161.4900n -0.000102 161.5000n -0.000101 161.5100n -0.000099 161.5200n -0.000097 161.5300n -0.000094 161.5400n -0.000092
+ 161.5500n -0.000089 161.5600n -0.000087 161.5700n -0.000084 161.5800n -0.000081 161.5900n -0.000078 161.6000n -0.000075 161.6100n -0.000072 161.6200n -0.000069 161.6300n -0.000066 161.6400n -0.000063 161.6500n -0.000059 161.6600n -0.000056 161.6700n -0.000053 161.6800n -0.000050 161.6900n -0.000046
+ 161.7000n -0.000043 161.7100n -0.000040 161.7200n -0.000037 161.7300n -0.000034 161.7400n -0.000031 161.7500n -0.000028 161.7600n -0.000025 161.7700n -0.000022 161.7800n -0.000019 161.7900n -0.000017 161.8000n -0.000014 161.8100n -0.000012 161.8200n -0.000010 161.8300n -0.000008 161.8400n -0.000006
+ 161.8500n -0.000004 161.8600n -0.000002 161.8700n -0.000001 161.8800n 0.000001 161.8900n 0.000002 161.9000n 0.000003 161.9100n 0.000004 161.9200n 0.000004 161.9300n 0.000005 161.9400n 0.000005 161.9500n 0.000005 161.9600n 0.000005 161.9700n 0.000004 161.9800n 0.000004 161.9900n 0.000003
+ 162.0000n 0.000002 162.0100n 0.000001 162.0200n -0.000001 162.0300n -0.000002 162.0400n -0.000004 162.0500n -0.000006 162.0600n -0.000009 162.0700n -0.000011 162.0800n -0.000014 162.0900n -0.000017 162.1000n -0.000020 162.1100n -0.000023 162.1200n -0.000027 162.1300n -0.000030 162.1400n -0.000034
+ 162.1500n -0.000038 162.1600n -0.000043 162.1700n -0.000047 162.1800n -0.000052 162.1900n -0.000057 162.2000n -0.000062 162.2100n -0.000067 162.2200n -0.000072 162.2300n -0.000078 162.2400n -0.000083 162.2500n -0.000089 162.2600n -0.000095 162.2700n -0.000101 162.2800n -0.000107 162.2900n -0.000114
+ 162.3000n -0.000120 162.3100n -0.000127 162.3200n -0.000133 162.3300n -0.000140 162.3400n -0.000147 162.3500n -0.000153 162.3600n -0.000160 162.3700n -0.000167 162.3800n -0.000174 162.3900n -0.000181 162.4000n -0.000188 162.4100n -0.000195 162.4200n -0.000202 162.4300n -0.000209 162.4400n -0.000216
+ 162.4500n -0.000223 162.4600n -0.000230 162.4700n -0.000236 162.4800n -0.000243 162.4900n -0.000250 162.5000n -0.000256 162.5100n -0.000263 162.5200n -0.000269 162.5300n -0.000275 162.5400n -0.000281 162.5500n -0.000287 162.5600n -0.000293 162.5700n -0.000299 162.5800n -0.000304 162.5900n -0.000309
+ 162.6000n -0.000315 162.6100n -0.000319 162.6200n -0.000324 162.6300n -0.000328 162.6400n -0.000333 162.6500n -0.000337 162.6600n -0.000340 162.6700n -0.000344 162.6800n -0.000347 162.6900n -0.000350 162.7000n -0.000353 162.7100n -0.000355 162.7200n -0.000357 162.7300n -0.000359 162.7400n -0.000360
+ 162.7500n -0.000361 162.7600n -0.000362 162.7700n -0.000362 162.7800n -0.000362 162.7900n -0.000362 162.8000n -0.000361 162.8100n -0.000360 162.8200n -0.000359 162.8300n -0.000357 162.8400n -0.000355 162.8500n -0.000352 162.8600n -0.000349 162.8700n -0.000346 162.8800n -0.000342 162.8900n -0.000338
+ 162.9000n -0.000333 162.9100n -0.000328 162.9200n -0.000323 162.9300n -0.000317 162.9400n -0.000311 162.9500n -0.000304 162.9600n -0.000297 162.9700n -0.000290 162.9800n -0.000282 162.9900n -0.000274 163.0000n -0.000265 163.0100n -0.000256 163.0200n -0.000247 163.0300n -0.000237 163.0400n -0.000227
+ 163.0500n -0.000216 163.0600n -0.000205 163.0700n -0.000194 163.0800n -0.000182 163.0900n -0.000170 163.1000n -0.000158 163.1100n -0.000145 163.1200n -0.000132 163.1300n -0.000118 163.1400n -0.000104 163.1500n -0.000090 163.1600n -0.000075 163.1700n -0.000061 163.1800n -0.000045 163.1900n -0.000030
+ 163.2000n -0.000014 163.2100n 0.000002 163.2200n 0.000018 163.2300n 0.000035 163.2400n 0.000051 163.2500n 0.000068 163.2600n 0.000086 163.2700n 0.000103 163.2800n 0.000121 163.2900n 0.000138 163.3000n 0.000156 163.3100n 0.000175 163.3200n 0.000193 163.3300n 0.000211 163.3400n 0.000230
+ 163.3500n 0.000248 163.3600n 0.000267 163.3700n 0.000286 163.3800n 0.000305 163.3900n 0.000324 163.4000n 0.000343 163.4100n 0.000362 163.4200n 0.000381 163.4300n 0.000400 163.4400n 0.000419 163.4500n 0.000437 163.4600n 0.000456 163.4700n 0.000475 163.4800n 0.000494 163.4900n 0.000512
+ 163.5000n 0.000530 163.5100n 0.000549 163.5200n 0.000567 163.5300n 0.000585 163.5400n 0.000602 163.5500n 0.000620 163.5600n 0.000637 163.5700n 0.000654 163.5800n 0.000671 163.5900n 0.000688 163.6000n 0.000704 163.6100n 0.000720 163.6200n 0.000735 163.6300n 0.000751 163.6400n 0.000765
+ 163.6500n 0.000780 163.6600n 0.000794 163.6700n 0.000808 163.6800n 0.000821 163.6900n 0.000834 163.7000n 0.000847 163.7100n 0.000859 163.7200n 0.000871 163.7300n 0.000882 163.7400n 0.000892 163.7500n 0.000903 163.7600n 0.000912 163.7700n 0.000921 163.7800n 0.000930 163.7900n 0.000938
+ 163.8000n 0.000945 163.8100n 0.000952 163.8200n 0.000959 163.8300n 0.000964 163.8400n 0.000970 163.8500n 0.000974 163.8600n 0.000978 163.8700n 0.000981 163.8800n 0.000984 163.8900n 0.000986 163.9000n 0.000987 163.9100n 0.000988 163.9200n 0.000988 163.9300n 0.000988 163.9400n 0.000987
+ 163.9500n 0.000985 163.9600n 0.000982 163.9700n 0.000979 163.9800n 0.000975 163.9900n 0.000970 164.0000n 0.000965 164.0100n 0.000959 164.0200n 0.000952 164.0300n 0.000945 164.0400n 0.000937 164.0500n 0.000928 164.0600n 0.000919 164.0700n 0.000909 164.0800n 0.000898 164.0900n 0.000887
+ 164.1000n 0.000874 164.1100n 0.000862 164.1200n 0.000848 164.1300n 0.000834 164.1400n 0.000819 164.1500n 0.000804 164.1600n 0.000788 164.1700n 0.000771 164.1800n 0.000754 164.1900n 0.000736 164.2000n 0.000718 164.2100n 0.000698 164.2200n 0.000679 164.2300n 0.000658 164.2400n 0.000638
+ 164.2500n 0.000616 164.2600n 0.000594 164.2700n 0.000572 164.2800n 0.000549 164.2900n 0.000525 164.3000n 0.000501 164.3100n 0.000477 164.3200n 0.000452 164.3300n 0.000426 164.3400n 0.000400 164.3500n 0.000374 164.3600n 0.000347 164.3700n 0.000320 164.3800n 0.000293 164.3900n 0.000265
+ 164.4000n 0.000237 164.4100n 0.000208 164.4200n 0.000180 164.4300n 0.000150 164.4400n 0.000121 164.4500n 0.000091 164.4600n 0.000062 164.4700n 0.000032 164.4800n 0.000001 164.4900n -0.000029 164.5000n -0.000060 164.5100n -0.000091 164.5200n -0.000121 164.5300n -0.000152 164.5400n -0.000183
+ 164.5500n -0.000215 164.5600n -0.000246 164.5700n -0.000277 164.5800n -0.000308 164.5900n -0.000339 164.6000n -0.000370 164.6100n -0.000402 164.6200n -0.000433 164.6300n -0.000463 164.6400n -0.000494 164.6500n -0.000525 164.6600n -0.000555 164.6700n -0.000586 164.6800n -0.000616 164.6900n -0.000646
+ 164.7000n -0.000675 164.7100n -0.000705 164.7200n -0.000734 164.7300n -0.000762 164.7400n -0.000791 164.7500n -0.000819 164.7600n -0.000847 164.7700n -0.000874 164.7800n -0.000901 164.7900n -0.000928 164.8000n -0.000954 164.8100n -0.000980 164.8200n -0.001005 164.8300n -0.001030 164.8400n -0.001054
+ 164.8500n -0.001078 164.8600n -0.001101 164.8700n -0.001124 164.8800n -0.001146 164.8900n -0.001168 164.9000n -0.001189 164.9100n -0.001209 164.9200n -0.001229 164.9300n -0.001248 164.9400n -0.001267 164.9500n -0.001285 164.9600n -0.001302 164.9700n -0.001318 164.9800n -0.001334 164.9900n -0.001349
+ 165.0000n -0.001364 165.0100n -0.001378 165.0200n -0.001391 165.0300n -0.001403 165.0400n -0.001415 165.0500n -0.001425 165.0600n -0.001435 165.0700n -0.001445 165.0800n -0.001453 165.0900n -0.001461 165.1000n -0.001468 165.1100n -0.001474 165.1200n -0.001480 165.1300n -0.001484 165.1400n -0.001488
+ 165.1500n -0.001491 165.1600n -0.001493 165.1700n -0.001495 165.1800n -0.001496 165.1900n -0.001496 165.2000n -0.001495 165.2100n -0.001493 165.2200n -0.001490 165.2300n -0.001487 165.2400n -0.001483 165.2500n -0.001478 165.2600n -0.001473 165.2700n -0.001466 165.2800n -0.001459 165.2900n -0.001451
+ 165.3000n -0.001443 165.3100n -0.001433 165.3200n -0.001423 165.3300n -0.001412 165.3400n -0.001400 165.3500n -0.001388 165.3600n -0.001375 165.3700n -0.001361 165.3800n -0.001347 165.3900n -0.001332 165.4000n -0.001316 165.4100n -0.001299 165.4200n -0.001282 165.4300n -0.001264 165.4400n -0.001246
+ 165.4500n -0.001227 165.4600n -0.001207 165.4700n -0.001187 165.4800n -0.001166 165.4900n -0.001145 165.5000n -0.001123 165.5100n -0.001101 165.5200n -0.001078 165.5300n -0.001054 165.5400n -0.001030 165.5500n -0.001006 165.5600n -0.000981 165.5700n -0.000956 165.5800n -0.000930 165.5900n -0.000904
+ 165.6000n -0.000878 165.6100n -0.000851 165.6200n -0.000823 165.6300n -0.000796 165.6400n -0.000768 165.6500n -0.000740 165.6600n -0.000711 165.6700n -0.000683 165.6800n -0.000654 165.6900n -0.000624 165.7000n -0.000595 165.7100n -0.000565 165.7200n -0.000535 165.7300n -0.000505 165.7400n -0.000475
+ 165.7500n -0.000445 165.7600n -0.000415 165.7700n -0.000384 165.7800n -0.000354 165.7900n -0.000323 165.8000n -0.000292 165.8100n -0.000262 165.8200n -0.000231 165.8300n -0.000201 165.8400n -0.000170 165.8500n -0.000139 165.8600n -0.000109 165.8700n -0.000079 165.8800n -0.000048 165.8900n -0.000018
+ 165.9000n 0.000012 165.9100n 0.000042 165.9200n 0.000072 165.9300n 0.000101 165.9400n 0.000130 165.9500n 0.000160 165.9600n 0.000188 165.9700n 0.000217 165.9800n 0.000246 165.9900n 0.000274 166.0000n 0.000302 166.0100n 0.000329 166.0200n 0.000357 166.0300n 0.000384 166.0400n 0.000410
+ 166.0500n 0.000436 166.0600n 0.000462 166.0700n 0.000488 166.0800n 0.000513 166.0900n 0.000538 166.1000n 0.000562 166.1100n 0.000586 166.1200n 0.000610 166.1300n 0.000633 166.1400n 0.000656 166.1500n 0.000678 166.1600n 0.000700 166.1700n 0.000722 166.1800n 0.000743 166.1900n 0.000763
+ 166.2000n 0.000783 166.2100n 0.000803 166.2200n 0.000822 166.2300n 0.000840 166.2400n 0.000858 166.2500n 0.000876 166.2600n 0.000893 166.2700n 0.000909 166.2800n 0.000925 166.2900n 0.000941 166.3000n 0.000956 166.3100n 0.000971 166.3200n 0.000985 166.3300n 0.000998 166.3400n 0.001011
+ 166.3500n 0.001023 166.3600n 0.001035 166.3700n 0.001047 166.3800n 0.001058 166.3900n 0.001068 166.4000n 0.001078 166.4100n 0.001087 166.4200n 0.001096 166.4300n 0.001105 166.4400n 0.001113 166.4500n 0.001120 166.4600n 0.001127 166.4700n 0.001133 166.4800n 0.001139 166.4900n 0.001145
+ 166.5000n 0.001150 166.5100n 0.001154 166.5200n 0.001158 166.5300n 0.001162 166.5400n 0.001165 166.5500n 0.001167 166.5600n 0.001170 166.5700n 0.001172 166.5800n 0.001173 166.5900n 0.001174 166.6000n 0.001175 166.6100n 0.001175 166.6200n 0.001174 166.6300n 0.001174 166.6400n 0.001173
+ 166.6500n 0.001172 166.6600n 0.001170 166.6700n 0.001168 166.6800n 0.001165 166.6900n 0.001163 166.7000n 0.001159 166.7100n 0.001156 166.7200n 0.001152 166.7300n 0.001148 166.7400n 0.001144 166.7500n 0.001140 166.7600n 0.001135 166.7700n 0.001130 166.7800n 0.001124 166.7900n 0.001119
+ 166.8000n 0.001113 166.8100n 0.001107 166.8200n 0.001100 166.8300n 0.001094 166.8400n 0.001087 166.8500n 0.001080 166.8600n 0.001073 166.8700n 0.001066 166.8800n 0.001059 166.8900n 0.001051 166.9000n 0.001043 166.9100n 0.001036 166.9200n 0.001028 166.9300n 0.001019 166.9400n 0.001011
+ 166.9500n 0.001003 166.9600n 0.000994 166.9700n 0.000986 166.9800n 0.000977 166.9900n 0.000969 167.0000n 0.000960 167.0100n 0.000951 167.0200n 0.000942 167.0300n 0.000933 167.0400n 0.000924 167.0500n 0.000915 167.0600n 0.000906 167.0700n 0.000897 167.0800n 0.000888 167.0900n 0.000879
+ 167.1000n 0.000870 167.1100n 0.000861 167.1200n 0.000852 167.1300n 0.000842 167.1400n 0.000833 167.1500n 0.000824 167.1600n 0.000815 167.1700n 0.000806 167.1800n 0.000797 167.1900n 0.000788 167.2000n 0.000779 167.2100n 0.000770 167.2200n 0.000761 167.2300n 0.000752 167.2400n 0.000743
+ 167.2500n 0.000734 167.2600n 0.000725 167.2700n 0.000716 167.2800n 0.000707 167.2900n 0.000698 167.3000n 0.000689 167.3100n 0.000680 167.3200n 0.000672 167.3300n 0.000663 167.3400n 0.000654 167.3500n 0.000646 167.3600n 0.000637 167.3700n 0.000628 167.3800n 0.000620 167.3900n 0.000611
+ 167.4000n 0.000602 167.4100n 0.000594 167.4200n 0.000585 167.4300n 0.000577 167.4400n 0.000568 167.4500n 0.000559 167.4600n 0.000551 167.4700n 0.000542 167.4800n 0.000534 167.4900n 0.000525 167.5000n 0.000516 167.5100n 0.000508 167.5200n 0.000499 167.5300n 0.000490 167.5400n 0.000481
+ 167.5500n 0.000472 167.5600n 0.000463 167.5700n 0.000455 167.5800n 0.000446 167.5900n 0.000436 167.6000n 0.000427 167.6100n 0.000418 167.6200n 0.000409 167.6300n 0.000399 167.6400n 0.000390 167.6500n 0.000380 167.6600n 0.000371 167.6700n 0.000361 167.6800n 0.000351 167.6900n 0.000341
+ 167.7000n 0.000331 167.7100n 0.000321 167.7200n 0.000310 167.7300n 0.000300 167.7400n 0.000289 167.7500n 0.000278 167.7600n 0.000267 167.7700n 0.000256 167.7800n 0.000245 167.7900n 0.000234 167.8000n 0.000222 167.8100n 0.000210 167.8200n 0.000198 167.8300n 0.000186 167.8400n 0.000174
+ 167.8500n 0.000162 167.8600n 0.000149 167.8700n 0.000136 167.8800n 0.000123 167.8900n 0.000110 167.9000n 0.000097 167.9100n 0.000083 167.9200n 0.000069 167.9300n 0.000055 167.9400n 0.000041 167.9500n 0.000027 167.9600n 0.000012 167.9700n -0.000003 167.9800n -0.000018 167.9900n -0.000033
+ 168.0000n -0.000048 168.0100n -0.000064 168.0200n -0.000080 168.0300n -0.000096 168.0400n -0.000112 168.0500n -0.000128 168.0600n -0.000145 168.0700n -0.000162 168.0800n -0.000178 168.0900n -0.000196 168.1000n -0.000213 168.1100n -0.000230 168.1200n -0.000248 168.1300n -0.000266 168.1400n -0.000284
+ 168.1500n -0.000302 168.1600n -0.000320 168.1700n -0.000339 168.1800n -0.000357 168.1900n -0.000376 168.2000n -0.000395 168.2100n -0.000414 168.2200n -0.000433 168.2300n -0.000452 168.2400n -0.000472 168.2500n -0.000491 168.2600n -0.000511 168.2700n -0.000530 168.2800n -0.000550 168.2900n -0.000570
+ 168.3000n -0.000589 168.3100n -0.000609 168.3200n -0.000629 168.3300n -0.000649 168.3400n -0.000669 168.3500n -0.000689 168.3600n -0.000709 168.3700n -0.000728 168.3800n -0.000748 168.3900n -0.000768 168.4000n -0.000788 168.4100n -0.000807 168.4200n -0.000827 168.4300n -0.000846 168.4400n -0.000866
+ 168.4500n -0.000885 168.4600n -0.000904 168.4700n -0.000923 168.4800n -0.000942 168.4900n -0.000961 168.5000n -0.000979 168.5100n -0.000998 168.5200n -0.001016 168.5300n -0.001034 168.5400n -0.001051 168.5500n -0.001069 168.5600n -0.001086 168.5700n -0.001103 168.5800n -0.001119 168.5900n -0.001136
+ 168.6000n -0.001152 168.6100n -0.001167 168.6200n -0.001183 168.6300n -0.001198 168.6400n -0.001212 168.6500n -0.001227 168.6600n -0.001241 168.6700n -0.001254 168.6800n -0.001267 168.6900n -0.001280 168.7000n -0.001292 168.7100n -0.001304 168.7200n -0.001315 168.7300n -0.001326 168.7400n -0.001336
+ 168.7500n -0.001346 168.7600n -0.001355 168.7700n -0.001364 168.7800n -0.001372 168.7900n -0.001380 168.8000n -0.001387 168.8100n -0.001394 168.8200n -0.001400 168.8300n -0.001405 168.8400n -0.001410 168.8500n -0.001415 168.8600n -0.001418 168.8700n -0.001421 168.8800n -0.001424 168.8900n -0.001425
+ 168.9000n -0.001427 168.9100n -0.001427 168.9200n -0.001427 168.9300n -0.001426 168.9400n -0.001425 168.9500n -0.001422 168.9600n -0.001420 168.9700n -0.001416 168.9800n -0.001412 168.9900n -0.001407 169.0000n -0.001401 169.0100n -0.001395 169.0200n -0.001388 169.0300n -0.001380 169.0400n -0.001372
+ 169.0500n -0.001363 169.0600n -0.001353 169.0700n -0.001343 169.0800n -0.001331 169.0900n -0.001320 169.1000n -0.001307 169.1100n -0.001294 169.1200n -0.001280 169.1300n -0.001265 169.1400n -0.001250 169.1500n -0.001233 169.1600n -0.001217 169.1700n -0.001199 169.1800n -0.001181 169.1900n -0.001162
+ 169.2000n -0.001143 169.2100n -0.001123 169.2200n -0.001102 169.2300n -0.001080 169.2400n -0.001058 169.2500n -0.001036 169.2600n -0.001012 169.2700n -0.000988 169.2800n -0.000964 169.2900n -0.000939 169.3000n -0.000913 169.3100n -0.000887 169.3200n -0.000860 169.3300n -0.000833 169.3400n -0.000805
+ 169.3500n -0.000776 169.3600n -0.000747 169.3700n -0.000718 169.3800n -0.000688 169.3900n -0.000658 169.4000n -0.000627 169.4100n -0.000596 169.4200n -0.000564 169.4300n -0.000532 169.4400n -0.000499 169.4500n -0.000467 169.4600n -0.000433 169.4700n -0.000400 169.4800n -0.000366 169.4900n -0.000332
+ 169.5000n -0.000297 169.5100n -0.000263 169.5200n -0.000228 169.5300n -0.000193 169.5400n -0.000157 169.5500n -0.000122 169.5600n -0.000086 169.5700n -0.000050 169.5800n -0.000014 169.5900n 0.000022 169.6000n 0.000058 169.6100n 0.000095 169.6200n 0.000131 169.6300n 0.000167 169.6400n 0.000204
+ 169.6500n 0.000240 169.6600n 0.000277 169.6700n 0.000313 169.6800n 0.000349 169.6900n 0.000385 169.7000n 0.000421 169.7100n 0.000457 169.7200n 0.000493 169.7300n 0.000528 169.7400n 0.000564 169.7500n 0.000599 169.7600n 0.000634 169.7700n 0.000668 169.7800n 0.000703 169.7900n 0.000737
+ 169.8000n 0.000771 169.8100n 0.000804 169.8200n 0.000837 169.8300n 0.000870 169.8400n 0.000902 169.8500n 0.000934 169.8600n 0.000965 169.8700n 0.000996 169.8800n 0.001027 169.8900n 0.001057 169.9000n 0.001086 169.9100n 0.001115 169.9200n 0.001144 169.9300n 0.001172 169.9400n 0.001199
+ 169.9500n 0.001226 169.9600n 0.001252 169.9700n 0.001278 169.9800n 0.001302 169.9900n 0.001327 170.0000n 0.001350 170.0100n 0.001373 170.0200n 0.001395 170.0300n 0.001417 170.0400n 0.001438 170.0500n 0.001458 170.0600n 0.001477 170.0700n 0.001495 170.0800n 0.001513 170.0900n 0.001530
+ 170.1000n 0.001546 170.1100n 0.001562 170.1200n 0.001577 170.1300n 0.001590 170.1400n 0.001603 170.1500n 0.001616 170.1600n 0.001627 170.1700n 0.001638 170.1800n 0.001647 170.1900n 0.001656 170.2000n 0.001664 170.2100n 0.001671 170.2200n 0.001678 170.2300n 0.001683 170.2400n 0.001688
+ 170.2500n 0.001691 170.2600n 0.001694 170.2700n 0.001696 170.2800n 0.001697 170.2900n 0.001698 170.3000n 0.001697 170.3100n 0.001696 170.3200n 0.001693 170.3300n 0.001690 170.3400n 0.001686 170.3500n 0.001681 170.3600n 0.001675 170.3700n 0.001669 170.3800n 0.001662 170.3900n 0.001653
+ 170.4000n 0.001644 170.4100n 0.001635 170.4200n 0.001624 170.4300n 0.001613 170.4400n 0.001600 170.4500n 0.001587 170.4600n 0.001574 170.4700n 0.001559 170.4800n 0.001544 170.4900n 0.001528 170.5000n 0.001511 170.5100n 0.001494 170.5200n 0.001476 170.5300n 0.001457 170.5400n 0.001438
+ 170.5500n 0.001418 170.5600n 0.001397 170.5700n 0.001376 170.5800n 0.001354 170.5900n 0.001331 170.6000n 0.001308 170.6100n 0.001284 170.6200n 0.001260 170.6300n 0.001236 170.6400n 0.001210 170.6500n 0.001185 170.6600n 0.001158 170.6700n 0.001132 170.6800n 0.001105 170.6900n 0.001077
+ 170.7000n 0.001049 170.7100n 0.001021 170.7200n 0.000992 170.7300n 0.000963 170.7400n 0.000934 170.7500n 0.000905 170.7600n 0.000875 170.7700n 0.000845 170.7800n 0.000814 170.7900n 0.000784 170.8000n 0.000753 170.8100n 0.000722 170.8200n 0.000691 170.8300n 0.000660 170.8400n 0.000628
+ 170.8500n 0.000597 170.8600n 0.000566 170.8700n 0.000534 170.8800n 0.000503 170.8900n 0.000471 170.9000n 0.000440 170.9100n 0.000408 170.9200n 0.000377 170.9300n 0.000345 170.9400n 0.000314 170.9500n 0.000283 170.9600n 0.000252 170.9700n 0.000221 170.9800n 0.000191 170.9900n 0.000160
+ 171.0000n 0.000130 171.0100n 0.000100 171.0200n 0.000070 171.0300n 0.000041 171.0400n 0.000012 171.0500n -0.000017 171.0600n -0.000045 171.0700n -0.000073 171.0800n -0.000101 171.0900n -0.000128 171.1000n -0.000155 171.1100n -0.000181 171.1200n -0.000207 171.1300n -0.000233 171.1400n -0.000258
+ 171.1500n -0.000282 171.1600n -0.000306 171.1700n -0.000330 171.1800n -0.000353 171.1900n -0.000375 171.2000n -0.000397 171.2100n -0.000418 171.2200n -0.000439 171.2300n -0.000459 171.2400n -0.000478 171.2500n -0.000497 171.2600n -0.000515 171.2700n -0.000533 171.2800n -0.000550 171.2900n -0.000566
+ 171.3000n -0.000581 171.3100n -0.000596 171.3200n -0.000610 171.3300n -0.000623 171.3400n -0.000636 171.3500n -0.000648 171.3600n -0.000659 171.3700n -0.000669 171.3800n -0.000679 171.3900n -0.000687 171.4000n -0.000696 171.4100n -0.000703 171.4200n -0.000709 171.4300n -0.000715 171.4400n -0.000720
+ 171.4500n -0.000724 171.4600n -0.000728 171.4700n -0.000730 171.4800n -0.000732 171.4900n -0.000733 171.5000n -0.000734 171.5100n -0.000733 171.5200n -0.000732 171.5300n -0.000730 171.5400n -0.000727 171.5500n -0.000723 171.5600n -0.000719 171.5700n -0.000714 171.5800n -0.000708 171.5900n -0.000701
+ 171.6000n -0.000694 171.6100n -0.000685 171.6200n -0.000676 171.6300n -0.000667 171.6400n -0.000656 171.6500n -0.000645 171.6600n -0.000633 171.6700n -0.000620 171.6800n -0.000607 171.6900n -0.000593 171.7000n -0.000578 171.7100n -0.000563 171.7200n -0.000546 171.7300n -0.000530 171.7400n -0.000512
+ 171.7500n -0.000494 171.7600n -0.000475 171.7700n -0.000456 171.7800n -0.000436 171.7900n -0.000415 171.8000n -0.000394 171.8100n -0.000372 171.8200n -0.000350 171.8300n -0.000327 171.8400n -0.000303 171.8500n -0.000279 171.8600n -0.000255 171.8700n -0.000230 171.8800n -0.000204 171.8900n -0.000178
+ 171.9000n -0.000152 171.9100n -0.000125 171.9200n -0.000097 171.9300n -0.000069 171.9400n -0.000041 171.9500n -0.000013 171.9600n 0.000016 171.9700n 0.000046 171.9800n 0.000075 171.9900n 0.000105 172.0000n 0.000136 172.0100n 0.000166 172.0200n 0.000197 172.0300n 0.000228 172.0400n 0.000260
+ 172.0500n 0.000292 172.0600n 0.000324 172.0700n 0.000356 172.0800n 0.000388 172.0900n 0.000421 172.1000n 0.000453 172.1100n 0.000486 172.1200n 0.000519 172.1300n 0.000552 172.1400n 0.000585 172.1500n 0.000619 172.1600n 0.000652 172.1700n 0.000685 172.1800n 0.000719 172.1900n 0.000752
+ 172.2000n 0.000786 172.2100n 0.000819 172.2200n 0.000853 172.2300n 0.000886 172.2400n 0.000920 172.2500n 0.000953 172.2600n 0.000986 172.2700n 0.001020 172.2800n 0.001053 172.2900n 0.001086 172.3000n 0.001119 172.3100n 0.001151 172.3200n 0.001184 172.3300n 0.001216 172.3400n 0.001249
+ 172.3500n 0.001281 172.3600n 0.001313 172.3700n 0.001344 172.3800n 0.001376 172.3900n 0.001407 172.4000n 0.001438 172.4100n 0.001469 172.4200n 0.001499 172.4300n 0.001529 172.4400n 0.001559 172.4500n 0.001589 172.4600n 0.001618 172.4700n 0.001647 172.4800n 0.001676 172.4900n 0.001704
+ 172.5000n 0.001732 172.5100n 0.001759 172.5200n 0.001787 172.5300n 0.001814 172.5400n 0.001840 172.5500n 0.001866 172.5600n 0.001892 172.5700n 0.001917 172.5800n 0.001942 172.5900n 0.001967 172.6000n 0.001991 172.6100n 0.002015 172.6200n 0.002038 172.6300n 0.002061 172.6400n 0.002083
+ 172.6500n 0.002105 172.6600n 0.002127 172.6700n 0.002148 172.6800n 0.002168 172.6900n 0.002189 172.7000n 0.002208 172.7100n 0.002228 172.7200n 0.002246 172.7300n 0.002265 172.7400n 0.002283 172.7500n 0.002300 172.7600n 0.002317 172.7700n 0.002333 172.7800n 0.002349 172.7900n 0.002365
+ 172.8000n 0.002380 172.8100n 0.002394 172.8200n 0.002408 172.8300n 0.002422 172.8400n 0.002435 172.8500n 0.002448 172.8600n 0.002460 172.8700n 0.002471 172.8800n 0.002482 172.8900n 0.002493 172.9000n 0.002503 172.9100n 0.002513 172.9200n 0.002522 172.9300n 0.002531 172.9400n 0.002539
+ 172.9500n 0.002547 172.9600n 0.002555 172.9700n 0.002562 172.9800n 0.002568 172.9900n 0.002574 173.0000n 0.002579 173.0100n 0.002584 173.0200n 0.002589 173.0300n 0.002593 173.0400n 0.002597 173.0500n 0.002600 173.0600n 0.002603 173.0700n 0.002605 173.0800n 0.002607 173.0900n 0.002609
+ 173.1000n 0.002610 173.1100n 0.002611 173.1200n 0.002611 173.1300n 0.002611 173.1400n 0.002610 173.1500n 0.002609 173.1600n 0.002608 173.1700n 0.002606 173.1800n 0.002604 173.1900n 0.002601 173.2000n 0.002598 173.2100n 0.002595 173.2200n 0.002591 173.2300n 0.002587 173.2400n 0.002583
+ 173.2500n 0.002578 173.2600n 0.002573 173.2700n 0.002567 173.2800n 0.002561 173.2900n 0.002555 173.3000n 0.002549 173.3100n 0.002542 173.3200n 0.002535 173.3300n 0.002527 173.3400n 0.002519 173.3500n 0.002511 173.3600n 0.002503 173.3700n 0.002494 173.3800n 0.002485 173.3900n 0.002475
+ 173.4000n 0.002466 173.4100n 0.002456 173.4200n 0.002446 173.4300n 0.002435 173.4400n 0.002425 173.4500n 0.002414 173.4600n 0.002402 173.4700n 0.002391 173.4800n 0.002379 173.4900n 0.002367 173.5000n 0.002355 173.5100n 0.002342 173.5200n 0.002330 173.5300n 0.002317 173.5400n 0.002304
+ 173.5500n 0.002291 173.5600n 0.002277 173.5700n 0.002263 173.5800n 0.002249 173.5900n 0.002235 173.6000n 0.002221 173.6100n 0.002207 173.6200n 0.002192 173.6300n 0.002177 173.6400n 0.002162 173.6500n 0.002147 173.6600n 0.002132 173.6700n 0.002117 173.6800n 0.002101 173.6900n 0.002085
+ 173.7000n 0.002070 173.7100n 0.002054 173.7200n 0.002038 173.7300n 0.002022 173.7400n 0.002005 173.7500n 0.001989 173.7600n 0.001972 173.7700n 0.001956 173.7800n 0.001939 173.7900n 0.001923 173.8000n 0.001906 173.8100n 0.001889 173.8200n 0.001872 173.8300n 0.001855 173.8400n 0.001838
+ 173.8500n 0.001821 173.8600n 0.001804 173.8700n 0.001787 173.8800n 0.001769 173.8900n 0.001752 173.9000n 0.001735 173.9100n 0.001718 173.9200n 0.001700 173.9300n 0.001683 173.9400n 0.001666 173.9500n 0.001649 173.9600n 0.001631 173.9700n 0.001614 173.9800n 0.001597 173.9900n 0.001580
+ 174.0000n 0.001562 174.0100n 0.001545 174.0200n 0.001528 174.0300n 0.001511 174.0400n 0.001494 174.0500n 0.001477 174.0600n 0.001461 174.0700n 0.001444 174.0800n 0.001427 174.0900n 0.001411 174.1000n 0.001394 174.1100n 0.001378 174.1200n 0.001361 174.1300n 0.001345 174.1400n 0.001329
+ 174.1500n 0.001313 174.1600n 0.001297 174.1700n 0.001282 174.1800n 0.001266 174.1900n 0.001251 174.2000n 0.001235 174.2100n 0.001220 174.2200n 0.001205 174.2300n 0.001191 174.2400n 0.001176 174.2500n 0.001162 174.2600n 0.001147 174.2700n 0.001133 174.2800n 0.001119 174.2900n 0.001106
+ 174.3000n 0.001092 174.3100n 0.001079 174.3200n 0.001066 174.3300n 0.001053 174.3400n 0.001041 174.3500n 0.001029 174.3600n 0.001017 174.3700n 0.001005 174.3800n 0.000993 174.3900n 0.000982 174.4000n 0.000971 174.4100n 0.000960 174.4200n 0.000949 174.4300n 0.000939 174.4400n 0.000929
+ 174.4500n 0.000920 174.4600n 0.000910 174.4700n 0.000901 174.4800n 0.000892 174.4900n 0.000884 174.5000n 0.000876 174.5100n 0.000868 174.5200n 0.000860 174.5300n 0.000853 174.5400n 0.000846 174.5500n 0.000840 174.5600n 0.000833 174.5700n 0.000828 174.5800n 0.000822 174.5900n 0.000817
+ 174.6000n 0.000812 174.6100n 0.000807 174.6200n 0.000803 174.6300n 0.000799 174.6400n 0.000796 174.6500n 0.000793 174.6600n 0.000790 174.6700n 0.000787 174.6800n 0.000785 174.6900n 0.000784 174.7000n 0.000782 174.7100n 0.000781 174.7200n 0.000781 174.7300n 0.000780 174.7400n 0.000781
+ 174.7500n 0.000781 174.7600n 0.000782 174.7700n 0.000783 174.7800n 0.000785 174.7900n 0.000787 174.8000n 0.000789 174.8100n 0.000792 174.8200n 0.000795 174.8300n 0.000798 174.8400n 0.000802 174.8500n 0.000806 174.8600n 0.000810 174.8700n 0.000815 174.8800n 0.000820 174.8900n 0.000826
+ 174.9000n 0.000832 174.9100n 0.000838 174.9200n 0.000844 174.9300n 0.000851 174.9400n 0.000858 174.9500n 0.000866 174.9600n 0.000873 174.9700n 0.000882 174.9800n 0.000890 174.9900n 0.000899 175.0000n 0.000908 175.0100n 0.000917 175.0200n 0.000926 175.0300n 0.000936 175.0400n 0.000946
+ 175.0500n 0.000957 175.0600n 0.000967 175.0700n 0.000978 175.0800n 0.000989 175.0900n 0.001001 175.1000n 0.001012 175.1100n 0.001024 175.1200n 0.001036 175.1300n 0.001048 175.1400n 0.001061 175.1500n 0.001073 175.1600n 0.001086 175.1700n 0.001099 175.1800n 0.001112 175.1900n 0.001125
+ 175.2000n 0.001139 175.2100n 0.001152 175.2200n 0.001166 175.2300n 0.001180 175.2400n 0.001193 175.2500n 0.001207 175.2600n 0.001221 175.2700n 0.001235 175.2800n 0.001249 175.2900n 0.001264 175.3000n 0.001278 175.3100n 0.001292 175.3200n 0.001306 175.3300n 0.001320 175.3400n 0.001334
+ 175.3500n 0.001348 175.3600n 0.001362 175.3700n 0.001377 175.3800n 0.001390 175.3900n 0.001404 175.4000n 0.001418 175.4100n 0.001432 175.4200n 0.001445 175.4300n 0.001459 175.4400n 0.001472 175.4500n 0.001485 175.4600n 0.001498 175.4700n 0.001511 175.4800n 0.001524 175.4900n 0.001536
+ 175.5000n 0.001548 175.5100n 0.001560 175.5200n 0.001572 175.5300n 0.001583 175.5400n 0.001595 175.5500n 0.001606 175.5600n 0.001616 175.5700n 0.001627 175.5800n 0.001637 175.5900n 0.001646 175.6000n 0.001656 175.6100n 0.001665 175.6200n 0.001674 175.6300n 0.001682 175.6400n 0.001690
+ 175.6500n 0.001698 175.6600n 0.001705 175.6700n 0.001711 175.6800n 0.001718 175.6900n 0.001724 175.7000n 0.001729 175.7100n 0.001734 175.7200n 0.001739 175.7300n 0.001743 175.7400n 0.001747 175.7500n 0.001750 175.7600n 0.001753 175.7700n 0.001755 175.7800n 0.001757 175.7900n 0.001758
+ 175.8000n 0.001759 175.8100n 0.001759 175.8200n 0.001758 175.8300n 0.001757 175.8400n 0.001756 175.8500n 0.001754 175.8600n 0.001752 175.8700n 0.001748 175.8800n 0.001745 175.8900n 0.001741 175.9000n 0.001736 175.9100n 0.001730 175.9200n 0.001724 175.9300n 0.001718 175.9400n 0.001711
+ 175.9500n 0.001703 175.9600n 0.001695 175.9700n 0.001686 175.9800n 0.001677 175.9900n 0.001667 176.0000n 0.001656 176.0100n 0.001645 176.0200n 0.001633 176.0300n 0.001621 176.0400n 0.001608 176.0500n 0.001594 176.0600n 0.001580 176.0700n 0.001565 176.0800n 0.001550 176.0900n 0.001534
+ 176.1000n 0.001518 176.1100n 0.001501 176.1200n 0.001483 176.1300n 0.001465 176.1400n 0.001447 176.1500n 0.001428 176.1600n 0.001408 176.1700n 0.001388 176.1800n 0.001367 176.1900n 0.001346 176.2000n 0.001324 176.2100n 0.001302 176.2200n 0.001279 176.2300n 0.001256 176.2400n 0.001232
+ 176.2500n 0.001208 176.2600n 0.001184 176.2700n 0.001159 176.2800n 0.001133 176.2900n 0.001107 176.3000n 0.001081 176.3100n 0.001055 176.3200n 0.001027 176.3300n 0.001000 176.3400n 0.000972 176.3500n 0.000944 176.3600n 0.000916 176.3700n 0.000887 176.3800n 0.000858 176.3900n 0.000829
+ 176.4000n 0.000799 176.4100n 0.000769 176.4200n 0.000739 176.4300n 0.000708 176.4400n 0.000678 176.4500n 0.000647 176.4600n 0.000616 176.4700n 0.000585 176.4800n 0.000554 176.4900n 0.000522 176.5000n 0.000490 176.5100n 0.000459 176.5200n 0.000427 176.5300n 0.000395 176.5400n 0.000363
+ 176.5500n 0.000331 176.5600n 0.000299 176.5700n 0.000267 176.5800n 0.000235 176.5900n 0.000203 176.6000n 0.000171 176.6100n 0.000139 176.6200n 0.000107 176.6300n 0.000076 176.6400n 0.000044 176.6500n 0.000012 176.6600n -0.000019 176.6700n -0.000050 176.6800n -0.000081 176.6900n -0.000112
+ 176.7000n -0.000143 176.7100n -0.000173 176.7200n -0.000204 176.7300n -0.000234 176.7400n -0.000263 176.7500n -0.000293 176.7600n -0.000322 176.7700n -0.000351 176.7800n -0.000379 176.7900n -0.000407 176.8000n -0.000435 176.8100n -0.000462 176.8200n -0.000489 176.8300n -0.000516 176.8400n -0.000542
+ 176.8500n -0.000568 176.8600n -0.000593 176.8700n -0.000618 176.8800n -0.000642 176.8900n -0.000666 176.9000n -0.000690 176.9100n -0.000713 176.9200n -0.000735 176.9300n -0.000757 176.9400n -0.000778 176.9500n -0.000799 176.9600n -0.000819 176.9700n -0.000839 176.9800n -0.000858 176.9900n -0.000876
+ 177.0000n -0.000894 177.0100n -0.000911 177.0200n -0.000928 177.0300n -0.000944 177.0400n -0.000959 177.0500n -0.000974 177.0600n -0.000988 177.0700n -0.001002 177.0800n -0.001015 177.0900n -0.001027 177.1000n -0.001038 177.1100n -0.001049 177.1200n -0.001059 177.1300n -0.001069 177.1400n -0.001077
+ 177.1500n -0.001086 177.1600n -0.001093 177.1700n -0.001100 177.1800n -0.001106 177.1900n -0.001111 177.2000n -0.001116 177.2100n -0.001120 177.2200n -0.001123 177.2300n -0.001126 177.2400n -0.001128 177.2500n -0.001129 177.2600n -0.001130 177.2700n -0.001130 177.2800n -0.001129 177.2900n -0.001128
+ 177.3000n -0.001126 177.3100n -0.001123 177.3200n -0.001120 177.3300n -0.001116 177.3400n -0.001111 177.3500n -0.001106 177.3600n -0.001100 177.3700n -0.001094 177.3800n -0.001087 177.3900n -0.001079 177.4000n -0.001071 177.4100n -0.001062 177.4200n -0.001053 177.4300n -0.001043 177.4400n -0.001032
+ 177.4500n -0.001021 177.4600n -0.001010 177.4700n -0.000997 177.4800n -0.000985 177.4900n -0.000972 177.5000n -0.000958 177.5100n -0.000944 177.5200n -0.000930 177.5300n -0.000915 177.5400n -0.000899 177.5500n -0.000883 177.5600n -0.000867 177.5700n -0.000851 177.5800n -0.000834 177.5900n -0.000816
+ 177.6000n -0.000798 177.6100n -0.000780 177.6200n -0.000762 177.6300n -0.000743 177.6400n -0.000725 177.6500n -0.000705 177.6600n -0.000686 177.6700n -0.000666 177.6800n -0.000646 177.6900n -0.000626 177.7000n -0.000606 177.7100n -0.000585 177.7200n -0.000565 177.7300n -0.000544 177.7400n -0.000523
+ 177.7500n -0.000502 177.7600n -0.000481 177.7700n -0.000460 177.7800n -0.000438 177.7900n -0.000417 177.8000n -0.000396 177.8100n -0.000374 177.8200n -0.000353 177.8300n -0.000332 177.8400n -0.000310 177.8500n -0.000289 177.8600n -0.000268 177.8700n -0.000247 177.8800n -0.000226 177.8900n -0.000205
+ 177.9000n -0.000185 177.9100n -0.000164 177.9200n -0.000144 177.9300n -0.000124 177.9400n -0.000104 177.9500n -0.000084 177.9600n -0.000064 177.9700n -0.000045 177.9800n -0.000026 177.9900n -0.000007 178.0000n 0.000012 178.0100n 0.000030 178.0200n 0.000048 178.0300n 0.000065 178.0400n 0.000083
+ 178.0500n 0.000099 178.0600n 0.000116 178.0700n 0.000132 178.0800n 0.000148 178.0900n 0.000164 178.1000n 0.000179 178.1100n 0.000193 178.1200n 0.000207 178.1300n 0.000221 178.1400n 0.000235 178.1500n 0.000247 178.1600n 0.000260 178.1700n 0.000272 178.1800n 0.000283 178.1900n 0.000294
+ 178.2000n 0.000305 178.2100n 0.000315 178.2200n 0.000325 178.2300n 0.000334 178.2400n 0.000342 178.2500n 0.000350 178.2600n 0.000358 178.2700n 0.000365 178.2800n 0.000371 178.2900n 0.000377 178.3000n 0.000383 178.3100n 0.000388 178.3200n 0.000392 178.3300n 0.000396 178.3400n 0.000399
+ 178.3500n 0.000402 178.3600n 0.000404 178.3700n 0.000406 178.3800n 0.000407 178.3900n 0.000408 178.4000n 0.000408 178.4100n 0.000407 178.4200n 0.000406 178.4300n 0.000405 178.4400n 0.000403 178.4500n 0.000400 178.4600n 0.000397 178.4700n 0.000393 178.4800n 0.000389 178.4900n 0.000384
+ 178.5000n 0.000379 178.5100n 0.000374 178.5200n 0.000368 178.5300n 0.000361 178.5400n 0.000354 178.5500n 0.000346 178.5600n 0.000338 178.5700n 0.000330 178.5800n 0.000321 178.5900n 0.000312 178.6000n 0.000302 178.6100n 0.000292 178.6200n 0.000281 178.6300n 0.000270 178.6400n 0.000259
+ 178.6500n 0.000247 178.6600n 0.000235 178.6700n 0.000222 178.6800n 0.000209 178.6900n 0.000196 178.7000n 0.000182 178.7100n 0.000168 178.7200n 0.000154 178.7300n 0.000140 178.7400n 0.000125 178.7500n 0.000110 178.7600n 0.000094 178.7700n 0.000079 178.7800n 0.000063 178.7900n 0.000047
+ 178.8000n 0.000031 178.8100n 0.000014 178.8200n -0.000002 178.8300n -0.000019 178.8400n -0.000036 178.8500n -0.000053 178.8600n -0.000071 178.8700n -0.000088 178.8800n -0.000106 178.8900n -0.000123 178.9000n -0.000141 178.9100n -0.000159 178.9200n -0.000177 178.9300n -0.000195 178.9400n -0.000213
+ 178.9500n -0.000231 178.9600n -0.000249 178.9700n -0.000267 178.9800n -0.000285 178.9900n -0.000303 179.0000n -0.000321 179.0100n -0.000338 179.0200n -0.000356 179.0300n -0.000374 179.0400n -0.000392 179.0500n -0.000409 179.0600n -0.000427 179.0700n -0.000444 179.0800n -0.000461 179.0900n -0.000478
+ 179.1000n -0.000495 179.1100n -0.000512 179.1200n -0.000529 179.1300n -0.000545 179.1400n -0.000561 179.1500n -0.000577 179.1600n -0.000593 179.1700n -0.000609 179.1800n -0.000624 179.1900n -0.000639 179.2000n -0.000654 179.2100n -0.000669 179.2200n -0.000683 179.2300n -0.000697 179.2400n -0.000711
+ 179.2500n -0.000725 179.2600n -0.000738 179.2700n -0.000751 179.2800n -0.000764 179.2900n -0.000776 179.3000n -0.000788 179.3100n -0.000800 179.3200n -0.000811 179.3300n -0.000823 179.3400n -0.000833 179.3500n -0.000844 179.3600n -0.000854 179.3700n -0.000864 179.3800n -0.000873 179.3900n -0.000882
+ 179.4000n -0.000891 179.4100n -0.000899 179.4200n -0.000907 179.4300n -0.000915 179.4400n -0.000922 179.4500n -0.000929 179.4600n -0.000936 179.4700n -0.000942 179.4800n -0.000948 179.4900n -0.000953 179.5000n -0.000958 179.5100n -0.000963 179.5200n -0.000968 179.5300n -0.000972 179.5400n -0.000975
+ 179.5500n -0.000979 179.5600n -0.000982 179.5700n -0.000985 179.5800n -0.000987 179.5900n -0.000989 179.6000n -0.000991 179.6100n -0.000992 179.6200n -0.000993 179.6300n -0.000994 179.6400n -0.000994 179.6500n -0.000994 179.6600n -0.000994 179.6700n -0.000993 179.6800n -0.000992 179.6900n -0.000991
+ 179.7000n -0.000990 179.7100n -0.000988 179.7200n -0.000986 179.7300n -0.000984 179.7400n -0.000981 179.7500n -0.000978 179.7600n -0.000975 179.7700n -0.000972 179.7800n -0.000969 179.7900n -0.000965 179.8000n -0.000961 179.8100n -0.000957 179.8200n -0.000952 179.8300n -0.000948 179.8400n -0.000943
+ 179.8500n -0.000938 179.8600n -0.000933 179.8700n -0.000927 179.8800n -0.000922 179.8900n -0.000916 179.9000n -0.000911 179.9100n -0.000905 179.9200n -0.000899 179.9300n -0.000892 179.9400n -0.000886 179.9500n -0.000880 179.9600n -0.000873 179.9700n -0.000866 179.9800n -0.000860 179.9900n -0.000853
+ 180.0000n -0.000846 180.0100n -0.000839 180.0200n -0.000832 180.0300n -0.000825 180.0400n -0.000818 180.0500n -0.000811 180.0600n -0.000804 180.0700n -0.000797 180.0800n -0.000790 180.0900n -0.000783 180.1000n -0.000776 180.1100n -0.000769 180.1200n -0.000762 180.1300n -0.000755 180.1400n -0.000748
+ 180.1500n -0.000741 180.1600n -0.000734 180.1700n -0.000727 180.1800n -0.000720 180.1900n -0.000713 180.2000n -0.000707 180.2100n -0.000700 180.2200n -0.000694 180.2300n -0.000687 180.2400n -0.000681 180.2500n -0.000675 180.2600n -0.000668 180.2700n -0.000662 180.2800n -0.000656 180.2900n -0.000651
+ 180.3000n -0.000645 180.3100n -0.000639 180.3200n -0.000634 180.3300n -0.000628 180.3400n -0.000623 180.3500n -0.000618 180.3600n -0.000613 180.3700n -0.000608 180.3800n -0.000603 180.3900n -0.000598 180.4000n -0.000594 180.4100n -0.000589 180.4200n -0.000585 180.4300n -0.000581 180.4400n -0.000577
+ 180.4500n -0.000573 180.4600n -0.000569 180.4700n -0.000566 180.4800n -0.000562 180.4900n -0.000559 180.5000n -0.000556 180.5100n -0.000553 180.5200n -0.000550 180.5300n -0.000547 180.5400n -0.000544 180.5500n -0.000542 180.5600n -0.000539 180.5700n -0.000537 180.5800n -0.000534 180.5900n -0.000532
+ 180.6000n -0.000530 180.6100n -0.000528 180.6200n -0.000526 180.6300n -0.000524 180.6400n -0.000523 180.6500n -0.000521 180.6600n -0.000519 180.6700n -0.000518 180.6800n -0.000516 180.6900n -0.000515 180.7000n -0.000514 180.7100n -0.000513 180.7200n -0.000511 180.7300n -0.000510 180.7400n -0.000509
+ 180.7500n -0.000508 180.7600n -0.000507 180.7700n -0.000506 180.7800n -0.000504 180.7900n -0.000503 180.8000n -0.000502 180.8100n -0.000501 180.8200n -0.000500 180.8300n -0.000499 180.8400n -0.000497 180.8500n -0.000496 180.8600n -0.000495 180.8700n -0.000493 180.8800n -0.000492 180.8900n -0.000491
+ 180.9000n -0.000489 180.9100n -0.000487 180.9200n -0.000485 180.9300n -0.000484 180.9400n -0.000482 180.9500n -0.000480 180.9600n -0.000477 180.9700n -0.000475 180.9800n -0.000472 180.9900n -0.000470 181.0000n -0.000467 181.0100n -0.000464 181.0200n -0.000461 181.0300n -0.000458 181.0400n -0.000454
+ 181.0500n -0.000451 181.0600n -0.000447 181.0700n -0.000443 181.0800n -0.000438 181.0900n -0.000434 181.1000n -0.000429 181.1100n -0.000424 181.1200n -0.000419 181.1300n -0.000414 181.1400n -0.000408 181.1500n -0.000402 181.1600n -0.000396 181.1700n -0.000390 181.1800n -0.000383 181.1900n -0.000376
+ 181.2000n -0.000369 181.2100n -0.000361 181.2200n -0.000354 181.2300n -0.000346 181.2400n -0.000337 181.2500n -0.000329 181.2600n -0.000320 181.2700n -0.000310 181.2800n -0.000301 181.2900n -0.000291 181.3000n -0.000281 181.3100n -0.000270 181.3200n -0.000260 181.3300n -0.000248 181.3400n -0.000237
+ 181.3500n -0.000225 181.3600n -0.000213 181.3700n -0.000201 181.3800n -0.000188 181.3900n -0.000175 181.4000n -0.000162 181.4100n -0.000148 181.4200n -0.000134 181.4300n -0.000120 181.4400n -0.000105 181.4500n -0.000090 181.4600n -0.000074 181.4700n -0.000059 181.4800n -0.000043 181.4900n -0.000027
+ 181.5000n -0.000010 181.5100n 0.000007 181.5200n 0.000024 181.5300n 0.000042 181.5400n 0.000060 181.5500n 0.000078 181.5600n 0.000096 181.5700n 0.000115 181.5800n 0.000134 181.5900n 0.000153 181.6000n 0.000173 181.6100n 0.000193 181.6200n 0.000213 181.6300n 0.000233 181.6400n 0.000254
+ 181.6500n 0.000275 181.6600n 0.000296 181.6700n 0.000317 181.6800n 0.000339 181.6900n 0.000361 181.7000n 0.000383 181.7100n 0.000405 181.7200n 0.000428 181.7300n 0.000450 181.7400n 0.000473 181.7500n 0.000496 181.7600n 0.000520 181.7700n 0.000543 181.7800n 0.000567 181.7900n 0.000590
+ 181.8000n 0.000614 181.8100n 0.000638 181.8200n 0.000662 181.8300n 0.000686 181.8400n 0.000711 181.8500n 0.000735 181.8600n 0.000760 181.8700n 0.000784 181.8800n 0.000809 181.8900n 0.000833 181.9000n 0.000858 181.9100n 0.000883 181.9200n 0.000908 181.9300n 0.000932 181.9400n 0.000957
+ 181.9500n 0.000982 181.9600n 0.001006 181.9700n 0.001031 181.9800n 0.001056 181.9900n 0.001080 182.0000n 0.001105 182.0100n 0.001129 182.0200n 0.001153 182.0300n 0.001178 182.0400n 0.001202 182.0500n 0.001226 182.0600n 0.001250 182.0700n 0.001273 182.0800n 0.001297 182.0900n 0.001320
+ 182.1000n 0.001343 182.1100n 0.001366 182.1200n 0.001389 182.1300n 0.001411 182.1400n 0.001434 182.1500n 0.001456 182.1600n 0.001478 182.1700n 0.001499 182.1800n 0.001520 182.1900n 0.001541 182.2000n 0.001562 182.2100n 0.001582 182.2200n 0.001602 182.2300n 0.001622 182.2400n 0.001641
+ 182.2500n 0.001661 182.2600n 0.001679 182.2700n 0.001697 182.2800n 0.001715 182.2900n 0.001733 182.3000n 0.001750 182.3100n 0.001767 182.3200n 0.001783 182.3300n 0.001799 182.3400n 0.001814 182.3500n 0.001829 182.3600n 0.001844 182.3700n 0.001858 182.3800n 0.001871 182.3900n 0.001884
+ 182.4000n 0.001897 182.4100n 0.001909 182.4200n 0.001920 182.4300n 0.001931 182.4400n 0.001942 182.4500n 0.001952 182.4600n 0.001961 182.4700n 0.001970 182.4800n 0.001978 182.4900n 0.001986 182.5000n 0.001993 182.5100n 0.001999 182.5200n 0.002005 182.5300n 0.002011 182.5400n 0.002016
+ 182.5500n 0.002020 182.5600n 0.002023 182.5700n 0.002026 182.5800n 0.002029 182.5900n 0.002031 182.6000n 0.002032 182.6100n 0.002032 182.6200n 0.002032 182.6300n 0.002031 182.6400n 0.002030 182.6500n 0.002028 182.6600n 0.002025 182.6700n 0.002022 182.6800n 0.002018 182.6900n 0.002013
+ 182.7000n 0.002008 182.7100n 0.002002 182.7200n 0.001995 182.7300n 0.001988 182.7400n 0.001980 182.7500n 0.001971 182.7600n 0.001962 182.7700n 0.001952 182.7800n 0.001942 182.7900n 0.001931 182.8000n 0.001919 182.8100n 0.001906 182.8200n 0.001893 182.8300n 0.001879 182.8400n 0.001865
+ 182.8500n 0.001850 182.8600n 0.001834 182.8700n 0.001817 182.8800n 0.001800 182.8900n 0.001783 182.9000n 0.001764 182.9100n 0.001745 182.9200n 0.001726 182.9300n 0.001706 182.9400n 0.001685 182.9500n 0.001663 182.9600n 0.001641 182.9700n 0.001619 182.9800n 0.001595 182.9900n 0.001571
+ 183.0000n 0.001547 183.0100n 0.001522 183.0200n 0.001496 183.0300n 0.001470 183.0400n 0.001444 183.0500n 0.001416 183.0600n 0.001388 183.0700n 0.001360 183.0800n 0.001331 183.0900n 0.001302 183.1000n 0.001272 183.1100n 0.001241 183.1200n 0.001210 183.1300n 0.001179 183.1400n 0.001147
+ 183.1500n 0.001115 183.1600n 0.001082 183.1700n 0.001049 183.1800n 0.001015 183.1900n 0.000981 183.2000n 0.000946 183.2100n 0.000911 183.2200n 0.000876 183.2300n 0.000840 183.2400n 0.000804 183.2500n 0.000767 183.2600n 0.000730 183.2700n 0.000693 183.2800n 0.000655 183.2900n 0.000617
+ 183.3000n 0.000579 183.3100n 0.000540 183.3200n 0.000501 183.3300n 0.000462 183.3400n 0.000423 183.3500n 0.000383 183.3600n 0.000343 183.3700n 0.000303 183.3800n 0.000263 183.3900n 0.000222 183.4000n 0.000182 183.4100n 0.000141 183.4200n 0.000100 183.4300n 0.000058 183.4400n 0.000017
+ 183.4500n -0.000024 183.4600n -0.000066 183.4700n -0.000108 183.4800n -0.000150 183.4900n -0.000191 183.5000n -0.000233 183.5100n -0.000275 183.5200n -0.000317 183.5300n -0.000359 183.5400n -0.000401 183.5500n -0.000443 183.5600n -0.000485 183.5700n -0.000527 183.5800n -0.000569 183.5900n -0.000610
+ 183.6000n -0.000652 183.6100n -0.000694 183.6200n -0.000735 183.6300n -0.000776 183.6400n -0.000817 183.6500n -0.000858 183.6600n -0.000899 183.6700n -0.000940 183.6800n -0.000980 183.6900n -0.001020 183.7000n -0.001060 183.7100n -0.001100 183.7200n -0.001139 183.7300n -0.001179 183.7400n -0.001218
+ 183.7500n -0.001256 183.7600n -0.001294 183.7700n -0.001332 183.7800n -0.001370 183.7900n -0.001407 183.8000n -0.001444 183.8100n -0.001480 183.8200n -0.001516 183.8300n -0.001552 183.8400n -0.001587 183.8500n -0.001622 183.8600n -0.001656 183.8700n -0.001690 183.8800n -0.001723 183.8900n -0.001756
+ 183.9000n -0.001788 183.9100n -0.001820 183.9200n -0.001851 183.9300n -0.001882 183.9400n -0.001912 183.9500n -0.001941 183.9600n -0.001970 183.9700n -0.001999 183.9800n -0.002027 183.9900n -0.002054 184.0000n -0.002080 184.0100n -0.002106 184.0200n -0.002131 184.0300n -0.002156 184.0400n -0.002180
+ 184.0500n -0.002203 184.0600n -0.002225 184.0700n -0.002247 184.0800n -0.002268 184.0900n -0.002288 184.1000n -0.002308 184.1100n -0.002327 184.1200n -0.002345 184.1300n -0.002362 184.1400n -0.002379 184.1500n -0.002395 184.1600n -0.002410 184.1700n -0.002424 184.1800n -0.002437 184.1900n -0.002450
+ 184.2000n -0.002462 184.2100n -0.002473 184.2200n -0.002483 184.2300n -0.002492 184.2400n -0.002501 184.2500n -0.002508 184.2600n -0.002515 184.2700n -0.002521 184.2800n -0.002526 184.2900n -0.002531 184.3000n -0.002534 184.3100n -0.002537 184.3200n -0.002538 184.3300n -0.002539 184.3400n -0.002539
+ 184.3500n -0.002538 184.3600n -0.002537 184.3700n -0.002534 184.3800n -0.002531 184.3900n -0.002526 184.4000n -0.002521 184.4100n -0.002515 184.4200n -0.002508 184.4300n -0.002500 184.4400n -0.002492 184.4500n -0.002482 184.4600n -0.002472 184.4700n -0.002460 184.4800n -0.002448 184.4900n -0.002435
+ 184.5000n -0.002422 184.5100n -0.002407 184.5200n -0.002392 184.5300n -0.002375 184.5400n -0.002358 184.5500n -0.002340 184.5600n -0.002322 184.5700n -0.002302 184.5800n -0.002282 184.5900n -0.002261 184.6000n -0.002239 184.6100n -0.002216 184.6200n -0.002193 184.6300n -0.002169 184.6400n -0.002144
+ 184.6500n -0.002118 184.6600n -0.002092 184.6700n -0.002065 184.6800n -0.002037 184.6900n -0.002009 184.7000n -0.001980 184.7100n -0.001950 184.7200n -0.001920 184.7300n -0.001889 184.7400n -0.001857 184.7500n -0.001825 184.7600n -0.001792 184.7700n -0.001759 184.7800n -0.001725 184.7900n -0.001691
+ 184.8000n -0.001655 184.8100n -0.001620 184.8200n -0.001584 184.8300n -0.001547 184.8400n -0.001510 184.8500n -0.001473 184.8600n -0.001435 184.8700n -0.001397 184.8800n -0.001358 184.8900n -0.001319 184.9000n -0.001280 184.9100n -0.001240 184.9200n -0.001200 184.9300n -0.001160 184.9400n -0.001119
+ 184.9500n -0.001078 184.9600n -0.001037 184.9700n -0.000996 184.9800n -0.000954 184.9900n -0.000912 185.0000n -0.000870 185.0100n -0.000828 185.0200n -0.000786 185.0300n -0.000744 185.0400n -0.000701 185.0500n -0.000659 185.0600n -0.000616 185.0700n -0.000574 185.0800n -0.000531 185.0900n -0.000489
+ 185.1000n -0.000447 185.1100n -0.000404 185.1200n -0.000362 185.1300n -0.000320 185.1400n -0.000278 185.1500n -0.000236 185.1600n -0.000194 185.1700n -0.000153 185.1800n -0.000111 185.1900n -0.000070 185.2000n -0.000030 185.2100n 0.000011 185.2200n 0.000051 185.2300n 0.000091 185.2400n 0.000131
+ 185.2500n 0.000170 185.2600n 0.000209 185.2700n 0.000247 185.2800n 0.000285 185.2900n 0.000322 185.3000n 0.000359 185.3100n 0.000396 185.3200n 0.000432 185.3300n 0.000468 185.3400n 0.000503 185.3500n 0.000537 185.3600n 0.000571 185.3700n 0.000604 185.3800n 0.000637 185.3900n 0.000669
+ 185.4000n 0.000700 185.4100n 0.000731 185.4200n 0.000761 185.4300n 0.000790 185.4400n 0.000819 185.4500n 0.000847 185.4600n 0.000874 185.4700n 0.000901 185.4800n 0.000926 185.4900n 0.000951 185.5000n 0.000975 185.5100n 0.000999 185.5200n 0.001021 185.5300n 0.001043 185.5400n 0.001063
+ 185.5500n 0.001083 185.5600n 0.001102 185.5700n 0.001121 185.5800n 0.001138 185.5900n 0.001154 185.6000n 0.001170 185.6100n 0.001184 185.6200n 0.001198 185.6300n 0.001211 185.6400n 0.001223 185.6500n 0.001234 185.6600n 0.001243 185.6700n 0.001252 185.6800n 0.001261 185.6900n 0.001268
+ 185.7000n 0.001274 185.7100n 0.001279 185.7200n 0.001283 185.7300n 0.001287 185.7400n 0.001289 185.7500n 0.001290 185.7600n 0.001291 185.7700n 0.001290 185.7800n 0.001289 185.7900n 0.001286 185.8000n 0.001283 185.8100n 0.001278 185.8200n 0.001273 185.8300n 0.001267 185.8400n 0.001260
+ 185.8500n 0.001252 185.8600n 0.001243 185.8700n 0.001233 185.8800n 0.001222 185.8900n 0.001210 185.9000n 0.001198 185.9100n 0.001184 185.9200n 0.001170 185.9300n 0.001155 185.9400n 0.001139 185.9500n 0.001122 185.9600n 0.001104 185.9700n 0.001086 185.9800n 0.001066 185.9900n 0.001046
+ 186.0000n 0.001025 186.0100n 0.001004 186.0200n 0.000982 186.0300n 0.000958 186.0400n 0.000935 186.0500n 0.000910 186.0600n 0.000885 186.0700n 0.000860 186.0800n 0.000833 186.0900n 0.000806 186.1000n 0.000779 186.1100n 0.000751 186.1200n 0.000722 186.1300n 0.000693 186.1400n 0.000663
+ 186.1500n 0.000633 186.1600n 0.000602 186.1700n 0.000571 186.1800n 0.000539 186.1900n 0.000507 186.2000n 0.000475 186.2100n 0.000442 186.2200n 0.000409 186.2300n 0.000376 186.2400n 0.000342 186.2500n 0.000308 186.2600n 0.000274 186.2700n 0.000240 186.2800n 0.000205 186.2900n 0.000170
+ 186.3000n 0.000135 186.3100n 0.000100 186.3200n 0.000065 186.3300n 0.000030 186.3400n -0.000005 186.3500n -0.000040 186.3600n -0.000076 186.3700n -0.000111 186.3800n -0.000146 186.3900n -0.000181 186.4000n -0.000216 186.4100n -0.000251 186.4200n -0.000286 186.4300n -0.000320 186.4400n -0.000354
+ 186.4500n -0.000388 186.4600n -0.000422 186.4700n -0.000456 186.4800n -0.000489 186.4900n -0.000522 186.5000n -0.000555 186.5100n -0.000587 186.5200n -0.000619 186.5300n -0.000650 186.5400n -0.000681 186.5500n -0.000712 186.5600n -0.000742 186.5700n -0.000771 186.5800n -0.000800 186.5900n -0.000829
+ 186.6000n -0.000857 186.6100n -0.000884 186.6200n -0.000911 186.6300n -0.000937 186.6400n -0.000962 186.6500n -0.000987 186.6600n -0.001011 186.6700n -0.001035 186.6800n -0.001057 186.6900n -0.001079 186.7000n -0.001101 186.7100n -0.001121 186.7200n -0.001141 186.7300n -0.001160 186.7400n -0.001178
+ 186.7500n -0.001196 186.7600n -0.001212 186.7700n -0.001228 186.7800n -0.001243 186.7900n -0.001257 186.8000n -0.001270 186.8100n -0.001282 186.8200n -0.001294 186.8300n -0.001304 186.8400n -0.001314 186.8500n -0.001322 186.8600n -0.001330 186.8700n -0.001337 186.8800n -0.001343 186.8900n -0.001348
+ 186.9000n -0.001352 186.9100n -0.001355 186.9200n -0.001358 186.9300n -0.001359 186.9400n -0.001360 186.9500n -0.001359 186.9600n -0.001358 186.9700n -0.001355 186.9800n -0.001352 186.9900n -0.001348 187.0000n -0.001343 187.0100n -0.001337 187.0200n -0.001330 187.0300n -0.001322 187.0400n -0.001313
+ 187.0500n -0.001304 187.0600n -0.001293 187.0700n -0.001282 187.0800n -0.001270 187.0900n -0.001257 187.1000n -0.001243 187.1100n -0.001228 187.1200n -0.001212 187.1300n -0.001196 187.1400n -0.001179 187.1500n -0.001161 187.1600n -0.001143 187.1700n -0.001123 187.1800n -0.001103 187.1900n -0.001082
+ 187.2000n -0.001061 187.2100n -0.001039 187.2200n -0.001016 187.2300n -0.000992 187.2400n -0.000968 187.2500n -0.000943 187.2600n -0.000918 187.2700n -0.000892 187.2800n -0.000866 187.2900n -0.000839 187.3000n -0.000811 187.3100n -0.000783 187.3200n -0.000755 187.3300n -0.000726 187.3400n -0.000697
+ 187.3500n -0.000667 187.3600n -0.000638 187.3700n -0.000607 187.3800n -0.000577 187.3900n -0.000546 187.4000n -0.000515 187.4100n -0.000483 187.4200n -0.000452 187.4300n -0.000420 187.4400n -0.000388 187.4500n -0.000356 187.4600n -0.000323 187.4700n -0.000291 187.4800n -0.000259 187.4900n -0.000226
+ 187.5000n -0.000194 187.5100n -0.000161 187.5200n -0.000129 187.5300n -0.000097 187.5400n -0.000065 187.5500n -0.000032 187.5600n -0.000001 187.5700n 0.000031 187.5800n 0.000063 187.5900n 0.000094 187.6000n 0.000125 187.6100n 0.000156 187.6200n 0.000187 187.6300n 0.000217 187.6400n 0.000247
+ 187.6500n 0.000276 187.6600n 0.000305 187.6700n 0.000334 187.6800n 0.000362 187.6900n 0.000390 187.7000n 0.000417 187.7100n 0.000444 187.7200n 0.000470 187.7300n 0.000496 187.7400n 0.000521 187.7500n 0.000545 187.7600n 0.000569 187.7700n 0.000593 187.7800n 0.000615 187.7900n 0.000637
+ 187.8000n 0.000658 187.8100n 0.000679 187.8200n 0.000699 187.8300n 0.000718 187.8400n 0.000736 187.8500n 0.000754 187.8600n 0.000770 187.8700n 0.000786 187.8800n 0.000801 187.8900n 0.000816 187.9000n 0.000829 187.9100n 0.000842 187.9200n 0.000854 187.9300n 0.000864 187.9400n 0.000874
+ 187.9500n 0.000884 187.9600n 0.000892 187.9700n 0.000899 187.9800n 0.000906 187.9900n 0.000911 188.0000n 0.000916 188.0100n 0.000919 188.0200n 0.000922 188.0300n 0.000924 188.0400n 0.000925 188.0500n 0.000925 188.0600n 0.000924 188.0700n 0.000922 188.0800n 0.000919 188.0900n 0.000915
+ 188.1000n 0.000910 188.1100n 0.000904 188.1200n 0.000898 188.1300n 0.000890 188.1400n 0.000882 188.1500n 0.000872 188.1600n 0.000862 188.1700n 0.000851 188.1800n 0.000839 188.1900n 0.000826 188.2000n 0.000812 188.2100n 0.000798 188.2200n 0.000782 188.2300n 0.000766 188.2400n 0.000749
+ 188.2500n 0.000731 188.2600n 0.000712 188.2700n 0.000692 188.2800n 0.000672 188.2900n 0.000651 188.3000n 0.000629 188.3100n 0.000607 188.3200n 0.000584 188.3300n 0.000560 188.3400n 0.000535 188.3500n 0.000510 188.3600n 0.000484 188.3700n 0.000458 188.3800n 0.000431 188.3900n 0.000403
+ 188.4000n 0.000375 188.4100n 0.000346 188.4200n 0.000317 188.4300n 0.000288 188.4400n 0.000257 188.4500n 0.000227 188.4600n 0.000196 188.4700n 0.000165 188.4800n 0.000133 188.4900n 0.000101 188.5000n 0.000069 188.5100n 0.000036 188.5200n 0.000004 188.5300n -0.000029 188.5400n -0.000063
+ 188.5500n -0.000096 188.5600n -0.000130 188.5700n -0.000163 188.5800n -0.000197 188.5900n -0.000231 188.6000n -0.000265 188.6100n -0.000299 188.6200n -0.000333 188.6300n -0.000366 188.6400n -0.000400 188.6500n -0.000434 188.6600n -0.000468 188.6700n -0.000501 188.6800n -0.000534 188.6900n -0.000567
+ 188.7000n -0.000600 188.7100n -0.000633 188.7200n -0.000665 188.7300n -0.000697 188.7400n -0.000729 188.7500n -0.000760 188.7600n -0.000791 188.7700n -0.000822 188.7800n -0.000852 188.7900n -0.000882 188.8000n -0.000911 188.8100n -0.000940 188.8200n -0.000968 188.8300n -0.000995 188.8400n -0.001023
+ 188.8500n -0.001049 188.8600n -0.001075 188.8700n -0.001100 188.8800n -0.001125 188.8900n -0.001149 188.9000n -0.001172 188.9100n -0.001195 188.9200n -0.001217 188.9300n -0.001238 188.9400n -0.001258 188.9500n -0.001278 188.9600n -0.001297 188.9700n -0.001315 188.9800n -0.001332 188.9900n -0.001349
+ 189.0000n -0.001364 189.0100n -0.001379 189.0200n -0.001393 189.0300n -0.001406 189.0400n -0.001418 189.0500n -0.001429 189.0600n -0.001439 189.0700n -0.001449 189.0800n -0.001457 189.0900n -0.001465 189.1000n -0.001471 189.1100n -0.001477 189.1200n -0.001482 189.1300n -0.001485 189.1400n -0.001488
+ 189.1500n -0.001490 189.1600n -0.001491 189.1700n -0.001491 189.1800n -0.001490 189.1900n -0.001488 189.2000n -0.001485 189.2100n -0.001482 189.2200n -0.001477 189.2300n -0.001471 189.2400n -0.001465 189.2500n -0.001457 189.2600n -0.001449 189.2700n -0.001439 189.2800n -0.001429 189.2900n -0.001418
+ 189.3000n -0.001406 189.3100n -0.001393 189.3200n -0.001380 189.3300n -0.001365 189.3400n -0.001350 189.3500n -0.001333 189.3600n -0.001316 189.3700n -0.001298 189.3800n -0.001280 189.3900n -0.001260 189.4000n -0.001240 189.4100n -0.001219 189.4200n -0.001198 189.4300n -0.001175 189.4400n -0.001152
+ 189.4500n -0.001129 189.4600n -0.001105 189.4700n -0.001080 189.4800n -0.001054 189.4900n -0.001028 189.5000n -0.001002 189.5100n -0.000974 189.5200n -0.000947 189.5300n -0.000919 189.5400n -0.000890 189.5500n -0.000861 189.5600n -0.000831 189.5700n -0.000801 189.5800n -0.000771 189.5900n -0.000741
+ 189.6000n -0.000710 189.6100n -0.000678 189.6200n -0.000647 189.6300n -0.000615 189.6400n -0.000583 189.6500n -0.000551 189.6600n -0.000519 189.6700n -0.000486 189.6800n -0.000454 189.6900n -0.000421 189.7000n -0.000389 189.7100n -0.000356 189.7200n -0.000323 189.7300n -0.000290 189.7400n -0.000258
+ 189.7500n -0.000225 189.7600n -0.000193 189.7700n -0.000160 189.7800n -0.000128 189.7900n -0.000096 189.8000n -0.000064 189.8100n -0.000033 189.8200n -0.000001 189.8300n 0.000030 189.8400n 0.000060 189.8500n 0.000091 189.8600n 0.000121 189.8700n 0.000151 189.8800n 0.000180 189.8900n 0.000209
+ 189.9000n 0.000237 189.9100n 0.000265 189.9200n 0.000292 189.9300n 0.000319 189.9400n 0.000346 189.9500n 0.000372 189.9600n 0.000397 189.9700n 0.000421 189.9800n 0.000445 189.9900n 0.000469 190.0000n 0.000492 190.0100n 0.000514 190.0200n 0.000535 190.0300n 0.000556 190.0400n 0.000576
+ 190.0500n 0.000595 190.0600n 0.000613 190.0700n 0.000631 190.0800n 0.000648 190.0900n 0.000664 190.1000n 0.000679 190.1100n 0.000694 190.1200n 0.000707 190.1300n 0.000720 190.1400n 0.000732 190.1500n 0.000743 190.1600n 0.000754 190.1700n 0.000763 190.1800n 0.000772 190.1900n 0.000779
+ 190.2000n 0.000786 190.2100n 0.000792 190.2200n 0.000797 190.2300n 0.000801 190.2400n 0.000805 190.2500n 0.000807 190.2600n 0.000809 190.2700n 0.000809 190.2800n 0.000809 190.2900n 0.000808 190.3000n 0.000806 190.3100n 0.000803 190.3200n 0.000799 190.3300n 0.000794 190.3400n 0.000789
+ 190.3500n 0.000782 190.3600n 0.000775 190.3700n 0.000767 190.3800n 0.000758 190.3900n 0.000748 190.4000n 0.000738 190.4100n 0.000726 190.4200n 0.000714 190.4300n 0.000701 190.4400n 0.000688 190.4500n 0.000673 190.4600n 0.000658 190.4700n 0.000643 190.4800n 0.000626 190.4900n 0.000609
+ 190.5000n 0.000591 190.5100n 0.000573 190.5200n 0.000554 190.5300n 0.000534 190.5400n 0.000514 190.5500n 0.000493 190.5600n 0.000471 190.5700n 0.000449 190.5800n 0.000427 190.5900n 0.000404 190.6000n 0.000381 190.6100n 0.000357 190.6200n 0.000333 190.6300n 0.000308 190.6400n 0.000283
+ 190.6500n 0.000258 190.6600n 0.000232 190.6700n 0.000207 190.6800n 0.000180 190.6900n 0.000154 190.7000n 0.000127 190.7100n 0.000101 190.7200n 0.000074 190.7300n 0.000047 190.7400n 0.000020 190.7500n -0.000008 190.7600n -0.000035 190.7700n -0.000062 190.7800n -0.000089 190.7900n -0.000117
+ 190.8000n -0.000144 190.8100n -0.000171 190.8200n -0.000198 190.8300n -0.000225 190.8400n -0.000251 190.8500n -0.000278 190.8600n -0.000304 190.8700n -0.000330 190.8800n -0.000356 190.8900n -0.000381 190.9000n -0.000406 190.9100n -0.000431 190.9200n -0.000455 190.9300n -0.000479 190.9400n -0.000503
+ 190.9500n -0.000526 190.9600n -0.000549 190.9700n -0.000571 190.9800n -0.000592 190.9900n -0.000613 191.0000n -0.000634 191.0100n -0.000653 191.0200n -0.000673 191.0300n -0.000691 191.0400n -0.000709 191.0500n -0.000726 191.0600n -0.000743 191.0700n -0.000759 191.0800n -0.000774 191.0900n -0.000788
+ 191.1000n -0.000802 191.1100n -0.000814 191.1200n -0.000826 191.1300n -0.000838 191.1400n -0.000848 191.1500n -0.000857 191.1600n -0.000866 191.1700n -0.000873 191.1800n -0.000880 191.1900n -0.000886 191.2000n -0.000891 191.2100n -0.000895 191.2200n -0.000898 191.2300n -0.000900 191.2400n -0.000902
+ 191.2500n -0.000902 191.2600n -0.000901 191.2700n -0.000899 191.2800n -0.000897 191.2900n -0.000893 191.3000n -0.000888 191.3100n -0.000883 191.3200n -0.000876 191.3300n -0.000868 191.3400n -0.000860 191.3500n -0.000850 191.3600n -0.000839 191.3700n -0.000828 191.3800n -0.000815 191.3900n -0.000802
+ 191.4000n -0.000787 191.4100n -0.000772 191.4200n -0.000755 191.4300n -0.000738 191.4400n -0.000719 191.4500n -0.000700 191.4600n -0.000680 191.4700n -0.000659 191.4800n -0.000636 191.4900n -0.000613 191.5000n -0.000589 191.5100n -0.000565 191.5200n -0.000539 191.5300n -0.000512 191.5400n -0.000485
+ 191.5500n -0.000457 191.5600n -0.000428 191.5700n -0.000398 191.5800n -0.000368 191.5900n -0.000336 191.6000n -0.000304 191.6100n -0.000272 191.6200n -0.000238 191.6300n -0.000204 191.6400n -0.000169 191.6500n -0.000134 191.6600n -0.000098 191.6700n -0.000061 191.6800n -0.000024 191.6900n 0.000013
+ 191.7000n 0.000052 191.7100n 0.000090 191.7200n 0.000130 191.7300n 0.000169 191.7400n 0.000209 191.7500n 0.000250 191.7600n 0.000290 191.7700n 0.000332 191.7800n 0.000373 191.7900n 0.000415 191.8000n 0.000457 191.8100n 0.000499 191.8200n 0.000541 191.8300n 0.000584 191.8400n 0.000627
+ 191.8500n 0.000669 191.8600n 0.000712 191.8700n 0.000755 191.8800n 0.000798 191.8900n 0.000841 191.9000n 0.000884 191.9100n 0.000927 191.9200n 0.000970 191.9300n 0.001013 191.9400n 0.001056 191.9500n 0.001098 191.9600n 0.001141 191.9700n 0.001183 191.9800n 0.001224 191.9900n 0.001266
+ 192.0000n 0.001307 192.0100n 0.001348 192.0200n 0.001389 192.0300n 0.001429 192.0400n 0.001468 192.0500n 0.001508 192.0600n 0.001547 192.0700n 0.001585 192.0800n 0.001623 192.0900n 0.001660 192.1000n 0.001697 192.1100n 0.001733 192.1200n 0.001768 192.1300n 0.001803 192.1400n 0.001837
+ 192.1500n 0.001871 192.1600n 0.001904 192.1700n 0.001936 192.1800n 0.001967 192.1900n 0.001998 192.2000n 0.002028 192.2100n 0.002057 192.2200n 0.002085 192.2300n 0.002112 192.2400n 0.002139 192.2500n 0.002164 192.2600n 0.002189 192.2700n 0.002213 192.2800n 0.002236 192.2900n 0.002258
+ 192.3000n 0.002279 192.3100n 0.002299 192.3200n 0.002318 192.3300n 0.002336 192.3400n 0.002353 192.3500n 0.002369 192.3600n 0.002384 192.3700n 0.002398 192.3800n 0.002412 192.3900n 0.002424 192.4000n 0.002435 192.4100n 0.002444 192.4200n 0.002453 192.4300n 0.002461 192.4400n 0.002468
+ 192.4500n 0.002474 192.4600n 0.002478 192.4700n 0.002482 192.4800n 0.002485 192.4900n 0.002486 192.5000n 0.002486 192.5100n 0.002486 192.5200n 0.002484 192.5300n 0.002481 192.5400n 0.002478 192.5500n 0.002473 192.5600n 0.002467 192.5700n 0.002460 192.5800n 0.002452 192.5900n 0.002443
+ 192.6000n 0.002434 192.6100n 0.002423 192.6200n 0.002411 192.6300n 0.002398 192.6400n 0.002384 192.6500n 0.002369 192.6600n 0.002354 192.6700n 0.002337 192.6800n 0.002320 192.6900n 0.002301 192.7000n 0.002282 192.7100n 0.002262 192.7200n 0.002241 192.7300n 0.002219 192.7400n 0.002196
+ 192.7500n 0.002173 192.7600n 0.002149 192.7700n 0.002124 192.7800n 0.002098 192.7900n 0.002072 192.8000n 0.002045 192.8100n 0.002017 192.8200n 0.001989 192.8300n 0.001960 192.8400n 0.001930 192.8500n 0.001900 192.8600n 0.001869 192.8700n 0.001838 192.8800n 0.001806 192.8900n 0.001774
+ 192.9000n 0.001741 192.9100n 0.001708 192.9200n 0.001674 192.9300n 0.001640 192.9400n 0.001606 192.9500n 0.001571 192.9600n 0.001536 192.9700n 0.001501 192.9800n 0.001465 192.9900n 0.001429 193.0000n 0.001393 193.0100n 0.001357 193.0200n 0.001320 193.0300n 0.001284 193.0400n 0.001247
+ 193.0500n 0.001210 193.0600n 0.001173 193.0700n 0.001136 193.0800n 0.001100 193.0900n 0.001063 193.1000n 0.001026 193.1100n 0.000989 193.1200n 0.000952 193.1300n 0.000916 193.1400n 0.000879 193.1500n 0.000843 193.1600n 0.000807 193.1700n 0.000771 193.1800n 0.000735 193.1900n 0.000700
+ 193.2000n 0.000665 193.2100n 0.000630 193.2200n 0.000596 193.2300n 0.000561 193.2400n 0.000528 193.2500n 0.000494 193.2600n 0.000461 193.2700n 0.000429 193.2800n 0.000397 193.2900n 0.000365 193.3000n 0.000334 193.3100n 0.000303 193.3200n 0.000273 193.3300n 0.000243 193.3400n 0.000214
+ 193.3500n 0.000186 193.3600n 0.000158 193.3700n 0.000131 193.3800n 0.000104 193.3900n 0.000078 193.4000n 0.000053 193.4100n 0.000028 193.4200n 0.000004 193.4300n -0.000019 193.4400n -0.000042 193.4500n -0.000064 193.4600n -0.000085 193.4700n -0.000105 193.4800n -0.000125 193.4900n -0.000144
+ 193.5000n -0.000162 193.5100n -0.000180 193.5200n -0.000196 193.5300n -0.000212 193.5400n -0.000227 193.5500n -0.000242 193.5600n -0.000255 193.5700n -0.000268 193.5800n -0.000280 193.5900n -0.000291 193.6000n -0.000301 193.6100n -0.000311 193.6200n -0.000320 193.6300n -0.000328 193.6400n -0.000335
+ 193.6500n -0.000341 193.6600n -0.000347 193.6700n -0.000351 193.6800n -0.000355 193.6900n -0.000358 193.7000n -0.000361 193.7100n -0.000362 193.7200n -0.000363 193.7300n -0.000363 193.7400n -0.000363 193.7500n -0.000361 193.7600n -0.000359 193.7700n -0.000356 193.7800n -0.000352 193.7900n -0.000348
+ 193.8000n -0.000343 193.8100n -0.000337 193.8200n -0.000330 193.8300n -0.000323 193.8400n -0.000315 193.8500n -0.000307 193.8600n -0.000298 193.8700n -0.000288 193.8800n -0.000278 193.8900n -0.000267 193.9000n -0.000255 193.9100n -0.000243 193.9200n -0.000230 193.9300n -0.000217 193.9400n -0.000203
+ 193.9500n -0.000189 193.9600n -0.000174 193.9700n -0.000159 193.9800n -0.000143 193.9900n -0.000127 194.0000n -0.000110 194.0100n -0.000093 194.0200n -0.000076 194.0300n -0.000058 194.0400n -0.000040 194.0500n -0.000022 194.0600n -0.000003 194.0700n 0.000016 194.0800n 0.000036 194.0900n 0.000055
+ 194.1000n 0.000075 194.1100n 0.000095 194.1200n 0.000116 194.1300n 0.000136 194.1400n 0.000157 194.1500n 0.000178 194.1600n 0.000199 194.1700n 0.000220 194.1800n 0.000241 194.1900n 0.000262 194.2000n 0.000283 194.2100n 0.000305 194.2200n 0.000326 194.2300n 0.000347 194.2400n 0.000369
+ 194.2500n 0.000390 194.2600n 0.000411 194.2700n 0.000433 194.2800n 0.000454 194.2900n 0.000475 194.3000n 0.000496 194.3100n 0.000516 194.3200n 0.000537 194.3300n 0.000557 194.3400n 0.000577 194.3500n 0.000597 194.3600n 0.000617 194.3700n 0.000637 194.3800n 0.000656 194.3900n 0.000675
+ 194.4000n 0.000694 194.4100n 0.000712 194.4200n 0.000730 194.4300n 0.000748 194.4400n 0.000765 194.4500n 0.000782 194.4600n 0.000799 194.4700n 0.000815 194.4800n 0.000831 194.4900n 0.000847 194.5000n 0.000862 194.5100n 0.000877 194.5200n 0.000891 194.5300n 0.000905 194.5400n 0.000918
+ 194.5500n 0.000931 194.5600n 0.000943 194.5700n 0.000955 194.5800n 0.000967 194.5900n 0.000978 194.6000n 0.000988 194.6100n 0.000998 194.6200n 0.001007 194.6300n 0.001016 194.6400n 0.001025 194.6500n 0.001032 194.6600n 0.001040 194.6700n 0.001046 194.6800n 0.001052 194.6900n 0.001058
+ 194.7000n 0.001063 194.7100n 0.001068 194.7200n 0.001071 194.7300n 0.001075 194.7400n 0.001078 194.7500n 0.001080 194.7600n 0.001081 194.7700n 0.001083 194.7800n 0.001083 194.7900n 0.001083 194.8000n 0.001082 194.8100n 0.001081 194.8200n 0.001079 194.8300n 0.001077 194.8400n 0.001074
+ 194.8500n 0.001071 194.8600n 0.001067 194.8700n 0.001062 194.8800n 0.001057 194.8900n 0.001052 194.9000n 0.001045 194.9100n 0.001039 194.9200n 0.001031 194.9300n 0.001024 194.9400n 0.001015 194.9500n 0.001007 194.9600n 0.000997 194.9700n 0.000988 194.9800n 0.000977 194.9900n 0.000967
+ 195.0000n 0.000955 195.0100n 0.000944 195.0200n 0.000931 195.0300n 0.000919 195.0400n 0.000906 195.0500n 0.000892 195.0600n 0.000878 195.0700n 0.000864 195.0800n 0.000849 195.0900n 0.000834 195.1000n 0.000818 195.1100n 0.000802 195.1200n 0.000786 195.1300n 0.000769 195.1400n 0.000752
+ 195.1500n 0.000735 195.1600n 0.000717 195.1700n 0.000699 195.1800n 0.000681 195.1900n 0.000662 195.2000n 0.000643 195.2100n 0.000623 195.2200n 0.000604 195.2300n 0.000584 195.2400n 0.000564 195.2500n 0.000544 195.2600n 0.000523 195.2700n 0.000502 195.2800n 0.000481 195.2900n 0.000460
+ 195.3000n 0.000438 195.3100n 0.000417 195.3200n 0.000395 195.3300n 0.000373 195.3400n 0.000351 195.3500n 0.000328 195.3600n 0.000306 195.3700n 0.000283 195.3800n 0.000261 195.3900n 0.000238 195.4000n 0.000215 195.4100n 0.000192 195.4200n 0.000169 195.4300n 0.000146 195.4400n 0.000123
+ 195.4500n 0.000099 195.4600n 0.000076 195.4700n 0.000053 195.4800n 0.000029 195.4900n 0.000006 195.5000n -0.000018 195.5100n -0.000041 195.5200n -0.000065 195.5300n -0.000088 195.5400n -0.000112 195.5500n -0.000135 195.5600n -0.000159 195.5700n -0.000182 195.5800n -0.000205 195.5900n -0.000229
+ 195.6000n -0.000252 195.6100n -0.000275 195.6200n -0.000298 195.6300n -0.000321 195.6400n -0.000344 195.6500n -0.000367 195.6600n -0.000390 195.6700n -0.000413 195.6800n -0.000436 195.6900n -0.000458 195.7000n -0.000481 195.7100n -0.000503 195.7200n -0.000525 195.7300n -0.000547 195.7400n -0.000569
+ 195.7500n -0.000591 195.7600n -0.000613 195.7700n -0.000635 195.7800n -0.000656 195.7900n -0.000678 195.8000n -0.000699 195.8100n -0.000720 195.8200n -0.000741 195.8300n -0.000762 195.8400n -0.000783 195.8500n -0.000803 195.8600n -0.000824 195.8700n -0.000844 195.8800n -0.000864 195.8900n -0.000884
+ 195.9000n -0.000904 195.9100n -0.000924 195.9200n -0.000943 195.9300n -0.000963 195.9400n -0.000982 195.9500n -0.001001 195.9600n -0.001020 195.9700n -0.001039 195.9800n -0.001057 195.9900n -0.001076 196.0000n -0.001094 196.0100n -0.001112 196.0200n -0.001130 196.0300n -0.001148 196.0400n -0.001166
+ 196.0500n -0.001183 196.0600n -0.001201 196.0700n -0.001218 196.0800n -0.001235 196.0900n -0.001252 196.1000n -0.001269 196.1100n -0.001285 196.1200n -0.001302 196.1300n -0.001318 196.1400n -0.001334 196.1500n -0.001350 196.1600n -0.001366 196.1700n -0.001382 196.1800n -0.001397 196.1900n -0.001412
+ 196.2000n -0.001428 196.2100n -0.001443 196.2200n -0.001458 196.2300n -0.001472 196.2400n -0.001487 196.2500n -0.001501 196.2600n -0.001515 196.2700n -0.001529 196.2800n -0.001543 196.2900n -0.001557 196.3000n -0.001571 196.3100n -0.001584 196.3200n -0.001597 196.3300n -0.001610 196.3400n -0.001623
+ 196.3500n -0.001636 196.3600n -0.001649 196.3700n -0.001661 196.3800n -0.001673 196.3900n -0.001685 196.4000n -0.001697 196.4100n -0.001709 196.4200n -0.001720 196.4300n -0.001732 196.4400n -0.001743 196.4500n -0.001754 196.4600n -0.001764 196.4700n -0.001775 196.4800n -0.001785 196.4900n -0.001795
+ 196.5000n -0.001805 196.5100n -0.001815 196.5200n -0.001824 196.5300n -0.001834 196.5400n -0.001843 196.5500n -0.001852 196.5600n -0.001860 196.5700n -0.001868 196.5800n -0.001877 196.5900n -0.001884 196.6000n -0.001892 196.6100n -0.001899 196.6200n -0.001907 196.6300n -0.001913 196.6400n -0.001920
+ 196.6500n -0.001926 196.6600n -0.001932 196.6700n -0.001938 196.6800n -0.001944 196.6900n -0.001949 196.7000n -0.001954 196.7100n -0.001958 196.7200n -0.001963 196.7300n -0.001967 196.7400n -0.001970 196.7500n -0.001974 196.7600n -0.001977 196.7700n -0.001979 196.7800n -0.001982 196.7900n -0.001984
+ 196.8000n -0.001985 196.8100n -0.001987 196.8200n -0.001988 196.8300n -0.001988 196.8400n -0.001988 196.8500n -0.001988 196.8600n -0.001988 196.8700n -0.001987 196.8800n -0.001985 196.8900n -0.001984 196.9000n -0.001981 196.9100n -0.001979 196.9200n -0.001976 196.9300n -0.001973 196.9400n -0.001969
+ 196.9500n -0.001965 196.9600n -0.001960 196.9700n -0.001955 196.9800n -0.001949 196.9900n -0.001943 197.0000n -0.001937 197.0100n -0.001930 197.0200n -0.001923 197.0300n -0.001915 197.0400n -0.001907 197.0500n -0.001898 197.0600n -0.001889 197.0700n -0.001879 197.0800n -0.001869 197.0900n -0.001859
+ 197.1000n -0.001848 197.1100n -0.001836 197.1200n -0.001824 197.1300n -0.001812 197.1400n -0.001799 197.1500n -0.001785 197.1600n -0.001771 197.1700n -0.001757 197.1800n -0.001742 197.1900n -0.001727 197.2000n -0.001711 197.2100n -0.001694 197.2200n -0.001678 197.2300n -0.001660 197.2400n -0.001642
+ 197.2500n -0.001624 197.2600n -0.001605 197.2700n -0.001586 197.2800n -0.001567 197.2900n -0.001546 197.3000n -0.001526 197.3100n -0.001505 197.3200n -0.001483 197.3300n -0.001461 197.3400n -0.001439 197.3500n -0.001416 197.3600n -0.001393 197.3700n -0.001369 197.3800n -0.001345 197.3900n -0.001321
+ 197.4000n -0.001296 197.4100n -0.001270 197.4200n -0.001245 197.4300n -0.001218 197.4400n -0.001192 197.4500n -0.001165 197.4600n -0.001138 197.4700n -0.001110 197.4800n -0.001082 197.4900n -0.001054 197.5000n -0.001026 197.5100n -0.000997 197.5200n -0.000968 197.5300n -0.000938 197.5400n -0.000909
+ 197.5500n -0.000879 197.5600n -0.000848 197.5700n -0.000818 197.5800n -0.000787 197.5900n -0.000756 197.6000n -0.000725 197.6100n -0.000694 197.6200n -0.000662 197.6300n -0.000631 197.6400n -0.000599 197.6500n -0.000567 197.6600n -0.000535 197.6700n -0.000503 197.6800n -0.000471 197.6900n -0.000439
+ 197.7000n -0.000406 197.7100n -0.000374 197.7200n -0.000341 197.7300n -0.000309 197.7400n -0.000277 197.7500n -0.000244 197.7600n -0.000212 197.7700n -0.000180 197.7800n -0.000147 197.7900n -0.000115 197.8000n -0.000083 197.8100n -0.000052 197.8200n -0.000020 197.8300n 0.000012 197.8400n 0.000043
+ 197.8500n 0.000074 197.8600n 0.000105 197.8700n 0.000136 197.8800n 0.000167 197.8900n 0.000197 197.9000n 0.000227 197.9100n 0.000256 197.9200n 0.000286 197.9300n 0.000315 197.9400n 0.000343 197.9500n 0.000372 197.9600n 0.000399 197.9700n 0.000427 197.9800n 0.000454 197.9900n 0.000481
+ 198.0000n 0.000507 198.0100n 0.000532 198.0200n 0.000558 198.0300n 0.000582 198.0400n 0.000607 198.0500n 0.000630 198.0600n 0.000653 198.0700n 0.000676 198.0800n 0.000698 198.0900n 0.000719 198.1000n 0.000740 198.1100n 0.000760 198.1200n 0.000779 198.1300n 0.000798 198.1400n 0.000816
+ 198.1500n 0.000834 198.1600n 0.000851 198.1700n 0.000867 198.1800n 0.000882 198.1900n 0.000897 198.2000n 0.000911 198.2100n 0.000924 198.2200n 0.000936 198.2300n 0.000948 198.2400n 0.000959 198.2500n 0.000969 198.2600n 0.000978 198.2700n 0.000986 198.2800n 0.000994 198.2900n 0.001001
+ 198.3000n 0.001007 198.3100n 0.001012 198.3200n 0.001016 198.3300n 0.001020 198.3400n 0.001022 198.3500n 0.001024 198.3600n 0.001025 198.3700n 0.001025 198.3800n 0.001024 198.3900n 0.001022 198.4000n 0.001019 198.4100n 0.001016 198.4200n 0.001011 198.4300n 0.001006 198.4400n 0.001000
+ 198.4500n 0.000993 198.4600n 0.000985 198.4700n 0.000976 198.4800n 0.000966 198.4900n 0.000956 198.5000n 0.000944 198.5100n 0.000932 198.5200n 0.000919 198.5300n 0.000905 198.5400n 0.000890 198.5500n 0.000874 198.5600n 0.000857 198.5700n 0.000840 198.5800n 0.000822 198.5900n 0.000803
+ 198.6000n 0.000783 198.6100n 0.000762 198.6200n 0.000740 198.6300n 0.000718 198.6400n 0.000695 198.6500n 0.000671 198.6600n 0.000647 198.6700n 0.000621 198.6800n 0.000595 198.6900n 0.000568 198.7000n 0.000541 198.7100n 0.000513 198.7200n 0.000484 198.7300n 0.000454 198.7400n 0.000424
+ 198.7500n 0.000394 198.7600n 0.000362 198.7700n 0.000330 198.7800n 0.000298 198.7900n 0.000265 198.8000n 0.000231 198.8100n 0.000197 198.8200n 0.000162 198.8300n 0.000127 198.8400n 0.000091 198.8500n 0.000055 198.8600n 0.000019 198.8700n -0.000018 198.8800n -0.000056 198.8900n -0.000093
+ 198.9000n -0.000131 198.9100n -0.000170 198.9200n -0.000208 198.9300n -0.000247 198.9400n -0.000287 198.9500n -0.000326 198.9600n -0.000366 198.9700n -0.000406 198.9800n -0.000446 198.9900n -0.000486 199.0000n -0.000526 199.0100n -0.000566 199.0200n -0.000607 199.0300n -0.000647 199.0400n -0.000688
+ 199.0500n -0.000729 199.0600n -0.000769 199.0700n -0.000810 199.0800n -0.000850 199.0900n -0.000890 199.1000n -0.000931 199.1100n -0.000971 199.1200n -0.001011 199.1300n -0.001050 199.1400n -0.001090 199.1500n -0.001129 199.1600n -0.001168 199.1700n -0.001207 199.1800n -0.001246 199.1900n -0.001284
+ 199.2000n -0.001322 199.2100n -0.001359 199.2200n -0.001396 199.2300n -0.001433 199.2400n -0.001469 199.2500n -0.001505 199.2600n -0.001540 199.2700n -0.001575 199.2800n -0.001609 199.2900n -0.001643 199.3000n -0.001676 199.3100n -0.001708 199.3200n -0.001740 199.3300n -0.001772 199.3400n -0.001802
+ 199.3500n -0.001832 199.3600n -0.001862 199.3700n -0.001890 199.3800n -0.001918 199.3900n -0.001946 199.4000n -0.001972 199.4100n -0.001998 199.4200n -0.002023 199.4300n -0.002047 199.4400n -0.002070 199.4500n -0.002092 199.4600n -0.002114 199.4700n -0.002135 199.4800n -0.002155 199.4900n -0.002174
+ 199.5000n -0.002192 199.5100n -0.002209 199.5200n -0.002225 199.5300n -0.002241 199.5400n -0.002255 199.5500n -0.002269 199.5600n -0.002281 199.5700n -0.002293 199.5800n -0.002304 199.5900n -0.002313 199.6000n -0.002322 199.6100n -0.002329 199.6200n -0.002336 199.6300n -0.002342 199.6400n -0.002346
+ 199.6500n -0.002350 199.6600n -0.002352 199.6700n -0.002354 199.6800n -0.002355 199.6900n -0.002354 199.7000n -0.002353 199.7100n -0.002350 199.7200n -0.002347 199.7300n -0.002342 199.7400n -0.002336 199.7500n -0.002330 199.7600n -0.002322 199.7700n -0.002313 199.7800n -0.002304 199.7900n -0.002293
+ 199.8000n -0.002281 199.8100n -0.002269 199.8200n -0.002255 199.8300n -0.002240 199.8400n -0.002224 199.8500n -0.002208 199.8600n -0.002190 199.8700n -0.002172 199.8800n -0.002152 199.8900n -0.002131 199.9000n -0.002110 199.9100n -0.002088 199.9200n -0.002064 199.9300n -0.002040 199.9400n -0.002015
+ 199.9500n -0.001989 199.9600n -0.001963 199.9700n -0.001935 199.9800n -0.001906 199.9900n -0.001877 200.0000n -0.001847 200.0100n -0.001816 200.0200n -0.001784 200.0300n -0.001752 200.0400n -0.001719 200.0500n -0.001685 200.0600n -0.001650 200.0700n -0.001615 200.0800n -0.001579 200.0900n -0.001542
+ 200.1000n -0.001505 200.1100n -0.001467 200.1200n -0.001428 200.1300n -0.001389 200.1400n -0.001349 200.1500n -0.001309 200.1600n -0.001268 200.1700n -0.001227 200.1800n -0.001185 200.1900n -0.001142 200.2000n -0.001100 200.2100n -0.001056 200.2200n -0.001013 200.2300n -0.000969 200.2400n -0.000924
+ 200.2500n -0.000879 200.2600n -0.000834 200.2700n -0.000789 200.2800n -0.000743 200.2900n -0.000697 200.3000n -0.000651 200.3100n -0.000605 200.3200n -0.000558 200.3300n -0.000511 200.3400n -0.000464 200.3500n -0.000417 200.3600n -0.000370 200.3700n -0.000322 200.3800n -0.000275 200.3900n -0.000227
+ 200.4000n -0.000180 200.4100n -0.000132 200.4200n -0.000085 200.4300n -0.000037 200.4400n 0.000010 200.4500n 0.000058 200.4600n 0.000105 200.4700n 0.000152 200.4800n 0.000199 200.4900n 0.000246 200.5000n 0.000293 200.5100n 0.000340 200.5200n 0.000386 200.5300n 0.000432 200.5400n 0.000478
+ 200.5500n 0.000524 200.5600n 0.000569 200.5700n 0.000614 200.5800n 0.000659 200.5900n 0.000703 200.6000n 0.000748 200.6100n 0.000791 200.6200n 0.000835 200.6300n 0.000878 200.6400n 0.000920 200.6500n 0.000962 200.6600n 0.001004 200.6700n 0.001045 200.6800n 0.001086 200.6900n 0.001127
+ 200.7000n 0.001166 200.7100n 0.001206 200.7200n 0.001244 200.7300n 0.001283 200.7400n 0.001320 200.7500n 0.001358 200.7600n 0.001394 200.7700n 0.001430 200.7800n 0.001466 200.7900n 0.001500 200.8000n 0.001535 200.8100n 0.001568 200.8200n 0.001601 200.8300n 0.001633 200.8400n 0.001665
+ 200.8500n 0.001696 200.8600n 0.001727 200.8700n 0.001756 200.8800n 0.001785 200.8900n 0.001814 200.9000n 0.001841 200.9100n 0.001868 200.9200n 0.001895 200.9300n 0.001920 200.9400n 0.001945 200.9500n 0.001970 200.9600n 0.001993 200.9700n 0.002016 200.9800n 0.002038 200.9900n 0.002060
+ 201.0000n 0.002080 201.0100n 0.002100 201.0200n 0.002120 201.0300n 0.002138 201.0400n 0.002156 201.0500n 0.002173 201.0600n 0.002190 201.0700n 0.002205 201.0800n 0.002221 201.0900n 0.002235 201.1000n 0.002249 201.1100n 0.002262 201.1200n 0.002274 201.1300n 0.002285 201.1400n 0.002296
+ 201.1500n 0.002307 201.1600n 0.002316 201.1700n 0.002325 201.1800n 0.002333 201.1900n 0.002341 201.2000n 0.002348 201.2100n 0.002354 201.2200n 0.002360 201.2300n 0.002365 201.2400n 0.002369 201.2500n 0.002373 201.2600n 0.002376 201.2700n 0.002379 201.2800n 0.002381 201.2900n 0.002382
+ 201.3000n 0.002383 201.3100n 0.002383 201.3200n 0.002383 201.3300n 0.002382 201.3400n 0.002380 201.3500n 0.002379 201.3600n 0.002376 201.3700n 0.002373 201.3800n 0.002370 201.3900n 0.002366 201.4000n 0.002362 201.4100n 0.002357 201.4200n 0.002351 201.4300n 0.002346 201.4400n 0.002339
+ 201.4500n 0.002333 201.4600n 0.002326 201.4700n 0.002318 201.4800n 0.002311 201.4900n 0.002302 201.5000n 0.002294 201.5100n 0.002285 201.5200n 0.002276 201.5300n 0.002266 201.5400n 0.002256 201.5500n 0.002246 201.5600n 0.002236 201.5700n 0.002225 201.5800n 0.002214 201.5900n 0.002203
+ 201.6000n 0.002191 201.6100n 0.002180 201.6200n 0.002168 201.6300n 0.002155 201.6400n 0.002143 201.6500n 0.002130 201.6600n 0.002118 201.6700n 0.002105 201.6800n 0.002092 201.6900n 0.002079 201.7000n 0.002065 201.7100n 0.002052 201.7200n 0.002038 201.7300n 0.002025 201.7400n 0.002011
+ 201.7500n 0.001997 201.7600n 0.001983 201.7700n 0.001969 201.7800n 0.001955 201.7900n 0.001941 201.8000n 0.001927 201.8100n 0.001913 201.8200n 0.001899 201.8300n 0.001885 201.8400n 0.001871 201.8500n 0.001856 201.8600n 0.001842 201.8700n 0.001828 201.8800n 0.001814 201.8900n 0.001801
+ 201.9000n 0.001787 201.9100n 0.001773 201.9200n 0.001759 201.9300n 0.001746 201.9400n 0.001732 201.9500n 0.001719 201.9600n 0.001705 201.9700n 0.001692 201.9800n 0.001679 201.9900n 0.001666 202.0000n 0.001653 202.0100n 0.001640 202.0200n 0.001628 202.0300n 0.001615 202.0400n 0.001603
+ 202.0500n 0.001591 202.0600n 0.001579 202.0700n 0.001567 202.0800n 0.001556 202.0900n 0.001544 202.1000n 0.001533 202.1100n 0.001522 202.1200n 0.001511 202.1300n 0.001500 202.1400n 0.001490 202.1500n 0.001479 202.1600n 0.001469 202.1700n 0.001459 202.1800n 0.001450 202.1900n 0.001440
+ 202.2000n 0.001431 202.2100n 0.001422 202.2200n 0.001413 202.2300n 0.001404 202.2400n 0.001396 202.2500n 0.001388 202.2600n 0.001380 202.2700n 0.001372 202.2800n 0.001364 202.2900n 0.001357 202.3000n 0.001350 202.3100n 0.001343 202.3200n 0.001336 202.3300n 0.001329 202.3400n 0.001323
+ 202.3500n 0.001317 202.3600n 0.001311 202.3700n 0.001305 202.3800n 0.001300 202.3900n 0.001295 202.4000n 0.001290 202.4100n 0.001285 202.4200n 0.001280 202.4300n 0.001275 202.4400n 0.001271 202.4500n 0.001267 202.4600n 0.001263 202.4700n 0.001260 202.4800n 0.001256 202.4900n 0.001253
+ 202.5000n 0.001250 202.5100n 0.001247 202.5200n 0.001244 202.5300n 0.001241 202.5400n 0.001239 202.5500n 0.001236 202.5600n 0.001234 202.5700n 0.001232 202.5800n 0.001230 202.5900n 0.001229 202.6000n 0.001227 202.6100n 0.001226 202.6200n 0.001225 202.6300n 0.001224 202.6400n 0.001223
+ 202.6500n 0.001222 202.6600n 0.001221 202.6700n 0.001220 202.6800n 0.001220 202.6900n 0.001219 202.7000n 0.001219 202.7100n 0.001219 202.7200n 0.001219 202.7300n 0.001219 202.7400n 0.001219 202.7500n 0.001219 202.7600n 0.001219 202.7700n 0.001220 202.7800n 0.001220 202.7900n 0.001221
+ 202.8000n 0.001221 202.8100n 0.001222 202.8200n 0.001222 202.8300n 0.001223 202.8400n 0.001224 202.8500n 0.001225 202.8600n 0.001225 202.8700n 0.001226 202.8800n 0.001227 202.8900n 0.001228 202.9000n 0.001229 202.9100n 0.001230 202.9200n 0.001231 202.9300n 0.001232 202.9400n 0.001233
+ 202.9500n 0.001234 202.9600n 0.001235 202.9700n 0.001236 202.9800n 0.001237 202.9900n 0.001237 203.0000n 0.001238 203.0100n 0.001239 203.0200n 0.001240 203.0300n 0.001241 203.0400n 0.001242 203.0500n 0.001242 203.0600n 0.001243 203.0700n 0.001244 203.0800n 0.001244 203.0900n 0.001245
+ 203.1000n 0.001245 203.1100n 0.001246 203.1200n 0.001246 203.1300n 0.001247 203.1400n 0.001247 203.1500n 0.001247 203.1600n 0.001247 203.1700n 0.001247 203.1800n 0.001247 203.1900n 0.001247 203.2000n 0.001247 203.2100n 0.001247 203.2200n 0.001246 203.2300n 0.001246 203.2400n 0.001245
+ 203.2500n 0.001245 203.2600n 0.001244 203.2700n 0.001243 203.2800n 0.001242 203.2900n 0.001241 203.3000n 0.001240 203.3100n 0.001239 203.3200n 0.001237 203.3300n 0.001236 203.3400n 0.001234 203.3500n 0.001233 203.3600n 0.001231 203.3700n 0.001229 203.3800n 0.001227 203.3900n 0.001225
+ 203.4000n 0.001223 203.4100n 0.001220 203.4200n 0.001218 203.4300n 0.001215 203.4400n 0.001212 203.4500n 0.001209 203.4600n 0.001207 203.4700n 0.001203 203.4800n 0.001200 203.4900n 0.001197 203.5000n 0.001193 203.5100n 0.001190 203.5200n 0.001186 203.5300n 0.001182 203.5400n 0.001178
+ 203.5500n 0.001174 203.5600n 0.001170 203.5700n 0.001165 203.5800n 0.001161 203.5900n 0.001156 203.6000n 0.001151 203.6100n 0.001146 203.6200n 0.001141 203.6300n 0.001136 203.6400n 0.001131 203.6500n 0.001125 203.6600n 0.001119 203.6700n 0.001114 203.6800n 0.001108 203.6900n 0.001102
+ 203.7000n 0.001096 203.7100n 0.001089 203.7200n 0.001083 203.7300n 0.001076 203.7400n 0.001070 203.7500n 0.001063 203.7600n 0.001056 203.7700n 0.001049 203.7800n 0.001042 203.7900n 0.001035 203.8000n 0.001027 203.8100n 0.001020 203.8200n 0.001012 203.8300n 0.001004 203.8400n 0.000996
+ 203.8500n 0.000988 203.8600n 0.000980 203.8700n 0.000971 203.8800n 0.000963 203.8900n 0.000954 203.9000n 0.000946 203.9100n 0.000937 203.9200n 0.000928 203.9300n 0.000919 203.9400n 0.000909 203.9500n 0.000900 203.9600n 0.000891 203.9700n 0.000881 203.9800n 0.000871 203.9900n 0.000862
+ 204.0000n 0.000852 204.0100n 0.000842 204.0200n 0.000832 204.0300n 0.000821 204.0400n 0.000811 204.0500n 0.000800 204.0600n 0.000790 204.0700n 0.000779 204.0800n 0.000768 204.0900n 0.000757 204.1000n 0.000746 204.1100n 0.000735 204.1200n 0.000724 204.1300n 0.000713 204.1400n 0.000701
+ 204.1500n 0.000690 204.1600n 0.000678 204.1700n 0.000666 204.1800n 0.000654 204.1900n 0.000642 204.2000n 0.000630 204.2100n 0.000618 204.2200n 0.000606 204.2300n 0.000594 204.2400n 0.000581 204.2500n 0.000569 204.2600n 0.000556 204.2700n 0.000543 204.2800n 0.000531 204.2900n 0.000518
+ 204.3000n 0.000505 204.3100n 0.000492 204.3200n 0.000479 204.3300n 0.000465 204.3400n 0.000452 204.3500n 0.000439 204.3600n 0.000425 204.3700n 0.000412 204.3800n 0.000398 204.3900n 0.000385 204.4000n 0.000371 204.4100n 0.000357 204.4200n 0.000344 204.4300n 0.000330 204.4400n 0.000316
+ 204.4500n 0.000302 204.4600n 0.000288 204.4700n 0.000274 204.4800n 0.000259 204.4900n 0.000245 204.5000n 0.000231 204.5100n 0.000217 204.5200n 0.000202 204.5300n 0.000188 204.5400n 0.000174 204.5500n 0.000159 204.5600n 0.000145 204.5700n 0.000130 204.5800n 0.000115 204.5900n 0.000101
+ 204.6000n 0.000086 204.6100n 0.000072 204.6200n 0.000057 204.6300n 0.000042 204.6400n 0.000027 204.6500n 0.000013 204.6600n -0.000002 204.6700n -0.000017 204.6800n -0.000032 204.6900n -0.000046 204.7000n -0.000061 204.7100n -0.000076 204.7200n -0.000091 204.7300n -0.000106 204.7400n -0.000120
+ 204.7500n -0.000135 204.7600n -0.000150 204.7700n -0.000165 204.7800n -0.000179 204.7900n -0.000194 204.8000n -0.000209 204.8100n -0.000224 204.8200n -0.000238 204.8300n -0.000253 204.8400n -0.000267 204.8500n -0.000282 204.8600n -0.000297 204.8700n -0.000311 204.8800n -0.000325 204.8900n -0.000340
+ 204.9000n -0.000354 204.9100n -0.000369 204.9200n -0.000383 204.9300n -0.000397 204.9400n -0.000411 204.9500n -0.000425 204.9600n -0.000439 204.9700n -0.000453 204.9800n -0.000467 204.9900n -0.000481 205.0000n -0.000495 205.0100n -0.000508 205.0200n -0.000522 205.0300n -0.000535 205.0400n -0.000549
+ 205.0500n -0.000562 205.0600n -0.000575 205.0700n -0.000588 205.0800n -0.000601 205.0900n -0.000614 205.1000n -0.000627 205.1100n -0.000640 205.1200n -0.000652 205.1300n -0.000665 205.1400n -0.000677 205.1500n -0.000689 205.1600n -0.000701 205.1700n -0.000713 205.1800n -0.000725 205.1900n -0.000737
+ 205.2000n -0.000749 205.2100n -0.000760 205.2200n -0.000771 205.2300n -0.000783 205.2400n -0.000794 205.2500n -0.000805 205.2600n -0.000815 205.2700n -0.000826 205.2800n -0.000836 205.2900n -0.000847 205.3000n -0.000857 205.3100n -0.000867 205.3200n -0.000877 205.3300n -0.000886 205.3400n -0.000896
+ 205.3500n -0.000905 205.3600n -0.000914 205.3700n -0.000923 205.3800n -0.000932 205.3900n -0.000941 205.4000n -0.000949 205.4100n -0.000958 205.4200n -0.000966 205.4300n -0.000974 205.4400n -0.000982 205.4500n -0.000989 205.4600n -0.000996 205.4700n -0.001004 205.4800n -0.001011 205.4900n -0.001018
+ 205.5000n -0.001024 205.5100n -0.001031 205.5200n -0.001037 205.5300n -0.001043 205.5400n -0.001049 205.5500n -0.001054 205.5600n -0.001060 205.5700n -0.001065 205.5800n -0.001070 205.5900n -0.001075 205.6000n -0.001080 205.6100n -0.001084 205.6200n -0.001088 205.6300n -0.001092 205.6400n -0.001096
+ 205.6500n -0.001100 205.6600n -0.001103 205.6700n -0.001106 205.6800n -0.001109 205.6900n -0.001112 205.7000n -0.001115 205.7100n -0.001117 205.7200n -0.001119 205.7300n -0.001121 205.7400n -0.001123 205.7500n -0.001125 205.7600n -0.001126 205.7700n -0.001127 205.7800n -0.001128 205.7900n -0.001129
+ 205.8000n -0.001130 205.8100n -0.001130 205.8200n -0.001130 205.8300n -0.001130 205.8400n -0.001130 205.8500n -0.001129 205.8600n -0.001129 205.8700n -0.001128 205.8800n -0.001127 205.8900n -0.001126 205.9000n -0.001124 205.9100n -0.001123 205.9200n -0.001121 205.9300n -0.001119 205.9400n -0.001117
+ 205.9500n -0.001115 205.9600n -0.001112 205.9700n -0.001109 205.9800n -0.001107 205.9900n -0.001104 206.0000n -0.001100 206.0100n -0.001097 206.0200n -0.001094 206.0300n -0.001090 206.0400n -0.001086 206.0500n -0.001082 206.0600n -0.001078 206.0700n -0.001074 206.0800n -0.001069 206.0900n -0.001064
+ 206.1000n -0.001060 206.1100n -0.001055 206.1200n -0.001050 206.1300n -0.001045 206.1400n -0.001039 206.1500n -0.001034 206.1600n -0.001028 206.1700n -0.001023 206.1800n -0.001017 206.1900n -0.001011 206.2000n -0.001005 206.2100n -0.000999 206.2200n -0.000993 206.2300n -0.000986 206.2400n -0.000980
+ 206.2500n -0.000973 206.2600n -0.000967 206.2700n -0.000960 206.2800n -0.000953 206.2900n -0.000946 206.3000n -0.000939 206.3100n -0.000932 206.3200n -0.000925 206.3300n -0.000918 206.3400n -0.000911 206.3500n -0.000903 206.3600n -0.000896 206.3700n -0.000889 206.3800n -0.000881 206.3900n -0.000874
+ 206.4000n -0.000866 206.4100n -0.000859 206.4200n -0.000851 206.4300n -0.000844 206.4400n -0.000836 206.4500n -0.000829 206.4600n -0.000821 206.4700n -0.000813 206.4800n -0.000806 206.4900n -0.000798 206.5000n -0.000790 206.5100n -0.000783 206.5200n -0.000775 206.5300n -0.000768 206.5400n -0.000760
+ 206.5500n -0.000753 206.5600n -0.000745 206.5700n -0.000738 206.5800n -0.000730 206.5900n -0.000723 206.6000n -0.000716 206.6100n -0.000709 206.6200n -0.000701 206.6300n -0.000694 206.6400n -0.000687 206.6500n -0.000680 206.6600n -0.000673 206.6700n -0.000667 206.6800n -0.000660 206.6900n -0.000653
+ 206.7000n -0.000647 206.7100n -0.000640 206.7200n -0.000634 206.7300n -0.000628 206.7400n -0.000621 206.7500n -0.000615 206.7600n -0.000609 206.7700n -0.000604 206.7800n -0.000598 206.7900n -0.000592 206.8000n -0.000587 206.8100n -0.000582 206.8200n -0.000577 206.8300n -0.000572 206.8400n -0.000567
+ 206.8500n -0.000562 206.8600n -0.000557 206.8700n -0.000553 206.8800n -0.000549 206.8900n -0.000545 206.9000n -0.000541 206.9100n -0.000537 206.9200n -0.000533 206.9300n -0.000530 206.9400n -0.000527 206.9500n -0.000524 206.9600n -0.000521 206.9700n -0.000518 206.9800n -0.000515 206.9900n -0.000513
+ 207.0000n -0.000511 207.0100n -0.000509 207.0200n -0.000507 207.0300n -0.000505 207.0400n -0.000504 207.0500n -0.000503 207.0600n -0.000502 207.0700n -0.000501 207.0800n -0.000500 207.0900n -0.000500 207.1000n -0.000499 207.1100n -0.000499 207.1200n -0.000500 207.1300n -0.000500 207.1400n -0.000500
+ 207.1500n -0.000501 207.1600n -0.000502 207.1700n -0.000503 207.1800n -0.000505 207.1900n -0.000506 207.2000n -0.000508 207.2100n -0.000510 207.2200n -0.000512 207.2300n -0.000515 207.2400n -0.000517 207.2500n -0.000520 207.2600n -0.000523 207.2700n -0.000526 207.2800n -0.000529 207.2900n -0.000533
+ 207.3000n -0.000537 207.3100n -0.000541 207.3200n -0.000545 207.3300n -0.000549 207.3400n -0.000554 207.3500n -0.000558 207.3600n -0.000563 207.3700n -0.000568 207.3800n -0.000573 207.3900n -0.000579 207.4000n -0.000584 207.4100n -0.000590 207.4200n -0.000596 207.4300n -0.000602 207.4400n -0.000608
+ 207.4500n -0.000614 207.4600n -0.000621 207.4700n -0.000627 207.4800n -0.000634 207.4900n -0.000641 207.5000n -0.000648 207.5100n -0.000655 207.5200n -0.000663 207.5300n -0.000670 207.5400n -0.000678 207.5500n -0.000685 207.5600n -0.000693 207.5700n -0.000701 207.5800n -0.000709 207.5900n -0.000717
+ 207.6000n -0.000725 207.6100n -0.000733 207.6200n -0.000741 207.6300n -0.000750 207.6400n -0.000758 207.6500n -0.000766 207.6600n -0.000775 207.6700n -0.000783 207.6800n -0.000792 207.6900n -0.000800 207.7000n -0.000809 207.7100n -0.000818 207.7200n -0.000826 207.7300n -0.000835 207.7400n -0.000844
+ 207.7500n -0.000852 207.7600n -0.000861 207.7700n -0.000869 207.7800n -0.000878 207.7900n -0.000887 207.8000n -0.000895 207.8100n -0.000903 207.8200n -0.000912 207.8300n -0.000920 207.8400n -0.000928 207.8500n -0.000937 207.8600n -0.000945 207.8700n -0.000953 207.8800n -0.000960 207.8900n -0.000968
+ 207.9000n -0.000976 207.9100n -0.000983 207.9200n -0.000991 207.9300n -0.000998 207.9400n -0.001005 207.9500n -0.001012 207.9600n -0.001019 207.9700n -0.001025 207.9800n -0.001032 207.9900n -0.001038 208.0000n -0.001044 208.0100n -0.001050 208.0200n -0.001056 208.0300n -0.001061 208.0400n -0.001067
+ 208.0500n -0.001072 208.0600n -0.001076 208.0700n -0.001081 208.0800n -0.001085 208.0900n -0.001089 208.1000n -0.001093 208.1100n -0.001097 208.1200n -0.001100 208.1300n -0.001103 208.1400n -0.001106 208.1500n -0.001108 208.1600n -0.001110 208.1700n -0.001112 208.1800n -0.001113 208.1900n -0.001115
+ 208.2000n -0.001116 208.2100n -0.001116 208.2200n -0.001116 208.2300n -0.001116 208.2400n -0.001116 208.2500n -0.001115 208.2600n -0.001114 208.2700n -0.001112 208.2800n -0.001111 208.2900n -0.001108 208.3000n -0.001106 208.3100n -0.001103 208.3200n -0.001100 208.3300n -0.001096 208.3400n -0.001092
+ 208.3500n -0.001088 208.3600n -0.001083 208.3700n -0.001078 208.3800n -0.001072 208.3900n -0.001066 208.4000n -0.001060 208.4100n -0.001053 208.4200n -0.001046 208.4300n -0.001038 208.4400n -0.001030 208.4500n -0.001022 208.4600n -0.001013 208.4700n -0.001004 208.4800n -0.000995 208.4900n -0.000985
+ 208.5000n -0.000975 208.5100n -0.000964 208.5200n -0.000953 208.5300n -0.000942 208.5400n -0.000930 208.5500n -0.000917 208.5600n -0.000905 208.5700n -0.000892 208.5800n -0.000879 208.5900n -0.000865 208.6000n -0.000851 208.6100n -0.000836 208.6200n -0.000821 208.6300n -0.000806 208.6400n -0.000791
+ 208.6500n -0.000775 208.6600n -0.000758 208.6700n -0.000742 208.6800n -0.000725 208.6900n -0.000708 208.7000n -0.000690 208.7100n -0.000672 208.7200n -0.000654 208.7300n -0.000635 208.7400n -0.000617 208.7500n -0.000598 208.7600n -0.000578 208.7700n -0.000559 208.7800n -0.000539 208.7900n -0.000519
+ 208.8000n -0.000498 208.8100n -0.000478 208.8200n -0.000457 208.8300n -0.000436 208.8400n -0.000414 208.8500n -0.000393 208.8600n -0.000371 208.8700n -0.000349 208.8800n -0.000327 208.8900n -0.000305 208.9000n -0.000283 208.9100n -0.000260 208.9200n -0.000238 208.9300n -0.000215 208.9400n -0.000192
+ 208.9500n -0.000169 208.9600n -0.000146 208.9700n -0.000123 208.9800n -0.000100 208.9900n -0.000077 209.0000n -0.000054 209.0100n -0.000031 209.0200n -0.000008 209.0300n 0.000015 209.0400n 0.000039 209.0500n 0.000062 209.0600n 0.000085 209.0700n 0.000108 209.0800n 0.000130 209.0900n 0.000153
+ 209.1000n 0.000176 209.1100n 0.000198 209.1200n 0.000221 209.1300n 0.000243 209.1400n 0.000265 209.1500n 0.000287 209.1600n 0.000308 209.1700n 0.000330 209.1800n 0.000351 209.1900n 0.000372 209.2000n 0.000393 209.2100n 0.000413 209.2200n 0.000433 209.2300n 0.000453 209.2400n 0.000473
+ 209.2500n 0.000492 209.2600n 0.000511 209.2700n 0.000529 209.2800n 0.000547 209.2900n 0.000565 209.3000n 0.000582 209.3100n 0.000599 209.3200n 0.000616 209.3300n 0.000632 209.3400n 0.000647 209.3500n 0.000662 209.3600n 0.000677 209.3700n 0.000691 209.3800n 0.000704 209.3900n 0.000717
+ 209.4000n 0.000730 209.4100n 0.000742 209.4200n 0.000753 209.4300n 0.000764 209.4400n 0.000774 209.4500n 0.000784 209.4600n 0.000793 209.4700n 0.000801 209.4800n 0.000809 209.4900n 0.000816 209.5000n 0.000823 209.5100n 0.000828 209.5200n 0.000834 209.5300n 0.000838 209.5400n 0.000842
+ 209.5500n 0.000845 209.5600n 0.000847 209.5700n 0.000848 209.5800n 0.000849 209.5900n 0.000849 209.6000n 0.000849 209.6100n 0.000847 209.6200n 0.000845 209.6300n 0.000842 209.6400n 0.000838 209.6500n 0.000834 209.6600n 0.000828 209.6700n 0.000822 209.6800n 0.000815 209.6900n 0.000808
+ 209.7000n 0.000799 209.7100n 0.000790 209.7200n 0.000780 209.7300n 0.000769 209.7400n 0.000757 209.7500n 0.000744 209.7600n 0.000731 209.7700n 0.000716 209.7800n 0.000701 209.7900n 0.000685 209.8000n 0.000669 209.8100n 0.000651 209.8200n 0.000633 209.8300n 0.000613 209.8400n 0.000593
+ 209.8500n 0.000572 209.8600n 0.000551 209.8700n 0.000528 209.8800n 0.000505 209.8900n 0.000481 209.9000n 0.000456 209.9100n 0.000430 209.9200n 0.000403 209.9300n 0.000376 209.9400n 0.000348 209.9500n 0.000319 209.9600n 0.000289 209.9700n 0.000259 209.9800n 0.000228 209.9900n 0.000196
+ 210.0000n 0.000163 210.0100n 0.000130 210.0200n 0.000096 210.0300n 0.000061 210.0400n 0.000025 210.0500n -0.000011 210.0600n -0.000048 210.0700n -0.000085 210.0800n -0.000123 210.0900n -0.000162 210.1000n -0.000202 210.1100n -0.000242 210.1200n -0.000283 210.1300n -0.000324 210.1400n -0.000366
+ 210.1500n -0.000408 210.1600n -0.000451 210.1700n -0.000495 210.1800n -0.000539 210.1900n -0.000583 210.2000n -0.000628 210.2100n -0.000674 210.2200n -0.000720 210.2300n -0.000766 210.2400n -0.000813 210.2500n -0.000860 210.2600n -0.000908 210.2700n -0.000956 210.2800n -0.001004 210.2900n -0.001053
+ 210.3000n -0.001102 210.3100n -0.001151 210.3200n -0.001200 210.3300n -0.001250 210.3400n -0.001300 210.3500n -0.001350 210.3600n -0.001401 210.3700n -0.001452 210.3800n -0.001502 210.3900n -0.001553 210.4000n -0.001604 210.4100n -0.001655 210.4200n -0.001707 210.4300n -0.001758 210.4400n -0.001809
+ 210.4500n -0.001860 210.4600n -0.001912 210.4700n -0.001963 210.4800n -0.002014 210.4900n -0.002065 210.5000n -0.002117 210.5100n -0.002168 210.5200n -0.002218 210.5300n -0.002269 210.5400n -0.002320 210.5500n -0.002370 210.5600n -0.002420 210.5700n -0.002470 210.5800n -0.002520 210.5900n -0.002569
+ 210.6000n -0.002618 210.6100n -0.002667 210.6200n -0.002716 210.6300n -0.002764 210.6400n -0.002812 210.6500n -0.002859 210.6600n -0.002906 210.6700n -0.002953 210.6800n -0.002999 210.6900n -0.003044 210.7000n -0.003090 210.7100n -0.003134 210.7200n -0.003179 210.7300n -0.003222 210.7400n -0.003265
+ 210.7500n -0.003308 210.7600n -0.003350 210.7700n -0.003391 210.7800n -0.003432 210.7900n -0.003472 210.8000n -0.003512 210.8100n -0.003551 210.8200n -0.003589 210.8300n -0.003627 210.8400n -0.003663 210.8500n -0.003700 210.8600n -0.003735 210.8700n -0.003770 210.8800n -0.003804 210.8900n -0.003837
+ 210.9000n -0.003869 210.9100n -0.003901 210.9200n -0.003932 210.9300n -0.003962 210.9400n -0.003991 210.9500n -0.004019 210.9600n -0.004047 210.9700n -0.004073 210.9800n -0.004099 210.9900n -0.004124 211.0000n -0.004148 211.0100n -0.004172 211.0200n -0.004194 211.0300n -0.004215 211.0400n -0.004236
+ 211.0500n -0.004256 211.0600n -0.004275 211.0700n -0.004292 211.0800n -0.004309 211.0900n -0.004325 211.1000n -0.004341 211.1100n -0.004355 211.1200n -0.004368 211.1300n -0.004381 211.1400n -0.004392 211.1500n -0.004403 211.1600n -0.004412 211.1700n -0.004421 211.1800n -0.004429 211.1900n -0.004436
+ 211.2000n -0.004442 211.2100n -0.004447 211.2200n -0.004451 211.2300n -0.004454 211.2400n -0.004456 211.2500n -0.004458 211.2600n -0.004458 211.2700n -0.004458 211.2800n -0.004456 211.2900n -0.004454 211.3000n -0.004451 211.3100n -0.004447 211.3200n -0.004442 211.3300n -0.004437 211.3400n -0.004430
+ 211.3500n -0.004423 211.3600n -0.004415 211.3700n -0.004405 211.3800n -0.004396 211.3900n -0.004385 211.4000n -0.004373 211.4100n -0.004361 211.4200n -0.004348 211.4300n -0.004334 211.4400n -0.004319 211.4500n -0.004304 211.4600n -0.004288 211.4700n -0.004271 211.4800n -0.004253 211.4900n -0.004235
+ 211.5000n -0.004216 211.5100n -0.004196 211.5200n -0.004176 211.5300n -0.004155 211.5400n -0.004133 211.5500n -0.004110 211.5600n -0.004087 211.5700n -0.004064 211.5800n -0.004040 211.5900n -0.004015 211.6000n -0.003989 211.6100n -0.003963 211.6200n -0.003937 211.6300n -0.003910 211.6400n -0.003882
+ 211.6500n -0.003854 211.6600n -0.003826 211.6700n -0.003797 211.6800n -0.003767 211.6900n -0.003737 211.7000n -0.003707 211.7100n -0.003676 211.7200n -0.003645 211.7300n -0.003613 211.7400n -0.003581 211.7500n -0.003549 211.7600n -0.003516 211.7700n -0.003483 211.7800n -0.003450 211.7900n -0.003416
+ 211.8000n -0.003382 211.8100n -0.003348 211.8200n -0.003313 211.8300n -0.003279 211.8400n -0.003244 211.8500n -0.003208 211.8600n -0.003173 211.8700n -0.003137 211.8800n -0.003102 211.8900n -0.003066 211.9000n -0.003029 211.9100n -0.002993 211.9200n -0.002957 211.9300n -0.002920 211.9400n -0.002883
+ 211.9500n -0.002847 211.9600n -0.002810 211.9700n -0.002773 211.9800n -0.002736 211.9900n -0.002699 212.0000n -0.002662 212.0100n -0.002625 212.0200n -0.002587 212.0300n -0.002550 212.0400n -0.002513 212.0500n -0.002476 212.0600n -0.002439 212.0700n -0.002402 212.0800n -0.002365 212.0900n -0.002327
+ 212.1000n -0.002291 212.1100n -0.002254 212.1200n -0.002217 212.1300n -0.002180 212.1400n -0.002143 212.1500n -0.002107 212.1600n -0.002070 212.1700n -0.002034 212.1800n -0.001998 212.1900n -0.001961 212.2000n -0.001925 212.2100n -0.001889 212.2200n -0.001854 212.2300n -0.001818 212.2400n -0.001782
+ 212.2500n -0.001747 212.2600n -0.001712 212.2700n -0.001677 212.2800n -0.001642 212.2900n -0.001607 212.3000n -0.001573 212.3100n -0.001538 212.3200n -0.001504 212.3300n -0.001470 212.3400n -0.001436 212.3500n -0.001403 212.3600n -0.001369 212.3700n -0.001336 212.3800n -0.001303 212.3900n -0.001270
+ 212.4000n -0.001237 212.4100n -0.001204 212.4200n -0.001172 212.4300n -0.001140 212.4400n -0.001108 212.4500n -0.001076 212.4600n -0.001044 212.4700n -0.001013 212.4800n -0.000981 212.4900n -0.000950 212.5000n -0.000919 212.5100n -0.000888 212.5200n -0.000858 212.5300n -0.000827 212.5400n -0.000797
+ 212.5500n -0.000767 212.5600n -0.000737 212.5700n -0.000707 212.5800n -0.000677 212.5900n -0.000648 212.6000n -0.000619 212.6100n -0.000589 212.6200n -0.000560 212.6300n -0.000532 212.6400n -0.000503 212.6500n -0.000474 212.6600n -0.000446 212.6700n -0.000417 212.6800n -0.000389 212.6900n -0.000361
+ 212.7000n -0.000333 212.7100n -0.000305 212.7200n -0.000278 212.7300n -0.000250 212.7400n -0.000222 212.7500n -0.000195 212.7600n -0.000168 212.7700n -0.000141 212.7800n -0.000113 212.7900n -0.000086 212.8000n -0.000059 212.8100n -0.000033 212.8200n -0.000006 212.8300n 0.000021 212.8400n 0.000048
+ 212.8500n 0.000074 212.8600n 0.000101 212.8700n 0.000127 212.8800n 0.000153 212.8900n 0.000180 212.9000n 0.000206 212.9100n 0.000232 212.9200n 0.000258 212.9300n 0.000284 212.9400n 0.000311 212.9500n 0.000337 212.9600n 0.000363 212.9700n 0.000389 212.9800n 0.000414 212.9900n 0.000440
+ 213.0000n 0.000466 213.0100n 0.000492 213.0200n 0.000518 213.0300n 0.000543 213.0400n 0.000569 213.0500n 0.000595 213.0600n 0.000620 213.0700n 0.000646 213.0800n 0.000672 213.0900n 0.000697 213.1000n 0.000723 213.1100n 0.000748 213.1200n 0.000774 213.1300n 0.000799 213.1400n 0.000824
+ 213.1500n 0.000850 213.1600n 0.000875 213.1700n 0.000900 213.1800n 0.000926 213.1900n 0.000951 213.2000n 0.000976 213.2100n 0.001001 213.2200n 0.001026 213.2300n 0.001051 213.2400n 0.001076 213.2500n 0.001101 213.2600n 0.001126 213.2700n 0.001150 213.2800n 0.001175 213.2900n 0.001200
+ 213.3000n 0.001224 213.3100n 0.001249 213.3200n 0.001273 213.3300n 0.001297 213.3400n 0.001321 213.3500n 0.001346 213.3600n 0.001369 213.3700n 0.001393 213.3800n 0.001417 213.3900n 0.001441 213.4000n 0.001464 213.4100n 0.001487 213.4200n 0.001511 213.4300n 0.001534 213.4400n 0.001556
+ 213.4500n 0.001579 213.4600n 0.001602 213.4700n 0.001624 213.4800n 0.001646 213.4900n 0.001668 213.5000n 0.001690 213.5100n 0.001712 213.5200n 0.001733 213.5300n 0.001754 213.5400n 0.001775 213.5500n 0.001796 213.5600n 0.001816 213.5700n 0.001837 213.5800n 0.001857 213.5900n 0.001876
+ 213.6000n 0.001896 213.6100n 0.001915 213.6200n 0.001934 213.6300n 0.001953 213.6400n 0.001971 213.6500n 0.001989 213.6600n 0.002007 213.6700n 0.002024 213.6800n 0.002041 213.6900n 0.002058 213.7000n 0.002074 213.7100n 0.002090 213.7200n 0.002106 213.7300n 0.002121 213.7400n 0.002136
+ 213.7500n 0.002151 213.7600n 0.002165 213.7700n 0.002179 213.7800n 0.002193 213.7900n 0.002206 213.8000n 0.002218 213.8100n 0.002231 213.8200n 0.002242 213.8300n 0.002254 213.8400n 0.002265 213.8500n 0.002275 213.8600n 0.002286 213.8700n 0.002295 213.8800n 0.002305 213.8900n 0.002313
+ 213.9000n 0.002322 213.9100n 0.002330 213.9200n 0.002337 213.9300n 0.002344 213.9400n 0.002351 213.9500n 0.002357 213.9600n 0.002362 213.9700n 0.002367 213.9800n 0.002372 213.9900n 0.002376 214.0000n 0.002380 214.0100n 0.002383 214.0200n 0.002385 214.0300n 0.002388 214.0400n 0.002389
+ 214.0500n 0.002391 214.0600n 0.002391 214.0700n 0.002392 214.0800n 0.002391 214.0900n 0.002391 214.1000n 0.002389 214.1100n 0.002388 214.1200n 0.002385 214.1300n 0.002383 214.1400n 0.002380 214.1500n 0.002376 214.1600n 0.002372 214.1700n 0.002367 214.1800n 0.002362 214.1900n 0.002357
+ 214.2000n 0.002351 214.2100n 0.002344 214.2200n 0.002338 214.2300n 0.002330 214.2400n 0.002322 214.2500n 0.002314 214.2600n 0.002306 214.2700n 0.002297 214.2800n 0.002287 214.2900n 0.002277 214.3000n 0.002267 214.3100n 0.002256 214.3200n 0.002245 214.3300n 0.002234 214.3400n 0.002222
+ 214.3500n 0.002209 214.3600n 0.002197 214.3700n 0.002184 214.3800n 0.002170 214.3900n 0.002157 214.4000n 0.002143 214.4100n 0.002128 214.4200n 0.002114 214.4300n 0.002099 214.4400n 0.002084 214.4500n 0.002068 214.4600n 0.002052 214.4700n 0.002036 214.4800n 0.002020 214.4900n 0.002003
+ 214.5000n 0.001986 214.5100n 0.001969 214.5200n 0.001952 214.5300n 0.001935 214.5400n 0.001917 214.5500n 0.001899 214.5600n 0.001881 214.5700n 0.001863 214.5800n 0.001845 214.5900n 0.001826 214.6000n 0.001808 214.6100n 0.001789 214.6200n 0.001770 214.6300n 0.001751 214.6400n 0.001733
+ 214.6500n 0.001714 214.6600n 0.001694 214.6700n 0.001675 214.6800n 0.001656 214.6900n 0.001637 214.7000n 0.001618 214.7100n 0.001599 214.7200n 0.001580 214.7300n 0.001560 214.7400n 0.001541 214.7500n 0.001522 214.7600n 0.001503 214.7700n 0.001484 214.7800n 0.001466 214.7900n 0.001447
+ 214.8000n 0.001428 214.8100n 0.001410 214.8200n 0.001391 214.8300n 0.001373 214.8400n 0.001355 214.8500n 0.001337 214.8600n 0.001319 214.8700n 0.001302 214.8800n 0.001284 214.8900n 0.001267 214.9000n 0.001250 214.9100n 0.001233 214.9200n 0.001216 214.9300n 0.001200 214.9400n 0.001184
+ 214.9500n 0.001168 214.9600n 0.001152 214.9700n 0.001137 214.9800n 0.001122 214.9900n 0.001107 215.0000n 0.001092 215.0100n 0.001078 215.0200n 0.001064 215.0300n 0.001050 215.0400n 0.001036 215.0500n 0.001023 215.0600n 0.001011 215.0700n 0.000998 215.0800n 0.000986 215.0900n 0.000974
+ 215.1000n 0.000962 215.1100n 0.000951 215.1200n 0.000940 215.1300n 0.000930 215.1400n 0.000920 215.1500n 0.000910 215.1600n 0.000900 215.1700n 0.000891 215.1800n 0.000882 215.1900n 0.000874 215.2000n 0.000865 215.2100n 0.000858 215.2200n 0.000850 215.2300n 0.000843 215.2400n 0.000836
+ 215.2500n 0.000830 215.2600n 0.000824 215.2700n 0.000818 215.2800n 0.000812 215.2900n 0.000807 215.3000n 0.000803 215.3100n 0.000798 215.3200n 0.000794 215.3300n 0.000790 215.3400n 0.000787 215.3500n 0.000783 215.3600n 0.000781 215.3700n 0.000778 215.3800n 0.000776 215.3900n 0.000774
+ 215.4000n 0.000772 215.4100n 0.000770 215.4200n 0.000769 215.4300n 0.000768 215.4400n 0.000768 215.4500n 0.000767 215.4600n 0.000767 215.4700n 0.000767 215.4800n 0.000767 215.4900n 0.000768 215.5000n 0.000768 215.5100n 0.000769 215.5200n 0.000770 215.5300n 0.000772 215.5400n 0.000773
+ 215.5500n 0.000775 215.5600n 0.000776 215.5700n 0.000778 215.5800n 0.000780 215.5900n 0.000782 215.6000n 0.000785 215.6100n 0.000787 215.6200n 0.000789 215.6300n 0.000792 215.6400n 0.000795 215.6500n 0.000797 215.6600n 0.000800 215.6700n 0.000803 215.6800n 0.000805 215.6900n 0.000808
+ 215.7000n 0.000811 215.7100n 0.000814 215.7200n 0.000817 215.7300n 0.000819 215.7400n 0.000822 215.7500n 0.000825 215.7600n 0.000827 215.7700n 0.000830 215.7800n 0.000832 215.7900n 0.000835 215.8000n 0.000837 215.8100n 0.000839 215.8200n 0.000841 215.8300n 0.000843 215.8400n 0.000845
+ 215.8500n 0.000847 215.8600n 0.000848 215.8700n 0.000849 215.8800n 0.000850 215.8900n 0.000851 215.9000n 0.000852 215.9100n 0.000853 215.9200n 0.000853 215.9300n 0.000853 215.9400n 0.000853 215.9500n 0.000852 215.9600n 0.000852 215.9700n 0.000851 215.9800n 0.000850 215.9900n 0.000848
+ 216.0000n 0.000846 216.0100n 0.000844 216.0200n 0.000842 216.0300n 0.000839 216.0400n 0.000837 216.0500n 0.000833 216.0600n 0.000830 216.0700n 0.000826 216.0800n 0.000822 216.0900n 0.000817 216.1000n 0.000812 216.1100n 0.000807 216.1200n 0.000802 216.1300n 0.000796 216.1400n 0.000789
+ 216.1500n 0.000783 216.1600n 0.000776 216.1700n 0.000769 216.1800n 0.000761 216.1900n 0.000753 216.2000n 0.000745 216.2100n 0.000736 216.2200n 0.000727 216.2300n 0.000717 216.2400n 0.000708 216.2500n 0.000697 216.2600n 0.000687 216.2700n 0.000676 216.2800n 0.000665 216.2900n 0.000653
+ 216.3000n 0.000641 216.3100n 0.000629 216.3200n 0.000617 216.3300n 0.000604 216.3400n 0.000590 216.3500n 0.000577 216.3600n 0.000563 216.3700n 0.000549 216.3800n 0.000534 216.3900n 0.000519 216.4000n 0.000504 216.4100n 0.000489 216.4200n 0.000473 216.4300n 0.000457 216.4400n 0.000441
+ 216.4500n 0.000424 216.4600n 0.000407 216.4700n 0.000390 216.4800n 0.000373 216.4900n 0.000355 216.5000n 0.000338 216.5100n 0.000320 216.5200n 0.000301 216.5300n 0.000283 216.5400n 0.000264 216.5500n 0.000246 216.5600n 0.000227 216.5700n 0.000208 216.5800n 0.000189 216.5900n 0.000169
+ 216.6000n 0.000150 216.6100n 0.000130 216.6200n 0.000110 216.6300n 0.000091 216.6400n 0.000071 216.6500n 0.000051 216.6600n 0.000031 216.6700n 0.000011 216.6800n -0.000009 216.6900n -0.000029 216.7000n -0.000049 216.7100n -0.000069 216.7200n -0.000089 216.7300n -0.000109 216.7400n -0.000129
+ 216.7500n -0.000149 216.7600n -0.000169 216.7700n -0.000188 216.7800n -0.000208 216.7900n -0.000227 216.8000n -0.000247 216.8100n -0.000266 216.8200n -0.000285 216.8300n -0.000304 216.8400n -0.000323 216.8500n -0.000341 216.8600n -0.000360 216.8700n -0.000378 216.8800n -0.000396 216.8900n -0.000414
+ 216.9000n -0.000431 216.9100n -0.000448 216.9200n -0.000465 216.9300n -0.000482 216.9400n -0.000498 216.9500n -0.000514 216.9600n -0.000530 216.9700n -0.000545 216.9800n -0.000561 216.9900n -0.000575 217.0000n -0.000590 217.0100n -0.000604 217.0200n -0.000617 217.0300n -0.000631 217.0400n -0.000643
+ 217.0500n -0.000656 217.0600n -0.000668 217.0700n -0.000680 217.0800n -0.000691 217.0900n -0.000702 217.1000n -0.000712 217.1100n -0.000722 217.1200n -0.000732 217.1300n -0.000741 217.1400n -0.000749 217.1500n -0.000757 217.1600n -0.000765 217.1700n -0.000772 217.1800n -0.000779 217.1900n -0.000785
+ 217.2000n -0.000790 217.2100n -0.000796 217.2200n -0.000800 217.2300n -0.000804 217.2400n -0.000808 217.2500n -0.000811 217.2600n -0.000814 217.2700n -0.000816 217.2800n -0.000818 217.2900n -0.000819 217.3000n -0.000819 217.3100n -0.000819 217.3200n -0.000819 217.3300n -0.000818 217.3400n -0.000817
+ 217.3500n -0.000815 217.3600n -0.000812 217.3700n -0.000809 217.3800n -0.000806 217.3900n -0.000802 217.4000n -0.000798 217.4100n -0.000793 217.4200n -0.000787 217.4300n -0.000781 217.4400n -0.000775 217.4500n -0.000768 217.4600n -0.000761 217.4700n -0.000753 217.4800n -0.000745 217.4900n -0.000737
+ 217.5000n -0.000728 217.5100n -0.000718 217.5200n -0.000708 217.5300n -0.000698 217.5400n -0.000687 217.5500n -0.000676 217.5600n -0.000665 217.5700n -0.000653 217.5800n -0.000640 217.5900n -0.000628 217.6000n -0.000615 217.6100n -0.000602 217.6200n -0.000588 217.6300n -0.000574 217.6400n -0.000560
+ 217.6500n -0.000545 217.6600n -0.000530 217.6700n -0.000515 217.6800n -0.000500 217.6900n -0.000484 217.7000n -0.000469 217.7100n -0.000453 217.7200n -0.000436 217.7300n -0.000420 217.7400n -0.000403 217.7500n -0.000386 217.7600n -0.000369 217.7700n -0.000352 217.7800n -0.000335 217.7900n -0.000317
+ 217.8000n -0.000300 217.8100n -0.000282 217.8200n -0.000265 217.8300n -0.000247 217.8400n -0.000229 217.8500n -0.000211 217.8600n -0.000193 217.8700n -0.000175 217.8800n -0.000157 217.8900n -0.000139 217.9000n -0.000121 217.9100n -0.000103 217.9200n -0.000085 217.9300n -0.000068 217.9400n -0.000050
+ 217.9500n -0.000032 217.9600n -0.000015 217.9700n 0.000003 217.9800n 0.000020 217.9900n 0.000037 218.0000n 0.000054 218.0100n 0.000071 218.0200n 0.000088 218.0300n 0.000105 218.0400n 0.000121 218.0500n 0.000137 218.0600n 0.000153 218.0700n 0.000169 218.0800n 0.000184 218.0900n 0.000200
+ 218.1000n 0.000215 218.1100n 0.000230 218.1200n 0.000244 218.1300n 0.000258 218.1400n 0.000272 218.1500n 0.000286 218.1600n 0.000299 218.1700n 0.000312 218.1800n 0.000325 218.1900n 0.000337 218.2000n 0.000350 218.2100n 0.000361 218.2200n 0.000373 218.2300n 0.000384 218.2400n 0.000394
+ 218.2500n 0.000405 218.2600n 0.000415 218.2700n 0.000424 218.2800n 0.000434 218.2900n 0.000442 218.3000n 0.000451 218.3100n 0.000459 218.3200n 0.000467 218.3300n 0.000474 218.3400n 0.000481 218.3500n 0.000487 218.3600n 0.000493 218.3700n 0.000499 218.3800n 0.000504 218.3900n 0.000509
+ 218.4000n 0.000514 218.4100n 0.000518 218.4200n 0.000522 218.4300n 0.000525 218.4400n 0.000528 218.4500n 0.000531 218.4600n 0.000533 218.4700n 0.000534 218.4800n 0.000536 218.4900n 0.000537 218.5000n 0.000537 218.5100n 0.000538 218.5200n 0.000537 218.5300n 0.000537 218.5400n 0.000536
+ 218.5500n 0.000535 218.5600n 0.000533 218.5700n 0.000531 218.5800n 0.000529 218.5900n 0.000526 218.6000n 0.000523 218.6100n 0.000520 218.6200n 0.000517 218.6300n 0.000513 218.6400n 0.000509 218.6500n 0.000504 218.6600n 0.000499 218.6700n 0.000494 218.6800n 0.000489 218.6900n 0.000483
+ 218.7000n 0.000477 218.7100n 0.000471 218.7200n 0.000465 218.7300n 0.000458 218.7400n 0.000452 218.7500n 0.000445 218.7600n 0.000438 218.7700n 0.000430 218.7800n 0.000423 218.7900n 0.000415 218.8000n 0.000407 218.8100n 0.000399 218.8200n 0.000391 218.8300n 0.000383 218.8400n 0.000374
+ 218.8500n 0.000366 218.8600n 0.000357 218.8700n 0.000348 218.8800n 0.000340 218.8900n 0.000331 218.9000n 0.000322 218.9100n 0.000313 218.9200n 0.000304 218.9300n 0.000295 218.9400n 0.000286 218.9500n 0.000277 218.9600n 0.000268 218.9700n 0.000259 218.9800n 0.000250 218.9900n 0.000241
+ 219.0000n 0.000232 219.0100n 0.000223 219.0200n 0.000214 219.0300n 0.000206 219.0400n 0.000197 219.0500n 0.000189 219.0600n 0.000180 219.0700n 0.000172 219.0800n 0.000164 219.0900n 0.000156 219.1000n 0.000148 219.1100n 0.000140 219.1200n 0.000132 219.1300n 0.000125 219.1400n 0.000117
+ 219.1500n 0.000110 219.1600n 0.000103 219.1700n 0.000097 219.1800n 0.000090 219.1900n 0.000084 219.2000n 0.000077 219.2100n 0.000071 219.2200n 0.000066 219.2300n 0.000060 219.2400n 0.000055 219.2500n 0.000050 219.2600n 0.000045 219.2700n 0.000040 219.2800n 0.000036 219.2900n 0.000032
+ 219.3000n 0.000028 219.3100n 0.000024 219.3200n 0.000021 219.3300n 0.000018 219.3400n 0.000015 219.3500n 0.000013 219.3600n 0.000010 219.3700n 0.000008 219.3800n 0.000006 219.3900n 0.000005 219.4000n 0.000003 219.4100n 0.000002 219.4200n 0.000002 219.4300n 0.000001 219.4400n 0.000001
+ 219.4500n 0.000001 219.4600n 0.000001 219.4700n 0.000002 219.4800n 0.000002 219.4900n 0.000003 219.5000n 0.000005 219.5100n 0.000006 219.5200n 0.000008 219.5300n 0.000010 219.5400n 0.000012 219.5500n 0.000014 219.5600n 0.000017 219.5700n 0.000020 219.5800n 0.000023 219.5900n 0.000026
+ 219.6000n 0.000029 219.6100n 0.000033 219.6200n 0.000036 219.6300n 0.000040 219.6400n 0.000044 219.6500n 0.000049 219.6600n 0.000053 219.6700n 0.000058 219.6800n 0.000062 219.6900n 0.000067 219.7000n 0.000072 219.7100n 0.000077 219.7200n 0.000082 219.7300n 0.000087 219.7400n 0.000093
+ 219.7500n 0.000098 219.7600n 0.000103 219.7700n 0.000109 219.7800n 0.000114 219.7900n 0.000120 219.8000n 0.000125 219.8100n 0.000131 219.8200n 0.000137 219.8300n 0.000142 219.8400n 0.000148 219.8500n 0.000153 219.8600n 0.000159 219.8700n 0.000165 219.8800n 0.000170 219.8900n 0.000175
+ 219.9000n 0.000181 219.9100n 0.000186 219.9200n 0.000191 219.9300n 0.000196 219.9400n 0.000201 219.9500n 0.000206 219.9600n 0.000211 219.9700n 0.000215 219.9800n 0.000220 219.9900n 0.000224 220.0000n 0.000228 220.0100n 0.000232 220.0200n 0.000236 220.0300n 0.000239 220.0400n 0.000243
+ 220.0500n 0.000246 220.0600n 0.000249 220.0700n 0.000251 220.0800n 0.000254 220.0900n 0.000256 220.1000n 0.000258 220.1100n 0.000260 220.1200n 0.000261 220.1300n 0.000263 220.1400n 0.000263 220.1500n 0.000264 220.1600n 0.000264 220.1700n 0.000265 220.1800n 0.000264 220.1900n 0.000264
+ 220.2000n 0.000263 220.2100n 0.000262 220.2200n 0.000261 220.2300n 0.000259 220.2400n 0.000257 220.2500n 0.000254 220.2600n 0.000252 220.2700n 0.000249 220.2800n 0.000245 220.2900n 0.000242 220.3000n 0.000238 220.3100n 0.000233 220.3200n 0.000229 220.3300n 0.000223 220.3400n 0.000218
+ 220.3500n 0.000212 220.3600n 0.000206 220.3700n 0.000200 220.3800n 0.000193 220.3900n 0.000186 220.4000n 0.000179 220.4100n 0.000171 220.4200n 0.000163 220.4300n 0.000155 220.4400n 0.000147 220.4500n 0.000138 220.4600n 0.000128 220.4700n 0.000119 220.4800n 0.000109 220.4900n 0.000099
+ 220.5000n 0.000089 220.5100n 0.000078 220.5200n 0.000067 220.5300n 0.000056 220.5400n 0.000044 220.5500n 0.000033 220.5600n 0.000021 220.5700n 0.000009 220.5800n -0.000004 220.5900n -0.000016 220.6000n -0.000029 220.6100n -0.000042 220.6200n -0.000055 220.6300n -0.000069 220.6400n -0.000082
+ 220.6500n -0.000096 220.6600n -0.000109 220.6700n -0.000123 220.6800n -0.000137 220.6900n -0.000152 220.7000n -0.000166 220.7100n -0.000180 220.7200n -0.000195 220.7300n -0.000209 220.7400n -0.000224 220.7500n -0.000238 220.7600n -0.000253 220.7700n -0.000267 220.7800n -0.000282 220.7900n -0.000296
+ 220.8000n -0.000311 220.8100n -0.000325 220.8200n -0.000340 220.8300n -0.000354 220.8400n -0.000368 220.8500n -0.000383 220.8600n -0.000397 220.8700n -0.000410 220.8800n -0.000424 220.8900n -0.000438 220.9000n -0.000451 220.9100n -0.000464 220.9200n -0.000478 220.9300n -0.000490 220.9400n -0.000503
+ 220.9500n -0.000515 220.9600n -0.000527 220.9700n -0.000539 220.9800n -0.000551 220.9900n -0.000562 221.0000n -0.000573 221.0100n -0.000583 221.0200n -0.000594 221.0300n -0.000604 221.0400n -0.000613 221.0500n -0.000622 221.0600n -0.000631 221.0700n -0.000639 221.0800n -0.000647 221.0900n -0.000655
+ 221.1000n -0.000662 221.1100n -0.000668 221.1200n -0.000675 221.1300n -0.000680 221.1400n -0.000685 221.1500n -0.000690 221.1600n -0.000694 221.1700n -0.000698 221.1800n -0.000701 221.1900n -0.000704 221.2000n -0.000706 221.2100n -0.000707 221.2200n -0.000708 221.2300n -0.000709 221.2400n -0.000708
+ 221.2500n -0.000708 221.2600n -0.000706 221.2700n -0.000704 221.2800n -0.000702 221.2900n -0.000698 221.3000n -0.000695 221.3100n -0.000690 221.3200n -0.000685 221.3300n -0.000680 221.3400n -0.000673 221.3500n -0.000666 221.3600n -0.000659 221.3700n -0.000651 221.3800n -0.000642 221.3900n -0.000632
+ 221.4000n -0.000622 221.4100n -0.000611 221.4200n -0.000600 221.4300n -0.000588 221.4400n -0.000575 221.4500n -0.000562 221.4600n -0.000548 221.4700n -0.000533 221.4800n -0.000518 221.4900n -0.000502 221.5000n -0.000486 221.5100n -0.000469 221.5200n -0.000451 221.5300n -0.000433 221.5400n -0.000414
+ 221.5500n -0.000395 221.5600n -0.000375 221.5700n -0.000354 221.5800n -0.000333 221.5900n -0.000311 221.6000n -0.000289 221.6100n -0.000266 221.6200n -0.000242 221.6300n -0.000218 221.6400n -0.000194 221.6500n -0.000169 221.6600n -0.000144 221.6700n -0.000118 221.6800n -0.000091 221.6900n -0.000064
+ 221.7000n -0.000037 221.7100n -0.000009 221.7200n 0.000019 221.7300n 0.000047 221.7400n 0.000076 221.7500n 0.000106 221.7600n 0.000135 221.7700n 0.000165 221.7800n 0.000196 221.7900n 0.000226 221.8000n 0.000257 221.8100n 0.000289 221.8200n 0.000320 221.8300n 0.000352 221.8400n 0.000384
+ 221.8500n 0.000416 221.8600n 0.000448 221.8700n 0.000481 221.8800n 0.000514 221.8900n 0.000546 221.9000n 0.000579 221.9100n 0.000612 221.9200n 0.000645 221.9300n 0.000679 221.9400n 0.000712 221.9500n 0.000745 221.9600n 0.000778 221.9700n 0.000812 221.9800n 0.000845 221.9900n 0.000878
+ 222.0000n 0.000911 222.0100n 0.000944 222.0200n 0.000977 222.0300n 0.001010 222.0400n 0.001043 222.0500n 0.001075 222.0600n 0.001107 222.0700n 0.001139 222.0800n 0.001171 222.0900n 0.001203 222.1000n 0.001234 222.1100n 0.001265 222.1200n 0.001296 222.1300n 0.001326 222.1400n 0.001356
+ 222.1500n 0.001386 222.1600n 0.001415 222.1700n 0.001444 222.1800n 0.001472 222.1900n 0.001500 222.2000n 0.001528 222.2100n 0.001555 222.2200n 0.001582 222.2300n 0.001608 222.2400n 0.001633 222.2500n 0.001658 222.2600n 0.001683 222.2700n 0.001707 222.2800n 0.001730 222.2900n 0.001753
+ 222.3000n 0.001775 222.3100n 0.001797 222.3200n 0.001818 222.3300n 0.001838 222.3400n 0.001857 222.3500n 0.001876 222.3600n 0.001895 222.3700n 0.001912 222.3800n 0.001929 222.3900n 0.001945 222.4000n 0.001960 222.4100n 0.001975 222.4200n 0.001989 222.4300n 0.002002 222.4400n 0.002014
+ 222.4500n 0.002026 222.4600n 0.002036 222.4700n 0.002046 222.4800n 0.002055 222.4900n 0.002064 222.5000n 0.002071 222.5100n 0.002078 222.5200n 0.002084 222.5300n 0.002089 222.5400n 0.002093 222.5500n 0.002097 222.5600n 0.002099 222.5700n 0.002101 222.5800n 0.002102 222.5900n 0.002102
+ 222.6000n 0.002101 222.6100n 0.002100 222.6200n 0.002097 222.6300n 0.002094 222.6400n 0.002090 222.6500n 0.002085 222.6600n 0.002079 222.6700n 0.002072 222.6800n 0.002065 222.6900n 0.002057 222.7000n 0.002048 222.7100n 0.002038 222.7200n 0.002027 222.7300n 0.002016 222.7400n 0.002004
+ 222.7500n 0.001991 222.7600n 0.001977 222.7700n 0.001962 222.7800n 0.001947 222.7900n 0.001931 222.8000n 0.001914 222.8100n 0.001897 222.8200n 0.001879 222.8300n 0.001860 222.8400n 0.001840 222.8500n 0.001820 222.8600n 0.001799 222.8700n 0.001777 222.8800n 0.001755 222.8900n 0.001733
+ 222.9000n 0.001709 222.9100n 0.001685 222.9200n 0.001661 222.9300n 0.001635 222.9400n 0.001610 222.9500n 0.001584 222.9600n 0.001557 222.9700n 0.001530 222.9800n 0.001502 222.9900n 0.001474 223.0000n 0.001445 223.0100n 0.001416 223.0200n 0.001387 223.0300n 0.001357 223.0400n 0.001327
+ 223.0500n 0.001296 223.0600n 0.001265 223.0700n 0.001234 223.0800n 0.001203 223.0900n 0.001171 223.1000n 0.001139 223.1100n 0.001107 223.1200n 0.001074 223.1300n 0.001042 223.1400n 0.001009 223.1500n 0.000976 223.1600n 0.000943 223.1700n 0.000910 223.1800n 0.000877 223.1900n 0.000843
+ 223.2000n 0.000810 223.2100n 0.000776 223.2200n 0.000743 223.2300n 0.000710 223.2400n 0.000676 223.2500n 0.000643 223.2600n 0.000610 223.2700n 0.000577 223.2800n 0.000544 223.2900n 0.000511 223.3000n 0.000478 223.3100n 0.000446 223.3200n 0.000413 223.3300n 0.000381 223.3400n 0.000349
+ 223.3500n 0.000318 223.3600n 0.000286 223.3700n 0.000255 223.3800n 0.000224 223.3900n 0.000194 223.4000n 0.000164 223.4100n 0.000134 223.4200n 0.000105 223.4300n 0.000076 223.4400n 0.000047 223.4500n 0.000019 223.4600n -0.000008 223.4700n -0.000036 223.4800n -0.000062 223.4900n -0.000088
+ 223.5000n -0.000114 223.5100n -0.000139 223.5200n -0.000164 223.5300n -0.000188 223.5400n -0.000211 223.5500n -0.000234 223.5600n -0.000256 223.5700n -0.000278 223.5800n -0.000299 223.5900n -0.000320 223.6000n -0.000339 223.6100n -0.000358 223.6200n -0.000377 223.6300n -0.000395 223.6400n -0.000412
+ 223.6500n -0.000428 223.6600n -0.000444 223.6700n -0.000459 223.6800n -0.000473 223.6900n -0.000487 223.7000n -0.000500 223.7100n -0.000512 223.7200n -0.000523 223.7300n -0.000534 223.7400n -0.000544 223.7500n -0.000553 223.7600n -0.000561 223.7700n -0.000569 223.7800n -0.000575 223.7900n -0.000582
+ 223.8000n -0.000587 223.8100n -0.000591 223.8200n -0.000595 223.8300n -0.000598 223.8400n -0.000600 223.8500n -0.000602 223.8600n -0.000602 223.8700n -0.000602 223.8800n -0.000601 223.8900n -0.000600 223.9000n -0.000598 223.9100n -0.000594 223.9200n -0.000591 223.9300n -0.000586 223.9400n -0.000581
+ 223.9500n -0.000574 223.9600n -0.000568 223.9700n -0.000560 223.9800n -0.000552 223.9900n -0.000543 224.0000n -0.000533 224.0100n -0.000523 224.0200n -0.000512 224.0300n -0.000500 224.0400n -0.000488 224.0500n -0.000475 224.0600n -0.000461 224.0700n -0.000447 224.0800n -0.000432 224.0900n -0.000416
+ 224.1000n -0.000400 224.1100n -0.000384 224.1200n -0.000366 224.1300n -0.000348 224.1400n -0.000330 224.1500n -0.000311 224.1600n -0.000292 224.1700n -0.000272 224.1800n -0.000251 224.1900n -0.000230 224.2000n -0.000209 224.2100n -0.000187 224.2200n -0.000165 224.2300n -0.000142 224.2400n -0.000119
+ 224.2500n -0.000095 224.2600n -0.000071 224.2700n -0.000047 224.2800n -0.000022 224.2900n 0.000003 224.3000n 0.000028 224.3100n 0.000053 224.3200n 0.000079 224.3300n 0.000105 224.3400n 0.000132 224.3500n 0.000158 224.3600n 0.000185 224.3700n 0.000212 224.3800n 0.000239 224.3900n 0.000267
+ 224.4000n 0.000294 224.4100n 0.000322 224.4200n 0.000349 224.4300n 0.000377 224.4400n 0.000405 224.4500n 0.000433 224.4600n 0.000461 224.4700n 0.000489 224.4800n 0.000517 224.4900n 0.000545 224.5000n 0.000573 224.5100n 0.000600 224.5200n 0.000628 224.5300n 0.000656 224.5400n 0.000684
+ 224.5500n 0.000711 224.5600n 0.000738 224.5700n 0.000766 224.5800n 0.000793 224.5900n 0.000820 224.6000n 0.000846 224.6100n 0.000873 224.6200n 0.000899 224.6300n 0.000925 224.6400n 0.000951 224.6500n 0.000976 224.6600n 0.001002 224.6700n 0.001027 224.6800n 0.001051 224.6900n 0.001075
+ 224.7000n 0.001099 224.7100n 0.001123 224.7200n 0.001146 224.7300n 0.001169 224.7400n 0.001191 224.7500n 0.001213 224.7600n 0.001235 224.7700n 0.001256 224.7800n 0.001277 224.7900n 0.001297 224.8000n 0.001317 224.8100n 0.001336 224.8200n 0.001355 224.8300n 0.001374 224.8400n 0.001392
+ 224.8500n 0.001409 224.8600n 0.001426 224.8700n 0.001442 224.8800n 0.001458 224.8900n 0.001473 224.9000n 0.001488 224.9100n 0.001502 224.9200n 0.001515 224.9300n 0.001528 224.9400n 0.001541 224.9500n 0.001553 224.9600n 0.001564 224.9700n 0.001575 224.9800n 0.001585 224.9900n 0.001594
+ 225.0000n 0.001603 225.0100n 0.001611 225.0200n 0.001619 225.0300n 0.001626 225.0400n 0.001632 225.0500n 0.001638 225.0600n 0.001643 225.0700n 0.001647 225.0800n 0.001651 225.0900n 0.001654 225.1000n 0.001657 225.1100n 0.001659 225.1200n 0.001660 225.1300n 0.001661 225.1400n 0.001661
+ 225.1500n 0.001660 225.1600n 0.001659 225.1700n 0.001657 225.1800n 0.001654 225.1900n 0.001651 225.2000n 0.001647 225.2100n 0.001643 225.2200n 0.001638 225.2300n 0.001633 225.2400n 0.001626 225.2500n 0.001620 225.2600n 0.001612 225.2700n 0.001604 225.2800n 0.001595 225.2900n 0.001586
+ 225.3000n 0.001577 225.3100n 0.001566 225.3200n 0.001555 225.3300n 0.001544 225.3400n 0.001532 225.3500n 0.001519 225.3600n 0.001506 225.3700n 0.001492 225.3800n 0.001478 225.3900n 0.001463 225.4000n 0.001448 225.4100n 0.001432 225.4200n 0.001416 225.4300n 0.001399 225.4400n 0.001382
+ 225.4500n 0.001364 225.4600n 0.001346 225.4700n 0.001327 225.4800n 0.001308 225.4900n 0.001288 225.5000n 0.001268 225.5100n 0.001248 225.5200n 0.001227 225.5300n 0.001206 225.5400n 0.001184 225.5500n 0.001162 225.5600n 0.001139 225.5700n 0.001117 225.5800n 0.001093 225.5900n 0.001070
+ 225.6000n 0.001046 225.6100n 0.001022 225.6200n 0.000997 225.6300n 0.000972 225.6400n 0.000947 225.6500n 0.000922 225.6600n 0.000896 225.6700n 0.000870 225.6800n 0.000844 225.6900n 0.000817 225.7000n 0.000790 225.7100n 0.000763 225.7200n 0.000736 225.7300n 0.000708 225.7400n 0.000681
+ 225.7500n 0.000653 225.7600n 0.000625 225.7700n 0.000597 225.7800n 0.000568 225.7900n 0.000540 225.8000n 0.000511 225.8100n 0.000482 225.8200n 0.000453 225.8300n 0.000424 225.8400n 0.000395 225.8500n 0.000366 225.8600n 0.000336 225.8700n 0.000307 225.8800n 0.000277 225.8900n 0.000248
+ 225.9000n 0.000218 225.9100n 0.000188 225.9200n 0.000159 225.9300n 0.000129 225.9400n 0.000099 225.9500n 0.000069 225.9600n 0.000040 225.9700n 0.000010 225.9800n -0.000020 225.9900n -0.000050 226.0000n -0.000079 226.0100n -0.000109 226.0200n -0.000139 226.0300n -0.000168 226.0400n -0.000198
+ 226.0500n -0.000227 226.0600n -0.000257 226.0700n -0.000286 226.0800n -0.000315 226.0900n -0.000344 226.1000n -0.000373 226.1100n -0.000402 226.1200n -0.000431 226.1300n -0.000459 226.1400n -0.000488 226.1500n -0.000516 226.1600n -0.000545 226.1700n -0.000573 226.1800n -0.000601 226.1900n -0.000629
+ 226.2000n -0.000656 226.2100n -0.000684 226.2200n -0.000711 226.2300n -0.000738 226.2400n -0.000765 226.2500n -0.000792 226.2600n -0.000819 226.2700n -0.000845 226.2800n -0.000872 226.2900n -0.000898 226.3000n -0.000923 226.3100n -0.000949 226.3200n -0.000975 226.3300n -0.001000 226.3400n -0.001025
+ 226.3500n -0.001050 226.3600n -0.001074 226.3700n -0.001099 226.3800n -0.001123 226.3900n -0.001147 226.4000n -0.001170 226.4100n -0.001194 226.4200n -0.001217 226.4300n -0.001240 226.4400n -0.001263 226.4500n -0.001285 226.4600n -0.001307 226.4700n -0.001330 226.4800n -0.001351 226.4900n -0.001373
+ 226.5000n -0.001394 226.5100n -0.001415 226.5200n -0.001436 226.5300n -0.001456 226.5400n -0.001477 226.5500n -0.001497 226.5600n -0.001516 226.5700n -0.001536 226.5800n -0.001555 226.5900n -0.001574 226.6000n -0.001593 226.6100n -0.001611 226.6200n -0.001629 226.6300n -0.001647 226.6400n -0.001665
+ 226.6500n -0.001682 226.6600n -0.001700 226.6700n -0.001717 226.6800n -0.001733 226.6900n -0.001750 226.7000n -0.001766 226.7100n -0.001781 226.7200n -0.001797 226.7300n -0.001812 226.7400n -0.001827 226.7500n -0.001842 226.7600n -0.001857 226.7700n -0.001871 226.7800n -0.001885 226.7900n -0.001899
+ 226.8000n -0.001912 226.8100n -0.001925 226.8200n -0.001938 226.8300n -0.001951 226.8400n -0.001964 226.8500n -0.001976 226.8600n -0.001988 226.8700n -0.001999 226.8800n -0.002011 226.8900n -0.002022 226.9000n -0.002033 226.9100n -0.002043 226.9200n -0.002053 226.9300n -0.002064 226.9400n -0.002073
+ 226.9500n -0.002083 226.9600n -0.002092 226.9700n -0.002101 226.9800n -0.002110 226.9900n -0.002119 227.0000n -0.002127 227.0100n -0.002135 227.0200n -0.002142 227.0300n -0.002150 227.0400n -0.002157 227.0500n -0.002164 227.0600n -0.002171 227.0700n -0.002177 227.0800n -0.002183 227.0900n -0.002189
+ 227.1000n -0.002195 227.1100n -0.002200 227.1200n -0.002205 227.1300n -0.002210 227.1400n -0.002215 227.1500n -0.002219 227.1600n -0.002223 227.1700n -0.002227 227.1800n -0.002230 227.1900n -0.002234 227.2000n -0.002237 227.2100n -0.002240 227.2200n -0.002242 227.2300n -0.002244 227.2400n -0.002246
+ 227.2500n -0.002248 227.2600n -0.002249 227.2700n -0.002250 227.2800n -0.002251 227.2900n -0.002252 227.3000n -0.002252 227.3100n -0.002252 227.3200n -0.002252 227.3300n -0.002252 227.3400n -0.002251 227.3500n -0.002250 227.3600n -0.002248 227.3700n -0.002247 227.3800n -0.002245 227.3900n -0.002243
+ 227.4000n -0.002240 227.4100n -0.002238 227.4200n -0.002235 227.4300n -0.002232 227.4400n -0.002228 227.4500n -0.002224 227.4600n -0.002220 227.4700n -0.002216 227.4800n -0.002211 227.4900n -0.002206 227.5000n -0.002201 227.5100n -0.002196 227.5200n -0.002190 227.5300n -0.002184 227.5400n -0.002177
+ 227.5500n -0.002171 227.5600n -0.002164 227.5700n -0.002157 227.5800n -0.002149 227.5900n -0.002141 227.6000n -0.002133 227.6100n -0.002125 227.6200n -0.002116 227.6300n -0.002107 227.6400n -0.002098 227.6500n -0.002088 227.6600n -0.002079 227.6700n -0.002069 227.6800n -0.002058 227.6900n -0.002047
+ 227.7000n -0.002036 227.7100n -0.002025 227.7200n -0.002014 227.7300n -0.002002 227.7400n -0.001990 227.7500n -0.001977 227.7600n -0.001964 227.7700n -0.001951 227.7800n -0.001938 227.7900n -0.001924 227.8000n -0.001911 227.8100n -0.001896 227.8200n -0.001882 227.8300n -0.001867 227.8400n -0.001852
+ 227.8500n -0.001837 227.8600n -0.001821 227.8700n -0.001805 227.8800n -0.001789 227.8900n -0.001773 227.9000n -0.001756 227.9100n -0.001739 227.9200n -0.001721 227.9300n -0.001704 227.9400n -0.001686 227.9500n -0.001668 227.9600n -0.001649 227.9700n -0.001631 227.9800n -0.001612 227.9900n -0.001593
+ 228.0000n -0.001573 228.0100n -0.001553 228.0200n -0.001533 228.0300n -0.001513 228.0400n -0.001493 228.0500n -0.001472 228.0600n -0.001451 228.0700n -0.001429 228.0800n -0.001408 228.0900n -0.001386 228.1000n -0.001364 228.1100n -0.001342 228.1200n -0.001319 228.1300n -0.001297 228.1400n -0.001274
+ 228.1500n -0.001250 228.1600n -0.001227 228.1700n -0.001203 228.1800n -0.001179 228.1900n -0.001155 228.2000n -0.001131 228.2100n -0.001107 228.2200n -0.001082 228.2300n -0.001057 228.2400n -0.001032 228.2500n -0.001007 228.2600n -0.000981 228.2700n -0.000956 228.2800n -0.000930 228.2900n -0.000904
+ 228.3000n -0.000878 228.3100n -0.000851 228.3200n -0.000825 228.3300n -0.000798 228.3400n -0.000771 228.3500n -0.000744 228.3600n -0.000717 228.3700n -0.000690 228.3800n -0.000663 228.3900n -0.000635 228.4000n -0.000607 228.4100n -0.000580 228.4200n -0.000552 228.4300n -0.000524 228.4400n -0.000496
+ 228.4500n -0.000468 228.4600n -0.000439 228.4700n -0.000411 228.4800n -0.000383 228.4900n -0.000354 228.5000n -0.000326 228.5100n -0.000297 228.5200n -0.000268 228.5300n -0.000240 228.5400n -0.000211 228.5500n -0.000182 228.5600n -0.000153 228.5700n -0.000124 228.5800n -0.000095 228.5900n -0.000067
+ 228.6000n -0.000038 228.6100n -0.000009 228.6200n 0.000020 228.6300n 0.000049 228.6400n 0.000078 228.6500n 0.000107 228.6600n 0.000136 228.6700n 0.000165 228.6800n 0.000193 228.6900n 0.000222 228.7000n 0.000251 228.7100n 0.000280 228.7200n 0.000308 228.7300n 0.000337 228.7400n 0.000365
+ 228.7500n 0.000393 228.7600n 0.000422 228.7700n 0.000450 228.7800n 0.000478 228.7900n 0.000506 228.8000n 0.000534 228.8100n 0.000562 228.8200n 0.000589 228.8300n 0.000617 228.8400n 0.000644 228.8500n 0.000671 228.8600n 0.000698 228.8700n 0.000725 228.8800n 0.000752 228.8900n 0.000779
+ 228.9000n 0.000805 228.9100n 0.000831 228.9200n 0.000857 228.9300n 0.000883 228.9400n 0.000909 228.9500n 0.000934 228.9600n 0.000960 228.9700n 0.000985 228.9800n 0.001010 228.9900n 0.001034 229.0000n 0.001059 229.0100n 0.001083 229.0200n 0.001107 229.0300n 0.001131 229.0400n 0.001154
+ 229.0500n 0.001177 229.0600n 0.001200 229.0700n 0.001223 229.0800n 0.001245 229.0900n 0.001268 229.1000n 0.001290 229.1100n 0.001311 229.1200n 0.001333 229.1300n 0.001354 229.1400n 0.001374 229.1500n 0.001395 229.1600n 0.001415 229.1700n 0.001435 229.1800n 0.001454 229.1900n 0.001474
+ 229.2000n 0.001493 229.2100n 0.001511 229.2200n 0.001530 229.2300n 0.001548 229.2400n 0.001565 229.2500n 0.001583 229.2600n 0.001600 229.2700n 0.001616 229.2800n 0.001633 229.2900n 0.001649 229.3000n 0.001664 229.3100n 0.001680 229.3200n 0.001695 229.3300n 0.001709 229.3400n 0.001724
+ 229.3500n 0.001737 229.3600n 0.001751 229.3700n 0.001764 229.3800n 0.001777 229.3900n 0.001790 229.4000n 0.001802 229.4100n 0.001813 229.4200n 0.001825 229.4300n 0.001836 229.4400n 0.001847 229.4500n 0.001857 229.4600n 0.001867 229.4700n 0.001876 229.4800n 0.001886 229.4900n 0.001894
+ 229.5000n 0.001903 229.5100n 0.001911 229.5200n 0.001919 229.5300n 0.001926 229.5400n 0.001933 229.5500n 0.001940 229.5600n 0.001946 229.5700n 0.001952 229.5800n 0.001957 229.5900n 0.001962 229.6000n 0.001967 229.6100n 0.001971 229.6200n 0.001975 229.6300n 0.001979 229.6400n 0.001982
+ 229.6500n 0.001985 229.6600n 0.001988 229.6700n 0.001990 229.6800n 0.001992 229.6900n 0.001994 229.7000n 0.001995 229.7100n 0.001996 229.7200n 0.001996 229.7300n 0.001996 229.7400n 0.001996 229.7500n 0.001995 229.7600n 0.001994 229.7700n 0.001993 229.7800n 0.001992 229.7900n 0.001990
+ 229.8000n 0.001987 229.8100n 0.001985 229.8200n 0.001982 229.8300n 0.001979 229.8400n 0.001975 229.8500n 0.001971 229.8600n 0.001967 229.8700n 0.001963 229.8800n 0.001958 229.8900n 0.001953 229.9000n 0.001947 229.9100n 0.001942 229.9200n 0.001936 229.9300n 0.001929 229.9400n 0.001923
+ 229.9500n 0.001916 229.9600n 0.001909 229.9700n 0.001902 229.9800n 0.001894 229.9900n 0.001886 230.0000n 0.001878 230.0100n 0.001869 230.0200n 0.001861 230.0300n 0.001852 230.0400n 0.001842 230.0500n 0.001833 230.0600n 0.001823 230.0700n 0.001813 230.0800n 0.001803 230.0900n 0.001793
+ 230.1000n 0.001782 230.1100n 0.001771 230.1200n 0.001760 230.1300n 0.001749 230.1400n 0.001737 230.1500n 0.001726 230.1600n 0.001714 230.1700n 0.001702 230.1800n 0.001689 230.1900n 0.001677 230.2000n 0.001664 230.2100n 0.001651 230.2200n 0.001638 230.2300n 0.001625 230.2400n 0.001612
+ 230.2500n 0.001598 230.2600n 0.001584 230.2700n 0.001570 230.2800n 0.001556 230.2900n 0.001542 230.3000n 0.001528 230.3100n 0.001513 230.3200n 0.001499 230.3300n 0.001484 230.3400n 0.001469 230.3500n 0.001454 230.3600n 0.001439 230.3700n 0.001424 230.3800n 0.001408 230.3900n 0.001393
+ 230.4000n 0.001377 230.4100n 0.001362 230.4200n 0.001346 230.4300n 0.001330 230.4400n 0.001314 230.4500n 0.001298 230.4600n 0.001281 230.4700n 0.001265 230.4800n 0.001248 230.4900n 0.001232 230.5000n 0.001215 230.5100n 0.001199 230.5200n 0.001182 230.5300n 0.001165 230.5400n 0.001148
+ 230.5500n 0.001131 230.5600n 0.001114 230.5700n 0.001097 230.5800n 0.001080 230.5900n 0.001062 230.6000n 0.001045 230.6100n 0.001028 230.6200n 0.001010 230.6300n 0.000993 230.6400n 0.000975 230.6500n 0.000957 230.6600n 0.000940 230.6700n 0.000922 230.6800n 0.000904 230.6900n 0.000886
+ 230.7000n 0.000868 230.7100n 0.000850 230.7200n 0.000832 230.7300n 0.000814 230.7400n 0.000796 230.7500n 0.000778 230.7600n 0.000760 230.7700n 0.000742 230.7800n 0.000723 230.7900n 0.000705 230.8000n 0.000687 230.8100n 0.000668 230.8200n 0.000650 230.8300n 0.000631 230.8400n 0.000613
+ 230.8500n 0.000594 230.8600n 0.000576 230.8700n 0.000557 230.8800n 0.000538 230.8900n 0.000520 230.9000n 0.000501 230.9100n 0.000482 230.9200n 0.000463 230.9300n 0.000444 230.9400n 0.000425 230.9500n 0.000406 230.9600n 0.000387 230.9700n 0.000368 230.9800n 0.000349 230.9900n 0.000330
+ 231.0000n 0.000311 231.0100n 0.000292 231.0200n 0.000273 231.0300n 0.000253 231.0400n 0.000234 231.0500n 0.000215 231.0600n 0.000195 231.0700n 0.000176 231.0800n 0.000156 231.0900n 0.000137 231.1000n 0.000117 231.1100n 0.000098 231.1200n 0.000078 231.1300n 0.000058 231.1400n 0.000038
+ 231.1500n 0.000019 231.1600n -0.000001 231.1700n -0.000021 231.1800n -0.000041 231.1900n -0.000061 231.2000n -0.000081 231.2100n -0.000101 231.2200n -0.000121 231.2300n -0.000142 231.2400n -0.000162 231.2500n -0.000182 231.2600n -0.000202 231.2700n -0.000223 231.2800n -0.000243 231.2900n -0.000263
+ 231.3000n -0.000284 231.3100n -0.000304 231.3200n -0.000325 231.3300n -0.000346 231.3400n -0.000366 231.3500n -0.000387 231.3600n -0.000408 231.3700n -0.000428 231.3800n -0.000449 231.3900n -0.000470 231.4000n -0.000491 231.4100n -0.000512 231.4200n -0.000532 231.4300n -0.000553 231.4400n -0.000574
+ 231.4500n -0.000595 231.4600n -0.000616 231.4700n -0.000637 231.4800n -0.000658 231.4900n -0.000679 231.5000n -0.000700 231.5100n -0.000722 231.5200n -0.000743 231.5300n -0.000764 231.5400n -0.000785 231.5500n -0.000806 231.5600n -0.000827 231.5700n -0.000848 231.5800n -0.000869 231.5900n -0.000890
+ 231.6000n -0.000911 231.6100n -0.000932 231.6200n -0.000953 231.6300n -0.000974 231.6400n -0.000995 231.6500n -0.001016 231.6600n -0.001036 231.6700n -0.001057 231.6800n -0.001078 231.6900n -0.001098 231.7000n -0.001119 231.7100n -0.001139 231.7200n -0.001160 231.7300n -0.001180 231.7400n -0.001200
+ 231.7500n -0.001221 231.7600n -0.001241 231.7700n -0.001261 231.7800n -0.001280 231.7900n -0.001300 231.8000n -0.001320 231.8100n -0.001339 231.8200n -0.001359 231.8300n -0.001378 231.8400n -0.001397 231.8500n -0.001416 231.8600n -0.001435 231.8700n -0.001453 231.8800n -0.001472 231.8900n -0.001490
+ 231.9000n -0.001508 231.9100n -0.001526 231.9200n -0.001543 231.9300n -0.001561 231.9400n -0.001578 231.9500n -0.001595 231.9600n -0.001612 231.9700n -0.001628 231.9800n -0.001645 231.9900n -0.001661 232.0000n -0.001676 232.0100n -0.001692 232.0200n -0.001707 232.0300n -0.001722 232.0400n -0.001737
+ 232.0500n -0.001751 232.0600n -0.001765 232.0700n -0.001779 232.0800n -0.001792 232.0900n -0.001805 232.1000n -0.001818 232.1100n -0.001830 232.1200n -0.001842 232.1300n -0.001854 232.1400n -0.001865 232.1500n -0.001876 232.1600n -0.001886 232.1700n -0.001896 232.1800n -0.001906 232.1900n -0.001915
+ 232.2000n -0.001924 232.2100n -0.001932 232.2200n -0.001940 232.2300n -0.001948 232.2400n -0.001955 232.2500n -0.001961 232.2600n -0.001968 232.2700n -0.001973 232.2800n -0.001978 232.2900n -0.001983 232.3000n -0.001987 232.3100n -0.001991 232.3200n -0.001994 232.3300n -0.001997 232.3400n -0.001999
+ 232.3500n -0.002001 232.3600n -0.002002 232.3700n -0.002003 232.3800n -0.002003 232.3900n -0.002002 232.4000n -0.002001 232.4100n -0.002000 232.4200n -0.001998 232.4300n -0.001995 232.4400n -0.001992 232.4500n -0.001988 232.4600n -0.001983 232.4700n -0.001978 232.4800n -0.001973 232.4900n -0.001966
+ 232.5000n -0.001960 232.5100n -0.001952 232.5200n -0.001944 232.5300n -0.001936 232.5400n -0.001927 232.5500n -0.001917 232.5600n -0.001907 232.5700n -0.001896 232.5800n -0.001884 232.5900n -0.001872 232.6000n -0.001859 232.6100n -0.001846 232.6200n -0.001832 232.6300n -0.001817 232.6400n -0.001802
+ 232.6500n -0.001786 232.6600n -0.001770 232.6700n -0.001753 232.6800n -0.001735 232.6900n -0.001717 232.7000n -0.001698 232.7100n -0.001678 232.7200n -0.001658 232.7300n -0.001638 232.7400n -0.001617 232.7500n -0.001595 232.7600n -0.001573 232.7700n -0.001550 232.7800n -0.001526 232.7900n -0.001502
+ 232.8000n -0.001477 232.8100n -0.001452 232.8200n -0.001427 232.8300n -0.001400 232.8400n -0.001374 232.8500n -0.001346 232.8600n -0.001319 232.8700n -0.001290 232.8800n -0.001261 232.8900n -0.001232 232.9000n -0.001202 232.9100n -0.001172 232.9200n -0.001141 232.9300n -0.001110 232.9400n -0.001079
+ 232.9500n -0.001047 232.9600n -0.001014 232.9700n -0.000981 232.9800n -0.000948 232.9900n -0.000914 233.0000n -0.000880 233.0100n -0.000846 233.0200n -0.000811 233.0300n -0.000776 233.0400n -0.000740 233.0500n -0.000704 233.0600n -0.000668 233.0700n -0.000632 233.0800n -0.000595 233.0900n -0.000558
+ 233.1000n -0.000521 233.1100n -0.000483 233.1200n -0.000445 233.1300n -0.000407 233.1400n -0.000369 233.1500n -0.000331 233.1600n -0.000292 233.1700n -0.000254 233.1800n -0.000215 233.1900n -0.000176 233.2000n -0.000137 233.2100n -0.000098 233.2200n -0.000059 233.2300n -0.000019 233.2400n 0.000020
+ 233.2500n 0.000059 233.2600n 0.000099 233.2700n 0.000138 233.2800n 0.000178 233.2900n 0.000217 233.3000n 0.000256 233.3100n 0.000295 233.3200n 0.000335 233.3300n 0.000374 233.3400n 0.000413 233.3500n 0.000451 233.3600n 0.000490 233.3700n 0.000529 233.3800n 0.000567 233.3900n 0.000605
+ 233.4000n 0.000643 233.4100n 0.000681 233.4200n 0.000718 233.4300n 0.000755 233.4400n 0.000792 233.4500n 0.000829 233.4600n 0.000865 233.4700n 0.000901 233.4800n 0.000937 233.4900n 0.000972 233.5000n 0.001007 233.5100n 0.001042 233.5200n 0.001076 233.5300n 0.001110 233.5400n 0.001143
+ 233.5500n 0.001176 233.5600n 0.001208 233.5700n 0.001240 233.5800n 0.001272 233.5900n 0.001303 233.6000n 0.001333 233.6100n 0.001363 233.6200n 0.001393 233.6300n 0.001421 233.6400n 0.001450 233.6500n 0.001478 233.6600n 0.001505 233.6700n 0.001531 233.6800n 0.001557 233.6900n 0.001583
+ 233.7000n 0.001607 233.7100n 0.001632 233.7200n 0.001655 233.7300n 0.001678 233.7400n 0.001700 233.7500n 0.001721 233.7600n 0.001742 233.7700n 0.001762 233.7800n 0.001782 233.7900n 0.001800 233.8000n 0.001818 233.8100n 0.001836 233.8200n 0.001852 233.8300n 0.001868 233.8400n 0.001883
+ 233.8500n 0.001897 233.8600n 0.001911 233.8700n 0.001924 233.8800n 0.001936 233.8900n 0.001947 233.9000n 0.001958 233.9100n 0.001968 233.9200n 0.001977 233.9300n 0.001985 233.9400n 0.001993 233.9500n 0.002000 233.9600n 0.002006 233.9700n 0.002011 233.9800n 0.002015 233.9900n 0.002019
+ 234.0000n 0.002022 234.0100n 0.002024 234.0200n 0.002026 234.0300n 0.002027 234.0400n 0.002027 234.0500n 0.002026 234.0600n 0.002024 234.0700n 0.002022 234.0800n 0.002019 234.0900n 0.002015 234.1000n 0.002011 234.1100n 0.002006 234.1200n 0.002000 234.1300n 0.001993 234.1400n 0.001986
+ 234.1500n 0.001978 234.1600n 0.001970 234.1700n 0.001960 234.1800n 0.001950 234.1900n 0.001940 234.2000n 0.001929 234.2100n 0.001917 234.2200n 0.001904 234.2300n 0.001891 234.2400n 0.001877 234.2500n 0.001863 234.2600n 0.001848 234.2700n 0.001833 234.2800n 0.001817 234.2900n 0.001800
+ 234.3000n 0.001783 234.3100n 0.001766 234.3200n 0.001748 234.3300n 0.001729 234.3400n 0.001710 234.3500n 0.001691 234.3600n 0.001671 234.3700n 0.001650 234.3800n 0.001630 234.3900n 0.001609 234.4000n 0.001587 234.4100n 0.001565 234.4200n 0.001543 234.4300n 0.001520 234.4400n 0.001498
+ 234.4500n 0.001474 234.4600n 0.001451 234.4700n 0.001427 234.4800n 0.001403 234.4900n 0.001379 234.5000n 0.001355 234.5100n 0.001330 234.5200n 0.001305 234.5300n 0.001280 234.5400n 0.001255 234.5500n 0.001230 234.5600n 0.001204 234.5700n 0.001179 234.5800n 0.001153 234.5900n 0.001128
+ 234.6000n 0.001102 234.6100n 0.001076 234.6200n 0.001051 234.6300n 0.001025 234.6400n 0.000999 234.6500n 0.000974 234.6600n 0.000948 234.6700n 0.000923 234.6800n 0.000897 234.6900n 0.000872 234.7000n 0.000847 234.7100n 0.000822 234.7200n 0.000797 234.7300n 0.000772 234.7400n 0.000747
+ 234.7500n 0.000723 234.7600n 0.000699 234.7700n 0.000675 234.7800n 0.000651 234.7900n 0.000628 234.8000n 0.000605 234.8100n 0.000582 234.8200n 0.000559 234.8300n 0.000537 234.8400n 0.000515 234.8500n 0.000494 234.8600n 0.000473 234.8700n 0.000452 234.8800n 0.000431 234.8900n 0.000411
+ 234.9000n 0.000391 234.9100n 0.000372 234.9200n 0.000353 234.9300n 0.000335 234.9400n 0.000317 234.9500n 0.000299 234.9600n 0.000282 234.9700n 0.000266 234.9800n 0.000250 234.9900n 0.000234 235.0000n 0.000219 235.0100n 0.000204 235.0200n 0.000190 235.0300n 0.000176 235.0400n 0.000163
+ 235.0500n 0.000150 235.0600n 0.000138 235.0700n 0.000127 235.0800n 0.000116 235.0900n 0.000105 235.1000n 0.000095 235.1100n 0.000086 235.1200n 0.000077 235.1300n 0.000068 235.1400n 0.000060 235.1500n 0.000053 235.1600n 0.000046 235.1700n 0.000040 235.1800n 0.000034 235.1900n 0.000029
+ 235.2000n 0.000025 235.2100n 0.000021 235.2200n 0.000017 235.2300n 0.000014 235.2400n 0.000012 235.2500n 0.000010 235.2600n 0.000008 235.2700n 0.000007 235.2800n 0.000007 235.2900n 0.000007 235.3000n 0.000007 235.3100n 0.000008 235.3200n 0.000010 235.3300n 0.000012 235.3400n 0.000014
+ 235.3500n 0.000017 235.3600n 0.000021 235.3700n 0.000024 235.3800n 0.000029 235.3900n 0.000033 235.4000n 0.000038 235.4100n 0.000044 235.4200n 0.000050 235.4300n 0.000056 235.4400n 0.000062 235.4500n 0.000069 235.4600n 0.000077 235.4700n 0.000084 235.4800n 0.000092 235.4900n 0.000100
+ 235.5000n 0.000109 235.5100n 0.000117 235.5200n 0.000126 235.5300n 0.000136 235.5400n 0.000145 235.5500n 0.000155 235.5600n 0.000165 235.5700n 0.000175 235.5800n 0.000185 235.5900n 0.000195 235.6000n 0.000206 235.6100n 0.000216 235.6200n 0.000227 235.6300n 0.000238 235.6400n 0.000249
+ 235.6500n 0.000260 235.6600n 0.000271 235.6700n 0.000282 235.6800n 0.000293 235.6900n 0.000304 235.7000n 0.000315 235.7100n 0.000326 235.7200n 0.000336 235.7300n 0.000347 235.7400n 0.000358 235.7500n 0.000368 235.7600n 0.000379 235.7700n 0.000389 235.7800n 0.000399 235.7900n 0.000409
+ 235.8000n 0.000419 235.8100n 0.000428 235.8200n 0.000438 235.8300n 0.000447 235.8400n 0.000455 235.8500n 0.000464 235.8600n 0.000472 235.8700n 0.000480 235.8800n 0.000487 235.8900n 0.000495 235.9000n 0.000501 235.9100n 0.000508 235.9200n 0.000514 235.9300n 0.000520 235.9400n 0.000525
+ 235.9500n 0.000530 235.9600n 0.000534 235.9700n 0.000538 235.9800n 0.000541 235.9900n 0.000544 236.0000n 0.000547 236.0100n 0.000549 236.0200n 0.000550 236.0300n 0.000551 236.0400n 0.000552 236.0500n 0.000551 236.0600n 0.000551 236.0700n 0.000549 236.0800n 0.000547 236.0900n 0.000545
+ 236.1000n 0.000542 236.1100n 0.000538 236.1200n 0.000534 236.1300n 0.000529 236.1400n 0.000523 236.1500n 0.000517 236.1600n 0.000510 236.1700n 0.000502 236.1800n 0.000494 236.1900n 0.000485 236.2000n 0.000476 236.2100n 0.000466 236.2200n 0.000455 236.2300n 0.000443 236.2400n 0.000431
+ 236.2500n 0.000418 236.2600n 0.000405 236.2700n 0.000390 236.2800n 0.000376 236.2900n 0.000360 236.3000n 0.000344 236.3100n 0.000327 236.3200n 0.000309 236.3300n 0.000291 236.3400n 0.000272 236.3500n 0.000252 236.3600n 0.000232 236.3700n 0.000211 236.3800n 0.000189 236.3900n 0.000167
+ 236.4000n 0.000144 236.4100n 0.000120 236.4200n 0.000096 236.4300n 0.000071 236.4400n 0.000045 236.4500n 0.000019 236.4600n -0.000008 236.4700n -0.000035 236.4800n -0.000063 236.4900n -0.000091 236.5000n -0.000120 236.5100n -0.000150 236.5200n -0.000180 236.5300n -0.000211 236.5400n -0.000242
+ 236.5500n -0.000274 236.5600n -0.000306 236.5700n -0.000339 236.5800n -0.000372 236.5900n -0.000406 236.6000n -0.000440 236.6100n -0.000475 236.6200n -0.000510 236.6300n -0.000545 236.6400n -0.000581 236.6500n -0.000617 236.6600n -0.000653 236.6700n -0.000690 236.6800n -0.000727 236.6900n -0.000765
+ 236.7000n -0.000803 236.7100n -0.000841 236.7200n -0.000879 236.7300n -0.000917 236.7400n -0.000956 236.7500n -0.000995 236.7600n -0.001034 236.7700n -0.001073 236.7800n -0.001113 236.7900n -0.001152 236.8000n -0.001192 236.8100n -0.001232 236.8200n -0.001271 236.8300n -0.001311 236.8400n -0.001351
+ 236.8500n -0.001391 236.8600n -0.001431 236.8700n -0.001471 236.8800n -0.001510 236.8900n -0.001550 236.9000n -0.001589 236.9100n -0.001629 236.9200n -0.001668 236.9300n -0.001707 236.9400n -0.001746 236.9500n -0.001785 236.9600n -0.001824 236.9700n -0.001862 236.9800n -0.001900 236.9900n -0.001938
+ 237.0000n -0.001976 237.0100n -0.002013 237.0200n -0.002050 237.0300n -0.002086 237.0400n -0.002122 237.0500n -0.002158 237.0600n -0.002193 237.0700n -0.002228 237.0800n -0.002263 237.0900n -0.002297 237.1000n -0.002330 237.1100n -0.002363 237.1200n -0.002396 237.1300n -0.002428 237.1400n -0.002459
+ 237.1500n -0.002490 237.1600n -0.002521 237.1700n -0.002550 237.1800n -0.002579 237.1900n -0.002608 237.2000n -0.002636 237.2100n -0.002663 237.2200n -0.002689 237.2300n -0.002715 237.2400n -0.002740 237.2500n -0.002765 237.2600n -0.002788 237.2700n -0.002811 237.2800n -0.002833 237.2900n -0.002855
+ 237.3000n -0.002876 237.3100n -0.002895 237.3200n -0.002915 237.3300n -0.002933 237.3400n -0.002950 237.3500n -0.002967 237.3600n -0.002983 237.3700n -0.002998 237.3800n -0.003012 237.3900n -0.003025 237.4000n -0.003038 237.4100n -0.003050 237.4200n -0.003060 237.4300n -0.003070 237.4400n -0.003079
+ 237.4500n -0.003087 237.4600n -0.003095 237.4700n -0.003101 237.4800n -0.003106 237.4900n -0.003111 237.5000n -0.003115 237.5100n -0.003117 237.5200n -0.003119 237.5300n -0.003120 237.5400n -0.003121 237.5500n -0.003120 237.5600n -0.003118 237.5700n -0.003116 237.5800n -0.003112 237.5900n -0.003108
+ 237.6000n -0.003103 237.6100n -0.003096 237.6200n -0.003090 237.6300n -0.003082 237.6400n -0.003073 237.6500n -0.003063 237.6600n -0.003053 237.6700n -0.003042 237.6800n -0.003030 237.6900n -0.003017 237.7000n -0.003003 237.7100n -0.002989 237.7200n -0.002973 237.7300n -0.002957 237.7400n -0.002940
+ 237.7500n -0.002923 237.7600n -0.002904 237.7700n -0.002885 237.7800n -0.002865 237.7900n -0.002844 237.8000n -0.002823 237.8100n -0.002801 237.8200n -0.002778 237.8300n -0.002754 237.8400n -0.002730 237.8500n -0.002705 237.8600n -0.002680 237.8700n -0.002654 237.8800n -0.002627 237.8900n -0.002600
+ 237.9000n -0.002572 237.9100n -0.002543 237.9200n -0.002514 237.9300n -0.002485 237.9400n -0.002454 237.9500n -0.002424 237.9600n -0.002393 237.9700n -0.002361 237.9800n -0.002329 237.9900n -0.002297 238.0000n -0.002264 238.0100n -0.002230 238.0200n -0.002197 238.0300n -0.002163 238.0400n -0.002128
+ 238.0500n -0.002093 238.0600n -0.002058 238.0700n -0.002023 238.0800n -0.001987 238.0900n -0.001951 238.1000n -0.001915 238.1100n -0.001879 238.1200n -0.001842 238.1300n -0.001805 238.1400n -0.001768 238.1500n -0.001731 238.1600n -0.001693 238.1700n -0.001656 238.1800n -0.001618 238.1900n -0.001581
+ 238.2000n -0.001543 238.2100n -0.001505 238.2200n -0.001467 238.2300n -0.001430 238.2400n -0.001392 238.2500n -0.001354 238.2600n -0.001316 238.2700n -0.001278 238.2800n -0.001241 238.2900n -0.001203 238.3000n -0.001166 238.3100n -0.001128 238.3200n -0.001091 238.3300n -0.001054 238.3400n -0.001017
+ 238.3500n -0.000980 238.3600n -0.000943 238.3700n -0.000907 238.3800n -0.000871 238.3900n -0.000835 238.4000n -0.000799 238.4100n -0.000764 238.4200n -0.000729 238.4300n -0.000694 238.4400n -0.000659 238.4500n -0.000625 238.4600n -0.000591 238.4700n -0.000558 238.4800n -0.000525 238.4900n -0.000492
+ 238.5000n -0.000459 238.5100n -0.000427 238.5200n -0.000396 238.5300n -0.000364 238.5400n -0.000334 238.5500n -0.000303 238.5600n -0.000273 238.5700n -0.000244 238.5800n -0.000215 238.5900n -0.000186 238.6000n -0.000158 238.6100n -0.000130 238.6200n -0.000103 238.6300n -0.000076 238.6400n -0.000050
+ 238.6500n -0.000024 238.6600n 0.000001 238.6700n 0.000025 238.6800n 0.000050 238.6900n 0.000073 238.7000n 0.000096 238.7100n 0.000119 238.7200n 0.000141 238.7300n 0.000162 238.7400n 0.000183 238.7500n 0.000204 238.7600n 0.000224 238.7700n 0.000243 238.7800n 0.000262 238.7900n 0.000280
+ 238.8000n 0.000298 238.8100n 0.000315 238.8200n 0.000331 238.8300n 0.000347 238.8400n 0.000363 238.8500n 0.000378 238.8600n 0.000392 238.8700n 0.000406 238.8800n 0.000419 238.8900n 0.000432 238.9000n 0.000444 238.9100n 0.000456 238.9200n 0.000467 238.9300n 0.000478 238.9400n 0.000488
+ 238.9500n 0.000497 238.9600n 0.000507 238.9700n 0.000515 238.9800n 0.000523 238.9900n 0.000531 239.0000n 0.000538 239.0100n 0.000544 239.0200n 0.000551 239.0300n 0.000556 239.0400n 0.000562 239.0500n 0.000566 239.0600n 0.000571 239.0700n 0.000574 239.0800n 0.000578 239.0900n 0.000581
+ 239.1000n 0.000583 239.1100n 0.000586 239.1200n 0.000587 239.1300n 0.000589 239.1400n 0.000590 239.1500n 0.000590 239.1600n 0.000590 239.1700n 0.000590 239.1800n 0.000590 239.1900n 0.000589 239.2000n 0.000588 239.2100n 0.000586 239.2200n 0.000585 239.2300n 0.000582 239.2400n 0.000580
+ 239.2500n 0.000577 239.2600n 0.000574 239.2700n 0.000571 239.2800n 0.000568 239.2900n 0.000564 239.3000n 0.000560 239.3100n 0.000556 239.3200n 0.000551 239.3300n 0.000547 239.3400n 0.000542 239.3500n 0.000537 239.3600n 0.000532 239.3700n 0.000527 239.3800n 0.000521 239.3900n 0.000516
+ 239.4000n 0.000510 239.4100n 0.000504 239.4200n 0.000498 239.4300n 0.000492 239.4400n 0.000486 239.4500n 0.000479 239.4600n 0.000473 239.4700n 0.000467 239.4800n 0.000460 239.4900n 0.000454 239.5000n 0.000447 239.5100n 0.000441 239.5200n 0.000434 239.5300n 0.000427 239.5400n 0.000421
+ 239.5500n 0.000414 239.5600n 0.000407 239.5700n 0.000401 239.5800n 0.000394 239.5900n 0.000388 239.6000n 0.000381 239.6100n 0.000375 239.6200n 0.000368 239.6300n 0.000362 239.6400n 0.000356 239.6500n 0.000350 239.6600n 0.000344 239.6700n 0.000338 239.6800n 0.000332 239.6900n 0.000326
+ 239.7000n 0.000320 239.7100n 0.000315 239.7200n 0.000309 239.7300n 0.000304 239.7400n 0.000299 239.7500n 0.000294 239.7600n 0.000289 239.7700n 0.000284 239.7800n 0.000280 239.7900n 0.000275 239.8000n 0.000271 239.8100n 0.000267 239.8200n 0.000263 239.8300n 0.000259 239.8400n 0.000255
+ 239.8500n 0.000252 239.8600n 0.000249 239.8700n 0.000245 239.8800n 0.000243 239.8900n 0.000240 239.9000n 0.000237 239.9100n 0.000235 239.9200n 0.000233 239.9300n 0.000231 239.9400n 0.000229 239.9500n 0.000227 239.9600n 0.000226 239.9700n 0.000225 239.9800n 0.000224 239.9900n 0.000223
+ 240.0000n 0.000222 240.0100n 0.000222 240.0200n 0.000222 240.0300n 0.000222 240.0400n 0.000222 240.0500n 0.000222 240.0600n 0.000223 240.0700n 0.000223 240.0800n 0.000224 240.0900n 0.000225 240.1000n 0.000226 240.1100n 0.000228 240.1200n 0.000230 240.1300n 0.000231 240.1400n 0.000233
+ 240.1500n 0.000235 240.1600n 0.000238 240.1700n 0.000240 240.1800n 0.000243 240.1900n 0.000246 240.2000n 0.000249 240.2100n 0.000252 240.2200n 0.000255 240.2300n 0.000259 240.2400n 0.000262 240.2500n 0.000266 240.2600n 0.000270 240.2700n 0.000274 240.2800n 0.000278 240.2900n 0.000282
+ 240.3000n 0.000287 240.3100n 0.000291 240.3200n 0.000296 240.3300n 0.000301 240.3400n 0.000306 240.3500n 0.000311 240.3600n 0.000316 240.3700n 0.000321 240.3800n 0.000327 240.3900n 0.000332 240.4000n 0.000338 240.4100n 0.000343 240.4200n 0.000349 240.4300n 0.000355 240.4400n 0.000361
+ 240.4500n 0.000367 240.4600n 0.000373 240.4700n 0.000379 240.4800n 0.000385 240.4900n 0.000391 240.5000n 0.000397 240.5100n 0.000404 240.5200n 0.000410 240.5300n 0.000417 240.5400n 0.000423 240.5500n 0.000430 240.5600n 0.000436 240.5700n 0.000443 240.5800n 0.000450 240.5900n 0.000456
+ 240.6000n 0.000463 240.6100n 0.000470 240.6200n 0.000477 240.6300n 0.000484 240.6400n 0.000490 240.6500n 0.000497 240.6600n 0.000504 240.6700n 0.000511 240.6800n 0.000518 240.6900n 0.000525 240.7000n 0.000532 240.7100n 0.000539 240.7200n 0.000546 240.7300n 0.000553 240.7400n 0.000559
+ 240.7500n 0.000566 240.7600n 0.000573 240.7700n 0.000580 240.7800n 0.000587 240.7900n 0.000594 240.8000n 0.000601 240.8100n 0.000608 240.8200n 0.000615 240.8300n 0.000622 240.8400n 0.000629 240.8500n 0.000636 240.8600n 0.000643 240.8700n 0.000650 240.8800n 0.000657 240.8900n 0.000664
+ 240.9000n 0.000670 240.9100n 0.000677 240.9200n 0.000684 240.9300n 0.000691 240.9400n 0.000698 240.9500n 0.000705 240.9600n 0.000712 240.9700n 0.000719 240.9800n 0.000726 240.9900n 0.000733 241.0000n 0.000740 241.0100n 0.000746 241.0200n 0.000753 241.0300n 0.000760 241.0400n 0.000767
+ 241.0500n 0.000774 241.0600n 0.000781 241.0700n 0.000788 241.0800n 0.000795 241.0900n 0.000802 241.1000n 0.000809 241.1100n 0.000816 241.1200n 0.000823 241.1300n 0.000830 241.1400n 0.000837 241.1500n 0.000845 241.1600n 0.000852 241.1700n 0.000859 241.1800n 0.000866 241.1900n 0.000873
+ 241.2000n 0.000881 241.2100n 0.000888 241.2200n 0.000895 241.2300n 0.000903 241.2400n 0.000910 241.2500n 0.000918 241.2600n 0.000925 241.2700n 0.000933 241.2800n 0.000941 241.2900n 0.000948 241.3000n 0.000956 241.3100n 0.000964 241.3200n 0.000972 241.3300n 0.000980 241.3400n 0.000987
+ 241.3500n 0.000995 241.3600n 0.001004 241.3700n 0.001012 241.3800n 0.001020 241.3900n 0.001028 241.4000n 0.001036 241.4100n 0.001045 241.4200n 0.001053 241.4300n 0.001062 241.4400n 0.001070 241.4500n 0.001079 241.4600n 0.001088 241.4700n 0.001096 241.4800n 0.001105 241.4900n 0.001114
+ 241.5000n 0.001123 241.5100n 0.001132 241.5200n 0.001141 241.5300n 0.001150 241.5400n 0.001159 241.5500n 0.001168 241.5600n 0.001177 241.5700n 0.001187 241.5800n 0.001196 241.5900n 0.001206 241.6000n 0.001215 241.6100n 0.001224 241.6200n 0.001234 241.6300n 0.001244 241.6400n 0.001253
+ 241.6500n 0.001263 241.6600n 0.001272 241.6700n 0.001282 241.6800n 0.001292 241.6900n 0.001302 241.7000n 0.001311 241.7100n 0.001321 241.7200n 0.001331 241.7300n 0.001341 241.7400n 0.001350 241.7500n 0.001360 241.7600n 0.001370 241.7700n 0.001379 241.7800n 0.001389 241.7900n 0.001399
+ 241.8000n 0.001408 241.8100n 0.001418 241.8200n 0.001428 241.8300n 0.001437 241.8400n 0.001446 241.8500n 0.001456 241.8600n 0.001465 241.8700n 0.001474 241.8800n 0.001483 241.8900n 0.001492 241.9000n 0.001501 241.9100n 0.001510 241.9200n 0.001519 241.9300n 0.001528 241.9400n 0.001536
+ 241.9500n 0.001544 241.9600n 0.001552 241.9700n 0.001561 241.9800n 0.001568 241.9900n 0.001576 242.0000n 0.001584 242.0100n 0.001591 242.0200n 0.001598 242.0300n 0.001605 242.0400n 0.001612 242.0500n 0.001618 242.0600n 0.001625 242.0700n 0.001631 242.0800n 0.001636 242.0900n 0.001642
+ 242.1000n 0.001647 242.1100n 0.001652 242.1200n 0.001657 242.1300n 0.001661 242.1400n 0.001665 242.1500n 0.001669 242.1600n 0.001673 242.1700n 0.001676 242.1800n 0.001679 242.1900n 0.001681 242.2000n 0.001683 242.2100n 0.001685 242.2200n 0.001686 242.2300n 0.001687 242.2400n 0.001688
+ 242.2500n 0.001688 242.2600n 0.001688 242.2700n 0.001687 242.2800n 0.001686 242.2900n 0.001685 242.3000n 0.001683 242.3100n 0.001680 242.3200n 0.001678 242.3300n 0.001674 242.3400n 0.001671 242.3500n 0.001666 242.3600n 0.001662 242.3700n 0.001656 242.3800n 0.001651 242.3900n 0.001644
+ 242.4000n 0.001638 242.4100n 0.001630 242.4200n 0.001622 242.4300n 0.001614 242.4400n 0.001605 242.4500n 0.001596 242.4600n 0.001586 242.4700n 0.001575 242.4800n 0.001564 242.4900n 0.001552 242.5000n 0.001540 242.5100n 0.001527 242.5200n 0.001514 242.5300n 0.001500 242.5400n 0.001485
+ 242.5500n 0.001470 242.5600n 0.001454 242.5700n 0.001438 242.5800n 0.001421 242.5900n 0.001404 242.6000n 0.001386 242.6100n 0.001367 242.6200n 0.001347 242.6300n 0.001328 242.6400n 0.001307 242.6500n 0.001286 242.6600n 0.001264 242.6700n 0.001242 242.6800n 0.001219 242.6900n 0.001196
+ 242.7000n 0.001172 242.7100n 0.001147 242.7200n 0.001122 242.7300n 0.001096 242.7400n 0.001069 242.7500n 0.001042 242.7600n 0.001015 242.7700n 0.000987 242.7800n 0.000958 242.7900n 0.000929 242.8000n 0.000899 242.8100n 0.000869 242.8200n 0.000838 242.8300n 0.000807 242.8400n 0.000775
+ 242.8500n 0.000743 242.8600n 0.000710 242.8700n 0.000677 242.8800n 0.000643 242.8900n 0.000609 242.9000n 0.000574 242.9100n 0.000539 242.9200n 0.000503 242.9300n 0.000467 242.9400n 0.000431 242.9500n 0.000394 242.9600n 0.000357 242.9700n 0.000319 242.9800n 0.000281 242.9900n 0.000243
+ 243.0000n 0.000204 243.0100n 0.000165 243.0200n 0.000126 243.0300n 0.000086 243.0400n 0.000047 243.0500n 0.000007 243.0600n -0.000034 243.0700n -0.000074 243.0800n -0.000115 243.0900n -0.000156 243.1000n -0.000197 243.1100n -0.000238 243.1200n -0.000280 243.1300n -0.000321 243.1400n -0.000363
+ 243.1500n -0.000405 243.1600n -0.000446 243.1700n -0.000488 243.1800n -0.000530 243.1900n -0.000572 243.2000n -0.000614 243.2100n -0.000655 243.2200n -0.000697 243.2300n -0.000739 243.2400n -0.000780 243.2500n -0.000822 243.2600n -0.000863 243.2700n -0.000904 243.2800n -0.000945 243.2900n -0.000986
+ 243.3000n -0.001027 243.3100n -0.001067 243.3200n -0.001107 243.3300n -0.001147 243.3400n -0.001186 243.3500n -0.001225 243.3600n -0.001264 243.3700n -0.001302 243.3800n -0.001340 243.3900n -0.001378 243.4000n -0.001415 243.4100n -0.001452 243.4200n -0.001488 243.4300n -0.001524 243.4400n -0.001559
+ 243.4500n -0.001594 243.4600n -0.001628 243.4700n -0.001662 243.4800n -0.001695 243.4900n -0.001727 243.5000n -0.001759 243.5100n -0.001790 243.5200n -0.001820 243.5300n -0.001850 243.5400n -0.001879 243.5500n -0.001907 243.5600n -0.001934 243.5700n -0.001961 243.5800n -0.001987 243.5900n -0.002012
+ 243.6000n -0.002036 243.6100n -0.002060 243.6200n -0.002082 243.6300n -0.002104 243.6400n -0.002125 243.6500n -0.002145 243.6600n -0.002164 243.6700n -0.002182 243.6800n -0.002199 243.6900n -0.002215 243.7000n -0.002230 243.7100n -0.002244 243.7200n -0.002257 243.7300n -0.002270 243.7400n -0.002281
+ 243.7500n -0.002291 243.7600n -0.002300 243.7700n -0.002308 243.7800n -0.002315 243.7900n -0.002321 243.8000n -0.002325 243.8100n -0.002329 243.8200n -0.002332 243.8300n -0.002333 243.8400n -0.002333 243.8500n -0.002333 243.8600n -0.002331 243.8700n -0.002328 243.8800n -0.002324 243.8900n -0.002318
+ 243.9000n -0.002312 243.9100n -0.002305 243.9200n -0.002296 243.9300n -0.002286 243.9400n -0.002275 243.9500n -0.002263 243.9600n -0.002250 243.9700n -0.002236 243.9800n -0.002220 243.9900n -0.002204 244.0000n -0.002186 244.0100n -0.002167 244.0200n -0.002147 244.0300n -0.002126 244.0400n -0.002104
+ 244.0500n -0.002081 244.0600n -0.002057 244.0700n -0.002031 244.0800n -0.002005 244.0900n -0.001978 244.1000n -0.001949 244.1100n -0.001920 244.1200n -0.001889 244.1300n -0.001858 244.1400n -0.001825 244.1500n -0.001792 244.1600n -0.001757 244.1700n -0.001722 244.1800n -0.001686 244.1900n -0.001648
+ 244.2000n -0.001610 244.2100n -0.001571 244.2200n -0.001531 244.2300n -0.001491 244.2400n -0.001449 244.2500n -0.001407 244.2600n -0.001364 244.2700n -0.001320 244.2800n -0.001275 244.2900n -0.001230 244.3000n -0.001184 244.3100n -0.001137 244.3200n -0.001090 244.3300n -0.001042 244.3400n -0.000994
+ 244.3500n -0.000945 244.3600n -0.000895 244.3700n -0.000845 244.3800n -0.000794 244.3900n -0.000743 244.4000n -0.000691 244.4100n -0.000639 244.4200n -0.000587 244.4300n -0.000534 244.4400n -0.000481 244.4500n -0.000428 244.4600n -0.000374 244.4700n -0.000321 244.4800n -0.000266 244.4900n -0.000212
+ 244.5000n -0.000158 244.5100n -0.000103 244.5200n -0.000049 244.5300n 0.000006 244.5400n 0.000061 244.5500n 0.000115 244.5600n 0.000170 244.5700n 0.000225 244.5800n 0.000279 244.5900n 0.000334 244.6000n 0.000388 244.6100n 0.000442 244.6200n 0.000496 244.6300n 0.000550 244.6400n 0.000603
+ 244.6500n 0.000656 244.6600n 0.000709 244.6700n 0.000761 244.6800n 0.000813 244.6900n 0.000865 244.7000n 0.000916 244.7100n 0.000966 244.7200n 0.001016 244.7300n 0.001066 244.7400n 0.001115 244.7500n 0.001163 244.7600n 0.001211 244.7700n 0.001258 244.7800n 0.001304 244.7900n 0.001350
+ 244.8000n 0.001395 244.8100n 0.001439 244.8200n 0.001483 244.8300n 0.001525 244.8400n 0.001567 244.8500n 0.001608 244.8600n 0.001648 244.8700n 0.001687 244.8800n 0.001725 244.8900n 0.001763 244.9000n 0.001799 244.9100n 0.001834 244.9200n 0.001868 244.9300n 0.001901 244.9400n 0.001934
+ 244.9500n 0.001965 244.9600n 0.001995 244.9700n 0.002023 244.9800n 0.002051 244.9900n 0.002078 245.0000n 0.002103 245.0100n 0.002127 245.0200n 0.002150 245.0300n 0.002172 245.0400n 0.002193 245.0500n 0.002212 245.0600n 0.002231 245.0700n 0.002247 245.0800n 0.002263 245.0900n 0.002277
+ 245.1000n 0.002291 245.1100n 0.002302 245.1200n 0.002313 245.1300n 0.002322 245.1400n 0.002330 245.1500n 0.002337 245.1600n 0.002342 245.1700n 0.002346 245.1800n 0.002349 245.1900n 0.002351 245.2000n 0.002351 245.2100n 0.002350 245.2200n 0.002347 245.2300n 0.002344 245.2400n 0.002339
+ 245.2500n 0.002332 245.2600n 0.002325 245.2700n 0.002316 245.2800n 0.002306 245.2900n 0.002294 245.3000n 0.002282 245.3100n 0.002268 245.3200n 0.002253 245.3300n 0.002237 245.3400n 0.002219 245.3500n 0.002200 245.3600n 0.002180 245.3700n 0.002159 245.3800n 0.002137 245.3900n 0.002114
+ 245.4000n 0.002090 245.4100n 0.002064 245.4200n 0.002038 245.4300n 0.002010 245.4400n 0.001982 245.4500n 0.001952 245.4600n 0.001921 245.4700n 0.001890 245.4800n 0.001857 245.4900n 0.001824 245.5000n 0.001790 245.5100n 0.001754 245.5200n 0.001718 245.5300n 0.001682 245.5400n 0.001644
+ 245.5500n 0.001606 245.5600n 0.001566 245.5700n 0.001527 245.5800n 0.001486 245.5900n 0.001445 245.6000n 0.001403 245.6100n 0.001361 245.6200n 0.001318 245.6300n 0.001275 245.6400n 0.001231 245.6500n 0.001187 245.6600n 0.001142 245.6700n 0.001097 245.6800n 0.001052 245.6900n 0.001006
+ 245.7000n 0.000960 245.7100n 0.000914 245.7200n 0.000867 245.7300n 0.000821 245.7400n 0.000774 245.7500n 0.000727 245.7600n 0.000680 245.7700n 0.000633 245.7800n 0.000586 245.7900n 0.000539 245.8000n 0.000492 245.8100n 0.000445 245.8200n 0.000399 245.8300n 0.000352 245.8400n 0.000306
+ 245.8500n 0.000260 245.8600n 0.000214 245.8700n 0.000168 245.8800n 0.000123 245.8900n 0.000079 245.9000n 0.000034 245.9100n -0.000009 245.9200n -0.000053 245.9300n -0.000096 245.9400n -0.000138 245.9500n -0.000180 245.9600n -0.000221 245.9700n -0.000261 245.9800n -0.000301 245.9900n -0.000340
+ 246.0000n -0.000378 246.0100n -0.000416 246.0200n -0.000452 246.0300n -0.000488 246.0400n -0.000523 246.0500n -0.000557 246.0600n -0.000591 246.0700n -0.000623 246.0800n -0.000654 246.0900n -0.000684 246.1000n -0.000714 246.1100n -0.000742 246.1200n -0.000769 246.1300n -0.000795 246.1400n -0.000820
+ 246.1500n -0.000844 246.1600n -0.000866 246.1700n -0.000888 246.1800n -0.000908 246.1900n -0.000927 246.2000n -0.000945 246.2100n -0.000962 246.2200n -0.000977 246.2300n -0.000991 246.2400n -0.001004 246.2500n -0.001015 246.2600n -0.001026 246.2700n -0.001035 246.2800n -0.001042 246.2900n -0.001048
+ 246.3000n -0.001053 246.3100n -0.001057 246.3200n -0.001059 246.3300n -0.001059 246.3400n -0.001059 246.3500n -0.001057 246.3600n -0.001053 246.3700n -0.001049 246.3800n -0.001043 246.3900n -0.001035 246.4000n -0.001026 246.4100n -0.001016 246.4200n -0.001004 246.4300n -0.000991 246.4400n -0.000977
+ 246.4500n -0.000962 246.4600n -0.000945 246.4700n -0.000926 246.4800n -0.000907 246.4900n -0.000886 246.5000n -0.000863 246.5100n -0.000840 246.5200n -0.000815 246.5300n -0.000789 246.5400n -0.000762 246.5500n -0.000733 246.5600n -0.000703 246.5700n -0.000673 246.5800n -0.000640 246.5900n -0.000607
+ 246.6000n -0.000573 246.6100n -0.000537 246.6200n -0.000501 246.6300n -0.000463 246.6400n -0.000425 246.6500n -0.000385 246.6600n -0.000345 246.6700n -0.000303 246.6800n -0.000261 246.6900n -0.000217 246.7000n -0.000173 246.7100n -0.000128 246.7200n -0.000082 246.7300n -0.000036 246.7400n 0.000012
+ 246.7500n 0.000060 246.7600n 0.000108 246.7700n 0.000158 246.7800n 0.000208 246.7900n 0.000258 246.8000n 0.000309 246.8100n 0.000361 246.8200n 0.000413 246.8300n 0.000465 246.8400n 0.000518 246.8500n 0.000571 246.8600n 0.000625 246.8700n 0.000679 246.8800n 0.000733 246.8900n 0.000787
+ 246.9000n 0.000841 246.9100n 0.000896 246.9200n 0.000950 246.9300n 0.001005 246.9400n 0.001059 246.9500n 0.001114 246.9600n 0.001168 246.9700n 0.001223 246.9800n 0.001277 246.9900n 0.001331 247.0000n 0.001384 247.0100n 0.001438 247.0200n 0.001491 247.0300n 0.001544 247.0400n 0.001596
+ 247.0500n 0.001648 247.0600n 0.001699 247.0700n 0.001750 247.0800n 0.001801 247.0900n 0.001850 247.1000n 0.001900 247.1100n 0.001948 247.1200n 0.001996 247.1300n 0.002043 247.1400n 0.002089 247.1500n 0.002134 247.1600n 0.002179 247.1700n 0.002223 247.1800n 0.002266 247.1900n 0.002307
+ 247.2000n 0.002348 247.2100n 0.002388 247.2200n 0.002427 247.2300n 0.002464 247.2400n 0.002501 247.2500n 0.002536 247.2600n 0.002571 247.2700n 0.002604 247.2800n 0.002636 247.2900n 0.002666 247.3000n 0.002695 247.3100n 0.002723 247.3200n 0.002750 247.3300n 0.002775 247.3400n 0.002799
+ 247.3500n 0.002822 247.3600n 0.002843 247.3700n 0.002863 247.3800n 0.002881 247.3900n 0.002898 247.4000n 0.002913 247.4100n 0.002927 247.4200n 0.002939 247.4300n 0.002950 247.4400n 0.002959 247.4500n 0.002967 247.4600n 0.002973 247.4700n 0.002977 247.4800n 0.002980 247.4900n 0.002981
+ 247.5000n 0.002981 247.5100n 0.002979 247.5200n 0.002976 247.5300n 0.002971 247.5400n 0.002964 247.5500n 0.002956 247.5600n 0.002946 247.5700n 0.002934 247.5800n 0.002921 247.5900n 0.002906 247.6000n 0.002890 247.6100n 0.002872 247.6200n 0.002853 247.6300n 0.002832 247.6400n 0.002809
+ 247.6500n 0.002785 247.6600n 0.002759 247.6700n 0.002732 247.6800n 0.002703 247.6900n 0.002673 247.7000n 0.002641 247.7100n 0.002608 247.7200n 0.002573 247.7300n 0.002537 247.7400n 0.002499 247.7500n 0.002460 247.7600n 0.002420 247.7700n 0.002378 247.7800n 0.002335 247.7900n 0.002291
+ 247.8000n 0.002246 247.8100n 0.002199 247.8200n 0.002151 247.8300n 0.002102 247.8400n 0.002051 247.8500n 0.002000 247.8600n 0.001947 247.8700n 0.001893 247.8800n 0.001839 247.8900n 0.001783 247.9000n 0.001726 247.9100n 0.001669 247.9200n 0.001610 247.9300n 0.001551 247.9400n 0.001490
+ 247.9500n 0.001429 247.9600n 0.001368 247.9700n 0.001305 247.9800n 0.001242 247.9900n 0.001178 248.0000n 0.001114 248.0100n 0.001048 248.0200n 0.000983 248.0300n 0.000917 248.0400n 0.000850 248.0500n 0.000783 248.0600n 0.000716 248.0700n 0.000649 248.0800n 0.000581 248.0900n 0.000513
+ 248.1000n 0.000444 248.1100n 0.000376 248.1200n 0.000307 248.1300n 0.000239 248.1400n 0.000170 248.1500n 0.000101 248.1600n 0.000033 248.1700n -0.000036 248.1800n -0.000104 248.1900n -0.000172 248.2000n -0.000240 248.2100n -0.000308 248.2200n -0.000376 248.2300n -0.000443 248.2400n -0.000509
+ 248.2500n -0.000576 248.2600n -0.000642 248.2700n -0.000707 248.2800n -0.000772 248.2900n -0.000836 248.3000n -0.000899 248.3100n -0.000962 248.3200n -0.001025 248.3300n -0.001086 248.3400n -0.001147 248.3500n -0.001207 248.3600n -0.001266 248.3700n -0.001324 248.3800n -0.001382 248.3900n -0.001438
+ 248.4000n -0.001493 248.4100n -0.001548 248.4200n -0.001601 248.4300n -0.001654 248.4400n -0.001705 248.4500n -0.001755 248.4600n -0.001804 248.4700n -0.001852 248.4800n -0.001898 248.4900n -0.001944 248.5000n -0.001988 248.5100n -0.002031 248.5200n -0.002073 248.5300n -0.002113 248.5400n -0.002152
+ 248.5500n -0.002189 248.5600n -0.002226 248.5700n -0.002261 248.5800n -0.002294 248.5900n -0.002326 248.6000n -0.002357 248.6100n -0.002386 248.6200n -0.002414 248.6300n -0.002440 248.6400n -0.002465 248.6500n -0.002488 248.6600n -0.002510 248.6700n -0.002530 248.6800n -0.002549 248.6900n -0.002567
+ 248.7000n -0.002582 248.7100n -0.002597 248.7200n -0.002610 248.7300n -0.002621 248.7400n -0.002631 248.7500n -0.002639 248.7600n -0.002646 248.7700n -0.002651 248.7800n -0.002655 248.7900n -0.002657 248.8000n -0.002658 248.8100n -0.002657 248.8200n -0.002655 248.8300n -0.002652 248.8400n -0.002647
+ 248.8500n -0.002641 248.8600n -0.002633 248.8700n -0.002624 248.8800n -0.002613 248.8900n -0.002601 248.9000n -0.002588 248.9100n -0.002573 248.9200n -0.002558 248.9300n -0.002540 248.9400n -0.002522 248.9500n -0.002502 248.9600n -0.002482 248.9700n -0.002460 248.9800n -0.002436 248.9900n -0.002412
+ 249.0000n -0.002387 249.0100n -0.002360 249.0200n -0.002333 249.0300n -0.002304 249.0400n -0.002274 249.0500n -0.002244 249.0600n -0.002212 249.0700n -0.002180 249.0800n -0.002147 249.0900n -0.002113 249.1000n -0.002078 249.1100n -0.002042 249.1200n -0.002006 249.1300n -0.001969 249.1400n -0.001931
+ 249.1500n -0.001893 249.1600n -0.001854 249.1700n -0.001814 249.1800n -0.001774 249.1900n -0.001733 249.2000n -0.001692 249.2100n -0.001651 249.2200n -0.001609 249.2300n -0.001567 249.2400n -0.001524 249.2500n -0.001482 249.2600n -0.001439 249.2700n -0.001396 249.2800n -0.001352 249.2900n -0.001309
+ 249.3000n -0.001265 249.3100n -0.001222 249.3200n -0.001178 249.3300n -0.001135 249.3400n -0.001091 249.3500n -0.001048 249.3600n -0.001005 249.3700n -0.000962 249.3800n -0.000919 249.3900n -0.000877 249.4000n -0.000834 249.4100n -0.000792 249.4200n -0.000751 249.4300n -0.000710 249.4400n -0.000669
+ 249.4500n -0.000629 249.4600n -0.000589 249.4700n -0.000550 249.4800n -0.000511 249.4900n -0.000473 249.5000n -0.000435 249.5100n -0.000398 249.5200n -0.000362 249.5300n -0.000327 249.5400n -0.000292 249.5500n -0.000258 249.5600n -0.000224 249.5700n -0.000192 249.5800n -0.000160 249.5900n -0.000130
+ 249.6000n -0.000100 249.6100n -0.000071 249.6200n -0.000043 249.6300n -0.000016 249.6400n 0.000011 249.6500n 0.000036 249.6600n 0.000060 249.6700n 0.000083 249.6800n 0.000105 249.6900n 0.000126 249.7000n 0.000146 249.7100n 0.000165 249.7200n 0.000183 249.7300n 0.000200 249.7400n 0.000216
+ 249.7500n 0.000230 249.7600n 0.000244 249.7700n 0.000256 249.7800n 0.000267 249.7900n 0.000277 249.8000n 0.000286 249.8100n 0.000293 249.8200n 0.000300 249.8300n 0.000305 249.8400n 0.000310 249.8500n 0.000313 249.8600n 0.000315 249.8700n 0.000315 249.8800n 0.000315 249.8900n 0.000314
+ 249.9000n 0.000311 249.9100n 0.000307 249.9200n 0.000302 249.9300n 0.000296 249.9400n 0.000289 249.9500n 0.000281 249.9600n 0.000272 249.9700n 0.000261 249.9800n 0.000250 249.9900n 0.000237 250.0000n 0.000224 250.0100n 0.000209 250.0200n 0.000194 250.0300n 0.000177 250.0400n 0.000160
+ 250.0500n 0.000141 250.0600n 0.000122 250.0700n 0.000102 250.0800n 0.000081 250.0900n 0.000059 250.1000n 0.000036 250.1100n 0.000013 250.1200n -0.000012 250.1300n -0.000037 250.1400n -0.000063 250.1500n -0.000089 250.1600n -0.000116 250.1700n -0.000144 250.1800n -0.000173 250.1900n -0.000202
+ 250.2000n -0.000232 250.2100n -0.000262 250.2200n -0.000293 250.2300n -0.000324 250.2400n -0.000356 250.2500n -0.000388 250.2600n -0.000420 250.2700n -0.000453 250.2800n -0.000486 250.2900n -0.000520 250.3000n -0.000553 250.3100n -0.000587 250.3200n -0.000622 250.3300n -0.000656 250.3400n -0.000691
+ 250.3500n -0.000725 250.3600n -0.000760 250.3700n -0.000794 250.3800n -0.000829 250.3900n -0.000864 250.4000n -0.000899 250.4100n -0.000933 250.4200n -0.000967 250.4300n -0.001002 250.4400n -0.001036 250.4500n -0.001070 250.4600n -0.001103 250.4700n -0.001137 250.4800n -0.001170 250.4900n -0.001202
+ 250.5000n -0.001235 250.5100n -0.001267 250.5200n -0.001298 250.5300n -0.001329 250.5400n -0.001360 250.5500n -0.001390 250.5600n -0.001419 250.5700n -0.001448 250.5800n -0.001476 250.5900n -0.001504 250.6000n -0.001531 250.6100n -0.001558 250.6200n -0.001583 250.6300n -0.001608 250.6400n -0.001632
+ 250.6500n -0.001656 250.6600n -0.001679 250.6700n -0.001701 250.6800n -0.001722 250.6900n -0.001742 250.7000n -0.001761 250.7100n -0.001780 250.7200n -0.001797 250.7300n -0.001814 250.7400n -0.001830 250.7500n -0.001844 250.7600n -0.001858 250.7700n -0.001871 250.7800n -0.001883 250.7900n -0.001894
+ 250.8000n -0.001904 250.8100n -0.001913 250.8200n -0.001921 250.8300n -0.001927 250.8400n -0.001933 250.8500n -0.001938 250.8600n -0.001942 250.8700n -0.001944 250.8800n -0.001946 250.8900n -0.001947 250.9000n -0.001946 250.9100n -0.001945 250.9200n -0.001942 250.9300n -0.001939 250.9400n -0.001934
+ 250.9500n -0.001928 250.9600n -0.001921 250.9700n -0.001914 250.9800n -0.001905 250.9900n -0.001895 251.0000n -0.001884 251.0100n -0.001872 251.0200n -0.001859 251.0300n -0.001846 251.0400n -0.001831 251.0500n -0.001815 251.0600n -0.001798 251.0700n -0.001781 251.0800n -0.001762 251.0900n -0.001743
+ 251.1000n -0.001722 251.1100n -0.001701 251.1200n -0.001679 251.1300n -0.001656 251.1400n -0.001633 251.1500n -0.001608 251.1600n -0.001583 251.1700n -0.001557 251.1800n -0.001530 251.1900n -0.001503 251.2000n -0.001475 251.2100n -0.001446 251.2200n -0.001416 251.2300n -0.001386 251.2400n -0.001356
+ 251.2500n -0.001324 251.2600n -0.001293 251.2700n -0.001260 251.2800n -0.001228 251.2900n -0.001194 251.3000n -0.001161 251.3100n -0.001127 251.3200n -0.001092 251.3300n -0.001058 251.3400n -0.001023 251.3500n -0.000987 251.3600n -0.000952 251.3700n -0.000916 251.3800n -0.000880 251.3900n -0.000844
+ 251.4000n -0.000807 251.4100n -0.000771 251.4200n -0.000734 251.4300n -0.000698 251.4400n -0.000661 251.4500n -0.000624 251.4600n -0.000588 251.4700n -0.000551 251.4800n -0.000515 251.4900n -0.000479 251.5000n -0.000443 251.5100n -0.000407 251.5200n -0.000371 251.5300n -0.000336 251.5400n -0.000300
+ 251.5500n -0.000266 251.5600n -0.000231 251.5700n -0.000197 251.5800n -0.000163 251.5900n -0.000130 251.6000n -0.000097 251.6100n -0.000064 251.6200n -0.000032 251.6300n -0.000001 251.6400n 0.000030 251.6500n 0.000061 251.6600n 0.000090 251.6700n 0.000119 251.6800n 0.000148 251.6900n 0.000176
+ 251.7000n 0.000203 251.7100n 0.000230 251.7200n 0.000255 251.7300n 0.000280 251.7400n 0.000305 251.7500n 0.000328 251.7600n 0.000351 251.7700n 0.000373 251.7800n 0.000394 251.7900n 0.000414 251.8000n 0.000433 251.8100n 0.000452 251.8200n 0.000470 251.8300n 0.000486 251.8400n 0.000502
+ 251.8500n 0.000517 251.8600n 0.000531 251.8700n 0.000544 251.8800n 0.000556 251.8900n 0.000567 251.9000n 0.000577 251.9100n 0.000586 251.9200n 0.000595 251.9300n 0.000602 251.9400n 0.000608 251.9500n 0.000613 251.9600n 0.000618 251.9700n 0.000621 251.9800n 0.000623 251.9900n 0.000625
+ 252.0000n 0.000625 252.0100n 0.000624 252.0200n 0.000623 252.0300n 0.000620 252.0400n 0.000617 252.0500n 0.000612 252.0600n 0.000607 252.0700n 0.000600 252.0800n 0.000593 252.0900n 0.000585 252.1000n 0.000575 252.1100n 0.000565 252.1200n 0.000554 252.1300n 0.000542 252.1400n 0.000530
+ 252.1500n 0.000516 252.1600n 0.000501 252.1700n 0.000486 252.1800n 0.000470 252.1900n 0.000453 252.2000n 0.000435 252.2100n 0.000417 252.2200n 0.000397 252.2300n 0.000377 252.2400n 0.000357 252.2500n 0.000335 252.2600n 0.000313 252.2700n 0.000290 252.2800n 0.000267 252.2900n 0.000243
+ 252.3000n 0.000218 252.3100n 0.000193 252.3200n 0.000167 252.3300n 0.000141 252.3400n 0.000115 252.3500n 0.000087 252.3600n 0.000060 252.3700n 0.000032 252.3800n 0.000003 252.3900n -0.000026 252.4000n -0.000055 252.4100n -0.000085 252.4200n -0.000114 252.4300n -0.000144 252.4400n -0.000175
+ 252.4500n -0.000205 252.4600n -0.000236 252.4700n -0.000267 252.4800n -0.000298 252.4900n -0.000329 252.5000n -0.000361 252.5100n -0.000392 252.5200n -0.000424 252.5300n -0.000455 252.5400n -0.000486 252.5500n -0.000518 252.5600n -0.000549 252.5700n -0.000580 252.5800n -0.000611 252.5900n -0.000642
+ 252.6000n -0.000673 252.6100n -0.000704 252.6200n -0.000734 252.6300n -0.000764 252.6400n -0.000794 252.6500n -0.000824 252.6600n -0.000853 252.6700n -0.000882 252.6800n -0.000910 252.6900n -0.000938 252.7000n -0.000966 252.7100n -0.000994 252.7200n -0.001021 252.7300n -0.001047 252.7400n -0.001073
+ 252.7500n -0.001099 252.7600n -0.001123 252.7700n -0.001148 252.7800n -0.001172 252.7900n -0.001195 252.8000n -0.001218 252.8100n -0.001240 252.8200n -0.001261 252.8300n -0.001282 252.8400n -0.001303 252.8500n -0.001322 252.8600n -0.001341 252.8700n -0.001359 252.8800n -0.001377 252.8900n -0.001394
+ 252.9000n -0.001410 252.9100n -0.001425 252.9200n -0.001440 252.9300n -0.001454 252.9400n -0.001467 252.9500n -0.001479 252.9600n -0.001491 252.9700n -0.001502 252.9800n -0.001512 252.9900n -0.001521 253.0000n -0.001530 253.0100n -0.001537 253.0200n -0.001545 253.0300n -0.001551 253.0400n -0.001556
+ 253.0500n -0.001561 253.0600n -0.001565 253.0700n -0.001568 253.0800n -0.001570 253.0900n -0.001572 253.1000n -0.001573 253.1100n -0.001573 253.1200n -0.001573 253.1300n -0.001571 253.1400n -0.001569 253.1500n -0.001566 253.1600n -0.001563 253.1700n -0.001559 253.1800n -0.001554 253.1900n -0.001548
+ 253.2000n -0.001542 253.2100n -0.001535 253.2200n -0.001527 253.2300n -0.001519 253.2400n -0.001510 253.2500n -0.001501 253.2600n -0.001491 253.2700n -0.001480 253.2800n -0.001469 253.2900n -0.001457 253.3000n -0.001445 253.3100n -0.001433 253.3200n -0.001419 253.3300n -0.001406 253.3400n -0.001391
+ 253.3500n -0.001377 253.3600n -0.001362 253.3700n -0.001346 253.3800n -0.001331 253.3900n -0.001314 253.4000n -0.001298 253.4100n -0.001281 253.4200n -0.001264 253.4300n -0.001246 253.4400n -0.001229 253.4500n -0.001211 253.4600n -0.001193 253.4700n -0.001174 253.4800n -0.001156 253.4900n -0.001137
+ 253.5000n -0.001118 253.5100n -0.001099 253.5200n -0.001080 253.5300n -0.001061 253.5400n -0.001042 253.5500n -0.001023 253.5600n -0.001004 253.5700n -0.000985 253.5800n -0.000966 253.5900n -0.000946 253.6000n -0.000928 253.6100n -0.000909 253.6200n -0.000890 253.6300n -0.000871 253.6400n -0.000853
+ 253.6500n -0.000835 253.6600n -0.000816 253.6700n -0.000799 253.6800n -0.000781 253.6900n -0.000764 253.7000n -0.000746 253.7100n -0.000730 253.7200n -0.000713 253.7300n -0.000697 253.7400n -0.000681 253.7500n -0.000666 253.7600n -0.000650 253.7700n -0.000636 253.7800n -0.000621 253.7900n -0.000607
+ 253.8000n -0.000594 253.8100n -0.000581 253.8200n -0.000568 253.8300n -0.000556 253.8400n -0.000544 253.8500n -0.000533 253.8600n -0.000523 253.8700n -0.000512 253.8800n -0.000503 253.8900n -0.000494 253.9000n -0.000485 253.9100n -0.000477 253.9200n -0.000469 253.9300n -0.000462 253.9400n -0.000456
+ 253.9500n -0.000450 253.9600n -0.000445 253.9700n -0.000440 253.9800n -0.000436 253.9900n -0.000432 254.0000n -0.000429 254.0100n -0.000427 254.0200n -0.000425 254.0300n -0.000424 254.0400n -0.000423 254.0500n -0.000423 254.0600n -0.000423 254.0700n -0.000424 254.0800n -0.000425 254.0900n -0.000428
+ 254.1000n -0.000430 254.1100n -0.000433 254.1200n -0.000437 254.1300n -0.000441 254.1400n -0.000446 254.1500n -0.000451 254.1600n -0.000457 254.1700n -0.000463 254.1800n -0.000470 254.1900n -0.000477 254.2000n -0.000485 254.2100n -0.000493 254.2200n -0.000501 254.2300n -0.000510 254.2400n -0.000520
+ 254.2500n -0.000529 254.2600n -0.000540 254.2700n -0.000550 254.2800n -0.000561 254.2900n -0.000572 254.3000n -0.000584 254.3100n -0.000596 254.3200n -0.000608 254.3300n -0.000620 254.3400n -0.000633 254.3500n -0.000646 254.3600n -0.000659 254.3700n -0.000672 254.3800n -0.000685 254.3900n -0.000699
+ 254.4000n -0.000713 254.4100n -0.000727 254.4200n -0.000741 254.4300n -0.000755 254.4400n -0.000769 254.4500n -0.000783 254.4600n -0.000798 254.4700n -0.000812 254.4800n -0.000826 254.4900n -0.000840 254.5000n -0.000854 254.5100n -0.000868 254.5200n -0.000882 254.5300n -0.000896 254.5400n -0.000910
+ 254.5500n -0.000924 254.5600n -0.000937 254.5700n -0.000950 254.5800n -0.000963 254.5900n -0.000976 254.6000n -0.000988 254.6100n -0.001001 254.6200n -0.001013 254.6300n -0.001024 254.6400n -0.001036 254.6500n -0.001047 254.6600n -0.001057 254.6700n -0.001068 254.6800n -0.001077 254.6900n -0.001087
+ 254.7000n -0.001096 254.7100n -0.001104 254.7200n -0.001113 254.7300n -0.001120 254.7400n -0.001127 254.7500n -0.001134 254.7600n -0.001140 254.7700n -0.001146 254.7800n -0.001151 254.7900n -0.001155 254.8000n -0.001159 254.8100n -0.001163 254.8200n -0.001166 254.8300n -0.001168 254.8400n -0.001169
+ 254.8500n -0.001170 254.8600n -0.001171 254.8700n -0.001171 254.8800n -0.001170 254.8900n -0.001168 254.9000n -0.001166 254.9100n -0.001163 254.9200n -0.001160 254.9300n -0.001156 254.9400n -0.001151 254.9500n -0.001146 254.9600n -0.001140 254.9700n -0.001133 254.9800n -0.001126 254.9900n -0.001118
+ 255.0000n -0.001109 255.0100n -0.001100 255.0200n -0.001090 255.0300n -0.001079 255.0400n -0.001068 255.0500n -0.001056 255.0600n -0.001044 255.0700n -0.001030 255.0800n -0.001017 255.0900n -0.001002 255.1000n -0.000987 255.1100n -0.000972 255.1200n -0.000956 255.1300n -0.000939 255.1400n -0.000922
+ 255.1500n -0.000904 255.1600n -0.000885 255.1700n -0.000866 255.1800n -0.000847 255.1900n -0.000827 255.2000n -0.000807 255.2100n -0.000786 255.2200n -0.000765 255.2300n -0.000743 255.2400n -0.000721 255.2500n -0.000698 255.2600n -0.000675 255.2700n -0.000652 255.2800n -0.000628 255.2900n -0.000604
+ 255.3000n -0.000580 255.3100n -0.000556 255.3200n -0.000531 255.3300n -0.000506 255.3400n -0.000481 255.3500n -0.000455 255.3600n -0.000429 255.3700n -0.000404 255.3800n -0.000378 255.3900n -0.000352 255.4000n -0.000325 255.4100n -0.000299 255.4200n -0.000273 255.4300n -0.000247 255.4400n -0.000220
+ 255.4500n -0.000194 255.4600n -0.000168 255.4700n -0.000142 255.4800n -0.000116 255.4900n -0.000090 255.5000n -0.000064 255.5100n -0.000038 255.5200n -0.000013 255.5300n 0.000012 255.5400n 0.000037 255.5500n 0.000062 255.5600n 0.000086 255.5700n 0.000110 255.5800n 0.000134 255.5900n 0.000158
+ 255.6000n 0.000181 255.6100n 0.000203 255.6200n 0.000226 255.6300n 0.000247 255.6400n 0.000269 255.6500n 0.000289 255.6600n 0.000310 255.6700n 0.000329 255.6800n 0.000349 255.6900n 0.000367 255.7000n 0.000385 255.7100n 0.000403 255.7200n 0.000419 255.7300n 0.000436 255.7400n 0.000451
+ 255.7500n 0.000466 255.7600n 0.000480 255.7700n 0.000493 255.7800n 0.000506 255.7900n 0.000518 255.8000n 0.000529 255.8100n 0.000540 255.8200n 0.000549 255.8300n 0.000558 255.8400n 0.000566 255.8500n 0.000573 255.8600n 0.000580 255.8700n 0.000585 255.8800n 0.000590 255.8900n 0.000594
+ 255.9000n 0.000597 255.9100n 0.000599 255.9200n 0.000600 255.9300n 0.000601 255.9400n 0.000600 255.9500n 0.000599 255.9600n 0.000597 255.9700n 0.000594 255.9800n 0.000590 255.9900n 0.000585 256.0000n 0.000579 256.0100n 0.000572 256.0200n 0.000565 256.0300n 0.000556 256.0400n 0.000547
+ 256.0500n 0.000537 256.0600n 0.000526 256.0700n 0.000514 256.0800n 0.000501 256.0900n 0.000488 256.1000n 0.000473 256.1100n 0.000458 256.1200n 0.000442 256.1300n 0.000425 256.1400n 0.000408 256.1500n 0.000389 256.1600n 0.000370 256.1700n 0.000350 256.1800n 0.000329 256.1900n 0.000308
+ 256.2000n 0.000286 256.2100n 0.000263 256.2200n 0.000240 256.2300n 0.000216 256.2400n 0.000191 256.2500n 0.000166 256.2600n 0.000140 256.2700n 0.000113 256.2800n 0.000086 256.2900n 0.000059 256.3000n 0.000031 256.3100n 0.000002 256.3200n -0.000027 256.3300n -0.000056 256.3400n -0.000086
+ 256.3500n -0.000116 256.3600n -0.000147 256.3700n -0.000178 256.3800n -0.000209 256.3900n -0.000241 256.4000n -0.000272 256.4100n -0.000304 256.4200n -0.000336 256.4300n -0.000369 256.4400n -0.000401 256.4500n -0.000434 256.4600n -0.000466 256.4700n -0.000499 256.4800n -0.000532 256.4900n -0.000564
+ 256.5000n -0.000597 256.5100n -0.000629 256.5200n -0.000662 256.5300n -0.000694 256.5400n -0.000726 256.5500n -0.000758 256.5600n -0.000790 256.5700n -0.000822 256.5800n -0.000853 256.5900n -0.000884 256.6000n -0.000915 256.6100n -0.000945 256.6200n -0.000975 256.6300n -0.001004 256.6400n -0.001033
+ 256.6500n -0.001062 256.6600n -0.001090 256.6700n -0.001117 256.6800n -0.001144 256.6900n -0.001170 256.7000n -0.001196 256.7100n -0.001221 256.7200n -0.001245 256.7300n -0.001269 256.7400n -0.001292 256.7500n -0.001314 256.7600n -0.001336 256.7700n -0.001356 256.7800n -0.001376 256.7900n -0.001395
+ 256.8000n -0.001413 256.8100n -0.001431 256.8200n -0.001447 256.8300n -0.001463 256.8400n -0.001477 256.8500n -0.001491 256.8600n -0.001503 256.8700n -0.001515 256.8800n -0.001526 256.8900n -0.001535 256.9000n -0.001544 256.9100n -0.001551 256.9200n -0.001558 256.9300n -0.001563 256.9400n -0.001567
+ 256.9500n -0.001571 256.9600n -0.001573 256.9700n -0.001574 256.9800n -0.001573 256.9900n -0.001572 257.0000n -0.001570 257.0100n -0.001566 257.0200n -0.001562 257.0300n -0.001556 257.0400n -0.001549 257.0500n -0.001541 257.0600n -0.001531 257.0700n -0.001521 257.0800n -0.001509 257.0900n -0.001496
+ 257.1000n -0.001483 257.1100n -0.001468 257.1200n -0.001451 257.1300n -0.001434 257.1400n -0.001416 257.1500n -0.001396 257.1600n -0.001375 257.1700n -0.001354 257.1800n -0.001331 257.1900n -0.001307 257.2000n -0.001282 257.2100n -0.001256 257.2200n -0.001229 257.2300n -0.001201 257.2400n -0.001171
+ 257.2500n -0.001141 257.2600n -0.001110 257.2700n -0.001078 257.2800n -0.001045 257.2900n -0.001011 257.3000n -0.000976 257.3100n -0.000941 257.3200n -0.000904 257.3300n -0.000866 257.3400n -0.000828 257.3500n -0.000789 257.3600n -0.000749 257.3700n -0.000709 257.3800n -0.000668 257.3900n -0.000626
+ 257.4000n -0.000583 257.4100n -0.000540 257.4200n -0.000496 257.4300n -0.000451 257.4400n -0.000406 257.4500n -0.000361 257.4600n -0.000314 257.4700n -0.000268 257.4800n -0.000221 257.4900n -0.000174 257.5000n -0.000126 257.5100n -0.000078 257.5200n -0.000029 257.5300n 0.000019 257.5400n 0.000068
+ 257.5500n 0.000118 257.5600n 0.000167 257.5700n 0.000217 257.5800n 0.000266 257.5900n 0.000316 257.6000n 0.000366 257.6100n 0.000416 257.6200n 0.000465 257.6300n 0.000515 257.6400n 0.000565 257.6500n 0.000614 257.6600n 0.000664 257.6700n 0.000713 257.6800n 0.000762 257.6900n 0.000811
+ 257.7000n 0.000860 257.7100n 0.000908 257.7200n 0.000956 257.7300n 0.001003 257.7400n 0.001051 257.7500n 0.001097 257.7600n 0.001144 257.7700n 0.001189 257.7800n 0.001235 257.7900n 0.001279 257.8000n 0.001324 257.8100n 0.001367 257.8200n 0.001410 257.8300n 0.001452 257.8400n 0.001494
+ 257.8500n 0.001535 257.8600n 0.001575 257.8700n 0.001614 257.8800n 0.001653 257.8900n 0.001691 257.9000n 0.001728 257.9100n 0.001764 257.9200n 0.001799 257.9300n 0.001833 257.9400n 0.001867 257.9500n 0.001899 257.9600n 0.001931 257.9700n 0.001961 257.9800n 0.001991 257.9900n 0.002019
+ 258.0000n 0.002047 258.0100n 0.002073 258.0200n 0.002099 258.0300n 0.002123 258.0400n 0.002146 258.0500n 0.002169 258.0600n 0.002190 258.0700n 0.002210 258.0800n 0.002228 258.0900n 0.002246 258.1000n 0.002263 258.1100n 0.002278 258.1200n 0.002292 258.1300n 0.002305 258.1400n 0.002317
+ 258.1500n 0.002328 258.1600n 0.002338 258.1700n 0.002346 258.1800n 0.002353 258.1900n 0.002359 258.2000n 0.002364 258.2100n 0.002368 258.2200n 0.002371 258.2300n 0.002372 258.2400n 0.002372 258.2500n 0.002371 258.2600n 0.002369 258.2700n 0.002366 258.2800n 0.002362 258.2900n 0.002357
+ 258.3000n 0.002350 258.3100n 0.002343 258.3200n 0.002334 258.3300n 0.002324 258.3400n 0.002313 258.3500n 0.002301 258.3600n 0.002289 258.3700n 0.002275 258.3800n 0.002260 258.3900n 0.002244 258.4000n 0.002227 258.4100n 0.002209 258.4200n 0.002190 258.4300n 0.002171 258.4400n 0.002150
+ 258.4500n 0.002129 258.4600n 0.002106 258.4700n 0.002083 258.4800n 0.002059 258.4900n 0.002034 258.5000n 0.002009 258.5100n 0.001983 258.5200n 0.001956 258.5300n 0.001928 258.5400n 0.001900 258.5500n 0.001871 258.5600n 0.001841 258.5700n 0.001811 258.5800n 0.001780 258.5900n 0.001749
+ 258.6000n 0.001717 258.6100n 0.001684 258.6200n 0.001651 258.6300n 0.001618 258.6400n 0.001585 258.6500n 0.001550 258.6600n 0.001516 258.6700n 0.001481 258.6800n 0.001446 258.6900n 0.001411 258.7000n 0.001375 258.7100n 0.001339 258.7200n 0.001303 258.7300n 0.001267 258.7400n 0.001231
+ 258.7500n 0.001194 258.7600n 0.001158 258.7700n 0.001121 258.7800n 0.001084 258.7900n 0.001048 258.8000n 0.001011 258.8100n 0.000974 258.8200n 0.000938 258.8300n 0.000901 258.8400n 0.000865 258.8500n 0.000828 258.8600n 0.000792 258.8700n 0.000756 258.8800n 0.000721 258.8900n 0.000685
+ 258.9000n 0.000650 258.9100n 0.000615 258.9200n 0.000580 258.9300n 0.000546 258.9400n 0.000512 258.9500n 0.000478 258.9600n 0.000445 258.9700n 0.000412 258.9800n 0.000379 258.9900n 0.000347 259.0000n 0.000315 259.0100n 0.000284 259.0200n 0.000253 259.0300n 0.000223 259.0400n 0.000193
+ 259.0500n 0.000164 259.0600n 0.000135 259.0700n 0.000107 259.0800n 0.000079 259.0900n 0.000052 259.1000n 0.000026 259.1100n -0.000000 259.1200n -0.000026 259.1300n -0.000051 259.1400n -0.000075 259.1500n -0.000098 259.1600n -0.000121 259.1700n -0.000144 259.1800n -0.000166 259.1900n -0.000187
+ 259.2000n -0.000207 259.2100n -0.000227 259.2200n -0.000247 259.2300n -0.000265 259.2400n -0.000283 259.2500n -0.000301 259.2600n -0.000318 259.2700n -0.000334 259.2800n -0.000349 259.2900n -0.000364 259.3000n -0.000379 259.3100n -0.000392 259.3200n -0.000406 259.3300n -0.000418 259.3400n -0.000430
+ 259.3500n -0.000442 259.3600n -0.000453 259.3700n -0.000463 259.3800n -0.000473 259.3900n -0.000482 259.4000n -0.000491 259.4100n -0.000499 259.4200n -0.000507 259.4300n -0.000514 259.4400n -0.000521 259.4500n -0.000528 259.4600n -0.000533 259.4700n -0.000539 259.4800n -0.000544 259.4900n -0.000549
+ 259.5000n -0.000553 259.5100n -0.000557 259.5200n -0.000561 259.5300n -0.000564 259.5400n -0.000567 259.5500n -0.000570 259.5600n -0.000573 259.5700n -0.000575 259.5800n -0.000577 259.5900n -0.000579 259.6000n -0.000580 259.6100n -0.000582 259.6200n -0.000583 259.6300n -0.000584 259.6400n -0.000585
+ 259.6500n -0.000586 259.6600n -0.000587 259.6700n -0.000588 259.6800n -0.000588 259.6900n -0.000589 259.7000n -0.000590 259.7100n -0.000591 259.7200n -0.000592 259.7300n -0.000592 259.7400n -0.000593 259.7500n -0.000595 259.7600n -0.000596 259.7700n -0.000597 259.7800n -0.000599 259.7900n -0.000600
+ 259.8000n -0.000602 259.8100n -0.000604 259.8200n -0.000607 259.8300n -0.000609 259.8400n -0.000612 259.8500n -0.000615 259.8600n -0.000619 259.8700n -0.000623 259.8800n -0.000627 259.8900n -0.000631 259.9000n -0.000636 259.9100n -0.000642 259.9200n -0.000647 259.9300n -0.000653 259.9400n -0.000660
+ 259.9500n -0.000667 259.9600n -0.000674 259.9700n -0.000682 259.9800n -0.000690 259.9900n -0.000699 260.0000n -0.000708 260.0100n -0.000718 260.0200n -0.000728 260.0300n -0.000739 260.0400n -0.000750 260.0500n -0.000762 260.0600n -0.000775 260.0700n -0.000788 260.0800n -0.000801 260.0900n -0.000815
+ 260.1000n -0.000830 260.1100n -0.000845 260.1200n -0.000860 260.1300n -0.000877 260.1400n -0.000893 260.1500n -0.000911 260.1600n -0.000928 260.1700n -0.000947 260.1800n -0.000966 260.1900n -0.000985 260.2000n -0.001005 260.2100n -0.001026 260.2200n -0.001047 260.2300n -0.001069 260.2400n -0.001091
+ 260.2500n -0.001113 260.2600n -0.001136 260.2700n -0.001160 260.2800n -0.001184 260.2900n -0.001209 260.3000n -0.001234 260.3100n -0.001259 260.3200n -0.001285 260.3300n -0.001311 260.3400n -0.001338 260.3500n -0.001365 260.3600n -0.001393 260.3700n -0.001420 260.3800n -0.001448 260.3900n -0.001477
+ 260.4000n -0.001506 260.4100n -0.001535 260.4200n -0.001564 260.4300n -0.001594 260.4400n -0.001623 260.4500n -0.001653 260.4600n -0.001684 260.4700n -0.001714 260.4800n -0.001744 260.4900n -0.001775 260.5000n -0.001806 260.5100n -0.001836 260.5200n -0.001867 260.5300n -0.001898 260.5400n -0.001929
+ 260.5500n -0.001960 260.5600n -0.001991 260.5700n -0.002021 260.5800n -0.002052 260.5900n -0.002083 260.6000n -0.002113 260.6100n -0.002143 260.6200n -0.002173 260.6300n -0.002203 260.6400n -0.002233 260.6500n -0.002262 260.6600n -0.002291 260.6700n -0.002319 260.6800n -0.002348 260.6900n -0.002376
+ 260.7000n -0.002403 260.7100n -0.002430 260.7200n -0.002457 260.7300n -0.002483 260.7400n -0.002509 260.7500n -0.002534 260.7600n -0.002559 260.7700n -0.002583 260.7800n -0.002606 260.7900n -0.002629 260.8000n -0.002651 260.8100n -0.002673 260.8200n -0.002693 260.8300n -0.002713 260.8400n -0.002733
+ 260.8500n -0.002751 260.8600n -0.002769 260.8700n -0.002786 260.8800n -0.002802 260.8900n -0.002818 260.9000n -0.002832 260.9100n -0.002846 260.9200n -0.002858 260.9300n -0.002870 260.9400n -0.002881 260.9500n -0.002891 260.9600n -0.002900 260.9700n -0.002908 260.9800n -0.002915 260.9900n -0.002921
+ 261.0000n -0.002925 261.0100n -0.002929 261.0200n -0.002932 261.0300n -0.002934 261.0400n -0.002935 261.0500n -0.002934 261.0600n -0.002933 261.0700n -0.002930 261.0800n -0.002927 261.0900n -0.002922 261.1000n -0.002916 261.1100n -0.002909 261.1200n -0.002901 261.1300n -0.002892 261.1400n -0.002881
+ 261.1500n -0.002870 261.1600n -0.002857 261.1700n -0.002844 261.1800n -0.002829 261.1900n -0.002813 261.2000n -0.002796 261.2100n -0.002777 261.2200n -0.002758 261.2300n -0.002738 261.2400n -0.002716 261.2500n -0.002694 261.2600n -0.002670 261.2700n -0.002645 261.2800n -0.002619 261.2900n -0.002592
+ 261.3000n -0.002565 261.3100n -0.002536 261.3200n -0.002506 261.3300n -0.002475 261.3400n -0.002443 261.3500n -0.002410 261.3600n -0.002376 261.3700n -0.002341 261.3800n -0.002305 261.3900n -0.002269 261.4000n -0.002231 261.4100n -0.002193 261.4200n -0.002154 261.4300n -0.002114 261.4400n -0.002073
+ 261.4500n -0.002031 261.4600n -0.001989 261.4700n -0.001946 261.4800n -0.001902 261.4900n -0.001858 261.5000n -0.001813 261.5100n -0.001767 261.5200n -0.001721 261.5300n -0.001674 261.5400n -0.001627 261.5500n -0.001579 261.5600n -0.001530 261.5700n -0.001482 261.5800n -0.001432 261.5900n -0.001383
+ 261.6000n -0.001333 261.6100n -0.001282 261.6200n -0.001232 261.6300n -0.001181 261.6400n -0.001130 261.6500n -0.001078 261.6600n -0.001027 261.6700n -0.000975 261.6800n -0.000923 261.6900n -0.000871 261.7000n -0.000819 261.7100n -0.000767 261.7200n -0.000715 261.7300n -0.000664 261.7400n -0.000612
+ 261.7500n -0.000560 261.7600n -0.000508 261.7700n -0.000457 261.7800n -0.000406 261.7900n -0.000355 261.8000n -0.000304 261.8100n -0.000254 261.8200n -0.000204 261.8300n -0.000154 261.8400n -0.000105 261.8500n -0.000056 261.8600n -0.000007 261.8700n 0.000041 261.8800n 0.000088 261.8900n 0.000135
+ 261.9000n 0.000181 261.9100n 0.000227 261.9200n 0.000272 261.9300n 0.000317 261.9400n 0.000361 261.9500n 0.000404 261.9600n 0.000446 261.9700n 0.000488 261.9800n 0.000529 261.9900n 0.000569 262.0000n 0.000608 262.0100n 0.000647 262.0200n 0.000684 262.0300n 0.000721 262.0400n 0.000757
+ 262.0500n 0.000792 262.0600n 0.000826 262.0700n 0.000859 262.0800n 0.000891 262.0900n 0.000922 262.1000n 0.000952 262.1100n 0.000982 262.1200n 0.001010 262.1300n 0.001037 262.1400n 0.001063 262.1500n 0.001088 262.1600n 0.001112 262.1700n 0.001134 262.1800n 0.001156 262.1900n 0.001177
+ 262.2000n 0.001196 262.2100n 0.001215 262.2200n 0.001232 262.2300n 0.001248 262.2400n 0.001263 262.2500n 0.001278 262.2600n 0.001290 262.2700n 0.001302 262.2800n 0.001313 262.2900n 0.001323 262.3000n 0.001331 262.3100n 0.001338 262.3200n 0.001345 262.3300n 0.001350 262.3400n 0.001354
+ 262.3500n 0.001357 262.3600n 0.001359 262.3700n 0.001360 262.3800n 0.001360 262.3900n 0.001359 262.4000n 0.001356 262.4100n 0.001353 262.4200n 0.001349 262.4300n 0.001344 262.4400n 0.001338 262.4500n 0.001331 262.4600n 0.001323 262.4700n 0.001314 262.4800n 0.001304 262.4900n 0.001293
+ 262.5000n 0.001282 262.5100n 0.001269 262.5200n 0.001256 262.5300n 0.001242 262.5400n 0.001227 262.5500n 0.001212 262.5600n 0.001195 262.5700n 0.001178 262.5800n 0.001161 262.5900n 0.001142 262.6000n 0.001123 262.6100n 0.001104 262.6200n 0.001084 262.6300n 0.001063 262.6400n 0.001042
+ 262.6500n 0.001020 262.6600n 0.000998 262.6700n 0.000975 262.6800n 0.000952 262.6900n 0.000929 262.7000n 0.000905 262.7100n 0.000881 262.7200n 0.000857 262.7300n 0.000832 262.7400n 0.000807 262.7500n 0.000782 262.7600n 0.000757 262.7700n 0.000732 262.7800n 0.000706 262.7900n 0.000681
+ 262.8000n 0.000655 262.8100n 0.000630 262.8200n 0.000604 262.8300n 0.000578 262.8400n 0.000553 262.8500n 0.000528 262.8600n 0.000502 262.8700n 0.000477 262.8800n 0.000452 262.8900n 0.000428 262.9000n 0.000403 262.9100n 0.000379 262.9200n 0.000355 262.9300n 0.000332 262.9400n 0.000308
+ 262.9500n 0.000286 262.9600n 0.000263 262.9700n 0.000241 262.9800n 0.000220 262.9900n 0.000199 263.0000n 0.000178 263.0100n 0.000158 263.0200n 0.000139 263.0300n 0.000120 263.0400n 0.000102 263.0500n 0.000084 263.0600n 0.000068 263.0700n 0.000051 263.0800n 0.000036 263.0900n 0.000021
+ 263.1000n 0.000007 263.1100n -0.000007 263.1200n -0.000019 263.1300n -0.000031 263.1400n -0.000042 263.1500n -0.000053 263.1600n -0.000062 263.1700n -0.000071 263.1800n -0.000079 263.1900n -0.000085 263.2000n -0.000092 263.2100n -0.000097 263.2200n -0.000101 263.2300n -0.000104 263.2400n -0.000107
+ 263.2500n -0.000109 263.2600n -0.000109 263.2700n -0.000109 263.2800n -0.000108 263.2900n -0.000106 263.3000n -0.000103 263.3100n -0.000099 263.3200n -0.000094 263.3300n -0.000089 263.3400n -0.000082 263.3500n -0.000075 263.3600n -0.000066 263.3700n -0.000057 263.3800n -0.000046 263.3900n -0.000035
+ 263.4000n -0.000023 263.4100n -0.000010 263.4200n 0.000004 263.4300n 0.000018 263.4400n 0.000034 263.4500n 0.000050 263.4600n 0.000067 263.4700n 0.000085 263.4800n 0.000104 263.4900n 0.000124 263.5000n 0.000144 263.5100n 0.000165 263.5200n 0.000187 263.5300n 0.000209 263.5400n 0.000233
+ 263.5500n 0.000257 263.5600n 0.000281 263.5700n 0.000307 263.5800n 0.000332 263.5900n 0.000359 263.6000n 0.000386 263.6100n 0.000414 263.6200n 0.000442 263.6300n 0.000471 263.6400n 0.000500 263.6500n 0.000529 263.6600n 0.000559 263.6700n 0.000590 263.6800n 0.000621 263.6900n 0.000652
+ 263.7000n 0.000684 263.7100n 0.000715 263.7200n 0.000748 263.7300n 0.000780 263.7400n 0.000813 263.7500n 0.000846 263.7600n 0.000879 263.7700n 0.000912 263.7800n 0.000945 263.7900n 0.000978 263.8000n 0.001012 263.8100n 0.001045 263.8200n 0.001078 263.8300n 0.001112 263.8400n 0.001145
+ 263.8500n 0.001178 263.8600n 0.001211 263.8700n 0.001244 263.8800n 0.001277 263.8900n 0.001310 263.9000n 0.001342 263.9100n 0.001374 263.9200n 0.001406 263.9300n 0.001437 263.9400n 0.001468 263.9500n 0.001499 263.9600n 0.001529 263.9700n 0.001559 263.9800n 0.001589 263.9900n 0.001617
+ 264.0000n 0.001646 264.0100n 0.001674 264.0200n 0.001701 264.0300n 0.001728 264.0400n 0.001754 264.0500n 0.001779 264.0600n 0.001804 264.0700n 0.001828 264.0800n 0.001852 264.0900n 0.001874 264.1000n 0.001896 264.1100n 0.001918 264.1200n 0.001938 264.1300n 0.001958 264.1400n 0.001976
+ 264.1500n 0.001994 264.1600n 0.002012 264.1700n 0.002028 264.1800n 0.002043 264.1900n 0.002058 264.2000n 0.002071 264.2100n 0.002084 264.2200n 0.002095 264.2300n 0.002106 264.2400n 0.002116 264.2500n 0.002124 264.2600n 0.002132 264.2700n 0.002139 264.2800n 0.002145 264.2900n 0.002149
+ 264.3000n 0.002153 264.3100n 0.002156 264.3200n 0.002158 264.3300n 0.002158 264.3400n 0.002158 264.3500n 0.002156 264.3600n 0.002154 264.3700n 0.002151 264.3800n 0.002146 264.3900n 0.002141 264.4000n 0.002134 264.4100n 0.002126 264.4200n 0.002118 264.4300n 0.002108 264.4400n 0.002097
+ 264.4500n 0.002086 264.4600n 0.002073 264.4700n 0.002059 264.4800n 0.002045 264.4900n 0.002029 264.5000n 0.002013 264.5100n 0.001995 264.5200n 0.001977 264.5300n 0.001957 264.5400n 0.001937 264.5500n 0.001916 264.5600n 0.001894 264.5700n 0.001871 264.5800n 0.001847 264.5900n 0.001822
+ 264.6000n 0.001797 264.6100n 0.001770 264.6200n 0.001743 264.6300n 0.001716 264.6400n 0.001687 264.6500n 0.001658 264.6600n 0.001628 264.6700n 0.001597 264.6800n 0.001566 264.6900n 0.001534 264.7000n 0.001501 264.7100n 0.001468 264.7200n 0.001434 264.7300n 0.001400 264.7400n 0.001365
+ 264.7500n 0.001330 264.7600n 0.001294 264.7700n 0.001258 264.7800n 0.001222 264.7900n 0.001185 264.8000n 0.001147 264.8100n 0.001110 264.8200n 0.001072 264.8300n 0.001033 264.8400n 0.000995 264.8500n 0.000956 264.8600n 0.000917 264.8700n 0.000878 264.8800n 0.000839 264.8900n 0.000799
+ 264.9000n 0.000760 264.9100n 0.000720 264.9200n 0.000681 264.9300n 0.000641 264.9400n 0.000601 264.9500n 0.000562 264.9600n 0.000522 264.9700n 0.000483 264.9800n 0.000444 264.9900n 0.000405 265.0000n 0.000366 265.0100n 0.000327 265.0200n 0.000288 265.0300n 0.000250 265.0400n 0.000212
+ 265.0500n 0.000174 265.0600n 0.000137 265.0700n 0.000100 265.0800n 0.000063 265.0900n 0.000027 265.1000n -0.000009 265.1100n -0.000044 265.1200n -0.000079 265.1300n -0.000114 265.1400n -0.000148 265.1500n -0.000181 265.1600n -0.000214 265.1700n -0.000246 265.1800n -0.000278 265.1900n -0.000309
+ 265.2000n -0.000340 265.2100n -0.000370 265.2200n -0.000399 265.2300n -0.000428 265.2400n -0.000456 265.2500n -0.000483 265.2600n -0.000510 265.2700n -0.000536 265.2800n -0.000561 265.2900n -0.000585 265.3000n -0.000609 265.3100n -0.000632 265.3200n -0.000654 265.3300n -0.000676 265.3400n -0.000697
+ 265.3500n -0.000717 265.3600n -0.000736 265.3700n -0.000754 265.3800n -0.000772 265.3900n -0.000788 265.4000n -0.000804 265.4100n -0.000820 265.4200n -0.000834 265.4300n -0.000848 265.4400n -0.000860 265.4500n -0.000872 265.4600n -0.000884 265.4700n -0.000894 265.4800n -0.000904 265.4900n -0.000912
+ 265.5000n -0.000920 265.5100n -0.000928 265.5200n -0.000934 265.5300n -0.000940 265.5400n -0.000945 265.5500n -0.000949 265.5600n -0.000953 265.5700n -0.000956 265.5800n -0.000958 265.5900n -0.000959 265.6000n -0.000960 265.6100n -0.000960 265.6200n -0.000960 265.6300n -0.000958 265.6400n -0.000956
+ 265.6500n -0.000954 265.6600n -0.000951 265.6700n -0.000947 265.6800n -0.000943 265.6900n -0.000938 265.7000n -0.000933 265.7100n -0.000927 265.7200n -0.000921 265.7300n -0.000914 265.7400n -0.000907 265.7500n -0.000899 265.7600n -0.000891 265.7700n -0.000882 265.7800n -0.000873 265.7900n -0.000864
+ 265.8000n -0.000855 265.8100n -0.000845 265.8200n -0.000834 265.8300n -0.000824 265.8400n -0.000813 265.8500n -0.000802 265.8600n -0.000791 265.8700n -0.000780 265.8800n -0.000768 265.8900n -0.000757 265.9000n -0.000745 265.9100n -0.000733 265.9200n -0.000721 265.9300n -0.000709 265.9400n -0.000697
+ 265.9500n -0.000685 265.9600n -0.000673 265.9700n -0.000661 265.9800n -0.000650 265.9900n -0.000638 266.0000n -0.000626 266.0100n -0.000615 266.0200n -0.000603 266.0300n -0.000592 266.0400n -0.000581 266.0500n -0.000571 266.0600n -0.000560 266.0700n -0.000550 266.0800n -0.000540 266.0900n -0.000530
+ 266.1000n -0.000521 266.1100n -0.000512 266.1200n -0.000504 266.1300n -0.000495 266.1400n -0.000487 266.1500n -0.000480 266.1600n -0.000473 266.1700n -0.000466 266.1800n -0.000460 266.1900n -0.000455 266.2000n -0.000450 266.2100n -0.000445 266.2200n -0.000441 266.2300n -0.000437 266.2400n -0.000434
+ 266.2500n -0.000432 266.2600n -0.000430 266.2700n -0.000429 266.2800n -0.000428 266.2900n -0.000428 266.3000n -0.000428 266.3100n -0.000429 266.3200n -0.000431 266.3300n -0.000433 266.3400n -0.000436 266.3500n -0.000440 266.3600n -0.000444 266.3700n -0.000449 266.3800n -0.000455 266.3900n -0.000461
+ 266.4000n -0.000468 266.4100n -0.000475 266.4200n -0.000483 266.4300n -0.000492 266.4400n -0.000501 266.4500n -0.000512 266.4600n -0.000522 266.4700n -0.000534 266.4800n -0.000546 266.4900n -0.000558 266.5000n -0.000572 266.5100n -0.000586 266.5200n -0.000600 266.5300n -0.000615 266.5400n -0.000631
+ 266.5500n -0.000647 266.5600n -0.000664 266.5700n -0.000682 266.5800n -0.000700 266.5900n -0.000718 266.6000n -0.000737 266.6100n -0.000757 266.6200n -0.000777 266.6300n -0.000798 266.6400n -0.000819 266.6500n -0.000840 266.6600n -0.000862 266.6700n -0.000885 266.6800n -0.000908 266.6900n -0.000931
+ 266.7000n -0.000954 266.7100n -0.000978 266.7200n -0.001003 266.7300n -0.001027 266.7400n -0.001052 266.7500n -0.001078 266.7600n -0.001103 266.7700n -0.001129 266.7800n -0.001155 266.7900n -0.001181 266.8000n -0.001207 266.8100n -0.001234 266.8200n -0.001260 266.8300n -0.001287 266.8400n -0.001314
+ 266.8500n -0.001341 266.8600n -0.001368 266.8700n -0.001395 266.8800n -0.001422 266.8900n -0.001448 266.9000n -0.001475 266.9100n -0.001502 266.9200n -0.001529 266.9300n -0.001555 266.9400n -0.001581 266.9500n -0.001608 266.9600n -0.001634 266.9700n -0.001659 266.9800n -0.001685 266.9900n -0.001710
+ 267.0000n -0.001735 267.0100n -0.001760 267.0200n -0.001784 267.0300n -0.001808 267.0400n -0.001831 267.0500n -0.001854 267.0600n -0.001877 267.0700n -0.001899 267.0800n -0.001921 267.0900n -0.001942 267.1000n -0.001962 267.1100n -0.001983 267.1200n -0.002002 267.1300n -0.002021 267.1400n -0.002039
+ 267.1500n -0.002057 267.1600n -0.002074 267.1700n -0.002090 267.1800n -0.002106 267.1900n -0.002121 267.2000n -0.002135 267.2100n -0.002149 267.2200n -0.002161 267.2300n -0.002173 267.2400n -0.002184 267.2500n -0.002195 267.2600n -0.002204 267.2700n -0.002213 267.2800n -0.002221 267.2900n -0.002228
+ 267.3000n -0.002234 267.3100n -0.002239 267.3200n -0.002243 267.3300n -0.002247 267.3400n -0.002249 267.3500n -0.002251 267.3600n -0.002252 267.3700n -0.002251 267.3800n -0.002250 267.3900n -0.002248 267.4000n -0.002245 267.4100n -0.002240 267.4200n -0.002235 267.4300n -0.002229 267.4400n -0.002222
+ 267.4500n -0.002214 267.4600n -0.002205 267.4700n -0.002195 267.4800n -0.002185 267.4900n -0.002173 267.5000n -0.002160 267.5100n -0.002146 267.5200n -0.002131 267.5300n -0.002115 267.5400n -0.002099 267.5500n -0.002081 267.5600n -0.002062 267.5700n -0.002043 267.5800n -0.002022 267.5900n -0.002001
+ 267.6000n -0.001979 267.6100n -0.001956 267.6200n -0.001931 267.6300n -0.001907 267.6400n -0.001881 267.6500n -0.001854 267.6600n -0.001826 267.6700n -0.001798 267.6800n -0.001769 267.6900n -0.001739 267.7000n -0.001708 267.7100n -0.001677 267.7200n -0.001644 267.7300n -0.001611 267.7400n -0.001578
+ 267.7500n -0.001543 267.7600n -0.001508 267.7700n -0.001472 267.7800n -0.001436 267.7900n -0.001399 267.8000n -0.001361 267.8100n -0.001323 267.8200n -0.001284 267.8300n -0.001245 267.8400n -0.001205 267.8500n -0.001165 267.8600n -0.001124 267.8700n -0.001083 267.8800n -0.001041 267.8900n -0.000999
+ 267.9000n -0.000957 267.9100n -0.000914 267.9200n -0.000871 267.9300n -0.000828 267.9400n -0.000784 267.9500n -0.000740 267.9600n -0.000696 267.9700n -0.000652 267.9800n -0.000607 267.9900n -0.000562 268.0000n -0.000518 268.0100n -0.000473 268.0200n -0.000428 268.0300n -0.000383 268.0400n -0.000338
+ 268.0500n -0.000293 268.0600n -0.000248 268.0700n -0.000203 268.0800n -0.000158 268.0900n -0.000113 268.1000n -0.000069 268.1100n -0.000024 268.1200n 0.000020 268.1300n 0.000064 268.1400n 0.000108 268.1500n 0.000151 268.1600n 0.000195 268.1700n 0.000238 268.1800n 0.000280 268.1900n 0.000323
+ 268.2000n 0.000364 268.2100n 0.000406 268.2200n 0.000447 268.2300n 0.000488 268.2400n 0.000528 268.2500n 0.000568 268.2600n 0.000607 268.2700n 0.000646 268.2800n 0.000684 268.2900n 0.000721 268.3000n 0.000758 268.3100n 0.000795 268.3200n 0.000831 268.3300n 0.000866 268.3400n 0.000900
+ 268.3500n 0.000934 268.3600n 0.000967 268.3700n 0.001000 268.3800n 0.001032 268.3900n 0.001063 268.4000n 0.001093 268.4100n 0.001122 268.4200n 0.001151 268.4300n 0.001179 268.4400n 0.001206 268.4500n 0.001233 268.4600n 0.001258 268.4700n 0.001283 268.4800n 0.001307 268.4900n 0.001330
+ 268.5000n 0.001353 268.5100n 0.001374 268.5200n 0.001395 268.5300n 0.001414 268.5400n 0.001433 268.5500n 0.001451 268.5600n 0.001468 268.5700n 0.001485 268.5800n 0.001500 268.5900n 0.001514 268.6000n 0.001528 268.6100n 0.001541 268.6200n 0.001553 268.6300n 0.001564 268.6400n 0.001574
+ 268.6500n 0.001583 268.6600n 0.001591 268.6700n 0.001599 268.6800n 0.001605 268.6900n 0.001611 268.7000n 0.001616 268.7100n 0.001620 268.7200n 0.001623 268.7300n 0.001625 268.7400n 0.001627 268.7500n 0.001628 268.7600n 0.001628 268.7700n 0.001627 268.7800n 0.001625 268.7900n 0.001623
+ 268.8000n 0.001619 268.8100n 0.001615 268.8200n 0.001611 268.8300n 0.001605 268.8400n 0.001599 268.8500n 0.001592 268.8600n 0.001584 268.8700n 0.001576 268.8800n 0.001567 268.8900n 0.001557 268.9000n 0.001547 268.9100n 0.001536 268.9200n 0.001524 268.9300n 0.001512 268.9400n 0.001500
+ 268.9500n 0.001486 268.9600n 0.001473 268.9700n 0.001458 268.9800n 0.001443 268.9900n 0.001428 269.0000n 0.001412 269.0100n 0.001396 269.0200n 0.001379 269.0300n 0.001362 269.0400n 0.001345 269.0500n 0.001327 269.0600n 0.001308 269.0700n 0.001290 269.0800n 0.001271 269.0900n 0.001251
+ 269.1000n 0.001232 269.1100n 0.001212 269.1200n 0.001192 269.1300n 0.001172 269.1400n 0.001151 269.1500n 0.001131 269.1600n 0.001110 269.1700n 0.001089 269.1800n 0.001067 269.1900n 0.001046 269.2000n 0.001025 269.2100n 0.001003 269.2200n 0.000982 269.2300n 0.000960 269.2400n 0.000939
+ 269.2500n 0.000917 269.2600n 0.000896 269.2700n 0.000874 269.2800n 0.000853 269.2900n 0.000831 269.3000n 0.000810 269.3100n 0.000789 269.3200n 0.000767 269.3300n 0.000746 269.3400n 0.000726 269.3500n 0.000705 269.3600n 0.000685 269.3700n 0.000664 269.3800n 0.000644 269.3900n 0.000624
+ 269.4000n 0.000605 269.4100n 0.000586 269.4200n 0.000566 269.4300n 0.000548 269.4400n 0.000529 269.4500n 0.000511 269.4600n 0.000493 269.4700n 0.000476 269.4800n 0.000459 269.4900n 0.000442 269.5000n 0.000425 269.5100n 0.000409 269.5200n 0.000394 269.5300n 0.000379 269.5400n 0.000364
+ 269.5500n 0.000349 269.5600n 0.000335 269.5700n 0.000322 269.5800n 0.000309 269.5900n 0.000296 269.6000n 0.000284 269.6100n 0.000272 269.6200n 0.000261 269.6300n 0.000250 269.6400n 0.000240 269.6500n 0.000230 269.6600n 0.000220 269.6700n 0.000211 269.6800n 0.000203 269.6900n 0.000195
+ 269.7000n 0.000188 269.7100n 0.000181 269.7200n 0.000175 269.7300n 0.000169 269.7400n 0.000163 269.7500n 0.000158 269.7600n 0.000154 269.7700n 0.000150 269.7800n 0.000147 269.7900n 0.000144 269.8000n 0.000142 269.8100n 0.000140 269.8200n 0.000138 269.8300n 0.000138 269.8400n 0.000137
+ 269.8500n 0.000137 269.8600n 0.000138 269.8700n 0.000139 269.8800n 0.000141 269.8900n 0.000143 269.9000n 0.000145 269.9100n 0.000148 269.9200n 0.000152 269.9300n 0.000156 269.9400n 0.000160 269.9500n 0.000165 269.9600n 0.000170 269.9700n 0.000176 269.9800n 0.000182 269.9900n 0.000188
+ 270.0000n 0.000195 270.0100n 0.000202 270.0200n 0.000210 270.0300n 0.000218 270.0400n 0.000226 270.0500n 0.000235 270.0600n 0.000244 270.0700n 0.000254 270.0800n 0.000264 270.0900n 0.000274 270.1000n 0.000284 270.1100n 0.000295 270.1200n 0.000306 270.1300n 0.000318 270.1400n 0.000329
+ 270.1500n 0.000341 270.1600n 0.000354 270.1700n 0.000366 270.1800n 0.000379 270.1900n 0.000392 270.2000n 0.000405 270.2100n 0.000419 270.2200n 0.000432 270.2300n 0.000446 270.2400n 0.000460 270.2500n 0.000474 270.2600n 0.000489 270.2700n 0.000503 270.2800n 0.000518 270.2900n 0.000533
+ 270.3000n 0.000548 270.3100n 0.000563 270.3200n 0.000578 270.3300n 0.000594 270.3400n 0.000609 270.3500n 0.000625 270.3600n 0.000640 270.3700n 0.000656 270.3800n 0.000672 270.3900n 0.000688 270.4000n 0.000704 270.4100n 0.000719 270.4200n 0.000735 270.4300n 0.000751 270.4400n 0.000767
+ 270.4500n 0.000783 270.4600n 0.000799 270.4700n 0.000815 270.4800n 0.000831 270.4900n 0.000847 270.5000n 0.000863 270.5100n 0.000879 270.5200n 0.000895 270.5300n 0.000910 270.5400n 0.000926 270.5500n 0.000942 270.5600n 0.000957 270.5700n 0.000973 270.5800n 0.000988 270.5900n 0.001004
+ 270.6000n 0.001019 270.6100n 0.001034 270.6200n 0.001049 270.6300n 0.001064 270.6400n 0.001079 270.6500n 0.001094 270.6600n 0.001108 270.6700n 0.001123 270.6800n 0.001137 270.6900n 0.001151 270.7000n 0.001165 270.7100n 0.001179 270.7200n 0.001193 270.7300n 0.001207 270.7400n 0.001220
+ 270.7500n 0.001234 270.7600n 0.001247 270.7700n 0.001260 270.7800n 0.001273 270.7900n 0.001285 270.8000n 0.001298 270.8100n 0.001310 270.8200n 0.001323 270.8300n 0.001335 270.8400n 0.001347 270.8500n 0.001358 270.8600n 0.001370 270.8700n 0.001381 270.8800n 0.001392 270.8900n 0.001403
+ 270.9000n 0.001414 270.9100n 0.001425 270.9200n 0.001435 270.9300n 0.001446 270.9400n 0.001456 270.9500n 0.001466 270.9600n 0.001475 270.9700n 0.001485 270.9800n 0.001494 270.9900n 0.001503 271.0000n 0.001512 271.0100n 0.001521 271.0200n 0.001530 271.0300n 0.001538 271.0400n 0.001546
+ 271.0500n 0.001554 271.0600n 0.001562 271.0700n 0.001570 271.0800n 0.001577 271.0900n 0.001585 271.1000n 0.001592 271.1100n 0.001599 271.1200n 0.001605 271.1300n 0.001612 271.1400n 0.001618 271.1500n 0.001624 271.1600n 0.001630 271.1700n 0.001636 271.1800n 0.001641 271.1900n 0.001646
+ 271.2000n 0.001651 271.2100n 0.001656 271.2200n 0.001661 271.2300n 0.001665 271.2400n 0.001670 271.2500n 0.001674 271.2600n 0.001678 271.2700n 0.001681 271.2800n 0.001685 271.2900n 0.001688 271.3000n 0.001691 271.3100n 0.001694 271.3200n 0.001696 271.3300n 0.001699 271.3400n 0.001701
+ 271.3500n 0.001703 271.3600n 0.001704 271.3700n 0.001706 271.3800n 0.001707 271.3900n 0.001708 271.4000n 0.001709 271.4100n 0.001709 271.4200n 0.001710 271.4300n 0.001710 271.4400n 0.001710 271.4500n 0.001709 271.4600n 0.001709 271.4700n 0.001708 271.4800n 0.001707 271.4900n 0.001705
+ 271.5000n 0.001704 271.5100n 0.001702 271.5200n 0.001700 271.5300n 0.001697 271.5400n 0.001695 271.5500n 0.001692 271.5600n 0.001688 271.5700n 0.001685 271.5800n 0.001681 271.5900n 0.001677 271.6000n 0.001673 271.6100n 0.001668 271.6200n 0.001663 271.6300n 0.001658 271.6400n 0.001653
+ 271.6500n 0.001647 271.6600n 0.001641 271.6700n 0.001634 271.6800n 0.001628 271.6900n 0.001621 271.7000n 0.001614 271.7100n 0.001606 271.7200n 0.001598 271.7300n 0.001590 271.7400n 0.001581 271.7500n 0.001573 271.7600n 0.001563 271.7700n 0.001554 271.7800n 0.001544 271.7900n 0.001534
+ 271.8000n 0.001523 271.8100n 0.001513 271.8200n 0.001502 271.8300n 0.001490 271.8400n 0.001478 271.8500n 0.001466 271.8600n 0.001454 271.8700n 0.001441 271.8800n 0.001428 271.8900n 0.001414 271.9000n 0.001401 271.9100n 0.001386 271.9200n 0.001372 271.9300n 0.001357 271.9400n 0.001342
+ 271.9500n 0.001327 271.9600n 0.001311 271.9700n 0.001295 271.9800n 0.001278 271.9900n 0.001261 272.0000n 0.001244 272.0100n 0.001227 272.0200n 0.001209 272.0300n 0.001191 272.0400n 0.001172 272.0500n 0.001154 272.0600n 0.001135 272.0700n 0.001115 272.0800n 0.001096 272.0900n 0.001076
+ 272.1000n 0.001055 272.1100n 0.001035 272.1200n 0.001014 272.1300n 0.000993 272.1400n 0.000972 272.1500n 0.000950 272.1600n 0.000928 272.1700n 0.000906 272.1800n 0.000883 272.1900n 0.000861 272.2000n 0.000838 272.2100n 0.000815 272.2200n 0.000791 272.2300n 0.000768 272.2400n 0.000744
+ 272.2500n 0.000720 272.2600n 0.000696 272.2700n 0.000671 272.2800n 0.000647 272.2900n 0.000622 272.3000n 0.000597 272.3100n 0.000572 272.3200n 0.000547 272.3300n 0.000521 272.3400n 0.000496 272.3500n 0.000470 272.3600n 0.000445 272.3700n 0.000419 272.3800n 0.000393 272.3900n 0.000367
+ 272.4000n 0.000341 272.4100n 0.000316 272.4200n 0.000290 272.4300n 0.000264 272.4400n 0.000238 272.4500n 0.000212 272.4600n 0.000186 272.4700n 0.000160 272.4800n 0.000134 272.4900n 0.000108 272.5000n 0.000082 272.5100n 0.000057 272.5200n 0.000031 272.5300n 0.000006 272.5400n -0.000020
+ 272.5500n -0.000045 272.5600n -0.000070 272.5700n -0.000095 272.5800n -0.000120 272.5900n -0.000144 272.6000n -0.000168 272.6100n -0.000192 272.6200n -0.000216 272.6300n -0.000240 272.6400n -0.000263 272.6500n -0.000286 272.6600n -0.000309 272.6700n -0.000331 272.6800n -0.000353 272.6900n -0.000375
+ 272.7000n -0.000397 272.7100n -0.000418 272.7200n -0.000439 272.7300n -0.000459 272.7400n -0.000479 272.7500n -0.000498 272.7600n -0.000517 272.7700n -0.000536 272.7800n -0.000554 272.7900n -0.000572 272.8000n -0.000589 272.8100n -0.000606 272.8200n -0.000623 272.8300n -0.000638 272.8400n -0.000654
+ 272.8500n -0.000669 272.8600n -0.000683 272.8700n -0.000697 272.8800n -0.000710 272.8900n -0.000722 272.9000n -0.000734 272.9100n -0.000746 272.9200n -0.000757 272.9300n -0.000767 272.9400n -0.000776 272.9500n -0.000785 272.9600n -0.000794 272.9700n -0.000802 272.9800n -0.000809 272.9900n -0.000815
+ 273.0000n -0.000821 273.0100n -0.000826 273.0200n -0.000831 273.0300n -0.000835 273.0400n -0.000838 273.0500n -0.000841 273.0600n -0.000843 273.0700n -0.000844 273.0800n -0.000844 273.0900n -0.000844 273.1000n -0.000843 273.1100n -0.000842 273.1200n -0.000840 273.1300n -0.000837 273.1400n -0.000834
+ 273.1500n -0.000829 273.1600n -0.000825 273.1700n -0.000819 273.1800n -0.000813 273.1900n -0.000806 273.2000n -0.000799 273.2100n -0.000790 273.2200n -0.000782 273.2300n -0.000772 273.2400n -0.000762 273.2500n -0.000751 273.2600n -0.000740 273.2700n -0.000728 273.2800n -0.000716 273.2900n -0.000702
+ 273.3000n -0.000689 273.3100n -0.000674 273.3200n -0.000659 273.3300n -0.000644 273.3400n -0.000628 273.3500n -0.000611 273.3600n -0.000594 273.3700n -0.000577 273.3800n -0.000559 273.3900n -0.000540 273.4000n -0.000521 273.4100n -0.000501 273.4200n -0.000481 273.4300n -0.000461 273.4400n -0.000440
+ 273.4500n -0.000419 273.4600n -0.000397 273.4700n -0.000375 273.4800n -0.000352 273.4900n -0.000330 273.5000n -0.000307 273.5100n -0.000283 273.5200n -0.000259 273.5300n -0.000235 273.5400n -0.000211 273.5500n -0.000187 273.5600n -0.000162 273.5700n -0.000137 273.5800n -0.000112 273.5900n -0.000087
+ 273.6000n -0.000061 273.6100n -0.000036 273.6200n -0.000010 273.6300n 0.000016 273.6400n 0.000042 273.6500n 0.000067 273.6600n 0.000093 273.6700n 0.000119 273.6800n 0.000145 273.6900n 0.000171 273.7000n 0.000197 273.7100n 0.000222 273.7200n 0.000248 273.7300n 0.000274 273.7400n 0.000299
+ 273.7500n 0.000324 273.7600n 0.000349 273.7700n 0.000374 273.7800n 0.000399 273.7900n 0.000423 273.8000n 0.000448 273.8100n 0.000472 273.8200n 0.000495 273.8300n 0.000518 273.8400n 0.000541 273.8500n 0.000564 273.8600n 0.000586 273.8700n 0.000608 273.8800n 0.000630 273.8900n 0.000651
+ 273.9000n 0.000672 273.9100n 0.000692 273.9200n 0.000712 273.9300n 0.000731 273.9400n 0.000750 273.9500n 0.000768 273.9600n 0.000786 273.9700n 0.000803 273.9800n 0.000819 273.9900n 0.000835 274.0000n 0.000851 274.0100n 0.000866 274.0200n 0.000880 274.0300n 0.000893 274.0400n 0.000906
+ 274.0500n 0.000919 274.0600n 0.000930 274.0700n 0.000941 274.0800n 0.000952 274.0900n 0.000961 274.1000n 0.000970 274.1100n 0.000978 274.1200n 0.000986 274.1300n 0.000993 274.1400n 0.000999 274.1500n 0.001004 274.1600n 0.001009 274.1700n 0.001013 274.1800n 0.001016 274.1900n 0.001018
+ 274.2000n 0.001020 274.2100n 0.001021 274.2200n 0.001021 274.2300n 0.001020 274.2400n 0.001019 274.2500n 0.001017 274.2600n 0.001014 274.2700n 0.001010 274.2800n 0.001006 274.2900n 0.001001 274.3000n 0.000995 274.3100n 0.000988 274.3200n 0.000981 274.3300n 0.000973 274.3400n 0.000964
+ 274.3500n 0.000955 274.3600n 0.000945 274.3700n 0.000934 274.3800n 0.000922 274.3900n 0.000910 274.4000n 0.000897 274.4100n 0.000883 274.4200n 0.000869 274.4300n 0.000854 274.4400n 0.000839 274.4500n 0.000823 274.4600n 0.000806 274.4700n 0.000789 274.4800n 0.000771 274.4900n 0.000753
+ 274.5000n 0.000734 274.5100n 0.000714 274.5200n 0.000694 274.5300n 0.000674 274.5400n 0.000653 274.5500n 0.000632 274.5600n 0.000610 274.5700n 0.000587 274.5800n 0.000565 274.5900n 0.000542 274.6000n 0.000518 274.6100n 0.000495 274.6200n 0.000471 274.6300n 0.000446 274.6400n 0.000422
+ 274.6500n 0.000397 274.6600n 0.000372 274.6700n 0.000346 274.6800n 0.000321 274.6900n 0.000295 274.7000n 0.000269 274.7100n 0.000243 274.7200n 0.000217 274.7300n 0.000191 274.7400n 0.000165 274.7500n 0.000138 274.7600n 0.000112 274.7700n 0.000086 274.7800n 0.000060 274.7900n 0.000034
+ 274.8000n 0.000007 274.8100n -0.000019 274.8200n -0.000044 274.8300n -0.000070 274.8400n -0.000096 274.8500n -0.000121 274.8600n -0.000146 274.8700n -0.000171 274.8800n -0.000196 274.8900n -0.000220 274.9000n -0.000244 274.9100n -0.000268 274.9200n -0.000291 274.9300n -0.000314 274.9400n -0.000336
+ 274.9500n -0.000358 274.9600n -0.000380 274.9700n -0.000401 274.9800n -0.000422 274.9900n -0.000442 275.0000n -0.000462 275.0100n -0.000481 275.0200n -0.000500 275.0300n -0.000518 275.0400n -0.000535 275.0500n -0.000552 275.0600n -0.000568 275.0700n -0.000583 275.0800n -0.000598 275.0900n -0.000612
+ 275.1000n -0.000626 275.1100n -0.000639 275.1200n -0.000651 275.1300n -0.000662 275.1400n -0.000672 275.1500n -0.000682 275.1600n -0.000691 275.1700n -0.000699 275.1800n -0.000707 275.1900n -0.000713 275.2000n -0.000719 275.2100n -0.000724 275.2200n -0.000728 275.2300n -0.000732 275.2400n -0.000734
+ 275.2500n -0.000736 275.2600n -0.000736 275.2700n -0.000736 275.2800n -0.000735 275.2900n -0.000733 275.3000n -0.000731 275.3100n -0.000727 275.3200n -0.000722 275.3300n -0.000717 275.3400n -0.000711 275.3500n -0.000703 275.3600n -0.000695 275.3700n -0.000687 275.3800n -0.000677 275.3900n -0.000666
+ 275.4000n -0.000655 275.4100n -0.000642 275.4200n -0.000629 275.4300n -0.000615 275.4400n -0.000600 275.4500n -0.000584 275.4600n -0.000567 275.4700n -0.000550 275.4800n -0.000532 275.4900n -0.000513 275.5000n -0.000493 275.5100n -0.000472 275.5200n -0.000451 275.5300n -0.000429 275.5400n -0.000406
+ 275.5500n -0.000382 275.5600n -0.000358 275.5700n -0.000333 275.5800n -0.000307 275.5900n -0.000281 275.6000n -0.000254 275.6100n -0.000226 275.6200n -0.000198 275.6300n -0.000169 275.6400n -0.000140 275.6500n -0.000110 275.6600n -0.000079 275.6700n -0.000048 275.6800n -0.000017 275.6900n 0.000015
+ 275.7000n 0.000048 275.7100n 0.000081 275.7200n 0.000114 275.7300n 0.000148 275.7400n 0.000182 275.7500n 0.000216 275.7600n 0.000251 275.7700n 0.000286 275.7800n 0.000321 275.7900n 0.000357 275.8000n 0.000393 275.8100n 0.000429 275.8200n 0.000465 275.8300n 0.000502 275.8400n 0.000538
+ 275.8500n 0.000575 275.8600n 0.000612 275.8700n 0.000649 275.8800n 0.000686 275.8900n 0.000722 275.9000n 0.000759 275.9100n 0.000796 275.9200n 0.000833 275.9300n 0.000870 275.9400n 0.000907 275.9500n 0.000943 275.9600n 0.000979 275.9700n 0.001016 275.9800n 0.001052 275.9900n 0.001087
+ 276.0000n 0.001123 276.0100n 0.001158 276.0200n 0.001193 276.0300n 0.001228 276.0400n 0.001262 276.0500n 0.001296 276.0600n 0.001330 276.0700n 0.001363 276.0800n 0.001396 276.0900n 0.001429 276.1000n 0.001461 276.1100n 0.001492 276.1200n 0.001523 276.1300n 0.001554 276.1400n 0.001583
+ 276.1500n 0.001613 276.1600n 0.001642 276.1700n 0.001670 276.1800n 0.001698 276.1900n 0.001725 276.2000n 0.001751 276.2100n 0.001777 276.2200n 0.001802 276.2300n 0.001826 276.2400n 0.001850 276.2500n 0.001873 276.2600n 0.001896 276.2700n 0.001917 276.2800n 0.001938 276.2900n 0.001958
+ 276.3000n 0.001978 276.3100n 0.001997 276.3200n 0.002015 276.3300n 0.002032 276.3400n 0.002048 276.3500n 0.002064 276.3600n 0.002078 276.3700n 0.002092 276.3800n 0.002106 276.3900n 0.002118 276.4000n 0.002130 276.4100n 0.002141 276.4200n 0.002151 276.4300n 0.002160 276.4400n 0.002168
+ 276.4500n 0.002176 276.4600n 0.002183 276.4700n 0.002189 276.4800n 0.002194 276.4900n 0.002198 276.5000n 0.002202 276.5100n 0.002205 276.5200n 0.002207 276.5300n 0.002208 276.5400n 0.002208 276.5500n 0.002208 276.5600n 0.002207 276.5700n 0.002205 276.5800n 0.002203 276.5900n 0.002199
+ 276.6000n 0.002195 276.6100n 0.002191 276.6200n 0.002185 276.6300n 0.002179 276.6400n 0.002172 276.6500n 0.002165 276.6600n 0.002157 276.6700n 0.002148 276.6800n 0.002139 276.6900n 0.002129 276.7000n 0.002119 276.7100n 0.002108 276.7200n 0.002096 276.7300n 0.002084 276.7400n 0.002071
+ 276.7500n 0.002058 276.7600n 0.002044 276.7700n 0.002030 276.7800n 0.002015 276.7900n 0.002000 276.8000n 0.001985 276.8100n 0.001969 276.8200n 0.001953 276.8300n 0.001936 276.8400n 0.001919 276.8500n 0.001902 276.8600n 0.001884 276.8700n 0.001866 276.8800n 0.001848 276.8900n 0.001830
+ 276.9000n 0.001811 276.9100n 0.001792 276.9200n 0.001773 276.9300n 0.001754 276.9400n 0.001735 276.9500n 0.001716 276.9600n 0.001696 276.9700n 0.001677 276.9800n 0.001657 276.9900n 0.001637 277.0000n 0.001618 277.0100n 0.001598 277.0200n 0.001578 277.0300n 0.001559 277.0400n 0.001539
+ 277.0500n 0.001520 277.0600n 0.001500 277.0700n 0.001481 277.0800n 0.001462 277.0900n 0.001443 277.1000n 0.001424 277.1100n 0.001406 277.1200n 0.001388 277.1300n 0.001369 277.1400n 0.001352 277.1500n 0.001334 277.1600n 0.001317 277.1700n 0.001300 277.1800n 0.001283 277.1900n 0.001267
+ 277.2000n 0.001251 277.2100n 0.001235 277.2200n 0.001220 277.2300n 0.001205 277.2400n 0.001190 277.2500n 0.001176 277.2600n 0.001163 277.2700n 0.001150 277.2800n 0.001137 277.2900n 0.001124 277.3000n 0.001113 277.3100n 0.001101 277.3200n 0.001090 277.3300n 0.001080 277.3400n 0.001070
+ 277.3500n 0.001061 277.3600n 0.001052 277.3700n 0.001043 277.3800n 0.001036 277.3900n 0.001028 277.4000n 0.001022 277.4100n 0.001015 277.4200n 0.001010 277.4300n 0.001005 277.4400n 0.001000 277.4500n 0.000996 277.4600n 0.000993 277.4700n 0.000990 277.4800n 0.000987 277.4900n 0.000985
+ 277.5000n 0.000984 277.5100n 0.000983 277.5200n 0.000983 277.5300n 0.000983 277.5400n 0.000984 277.5500n 0.000986 277.5600n 0.000987 277.5700n 0.000990 277.5800n 0.000993 277.5900n 0.000996 277.6000n 0.001000 277.6100n 0.001004 277.6200n 0.001009 277.6300n 0.001015 277.6400n 0.001021
+ 277.6500n 0.001027 277.6600n 0.001033 277.6700n 0.001041 277.6800n 0.001048 277.6900n 0.001056 277.7000n 0.001064 277.7100n 0.001073 277.7200n 0.001082 277.7300n 0.001092 277.7400n 0.001101 277.7500n 0.001111 277.7600n 0.001122 277.7700n 0.001132 277.7800n 0.001143 277.7900n 0.001155
+ 277.8000n 0.001166 277.8100n 0.001178 277.8200n 0.001190 277.8300n 0.001202 277.8400n 0.001214 277.8500n 0.001227 277.8600n 0.001239 277.8700n 0.001252 277.8800n 0.001265 277.8900n 0.001278 277.9000n 0.001291 277.9100n 0.001304 277.9200n 0.001317 277.9300n 0.001330 277.9400n 0.001343
+ 277.9500n 0.001356 277.9600n 0.001369 277.9700n 0.001382 277.9800n 0.001395 277.9900n 0.001408 278.0000n 0.001420 278.0100n 0.001433 278.0200n 0.001445 278.0300n 0.001457 278.0400n 0.001470 278.0500n 0.001481 278.0600n 0.001493 278.0700n 0.001504 278.0800n 0.001516 278.0900n 0.001526
+ 278.1000n 0.001537 278.1100n 0.001547 278.1200n 0.001557 278.1300n 0.001567 278.1400n 0.001576 278.1500n 0.001585 278.1600n 0.001593 278.1700n 0.001601 278.1800n 0.001609 278.1900n 0.001616 278.2000n 0.001623 278.2100n 0.001629 278.2200n 0.001635 278.2300n 0.001640 278.2400n 0.001645
+ 278.2500n 0.001650 278.2600n 0.001653 278.2700n 0.001657 278.2800n 0.001659 278.2900n 0.001662 278.3000n 0.001663 278.3100n 0.001664 278.3200n 0.001665 278.3300n 0.001665 278.3400n 0.001664 278.3500n 0.001663 278.3600n 0.001661 278.3700n 0.001658 278.3800n 0.001655 278.3900n 0.001651
+ 278.4000n 0.001647 278.4100n 0.001642 278.4200n 0.001636 278.4300n 0.001630 278.4400n 0.001623 278.4500n 0.001616 278.4600n 0.001607 278.4700n 0.001598 278.4800n 0.001589 278.4900n 0.001579 278.5000n 0.001568 278.5100n 0.001557 278.5200n 0.001545 278.5300n 0.001532 278.5400n 0.001519
+ 278.5500n 0.001505 278.5600n 0.001490 278.5700n 0.001475 278.5800n 0.001459 278.5900n 0.001443 278.6000n 0.001426 278.6100n 0.001408 278.6200n 0.001390 278.6300n 0.001372 278.6400n 0.001352 278.6500n 0.001333 278.6600n 0.001312 278.6700n 0.001291 278.6800n 0.001270 278.6900n 0.001248
+ 278.7000n 0.001226 278.7100n 0.001203 278.7200n 0.001180 278.7300n 0.001156 278.7400n 0.001132 278.7500n 0.001107 278.7600n 0.001082 278.7700n 0.001057 278.7800n 0.001031 278.7900n 0.001005 278.8000n 0.000979 278.8100n 0.000952 278.8200n 0.000925 278.8300n 0.000897 278.8400n 0.000870
+ 278.8500n 0.000842 278.8600n 0.000813 278.8700n 0.000785 278.8800n 0.000756 278.8900n 0.000727 278.9000n 0.000698 278.9100n 0.000669 278.9200n 0.000640 278.9300n 0.000611 278.9400n 0.000581 278.9500n 0.000552 278.9600n 0.000522 278.9700n 0.000492 278.9800n 0.000463 278.9900n 0.000433
+ 279.0000n 0.000404 279.0100n 0.000374 279.0200n 0.000344 279.0300n 0.000315 279.0400n 0.000286 279.0500n 0.000256 279.0600n 0.000227 279.0700n 0.000198 279.0800n 0.000170 279.0900n 0.000141 279.1000n 0.000113 279.1100n 0.000085 279.1200n 0.000057 279.1300n 0.000029 279.1400n 0.000002
+ 279.1500n -0.000025 279.1600n -0.000052 279.1700n -0.000078 279.1800n -0.000104 279.1900n -0.000129 279.2000n -0.000155 279.2100n -0.000180 279.2200n -0.000204 279.2300n -0.000228 279.2400n -0.000251 279.2500n -0.000274 279.2600n -0.000297 279.2700n -0.000319 279.2800n -0.000341 279.2900n -0.000362
+ 279.3000n -0.000382 279.3100n -0.000402 279.3200n -0.000422 279.3300n -0.000440 279.3400n -0.000459 279.3500n -0.000476 279.3600n -0.000494 279.3700n -0.000510 279.3800n -0.000526 279.3900n -0.000541 279.4000n -0.000556 279.4100n -0.000570 279.4200n -0.000583 279.4300n -0.000596 279.4400n -0.000608
+ 279.4500n -0.000620 279.4600n -0.000630 279.4700n -0.000640 279.4800n -0.000650 279.4900n -0.000659 279.5000n -0.000667 279.5100n -0.000674 279.5200n -0.000681 279.5300n -0.000687 279.5400n -0.000692 279.5500n -0.000697 279.5600n -0.000701 279.5700n -0.000705 279.5800n -0.000707 279.5900n -0.000709
+ 279.6000n -0.000711 279.6100n -0.000711 279.6200n -0.000711 279.6300n -0.000711 279.6400n -0.000710 279.6500n -0.000708 279.6600n -0.000705 279.6700n -0.000702 279.6800n -0.000698 279.6900n -0.000694 279.7000n -0.000689 279.7100n -0.000684 279.7200n -0.000678 279.7300n -0.000671 279.7400n -0.000664
+ 279.7500n -0.000656 279.7600n -0.000647 279.7700n -0.000639 279.7800n -0.000629 279.7900n -0.000619 279.8000n -0.000609 279.8100n -0.000598 279.8200n -0.000587 279.8300n -0.000575 279.8400n -0.000563 279.8500n -0.000550 279.8600n -0.000537 279.8700n -0.000523 279.8800n -0.000509 279.8900n -0.000495
+ 279.9000n -0.000480 279.9100n -0.000466 279.9200n -0.000450 279.9300n -0.000435 279.9400n -0.000419 279.9500n -0.000403 279.9600n -0.000386 279.9700n -0.000370 279.9800n -0.000353 279.9900n -0.000336 280.0000n -0.000318 280.0100n -0.000301 280.0200n -0.000283 280.0300n -0.000266 280.0400n -0.000248
+ 280.0500n -0.000230 280.0600n -0.000212 280.0700n -0.000194 280.0800n -0.000175 280.0900n -0.000157 280.1000n -0.000139 280.1100n -0.000121 280.1200n -0.000102 280.1300n -0.000084 280.1400n -0.000066 280.1500n -0.000048 280.1600n -0.000030 280.1700n -0.000012 280.1800n 0.000006 280.1900n 0.000024
+ 280.2000n 0.000041 280.2100n 0.000059 280.2200n 0.000076 280.2300n 0.000093 280.2400n 0.000110 280.2500n 0.000127 280.2600n 0.000143 280.2700n 0.000160 280.2800n 0.000176 280.2900n 0.000191 280.3000n 0.000207 280.3100n 0.000222 280.3200n 0.000237 280.3300n 0.000252 280.3400n 0.000266
+ 280.3500n 0.000280 280.3600n 0.000293 280.3700n 0.000307 280.3800n 0.000320 280.3900n 0.000332 280.4000n 0.000344 280.4100n 0.000356 280.4200n 0.000368 280.4300n 0.000379 280.4400n 0.000389 280.4500n 0.000399 280.4600n 0.000409 280.4700n 0.000418 280.4800n 0.000427 280.4900n 0.000436
+ 280.5000n 0.000444 280.5100n 0.000451 280.5200n 0.000459 280.5300n 0.000465 280.5400n 0.000472 280.5500n 0.000477 280.5600n 0.000483 280.5700n 0.000488 280.5800n 0.000492 280.5900n 0.000496 280.6000n 0.000500 280.6100n 0.000503 280.6200n 0.000505 280.6300n 0.000507 280.6400n 0.000509
+ 280.6500n 0.000510 280.6600n 0.000511 280.6700n 0.000512 280.6800n 0.000511 280.6900n 0.000511 280.7000n 0.000510 280.7100n 0.000509 280.7200n 0.000507 280.7300n 0.000505 280.7400n 0.000502 280.7500n 0.000499 280.7600n 0.000496 280.7700n 0.000492 280.7800n 0.000488 280.7900n 0.000483
+ 280.8000n 0.000478 280.8100n 0.000473 280.8200n 0.000467 280.8300n 0.000461 280.8400n 0.000455 280.8500n 0.000448 280.8600n 0.000441 280.8700n 0.000434 280.8800n 0.000426 280.8900n 0.000418 280.9000n 0.000410 280.9100n 0.000402 280.9200n 0.000393 280.9300n 0.000384 280.9400n 0.000375
+ 280.9500n 0.000365 280.9600n 0.000356 280.9700n 0.000346 280.9800n 0.000336 280.9900n 0.000325 281.0000n 0.000315 281.0100n 0.000304 281.0200n 0.000294 281.0300n 0.000283 281.0400n 0.000272 281.0500n 0.000261 281.0600n 0.000249 281.0700n 0.000238 281.0800n 0.000226 281.0900n 0.000215
+ 281.1000n 0.000203 281.1100n 0.000192 281.1200n 0.000180 281.1300n 0.000168 281.1400n 0.000157 281.1500n 0.000145 281.1600n 0.000133 281.1700n 0.000121 281.1800n 0.000110 281.1900n 0.000098 281.2000n 0.000086 281.2100n 0.000075 281.2200n 0.000063 281.2300n 0.000052 281.2400n 0.000040
+ 281.2500n 0.000029 281.2600n 0.000017 281.2700n 0.000006 281.2800n -0.000005 281.2900n -0.000016 281.3000n -0.000027 281.3100n -0.000037 281.3200n -0.000048 281.3300n -0.000058 281.3400n -0.000069 281.3500n -0.000079 281.3600n -0.000089 281.3700n -0.000098 281.3800n -0.000108 281.3900n -0.000118
+ 281.4000n -0.000127 281.4100n -0.000136 281.4200n -0.000145 281.4300n -0.000154 281.4400n -0.000162 281.4500n -0.000171 281.4600n -0.000179 281.4700n -0.000187 281.4800n -0.000195 281.4900n -0.000202 281.5000n -0.000210 281.5100n -0.000217 281.5200n -0.000224 281.5300n -0.000231 281.5400n -0.000237
+ 281.5500n -0.000244 281.5600n -0.000250 281.5700n -0.000256 281.5800n -0.000262 281.5900n -0.000267 281.6000n -0.000273 281.6100n -0.000278 281.6200n -0.000283 281.6300n -0.000288 281.6400n -0.000293 281.6500n -0.000297 281.6600n -0.000302 281.6700n -0.000306 281.6800n -0.000310 281.6900n -0.000314
+ 281.7000n -0.000318 281.7100n -0.000322 281.7200n -0.000325 281.7300n -0.000328 281.7400n -0.000332 281.7500n -0.000335 281.7600n -0.000338 281.7700n -0.000341 281.7800n -0.000344 281.7900n -0.000346 281.8000n -0.000349 281.8100n -0.000352 281.8200n -0.000354 281.8300n -0.000357 281.8400n -0.000359
+ 281.8500n -0.000361 281.8600n -0.000364 281.8700n -0.000366 281.8800n -0.000368 281.8900n -0.000371 281.9000n -0.000373 281.9100n -0.000375 281.9200n -0.000378 281.9300n -0.000380 281.9400n -0.000382 281.9500n -0.000385 281.9600n -0.000387 281.9700n -0.000390 281.9800n -0.000392 281.9900n -0.000395
+ 282.0000n -0.000398 282.0100n -0.000400 282.0200n -0.000403 282.0300n -0.000406 282.0400n -0.000409 282.0500n -0.000413 282.0600n -0.000416 282.0700n -0.000420 282.0800n -0.000423 282.0900n -0.000427 282.1000n -0.000431 282.1100n -0.000435 282.1200n -0.000439 282.1300n -0.000444 282.1400n -0.000448
+ 282.1500n -0.000453 282.1600n -0.000458 282.1700n -0.000463 282.1800n -0.000469 282.1900n -0.000474 282.2000n -0.000480 282.2100n -0.000486 282.2200n -0.000492 282.2300n -0.000499 282.2400n -0.000505 282.2500n -0.000512 282.2600n -0.000519 282.2700n -0.000526 282.2800n -0.000534 282.2900n -0.000542
+ 282.3000n -0.000550 282.3100n -0.000558 282.3200n -0.000566 282.3300n -0.000575 282.3400n -0.000584 282.3500n -0.000593 282.3600n -0.000602 282.3700n -0.000612 282.3800n -0.000622 282.3900n -0.000632 282.4000n -0.000642 282.4100n -0.000652 282.4200n -0.000663 282.4300n -0.000674 282.4400n -0.000685
+ 282.4500n -0.000696 282.4600n -0.000707 282.4700n -0.000719 282.4800n -0.000730 282.4900n -0.000742 282.5000n -0.000754 282.5100n -0.000767 282.5200n -0.000779 282.5300n -0.000791 282.5400n -0.000804 282.5500n -0.000817 282.5600n -0.000830 282.5700n -0.000843 282.5800n -0.000856 282.5900n -0.000869
+ 282.6000n -0.000882 282.6100n -0.000895 282.6200n -0.000908 282.6300n -0.000922 282.6400n -0.000935 282.6500n -0.000948 282.6600n -0.000962 282.6700n -0.000975 282.6800n -0.000988 282.6900n -0.001002 282.7000n -0.001015 282.7100n -0.001028 282.7200n -0.001041 282.7300n -0.001054 282.7400n -0.001067
+ 282.7500n -0.001080 282.7600n -0.001092 282.7700n -0.001105 282.7800n -0.001117 282.7900n -0.001129 282.8000n -0.001141 282.8100n -0.001153 282.8200n -0.001165 282.8300n -0.001176 282.8400n -0.001187 282.8500n -0.001198 282.8600n -0.001208 282.8700n -0.001218 282.8800n -0.001228 282.8900n -0.001238
+ 282.9000n -0.001247 282.9100n -0.001256 282.9200n -0.001264 282.9300n -0.001272 282.9400n -0.001280 282.9500n -0.001287 282.9600n -0.001294 282.9700n -0.001300 282.9800n -0.001306 282.9900n -0.001312 283.0000n -0.001317 283.0100n -0.001321 283.0200n -0.001325 283.0300n -0.001329 283.0400n -0.001332
+ 283.0500n -0.001334 283.0600n -0.001336 283.0700n -0.001337 283.0800n -0.001338 283.0900n -0.001338 283.1000n -0.001338 283.1100n -0.001337 283.1200n -0.001335 283.1300n -0.001333 283.1400n -0.001330 283.1500n -0.001326 283.1600n -0.001322 283.1700n -0.001317 283.1800n -0.001311 283.1900n -0.001305
+ 283.2000n -0.001298 283.2100n -0.001290 283.2200n -0.001282 283.2300n -0.001273 283.2400n -0.001263 283.2500n -0.001253 283.2600n -0.001242 283.2700n -0.001230 283.2800n -0.001217 283.2900n -0.001204 283.3000n -0.001190 283.3100n -0.001175 283.3200n -0.001160 283.3300n -0.001144 283.3400n -0.001127
+ 283.3500n -0.001109 283.3600n -0.001091 283.3700n -0.001072 283.3800n -0.001053 283.3900n -0.001032 283.4000n -0.001011 283.4100n -0.000990 283.4200n -0.000967 283.4300n -0.000944 283.4400n -0.000921 283.4500n -0.000896 283.4600n -0.000871 283.4700n -0.000846 283.4800n -0.000819 283.4900n -0.000793
+ 283.5000n -0.000765 283.5100n -0.000737 283.5200n -0.000708 283.5300n -0.000679 283.5400n -0.000649 283.5500n -0.000619 283.5600n -0.000588 283.5700n -0.000557 283.5800n -0.000525 283.5900n -0.000493 283.6000n -0.000460 283.6100n -0.000427 283.6200n -0.000393 283.6300n -0.000359 283.6400n -0.000325
+ 283.6500n -0.000290 283.6600n -0.000255 283.6700n -0.000219 283.6800n -0.000183 283.6900n -0.000147 283.7000n -0.000111 283.7100n -0.000074 283.7200n -0.000037 283.7300n -0.000000 283.7400n 0.000037 283.7500n 0.000074 283.7600n 0.000112 283.7700n 0.000150 283.7800n 0.000188 283.7900n 0.000225
+ 283.8000n 0.000263 283.8100n 0.000301 283.8200n 0.000339 283.8300n 0.000377 283.8400n 0.000415 283.8500n 0.000453 283.8600n 0.000491 283.8700n 0.000528 283.8800n 0.000566 283.8900n 0.000603 283.9000n 0.000640 283.9100n 0.000677 283.9200n 0.000713 283.9300n 0.000749 283.9400n 0.000785
+ 283.9500n 0.000821 283.9600n 0.000856 283.9700n 0.000891 283.9800n 0.000926 283.9900n 0.000960 284.0000n 0.000994 284.0100n 0.001027 284.0200n 0.001060 284.0300n 0.001092 284.0400n 0.001124 284.0500n 0.001155 284.0600n 0.001185 284.0700n 0.001215 284.0800n 0.001244 284.0900n 0.001273
+ 284.1000n 0.001301 284.1100n 0.001328 284.1200n 0.001355 284.1300n 0.001380 284.1400n 0.001405 284.1500n 0.001429 284.1600n 0.001453 284.1700n 0.001476 284.1800n 0.001497 284.1900n 0.001518 284.2000n 0.001538 284.2100n 0.001557 284.2200n 0.001576 284.2300n 0.001593 284.2400n 0.001609
+ 284.2500n 0.001625 284.2600n 0.001639 284.2700n 0.001653 284.2800n 0.001665 284.2900n 0.001677 284.3000n 0.001687 284.3100n 0.001697 284.3200n 0.001705 284.3300n 0.001713 284.3400n 0.001719 284.3500n 0.001724 284.3600n 0.001729 284.3700n 0.001732 284.3800n 0.001734 284.3900n 0.001735
+ 284.4000n 0.001735 284.4100n 0.001734 284.4200n 0.001732 284.4300n 0.001728 284.4400n 0.001724 284.4500n 0.001718 284.4600n 0.001712 284.4700n 0.001704 284.4800n 0.001695 284.4900n 0.001685 284.5000n 0.001675 284.5100n 0.001663 284.5200n 0.001649 284.5300n 0.001635 284.5400n 0.001620
+ 284.5500n 0.001604 284.5600n 0.001586 284.5700n 0.001568 284.5800n 0.001549 284.5900n 0.001528 284.6000n 0.001507 284.6100n 0.001485 284.6200n 0.001461 284.6300n 0.001437 284.6400n 0.001412 284.6500n 0.001385 284.6600n 0.001358 284.6700n 0.001330 284.6800n 0.001301 284.6900n 0.001271
+ 284.7000n 0.001241 284.7100n 0.001209 284.7200n 0.001177 284.7300n 0.001143 284.7400n 0.001110 284.7500n 0.001075 284.7600n 0.001039 284.7700n 0.001003 284.7800n 0.000966 284.7900n 0.000929 284.8000n 0.000891 284.8100n 0.000852 284.8200n 0.000812 284.8300n 0.000772 284.8400n 0.000732
+ 284.8500n 0.000691 284.8600n 0.000649 284.8700n 0.000607 284.8800n 0.000565 284.8900n 0.000522 284.9000n 0.000479 284.9100n 0.000435 284.9200n 0.000391 284.9300n 0.000347 284.9400n 0.000302 284.9500n 0.000257 284.9600n 0.000212 284.9700n 0.000167 284.9800n 0.000121 284.9900n 0.000075
+ 285.0000n 0.000030 285.0100n -0.000016 285.0200n -0.000062 285.0300n -0.000108 285.0400n -0.000154 285.0500n -0.000200 285.0600n -0.000246 285.0700n -0.000291 285.0800n -0.000337 285.0900n -0.000382 285.1000n -0.000428 285.1100n -0.000473 285.1200n -0.000518 285.1300n -0.000562 285.1400n -0.000607
+ 285.1500n -0.000651 285.1600n -0.000695 285.1700n -0.000738 285.1800n -0.000781 285.1900n -0.000824 285.2000n -0.000866 285.2100n -0.000907 285.2200n -0.000949 285.2300n -0.000989 285.2400n -0.001029 285.2500n -0.001069 285.2600n -0.001108 285.2700n -0.001146 285.2800n -0.001184 285.2900n -0.001221
+ 285.3000n -0.001258 285.3100n -0.001294 285.3200n -0.001329 285.3300n -0.001363 285.3400n -0.001397 285.3500n -0.001430 285.3600n -0.001462 285.3700n -0.001493 285.3800n -0.001523 285.3900n -0.001553 285.4000n -0.001582 285.4100n -0.001610 285.4200n -0.001637 285.4300n -0.001663 285.4400n -0.001688
+ 285.4500n -0.001712 285.4600n -0.001736 285.4700n -0.001758 285.4800n -0.001780 285.4900n -0.001801 285.5000n -0.001820 285.5100n -0.001839 285.5200n -0.001857 285.5300n -0.001873 285.5400n -0.001889 285.5500n -0.001904 285.5600n -0.001918 285.5700n -0.001931 285.5800n -0.001943 285.5900n -0.001953
+ 285.6000n -0.001963 285.6100n -0.001972 285.6200n -0.001980 285.6300n -0.001987 285.6400n -0.001993 285.6500n -0.001998 285.6600n -0.002002 285.6700n -0.002005 285.6800n -0.002007 285.6900n -0.002008 285.7000n -0.002008 285.7100n -0.002007 285.7200n -0.002006 285.7300n -0.002003 285.7400n -0.001999
+ 285.7500n -0.001995 285.7600n -0.001990 285.7700n -0.001983 285.7800n -0.001976 285.7900n -0.001968 285.8000n -0.001959 285.8100n -0.001950 285.8200n -0.001939 285.8300n -0.001928 285.8400n -0.001916 285.8500n -0.001903 285.8600n -0.001890 285.8700n -0.001875 285.8800n -0.001860 285.8900n -0.001845
+ 285.9000n -0.001828 285.9100n -0.001811 285.9200n -0.001793 285.9300n -0.001775 285.9400n -0.001756 285.9500n -0.001737 285.9600n -0.001717 285.9700n -0.001696 285.9800n -0.001675 285.9900n -0.001654 286.0000n -0.001632 286.0100n -0.001609 286.0200n -0.001586 286.0300n -0.001563 286.0400n -0.001539
+ 286.0500n -0.001515 286.0600n -0.001491 286.0700n -0.001466 286.0800n -0.001441 286.0900n -0.001416 286.1000n -0.001390 286.1100n -0.001365 286.1200n -0.001339 286.1300n -0.001313 286.1400n -0.001286 286.1500n -0.001260 286.1600n -0.001234 286.1700n -0.001207 286.1800n -0.001181 286.1900n -0.001154
+ 286.2000n -0.001127 286.2100n -0.001101 286.2200n -0.001074 286.2300n -0.001048 286.2400n -0.001022 286.2500n -0.000995 286.2600n -0.000969 286.2700n -0.000943 286.2800n -0.000917 286.2900n -0.000891 286.3000n -0.000866 286.3100n -0.000841 286.3200n -0.000816 286.3300n -0.000791 286.3400n -0.000767
+ 286.3500n -0.000742 286.3600n -0.000719 286.3700n -0.000695 286.3800n -0.000672 286.3900n -0.000649 286.4000n -0.000627 286.4100n -0.000605 286.4200n -0.000583 286.4300n -0.000562 286.4400n -0.000541 286.4500n -0.000521 286.4600n -0.000501 286.4700n -0.000482 286.4800n -0.000463 286.4900n -0.000445
+ 286.5000n -0.000427 286.5100n -0.000410 286.5200n -0.000393 286.5300n -0.000377 286.5400n -0.000361 286.5500n -0.000346 286.5600n -0.000331 286.5700n -0.000317 286.5800n -0.000304 286.5900n -0.000291 286.6000n -0.000278 286.6100n -0.000267 286.6200n -0.000255 286.6300n -0.000245 286.6400n -0.000235
+ 286.6500n -0.000225 286.6600n -0.000216 286.6700n -0.000208 286.6800n -0.000200 286.6900n -0.000193 286.7000n -0.000187 286.7100n -0.000181 286.7200n -0.000175 286.7300n -0.000170 286.7400n -0.000166 286.7500n -0.000162 286.7600n -0.000159 286.7700n -0.000156 286.7800n -0.000154 286.7900n -0.000152
+ 286.8000n -0.000151 286.8100n -0.000150 286.8200n -0.000150 286.8300n -0.000150 286.8400n -0.000151 286.8500n -0.000152 286.8600n -0.000153 286.8700n -0.000155 286.8800n -0.000158 286.8900n -0.000160 286.9000n -0.000163 286.9100n -0.000167 286.9200n -0.000171 286.9300n -0.000175 286.9400n -0.000179
+ 286.9500n -0.000184 286.9600n -0.000189 286.9700n -0.000195 286.9800n -0.000200 286.9900n -0.000206 287.0000n -0.000212 287.0100n -0.000218 287.0200n -0.000225 287.0300n -0.000231 287.0400n -0.000238 287.0500n -0.000244 287.0600n -0.000251 287.0700n -0.000258 287.0800n -0.000265 287.0900n -0.000272
+ 287.1000n -0.000279 287.1100n -0.000286 287.1200n -0.000293 287.1300n -0.000300 287.1400n -0.000307 287.1500n -0.000314 287.1600n -0.000321 287.1700n -0.000327 287.1800n -0.000334 287.1900n -0.000340 287.2000n -0.000346 287.2100n -0.000352 287.2200n -0.000357 287.2300n -0.000363 287.2400n -0.000368
+ 287.2500n -0.000372 287.2600n -0.000377 287.2700n -0.000381 287.2800n -0.000385 287.2900n -0.000388 287.3000n -0.000391 287.3100n -0.000394 287.3200n -0.000396 287.3300n -0.000398 287.3400n -0.000399 287.3500n -0.000400 287.3600n -0.000400 287.3700n -0.000400 287.3800n -0.000400 287.3900n -0.000398
+ 287.4000n -0.000397 287.4100n -0.000394 287.4200n -0.000391 287.4300n -0.000388 287.4400n -0.000384 287.4500n -0.000379 287.4600n -0.000374 287.4700n -0.000368 287.4800n -0.000361 287.4900n -0.000354 287.5000n -0.000346 287.5100n -0.000338 287.5200n -0.000328 287.5300n -0.000318 287.5400n -0.000308
+ 287.5500n -0.000296 287.5600n -0.000284 287.5700n -0.000271 287.5800n -0.000258 287.5900n -0.000244 287.6000n -0.000229 287.6100n -0.000213 287.6200n -0.000197 287.6300n -0.000179 287.6400n -0.000161 287.6500n -0.000143 287.6600n -0.000123 287.6700n -0.000103 287.6800n -0.000083 287.6900n -0.000061
+ 287.7000n -0.000039 287.7100n -0.000016 287.7200n 0.000008 287.7300n 0.000032 287.7400n 0.000058 287.7500n 0.000083 287.7600n 0.000110 287.7700n 0.000137 287.7800n 0.000165 287.7900n 0.000193 287.8000n 0.000223 287.8100n 0.000252 287.8200n 0.000283 287.8300n 0.000314 287.8400n 0.000346
+ 287.8500n 0.000378 287.8600n 0.000411 287.8700n 0.000444 287.8800n 0.000478 287.8900n 0.000513 287.9000n 0.000548 287.9100n 0.000583 287.9200n 0.000619 287.9300n 0.000656 287.9400n 0.000693 287.9500n 0.000730 287.9600n 0.000768 287.9700n 0.000806 287.9800n 0.000844 287.9900n 0.000883
+ 288.0000n 0.000923 288.0100n 0.000962 288.0200n 0.001002 288.0300n 0.001042 288.0400n 0.001082 288.0500n 0.001123 288.0600n 0.001164 288.0700n 0.001205 288.0800n 0.001246 288.0900n 0.001287 288.1000n 0.001329 288.1100n 0.001370 288.1200n 0.001412 288.1300n 0.001453 288.1400n 0.001495
+ 288.1500n 0.001537 288.1600n 0.001578 288.1700n 0.001620 288.1800n 0.001661 288.1900n 0.001703 288.2000n 0.001744 288.2100n 0.001785 288.2200n 0.001826 288.2300n 0.001866 288.2400n 0.001907 288.2500n 0.001947 288.2600n 0.001987 288.2700n 0.002026 288.2800n 0.002066 288.2900n 0.002105
+ 288.3000n 0.002143 288.3100n 0.002181 288.3200n 0.002219 288.3300n 0.002256 288.3400n 0.002293 288.3500n 0.002329 288.3600n 0.002365 288.3700n 0.002400 288.3800n 0.002435 288.3900n 0.002469 288.4000n 0.002503 288.4100n 0.002536 288.4200n 0.002568 288.4300n 0.002599 288.4400n 0.002630
+ 288.4500n 0.002660 288.4600n 0.002690 288.4700n 0.002718 288.4800n 0.002746 288.4900n 0.002773 288.5000n 0.002800 288.5100n 0.002825 288.5200n 0.002850 288.5300n 0.002874 288.5400n 0.002896 288.5500n 0.002918 288.5600n 0.002940 288.5700n 0.002960 288.5800n 0.002979 288.5900n 0.002998
+ 288.6000n 0.003015 288.6100n 0.003031 288.6200n 0.003047 288.6300n 0.003061 288.6400n 0.003075 288.6500n 0.003087 288.6600n 0.003099 288.6700n 0.003109 288.6800n 0.003119 288.6900n 0.003127 288.7000n 0.003135 288.7100n 0.003141 288.7200n 0.003146 288.7300n 0.003151 288.7400n 0.003154
+ 288.7500n 0.003156 288.7600n 0.003157 288.7700n 0.003157 288.7800n 0.003156 288.7900n 0.003154 288.8000n 0.003151 288.8100n 0.003147 288.8200n 0.003141 288.8300n 0.003135 288.8400n 0.003128 288.8500n 0.003119 288.8600n 0.003110 288.8700n 0.003099 288.8800n 0.003088 288.8900n 0.003075
+ 288.9000n 0.003062 288.9100n 0.003047 288.9200n 0.003032 288.9300n 0.003015 288.9400n 0.002997 288.9500n 0.002979 288.9600n 0.002960 288.9700n 0.002939 288.9800n 0.002918 288.9900n 0.002896 289.0000n 0.002872 289.0100n 0.002848 289.0200n 0.002823 289.0300n 0.002798 289.0400n 0.002771
+ 289.0500n 0.002744 289.0600n 0.002715 289.0700n 0.002686 289.0800n 0.002656 289.0900n 0.002626 289.1000n 0.002594 289.1100n 0.002562 289.1200n 0.002529 289.1300n 0.002496 289.1400n 0.002462 289.1500n 0.002427 289.1600n 0.002392 289.1700n 0.002355 289.1800n 0.002319 289.1900n 0.002282
+ 289.2000n 0.002244 289.2100n 0.002206 289.2200n 0.002167 289.2300n 0.002128 289.2400n 0.002088 289.2500n 0.002048 289.2600n 0.002007 289.2700n 0.001966 289.2800n 0.001925 289.2900n 0.001883 289.3000n 0.001841 289.3100n 0.001799 289.3200n 0.001756 289.3300n 0.001714 289.3400n 0.001671
+ 289.3500n 0.001628 289.3600n 0.001584 289.3700n 0.001541 289.3800n 0.001497 289.3900n 0.001453 289.4000n 0.001409 289.4100n 0.001366 289.4200n 0.001322 289.4300n 0.001278 289.4400n 0.001234 289.4500n 0.001190 289.4600n 0.001146 289.4700n 0.001102 289.4800n 0.001059 289.4900n 0.001015
+ 289.5000n 0.000972 289.5100n 0.000929 289.5200n 0.000886 289.5300n 0.000843 289.5400n 0.000801 289.5500n 0.000758 289.5600n 0.000717 289.5700n 0.000675 289.5800n 0.000634 289.5900n 0.000593 289.6000n 0.000552 289.6100n 0.000512 289.6200n 0.000472 289.6300n 0.000432 289.6400n 0.000393
+ 289.6500n 0.000355 289.6600n 0.000317 289.6700n 0.000279 289.6800n 0.000242 289.6900n 0.000205 289.7000n 0.000169 289.7100n 0.000134 289.7200n 0.000099 289.7300n 0.000065 289.7400n 0.000031 289.7500n -0.000002 289.7600n -0.000035 289.7700n -0.000067 289.7800n -0.000098 289.7900n -0.000129
+ 289.8000n -0.000159 289.8100n -0.000188 289.8200n -0.000216 289.8300n -0.000244 289.8400n -0.000271 289.8500n -0.000298 289.8600n -0.000324 289.8700n -0.000349 289.8800n -0.000373 289.8900n -0.000397 289.9000n -0.000419 289.9100n -0.000442 289.9200n -0.000463 289.9300n -0.000483 289.9400n -0.000503
+ 289.9500n -0.000522 289.9600n -0.000541 289.9700n -0.000558 289.9800n -0.000575 289.9900n -0.000591 290.0000n -0.000606 290.0100n -0.000620 290.0200n -0.000634 290.0300n -0.000647 290.0400n -0.000659 290.0500n -0.000671 290.0600n -0.000681 290.0700n -0.000691 290.0800n -0.000700 290.0900n -0.000708
+ 290.1000n -0.000716 290.1100n -0.000723 290.1200n -0.000729 290.1300n -0.000734 290.1400n -0.000739 290.1500n -0.000743 290.1600n -0.000746 290.1700n -0.000749 290.1800n -0.000751 290.1900n -0.000752 290.2000n -0.000753 290.2100n -0.000752 290.2200n -0.000752 290.2300n -0.000750 290.2400n -0.000748
+ 290.2500n -0.000745 290.2600n -0.000742 290.2700n -0.000738 290.2800n -0.000733 290.2900n -0.000728 290.3000n -0.000723 290.3100n -0.000716 290.3200n -0.000710 290.3300n -0.000702 290.3400n -0.000694 290.3500n -0.000686 290.3600n -0.000677 290.3700n -0.000668 290.3800n -0.000658 290.3900n -0.000648
+ 290.4000n -0.000637 290.4100n -0.000626 290.4200n -0.000615 290.4300n -0.000603 290.4400n -0.000590 290.4500n -0.000578 290.4600n -0.000565 290.4700n -0.000552 290.4800n -0.000538 290.4900n -0.000524 290.5000n -0.000510 290.5100n -0.000495 290.5200n -0.000481 290.5300n -0.000466 290.5400n -0.000450
+ 290.5500n -0.000435 290.5600n -0.000419 290.5700n -0.000404 290.5800n -0.000388 290.5900n -0.000372 290.6000n -0.000355 290.6100n -0.000339 290.6200n -0.000323 290.6300n -0.000306 290.6400n -0.000290 290.6500n -0.000273 290.6600n -0.000256 290.6700n -0.000240 290.6800n -0.000223 290.6900n -0.000206
+ 290.7000n -0.000190 290.7100n -0.000173 290.7200n -0.000156 290.7300n -0.000140 290.7400n -0.000123 290.7500n -0.000107 290.7600n -0.000091 290.7700n -0.000074 290.7800n -0.000058 290.7900n -0.000042 290.8000n -0.000027 290.8100n -0.000011 290.8200n 0.000004 290.8300n 0.000019 290.8400n 0.000035
+ 290.8500n 0.000049 290.8600n 0.000064 290.8700n 0.000078 290.8800n 0.000092 290.8900n 0.000106 290.9000n 0.000120 290.9100n 0.000133 290.9200n 0.000146 290.9300n 0.000159 290.9400n 0.000171 290.9500n 0.000183 290.9600n 0.000195 290.9700n 0.000207 290.9800n 0.000218 290.9900n 0.000229
+ 291.0000n 0.000239 291.0100n 0.000249 291.0200n 0.000259 291.0300n 0.000268 291.0400n 0.000277 291.0500n 0.000286 291.0600n 0.000294 291.0700n 0.000302 291.0800n 0.000309 291.0900n 0.000316 291.1000n 0.000323 291.1100n 0.000329 291.1200n 0.000335 291.1300n 0.000340 291.1400n 0.000345
+ 291.1500n 0.000349 291.1600n 0.000353 291.1700n 0.000357 291.1800n 0.000360 291.1900n 0.000363 291.2000n 0.000365 291.2100n 0.000367 291.2200n 0.000369 291.2300n 0.000370 291.2400n 0.000371 291.2500n 0.000371 291.2600n 0.000371 291.2700n 0.000370 291.2800n 0.000369 291.2900n 0.000367
+ 291.3000n 0.000365 291.3100n 0.000363 291.3200n 0.000360 291.3300n 0.000357 291.3400n 0.000353 291.3500n 0.000349 291.3600n 0.000345 291.3700n 0.000340 291.3800n 0.000335 291.3900n 0.000329 291.4000n 0.000323 291.4100n 0.000316 291.4200n 0.000309 291.4300n 0.000302 291.4400n 0.000295
+ 291.4500n 0.000287 291.4600n 0.000278 291.4700n 0.000270 291.4800n 0.000260 291.4900n 0.000251 291.5000n 0.000241 291.5100n 0.000231 291.5200n 0.000221 291.5300n 0.000210 291.5400n 0.000199 291.5500n 0.000188 291.5600n 0.000176 291.5700n 0.000164 291.5800n 0.000152 291.5900n 0.000139
+ 291.6000n 0.000126 291.6100n 0.000113 291.6200n 0.000100 291.6300n 0.000086 291.6400n 0.000073 291.6500n 0.000058 291.6600n 0.000044 291.6700n 0.000030 291.6800n 0.000015 291.6900n 0.000000 291.7000n -0.000015 291.7100n -0.000030 291.7200n -0.000045 291.7300n -0.000061 291.7400n -0.000077
+ 291.7500n -0.000093 291.7600n -0.000109 291.7700n -0.000125 291.7800n -0.000141 291.7900n -0.000157 291.8000n -0.000173 291.8100n -0.000190 291.8200n -0.000206 291.8300n -0.000223 291.8400n -0.000240 291.8500n -0.000256 291.8600n -0.000273 291.8700n -0.000290 291.8800n -0.000306 291.8900n -0.000323
+ 291.9000n -0.000340 291.9100n -0.000357 291.9200n -0.000373 291.9300n -0.000390 291.9400n -0.000407 291.9500n -0.000423 291.9600n -0.000440 291.9700n -0.000456 291.9800n -0.000472 291.9900n -0.000488 292.0000n -0.000504 292.0100n -0.000520 292.0200n -0.000536 292.0300n -0.000552 292.0400n -0.000568
+ 292.0500n -0.000583 292.0600n -0.000598 292.0700n -0.000613 292.0800n -0.000628 292.0900n -0.000643 292.1000n -0.000657 292.1100n -0.000671 292.1200n -0.000685 292.1300n -0.000699 292.1400n -0.000713 292.1500n -0.000726 292.1600n -0.000739 292.1700n -0.000752 292.1800n -0.000764 292.1900n -0.000776
+ 292.2000n -0.000788 292.2100n -0.000800 292.2200n -0.000811 292.2300n -0.000822 292.2400n -0.000833 292.2500n -0.000843 292.2600n -0.000853 292.2700n -0.000863 292.2800n -0.000872 292.2900n -0.000881 292.3000n -0.000889 292.3100n -0.000897 292.3200n -0.000905 292.3300n -0.000913 292.3400n -0.000920
+ 292.3500n -0.000926 292.3600n -0.000932 292.3700n -0.000938 292.3800n -0.000943 292.3900n -0.000948 292.4000n -0.000953 292.4100n -0.000957 292.4200n -0.000960 292.4300n -0.000963 292.4400n -0.000966 292.4500n -0.000968 292.4600n -0.000970 292.4700n -0.000971 292.4800n -0.000972 292.4900n -0.000972
+ 292.5000n -0.000972 292.5100n -0.000971 292.5200n -0.000970 292.5300n -0.000968 292.5400n -0.000966 292.5500n -0.000964 292.5600n -0.000961 292.5700n -0.000957 292.5800n -0.000953 292.5900n -0.000948 292.6000n -0.000943 292.6100n -0.000937 292.6200n -0.000931 292.6300n -0.000924 292.6400n -0.000917
+ 292.6500n -0.000910 292.6600n -0.000901 292.6700n -0.000893 292.6800n -0.000883 292.6900n -0.000874 292.7000n -0.000863 292.7100n -0.000853 292.7200n -0.000841 292.7300n -0.000829 292.7400n -0.000817 292.7500n -0.000804 292.7600n -0.000791 292.7700n -0.000777 292.7800n -0.000763 292.7900n -0.000748
+ 292.8000n -0.000733 292.8100n -0.000717 292.8200n -0.000701 292.8300n -0.000684 292.8400n -0.000667 292.8500n -0.000649 292.8600n -0.000631 292.8700n -0.000613 292.8800n -0.000594 292.8900n -0.000574 292.9000n -0.000555 292.9100n -0.000534 292.9200n -0.000513 292.9300n -0.000492 292.9400n -0.000471
+ 292.9500n -0.000449 292.9600n -0.000426 292.9700n -0.000404 292.9800n -0.000381 292.9900n -0.000357 293.0000n -0.000333 293.0100n -0.000309 293.0200n -0.000284 293.0300n -0.000259 293.0400n -0.000234 293.0500n -0.000209 293.0600n -0.000183 293.0700n -0.000157 293.0800n -0.000130 293.0900n -0.000104
+ 293.1000n -0.000077 293.1100n -0.000050 293.1200n -0.000022 293.1300n 0.000006 293.1400n 0.000033 293.1500n 0.000062 293.1600n 0.000090 293.1700n 0.000118 293.1800n 0.000147 293.1900n 0.000176 293.2000n 0.000204 293.2100n 0.000233 293.2200n 0.000263 293.2300n 0.000292 293.2400n 0.000321
+ 293.2500n 0.000350 293.2600n 0.000380 293.2700n 0.000409 293.2800n 0.000439 293.2900n 0.000468 293.3000n 0.000498 293.3100n 0.000527 293.3200n 0.000556 293.3300n 0.000586 293.3400n 0.000615 293.3500n 0.000644 293.3600n 0.000673 293.3700n 0.000702 293.3800n 0.000731 293.3900n 0.000760
+ 293.4000n 0.000788 293.4100n 0.000817 293.4200n 0.000845 293.4300n 0.000873 293.4400n 0.000901 293.4500n 0.000928 293.4600n 0.000955 293.4700n 0.000982 293.4800n 0.001009 293.4900n 0.001035 293.5000n 0.001061 293.5100n 0.001087 293.5200n 0.001112 293.5300n 0.001137 293.5400n 0.001162
+ 293.5500n 0.001186 293.5600n 0.001210 293.5700n 0.001233 293.5800n 0.001256 293.5900n 0.001279 293.6000n 0.001301 293.6100n 0.001322 293.6200n 0.001343 293.6300n 0.001364 293.6400n 0.001384 293.6500n 0.001403 293.6600n 0.001422 293.6700n 0.001441 293.6800n 0.001458 293.6900n 0.001475
+ 293.7000n 0.001492 293.7100n 0.001508 293.7200n 0.001523 293.7300n 0.001538 293.7400n 0.001552 293.7500n 0.001565 293.7600n 0.001578 293.7700n 0.001590 293.7800n 0.001601 293.7900n 0.001611 293.8000n 0.001621 293.8100n 0.001630 293.8200n 0.001639 293.8300n 0.001646 293.8400n 0.001653
+ 293.8500n 0.001659 293.8600n 0.001664 293.8700n 0.001669 293.8800n 0.001673 293.8900n 0.001676 293.9000n 0.001678 293.9100n 0.001679 293.9200n 0.001680 293.9300n 0.001679 293.9400n 0.001678 293.9500n 0.001676 293.9600n 0.001674 293.9700n 0.001670 293.9800n 0.001666 293.9900n 0.001661
+ 294.0000n 0.001655 294.0100n 0.001648 294.0200n 0.001640 294.0300n 0.001632 294.0400n 0.001622 294.0500n 0.001612 294.0600n 0.001601 294.0700n 0.001590 294.0800n 0.001577 294.0900n 0.001563 294.1000n 0.001549 294.1100n 0.001534 294.1200n 0.001518 294.1300n 0.001502 294.1400n 0.001484
+ 294.1500n 0.001466 294.1600n 0.001447 294.1700n 0.001427 294.1800n 0.001407 294.1900n 0.001385 294.2000n 0.001363 294.2100n 0.001341 294.2200n 0.001317 294.2300n 0.001293 294.2400n 0.001268 294.2500n 0.001242 294.2600n 0.001216 294.2700n 0.001189 294.2800n 0.001161 294.2900n 0.001133
+ 294.3000n 0.001104 294.3100n 0.001075 294.3200n 0.001044 294.3300n 0.001014 294.3400n 0.000982 294.3500n 0.000951 294.3600n 0.000918 294.3700n 0.000885 294.3800n 0.000852 294.3900n 0.000818 294.4000n 0.000783 294.4100n 0.000748 294.4200n 0.000713 294.4300n 0.000677 294.4400n 0.000641
+ 294.4500n 0.000605 294.4600n 0.000568 294.4700n 0.000531 294.4800n 0.000493 294.4900n 0.000455 294.5000n 0.000417 294.5100n 0.000379 294.5200n 0.000340 294.5300n 0.000301 294.5400n 0.000262 294.5500n 0.000223 294.5600n 0.000184 294.5700n 0.000144 294.5800n 0.000104 294.5900n 0.000065
+ 294.6000n 0.000025 294.6100n -0.000015 294.6200n -0.000055 294.6300n -0.000095 294.6400n -0.000134 294.6500n -0.000174 294.6600n -0.000214 294.6700n -0.000254 294.6800n -0.000293 294.6900n -0.000332 294.7000n -0.000372 294.7100n -0.000411 294.7200n -0.000449 294.7300n -0.000488 294.7400n -0.000526
+ 294.7500n -0.000565 294.7600n -0.000602 294.7700n -0.000640 294.7800n -0.000677 294.7900n -0.000714 294.8000n -0.000750 294.8100n -0.000786 294.8200n -0.000822 294.8300n -0.000857 294.8400n -0.000892 294.8500n -0.000926 294.8600n -0.000959 294.8700n -0.000993 294.8800n -0.001025 294.8900n -0.001057
+ 294.9000n -0.001089 294.9100n -0.001120 294.9200n -0.001150 294.9300n -0.001180 294.9400n -0.001209 294.9500n -0.001237 294.9600n -0.001265 294.9700n -0.001292 294.9800n -0.001318 294.9900n -0.001344 295.0000n -0.001369 295.0100n -0.001393 295.0200n -0.001416 295.0300n -0.001439 295.0400n -0.001461
+ 295.0500n -0.001482 295.0600n -0.001502 295.0700n -0.001522 295.0800n -0.001540 295.0900n -0.001558 295.1000n -0.001575 295.1100n -0.001591 295.1200n -0.001606 295.1300n -0.001620 295.1400n -0.001634 295.1500n -0.001647 295.1600n -0.001658 295.1700n -0.001669 295.1800n -0.001679 295.1900n -0.001688
+ 295.2000n -0.001696 295.2100n -0.001704 295.2200n -0.001710 295.2300n -0.001716 295.2400n -0.001720 295.2500n -0.001724 295.2600n -0.001727 295.2700n -0.001729 295.2800n -0.001730 295.2900n -0.001730 295.3000n -0.001729 295.3100n -0.001728 295.3200n -0.001725 295.3300n -0.001722 295.3400n -0.001718
+ 295.3500n -0.001713 295.3600n -0.001707 295.3700n -0.001700 295.3800n -0.001693 295.3900n -0.001685 295.4000n -0.001676 295.4100n -0.001666 295.4200n -0.001655 295.4300n -0.001644 295.4400n -0.001631 295.4500n -0.001618 295.4600n -0.001605 295.4700n -0.001590 295.4800n -0.001575 295.4900n -0.001560
+ 295.5000n -0.001543 295.5100n -0.001526 295.5200n -0.001509 295.5300n -0.001490 295.5400n -0.001471 295.5500n -0.001452 295.5600n -0.001432 295.5700n -0.001411 295.5800n -0.001390 295.5900n -0.001369 295.6000n -0.001347 295.6100n -0.001324 295.6200n -0.001301 295.6300n -0.001278 295.6400n -0.001254
+ 295.6500n -0.001230 295.6600n -0.001205 295.6700n -0.001180 295.6800n -0.001155 295.6900n -0.001130 295.7000n -0.001104 295.7100n -0.001078 295.7200n -0.001051 295.7300n -0.001025 295.7400n -0.000998 295.7500n -0.000972 295.7600n -0.000945 295.7700n -0.000918 295.7800n -0.000891 295.7900n -0.000863
+ 295.8000n -0.000836 295.8100n -0.000809 295.8200n -0.000782 295.8300n -0.000755 295.8400n -0.000728 295.8500n -0.000700 295.8600n -0.000673 295.8700n -0.000647 295.8800n -0.000620 295.8900n -0.000593 295.9000n -0.000567 295.9100n -0.000541 295.9200n -0.000515 295.9300n -0.000489 295.9400n -0.000464
+ 295.9500n -0.000439 295.9600n -0.000414 295.9700n -0.000389 295.9800n -0.000365 295.9900n -0.000342 296.0000n -0.000318 296.0100n -0.000295 296.0200n -0.000273 296.0300n -0.000251 296.0400n -0.000229 296.0500n -0.000208 296.0600n -0.000187 296.0700n -0.000167 296.0800n -0.000147 296.0900n -0.000128
+ 296.1000n -0.000109 296.1100n -0.000091 296.1200n -0.000074 296.1300n -0.000057 296.1400n -0.000041 296.1500n -0.000025 296.1600n -0.000010 296.1700n 0.000004 296.1800n 0.000018 296.1900n 0.000031 296.2000n 0.000044 296.2100n 0.000056 296.2200n 0.000067 296.2300n 0.000077 296.2400n 0.000087
+ 296.2500n 0.000096 296.2600n 0.000105 296.2700n 0.000112 296.2800n 0.000120 296.2900n 0.000126 296.3000n 0.000132 296.3100n 0.000137 296.3200n 0.000141 296.3300n 0.000144 296.3400n 0.000147 296.3500n 0.000150 296.3600n 0.000151 296.3700n 0.000152 296.3800n 0.000152 296.3900n 0.000152
+ 296.4000n 0.000151 296.4100n 0.000149 296.4200n 0.000146 296.4300n 0.000143 296.4400n 0.000140 296.4500n 0.000135 296.4600n 0.000130 296.4700n 0.000125 296.4800n 0.000119 296.4900n 0.000112 296.5000n 0.000105 296.5100n 0.000097 296.5200n 0.000088 296.5300n 0.000079 296.5400n 0.000070
+ 296.5500n 0.000060 296.5600n 0.000050 296.5700n 0.000039 296.5800n 0.000027 296.5900n 0.000016 296.6000n 0.000004 296.6100n -0.000009 296.6200n -0.000022 296.6300n -0.000035 296.6400n -0.000049 296.6500n -0.000063 296.6600n -0.000077 296.6700n -0.000092 296.6800n -0.000106 296.6900n -0.000121
+ 296.7000n -0.000137 296.7100n -0.000152 296.7200n -0.000168 296.7300n -0.000183 296.7400n -0.000199 296.7500n -0.000215 296.7600n -0.000231 296.7700n -0.000247 296.7800n -0.000263 296.7900n -0.000280 296.8000n -0.000296 296.8100n -0.000312 296.8200n -0.000328 296.8300n -0.000344 296.8400n -0.000360
+ 296.8500n -0.000375 296.8600n -0.000391 296.8700n -0.000406 296.8800n -0.000421 296.8900n -0.000436 296.9000n -0.000451 296.9100n -0.000465 296.9200n -0.000479 296.9300n -0.000493 296.9400n -0.000507 296.9500n -0.000520 296.9600n -0.000533 296.9700n -0.000545 296.9800n -0.000557 296.9900n -0.000568
+ 297.0000n -0.000579 297.0100n -0.000590 297.0200n -0.000600 297.0300n -0.000609 297.0400n -0.000618 297.0500n -0.000627 297.0600n -0.000635 297.0700n -0.000642 297.0800n -0.000648 297.0900n -0.000654 297.1000n -0.000660 297.1100n -0.000665 297.1200n -0.000669 297.1300n -0.000672 297.1400n -0.000675
+ 297.1500n -0.000677 297.1600n -0.000678 297.1700n -0.000678 297.1800n -0.000678 297.1900n -0.000677 297.2000n -0.000675 297.2100n -0.000673 297.2200n -0.000670 297.2300n -0.000666 297.2400n -0.000661 297.2500n -0.000655 297.2600n -0.000649 297.2700n -0.000641 297.2800n -0.000633 297.2900n -0.000625
+ 297.3000n -0.000615 297.3100n -0.000604 297.3200n -0.000593 297.3300n -0.000581 297.3400n -0.000568 297.3500n -0.000555 297.3600n -0.000540 297.3700n -0.000525 297.3800n -0.000509 297.3900n -0.000492 297.4000n -0.000474 297.4100n -0.000456 297.4200n -0.000437 297.4300n -0.000417 297.4400n -0.000396
+ 297.4500n -0.000375 297.4600n -0.000353 297.4700n -0.000330 297.4800n -0.000307 297.4900n -0.000283 297.5000n -0.000258 297.5100n -0.000233 297.5200n -0.000207 297.5300n -0.000180 297.5400n -0.000153 297.5500n -0.000125 297.5600n -0.000097 297.5700n -0.000068 297.5800n -0.000038 297.5900n -0.000008
+ 297.6000n 0.000022 297.6100n 0.000053 297.6200n 0.000084 297.6300n 0.000116 297.6400n 0.000148 297.6500n 0.000180 297.6600n 0.000212 297.6700n 0.000245 297.6800n 0.000279 297.6900n 0.000312 297.7000n 0.000346 297.7100n 0.000380 297.7200n 0.000414 297.7300n 0.000448 297.7400n 0.000482
+ 297.7500n 0.000516 297.7600n 0.000550 297.7700n 0.000585 297.7800n 0.000619 297.7900n 0.000653 297.8000n 0.000687 297.8100n 0.000722 297.8200n 0.000755 297.8300n 0.000789 297.8400n 0.000823 297.8500n 0.000856 297.8600n 0.000889 297.8700n 0.000922 297.8800n 0.000954 297.8900n 0.000986
+ 297.9000n 0.001017 297.9100n 0.001048 297.9200n 0.001079 297.9300n 0.001109 297.9400n 0.001139 297.9500n 0.001168 297.9600n 0.001196 297.9700n 0.001224 297.9800n 0.001251 297.9900n 0.001278 298.0000n 0.001304 298.0100n 0.001329 298.0200n 0.001353 298.0300n 0.001377 298.0400n 0.001399
+ 298.0500n 0.001421 298.0600n 0.001442 298.0700n 0.001462 298.0800n 0.001481 298.0900n 0.001499 298.1000n 0.001516 298.1100n 0.001532 298.1200n 0.001547 298.1300n 0.001561 298.1400n 0.001574 298.1500n 0.001586 298.1600n 0.001596 298.1700n 0.001606 298.1800n 0.001614 298.1900n 0.001621
+ 298.2000n 0.001627 298.2100n 0.001632 298.2200n 0.001635 298.2300n 0.001637 298.2400n 0.001638 298.2500n 0.001638 298.2600n 0.001636 298.2700n 0.001633 298.2800n 0.001629 298.2900n 0.001623 298.3000n 0.001616 298.3100n 0.001608 298.3200n 0.001598 298.3300n 0.001587 298.3400n 0.001575
+ 298.3500n 0.001561 298.3600n 0.001546 298.3700n 0.001529 298.3800n 0.001511 298.3900n 0.001492 298.4000n 0.001471 298.4100n 0.001449 298.4200n 0.001425 298.4300n 0.001401 298.4400n 0.001374 298.4500n 0.001347 298.4600n 0.001318 298.4700n 0.001287 298.4800n 0.001256 298.4900n 0.001223
+ 298.5000n 0.001188 298.5100n 0.001153 298.5200n 0.001116 298.5300n 0.001078 298.5400n 0.001038 298.5500n 0.000998 298.5600n 0.000956 298.5700n 0.000913 298.5800n 0.000868 298.5900n 0.000823 298.6000n 0.000776 298.6100n 0.000728 298.6200n 0.000680 298.6300n 0.000630 298.6400n 0.000579
+ 298.6500n 0.000527 298.6600n 0.000473 298.6700n 0.000419 298.6800n 0.000365 298.6900n 0.000309 298.7000n 0.000252 298.7100n 0.000194 298.7200n 0.000136 298.7300n 0.000077 298.7400n 0.000017 298.7500n -0.000044 298.7600n -0.000105 298.7700n -0.000167 298.7800n -0.000230 298.7900n -0.000293
+ 298.8000n -0.000357 298.8100n -0.000421 298.8200n -0.000486 298.8300n -0.000551 298.8400n -0.000617 298.8500n -0.000683 298.8600n -0.000749 298.8700n -0.000815 298.8800n -0.000882 298.8900n -0.000949 298.9000n -0.001016 298.9100n -0.001083 298.9200n -0.001151 298.9300n -0.001218 298.9400n -0.001285
+ 298.9500n -0.001352 298.9600n -0.001419 298.9700n -0.001486 298.9800n -0.001553 298.9900n -0.001619 299.0000n -0.001686 299.0100n -0.001752 299.0200n -0.001817 299.0300n -0.001882 299.0400n -0.001947 299.0500n -0.002011 299.0600n -0.002075 299.0700n -0.002138 299.0800n -0.002201 299.0900n -0.002263
+ 299.1000n -0.002324 299.1100n -0.002384 299.1200n -0.002444 299.1300n -0.002503 299.1400n -0.002561 299.1500n -0.002618 299.1600n -0.002675 299.1700n -0.002730 299.1800n -0.002784 299.1900n -0.002838 299.2000n -0.002890 299.2100n -0.002941 299.2200n -0.002991 299.2300n -0.003040 299.2400n -0.003088
+ 299.2500n -0.003134 299.2600n -0.003179 299.2700n -0.003223 299.2800n -0.003266 299.2900n -0.003307 299.3000n -0.003347 299.3100n -0.003386 299.3200n -0.003423 299.3300n -0.003459 299.3400n -0.003493 299.3500n -0.003526 299.3600n -0.003557 299.3700n -0.003587 299.3800n -0.003615 299.3900n -0.003641
+ 299.4000n -0.003666 299.4100n -0.003690 299.4200n -0.003712 299.4300n -0.003732 299.4400n -0.003750 299.4500n -0.003767 299.4600n -0.003783 299.4700n -0.003796 299.4800n -0.003808 299.4900n -0.003819 299.5000n -0.003827 299.5100n -0.003834 299.5200n -0.003839 299.5300n -0.003843 299.5400n -0.003845
+ 299.5500n -0.003845 299.5600n -0.003843 299.5700n -0.003840 299.5800n -0.003835 299.5900n -0.003829 299.6000n -0.003821 299.6100n -0.003811 299.6200n -0.003799 299.6300n -0.003786 299.6400n -0.003772 299.6500n -0.003755 299.6600n -0.003737 299.6700n -0.003718 299.6800n -0.003697 299.6900n -0.003674
+ 299.7000n -0.003650 299.7100n -0.003624 299.7200n -0.003597 299.7300n -0.003568 299.7400n -0.003538 299.7500n -0.003507 299.7600n -0.003474 299.7700n -0.003440 299.7800n -0.003404 299.7900n -0.003367 299.8000n -0.003329 299.8100n -0.003290 299.8200n -0.003249 299.8300n -0.003207 299.8400n -0.003164
+ 299.8500n -0.003120 299.8600n -0.003075 299.8700n -0.003029 299.8800n -0.002981 299.8900n -0.002933 299.9000n -0.002884 299.9100n -0.002834 299.9200n -0.002783 299.9300n -0.002731 299.9400n -0.002678 299.9500n -0.002625 299.9600n -0.002571 299.9700n -0.002516 299.9800n -0.002460 299.9900n -0.002404
+ 300.0000n -0.002348 300.0100n -0.002291 300.0200n -0.002233 300.0300n -0.002175 300.0400n -0.002117 300.0500n -0.002058 300.0600n -0.001999 300.0700n -0.001940 300.0800n -0.001880 300.0900n -0.001821 300.1000n -0.001761 300.1100n -0.001701 300.1200n -0.001641 300.1300n -0.001581 300.1400n -0.001522
+ 300.1500n -0.001462 300.1600n -0.001402 300.1700n -0.001343 300.1800n -0.001284 300.1900n -0.001225 300.2000n -0.001166 300.2100n -0.001108 300.2200n -0.001050 300.2300n -0.000993 300.2400n -0.000936 300.2500n -0.000879 300.2600n -0.000824 300.2700n -0.000768 300.2800n -0.000714 300.2900n -0.000660
+ 300.3000n -0.000606 300.3100n -0.000554 300.3200n -0.000502 300.3300n -0.000451 300.3400n -0.000401 300.3500n -0.000352 300.3600n -0.000304 300.3700n -0.000256 300.3800n -0.000210 300.3900n -0.000165 300.4000n -0.000120 300.4100n -0.000077 300.4200n -0.000035 300.4300n 0.000006 300.4400n 0.000046
+ 300.4500n 0.000085 300.4600n 0.000122 300.4700n 0.000159 300.4800n 0.000194 300.4900n 0.000228 300.5000n 0.000260 300.5100n 0.000291 300.5200n 0.000321 300.5300n 0.000350 300.5400n 0.000377 300.5500n 0.000403 300.5600n 0.000427 300.5700n 0.000450 300.5800n 0.000472 300.5900n 0.000492
+ 300.6000n 0.000511 300.6100n 0.000529 300.6200n 0.000545 300.6300n 0.000559 300.6400n 0.000573 300.6500n 0.000584 300.6600n 0.000594 300.6700n 0.000603 300.6800n 0.000611 300.6900n 0.000617 300.7000n 0.000621 300.7100n 0.000624 300.7200n 0.000626 300.7300n 0.000626 300.7400n 0.000625
+ 300.7500n 0.000622 300.7600n 0.000618 300.7700n 0.000613 300.7800n 0.000606 300.7900n 0.000598 300.8000n 0.000588 300.8100n 0.000578 300.8200n 0.000566 300.8300n 0.000552 300.8400n 0.000538 300.8500n 0.000522 300.8600n 0.000504 300.8700n 0.000486 300.8800n 0.000467 300.8900n 0.000446
+ 300.9000n 0.000424 300.9100n 0.000401 300.9200n 0.000377 300.9300n 0.000352 300.9400n 0.000325 300.9500n 0.000298 300.9600n 0.000270 300.9700n 0.000241 300.9800n 0.000211 300.9900n 0.000180 301.0000n 0.000148 301.0100n 0.000116 301.0200n 0.000082 301.0300n 0.000048 301.0400n 0.000013
+ 301.0500n -0.000023 301.0600n -0.000059 301.0700n -0.000096 301.0800n -0.000133 301.0900n -0.000171 301.1000n -0.000210 301.1100n -0.000249 301.1200n -0.000288 301.1300n -0.000328 301.1400n -0.000368 301.1500n -0.000409 301.1600n -0.000450 301.1700n -0.000491 301.1800n -0.000532 301.1900n -0.000573
+ 301.2000n -0.000615 301.2100n -0.000657 301.2200n -0.000698 301.2300n -0.000740 301.2400n -0.000782 301.2500n -0.000824 301.2600n -0.000865 301.2700n -0.000907 301.2800n -0.000948 301.2900n -0.000989 301.3000n -0.001030 301.3100n -0.001071 301.3200n -0.001111 301.3300n -0.001151 301.3400n -0.001190
+ 301.3500n -0.001230 301.3600n -0.001268 301.3700n -0.001306 301.3800n -0.001344 301.3900n -0.001381 301.4000n -0.001418 301.4100n -0.001454 301.4200n -0.001489 301.4300n -0.001524 301.4400n -0.001558 301.4500n -0.001591 301.4600n -0.001623 301.4700n -0.001655 301.4800n -0.001686 301.4900n -0.001716
+ 301.5000n -0.001745 301.5100n -0.001773 301.5200n -0.001800 301.5300n -0.001827 301.5400n -0.001852 301.5500n -0.001877 301.5600n -0.001900 301.5700n -0.001923 301.5800n -0.001944 301.5900n -0.001965 301.6000n -0.001984 301.6100n -0.002002 301.6200n -0.002019 301.6300n -0.002035 301.6400n -0.002050
+ 301.6500n -0.002064 301.6600n -0.002077 301.6700n -0.002088 301.6800n -0.002099 301.6900n -0.002108 301.7000n -0.002116 301.7100n -0.002123 301.7200n -0.002129 301.7300n -0.002133 301.7400n -0.002137 301.7500n -0.002139 301.7600n -0.002140 301.7700n -0.002140 301.7800n -0.002139 301.7900n -0.002137
+ 301.8000n -0.002133 301.8100n -0.002128 301.8200n -0.002122 301.8300n -0.002115 301.8400n -0.002107 301.8500n -0.002098 301.8600n -0.002088 301.8700n -0.002076 301.8800n -0.002064 301.8900n -0.002050 301.9000n -0.002036 301.9100n -0.002020 301.9200n -0.002003 301.9300n -0.001986 301.9400n -0.001967
+ 301.9500n -0.001947 301.9600n -0.001927 301.9700n -0.001905 301.9800n -0.001883 301.9900n -0.001860 302.0000n -0.001836 302.0100n -0.001811 302.0200n -0.001785 302.0300n -0.001759 302.0400n -0.001731 302.0500n -0.001703 302.0600n -0.001675 302.0700n -0.001645 302.0800n -0.001615 302.0900n -0.001585
+ 302.1000n -0.001554 302.1100n -0.001522 302.1200n -0.001490 302.1300n -0.001457 302.1400n -0.001424 302.1500n -0.001390 302.1600n -0.001356 302.1700n -0.001322 302.1800n -0.001287 302.1900n -0.001252 302.2000n -0.001216 302.2100n -0.001181 302.2200n -0.001145 302.2300n -0.001109 302.2400n -0.001073
+ 302.2500n -0.001037 302.2600n -0.001000 302.2700n -0.000964 302.2800n -0.000928 302.2900n -0.000891 302.3000n -0.000855 302.3100n -0.000819 302.3200n -0.000783 302.3300n -0.000747 302.3400n -0.000711 302.3500n -0.000676 302.3600n -0.000641 302.3700n -0.000606 302.3800n -0.000571 302.3900n -0.000537
+ 302.4000n -0.000503 302.4100n -0.000469 302.4200n -0.000436 302.4300n -0.000404 302.4400n -0.000372 302.4500n -0.000340 302.4600n -0.000309 302.4700n -0.000279 302.4800n -0.000249 302.4900n -0.000219 302.5000n -0.000191 302.5100n -0.000163 302.5200n -0.000136 302.5300n -0.000109 302.5400n -0.000083
+ 302.5500n -0.000058 302.5600n -0.000034 302.5700n -0.000011 302.5800n 0.000012 302.5900n 0.000034 302.6000n 0.000055 302.6100n 0.000075 302.6200n 0.000094 302.6300n 0.000112 302.6400n 0.000129 302.6500n 0.000146 302.6600n 0.000161 302.6700n 0.000175 302.6800n 0.000189 302.6900n 0.000201
+ 302.7000n 0.000213 302.7100n 0.000224 302.7200n 0.000233 302.7300n 0.000242 302.7400n 0.000249 302.7500n 0.000256 302.7600n 0.000261 302.7700n 0.000266 302.7800n 0.000269 302.7900n 0.000271 302.8000n 0.000273 302.8100n 0.000273 302.8200n 0.000272 302.8300n 0.000271 302.8400n 0.000268
+ 302.8500n 0.000264 302.8600n 0.000260 302.8700n 0.000254 302.8800n 0.000248 302.8900n 0.000240 302.9000n 0.000231 302.9100n 0.000222 302.9200n 0.000211 302.9300n 0.000200 302.9400n 0.000188 302.9500n 0.000175 302.9600n 0.000161 302.9700n 0.000146 302.9800n 0.000130 302.9900n 0.000114
+ 303.0000n 0.000096 303.0100n 0.000078 303.0200n 0.000059 303.0300n 0.000039 303.0400n 0.000019 303.0500n -0.000002 303.0600n -0.000024 303.0700n -0.000046 303.0800n -0.000069 303.0900n -0.000093 303.1000n -0.000117 303.1100n -0.000142 303.1200n -0.000167 303.1300n -0.000193 303.1400n -0.000219
+ 303.1500n -0.000246 303.1600n -0.000273 303.1700n -0.000301 303.1800n -0.000329 303.1900n -0.000357 303.2000n -0.000385 303.2100n -0.000414 303.2200n -0.000443 303.2300n -0.000473 303.2400n -0.000502 303.2500n -0.000531 303.2600n -0.000561 303.2700n -0.000591 303.2800n -0.000621 303.2900n -0.000651
+ 303.3000n -0.000680 303.3100n -0.000710 303.3200n -0.000740 303.3300n -0.000770 303.3400n -0.000799 303.3500n -0.000828 303.3600n -0.000858 303.3700n -0.000886 303.3800n -0.000915 303.3900n -0.000943 303.4000n -0.000971 303.4100n -0.000999 303.4200n -0.001026 303.4300n -0.001053 303.4400n -0.001080
+ 303.4500n -0.001106 303.4600n -0.001131 303.4700n -0.001156 303.4800n -0.001181 303.4900n -0.001205 303.5000n -0.001228 303.5100n -0.001250 303.5200n -0.001272 303.5300n -0.001294 303.5400n -0.001314 303.5500n -0.001334 303.5600n -0.001353 303.5700n -0.001372 303.5800n -0.001389 303.5900n -0.001406
+ 303.6000n -0.001422 303.6100n -0.001437 303.6200n -0.001451 303.6300n -0.001465 303.6400n -0.001477 303.6500n -0.001489 303.6600n -0.001499 303.6700n -0.001509 303.6800n -0.001518 303.6900n -0.001525 303.7000n -0.001532 303.7100n -0.001538 303.7200n -0.001542 303.7300n -0.001546 303.7400n -0.001549
+ 303.7500n -0.001550 303.7600n -0.001551 303.7700n -0.001550 303.7800n -0.001549 303.7900n -0.001546 303.8000n -0.001543 303.8100n -0.001538 303.8200n -0.001532 303.8300n -0.001525 303.8400n -0.001518 303.8500n -0.001509 303.8600n -0.001499 303.8700n -0.001488 303.8800n -0.001476 303.8900n -0.001462
+ 303.9000n -0.001448 303.9100n -0.001433 303.9200n -0.001417 303.9300n -0.001400 303.9400n -0.001382 303.9500n -0.001362 303.9600n -0.001342 303.9700n -0.001321 303.9800n -0.001299 303.9900n -0.001276 304.0000n -0.001252 304.0100n -0.001227 304.0200n -0.001201 304.0300n -0.001175 304.0400n -0.001147
+ 304.0500n -0.001119 304.0600n -0.001090 304.0700n -0.001060 304.0800n -0.001029 304.0900n -0.000998 304.1000n -0.000966 304.1100n -0.000933 304.1200n -0.000899 304.1300n -0.000865 304.1400n -0.000830 304.1500n -0.000795 304.1600n -0.000759 304.1700n -0.000723 304.1800n -0.000685 304.1900n -0.000648
+ 304.2000n -0.000610 304.2100n -0.000571 304.2200n -0.000533 304.2300n -0.000493 304.2400n -0.000454 304.2500n -0.000414 304.2600n -0.000374 304.2700n -0.000333 304.2800n -0.000293 304.2900n -0.000252 304.3000n -0.000211 304.3100n -0.000169 304.3200n -0.000128 304.3300n -0.000087 304.3400n -0.000046
+ 304.3500n -0.000004 304.3600n 0.000037 304.3700n 0.000078 304.3800n 0.000120 304.3900n 0.000161 304.4000n 0.000202 304.4100n 0.000242 304.4200n 0.000283 304.4300n 0.000323 304.4400n 0.000363 304.4500n 0.000403 304.4600n 0.000442 304.4700n 0.000481 304.4800n 0.000520 304.4900n 0.000558
+ 304.5000n 0.000595 304.5100n 0.000633 304.5200n 0.000669 304.5300n 0.000705 304.5400n 0.000741 304.5500n 0.000776 304.5600n 0.000810 304.5700n 0.000844 304.5800n 0.000877 304.5900n 0.000909 304.6000n 0.000940 304.6100n 0.000971 304.6200n 0.001001 304.6300n 0.001030 304.6400n 0.001058
+ 304.6500n 0.001086 304.6600n 0.001112 304.6700n 0.001138 304.6800n 0.001163 304.6900n 0.001187 304.7000n 0.001210 304.7100n 0.001231 304.7200n 0.001252 304.7300n 0.001272 304.7400n 0.001291 304.7500n 0.001309 304.7600n 0.001326 304.7700n 0.001342 304.7800n 0.001357 304.7900n 0.001370
+ 304.8000n 0.001383 304.8100n 0.001394 304.8200n 0.001405 304.8300n 0.001414 304.8400n 0.001422 304.8500n 0.001429 304.8600n 0.001435 304.8700n 0.001440 304.8800n 0.001444 304.8900n 0.001446 304.9000n 0.001447 304.9100n 0.001448 304.9200n 0.001447 304.9300n 0.001445 304.9400n 0.001442
+ 304.9500n 0.001437 304.9600n 0.001432 304.9700n 0.001425 304.9800n 0.001418 304.9900n 0.001409 305.0000n 0.001399 305.0100n 0.001388 305.0200n 0.001376 305.0300n 0.001363 305.0400n 0.001349 305.0500n 0.001334 305.0600n 0.001318 305.0700n 0.001301 305.0800n 0.001283 305.0900n 0.001263
+ 305.1000n 0.001243 305.1100n 0.001222 305.1200n 0.001200 305.1300n 0.001177 305.1400n 0.001154 305.1500n 0.001129 305.1600n 0.001103 305.1700n 0.001077 305.1800n 0.001050 305.1900n 0.001022 305.2000n 0.000993 305.2100n 0.000964 305.2200n 0.000934 305.2300n 0.000903 305.2400n 0.000871
+ 305.2500n 0.000839 305.2600n 0.000806 305.2700n 0.000773 305.2800n 0.000739 305.2900n 0.000705 305.3000n 0.000670 305.3100n 0.000634 305.3200n 0.000599 305.3300n 0.000562 305.3400n 0.000526 305.3500n 0.000489 305.3600n 0.000451 305.3700n 0.000414 305.3800n 0.000376 305.3900n 0.000338
+ 305.4000n 0.000299 305.4100n 0.000261 305.4200n 0.000222 305.4300n 0.000184 305.4400n 0.000145 305.4500n 0.000106 305.4600n 0.000067 305.4700n 0.000028 305.4800n -0.000010 305.4900n -0.000049 305.5000n -0.000088 305.5100n -0.000126 305.5200n -0.000165 305.5300n -0.000203 305.5400n -0.000241
+ 305.5500n -0.000278 305.5600n -0.000315 305.5700n -0.000352 305.5800n -0.000389 305.5900n -0.000425 305.6000n -0.000461 305.6100n -0.000497 305.6200n -0.000532 305.6300n -0.000566 305.6400n -0.000600 305.6500n -0.000633 305.6600n -0.000666 305.6700n -0.000699 305.6800n -0.000730 305.6900n -0.000761
+ 305.7000n -0.000791 305.7100n -0.000821 305.7200n -0.000850 305.7300n -0.000878 305.7400n -0.000906 305.7500n -0.000932 305.7600n -0.000958 305.7700n -0.000983 305.7800n -0.001007 305.7900n -0.001030 305.8000n -0.001053 305.8100n -0.001074 305.8200n -0.001095 305.8300n -0.001115 305.8400n -0.001133
+ 305.8500n -0.001151 305.8600n -0.001168 305.8700n -0.001184 305.8800n -0.001199 305.8900n -0.001213 305.9000n -0.001225 305.9100n -0.001237 305.9200n -0.001248 305.9300n -0.001258 305.9400n -0.001267 305.9500n -0.001274 305.9600n -0.001281 305.9700n -0.001286 305.9800n -0.001291 305.9900n -0.001294
+ 306.0000n -0.001296 306.0100n -0.001298 306.0200n -0.001298 306.0300n -0.001297 306.0400n -0.001295 306.0500n -0.001292 306.0600n -0.001288 306.0700n -0.001283 306.0800n -0.001276 306.0900n -0.001269 306.1000n -0.001261 306.1100n -0.001251 306.1200n -0.001241 306.1300n -0.001230 306.1400n -0.001217
+ 306.1500n -0.001204 306.1600n -0.001189 306.1700n -0.001174 306.1800n -0.001157 306.1900n -0.001140 306.2000n -0.001121 306.2100n -0.001102 306.2200n -0.001082 306.2300n -0.001061 306.2400n -0.001039 306.2500n -0.001016 306.2600n -0.000992 306.2700n -0.000967 306.2800n -0.000942 306.2900n -0.000916
+ 306.3000n -0.000888 306.3100n -0.000861 306.3200n -0.000832 306.3300n -0.000803 306.3400n -0.000773 306.3500n -0.000742 306.3600n -0.000711 306.3700n -0.000678 306.3800n -0.000646 306.3900n -0.000612 306.4000n -0.000579 306.4100n -0.000544 306.4200n -0.000509 306.4300n -0.000474 306.4400n -0.000438
+ 306.4500n -0.000401 306.4600n -0.000365 306.4700n -0.000327 306.4800n -0.000290 306.4900n -0.000252 306.5000n -0.000213 306.5100n -0.000175 306.5200n -0.000136 306.5300n -0.000096 306.5400n -0.000057 306.5500n -0.000017 306.5600n 0.000023 306.5700n 0.000063 306.5800n 0.000103 306.5900n 0.000143
+ 306.6000n 0.000184 306.6100n 0.000224 306.6200n 0.000264 306.6300n 0.000305 306.6400n 0.000345 306.6500n 0.000386 306.6600n 0.000426 306.6700n 0.000467 306.6800n 0.000507 306.6900n 0.000547 306.7000n 0.000587 306.7100n 0.000627 306.7200n 0.000666 306.7300n 0.000705 306.7400n 0.000744
+ 306.7500n 0.000783 306.7600n 0.000822 306.7700n 0.000860 306.7800n 0.000898 306.7900n 0.000935 306.8000n 0.000973 306.8100n 0.001009 306.8200n 0.001046 306.8300n 0.001082 306.8400n 0.001117 306.8500n 0.001152 306.8600n 0.001187 306.8700n 0.001221 306.8800n 0.001255 306.8900n 0.001288
+ 306.9000n 0.001320 306.9100n 0.001352 306.9200n 0.001384 306.9300n 0.001415 306.9400n 0.001445 306.9500n 0.001474 306.9600n 0.001503 306.9700n 0.001532 306.9800n 0.001560 306.9900n 0.001587 307.0000n 0.001613 307.0100n 0.001639 307.0200n 0.001664 307.0300n 0.001689 307.0400n 0.001712
+ 307.0500n 0.001735 307.0600n 0.001758 307.0700n 0.001779 307.0800n 0.001800 307.0900n 0.001821 307.1000n 0.001840 307.1100n 0.001859 307.1200n 0.001877 307.1300n 0.001894 307.1400n 0.001911 307.1500n 0.001927 307.1600n 0.001942 307.1700n 0.001957 307.1800n 0.001970 307.1900n 0.001983
+ 307.2000n 0.001996 307.2100n 0.002007 307.2200n 0.002018 307.2300n 0.002028 307.2400n 0.002038 307.2500n 0.002046 307.2600n 0.002054 307.2700n 0.002062 307.2800n 0.002069 307.2900n 0.002075 307.3000n 0.002080 307.3100n 0.002085 307.3200n 0.002089 307.3300n 0.002092 307.3400n 0.002095
+ 307.3500n 0.002097 307.3600n 0.002098 307.3700n 0.002099 307.3800n 0.002099 307.3900n 0.002099 307.4000n 0.002098 307.4100n 0.002097 307.4200n 0.002095 307.4300n 0.002092 307.4400n 0.002089 307.4500n 0.002086 307.4600n 0.002081 307.4700n 0.002077 307.4800n 0.002072 307.4900n 0.002066
+ 307.5000n 0.002060 307.5100n 0.002054 307.5200n 0.002047 307.5300n 0.002039 307.5400n 0.002032 307.5500n 0.002024 307.5600n 0.002015 307.5700n 0.002006 307.5800n 0.001997 307.5900n 0.001988 307.6000n 0.001978 307.6100n 0.001968 307.6200n 0.001957 307.6300n 0.001946 307.6400n 0.001935
+ 307.6500n 0.001924 307.6600n 0.001913 307.6700n 0.001901 307.6800n 0.001889 307.6900n 0.001877 307.7000n 0.001865 307.7100n 0.001852 307.7200n 0.001839 307.7300n 0.001827 307.7400n 0.001814 307.7500n 0.001801 307.7600n 0.001787 307.7700n 0.001774 307.7800n 0.001761 307.7900n 0.001747
+ 307.8000n 0.001734 307.8100n 0.001720 307.8200n 0.001707 307.8300n 0.001693 307.8400n 0.001680 307.8500n 0.001666 307.8600n 0.001652 307.8700n 0.001639 307.8800n 0.001625 307.8900n 0.001612 307.9000n 0.001598 307.9100n 0.001584 307.9200n 0.001571 307.9300n 0.001558 307.9400n 0.001544
+ 307.9500n 0.001531 307.9600n 0.001518 307.9700n 0.001505 307.9800n 0.001492 307.9900n 0.001479 308.0000n 0.001466 308.0100n 0.001453 308.0200n 0.001441 308.0300n 0.001428 308.0400n 0.001416 308.0500n 0.001404 308.0600n 0.001392 308.0700n 0.001380 308.0800n 0.001368 308.0900n 0.001356
+ 308.1000n 0.001344 308.1100n 0.001333 308.1200n 0.001321 308.1300n 0.001310 308.1400n 0.001299 308.1500n 0.001288 308.1600n 0.001277 308.1700n 0.001267 308.1800n 0.001256 308.1900n 0.001246 308.2000n 0.001235 308.2100n 0.001225 308.2200n 0.001215 308.2300n 0.001205 308.2400n 0.001195
+ 308.2500n 0.001185 308.2600n 0.001176 308.2700n 0.001166 308.2800n 0.001157 308.2900n 0.001147 308.3000n 0.001138 308.3100n 0.001129 308.3200n 0.001120 308.3300n 0.001111 308.3400n 0.001102 308.3500n 0.001093 308.3600n 0.001084 308.3700n 0.001075 308.3800n 0.001066 308.3900n 0.001058
+ 308.4000n 0.001049 308.4100n 0.001040 308.4200n 0.001031 308.4300n 0.001023 308.4400n 0.001014 308.4500n 0.001005 308.4600n 0.000997 308.4700n 0.000988 308.4800n 0.000979 308.4900n 0.000970 308.5000n 0.000961 308.5100n 0.000952 308.5200n 0.000943 308.5300n 0.000934 308.5400n 0.000925
+ 308.5500n 0.000916 308.5600n 0.000906 308.5700n 0.000897 308.5800n 0.000887 308.5900n 0.000877 308.6000n 0.000868 308.6100n 0.000858 308.6200n 0.000848 308.6300n 0.000837 308.6400n 0.000827 308.6500n 0.000816 308.6600n 0.000806 308.6700n 0.000795 308.6800n 0.000784 308.6900n 0.000772
+ 308.7000n 0.000761 308.7100n 0.000749 308.7200n 0.000737 308.7300n 0.000725 308.7400n 0.000713 308.7500n 0.000700 308.7600n 0.000688 308.7700n 0.000675 308.7800n 0.000661 308.7900n 0.000648 308.8000n 0.000634 308.8100n 0.000620 308.8200n 0.000606 308.8300n 0.000592 308.8400n 0.000577
+ 308.8500n 0.000562 308.8600n 0.000547 308.8700n 0.000532 308.8800n 0.000516 308.8900n 0.000500 308.9000n 0.000484 308.9100n 0.000467 308.9200n 0.000451 308.9300n 0.000434 308.9400n 0.000417 308.9500n 0.000399 308.9600n 0.000381 308.9700n 0.000363 308.9800n 0.000345 308.9900n 0.000327
+ 309.0000n 0.000308 309.0100n 0.000289 309.0200n 0.000270 309.0300n 0.000251 309.0400n 0.000231 309.0500n 0.000211 309.0600n 0.000191 309.0700n 0.000171 309.0800n 0.000151 309.0900n 0.000130 309.1000n 0.000109 309.1100n 0.000088 309.1200n 0.000067 309.1300n 0.000046 309.1400n 0.000024
+ 309.1500n 0.000003 309.1600n -0.000019 309.1700n -0.000041 309.1800n -0.000063 309.1900n -0.000085 309.2000n -0.000107 309.2100n -0.000130 309.2200n -0.000152 309.2300n -0.000175 309.2400n -0.000197 309.2500n -0.000220 309.2600n -0.000242 309.2700n -0.000265 309.2800n -0.000288 309.2900n -0.000310
+ 309.3000n -0.000333 309.3100n -0.000356 309.3200n -0.000378 309.3300n -0.000401 309.3400n -0.000423 309.3500n -0.000446 309.3600n -0.000468 309.3700n -0.000490 309.3800n -0.000513 309.3900n -0.000535 309.4000n -0.000556 309.4100n -0.000578 309.4200n -0.000600 309.4300n -0.000621 309.4400n -0.000642
+ 309.4500n -0.000663 309.4600n -0.000684 309.4700n -0.000705 309.4800n -0.000725 309.4900n -0.000745 309.5000n -0.000765 309.5100n -0.000784 309.5200n -0.000803 309.5300n -0.000822 309.5400n -0.000840 309.5500n -0.000859 309.5600n -0.000876 309.5700n -0.000894 309.5800n -0.000911 309.5900n -0.000928
+ 309.6000n -0.000944 309.6100n -0.000960 309.6200n -0.000975 309.6300n -0.000990 309.6400n -0.001005 309.6500n -0.001019 309.6600n -0.001032 309.6700n -0.001045 309.6800n -0.001058 309.6900n -0.001070 309.7000n -0.001081 309.7100n -0.001092 309.7200n -0.001103 309.7300n -0.001113 309.7400n -0.001122
+ 309.7500n -0.001131 309.7600n -0.001139 309.7700n -0.001147 309.7800n -0.001154 309.7900n -0.001161 309.8000n -0.001167 309.8100n -0.001172 309.8200n -0.001176 309.8300n -0.001181 309.8400n -0.001184 309.8500n -0.001187 309.8600n -0.001189 309.8700n -0.001190 309.8800n -0.001191 309.8900n -0.001191
+ 309.9000n -0.001191 309.9100n -0.001190 309.9200n -0.001188 309.9300n -0.001186 309.9400n -0.001183 309.9500n -0.001179 309.9600n -0.001175 309.9700n -0.001170 309.9800n -0.001164 309.9900n -0.001158 310.0000n -0.001151 310.0100n -0.001143 310.0200n -0.001135 310.0300n -0.001126 310.0400n -0.001116
+ 310.0500n -0.001106 310.0600n -0.001095 310.0700n -0.001083 310.0800n -0.001071 310.0900n -0.001059 310.1000n -0.001045 310.1100n -0.001031 310.1200n -0.001017 310.1300n -0.001001 310.1400n -0.000986 310.1500n -0.000969 310.1600n -0.000952 310.1700n -0.000935 310.1800n -0.000917 310.1900n -0.000898
+ 310.2000n -0.000879 310.2100n -0.000860 310.2200n -0.000840 310.2300n -0.000819 310.2400n -0.000798 310.2500n -0.000776 310.2600n -0.000754 310.2700n -0.000732 310.2800n -0.000709 310.2900n -0.000685 310.3000n -0.000662 310.3100n -0.000637 310.3200n -0.000613 310.3300n -0.000588 310.3400n -0.000563
+ 310.3500n -0.000537 310.3600n -0.000511 310.3700n -0.000485 310.3800n -0.000458 310.3900n -0.000431 310.4000n -0.000404 310.4100n -0.000377 310.4200n -0.000349 310.4300n -0.000321 310.4400n -0.000293 310.4500n -0.000265 310.4600n -0.000237 310.4700n -0.000208 310.4800n -0.000180 310.4900n -0.000151
+ 310.5000n -0.000122 310.5100n -0.000093 310.5200n -0.000064 310.5300n -0.000035 310.5400n -0.000006 310.5500n 0.000023 310.5600n 0.000052 310.5700n 0.000081 310.5800n 0.000110 310.5900n 0.000139 310.6000n 0.000168 310.6100n 0.000197 310.6200n 0.000226 310.6300n 0.000255 310.6400n 0.000283
+ 310.6500n 0.000311 310.6600n 0.000340 310.6700n 0.000368 310.6800n 0.000395 310.6900n 0.000423 310.7000n 0.000450 310.7100n 0.000478 310.7200n 0.000504 310.7300n 0.000531 310.7400n 0.000557 310.7500n 0.000583 310.7600n 0.000609 310.7700n 0.000634 310.7800n 0.000659 310.7900n 0.000684
+ 310.8000n 0.000708 310.8100n 0.000732 310.8200n 0.000756 310.8300n 0.000779 310.8400n 0.000802 310.8500n 0.000824 310.8600n 0.000846 310.8700n 0.000867 310.8800n 0.000888 310.8900n 0.000909 310.9000n 0.000929 310.9100n 0.000948 310.9200n 0.000967 310.9300n 0.000986 310.9400n 0.001004
+ 310.9500n 0.001021 310.9600n 0.001038 310.9700n 0.001055 310.9800n 0.001070 310.9900n 0.001086 311.0000n 0.001101 311.0100n 0.001115 311.0200n 0.001129 311.0300n 0.001142 311.0400n 0.001154 311.0500n 0.001166 311.0600n 0.001178 311.0700n 0.001189 311.0800n 0.001199 311.0900n 0.001209
+ 311.1000n 0.001218 311.1100n 0.001227 311.1200n 0.001235 311.1300n 0.001242 311.1400n 0.001249 311.1500n 0.001256 311.1600n 0.001261 311.1700n 0.001267 311.1800n 0.001271 311.1900n 0.001275 311.2000n 0.001279 311.2100n 0.001282 311.2200n 0.001284 311.2300n 0.001286 311.2400n 0.001288
+ 311.2500n 0.001288 311.2600n 0.001289 311.2700n 0.001289 311.2800n 0.001288 311.2900n 0.001287 311.3000n 0.001285 311.3100n 0.001283 311.3200n 0.001280 311.3300n 0.001277 311.3400n 0.001273 311.3500n 0.001269 311.3600n 0.001265 311.3700n 0.001260 311.3800n 0.001254 311.3900n 0.001249
+ 311.4000n 0.001242 311.4100n 0.001236 311.4200n 0.001229 311.4300n 0.001221 311.4400n 0.001214 311.4500n 0.001206 311.4600n 0.001197 311.4700n 0.001189 311.4800n 0.001180 311.4900n 0.001170 311.5000n 0.001161 311.5100n 0.001151 311.5200n 0.001141 311.5300n 0.001130 311.5400n 0.001120
+ 311.5500n 0.001109 311.5600n 0.001098 311.5700n 0.001086 311.5800n 0.001075 311.5900n 0.001063 311.6000n 0.001051 311.6100n 0.001040 311.6200n 0.001028 311.6300n 0.001015 311.6400n 0.001003 311.6500n 0.000991 311.6600n 0.000978 311.6700n 0.000966 311.6800n 0.000953 311.6900n 0.000941
+ 311.7000n 0.000928 311.7100n 0.000916 311.7200n 0.000903 311.7300n 0.000890 311.7400n 0.000878 311.7500n 0.000865 311.7600n 0.000853 311.7700n 0.000841 311.7800n 0.000828 311.7900n 0.000816 311.8000n 0.000804 311.8100n 0.000792 311.8200n 0.000780 311.8300n 0.000769 311.8400n 0.000757
+ 311.8500n 0.000746 311.8600n 0.000734 311.8700n 0.000723 311.8800n 0.000712 311.8900n 0.000702 311.9000n 0.000691 311.9100n 0.000681 311.9200n 0.000671 311.9300n 0.000662 311.9400n 0.000652 311.9500n 0.000643 311.9600n 0.000634 311.9700n 0.000625 311.9800n 0.000617 311.9900n 0.000609
+ 312.0000n 0.000601 312.0100n 0.000593 312.0200n 0.000586 312.0300n 0.000579 312.0400n 0.000573 312.0500n 0.000566 312.0600n 0.000560 312.0700n 0.000555 312.0800n 0.000549 312.0900n 0.000544 312.1000n 0.000540 312.1100n 0.000536 312.1200n 0.000532 312.1300n 0.000528 312.1400n 0.000525
+ 312.1500n 0.000522 312.1600n 0.000519 312.1700n 0.000517 312.1800n 0.000515 312.1900n 0.000514 312.2000n 0.000513 312.2100n 0.000512 312.2200n 0.000512 312.2300n 0.000512 312.2400n 0.000512 312.2500n 0.000513 312.2600n 0.000514 312.2700n 0.000515 312.2800n 0.000516 312.2900n 0.000518
+ 312.3000n 0.000521 312.3100n 0.000523 312.3200n 0.000526 312.3300n 0.000530 312.3400n 0.000533 312.3500n 0.000537 312.3600n 0.000541 312.3700n 0.000546 312.3800n 0.000550 312.3900n 0.000556 312.4000n 0.000561 312.4100n 0.000566 312.4200n 0.000572 312.4300n 0.000578 312.4400n 0.000585
+ 312.4500n 0.000591 312.4600n 0.000598 312.4700n 0.000605 312.4800n 0.000612 312.4900n 0.000620 312.5000n 0.000627 312.5100n 0.000635 312.5200n 0.000643 312.5300n 0.000651 312.5400n 0.000659 312.5500n 0.000668 312.5600n 0.000676 312.5700n 0.000685 312.5800n 0.000694 312.5900n 0.000703
+ 312.6000n 0.000712 312.6100n 0.000721 312.6200n 0.000730 312.6300n 0.000739 312.6400n 0.000749 312.6500n 0.000758 312.6600n 0.000767 312.6700n 0.000777 312.6800n 0.000786 312.6900n 0.000795 312.7000n 0.000805 312.7100n 0.000814 312.7200n 0.000823 312.7300n 0.000833 312.7400n 0.000842
+ 312.7500n 0.000851 312.7600n 0.000860 312.7700n 0.000869 312.7800n 0.000878 312.7900n 0.000886 312.8000n 0.000895 312.8100n 0.000903 312.8200n 0.000912 312.8300n 0.000920 312.8400n 0.000928 312.8500n 0.000936 312.8600n 0.000944 312.8700n 0.000951 312.8800n 0.000958 312.8900n 0.000965
+ 312.9000n 0.000972 312.9100n 0.000979 312.9200n 0.000985 312.9300n 0.000991 312.9400n 0.000997 312.9500n 0.001003 312.9600n 0.001008 312.9700n 0.001013 312.9800n 0.001018 312.9900n 0.001023 313.0000n 0.001027 313.0100n 0.001031 313.0200n 0.001034 313.0300n 0.001038 313.0400n 0.001041
+ 313.0500n 0.001043 313.0600n 0.001046 313.0700n 0.001048 313.0800n 0.001049 313.0900n 0.001050 313.1000n 0.001051 313.1100n 0.001052 313.1200n 0.001052 313.1300n 0.001052 313.1400n 0.001051 313.1500n 0.001050 313.1600n 0.001049 313.1700n 0.001047 313.1800n 0.001045 313.1900n 0.001043
+ 313.2000n 0.001040 313.2100n 0.001037 313.2200n 0.001033 313.2300n 0.001029 313.2400n 0.001025 313.2500n 0.001020 313.2600n 0.001015 313.2700n 0.001010 313.2800n 0.001004 313.2900n 0.000998 313.3000n 0.000991 313.3100n 0.000984 313.3200n 0.000977 313.3300n 0.000969 313.3400n 0.000961
+ 313.3500n 0.000952 313.3600n 0.000943 313.3700n 0.000934 313.3800n 0.000924 313.3900n 0.000914 313.4000n 0.000904 313.4100n 0.000893 313.4200n 0.000882 313.4300n 0.000871 313.4400n 0.000859 313.4500n 0.000847 313.4600n 0.000835 313.4700n 0.000822 313.4800n 0.000809 313.4900n 0.000796
+ 313.5000n 0.000782 313.5100n 0.000769 313.5200n 0.000754 313.5300n 0.000740 313.5400n 0.000725 313.5500n 0.000710 313.5600n 0.000695 313.5700n 0.000680 313.5800n 0.000664 313.5900n 0.000648 313.6000n 0.000632 313.6100n 0.000615 313.6200n 0.000599 313.6300n 0.000582 313.6400n 0.000565
+ 313.6500n 0.000548 313.6600n 0.000530 313.6700n 0.000513 313.6800n 0.000495 313.6900n 0.000477 313.7000n 0.000459 313.7100n 0.000441 313.7200n 0.000423 313.7300n 0.000405 313.7400n 0.000386 313.7500n 0.000368 313.7600n 0.000349 313.7700n 0.000330 313.7800n 0.000312 313.7900n 0.000293
+ 313.8000n 0.000274 313.8100n 0.000255 313.8200n 0.000236 313.8300n 0.000217 313.8400n 0.000198 313.8500n 0.000179 313.8600n 0.000160 313.8700n 0.000141 313.8800n 0.000123 313.8900n 0.000104 313.9000n 0.000085 313.9100n 0.000066 313.9200n 0.000048 313.9300n 0.000029 313.9400n 0.000010
+ 313.9500n -0.000008 313.9600n -0.000026 313.9700n -0.000045 313.9800n -0.000063 313.9900n -0.000081 314.0000n -0.000099 314.0100n -0.000116 314.0200n -0.000134 314.0300n -0.000151 314.0400n -0.000168 314.0500n -0.000186 314.0600n -0.000202 314.0700n -0.000219 314.0800n -0.000236 314.0900n -0.000252
+ 314.1000n -0.000268 314.1100n -0.000284 314.1200n -0.000299 314.1300n -0.000315 314.1400n -0.000330 314.1500n -0.000345 314.1600n -0.000360 314.1700n -0.000374 314.1800n -0.000388 314.1900n -0.000402 314.2000n -0.000416 314.2100n -0.000429 314.2200n -0.000442 314.2300n -0.000455 314.2400n -0.000468
+ 314.2500n -0.000480 314.2600n -0.000492 314.2700n -0.000504 314.2800n -0.000515 314.2900n -0.000526 314.3000n -0.000537 314.3100n -0.000547 314.3200n -0.000557 314.3300n -0.000567 314.3400n -0.000577 314.3500n -0.000586 314.3600n -0.000595 314.3700n -0.000603 314.3800n -0.000611 314.3900n -0.000619
+ 314.4000n -0.000627 314.4100n -0.000634 314.4200n -0.000641 314.4300n -0.000647 314.4400n -0.000654 314.4500n -0.000659 314.4600n -0.000665 314.4700n -0.000670 314.4800n -0.000675 314.4900n -0.000680 314.5000n -0.000684 314.5100n -0.000688 314.5200n -0.000691 314.5300n -0.000694 314.5400n -0.000697
+ 314.5500n -0.000700 314.5600n -0.000702 314.5700n -0.000704 314.5800n -0.000706 314.5900n -0.000707 314.6000n -0.000708 314.6100n -0.000709 314.6200n -0.000709 314.6300n -0.000709 314.6400n -0.000709 314.6500n -0.000708 314.6600n -0.000707 314.6700n -0.000706 314.6800n -0.000705 314.6900n -0.000703
+ 314.7000n -0.000701 314.7100n -0.000699 314.7200n -0.000696 314.7300n -0.000693 314.7400n -0.000690 314.7500n -0.000687 314.7600n -0.000683 314.7700n -0.000679 314.7800n -0.000675 314.7900n -0.000671 314.8000n -0.000666 314.8100n -0.000661 314.8200n -0.000656 314.8300n -0.000651 314.8400n -0.000645
+ 314.8500n -0.000640 314.8600n -0.000634 314.8700n -0.000627 314.8800n -0.000621 314.8900n -0.000614 314.9000n -0.000608 314.9100n -0.000601 314.9200n -0.000594 314.9300n -0.000586 314.9400n -0.000579 314.9500n -0.000571 314.9600n -0.000563 314.9700n -0.000555 314.9800n -0.000547 314.9900n -0.000539
+ 315.0000n -0.000531 315.0100n -0.000522 315.0200n -0.000514 315.0300n -0.000505 315.0400n -0.000496 315.0500n -0.000487 315.0600n -0.000478 315.0700n -0.000469 315.0800n -0.000460 315.0900n -0.000450 315.1000n -0.000441 315.1100n -0.000432 315.1200n -0.000422 315.1300n -0.000413 315.1400n -0.000403
+ 315.1500n -0.000393 315.1600n -0.000384 315.1700n -0.000374 315.1800n -0.000364 315.1900n -0.000354 315.2000n -0.000345 315.2100n -0.000335 315.2200n -0.000325 315.2300n -0.000315 315.2400n -0.000306 315.2500n -0.000296 315.2600n -0.000286 315.2700n -0.000276 315.2800n -0.000267 315.2900n -0.000257
+ 315.3000n -0.000247 315.3100n -0.000238 315.3200n -0.000228 315.3300n -0.000219 315.3400n -0.000210 315.3500n -0.000200 315.3600n -0.000191 315.3700n -0.000182 315.3800n -0.000173 315.3900n -0.000164 315.4000n -0.000155 315.4100n -0.000146 315.4200n -0.000138 315.4300n -0.000129 315.4400n -0.000121
+ 315.4500n -0.000113 315.4600n -0.000104 315.4700n -0.000096 315.4800n -0.000088 315.4900n -0.000081 315.5000n -0.000073 315.5100n -0.000066 315.5200n -0.000058 315.5300n -0.000051 315.5400n -0.000044 315.5500n -0.000038 315.5600n -0.000031 315.5700n -0.000025 315.5800n -0.000018 315.5900n -0.000012
+ 315.6000n -0.000006 315.6100n -0.000001 315.6200n 0.000005 315.6300n 0.000010 315.6400n 0.000015 315.6500n 0.000020 315.6600n 0.000024 315.6700n 0.000029 315.6800n 0.000033 315.6900n 0.000037 315.7000n 0.000041 315.7100n 0.000044 315.7200n 0.000047 315.7300n 0.000050 315.7400n 0.000053
+ 315.7500n 0.000056 315.7600n 0.000058 315.7700n 0.000060 315.7800n 0.000062 315.7900n 0.000063 315.8000n 0.000064 315.8100n 0.000065 315.8200n 0.000066 315.8300n 0.000067 315.8400n 0.000067 315.8500n 0.000067 315.8600n 0.000066 315.8700n 0.000066 315.8800n 0.000065 315.8900n 0.000063
+ 315.9000n 0.000062 315.9100n 0.000060 315.9200n 0.000058 315.9300n 0.000056 315.9400n 0.000053 315.9500n 0.000050 315.9600n 0.000047 315.9700n 0.000043 315.9800n 0.000039 315.9900n 0.000035 316.0000n 0.000031 316.0100n 0.000026 316.0200n 0.000021 316.0300n 0.000016 316.0400n 0.000010
+ 316.0500n 0.000004 316.0600n -0.000002 316.0700n -0.000008 316.0800n -0.000015 316.0900n -0.000022 316.1000n -0.000029 316.1100n -0.000037 316.1200n -0.000045 316.1300n -0.000053 316.1400n -0.000062 316.1500n -0.000071 316.1600n -0.000080 316.1700n -0.000089 316.1800n -0.000099 316.1900n -0.000109
+ 316.2000n -0.000119 316.2100n -0.000130 316.2200n -0.000140 316.2300n -0.000151 316.2400n -0.000163 316.2500n -0.000174 316.2600n -0.000186 316.2700n -0.000198 316.2800n -0.000211 316.2900n -0.000223 316.3000n -0.000236 316.3100n -0.000249 316.3200n -0.000263 316.3300n -0.000276 316.3400n -0.000290
+ 316.3500n -0.000304 316.3600n -0.000319 316.3700n -0.000333 316.3800n -0.000348 316.3900n -0.000363 316.4000n -0.000378 316.4100n -0.000393 316.4200n -0.000409 316.4300n -0.000425 316.4400n -0.000441 316.4500n -0.000457 316.4600n -0.000473 316.4700n -0.000489 316.4800n -0.000506 316.4900n -0.000523
+ 316.5000n -0.000540 316.5100n -0.000557 316.5200n -0.000574 316.5300n -0.000591 316.5400n -0.000609 316.5500n -0.000626 316.5600n -0.000644 316.5700n -0.000661 316.5800n -0.000679 316.5900n -0.000697 316.6000n -0.000715 316.6100n -0.000733 316.6200n -0.000751 316.6300n -0.000769 316.6400n -0.000787
+ 316.6500n -0.000805 316.6600n -0.000823 316.6700n -0.000842 316.6800n -0.000860 316.6900n -0.000878 316.7000n -0.000896 316.7100n -0.000914 316.7200n -0.000932 316.7300n -0.000950 316.7400n -0.000968 316.7500n -0.000986 316.7600n -0.001004 316.7700n -0.001021 316.7800n -0.001039 316.7900n -0.001056
+ 316.8000n -0.001074 316.8100n -0.001091 316.8200n -0.001108 316.8300n -0.001125 316.8400n -0.001142 316.8500n -0.001158 316.8600n -0.001175 316.8700n -0.001191 316.8800n -0.001207 316.8900n -0.001223 316.9000n -0.001238 316.9100n -0.001254 316.9200n -0.001269 316.9300n -0.001283 316.9400n -0.001298
+ 316.9500n -0.001312 316.9600n -0.001326 316.9700n -0.001340 316.9800n -0.001353 316.9900n -0.001366 317.0000n -0.001379 317.0100n -0.001391 317.0200n -0.001403 317.0300n -0.001415 317.0400n -0.001426 317.0500n -0.001437 317.0600n -0.001448 317.0700n -0.001458 317.0800n -0.001467 317.0900n -0.001477
+ 317.1000n -0.001486 317.1100n -0.001494 317.1200n -0.001502 317.1300n -0.001509 317.1400n -0.001517 317.1500n -0.001523 317.1600n -0.001529 317.1700n -0.001535 317.1800n -0.001540 317.1900n -0.001545 317.2000n -0.001549 317.2100n -0.001552 317.2200n -0.001555 317.2300n -0.001558 317.2400n -0.001560
+ 317.2500n -0.001561 317.2600n -0.001562 317.2700n -0.001563 317.2800n -0.001562 317.2900n -0.001562 317.3000n -0.001560 317.3100n -0.001558 317.3200n -0.001556 317.3300n -0.001553 317.3400n -0.001549 317.3500n -0.001545 317.3600n -0.001540 317.3700n -0.001534 317.3800n -0.001528 317.3900n -0.001522
+ 317.4000n -0.001514 317.4100n -0.001507 317.4200n -0.001498 317.4300n -0.001489 317.4400n -0.001479 317.4500n -0.001469 317.4600n -0.001458 317.4700n -0.001447 317.4800n -0.001435 317.4900n -0.001422 317.5000n -0.001409 317.5100n -0.001395 317.5200n -0.001380 317.5300n -0.001365 317.5400n -0.001349
+ 317.5500n -0.001333 317.5600n -0.001316 317.5700n -0.001299 317.5800n -0.001281 317.5900n -0.001262 317.6000n -0.001243 317.6100n -0.001223 317.6200n -0.001203 317.6300n -0.001182 317.6400n -0.001161 317.6500n -0.001139 317.6600n -0.001116 317.6700n -0.001093 317.6800n -0.001070 317.6900n -0.001046
+ 317.7000n -0.001021 317.7100n -0.000996 317.7200n -0.000971 317.7300n -0.000945 317.7400n -0.000919 317.7500n -0.000892 317.7600n -0.000865 317.7700n -0.000837 317.7800n -0.000809 317.7900n -0.000780 317.8000n -0.000751 317.8100n -0.000722 317.8200n -0.000693 317.8300n -0.000663 317.8400n -0.000632
+ 317.8500n -0.000602 317.8600n -0.000571 317.8700n -0.000540 317.8800n -0.000508 317.8900n -0.000476 317.9000n -0.000444 317.9100n -0.000412 317.9200n -0.000380 317.9300n -0.000347 317.9400n -0.000314 317.9500n -0.000281 317.9600n -0.000248 317.9700n -0.000215 317.9800n -0.000181 317.9900n -0.000148
+ 318.0000n -0.000114 318.0100n -0.000080 318.0200n -0.000046 318.0300n -0.000013 318.0400n 0.000021 318.0500n 0.000055 318.0600n 0.000089 318.0700n 0.000123 318.0800n 0.000157 318.0900n 0.000190 318.1000n 0.000224 318.1100n 0.000257 318.1200n 0.000291 318.1300n 0.000324 318.1400n 0.000357
+ 318.1500n 0.000390 318.1600n 0.000423 318.1700n 0.000455 318.1800n 0.000488 318.1900n 0.000520 318.2000n 0.000551 318.2100n 0.000583 318.2200n 0.000614 318.2300n 0.000645 318.2400n 0.000676 318.2500n 0.000706 318.2600n 0.000736 318.2700n 0.000765 318.2800n 0.000794 318.2900n 0.000823
+ 318.3000n 0.000851 318.3100n 0.000879 318.3200n 0.000906 318.3300n 0.000933 318.3400n 0.000960 318.3500n 0.000985 318.3600n 0.001011 318.3700n 0.001036 318.3800n 0.001060 318.3900n 0.001084 318.4000n 0.001107 318.4100n 0.001129 318.4200n 0.001151 318.4300n 0.001172 318.4400n 0.001193
+ 318.4500n 0.001213 318.4600n 0.001232 318.4700n 0.001251 318.4800n 0.001269 318.4900n 0.001286 318.5000n 0.001303 318.5100n 0.001319 318.5200n 0.001334 318.5300n 0.001349 318.5400n 0.001363 318.5500n 0.001376 318.5600n 0.001388 318.5700n 0.001399 318.5800n 0.001410 318.5900n 0.001420
+ 318.6000n 0.001429 318.6100n 0.001438 318.6200n 0.001445 318.6300n 0.001452 318.6400n 0.001458 318.6500n 0.001463 318.6600n 0.001468 318.6700n 0.001471 318.6800n 0.001474 318.6900n 0.001476 318.7000n 0.001478 318.7100n 0.001478 318.7200n 0.001478 318.7300n 0.001476 318.7400n 0.001474
+ 318.7500n 0.001471 318.7600n 0.001468 318.7700n 0.001463 318.7800n 0.001458 318.7900n 0.001452 318.8000n 0.001445 318.8100n 0.001438 318.8200n 0.001429 318.8300n 0.001420 318.8400n 0.001410 318.8500n 0.001399 318.8600n 0.001388 318.8700n 0.001376 318.8800n 0.001363 318.8900n 0.001349
+ 318.9000n 0.001334 318.9100n 0.001319 318.9200n 0.001303 318.9300n 0.001287 318.9400n 0.001269 318.9500n 0.001251 318.9600n 0.001233 318.9700n 0.001214 318.9800n 0.001194 318.9900n 0.001173 319.0000n 0.001152 319.0100n 0.001130 319.0200n 0.001108 319.0300n 0.001085 319.0400n 0.001061
+ 319.0500n 0.001037 319.0600n 0.001012 319.0700n 0.000987 319.0800n 0.000962 319.0900n 0.000936 319.1000n 0.000909 319.1100n 0.000882 319.1200n 0.000854 319.1300n 0.000827 319.1400n 0.000798 319.1500n 0.000769 319.1600n 0.000740 319.1700n 0.000711 319.1800n 0.000681 319.1900n 0.000651
+ 319.2000n 0.000621 319.2100n 0.000590 319.2200n 0.000559 319.2300n 0.000528 319.2400n 0.000497 319.2500n 0.000465 319.2600n 0.000433 319.2700n 0.000402 319.2800n 0.000369 319.2900n 0.000337 319.3000n 0.000305 319.3100n 0.000273 319.3200n 0.000240 319.3300n 0.000208 319.3400n 0.000175
+ 319.3500n 0.000143 319.3600n 0.000110 319.3700n 0.000078 319.3800n 0.000045 319.3900n 0.000013 319.4000n -0.000019 319.4100n -0.000051 319.4200n -0.000083 319.4300n -0.000115 319.4400n -0.000147 319.4500n -0.000178 319.4600n -0.000209 319.4700n -0.000241 319.4800n -0.000271 319.4900n -0.000302
+ 319.5000n -0.000332 319.5100n -0.000362 319.5200n -0.000392 319.5300n -0.000421 319.5400n -0.000450 319.5500n -0.000479 319.5600n -0.000507 319.5700n -0.000535 319.5800n -0.000562 319.5900n -0.000589 319.6000n -0.000616 319.6100n -0.000642 319.6200n -0.000668 319.6300n -0.000693 319.6400n -0.000718
+ 319.6500n -0.000742 319.6600n -0.000766 319.6700n -0.000789 319.6800n -0.000811 319.6900n -0.000833 319.7000n -0.000855 319.7100n -0.000876 319.7200n -0.000896 319.7300n -0.000916 319.7400n -0.000935 319.7500n -0.000953 319.7600n -0.000971 319.7700n -0.000988 319.7800n -0.001005 319.7900n -0.001021
+ 319.8000n -0.001036 319.8100n -0.001051 319.8200n -0.001065 319.8300n -0.001078 319.8400n -0.001090 319.8500n -0.001102 319.8600n -0.001114 319.8700n -0.001124 319.8800n -0.001134 319.8900n -0.001143 319.9000n -0.001152 319.9100n -0.001159 319.9200n -0.001167 319.9300n -0.001173 319.9400n -0.001179
+ 319.9500n -0.001184 319.9600n -0.001188 319.9700n -0.001191 319.9800n -0.001194 319.9900n -0.001197 320.0000n -0.001198 320.0100n -0.001199 320.0200n -0.001199 320.0300n -0.001199 320.0400n -0.001197 320.0500n -0.001196 320.0600n -0.001193 320.0700n -0.001190 320.0800n -0.001186 320.0900n -0.001182
+ 320.1000n -0.001177 320.1100n -0.001171 320.1200n -0.001165 320.1300n -0.001158 320.1400n -0.001150 320.1500n -0.001142 320.1600n -0.001133 320.1700n -0.001124 320.1800n -0.001114 320.1900n -0.001104 320.2000n -0.001093 320.2100n -0.001081 320.2200n -0.001069 320.2300n -0.001057 320.2400n -0.001044
+ 320.2500n -0.001031 320.2600n -0.001017 320.2700n -0.001002 320.2800n -0.000988 320.2900n -0.000972 320.3000n -0.000957 320.3100n -0.000941 320.3200n -0.000924 320.3300n -0.000907 320.3400n -0.000890 320.3500n -0.000873 320.3600n -0.000855 320.3700n -0.000837 320.3800n -0.000818 320.3900n -0.000799
+ 320.4000n -0.000780 320.4100n -0.000761 320.4200n -0.000741 320.4300n -0.000722 320.4400n -0.000702 320.4500n -0.000682 320.4600n -0.000661 320.4700n -0.000641 320.4800n -0.000620 320.4900n -0.000599 320.5000n -0.000578 320.5100n -0.000557 320.5200n -0.000536 320.5300n -0.000515 320.5400n -0.000494
+ 320.5500n -0.000473 320.5600n -0.000451 320.5700n -0.000430 320.5800n -0.000409 320.5900n -0.000387 320.6000n -0.000366 320.6100n -0.000345 320.6200n -0.000324 320.6300n -0.000302 320.6400n -0.000281 320.6500n -0.000260 320.6600n -0.000240 320.6700n -0.000219 320.6800n -0.000198 320.6900n -0.000178
+ 320.7000n -0.000158 320.7100n -0.000138 320.7200n -0.000118 320.7300n -0.000098 320.7400n -0.000079 320.7500n -0.000059 320.7600n -0.000040 320.7700n -0.000022 320.7800n -0.000003 320.7900n 0.000015 320.8000n 0.000033 320.8100n 0.000051 320.8200n 0.000068 320.8300n 0.000086 320.8400n 0.000102
+ 320.8500n 0.000119 320.8600n 0.000135 320.8700n 0.000151 320.8800n 0.000167 320.8900n 0.000182 320.9000n 0.000197 320.9100n 0.000211 320.9200n 0.000225 320.9300n 0.000239 320.9400n 0.000253 320.9500n 0.000266 320.9600n 0.000278 320.9700n 0.000291 320.9800n 0.000302 320.9900n 0.000314
+ 321.0000n 0.000325 321.0100n 0.000336 321.0200n 0.000346 321.0300n 0.000356 321.0400n 0.000366 321.0500n 0.000375 321.0600n 0.000384 321.0700n 0.000392 321.0800n 0.000400 321.0900n 0.000408 321.1000n 0.000415 321.1100n 0.000422 321.1200n 0.000428 321.1300n 0.000434 321.1400n 0.000440
+ 321.1500n 0.000445 321.1600n 0.000450 321.1700n 0.000454 321.1800n 0.000458 321.1900n 0.000462 321.2000n 0.000465 321.2100n 0.000468 321.2200n 0.000471 321.2300n 0.000473 321.2400n 0.000475 321.2500n 0.000477 321.2600n 0.000478 321.2700n 0.000479 321.2800n 0.000480 321.2900n 0.000480
+ 321.3000n 0.000480 321.3100n 0.000480 321.3200n 0.000479 321.3300n 0.000478 321.3400n 0.000477 321.3500n 0.000475 321.3600n 0.000474 321.3700n 0.000472 321.3800n 0.000469 321.3900n 0.000467 321.4000n 0.000464 321.4100n 0.000461 321.4200n 0.000458 321.4300n 0.000454 321.4400n 0.000451
+ 321.4500n 0.000447 321.4600n 0.000443 321.4700n 0.000438 321.4800n 0.000434 321.4900n 0.000429 321.5000n 0.000425 321.5100n 0.000420 321.5200n 0.000415 321.5300n 0.000410 321.5400n 0.000404 321.5500n 0.000399 321.5600n 0.000394 321.5700n 0.000388 321.5800n 0.000382 321.5900n 0.000377
+ 321.6000n 0.000371 321.6100n 0.000365 321.6200n 0.000359 321.6300n 0.000353 321.6400n 0.000347 321.6500n 0.000341 321.6600n 0.000334 321.6700n 0.000328 321.6800n 0.000322 321.6900n 0.000316 321.7000n 0.000310 321.7100n 0.000304 321.7200n 0.000298 321.7300n 0.000291 321.7400n 0.000285
+ 321.7500n 0.000279 321.7600n 0.000273 321.7700n 0.000267 321.7800n 0.000261 321.7900n 0.000255 321.8000n 0.000250 321.8100n 0.000244 321.8200n 0.000238 321.8300n 0.000233 321.8400n 0.000227 321.8500n 0.000222 321.8600n 0.000216 321.8700n 0.000211 321.8800n 0.000206 321.8900n 0.000200
+ 321.9000n 0.000195 321.9100n 0.000191 321.9200n 0.000186 321.9300n 0.000181 321.9400n 0.000176 321.9500n 0.000172 321.9600n 0.000167 321.9700n 0.000163 321.9800n 0.000159 321.9900n 0.000155 322.0000n 0.000151 322.0100n 0.000147 322.0200n 0.000143 322.0300n 0.000139 322.0400n 0.000136
+ 322.0500n 0.000132 322.0600n 0.000129 322.0700n 0.000125 322.0800n 0.000122 322.0900n 0.000119 322.1000n 0.000116 322.1100n 0.000113 322.1200n 0.000110 322.1300n 0.000107 322.1400n 0.000105 322.1500n 0.000102 322.1600n 0.000100 322.1700n 0.000097 322.1800n 0.000095 322.1900n 0.000092
+ 322.2000n 0.000090 322.2100n 0.000088 322.2200n 0.000085 322.2300n 0.000083 322.2400n 0.000081 322.2500n 0.000079 322.2600n 0.000077 322.2700n 0.000075 322.2800n 0.000073 322.2900n 0.000071 322.3000n 0.000069 322.3100n 0.000067 322.3200n 0.000065 322.3300n 0.000063 322.3400n 0.000061
+ 322.3500n 0.000059 322.3600n 0.000056 322.3700n 0.000054 322.3800n 0.000052 322.3900n 0.000050 322.4000n 0.000048 322.4100n 0.000045 322.4200n 0.000043 322.4300n 0.000040 322.4400n 0.000038 322.4500n 0.000035 322.4600n 0.000032 322.4700n 0.000029 322.4800n 0.000026 322.4900n 0.000023
+ 322.5000n 0.000020 322.5100n 0.000017 322.5200n 0.000014 322.5300n 0.000010 322.5400n 0.000006 322.5500n 0.000003 322.5600n -0.000001 322.5700n -0.000005 322.5800n -0.000010 322.5900n -0.000014 322.6000n -0.000019 322.6100n -0.000023 322.6200n -0.000028 322.6300n -0.000033 322.6400n -0.000038
+ 322.6500n -0.000044 322.6600n -0.000049 322.6700n -0.000055 322.6800n -0.000061 322.6900n -0.000067 322.7000n -0.000073 322.7100n -0.000080 322.7200n -0.000087 322.7300n -0.000093 322.7400n -0.000100 322.7500n -0.000108 322.7600n -0.000115 322.7700n -0.000123 322.7800n -0.000130 322.7900n -0.000138
+ 322.8000n -0.000147 322.8100n -0.000155 322.8200n -0.000163 322.8300n -0.000172 322.8400n -0.000181 322.8500n -0.000190 322.8600n -0.000199 322.8700n -0.000209 322.8800n -0.000218 322.8900n -0.000228 322.9000n -0.000238 322.9100n -0.000248 322.9200n -0.000258 322.9300n -0.000268 322.9400n -0.000279
+ 322.9500n -0.000290 322.9600n -0.000300 322.9700n -0.000311 322.9800n -0.000322 322.9900n -0.000333 323.0000n -0.000344 323.0100n -0.000356 323.0200n -0.000367 323.0300n -0.000378 323.0400n -0.000390 323.0500n -0.000401 323.0600n -0.000413 323.0700n -0.000425 323.0800n -0.000436 323.0900n -0.000448
+ 323.1000n -0.000460 323.1100n -0.000471 323.1200n -0.000483 323.1300n -0.000495 323.1400n -0.000506 323.1500n -0.000518 323.1600n -0.000529 323.1700n -0.000541 323.1800n -0.000552 323.1900n -0.000563 323.2000n -0.000575 323.2100n -0.000586 323.2200n -0.000597 323.2300n -0.000607 323.2400n -0.000618
+ 323.2500n -0.000629 323.2600n -0.000639 323.2700n -0.000649 323.2800n -0.000659 323.2900n -0.000669 323.3000n -0.000678 323.3100n -0.000687 323.3200n -0.000696 323.3300n -0.000705 323.3400n -0.000714 323.3500n -0.000722 323.3600n -0.000730 323.3700n -0.000737 323.3800n -0.000744 323.3900n -0.000751
+ 323.4000n -0.000758 323.4100n -0.000764 323.4200n -0.000770 323.4300n -0.000775 323.4400n -0.000780 323.4500n -0.000785 323.4600n -0.000789 323.4700n -0.000793 323.4800n -0.000796 323.4900n -0.000799 323.5000n -0.000801 323.5100n -0.000803 323.5200n -0.000804 323.5300n -0.000805 323.5400n -0.000806
+ 323.5500n -0.000805 323.5600n -0.000805 323.5700n -0.000803 323.5800n -0.000802 323.5900n -0.000799 323.6000n -0.000796 323.6100n -0.000793 323.6200n -0.000789 323.6300n -0.000784 323.6400n -0.000779 323.6500n -0.000773 323.6600n -0.000766 323.6700n -0.000759 323.6800n -0.000752 323.6900n -0.000743
+ 323.7000n -0.000734 323.7100n -0.000725 323.7200n -0.000714 323.7300n -0.000703 323.7400n -0.000692 323.7500n -0.000680 323.7600n -0.000667 323.7700n -0.000653 323.7800n -0.000639 323.7900n -0.000624 323.8000n -0.000609 323.8100n -0.000593 323.8200n -0.000576 323.8300n -0.000559 323.8400n -0.000541
+ 323.8500n -0.000522 323.8600n -0.000503 323.8700n -0.000483 323.8800n -0.000462 323.8900n -0.000441 323.9000n -0.000419 323.9100n -0.000397 323.9200n -0.000374 323.9300n -0.000350 323.9400n -0.000326 323.9500n -0.000301 323.9600n -0.000275 323.9700n -0.000250 323.9800n -0.000223 323.9900n -0.000196
+ 324.0000n -0.000168 324.0100n -0.000140 324.0200n -0.000112 324.0300n -0.000082 324.0400n -0.000053 324.0500n -0.000023 324.0600n 0.000008 324.0700n 0.000039 324.0800n 0.000070 324.0900n 0.000102 324.1000n 0.000134 324.1100n 0.000167 324.1200n 0.000200 324.1300n 0.000233 324.1400n 0.000267
+ 324.1500n 0.000301 324.1600n 0.000335 324.1700n 0.000370 324.1800n 0.000405 324.1900n 0.000440 324.2000n 0.000475 324.2100n 0.000511 324.2200n 0.000547 324.2300n 0.000582 324.2400n 0.000618 324.2500n 0.000655 324.2600n 0.000691 324.2700n 0.000727 324.2800n 0.000763 324.2900n 0.000800
+ 324.3000n 0.000836 324.3100n 0.000873 324.3200n 0.000909 324.3300n 0.000945 324.3400n 0.000981 324.3500n 0.001018 324.3600n 0.001054 324.3700n 0.001089 324.3800n 0.001125 324.3900n 0.001160 324.4000n 0.001196 324.4100n 0.001231 324.4200n 0.001265 324.4300n 0.001300 324.4400n 0.001334
+ 324.4500n 0.001368 324.4600n 0.001401 324.4700n 0.001434 324.4800n 0.001466 324.4900n 0.001499 324.5000n 0.001530 324.5100n 0.001561 324.5200n 0.001592 324.5300n 0.001622 324.5400n 0.001652 324.5500n 0.001681 324.5600n 0.001709 324.5700n 0.001737 324.5800n 0.001764 324.5900n 0.001791
+ 324.6000n 0.001816 324.6100n 0.001842 324.6200n 0.001866 324.6300n 0.001890 324.6400n 0.001912 324.6500n 0.001934 324.6600n 0.001956 324.6700n 0.001976 324.6800n 0.001996 324.6900n 0.002014 324.7000n 0.002032 324.7100n 0.002049 324.7200n 0.002065 324.7300n 0.002080 324.7400n 0.002095
+ 324.7500n 0.002108 324.7600n 0.002120 324.7700n 0.002131 324.7800n 0.002142 324.7900n 0.002151 324.8000n 0.002159 324.8100n 0.002166 324.8200n 0.002173 324.8300n 0.002178 324.8400n 0.002182 324.8500n 0.002185 324.8600n 0.002187 324.8700n 0.002187 324.8800n 0.002187 324.8900n 0.002186
+ 324.9000n 0.002183 324.9100n 0.002179 324.9200n 0.002175 324.9300n 0.002169 324.9400n 0.002162 324.9500n 0.002154 324.9600n 0.002145 324.9700n 0.002134 324.9800n 0.002123 324.9900n 0.002110 325.0000n 0.002096 325.0100n 0.002082 325.0200n 0.002066 325.0300n 0.002049 325.0400n 0.002030
+ 325.0500n 0.002011 325.0600n 0.001991 325.0700n 0.001969 325.0800n 0.001947 325.0900n 0.001923 325.1000n 0.001898 325.1100n 0.001873 325.1200n 0.001846 325.1300n 0.001818 325.1400n 0.001789 325.1500n 0.001759 325.1600n 0.001729 325.1700n 0.001697 325.1800n 0.001664 325.1900n 0.001630
+ 325.2000n 0.001596 325.2100n 0.001560 325.2200n 0.001524 325.2300n 0.001486 325.2400n 0.001448 325.2500n 0.001409 325.2600n 0.001369 325.2700n 0.001329 325.2800n 0.001287 325.2900n 0.001245 325.3000n 0.001202 325.3100n 0.001158 325.3200n 0.001114 325.3300n 0.001069 325.3400n 0.001023
+ 325.3500n 0.000977 325.3600n 0.000930 325.3700n 0.000883 325.3800n 0.000835 325.3900n 0.000786 325.4000n 0.000737 325.4100n 0.000688 325.4200n 0.000638 325.4300n 0.000588 325.4400n 0.000537 325.4500n 0.000486 325.4600n 0.000435 325.4700n 0.000384 325.4800n 0.000332 325.4900n 0.000280
+ 325.5000n 0.000227 325.5100n 0.000175 325.5200n 0.000122 325.5300n 0.000070 325.5400n 0.000017 325.5500n -0.000036 325.5600n -0.000088 325.5700n -0.000141 325.5800n -0.000194 325.5900n -0.000247 325.6000n -0.000299 325.6100n -0.000352 325.6200n -0.000404 325.6300n -0.000456 325.6400n -0.000508
+ 325.6500n -0.000559 325.6600n -0.000610 325.6700n -0.000661 325.6800n -0.000712 325.6900n -0.000762 325.7000n -0.000812 325.7100n -0.000861 325.7200n -0.000910 325.7300n -0.000958 325.7400n -0.001006 325.7500n -0.001054 325.7600n -0.001100 325.7700n -0.001146 325.7800n -0.001192 325.7900n -0.001237
+ 325.8000n -0.001281 325.8100n -0.001324 325.8200n -0.001367 325.8300n -0.001408 325.8400n -0.001450 325.8500n -0.001490 325.8600n -0.001529 325.8700n -0.001568 325.8800n -0.001605 325.8900n -0.001642 325.9000n -0.001678 325.9100n -0.001713 325.9200n -0.001747 325.9300n -0.001780 325.9400n -0.001812
+ 325.9500n -0.001843 325.9600n -0.001872 325.9700n -0.001901 325.9800n -0.001929 325.9900n -0.001956 326.0000n -0.001981 326.0100n -0.002005 326.0200n -0.002029 326.0300n -0.002051 326.0400n -0.002072 326.0500n -0.002092 326.0600n -0.002110 326.0700n -0.002128 326.0800n -0.002144 326.0900n -0.002159
+ 326.1000n -0.002173 326.1100n -0.002186 326.1200n -0.002197 326.1300n -0.002207 326.1400n -0.002216 326.1500n -0.002224 326.1600n -0.002230 326.1700n -0.002236 326.1800n -0.002240 326.1900n -0.002243 326.2000n -0.002244 326.2100n -0.002245 326.2200n -0.002244 326.2300n -0.002242 326.2400n -0.002238
+ 326.2500n -0.002234 326.2600n -0.002228 326.2700n -0.002221 326.2800n -0.002213 326.2900n -0.002204 326.3000n -0.002193 326.3100n -0.002181 326.3200n -0.002168 326.3300n -0.002154 326.3400n -0.002139 326.3500n -0.002123 326.3600n -0.002106 326.3700n -0.002087 326.3800n -0.002068 326.3900n -0.002047
+ 326.4000n -0.002026 326.4100n -0.002003 326.4200n -0.001979 326.4300n -0.001955 326.4400n -0.001929 326.4500n -0.001902 326.4600n -0.001875 326.4700n -0.001847 326.4800n -0.001817 326.4900n -0.001787 326.5000n -0.001756 326.5100n -0.001724 326.5200n -0.001691 326.5300n -0.001658 326.5400n -0.001624
+ 326.5500n -0.001589 326.5600n -0.001553 326.5700n -0.001517 326.5800n -0.001480 326.5900n -0.001442 326.6000n -0.001404 326.6100n -0.001365 326.6200n -0.001326 326.6300n -0.001286 326.6400n -0.001245 326.6500n -0.001205 326.6600n -0.001163 326.6700n -0.001122 326.6800n -0.001080 326.6900n -0.001037
+ 326.7000n -0.000994 326.7100n -0.000951 326.7200n -0.000908 326.7300n -0.000865 326.7400n -0.000821 326.7500n -0.000777 326.7600n -0.000733 326.7700n -0.000689 326.7800n -0.000644 326.7900n -0.000600 326.8000n -0.000556 326.8100n -0.000511 326.8200n -0.000467 326.8300n -0.000422 326.8400n -0.000378
+ 326.8500n -0.000334 326.8600n -0.000290 326.8700n -0.000246 326.8800n -0.000203 326.8900n -0.000159 326.9000n -0.000116 326.9100n -0.000073 326.9200n -0.000031 326.9300n 0.000012 326.9400n 0.000054 326.9500n 0.000095 326.9600n 0.000136 326.9700n 0.000177 326.9800n 0.000217 326.9900n 0.000257
+ 327.0000n 0.000296 327.0100n 0.000335 327.0200n 0.000373 327.0300n 0.000411 327.0400n 0.000448 327.0500n 0.000484 327.0600n 0.000520 327.0700n 0.000555 327.0800n 0.000590 327.0900n 0.000624 327.1000n 0.000657 327.1100n 0.000689 327.1200n 0.000721 327.1300n 0.000751 327.1400n 0.000782
+ 327.1500n 0.000811 327.1600n 0.000839 327.1700n 0.000867 327.1800n 0.000894 327.1900n 0.000920 327.2000n 0.000945 327.2100n 0.000969 327.2200n 0.000993 327.2300n 0.001015 327.2400n 0.001037 327.2500n 0.001058 327.2600n 0.001078 327.2700n 0.001097 327.2800n 0.001115 327.2900n 0.001132
+ 327.3000n 0.001148 327.3100n 0.001163 327.3200n 0.001177 327.3300n 0.001191 327.3400n 0.001203 327.3500n 0.001215 327.3600n 0.001225 327.3700n 0.001235 327.3800n 0.001243 327.3900n 0.001251 327.4000n 0.001258 327.4100n 0.001263 327.4200n 0.001268 327.4300n 0.001272 327.4400n 0.001275
+ 327.4500n 0.001277 327.4600n 0.001278 327.4700n 0.001278 327.4800n 0.001278 327.4900n 0.001276 327.5000n 0.001274 327.5100n 0.001270 327.5200n 0.001266 327.5300n 0.001261 327.5400n 0.001255 327.5500n 0.001249 327.5600n 0.001241 327.5700n 0.001233 327.5800n 0.001223 327.5900n 0.001214
+ 327.6000n 0.001203 327.6100n 0.001191 327.6200n 0.001179 327.6300n 0.001166 327.6400n 0.001153 327.6500n 0.001138 327.6600n 0.001123 327.6700n 0.001107 327.6800n 0.001091 327.6900n 0.001074 327.7000n 0.001057 327.7100n 0.001038 327.7200n 0.001020 327.7300n 0.001001 327.7400n 0.000981
+ 327.7500n 0.000960 327.7600n 0.000940 327.7700n 0.000918 327.7800n 0.000897 327.7900n 0.000874 327.8000n 0.000852 327.8100n 0.000829 327.8200n 0.000805 327.8300n 0.000782 327.8400n 0.000758 327.8500n 0.000733 327.8600n 0.000709 327.8700n 0.000684 327.8800n 0.000659 327.8900n 0.000633
+ 327.9000n 0.000608 327.9100n 0.000582 327.9200n 0.000556 327.9300n 0.000530 327.9400n 0.000503 327.9500n 0.000477 327.9600n 0.000451 327.9700n 0.000424 327.9800n 0.000398 327.9900n 0.000371 328.0000n 0.000344 328.0100n 0.000318 328.0200n 0.000291 328.0300n 0.000265 328.0400n 0.000238
+ 328.0500n 0.000212 328.0600n 0.000186 328.0700n 0.000160 328.0800n 0.000134 328.0900n 0.000108 328.1000n 0.000082 328.1100n 0.000057 328.1200n 0.000031 328.1300n 0.000006 328.1400n -0.000019 328.1500n -0.000043 328.1600n -0.000067 328.1700n -0.000092 328.1800n -0.000115 328.1900n -0.000139
+ 328.2000n -0.000162 328.2100n -0.000185 328.2200n -0.000207 328.2300n -0.000229 328.2400n -0.000251 328.2500n -0.000272 328.2600n -0.000294 328.2700n -0.000314 328.2800n -0.000334 328.2900n -0.000354 328.3000n -0.000374 328.3100n -0.000393 328.3200n -0.000411 328.3300n -0.000429 328.3400n -0.000447
+ 328.3500n -0.000464 328.3600n -0.000481 328.3700n -0.000498 328.3800n -0.000514 328.3900n -0.000529 328.4000n -0.000544 328.4100n -0.000559 328.4200n -0.000573 328.4300n -0.000586 328.4400n -0.000600 328.4500n -0.000612 328.4600n -0.000625 328.4700n -0.000637 328.4800n -0.000648 328.4900n -0.000659
+ 328.5000n -0.000669 328.5100n -0.000679 328.5200n -0.000689 328.5300n -0.000698 328.5400n -0.000707 328.5500n -0.000715 328.5600n -0.000723 328.5700n -0.000730 328.5800n -0.000737 328.5900n -0.000744 328.6000n -0.000750 328.6100n -0.000756 328.6200n -0.000762 328.6300n -0.000767 328.6400n -0.000772
+ 328.6500n -0.000776 328.6600n -0.000780 328.6700n -0.000784 328.6800n -0.000787 328.6900n -0.000791 328.7000n -0.000793 328.7100n -0.000796 328.7200n -0.000798 328.7300n -0.000800 328.7400n -0.000802 328.7500n -0.000804 328.7600n -0.000805 328.7700n -0.000806 328.7800n -0.000807 328.7900n -0.000808
+ 328.8000n -0.000808 328.8100n -0.000809 328.8200n -0.000809 328.8300n -0.000809 328.8400n -0.000809 328.8500n -0.000809 328.8600n -0.000809 328.8700n -0.000809 328.8800n -0.000808 328.8900n -0.000808 328.9000n -0.000807 328.9100n -0.000807 328.9200n -0.000807 328.9300n -0.000806 328.9400n -0.000806
+ 328.9500n -0.000805 328.9600n -0.000805 328.9700n -0.000805 328.9800n -0.000805 328.9900n -0.000805 329.0000n -0.000805 329.0100n -0.000805 329.0200n -0.000805 329.0300n -0.000805 329.0400n -0.000806 329.0500n -0.000806 329.0600n -0.000807 329.0700n -0.000808 329.0800n -0.000809 329.0900n -0.000811
+ 329.1000n -0.000813 329.1100n -0.000814 329.1200n -0.000817 329.1300n -0.000819 329.1400n -0.000821 329.1500n -0.000824 329.1600n -0.000827 329.1700n -0.000831 329.1800n -0.000835 329.1900n -0.000839 329.2000n -0.000843 329.2100n -0.000847 329.2200n -0.000852 329.2300n -0.000858 329.2400n -0.000863
+ 329.2500n -0.000869 329.2600n -0.000875 329.2700n -0.000882 329.2800n -0.000888 329.2900n -0.000896 329.3000n -0.000903 329.3100n -0.000911 329.3200n -0.000919 329.3300n -0.000928 329.3400n -0.000937 329.3500n -0.000946 329.3600n -0.000956 329.3700n -0.000965 329.3800n -0.000976 329.3900n -0.000986
+ 329.4000n -0.000997 329.4100n -0.001008 329.4200n -0.001020 329.4300n -0.001032 329.4400n -0.001044 329.4500n -0.001057 329.4600n -0.001069 329.4700n -0.001083 329.4800n -0.001096 329.4900n -0.001110 329.5000n -0.001124 329.5100n -0.001138 329.5200n -0.001152 329.5300n -0.001167 329.5400n -0.001182
+ 329.5500n -0.001197 329.5600n -0.001212 329.5700n -0.001228 329.5800n -0.001244 329.5900n -0.001260 329.6000n -0.001276 329.6100n -0.001292 329.6200n -0.001308 329.6300n -0.001325 329.6400n -0.001342 329.6500n -0.001358 329.6600n -0.001375 329.6700n -0.001392 329.6800n -0.001409 329.6900n -0.001426
+ 329.7000n -0.001443 329.7100n -0.001460 329.7200n -0.001477 329.7300n -0.001494 329.7400n -0.001511 329.7500n -0.001528 329.7600n -0.001545 329.7700n -0.001561 329.7800n -0.001578 329.7900n -0.001594 329.8000n -0.001610 329.8100n -0.001626 329.8200n -0.001642 329.8300n -0.001658 329.8400n -0.001674
+ 329.8500n -0.001689 329.8600n -0.001704 329.8700n -0.001718 329.8800n -0.001733 329.8900n -0.001747 329.9000n -0.001761 329.9100n -0.001774 329.9200n -0.001787 329.9300n -0.001799 329.9400n -0.001812 329.9500n -0.001823 329.9600n -0.001835 329.9700n -0.001845 329.9800n -0.001856 329.9900n -0.001866
+ 330.0000n -0.001875 330.0100n -0.001884 330.0200n -0.001892 330.0300n -0.001900 330.0400n -0.001907 330.0500n -0.001913 330.0600n -0.001919 330.0700n -0.001924 330.0800n -0.001929 330.0900n -0.001933 330.1000n -0.001936 330.1100n -0.001938 330.1200n -0.001940 330.1300n -0.001941 330.1400n -0.001942
+ 330.1500n -0.001941 330.1600n -0.001940 330.1700n -0.001938 330.1800n -0.001936 330.1900n -0.001932 330.2000n -0.001928 330.2100n -0.001923 330.2200n -0.001917 330.2300n -0.001910 330.2400n -0.001903 330.2500n -0.001894 330.2600n -0.001885 330.2700n -0.001875 330.2800n -0.001864 330.2900n -0.001852
+ 330.3000n -0.001840 330.3100n -0.001826 330.3200n -0.001812 330.3300n -0.001796 330.3400n -0.001780 330.3500n -0.001763 330.3600n -0.001745 330.3700n -0.001727 330.3800n -0.001707 330.3900n -0.001686 330.4000n -0.001665 330.4100n -0.001643 330.4200n -0.001620 330.4300n -0.001596 330.4400n -0.001571
+ 330.4500n -0.001545 330.4600n -0.001518 330.4700n -0.001491 330.4800n -0.001463 330.4900n -0.001434 330.5000n -0.001404 330.5100n -0.001373 330.5200n -0.001342 330.5300n -0.001309 330.5400n -0.001276 330.5500n -0.001243 330.5600n -0.001208 330.5700n -0.001173 330.5800n -0.001137 330.5900n -0.001100
+ 330.6000n -0.001063 330.6100n -0.001025 330.6200n -0.000986 330.6300n -0.000947 330.6400n -0.000907 330.6500n -0.000866 330.6600n -0.000825 330.6700n -0.000783 330.6800n -0.000741 330.6900n -0.000698 330.7000n -0.000655 330.7100n -0.000611 330.7200n -0.000567 330.7300n -0.000522 330.7400n -0.000477
+ 330.7500n -0.000432 330.7600n -0.000386 330.7700n -0.000339 330.7800n -0.000293 330.7900n -0.000246 330.8000n -0.000199 330.8100n -0.000152 330.8200n -0.000104 330.8300n -0.000056 330.8400n -0.000008 330.8500n 0.000040 330.8600n 0.000088 330.8700n 0.000136 330.8800n 0.000185 330.8900n 0.000233
+ 330.9000n 0.000281 330.9100n 0.000330 330.9200n 0.000378 330.9300n 0.000426 330.9400n 0.000474 330.9500n 0.000523 330.9600n 0.000570 330.9700n 0.000618 330.9800n 0.000665 330.9900n 0.000713 331.0000n 0.000760 331.0100n 0.000806 331.0200n 0.000853 331.0300n 0.000899 331.0400n 0.000944
+ 331.0500n 0.000989 331.0600n 0.001034 331.0700n 0.001078 331.0800n 0.001122 331.0900n 0.001165 331.1000n 0.001208 331.1100n 0.001250 331.1200n 0.001292 331.1300n 0.001333 331.1400n 0.001373 331.1500n 0.001413 331.1600n 0.001452 331.1700n 0.001490 331.1800n 0.001527 331.1900n 0.001564
+ 331.2000n 0.001600 331.2100n 0.001635 331.2200n 0.001669 331.2300n 0.001703 331.2400n 0.001735 331.2500n 0.001767 331.2600n 0.001798 331.2700n 0.001828 331.2800n 0.001857 331.2900n 0.001884 331.3000n 0.001911 331.3100n 0.001937 331.3200n 0.001962 331.3300n 0.001986 331.3400n 0.002009
+ 331.3500n 0.002031 331.3600n 0.002051 331.3700n 0.002071 331.3800n 0.002089 331.3900n 0.002107 331.4000n 0.002123 331.4100n 0.002138 331.4200n 0.002152 331.4300n 0.002165 331.4400n 0.002177 331.4500n 0.002187 331.4600n 0.002196 331.4700n 0.002205 331.4800n 0.002211 331.4900n 0.002217
+ 331.5000n 0.002222 331.5100n 0.002225 331.5200n 0.002228 331.5300n 0.002229 331.5400n 0.002228 331.5500n 0.002227 331.5600n 0.002225 331.5700n 0.002221 331.5800n 0.002216 331.5900n 0.002210 331.6000n 0.002203 331.6100n 0.002194 331.6200n 0.002185 331.6300n 0.002174 331.6400n 0.002162
+ 331.6500n 0.002149 331.6600n 0.002135 331.6700n 0.002120 331.6800n 0.002104 331.6900n 0.002086 331.7000n 0.002068 331.7100n 0.002049 331.7200n 0.002028 331.7300n 0.002006 331.7400n 0.001984 331.7500n 0.001960 331.7600n 0.001936 331.7700n 0.001910 331.7800n 0.001884 331.7900n 0.001856
+ 331.8000n 0.001828 331.8100n 0.001799 331.8200n 0.001769 331.8300n 0.001738 331.8400n 0.001706 331.8500n 0.001674 331.8600n 0.001641 331.8700n 0.001607 331.8800n 0.001572 331.8900n 0.001536 331.9000n 0.001500 331.9100n 0.001464 331.9200n 0.001426 331.9300n 0.001388 331.9400n 0.001350
+ 331.9500n 0.001311 331.9600n 0.001271 331.9700n 0.001231 331.9800n 0.001191 331.9900n 0.001150 332.0000n 0.001109 332.0100n 0.001067 332.0200n 0.001025 332.0300n 0.000983 332.0400n 0.000940 332.0500n 0.000897 332.0600n 0.000854 332.0700n 0.000811 332.0800n 0.000768 332.0900n 0.000724
+ 332.1000n 0.000681 332.1100n 0.000637 332.1200n 0.000594 332.1300n 0.000550 332.1400n 0.000506 332.1500n 0.000463 332.1600n 0.000420 332.1700n 0.000376 332.1800n 0.000333 332.1900n 0.000290 332.2000n 0.000247 332.2100n 0.000205 332.2200n 0.000163 332.2300n 0.000121 332.2400n 0.000079
+ 332.2500n 0.000038 332.2600n -0.000003 332.2700n -0.000043 332.2800n -0.000083 332.2900n -0.000122 332.3000n -0.000161 332.3100n -0.000200 332.3200n -0.000238 332.3300n -0.000275 332.3400n -0.000311 332.3500n -0.000347 332.3600n -0.000383 332.3700n -0.000417 332.3800n -0.000451 332.3900n -0.000485
+ 332.4000n -0.000517 332.4100n -0.000549 332.4200n -0.000580 332.4300n -0.000610 332.4400n -0.000639 332.4500n -0.000667 332.4600n -0.000695 332.4700n -0.000721 332.4800n -0.000747 332.4900n -0.000772 332.5000n -0.000795 332.5100n -0.000818 332.5200n -0.000840 332.5300n -0.000861 332.5400n -0.000881
+ 332.5500n -0.000900 332.5600n -0.000917 332.5700n -0.000934 332.5800n -0.000950 332.5900n -0.000965 332.6000n -0.000978 332.6100n -0.000991 332.6200n -0.001002 332.6300n -0.001013 332.6400n -0.001022 332.6500n -0.001030 332.6600n -0.001037 332.6700n -0.001043 332.6800n -0.001048 332.6900n -0.001052
+ 332.7000n -0.001055 332.7100n -0.001056 332.7200n -0.001057 332.7300n -0.001056 332.7400n -0.001054 332.7500n -0.001051 332.7600n -0.001048 332.7700n -0.001043 332.7800n -0.001036 332.7900n -0.001029 332.8000n -0.001021 332.8100n -0.001012 332.8200n -0.001002 332.8300n -0.000990 332.8400n -0.000978
+ 332.8500n -0.000965 332.8600n -0.000950 332.8700n -0.000935 332.8800n -0.000919 332.8900n -0.000902 332.9000n -0.000883 332.9100n -0.000864 332.9200n -0.000844 332.9300n -0.000823 332.9400n -0.000802 332.9500n -0.000779 332.9600n -0.000756 332.9700n -0.000731 332.9800n -0.000706 332.9900n -0.000681
+ 333.0000n -0.000654 333.0100n -0.000627 333.0200n -0.000599 333.0300n -0.000570 333.0400n -0.000541 333.0500n -0.000511 333.0600n -0.000480 333.0700n -0.000449 333.0800n -0.000417 333.0900n -0.000385 333.1000n -0.000352 333.1100n -0.000319 333.1200n -0.000285 333.1300n -0.000251 333.1400n -0.000217
+ 333.1500n -0.000182 333.1600n -0.000147 333.1700n -0.000111 333.1800n -0.000075 333.1900n -0.000039 333.2000n -0.000003 333.2100n 0.000034 333.2200n 0.000070 333.2300n 0.000107 333.2400n 0.000144 333.2500n 0.000181 333.2600n 0.000218 333.2700n 0.000255 333.2800n 0.000293 333.2900n 0.000330
+ 333.3000n 0.000367 333.3100n 0.000404 333.3200n 0.000440 333.3300n 0.000477 333.3400n 0.000514 333.3500n 0.000550 333.3600n 0.000586 333.3700n 0.000622 333.3800n 0.000658 333.3900n 0.000693 333.4000n 0.000728 333.4100n 0.000762 333.4200n 0.000796 333.4300n 0.000830 333.4400n 0.000863
+ 333.4500n 0.000896 333.4600n 0.000929 333.4700n 0.000960 333.4800n 0.000992 333.4900n 0.001022 333.5000n 0.001053 333.5100n 0.001082 333.5200n 0.001111 333.5300n 0.001139 333.5400n 0.001167 333.5500n 0.001194 333.5600n 0.001220 333.5700n 0.001246 333.5800n 0.001270 333.5900n 0.001294
+ 333.6000n 0.001317 333.6100n 0.001340 333.6200n 0.001361 333.6300n 0.001382 333.6400n 0.001402 333.6500n 0.001421 333.6600n 0.001439 333.6700n 0.001456 333.6800n 0.001473 333.6900n 0.001488 333.7000n 0.001503 333.7100n 0.001517 333.7200n 0.001529 333.7300n 0.001541 333.7400n 0.001552
+ 333.7500n 0.001562 333.7600n 0.001571 333.7700n 0.001579 333.7800n 0.001586 333.7900n 0.001592 333.8000n 0.001597 333.8100n 0.001601 333.8200n 0.001604 333.8300n 0.001606 333.8400n 0.001607 333.8500n 0.001607 333.8600n 0.001606 333.8700n 0.001604 333.8800n 0.001602 333.8900n 0.001598
+ 333.9000n 0.001593 333.9100n 0.001587 333.9200n 0.001581 333.9300n 0.001573 333.9400n 0.001565 333.9500n 0.001555 333.9600n 0.001545 333.9700n 0.001534 333.9800n 0.001522 333.9900n 0.001509 334.0000n 0.001495 334.0100n 0.001480 334.0200n 0.001464 334.0300n 0.001448 334.0400n 0.001431
+ 334.0500n 0.001413 334.0600n 0.001394 334.0700n 0.001374 334.0800n 0.001354 334.0900n 0.001333 334.1000n 0.001311 334.1100n 0.001289 334.1200n 0.001266 334.1300n 0.001242 334.1400n 0.001217 334.1500n 0.001192 334.1600n 0.001167 334.1700n 0.001140 334.1800n 0.001114 334.1900n 0.001086
+ 334.2000n 0.001059 334.2100n 0.001030 334.2200n 0.001002 334.2300n 0.000972 334.2400n 0.000943 334.2500n 0.000913 334.2600n 0.000882 334.2700n 0.000852 334.2800n 0.000821 334.2900n 0.000789 334.3000n 0.000758 334.3100n 0.000726 334.3200n 0.000694 334.3300n 0.000662 334.3400n 0.000629
+ 334.3500n 0.000597 334.3600n 0.000564 334.3700n 0.000532 334.3800n 0.000499 334.3900n 0.000466 334.4000n 0.000433 334.4100n 0.000401 334.4200n 0.000368 334.4300n 0.000335 334.4400n 0.000303 334.4500n 0.000270 334.4600n 0.000238 334.4700n 0.000206 334.4800n 0.000174 334.4900n 0.000142
+ 334.5000n 0.000111 334.5100n 0.000079 334.5200n 0.000049 334.5300n 0.000018 334.5400n -0.000012 334.5500n -0.000042 334.5600n -0.000072 334.5700n -0.000101 334.5800n -0.000129 334.5900n -0.000158 334.6000n -0.000185 334.6100n -0.000213 334.6200n -0.000239 334.6300n -0.000266 334.6400n -0.000291
+ 334.6500n -0.000316 334.6600n -0.000341 334.6700n -0.000365 334.6800n -0.000388 334.6900n -0.000411 334.7000n -0.000433 334.7100n -0.000454 334.7200n -0.000475 334.7300n -0.000495 334.7400n -0.000514 334.7500n -0.000532 334.7600n -0.000550 334.7700n -0.000567 334.7800n -0.000583 334.7900n -0.000599
+ 334.8000n -0.000614 334.8100n -0.000627 334.8200n -0.000641 334.8300n -0.000653 334.8400n -0.000664 334.8500n -0.000675 334.8600n -0.000685 334.8700n -0.000694 334.8800n -0.000702 334.8900n -0.000710 334.9000n -0.000716 334.9100n -0.000722 334.9200n -0.000727 334.9300n -0.000731 334.9400n -0.000734
+ 334.9500n -0.000736 334.9600n -0.000738 334.9700n -0.000738 334.9800n -0.000738 334.9900n -0.000737 335.0000n -0.000735 335.0100n -0.000733 335.0200n -0.000729 335.0300n -0.000725 335.0400n -0.000720 335.0500n -0.000714 335.0600n -0.000707 335.0700n -0.000699 335.0800n -0.000691 335.0900n -0.000682
+ 335.1000n -0.000672 335.1100n -0.000662 335.1200n -0.000651 335.1300n -0.000639 335.1400n -0.000626 335.1500n -0.000613 335.1600n -0.000598 335.1700n -0.000584 335.1800n -0.000568 335.1900n -0.000552 335.2000n -0.000536 335.2100n -0.000519 335.2200n -0.000501 335.2300n -0.000482 335.2400n -0.000463
+ 335.2500n -0.000444 335.2600n -0.000424 335.2700n -0.000403 335.2800n -0.000383 335.2900n -0.000361 335.3000n -0.000339 335.3100n -0.000317 335.3200n -0.000294 335.3300n -0.000271 335.3400n -0.000248 335.3500n -0.000224 335.3600n -0.000200 335.3700n -0.000176 335.3800n -0.000151 335.3900n -0.000127
+ 335.4000n -0.000102 335.4100n -0.000076 335.4200n -0.000051 335.4300n -0.000025 335.4400n 0.000000 335.4500n 0.000026 335.4600n 0.000052 335.4700n 0.000078 335.4800n 0.000104 335.4900n 0.000130 335.5000n 0.000156 335.5100n 0.000182 335.5200n 0.000208 335.5300n 0.000234 335.5400n 0.000259
+ 335.5500n 0.000285 335.5600n 0.000311 335.5700n 0.000336 335.5800n 0.000361 335.5900n 0.000386 335.6000n 0.000411 335.6100n 0.000435 335.6200n 0.000459 335.6300n 0.000483 335.6400n 0.000507 335.6500n 0.000530 335.6600n 0.000553 335.6700n 0.000576 335.6800n 0.000598 335.6900n 0.000620
+ 335.7000n 0.000641 335.7100n 0.000662 335.7200n 0.000683 335.7300n 0.000703 335.7400n 0.000722 335.7500n 0.000741 335.7600n 0.000760 335.7700n 0.000778 335.7800n 0.000795 335.7900n 0.000812 335.8000n 0.000829 335.8100n 0.000844 335.8200n 0.000859 335.8300n 0.000874 335.8400n 0.000888
+ 335.8500n 0.000901 335.8600n 0.000914 335.8700n 0.000926 335.8800n 0.000937 335.8900n 0.000948 335.9000n 0.000958 335.9100n 0.000967 335.9200n 0.000976 335.9300n 0.000983 335.9400n 0.000991 335.9500n 0.000997 335.9600n 0.001003 335.9700n 0.001008 335.9800n 0.001012 335.9900n 0.001016
+ 336.0000n 0.001019 336.0100n 0.001021 336.0200n 0.001023 336.0300n 0.001023 336.0400n 0.001023 336.0500n 0.001023 336.0600n 0.001021 336.0700n 0.001019 336.0800n 0.001017 336.0900n 0.001013 336.1000n 0.001009 336.1100n 0.001004 336.1200n 0.000998 336.1300n 0.000992 336.1400n 0.000985
+ 336.1500n 0.000978 336.1600n 0.000970 336.1700n 0.000961 336.1800n 0.000951 336.1900n 0.000941 336.2000n 0.000930 336.2100n 0.000919 336.2200n 0.000907 336.2300n 0.000895 336.2400n 0.000882 336.2500n 0.000868 336.2600n 0.000854 336.2700n 0.000839 336.2800n 0.000824 336.2900n 0.000808
+ 336.3000n 0.000792 336.3100n 0.000775 336.3200n 0.000758 336.3300n 0.000741 336.3400n 0.000723 336.3500n 0.000705 336.3600n 0.000686 336.3700n 0.000667 336.3800n 0.000648 336.3900n 0.000628 336.4000n 0.000608 336.4100n 0.000588 336.4200n 0.000567 336.4300n 0.000546 336.4400n 0.000525
+ 336.4500n 0.000504 336.4600n 0.000483 336.4700n 0.000461 336.4800n 0.000440 336.4900n 0.000418 336.5000n 0.000396 336.5100n 0.000374 336.5200n 0.000352 336.5300n 0.000330 336.5400n 0.000308 336.5500n 0.000286 336.5600n 0.000264 336.5700n 0.000242 336.5800n 0.000220 336.5900n 0.000198
+ 336.6000n 0.000176 336.6100n 0.000155 336.6200n 0.000133 336.6300n 0.000112 336.6400n 0.000091 336.6500n 0.000070 336.6600n 0.000049 336.6700n 0.000029 336.6800n 0.000009 336.6900n -0.000011 336.7000n -0.000030 336.7100n -0.000050 336.7200n -0.000068 336.7300n -0.000087 336.7400n -0.000105
+ 336.7500n -0.000122 336.7600n -0.000140 336.7700n -0.000156 336.7800n -0.000173 336.7900n -0.000188 336.8000n -0.000204 336.8100n -0.000219 336.8200n -0.000233 336.8300n -0.000247 336.8400n -0.000260 336.8500n -0.000273 336.8600n -0.000285 336.8700n -0.000296 336.8800n -0.000307 336.8900n -0.000317
+ 336.9000n -0.000327 336.9100n -0.000336 336.9200n -0.000344 336.9300n -0.000352 336.9400n -0.000359 336.9500n -0.000365 336.9600n -0.000371 336.9700n -0.000376 336.9800n -0.000380 336.9900n -0.000384 337.0000n -0.000387 337.0100n -0.000389 337.0200n -0.000390 337.0300n -0.000391 337.0400n -0.000391
+ 337.0500n -0.000390 337.0600n -0.000388 337.0700n -0.000386 337.0800n -0.000383 337.0900n -0.000379 337.1000n -0.000375 337.1100n -0.000370 337.1200n -0.000364 337.1300n -0.000357 337.1400n -0.000349 337.1500n -0.000341 337.1600n -0.000332 337.1700n -0.000322 337.1800n -0.000312 337.1900n -0.000301
+ 337.2000n -0.000289 337.2100n -0.000277 337.2200n -0.000263 337.2300n -0.000249 337.2400n -0.000235 337.2500n -0.000219 337.2600n -0.000204 337.2700n -0.000187 337.2800n -0.000170 337.2900n -0.000152 337.3000n -0.000133 337.3100n -0.000114 337.3200n -0.000094 337.3300n -0.000074 337.3400n -0.000053
+ 337.3500n -0.000031 337.3600n -0.000009 337.3700n 0.000013 337.3800n 0.000036 337.3900n 0.000060 337.4000n 0.000084 337.4100n 0.000109 337.4200n 0.000134 337.4300n 0.000159 337.4400n 0.000185 337.4500n 0.000212 337.4600n 0.000238 337.4700n 0.000266 337.4800n 0.000293 337.4900n 0.000321
+ 337.5000n 0.000349 337.5100n 0.000378 337.5200n 0.000406 337.5300n 0.000435 337.5400n 0.000465 337.5500n 0.000494 337.5600n 0.000524 337.5700n 0.000554 337.5800n 0.000584 337.5900n 0.000614 337.6000n 0.000645 337.6100n 0.000675 337.6200n 0.000706 337.6300n 0.000736 337.6400n 0.000767
+ 337.6500n 0.000798 337.6600n 0.000829 337.6700n 0.000859 337.6800n 0.000890 337.6900n 0.000921 337.7000n 0.000951 337.7100n 0.000982 337.7200n 0.001012 337.7300n 0.001043 337.7400n 0.001073 337.7500n 0.001103 337.7600n 0.001133 337.7700n 0.001162 337.7800n 0.001192 337.7900n 0.001221
+ 337.8000n 0.001250 337.8100n 0.001278 337.8200n 0.001307 337.8300n 0.001335 337.8400n 0.001362 337.8500n 0.001390 337.8600n 0.001417 337.8700n 0.001443 337.8800n 0.001470 337.8900n 0.001495 337.9000n 0.001521 337.9100n 0.001546 337.9200n 0.001570 337.9300n 0.001594 337.9400n 0.001618
+ 337.9500n 0.001641 337.9600n 0.001664 337.9700n 0.001686 337.9800n 0.001707 337.9900n 0.001728 338.0000n 0.001749 338.0100n 0.001769 338.0200n 0.001788 338.0300n 0.001807 338.0400n 0.001825 338.0500n 0.001842 338.0600n 0.001859 338.0700n 0.001876 338.0800n 0.001891 338.0900n 0.001906
+ 338.1000n 0.001921 338.1100n 0.001935 338.1200n 0.001948 338.1300n 0.001960 338.1400n 0.001972 338.1500n 0.001983 338.1600n 0.001994 338.1700n 0.002004 338.1800n 0.002013 338.1900n 0.002022 338.2000n 0.002029 338.2100n 0.002037 338.2200n 0.002043 338.2300n 0.002049 338.2400n 0.002054
+ 338.2500n 0.002059 338.2600n 0.002063 338.2700n 0.002066 338.2800n 0.002068 338.2900n 0.002070 338.3000n 0.002071 338.3100n 0.002072 338.3200n 0.002072 338.3300n 0.002071 338.3400n 0.002070 338.3500n 0.002068 338.3600n 0.002065 338.3700n 0.002062 338.3800n 0.002058 338.3900n 0.002054
+ 338.4000n 0.002049 338.4100n 0.002043 338.4200n 0.002037 338.4300n 0.002031 338.4400n 0.002023 338.4500n 0.002015 338.4600n 0.002007 338.4700n 0.001998 338.4800n 0.001989 338.4900n 0.001979 338.5000n 0.001969 338.5100n 0.001958 338.5200n 0.001947 338.5300n 0.001935 338.5400n 0.001923
+ 338.5500n 0.001910 338.5600n 0.001897 338.5700n 0.001884 338.5800n 0.001870 338.5900n 0.001856 338.6000n 0.001841 338.6100n 0.001826 338.6200n 0.001811 338.6300n 0.001796 338.6400n 0.001780 338.6500n 0.001764 338.6600n 0.001747 338.6700n 0.001731 338.6800n 0.001714 338.6900n 0.001697
+ 338.7000n 0.001679 338.7100n 0.001662 338.7200n 0.001644 338.7300n 0.001626 338.7400n 0.001608 338.7500n 0.001590 338.7600n 0.001572 338.7700n 0.001554 338.7800n 0.001535 338.7900n 0.001517 338.8000n 0.001498 338.8100n 0.001479 338.8200n 0.001461 338.8300n 0.001442 338.8400n 0.001423
+ 338.8500n 0.001405 338.8600n 0.001386 338.8700n 0.001367 338.8800n 0.001349 338.8900n 0.001330 338.9000n 0.001312 338.9100n 0.001293 338.9200n 0.001275 338.9300n 0.001257 338.9400n 0.001239 338.9500n 0.001221 338.9600n 0.001203 338.9700n 0.001186 338.9800n 0.001168 338.9900n 0.001151
+ 339.0000n 0.001134 339.0100n 0.001117 339.0200n 0.001100 339.0300n 0.001084 339.0400n 0.001068 339.0500n 0.001052 339.0600n 0.001036 339.0700n 0.001020 339.0800n 0.001005 339.0900n 0.000990 339.1000n 0.000975 339.1100n 0.000961 339.1200n 0.000947 339.1300n 0.000933 339.1400n 0.000919
+ 339.1500n 0.000906 339.1600n 0.000893 339.1700n 0.000880 339.1800n 0.000868 339.1900n 0.000856 339.2000n 0.000844 339.2100n 0.000833 339.2200n 0.000821 339.2300n 0.000811 339.2400n 0.000800 339.2500n 0.000790 339.2600n 0.000780 339.2700n 0.000770 339.2800n 0.000761 339.2900n 0.000752
+ 339.3000n 0.000744 339.3100n 0.000735 339.3200n 0.000727 339.3300n 0.000720 339.3400n 0.000712 339.3500n 0.000705 339.3600n 0.000698 339.3700n 0.000692 339.3800n 0.000686 339.3900n 0.000680 339.4000n 0.000674 339.4100n 0.000669 339.4200n 0.000664 339.4300n 0.000659 339.4400n 0.000654
+ 339.4500n 0.000650 339.4600n 0.000646 339.4700n 0.000642 339.4800n 0.000638 339.4900n 0.000635 339.5000n 0.000632 339.5100n 0.000629 339.5200n 0.000626 339.5300n 0.000623 339.5400n 0.000621 339.5500n 0.000619 339.5600n 0.000617 339.5700n 0.000615 339.5800n 0.000613 339.5900n 0.000611
+ 339.6000n 0.000610 339.6100n 0.000608 339.6200n 0.000607 339.6300n 0.000606 339.6400n 0.000604 339.6500n 0.000603 339.6600n 0.000602 339.6700n 0.000601 339.6800n 0.000600 339.6900n 0.000599 339.7000n 0.000599 339.7100n 0.000598 339.7200n 0.000597 339.7300n 0.000596 339.7400n 0.000595
+ 339.7500n 0.000594 339.7600n 0.000593 339.7700n 0.000592 339.7800n 0.000591 339.7900n 0.000590 339.8000n 0.000588 339.8100n 0.000587 339.8200n 0.000585 339.8300n 0.000584 339.8400n 0.000582 339.8500n 0.000580 339.8600n 0.000578 339.8700n 0.000576 339.8800n 0.000574 339.8900n 0.000571
+ 339.9000n 0.000569 339.9100n 0.000566 339.9200n 0.000563 339.9300n 0.000559 339.9400n 0.000556 339.9500n 0.000552 339.9600n 0.000549 339.9700n 0.000544 339.9800n 0.000540 339.9900n 0.000535 340.0000n 0.000531 340.0100n 0.000526 340.0200n 0.000520 340.0300n 0.000515 340.0400n 0.000509
+ 340.0500n 0.000503 340.0600n 0.000496 340.0700n 0.000489 340.0800n 0.000482 340.0900n 0.000475 340.1000n 0.000468 340.1100n 0.000460 340.1200n 0.000452 340.1300n 0.000443 340.1400n 0.000435 340.1500n 0.000426 340.1600n 0.000416 340.1700n 0.000407 340.1800n 0.000397 340.1900n 0.000387
+ 340.2000n 0.000376 340.2100n 0.000365 340.2200n 0.000354 340.2300n 0.000343 340.2400n 0.000332 340.2500n 0.000320 340.2600n 0.000308 340.2700n 0.000295 340.2800n 0.000282 340.2900n 0.000270 340.3000n 0.000256 340.3100n 0.000243 340.3200n 0.000229 340.3300n 0.000215 340.3400n 0.000201
+ 340.3500n 0.000187 340.3600n 0.000172 340.3700n 0.000157 340.3800n 0.000142 340.3900n 0.000127 340.4000n 0.000112 340.4100n 0.000096 340.4200n 0.000081 340.4300n 0.000065 340.4400n 0.000049 340.4500n 0.000033 340.4600n 0.000016 340.4700n 0.000000 340.4800n -0.000016 340.4900n -0.000033
+ 340.5000n -0.000050 340.5100n -0.000066 340.5200n -0.000083 340.5300n -0.000100 340.5400n -0.000117 340.5500n -0.000134 340.5600n -0.000151 340.5700n -0.000168 340.5800n -0.000185 340.5900n -0.000201 340.6000n -0.000218 340.6100n -0.000235 340.6200n -0.000252 340.6300n -0.000268 340.6400n -0.000285
+ 340.6500n -0.000301 340.6600n -0.000318 340.6700n -0.000334 340.6800n -0.000350 340.6900n -0.000366 340.7000n -0.000382 340.7100n -0.000397 340.7200n -0.000412 340.7300n -0.000428 340.7400n -0.000443 340.7500n -0.000457 340.7600n -0.000472 340.7700n -0.000486 340.7800n -0.000500 340.7900n -0.000513
+ 340.8000n -0.000527 340.8100n -0.000540 340.8200n -0.000552 340.8300n -0.000565 340.8400n -0.000577 340.8500n -0.000588 340.8600n -0.000599 340.8700n -0.000610 340.8800n -0.000621 340.8900n -0.000631 340.9000n -0.000641 340.9100n -0.000650 340.9200n -0.000659 340.9300n -0.000667 340.9400n -0.000675
+ 340.9500n -0.000683 340.9600n -0.000690 340.9700n -0.000696 340.9800n -0.000702 340.9900n -0.000708 341.0000n -0.000713 341.0100n -0.000718 341.0200n -0.000722 341.0300n -0.000725 341.0400n -0.000728 341.0500n -0.000731 341.0600n -0.000733 341.0700n -0.000734 341.0800n -0.000735 341.0900n -0.000736
+ 341.1000n -0.000735 341.1100n -0.000735 341.1200n -0.000734 341.1300n -0.000732 341.1400n -0.000729 341.1500n -0.000727 341.1600n -0.000723 341.1700n -0.000719 341.1800n -0.000715 341.1900n -0.000710 341.2000n -0.000704 341.2100n -0.000698 341.2200n -0.000691 341.2300n -0.000684 341.2400n -0.000676
+ 341.2500n -0.000668 341.2600n -0.000659 341.2700n -0.000650 341.2800n -0.000640 341.2900n -0.000630 341.3000n -0.000619 341.3100n -0.000608 341.3200n -0.000596 341.3300n -0.000583 341.3400n -0.000571 341.3500n -0.000557 341.3600n -0.000544 341.3700n -0.000530 341.3800n -0.000515 341.3900n -0.000500
+ 341.4000n -0.000485 341.4100n -0.000469 341.4200n -0.000453 341.4300n -0.000436 341.4400n -0.000420 341.4500n -0.000402 341.4600n -0.000385 341.4700n -0.000367 341.4800n -0.000349 341.4900n -0.000330 341.5000n -0.000311 341.5100n -0.000292 341.5200n -0.000273 341.5300n -0.000253 341.5400n -0.000234
+ 341.5500n -0.000214 341.5600n -0.000194 341.5700n -0.000173 341.5800n -0.000153 341.5900n -0.000132 341.6000n -0.000112 341.6100n -0.000091 341.6200n -0.000070 341.6300n -0.000049 341.6400n -0.000028 341.6500n -0.000007 341.6600n 0.000014 341.6700n 0.000035 341.6800n 0.000057 341.6900n 0.000078
+ 341.7000n 0.000099 341.7100n 0.000119 341.7200n 0.000140 341.7300n 0.000161 341.7400n 0.000181 341.7500n 0.000202 341.7600n 0.000222 341.7700n 0.000242 341.7800n 0.000262 341.7900n 0.000282 341.8000n 0.000301 341.8100n 0.000320 341.8200n 0.000339 341.8300n 0.000358 341.8400n 0.000376
+ 341.8500n 0.000394 341.8600n 0.000412 341.8700n 0.000429 341.8800n 0.000446 341.8900n 0.000462 341.9000n 0.000478 341.9100n 0.000494 341.9200n 0.000509 341.9300n 0.000524 341.9400n 0.000539 341.9500n 0.000552 341.9600n 0.000566 341.9700n 0.000579 341.9800n 0.000591 341.9900n 0.000603
+ 342.0000n 0.000614 342.0100n 0.000625 342.0200n 0.000635 342.0300n 0.000644 342.0400n 0.000653 342.0500n 0.000662 342.0600n 0.000669 342.0700n 0.000677 342.0800n 0.000683 342.0900n 0.000689 342.1000n 0.000694 342.1100n 0.000699 342.1200n 0.000702 342.1300n 0.000706 342.1400n 0.000708
+ 342.1500n 0.000710 342.1600n 0.000711 342.1700n 0.000712 342.1800n 0.000711 342.1900n 0.000711 342.2000n 0.000709 342.2100n 0.000707 342.2200n 0.000704 342.2300n 0.000700 342.2400n 0.000695 342.2500n 0.000690 342.2600n 0.000684 342.2700n 0.000678 342.2800n 0.000671 342.2900n 0.000663
+ 342.3000n 0.000654 342.3100n 0.000645 342.3200n 0.000635 342.3300n 0.000624 342.3400n 0.000612 342.3500n 0.000600 342.3600n 0.000588 342.3700n 0.000574 342.3800n 0.000560 342.3900n 0.000545 342.4000n 0.000530 342.4100n 0.000514 342.4200n 0.000497 342.4300n 0.000480 342.4400n 0.000462
+ 342.4500n 0.000444 342.4600n 0.000425 342.4700n 0.000405 342.4800n 0.000385 342.4900n 0.000365 342.5000n 0.000343 342.5100n 0.000322 342.5200n 0.000300 342.5300n 0.000277 342.5400n 0.000254 342.5500n 0.000230 342.5600n 0.000206 342.5700n 0.000182 342.5800n 0.000157 342.5900n 0.000132
+ 342.6000n 0.000106 342.6100n 0.000080 342.6200n 0.000054 342.6300n 0.000027 342.6400n 0.000000 342.6500n -0.000027 342.6600n -0.000054 342.6700n -0.000082 342.6800n -0.000110 342.6900n -0.000138 342.7000n -0.000166 342.7100n -0.000194 342.7200n -0.000223 342.7300n -0.000252 342.7400n -0.000280
+ 342.7500n -0.000309 342.7600n -0.000338 342.7700n -0.000367 342.7800n -0.000396 342.7900n -0.000425 342.8000n -0.000453 342.8100n -0.000482 342.8200n -0.000511 342.8300n -0.000539 342.8400n -0.000568 342.8500n -0.000596 342.8600n -0.000624 342.8700n -0.000652 342.8800n -0.000680 342.8900n -0.000708
+ 342.9000n -0.000735 342.9100n -0.000762 342.9200n -0.000789 342.9300n -0.000815 342.9400n -0.000841 342.9500n -0.000867 342.9600n -0.000892 342.9700n -0.000917 342.9800n -0.000942 342.9900n -0.000966 343.0000n -0.000990 343.0100n -0.001013 343.0200n -0.001036 343.0300n -0.001058 343.0400n -0.001080
+ 343.0500n -0.001101 343.0600n -0.001121 343.0700n -0.001141 343.0800n -0.001161 343.0900n -0.001180 343.1000n -0.001198 343.1100n -0.001215 343.1200n -0.001232 343.1300n -0.001249 343.1400n -0.001264 343.1500n -0.001279 343.1600n -0.001293 343.1700n -0.001307 343.1800n -0.001320 343.1900n -0.001332
+ 343.2000n -0.001343 343.2100n -0.001354 343.2200n -0.001364 343.2300n -0.001373 343.2400n -0.001381 343.2500n -0.001388 343.2600n -0.001395 343.2700n -0.001401 343.2800n -0.001406 343.2900n -0.001410 343.3000n -0.001414 343.3100n -0.001417 343.3200n -0.001418 343.3300n -0.001420 343.3400n -0.001420
+ 343.3500n -0.001419 343.3600n -0.001418 343.3700n -0.001416 343.3800n -0.001412 343.3900n -0.001409 343.4000n -0.001404 343.4100n -0.001398 343.4200n -0.001392 343.4300n -0.001385 343.4400n -0.001377 343.4500n -0.001368 343.4600n -0.001359 343.4700n -0.001349 343.4800n -0.001337 343.4900n -0.001326
+ 343.5000n -0.001313 343.5100n -0.001300 343.5200n -0.001286 343.5300n -0.001271 343.5400n -0.001255 343.5500n -0.001239 343.5600n -0.001222 343.5700n -0.001204 343.5800n -0.001186 343.5900n -0.001167 343.6000n -0.001147 343.6100n -0.001127 343.6200n -0.001106 343.6300n -0.001085 343.6400n -0.001063
+ 343.6500n -0.001040 343.6600n -0.001017 343.6700n -0.000993 343.6800n -0.000969 343.6900n -0.000944 343.7000n -0.000919 343.7100n -0.000893 343.7200n -0.000867 343.7300n -0.000841 343.7400n -0.000814 343.7500n -0.000786 343.7600n -0.000759 343.7700n -0.000731 343.7800n -0.000702 343.7900n -0.000674
+ 343.8000n -0.000645 343.8100n -0.000616 343.8200n -0.000586 343.8300n -0.000556 343.8400n -0.000527 343.8500n -0.000497 343.8600n -0.000466 343.8700n -0.000436 343.8800n -0.000406 343.8900n -0.000375 343.9000n -0.000345 343.9100n -0.000314 343.9200n -0.000284 343.9300n -0.000253 343.9400n -0.000223
+ 343.9500n -0.000192 343.9600n -0.000162 343.9700n -0.000132 343.9800n -0.000102 343.9900n -0.000072 344.0000n -0.000042 344.0100n -0.000012 344.0200n 0.000017 344.0300n 0.000046 344.0400n 0.000075 344.0500n 0.000104 344.0600n 0.000132 344.0700n 0.000160 344.0800n 0.000188 344.0900n 0.000215
+ 344.1000n 0.000242 344.1100n 0.000268 344.1200n 0.000294 344.1300n 0.000320 344.1400n 0.000345 344.1500n 0.000370 344.1600n 0.000394 344.1700n 0.000417 344.1800n 0.000440 344.1900n 0.000463 344.2000n 0.000485 344.2100n 0.000506 344.2200n 0.000527 344.2300n 0.000547 344.2400n 0.000566
+ 344.2500n 0.000585 344.2600n 0.000603 344.2700n 0.000621 344.2800n 0.000638 344.2900n 0.000654 344.3000n 0.000669 344.3100n 0.000684 344.3200n 0.000698 344.3300n 0.000711 344.3400n 0.000723 344.3500n 0.000735 344.3600n 0.000746 344.3700n 0.000756 344.3800n 0.000765 344.3900n 0.000774
+ 344.4000n 0.000781 344.4100n 0.000788 344.4200n 0.000794 344.4300n 0.000799 344.4400n 0.000804 344.4500n 0.000808 344.4600n 0.000810 344.4700n 0.000812 344.4800n 0.000813 344.4900n 0.000814 344.5000n 0.000813 344.5100n 0.000812 344.5200n 0.000810 344.5300n 0.000807 344.5400n 0.000803
+ 344.5500n 0.000799 344.5600n 0.000793 344.5700n 0.000787 344.5800n 0.000780 344.5900n 0.000772 344.6000n 0.000764 344.6100n 0.000754 344.6200n 0.000744 344.6300n 0.000733 344.6400n 0.000721 344.6500n 0.000709 344.6600n 0.000696 344.6700n 0.000682 344.6800n 0.000667 344.6900n 0.000652
+ 344.7000n 0.000636 344.7100n 0.000620 344.7200n 0.000602 344.7300n 0.000584 344.7400n 0.000566 344.7500n 0.000547 344.7600n 0.000527 344.7700n 0.000506 344.7800n 0.000485 344.7900n 0.000464 344.8000n 0.000442 344.8100n 0.000419 344.8200n 0.000396 344.8300n 0.000372 344.8400n 0.000348
+ 344.8500n 0.000324 344.8600n 0.000299 344.8700n 0.000274 344.8800n 0.000248 344.8900n 0.000222 344.9000n 0.000195 344.9100n 0.000168 344.9200n 0.000141 344.9300n 0.000114 344.9400n 0.000086 344.9500n 0.000058 344.9600n 0.000030 344.9700n 0.000002 344.9800n -0.000027 344.9900n -0.000056
+ 345.0000n -0.000085 345.0100n -0.000114 345.0200n -0.000143 345.0300n -0.000172 345.0400n -0.000201 345.0500n -0.000230 345.0600n -0.000260 345.0700n -0.000289 345.0800n -0.000318 345.0900n -0.000347 345.1000n -0.000376 345.1100n -0.000405 345.1200n -0.000434 345.1300n -0.000463 345.1400n -0.000492
+ 345.1500n -0.000520 345.1600n -0.000548 345.1700n -0.000576 345.1800n -0.000604 345.1900n -0.000632 345.2000n -0.000659 345.2100n -0.000686 345.2200n -0.000712 345.2300n -0.000739 345.2400n -0.000764 345.2500n -0.000790 345.2600n -0.000815 345.2700n -0.000840 345.2800n -0.000864 345.2900n -0.000888
+ 345.3000n -0.000911 345.3100n -0.000934 345.3200n -0.000957 345.3300n -0.000979 345.3400n -0.001000 345.3500n -0.001021 345.3600n -0.001041 345.3700n -0.001061 345.3800n -0.001080 345.3900n -0.001099 345.4000n -0.001117 345.4100n -0.001134 345.4200n -0.001151 345.4300n -0.001167 345.4400n -0.001182
+ 345.4500n -0.001197 345.4600n -0.001211 345.4700n -0.001225 345.4800n -0.001237 345.4900n -0.001249 345.5000n -0.001261 345.5100n -0.001272 345.5200n -0.001282 345.5300n -0.001291 345.5400n -0.001299 345.5500n -0.001307 345.5600n -0.001314 345.5700n -0.001321 345.5800n -0.001327 345.5900n -0.001332
+ 345.6000n -0.001336 345.6100n -0.001339 345.6200n -0.001342 345.6300n -0.001344 345.6400n -0.001345 345.6500n -0.001346 345.6600n -0.001346 345.6700n -0.001345 345.6800n -0.001344 345.6900n -0.001341 345.7000n -0.001338 345.7100n -0.001335 345.7200n -0.001330 345.7300n -0.001325 345.7400n -0.001319
+ 345.7500n -0.001313 345.7600n -0.001306 345.7700n -0.001298 345.7800n -0.001290 345.7900n -0.001281 345.8000n -0.001271 345.8100n -0.001261 345.8200n -0.001250 345.8300n -0.001238 345.8400n -0.001226 345.8500n -0.001214 345.8600n -0.001200 345.8700n -0.001187 345.8800n -0.001172 345.8900n -0.001157
+ 345.9000n -0.001142 345.9100n -0.001126 345.9200n -0.001110 345.9300n -0.001093 345.9400n -0.001076 345.9500n -0.001058 345.9600n -0.001040 345.9700n -0.001022 345.9800n -0.001003 345.9900n -0.000983 346.0000n -0.000964 346.0100n -0.000944 346.0200n -0.000923 346.0300n -0.000903 346.0400n -0.000882
+ 346.0500n -0.000861 346.0600n -0.000839 346.0700n -0.000818 346.0800n -0.000796 346.0900n -0.000774 346.1000n -0.000752 346.1100n -0.000729 346.1200n -0.000707 346.1300n -0.000684 346.1400n -0.000661 346.1500n -0.000638 346.1600n -0.000616 346.1700n -0.000593 346.1800n -0.000570 346.1900n -0.000547
+ 346.2000n -0.000524 346.2100n -0.000501 346.2200n -0.000478 346.2300n -0.000455 346.2400n -0.000432 346.2500n -0.000409 346.2600n -0.000386 346.2700n -0.000364 346.2800n -0.000342 346.2900n -0.000319 346.3000n -0.000297 346.3100n -0.000276 346.3200n -0.000254 346.3300n -0.000233 346.3400n -0.000211
+ 346.3500n -0.000190 346.3600n -0.000170 346.3700n -0.000149 346.3800n -0.000129 346.3900n -0.000110 346.4000n -0.000090 346.4100n -0.000071 346.4200n -0.000053 346.4300n -0.000034 346.4400n -0.000016 346.4500n 0.000001 346.4600n 0.000019 346.4700n 0.000035 346.4800n 0.000052 346.4900n 0.000068
+ 346.5000n 0.000083 346.5100n 0.000098 346.5200n 0.000113 346.5300n 0.000127 346.5400n 0.000140 346.5500n 0.000153 346.5600n 0.000166 346.5700n 0.000178 346.5800n 0.000190 346.5900n 0.000201 346.6000n 0.000211 346.6100n 0.000221 346.6200n 0.000231 346.6300n 0.000240 346.6400n 0.000248
+ 346.6500n 0.000256 346.6600n 0.000264 346.6700n 0.000271 346.6800n 0.000277 346.6900n 0.000283 346.7000n 0.000288 346.7100n 0.000293 346.7200n 0.000297 346.7300n 0.000300 346.7400n 0.000303 346.7500n 0.000306 346.7600n 0.000308 346.7700n 0.000309 346.7800n 0.000310 346.7900n 0.000310
+ 346.8000n 0.000310 346.8100n 0.000309 346.8200n 0.000308 346.8300n 0.000306 346.8400n 0.000304 346.8500n 0.000301 346.8600n 0.000298 346.8700n 0.000294 346.8800n 0.000290 346.8900n 0.000285 346.9000n 0.000280 346.9100n 0.000275 346.9200n 0.000269 346.9300n 0.000262 346.9400n 0.000255
+ 346.9500n 0.000248 346.9600n 0.000240 346.9700n 0.000232 346.9800n 0.000223 346.9900n 0.000214 347.0000n 0.000205 347.0100n 0.000195 347.0200n 0.000185 347.0300n 0.000175 347.0400n 0.000164 347.0500n 0.000153 347.0600n 0.000142 347.0700n 0.000130 347.0800n 0.000118 347.0900n 0.000106
+ 347.1000n 0.000094 347.1100n 0.000081 347.1200n 0.000068 347.1300n 0.000055 347.1400n 0.000042 347.1500n 0.000028 347.1600n 0.000015 347.1700n 0.000001 347.1800n -0.000013 347.1900n -0.000027 347.2000n -0.000041 347.2100n -0.000056 347.2200n -0.000070 347.2300n -0.000084 347.2400n -0.000099
+ 347.2500n -0.000114 347.2600n -0.000128 347.2700n -0.000143 347.2800n -0.000157 347.2900n -0.000172 347.3000n -0.000187 347.3100n -0.000201 347.3200n -0.000216 347.3300n -0.000230 347.3400n -0.000245 347.3500n -0.000259 347.3600n -0.000273 347.3700n -0.000287 347.3800n -0.000301 347.3900n -0.000315
+ 347.4000n -0.000329 347.4100n -0.000343 347.4200n -0.000356 347.4300n -0.000370 347.4400n -0.000383 347.4500n -0.000396 347.4600n -0.000408 347.4700n -0.000421 347.4800n -0.000433 347.4900n -0.000445 347.5000n -0.000457 347.5100n -0.000469 347.5200n -0.000480 347.5300n -0.000491 347.5400n -0.000502
+ 347.5500n -0.000513 347.5600n -0.000523 347.5700n -0.000533 347.5800n -0.000543 347.5900n -0.000553 347.6000n -0.000562 347.6100n -0.000571 347.6200n -0.000579 347.6300n -0.000587 347.6400n -0.000595 347.6500n -0.000603 347.6600n -0.000610 347.6700n -0.000617 347.6800n -0.000624 347.6900n -0.000630
+ 347.7000n -0.000636 347.7100n -0.000642 347.7200n -0.000648 347.7300n -0.000653 347.7400n -0.000657 347.7500n -0.000662 347.7600n -0.000666 347.7700n -0.000670 347.7800n -0.000673 347.7900n -0.000676 347.8000n -0.000679 347.8100n -0.000682 347.8200n -0.000684 347.8300n -0.000686 347.8400n -0.000688
+ 347.8500n -0.000689 347.8600n -0.000690 347.8700n -0.000691 347.8800n -0.000692 347.8900n -0.000692 347.9000n -0.000692 347.9100n -0.000692 347.9200n -0.000691 347.9300n -0.000690 347.9400n -0.000689 347.9500n -0.000688 347.9600n -0.000687 347.9700n -0.000685 347.9800n -0.000684 347.9900n -0.000682
+ 348.0000n -0.000679 348.0100n -0.000677 348.0200n -0.000675 348.0300n -0.000672 348.0400n -0.000669 348.0500n -0.000666 348.0600n -0.000663 348.0700n -0.000660 348.0800n -0.000657 348.0900n -0.000654 348.1000n -0.000651 348.1100n -0.000647 348.1200n -0.000644 348.1300n -0.000640 348.1400n -0.000637
+ 348.1500n -0.000633 348.1600n -0.000630 348.1700n -0.000626 348.1800n -0.000623 348.1900n -0.000619 348.2000n -0.000616 348.2100n -0.000612 348.2200n -0.000609 348.2300n -0.000606 348.2400n -0.000603 348.2500n -0.000600 348.2600n -0.000597 348.2700n -0.000594 348.2800n -0.000591 348.2900n -0.000589
+ 348.3000n -0.000587 348.3100n -0.000585 348.3200n -0.000583 348.3300n -0.000581 348.3400n -0.000579 348.3500n -0.000578 348.3600n -0.000577 348.3700n -0.000576 348.3800n -0.000576 348.3900n -0.000575 348.4000n -0.000575 348.4100n -0.000576 348.4200n -0.000576 348.4300n -0.000577 348.4400n -0.000578
+ 348.4500n -0.000580 348.4600n -0.000582 348.4700n -0.000584 348.4800n -0.000586 348.4900n -0.000589 348.5000n -0.000592 348.5100n -0.000596 348.5200n -0.000600 348.5300n -0.000604 348.5400n -0.000609 348.5500n -0.000614 348.5600n -0.000619 348.5700n -0.000625 348.5800n -0.000632 348.5900n -0.000638
+ 348.6000n -0.000646 348.6100n -0.000653 348.6200n -0.000661 348.6300n -0.000670 348.6400n -0.000678 348.6500n -0.000688 348.6600n -0.000697 348.6700n -0.000707 348.6800n -0.000718 348.6900n -0.000729 348.7000n -0.000740 348.7100n -0.000752 348.7200n -0.000765 348.7300n -0.000777 348.7400n -0.000790
+ 348.7500n -0.000804 348.7600n -0.000818 348.7700n -0.000832 348.7800n -0.000847 348.7900n -0.000862 348.8000n -0.000878 348.8100n -0.000894 348.8200n -0.000910 348.8300n -0.000927 348.8400n -0.000944 348.8500n -0.000962 348.8600n -0.000980 348.8700n -0.000998 348.8800n -0.001017 348.8900n -0.001036
+ 348.9000n -0.001055 348.9100n -0.001075 348.9200n -0.001095 348.9300n -0.001116 348.9400n -0.001136 348.9500n -0.001157 348.9600n -0.001178 348.9700n -0.001200 348.9800n -0.001222 348.9900n -0.001244 349.0000n -0.001266 349.0100n -0.001289 349.0200n -0.001311 349.0300n -0.001334 349.0400n -0.001357
+ 349.0500n -0.001381 349.0600n -0.001404 349.0700n -0.001428 349.0800n -0.001451 349.0900n -0.001475 349.1000n -0.001499 349.1100n -0.001523 349.1200n -0.001547 349.1300n -0.001572 349.1400n -0.001596 349.1500n -0.001620 349.1600n -0.001644 349.1700n -0.001669 349.1800n -0.001693 349.1900n -0.001717
+ 349.2000n -0.001742 349.2100n -0.001766 349.2200n -0.001790 349.2300n -0.001814 349.2400n -0.001838 349.2500n -0.001861 349.2600n -0.001885 349.2700n -0.001908 349.2800n -0.001932 349.2900n -0.001955 349.3000n -0.001978 349.3100n -0.002000 349.3200n -0.002023 349.3300n -0.002045 349.3400n -0.002067
+ 349.3500n -0.002088 349.3600n -0.002110 349.3700n -0.002131 349.3800n -0.002151 349.3900n -0.002172 349.4000n -0.002192 349.4100n -0.002211 349.4200n -0.002230 349.4300n -0.002249 349.4400n -0.002267 349.4500n -0.002285 349.4600n -0.002303 349.4700n -0.002319 349.4800n -0.002336 349.4900n -0.002352
+ 349.5000n -0.002367 349.5100n -0.002382 349.5200n -0.002397 349.5300n -0.002410 349.5400n -0.002424 349.5500n -0.002436 349.5600n -0.002448 349.5700n -0.002460 349.5800n -0.002471 349.5900n -0.002481 349.6000n -0.002491 349.6100n -0.002500 349.6200n -0.002508 349.6300n -0.002516 349.6400n -0.002523
+ 349.6500n -0.002529 349.6600n -0.002535 349.6700n -0.002540 349.6800n -0.002544 349.6900n -0.002548 349.7000n -0.002551 349.7100n -0.002553 349.7200n -0.002554 349.7300n -0.002555 349.7400n -0.002555 349.7500n -0.002554 349.7600n -0.002553 349.7700n -0.002550 349.7800n -0.002547 349.7900n -0.002544
+ 349.8000n -0.002539 349.8100n -0.002534 349.8200n -0.002528 349.8300n -0.002521 349.8400n -0.002514 349.8500n -0.002505 349.8600n -0.002496 349.8700n -0.002487 349.8800n -0.002476 349.8900n -0.002465 349.9000n -0.002453 349.9100n -0.002440 349.9200n -0.002426 349.9300n -0.002412 349.9400n -0.002397
+ 349.9500n -0.002381 349.9600n -0.002365 349.9700n -0.002348 349.9800n -0.002330 349.9900n -0.002311 350.0000n -0.002292 350.0100n -0.002272 350.0200n -0.002251 350.0300n -0.002230 350.0400n -0.002208 350.0500n -0.002186 350.0600n -0.002162 350.0700n -0.002138 350.0800n -0.002114 350.0900n -0.002089
+ 350.1000n -0.002063 350.1100n -0.002037 350.1200n -0.002010 350.1300n -0.001982 350.1400n -0.001954 350.1500n -0.001926 350.1600n -0.001897 350.1700n -0.001867 350.1800n -0.001837 350.1900n -0.001806 350.2000n -0.001775 350.2100n -0.001744 350.2200n -0.001712 350.2300n -0.001679 350.2400n -0.001646
+ 350.2500n -0.001613 350.2600n -0.001580 350.2700n -0.001546 350.2800n -0.001511 350.2900n -0.001477 350.3000n -0.001442 350.3100n -0.001407 350.3200n -0.001371 350.3300n -0.001335 350.3400n -0.001299 350.3500n -0.001263 350.3600n -0.001226 350.3700n -0.001190 350.3800n -0.001153 350.3900n -0.001116
+ 350.4000n -0.001079 350.4100n -0.001042 350.4200n -0.001004 350.4300n -0.000967 350.4400n -0.000929 350.4500n -0.000892 350.4600n -0.000854 350.4700n -0.000817 350.4800n -0.000779 350.4900n -0.000742 350.5000n -0.000704 350.5100n -0.000667 350.5200n -0.000629 350.5300n -0.000592 350.5400n -0.000555
+ 350.5500n -0.000518 350.5600n -0.000481 350.5700n -0.000444 350.5800n -0.000408 350.5900n -0.000372 350.6000n -0.000336 350.6100n -0.000300 350.6200n -0.000264 350.6300n -0.000229 350.6400n -0.000194 350.6500n -0.000159 350.6600n -0.000125 350.6700n -0.000091 350.6800n -0.000057 350.6900n -0.000024
+ 350.7000n 0.000009 350.7100n 0.000042 350.7200n 0.000074 350.7300n 0.000105 350.7400n 0.000137 350.7500n 0.000167 350.7600n 0.000198 350.7700n 0.000228 350.7800n 0.000257 350.7900n 0.000286 350.8000n 0.000314 350.8100n 0.000342 350.8200n 0.000369 350.8300n 0.000396 350.8400n 0.000422
+ 350.8500n 0.000447 350.8600n 0.000472 350.8700n 0.000497 350.8800n 0.000520 350.8900n 0.000543 350.9000n 0.000566 350.9100n 0.000588 350.9200n 0.000609 350.9300n 0.000630 350.9400n 0.000649 350.9500n 0.000669 350.9600n 0.000687 350.9700n 0.000705 350.9800n 0.000722 350.9900n 0.000739
+ 351.0000n 0.000755 351.0100n 0.000770 351.0200n 0.000784 351.0300n 0.000798 351.0400n 0.000811 351.0500n 0.000823 351.0600n 0.000835 351.0700n 0.000846 351.0800n 0.000856 351.0900n 0.000865 351.1000n 0.000874 351.1100n 0.000882 351.1200n 0.000889 351.1300n 0.000896 351.1400n 0.000901
+ 351.1500n 0.000906 351.1600n 0.000911 351.1700n 0.000914 351.1800n 0.000917 351.1900n 0.000920 351.2000n 0.000921 351.2100n 0.000922 351.2200n 0.000922 351.2300n 0.000921 351.2400n 0.000920 351.2500n 0.000918 351.2600n 0.000915 351.2700n 0.000912 351.2800n 0.000908 351.2900n 0.000903
+ 351.3000n 0.000898 351.3100n 0.000892 351.3200n 0.000885 351.3300n 0.000878 351.3400n 0.000870 351.3500n 0.000861 351.3600n 0.000852 351.3700n 0.000842 351.3800n 0.000832 351.3900n 0.000821 351.4000n 0.000809 351.4100n 0.000797 351.4200n 0.000784 351.4300n 0.000771 351.4400n 0.000757
+ 351.4500n 0.000743 351.4600n 0.000728 351.4700n 0.000712 351.4800n 0.000696 351.4900n 0.000680 351.5000n 0.000663 351.5100n 0.000645 351.5200n 0.000628 351.5300n 0.000609 351.5400n 0.000590 351.5500n 0.000571 351.5600n 0.000552 351.5700n 0.000532 351.5800n 0.000511 351.5900n 0.000491
+ 351.6000n 0.000469 351.6100n 0.000448 351.6200n 0.000426 351.6300n 0.000404 351.6400n 0.000382 351.6500n 0.000359 351.6600n 0.000336 351.6700n 0.000313 351.6800n 0.000289 351.6900n 0.000265 351.7000n 0.000241 351.7100n 0.000217 351.7200n 0.000192 351.7300n 0.000168 351.7400n 0.000143
+ 351.7500n 0.000118 351.7600n 0.000093 351.7700n 0.000067 351.7800n 0.000042 351.7900n 0.000016 351.8000n -0.000009 351.8100n -0.000035 351.8200n -0.000061 351.8300n -0.000087 351.8400n -0.000113 351.8500n -0.000139 351.8600n -0.000165 351.8700n -0.000191 351.8800n -0.000217 351.8900n -0.000243
+ 351.9000n -0.000269 351.9100n -0.000295 351.9200n -0.000321 351.9300n -0.000347 351.9400n -0.000373 351.9500n -0.000398 351.9600n -0.000424 351.9700n -0.000450 351.9800n -0.000475 351.9900n -0.000500 352.0000n -0.000525 352.0100n -0.000550 352.0200n -0.000575 352.0300n -0.000600 352.0400n -0.000624
+ 352.0500n -0.000649 352.0600n -0.000673 352.0700n -0.000697 352.0800n -0.000720 352.0900n -0.000744 352.1000n -0.000767 352.1100n -0.000790 352.1200n -0.000813 352.1300n -0.000835 352.1400n -0.000857 352.1500n -0.000879 352.1600n -0.000901 352.1700n -0.000922 352.1800n -0.000943 352.1900n -0.000964
+ 352.2000n -0.000984 352.2100n -0.001004 352.2200n -0.001024 352.2300n -0.001043 352.2400n -0.001063 352.2500n -0.001081 352.2600n -0.001100 352.2700n -0.001118 352.2800n -0.001135 352.2900n -0.001152 352.3000n -0.001169 352.3100n -0.001186 352.3200n -0.001202 352.3300n -0.001218 352.3400n -0.001233
+ 352.3500n -0.001248 352.3600n -0.001262 352.3700n -0.001276 352.3800n -0.001290 352.3900n -0.001303 352.4000n -0.001316 352.4100n -0.001329 352.4200n -0.001341 352.4300n -0.001352 352.4400n -0.001363 352.4500n -0.001374 352.4600n -0.001384 352.4700n -0.001394 352.4800n -0.001404 352.4900n -0.001413
+ 352.5000n -0.001421 352.5100n -0.001429 352.5200n -0.001437 352.5300n -0.001444 352.5400n -0.001451 352.5500n -0.001457 352.5600n -0.001463 352.5700n -0.001468 352.5800n -0.001473 352.5900n -0.001478 352.6000n -0.001482 352.6100n -0.001485 352.6200n -0.001489 352.6300n -0.001491 352.6400n -0.001493
+ 352.6500n -0.001495 352.6600n -0.001497 352.6700n -0.001498 352.6800n -0.001498 352.6900n -0.001498 352.7000n -0.001498 352.7100n -0.001497 352.7200n -0.001496 352.7300n -0.001494 352.7400n -0.001492 352.7500n -0.001489 352.7600n -0.001486 352.7700n -0.001483 352.7800n -0.001479 352.7900n -0.001475
+ 352.8000n -0.001470 352.8100n -0.001465 352.8200n -0.001460 352.8300n -0.001454 352.8400n -0.001447 352.8500n -0.001440 352.8600n -0.001433 352.8700n -0.001426 352.8800n -0.001418 352.8900n -0.001409 352.9000n -0.001401 352.9100n -0.001392 352.9200n -0.001382 352.9300n -0.001372 352.9400n -0.001362
+ 352.9500n -0.001351 352.9600n -0.001340 352.9700n -0.001329 352.9800n -0.001317 352.9900n -0.001305 353.0000n -0.001292 353.0100n -0.001280 353.0200n -0.001266 353.0300n -0.001253 353.0400n -0.001239 353.0500n -0.001225 353.0600n -0.001210 353.0700n -0.001195 353.0800n -0.001180 353.0900n -0.001165
+ 353.1000n -0.001149 353.1100n -0.001133 353.1200n -0.001116 353.1300n -0.001099 353.1400n -0.001082 353.1500n -0.001065 353.1600n -0.001047 353.1700n -0.001029 353.1800n -0.001011 353.1900n -0.000992 353.2000n -0.000973 353.2100n -0.000954 353.2200n -0.000935 353.2300n -0.000915 353.2400n -0.000895
+ 353.2500n -0.000875 353.2600n -0.000855 353.2700n -0.000834 353.2800n -0.000813 353.2900n -0.000792 353.3000n -0.000771 353.3100n -0.000749 353.3200n -0.000727 353.3300n -0.000705 353.3400n -0.000683 353.3500n -0.000660 353.3600n -0.000638 353.3700n -0.000615 353.3800n -0.000592 353.3900n -0.000568
+ 353.4000n -0.000545 353.4100n -0.000521 353.4200n -0.000497 353.4300n -0.000473 353.4400n -0.000449 353.4500n -0.000424 353.4600n -0.000400 353.4700n -0.000375 353.4800n -0.000350 353.4900n -0.000325 353.5000n -0.000300 353.5100n -0.000275 353.5200n -0.000249 353.5300n -0.000224 353.5400n -0.000198
+ 353.5500n -0.000172 353.5600n -0.000147 353.5700n -0.000121 353.5800n -0.000094 353.5900n -0.000068 353.6000n -0.000042 353.6100n -0.000015 353.6200n 0.000011 353.6300n 0.000038 353.6400n 0.000064 353.6500n 0.000091 353.6600n 0.000118 353.6700n 0.000145 353.6800n 0.000171 353.6900n 0.000198
+ 353.7000n 0.000225 353.7100n 0.000252 353.7200n 0.000279 353.7300n 0.000306 353.7400n 0.000334 353.7500n 0.000361 353.7600n 0.000388 353.7700n 0.000415 353.7800n 0.000442 353.7900n 0.000469 353.8000n 0.000496 353.8100n 0.000523 353.8200n 0.000550 353.8300n 0.000577 353.8400n 0.000604
+ 353.8500n 0.000631 353.8600n 0.000658 353.8700n 0.000685 353.8800n 0.000712 353.8900n 0.000739 353.9000n 0.000765 353.9100n 0.000792 353.9200n 0.000818 353.9300n 0.000845 353.9400n 0.000871 353.9500n 0.000897 353.9600n 0.000923 353.9700n 0.000949 353.9800n 0.000975 353.9900n 0.001001
+ 354.0000n 0.001027 354.0100n 0.001052 354.0200n 0.001078 354.0300n 0.001103 354.0400n 0.001128 354.0500n 0.001153 354.0600n 0.001178 354.0700n 0.001202 354.0800n 0.001227 354.0900n 0.001251 354.1000n 0.001275 354.1100n 0.001299 354.1200n 0.001323 354.1300n 0.001346 354.1400n 0.001369
+ 354.1500n 0.001392 354.1600n 0.001415 354.1700n 0.001438 354.1800n 0.001460 354.1900n 0.001482 354.2000n 0.001504 354.2100n 0.001526 354.2200n 0.001547 354.2300n 0.001568 354.2400n 0.001589 354.2500n 0.001610 354.2600n 0.001630 354.2700n 0.001650 354.2800n 0.001670 354.2900n 0.001689
+ 354.3000n 0.001709 354.3100n 0.001727 354.3200n 0.001746 354.3300n 0.001764 354.3400n 0.001782 354.3500n 0.001800 354.3600n 0.001817 354.3700n 0.001834 354.3800n 0.001851 354.3900n 0.001867 354.4000n 0.001883 354.4100n 0.001898 354.4200n 0.001914 354.4300n 0.001928 354.4400n 0.001943
+ 354.4500n 0.001957 354.4600n 0.001971 354.4700n 0.001984 354.4800n 0.001997 354.4900n 0.002010 354.5000n 0.002022 354.5100n 0.002034 354.5200n 0.002046 354.5300n 0.002057 354.5400n 0.002067 354.5500n 0.002078 354.5600n 0.002088 354.5700n 0.002097 354.5800n 0.002106 354.5900n 0.002115
+ 354.6000n 0.002123 354.6100n 0.002131 354.6200n 0.002138 354.6300n 0.002145 354.6400n 0.002152 354.6500n 0.002158 354.6600n 0.002164 354.6700n 0.002169 354.6800n 0.002174 354.6900n 0.002178 354.7000n 0.002182 354.7100n 0.002186 354.7200n 0.002189 354.7300n 0.002191 354.7400n 0.002194
+ 354.7500n 0.002195 354.7600n 0.002197 354.7700n 0.002198 354.7800n 0.002198 354.7900n 0.002198 354.8000n 0.002198 354.8100n 0.002197 354.8200n 0.002196 354.8300n 0.002194 354.8400n 0.002192 354.8500n 0.002189 354.8600n 0.002186 354.8700n 0.002182 354.8800n 0.002179 354.8900n 0.002174
+ 354.9000n 0.002169 354.9100n 0.002164 354.9200n 0.002159 354.9300n 0.002153 354.9400n 0.002146 354.9500n 0.002139 354.9600n 0.002132 354.9700n 0.002124 354.9800n 0.002116 354.9900n 0.002107 355.0000n 0.002098 355.0100n 0.002089 355.0200n 0.002079 355.0300n 0.002069 355.0400n 0.002058
+ 355.0500n 0.002047 355.0600n 0.002036 355.0700n 0.002024 355.0800n 0.002012 355.0900n 0.001999 355.1000n 0.001987 355.1100n 0.001973 355.1200n 0.001960 355.1300n 0.001946 355.1400n 0.001931 355.1500n 0.001916 355.1600n 0.001901 355.1700n 0.001886 355.1800n 0.001870 355.1900n 0.001854
+ 355.2000n 0.001838 355.2100n 0.001821 355.2200n 0.001804 355.2300n 0.001787 355.2400n 0.001769 355.2500n 0.001751 355.2600n 0.001733 355.2700n 0.001714 355.2800n 0.001695 355.2900n 0.001676 355.3000n 0.001656 355.3100n 0.001637 355.3200n 0.001617 355.3300n 0.001597 355.3400n 0.001576
+ 355.3500n 0.001555 355.3600n 0.001535 355.3700n 0.001513 355.3800n 0.001492 355.3900n 0.001470 355.4000n 0.001449 355.4100n 0.001426 355.4200n 0.001404 355.4300n 0.001382 355.4400n 0.001359 355.4500n 0.001336 355.4600n 0.001313 355.4700n 0.001290 355.4800n 0.001267 355.4900n 0.001244
+ 355.5000n 0.001220 355.5100n 0.001196 355.5200n 0.001173 355.5300n 0.001149 355.5400n 0.001124 355.5500n 0.001100 355.5600n 0.001076 355.5700n 0.001052 355.5800n 0.001027 355.5900n 0.001003 355.6000n 0.000978 355.6100n 0.000953 355.6200n 0.000928 355.6300n 0.000904 355.6400n 0.000879
+ 355.6500n 0.000854 355.6600n 0.000829 355.6700n 0.000804 355.6800n 0.000779 355.6900n 0.000754 355.7000n 0.000729 355.7100n 0.000704 355.7200n 0.000679 355.7300n 0.000653 355.7400n 0.000628 355.7500n 0.000603 355.7600n 0.000578 355.7700n 0.000554 355.7800n 0.000529 355.7900n 0.000504
+ 355.8000n 0.000479 355.8100n 0.000454 355.8200n 0.000430 355.8300n 0.000405 355.8400n 0.000380 355.8500n 0.000356 355.8600n 0.000332 355.8700n 0.000307 355.8800n 0.000283 355.8900n 0.000259 355.9000n 0.000235 355.9100n 0.000211 355.9200n 0.000187 355.9300n 0.000164 355.9400n 0.000140
+ 355.9500n 0.000117 355.9600n 0.000094 355.9700n 0.000071 355.9800n 0.000048 355.9900n 0.000025 356.0000n 0.000002 356.0100n -0.000020 356.0200n -0.000042 356.0300n -0.000065 356.0400n -0.000087 356.0500n -0.000108 356.0600n -0.000130 356.0700n -0.000151 356.0800n -0.000173 356.0900n -0.000194
+ 356.1000n -0.000215 356.1100n -0.000235 356.1200n -0.000256 356.1300n -0.000276 356.1400n -0.000296 356.1500n -0.000316 356.1600n -0.000336 356.1700n -0.000355 356.1800n -0.000374 356.1900n -0.000393 356.2000n -0.000412 356.2100n -0.000431 356.2200n -0.000449 356.2300n -0.000467 356.2400n -0.000485
+ 356.2500n -0.000503 356.2600n -0.000520 356.2700n -0.000538 356.2800n -0.000555 356.2900n -0.000571 356.3000n -0.000588 356.3100n -0.000604 356.3200n -0.000620 356.3300n -0.000636 356.3400n -0.000652 356.3500n -0.000667 356.3600n -0.000682 356.3700n -0.000697 356.3800n -0.000712 356.3900n -0.000726
+ 356.4000n -0.000740 356.4100n -0.000754 356.4200n -0.000768 356.4300n -0.000781 356.4400n -0.000795 356.4500n -0.000808 356.4600n -0.000820 356.4700n -0.000833 356.4800n -0.000845 356.4900n -0.000857 356.5000n -0.000869 356.5100n -0.000881 356.5200n -0.000892 356.5300n -0.000903 356.5400n -0.000914
+ 356.5500n -0.000924 356.5600n -0.000935 356.5700n -0.000945 356.5800n -0.000955 356.5900n -0.000965 356.6000n -0.000974 356.6100n -0.000984 356.6200n -0.000993 356.6300n -0.001002 356.6400n -0.001010 356.6500n -0.001019 356.6600n -0.001027 356.6700n -0.001035 356.6800n -0.001043 356.6900n -0.001050
+ 356.7000n -0.001058 356.7100n -0.001065 356.7200n -0.001072 356.7300n -0.001079 356.7400n -0.001086 356.7500n -0.001092 356.7600n -0.001098 356.7700n -0.001104 356.7800n -0.001110 356.7900n -0.001116 356.8000n -0.001122 356.8100n -0.001127 356.8200n -0.001132 356.8300n -0.001137 356.8400n -0.001142
+ 356.8500n -0.001147 356.8600n -0.001151 356.8700n -0.001156 356.8800n -0.001160 356.8900n -0.001164 356.9000n -0.001168 356.9100n -0.001172 356.9200n -0.001175 356.9300n -0.001179 356.9400n -0.001182 356.9500n -0.001186 356.9600n -0.001189 356.9700n -0.001192 356.9800n -0.001195 356.9900n -0.001197
+ 357.0000n -0.001200 357.0100n -0.001203 357.0200n -0.001205 357.0300n -0.001207 357.0400n -0.001210 357.0500n -0.001212 357.0600n -0.001214 357.0700n -0.001216 357.0800n -0.001217 357.0900n -0.001219 357.1000n -0.001221 357.1100n -0.001222 357.1200n -0.001224 357.1300n -0.001225 357.1400n -0.001227
+ 357.1500n -0.001228 357.1600n -0.001229 357.1700n -0.001230 357.1800n -0.001231 357.1900n -0.001232 357.2000n -0.001233 357.2100n -0.001234 357.2200n -0.001235 357.2300n -0.001236 357.2400n -0.001237 357.2500n -0.001238 357.2600n -0.001238 357.2700n -0.001239 357.2800n -0.001240 357.2900n -0.001240
+ 357.3000n -0.001241 357.3100n -0.001241 357.3200n -0.001242 357.3300n -0.001242 357.3400n -0.001243 357.3500n -0.001243 357.3600n -0.001244 357.3700n -0.001244 357.3800n -0.001244 357.3900n -0.001245 357.4000n -0.001245 357.4100n -0.001246 357.4200n -0.001246 357.4300n -0.001246 357.4400n -0.001247
+ 357.4500n -0.001247 357.4600n -0.001248 357.4700n -0.001248 357.4800n -0.001248 357.4900n -0.001249 357.5000n -0.001249 357.5100n -0.001250 357.5200n -0.001250 357.5300n -0.001251 357.5400n -0.001251 357.5500n -0.001252 357.5600n -0.001252 357.5700n -0.001253 357.5800n -0.001253 357.5900n -0.001254
+ 357.6000n -0.001255 357.6100n -0.001255 357.6200n -0.001256 357.6300n -0.001257 357.6400n -0.001257 357.6500n -0.001258 357.6600n -0.001259 357.6700n -0.001260 357.6800n -0.001260 357.6900n -0.001261 357.7000n -0.001262 357.7100n -0.001263 357.7200n -0.001264 357.7300n -0.001265 357.7400n -0.001266
+ 357.7500n -0.001267 357.7600n -0.001268 357.7700n -0.001269 357.7800n -0.001270 357.7900n -0.001271 357.8000n -0.001272 357.8100n -0.001274 357.8200n -0.001275 357.8300n -0.001276 357.8400n -0.001277 357.8500n -0.001279 357.8600n -0.001280 357.8700n -0.001281 357.8800n -0.001283 357.8900n -0.001284
+ 357.9000n -0.001286 357.9100n -0.001287 357.9200n -0.001288 357.9300n -0.001290 357.9400n -0.001291 357.9500n -0.001293 357.9600n -0.001294 357.9700n -0.001296 357.9800n -0.001297 357.9900n -0.001299 358.0000n -0.001301 358.0100n -0.001302 358.0200n -0.001304 358.0300n -0.001305 358.0400n -0.001307
+ 358.0500n -0.001308 358.0600n -0.001310 358.0700n -0.001312 358.0800n -0.001313 358.0900n -0.001315 358.1000n -0.001316 358.1100n -0.001318 358.1200n -0.001319 358.1300n -0.001321 358.1400n -0.001322 358.1500n -0.001324 358.1600n -0.001325 358.1700n -0.001327 358.1800n -0.001328 358.1900n -0.001330
+ 358.2000n -0.001331 358.2100n -0.001333 358.2200n -0.001334 358.2300n -0.001335 358.2400n -0.001337 358.2500n -0.001338 358.2600n -0.001339 358.2700n -0.001340 358.2800n -0.001341 358.2900n -0.001342 358.3000n -0.001343 358.3100n -0.001344 358.3200n -0.001345 358.3300n -0.001346 358.3400n -0.001347
+ 358.3500n -0.001348 358.3600n -0.001348 358.3700n -0.001349 358.3800n -0.001350 358.3900n -0.001350 358.4000n -0.001351 358.4100n -0.001351 358.4200n -0.001351 358.4300n -0.001351 358.4400n -0.001352 358.4500n -0.001352 358.4600n -0.001352 358.4700n -0.001352 358.4800n -0.001351 358.4900n -0.001351
+ 358.5000n -0.001351 358.5100n -0.001350 358.5200n -0.001350 358.5300n -0.001349 358.5400n -0.001348 358.5500n -0.001348 358.5600n -0.001347 358.5700n -0.001346 358.5800n -0.001345 358.5900n -0.001343 358.6000n -0.001342 358.6100n -0.001341 358.6200n -0.001339 358.6300n -0.001337 358.6400n -0.001336
+ 358.6500n -0.001334 358.6600n -0.001332 358.6700n -0.001330 358.6800n -0.001327 358.6900n -0.001325 358.7000n -0.001323 358.7100n -0.001320 358.7200n -0.001318 358.7300n -0.001315 358.7400n -0.001312 358.7500n -0.001309 358.7600n -0.001306 358.7700n -0.001302 358.7800n -0.001299 358.7900n -0.001295
+ 358.8000n -0.001292 358.8100n -0.001288 358.8200n -0.001284 358.8300n -0.001280 358.8400n -0.001276 358.8500n -0.001272 358.8600n -0.001268 358.8700n -0.001263 358.8800n -0.001258 358.8900n -0.001254 358.9000n -0.001249 358.9100n -0.001244 358.9200n -0.001239 358.9300n -0.001234 358.9400n -0.001228
+ 358.9500n -0.001223 358.9600n -0.001217 358.9700n -0.001212 358.9800n -0.001206 358.9900n -0.001200 359.0000n -0.001194 359.0100n -0.001188 359.0200n -0.001182 359.0300n -0.001175 359.0400n -0.001169 359.0500n -0.001162 359.0600n -0.001156 359.0700n -0.001149 359.0800n -0.001142 359.0900n -0.001135
+ 359.1000n -0.001128 359.1100n -0.001121 359.1200n -0.001113 359.1300n -0.001106 359.1400n -0.001099 359.1500n -0.001091 359.1600n -0.001083 359.1700n -0.001076 359.1800n -0.001068 359.1900n -0.001060 359.2000n -0.001052 359.2100n -0.001044 359.2200n -0.001036 359.2300n -0.001028 359.2400n -0.001020
+ 359.2500n -0.001011 359.2600n -0.001003 359.2700n -0.000995 359.2800n -0.000986 359.2900n -0.000978 359.3000n -0.000969 359.3100n -0.000960 359.3200n -0.000952 359.3300n -0.000943 359.3400n -0.000934 359.3500n -0.000925 359.3600n -0.000916 359.3700n -0.000908 359.3800n -0.000899 359.3900n -0.000890
+ 359.4000n -0.000881 359.4100n -0.000872 359.4200n -0.000863 359.4300n -0.000854 359.4400n -0.000845 359.4500n -0.000836 359.4600n -0.000827 359.4700n -0.000818 359.4800n -0.000808 359.4900n -0.000799 359.5000n -0.000790 359.5100n -0.000781 359.5200n -0.000772 359.5300n -0.000763 359.5400n -0.000754
+ 359.5500n -0.000745 359.5600n -0.000736 359.5700n -0.000727 359.5800n -0.000718 359.5900n -0.000709 359.6000n -0.000701 359.6100n -0.000692 359.6200n -0.000683 359.6300n -0.000674 359.6400n -0.000665 359.6500n -0.000657 359.6600n -0.000648 359.6700n -0.000639 359.6800n -0.000631 359.6900n -0.000622
+ 359.7000n -0.000614 359.7100n -0.000606 359.7200n -0.000597 359.7300n -0.000589 359.7400n -0.000581 359.7500n -0.000573 359.7600n -0.000565 359.7700n -0.000557 359.7800n -0.000549 359.7900n -0.000541 359.8000n -0.000533 359.8100n -0.000525 359.8200n -0.000517 359.8300n -0.000510 359.8400n -0.000502
+ 359.8500n -0.000495 359.8600n -0.000487 359.8700n -0.000480 359.8800n -0.000473 359.8900n -0.000466 359.9000n -0.000459 359.9100n -0.000452 359.9200n -0.000445 359.9300n -0.000438 359.9400n -0.000431 359.9500n -0.000425 359.9600n -0.000418 359.9700n -0.000411 359.9800n -0.000405 359.9900n -0.000399
+ 360.0000n -0.000392 360.0100n -0.000386 360.0200n -0.000380 360.0300n -0.000374 360.0400n -0.000368 360.0500n -0.000362 360.0600n -0.000356 360.0700n -0.000351 360.0800n -0.000345 360.0900n -0.000339 360.1000n -0.000334 360.1100n -0.000328 360.1200n -0.000323 360.1300n -0.000318 360.1400n -0.000313
+ 360.1500n -0.000307 360.1600n -0.000302 360.1700n -0.000297 360.1800n -0.000292 360.1900n -0.000287 360.2000n -0.000282 360.2100n -0.000278 360.2200n -0.000273 360.2300n -0.000268 360.2400n -0.000263 360.2500n -0.000259 360.2600n -0.000254 360.2700n -0.000250 360.2800n -0.000245 360.2900n -0.000241
+ 360.3000n -0.000236 360.3100n -0.000232 360.3200n -0.000227 360.3300n -0.000223 360.3400n -0.000219 360.3500n -0.000214 360.3600n -0.000210 360.3700n -0.000206 360.3800n -0.000202 360.3900n -0.000197 360.4000n -0.000193 360.4100n -0.000189 360.4200n -0.000185 360.4300n -0.000180 360.4400n -0.000176
+ 360.4500n -0.000172 360.4600n -0.000168 360.4700n -0.000163 360.4800n -0.000159 360.4900n -0.000155 360.5000n -0.000150 360.5100n -0.000146 360.5200n -0.000142 360.5300n -0.000137 360.5400n -0.000133 360.5500n -0.000129 360.5600n -0.000124 360.5700n -0.000120 360.5800n -0.000115 360.5900n -0.000110
+ 360.6000n -0.000106 360.6100n -0.000101 360.6200n -0.000096 360.6300n -0.000092 360.6400n -0.000087 360.6500n -0.000082 360.6600n -0.000077 360.6700n -0.000072 360.6800n -0.000067 360.6900n -0.000062 360.7000n -0.000056 360.7100n -0.000051 360.7200n -0.000046 360.7300n -0.000041 360.7400n -0.000035
+ 360.7500n -0.000030 360.7600n -0.000024 360.7700n -0.000018 360.7800n -0.000013 360.7900n -0.000007 360.8000n -0.000001 360.8100n 0.000005 360.8200n 0.000011 360.8300n 0.000017 360.8400n 0.000023 360.8500n 0.000029 360.8600n 0.000036 360.8700n 0.000042 360.8800n 0.000048 360.8900n 0.000055
+ 360.9000n 0.000062 360.9100n 0.000068 360.9200n 0.000075 360.9300n 0.000082 360.9400n 0.000089 360.9500n 0.000096 360.9600n 0.000102 360.9700n 0.000110 360.9800n 0.000117 360.9900n 0.000124 361.0000n 0.000131 361.0100n 0.000138 361.0200n 0.000146 361.0300n 0.000153 361.0400n 0.000160
+ 361.0500n 0.000168 361.0600n 0.000175 361.0700n 0.000183 361.0800n 0.000190 361.0900n 0.000198 361.1000n 0.000206 361.1100n 0.000213 361.1200n 0.000221 361.1300n 0.000229 361.1400n 0.000236 361.1500n 0.000244 361.1600n 0.000252 361.1700n 0.000259 361.1800n 0.000267 361.1900n 0.000275
+ 361.2000n 0.000282 361.2100n 0.000290 361.2200n 0.000298 361.2300n 0.000305 361.2400n 0.000313 361.2500n 0.000321 361.2600n 0.000328 361.2700n 0.000335 361.2800n 0.000343 361.2900n 0.000350 361.3000n 0.000358 361.3100n 0.000365 361.3200n 0.000372 361.3300n 0.000379 361.3400n 0.000386
+ 361.3500n 0.000393 361.3600n 0.000400 361.3700n 0.000406 361.3800n 0.000413 361.3900n 0.000419 361.4000n 0.000425 361.4100n 0.000432 361.4200n 0.000438 361.4300n 0.000444 361.4400n 0.000449 361.4500n 0.000455 361.4600n 0.000461 361.4700n 0.000466 361.4800n 0.000471 361.4900n 0.000476
+ 361.5000n 0.000481 361.5100n 0.000485 361.5200n 0.000490 361.5300n 0.000494 361.5400n 0.000498 361.5500n 0.000502 361.5600n 0.000505 361.5700n 0.000508 361.5800n 0.000512 361.5900n 0.000514 361.6000n 0.000517 361.6100n 0.000519 361.6200n 0.000522 361.6300n 0.000523 361.6400n 0.000525
+ 361.6500n 0.000526 361.6600n 0.000527 361.6700n 0.000528 361.6800n 0.000529 361.6900n 0.000529 361.7000n 0.000529 361.7100n 0.000529 361.7200n 0.000528 361.7300n 0.000527 361.7400n 0.000526 361.7500n 0.000524 361.7600n 0.000523 361.7700n 0.000520 361.7800n 0.000518 361.7900n 0.000515
+ 361.8000n 0.000512 361.8100n 0.000509 361.8200n 0.000505 361.8300n 0.000501 361.8400n 0.000496 361.8500n 0.000491 361.8600n 0.000486 361.8700n 0.000481 361.8800n 0.000475 361.8900n 0.000469 361.9000n 0.000463 361.9100n 0.000456 361.9200n 0.000449 361.9300n 0.000441 361.9400n 0.000434
+ 361.9500n 0.000425 361.9600n 0.000417 361.9700n 0.000408 361.9800n 0.000399 361.9900n 0.000390 362.0000n 0.000380 362.0100n 0.000370 362.0200n 0.000359 362.0300n 0.000349 362.0400n 0.000338 362.0500n 0.000326 362.0600n 0.000314 362.0700n 0.000302 362.0800n 0.000290 362.0900n 0.000278
+ 362.1000n 0.000265 362.1100n 0.000251 362.1200n 0.000238 362.1300n 0.000224 362.1400n 0.000210 362.1500n 0.000196 362.1600n 0.000181 362.1700n 0.000167 362.1800n 0.000152 362.1900n 0.000136 362.2000n 0.000121 362.2100n 0.000105 362.2200n 0.000089 362.2300n 0.000073 362.2400n 0.000056
+ 362.2500n 0.000040 362.2600n 0.000023 362.2700n 0.000006 362.2800n -0.000011 362.2900n -0.000028 362.3000n -0.000046 362.3100n -0.000063 362.3200n -0.000081 362.3300n -0.000099 362.3400n -0.000117 362.3500n -0.000135 362.3600n -0.000153 362.3700n -0.000171 362.3800n -0.000190 362.3900n -0.000208
+ 362.4000n -0.000226 362.4100n -0.000245 362.4200n -0.000263 362.4300n -0.000282 362.4400n -0.000300 362.4500n -0.000319 362.4600n -0.000337 362.4700n -0.000356 362.4800n -0.000374 362.4900n -0.000392 362.5000n -0.000410 362.5100n -0.000429 362.5200n -0.000447 362.5300n -0.000465 362.5400n -0.000482
+ 362.5500n -0.000500 362.5600n -0.000518 362.5700n -0.000535 362.5800n -0.000552 362.5900n -0.000569 362.6000n -0.000586 362.6100n -0.000603 362.6200n -0.000619 362.6300n -0.000635 362.6400n -0.000651 362.6500n -0.000667 362.6600n -0.000682 362.6700n -0.000697 362.6800n -0.000712 362.6900n -0.000726
+ 362.7000n -0.000741 362.7100n -0.000754 362.7200n -0.000768 362.7300n -0.000781 362.7400n -0.000794 362.7500n -0.000806 362.7600n -0.000818 362.7700n -0.000830 362.7800n -0.000841 362.7900n -0.000852 362.8000n -0.000862 362.8100n -0.000872 362.8200n -0.000881 362.8300n -0.000890 362.8400n -0.000898
+ 362.8500n -0.000906 362.8600n -0.000914 362.8700n -0.000921 362.8800n -0.000927 362.8900n -0.000933 362.9000n -0.000938 362.9100n -0.000943 362.9200n -0.000947 362.9300n -0.000951 362.9400n -0.000954 362.9500n -0.000957 362.9600n -0.000959 362.9700n -0.000960 362.9800n -0.000961 362.9900n -0.000961
+ 363.0000n -0.000961 363.0100n -0.000960 363.0200n -0.000958 363.0300n -0.000956 363.0400n -0.000953 363.0500n -0.000950 363.0600n -0.000946 363.0700n -0.000941 363.0800n -0.000936 363.0900n -0.000930 363.1000n -0.000923 363.1100n -0.000916 363.1200n -0.000908 363.1300n -0.000899 363.1400n -0.000890
+ 363.1500n -0.000880 363.1600n -0.000869 363.1700n -0.000858 363.1800n -0.000847 363.1900n -0.000834 363.2000n -0.000821 363.2100n -0.000807 363.2200n -0.000793 363.2300n -0.000778 363.2400n -0.000763 363.2500n -0.000746 363.2600n -0.000730 363.2700n -0.000712 363.2800n -0.000694 363.2900n -0.000676
+ 363.3000n -0.000656 363.3100n -0.000636 363.3200n -0.000616 363.3300n -0.000595 363.3400n -0.000574 363.3500n -0.000552 363.3600n -0.000529 363.3700n -0.000506 363.3800n -0.000482 363.3900n -0.000458 363.4000n -0.000433 363.4100n -0.000408 363.4200n -0.000382 363.4300n -0.000356 363.4400n -0.000329
+ 363.4500n -0.000302 363.4600n -0.000274 363.4700n -0.000246 363.4800n -0.000218 363.4900n -0.000189 363.5000n -0.000160 363.5100n -0.000130 363.5200n -0.000100 363.5300n -0.000070 363.5400n -0.000039 363.5500n -0.000008 363.5600n 0.000023 363.5700n 0.000055 363.5800n 0.000087 363.5900n 0.000119
+ 363.6000n 0.000151 363.6100n 0.000184 363.6200n 0.000217 363.6300n 0.000250 363.6400n 0.000283 363.6500n 0.000316 363.6600n 0.000350 363.6700n 0.000383 363.6800n 0.000417 363.6900n 0.000451 363.7000n 0.000485 363.7100n 0.000519 363.7200n 0.000553 363.7300n 0.000587 363.7400n 0.000621
+ 363.7500n 0.000656 363.7600n 0.000690 363.7700n 0.000724 363.7800n 0.000758 363.7900n 0.000792 363.8000n 0.000825 363.8100n 0.000859 363.8200n 0.000893 363.8300n 0.000926 363.8400n 0.000959 363.8500n 0.000992 363.8600n 0.001025 363.8700n 0.001058 363.8800n 0.001090 363.8900n 0.001122
+ 363.9000n 0.001154 363.9100n 0.001186 363.9200n 0.001217 363.9300n 0.001248 363.9400n 0.001279 363.9500n 0.001309 363.9600n 0.001339 363.9700n 0.001368 363.9800n 0.001397 363.9900n 0.001426 364.0000n 0.001454 364.0100n 0.001482 364.0200n 0.001509 364.0300n 0.001536 364.0400n 0.001562
+ 364.0500n 0.001588 364.0600n 0.001614 364.0700n 0.001638 364.0800n 0.001662 364.0900n 0.001686 364.1000n 0.001709 364.1100n 0.001732 364.1200n 0.001754 364.1300n 0.001775 364.1400n 0.001795 364.1500n 0.001815 364.1600n 0.001835 364.1700n 0.001853 364.1800n 0.001871 364.1900n 0.001889
+ 364.2000n 0.001905 364.2100n 0.001921 364.2200n 0.001937 364.2300n 0.001951 364.2400n 0.001965 364.2500n 0.001978 364.2600n 0.001991 364.2700n 0.002002 364.2800n 0.002013 364.2900n 0.002023 364.3000n 0.002033 364.3100n 0.002041 364.3200n 0.002049 364.3300n 0.002057 364.3400n 0.002063
+ 364.3500n 0.002069 364.3600n 0.002073 364.3700n 0.002077 364.3800n 0.002081 364.3900n 0.002083 364.4000n 0.002085 364.4100n 0.002086 364.4200n 0.002086 364.4300n 0.002085 364.4400n 0.002084 364.4500n 0.002082 364.4600n 0.002079 364.4700n 0.002075 364.4800n 0.002071 364.4900n 0.002066
+ 364.5000n 0.002060 364.5100n 0.002053 364.5200n 0.002046 364.5300n 0.002038 364.5400n 0.002029 364.5500n 0.002019 364.5600n 0.002009 364.5700n 0.001998 364.5800n 0.001986 364.5900n 0.001974 364.6000n 0.001960 364.6100n 0.001947 364.6200n 0.001932 364.6300n 0.001917 364.6400n 0.001901
+ 364.6500n 0.001885 364.6600n 0.001868 364.6700n 0.001850 364.6800n 0.001832 364.6900n 0.001813 364.7000n 0.001793 364.7100n 0.001773 364.7200n 0.001753 364.7300n 0.001732 364.7400n 0.001710 364.7500n 0.001688 364.7600n 0.001665 364.7700n 0.001642 364.7800n 0.001618 364.7900n 0.001594
+ 364.8000n 0.001569 364.8100n 0.001544 364.8200n 0.001519 364.8300n 0.001493 364.8400n 0.001467 364.8500n 0.001440 364.8600n 0.001413 364.8700n 0.001386 364.8800n 0.001358 364.8900n 0.001330 364.9000n 0.001302 364.9100n 0.001274 364.9200n 0.001245 364.9300n 0.001216 364.9400n 0.001187
+ 364.9500n 0.001157 364.9600n 0.001128 364.9700n 0.001098 364.9800n 0.001068 364.9900n 0.001038 365.0000n 0.001007 365.0100n 0.000977 365.0200n 0.000947 365.0300n 0.000916 365.0400n 0.000885 365.0500n 0.000855 365.0600n 0.000824 365.0700n 0.000793 365.0800n 0.000763 365.0900n 0.000732
+ 365.1000n 0.000701 365.1100n 0.000671 365.1200n 0.000640 365.1300n 0.000610 365.1400n 0.000579 365.1500n 0.000549 365.1600n 0.000519 365.1700n 0.000489 365.1800n 0.000459 365.1900n 0.000429 365.2000n 0.000400 365.2100n 0.000370 365.2200n 0.000341 365.2300n 0.000312 365.2400n 0.000284
+ 365.2500n 0.000255 365.2600n 0.000227 365.2700n 0.000199 365.2800n 0.000172 365.2900n 0.000144 365.3000n 0.000117 365.3100n 0.000091 365.3200n 0.000064 365.3300n 0.000038 365.3400n 0.000013 365.3500n -0.000012 365.3600n -0.000037 365.3700n -0.000062 365.3800n -0.000086 365.3900n -0.000110
+ 365.4000n -0.000133 365.4100n -0.000156 365.4200n -0.000179 365.4300n -0.000201 365.4400n -0.000223 365.4500n -0.000244 365.4600n -0.000265 365.4700n -0.000285 365.4800n -0.000305 365.4900n -0.000325 365.5000n -0.000344 365.5100n -0.000362 365.5200n -0.000381 365.5300n -0.000398 365.5400n -0.000415
+ 365.5500n -0.000432 365.5600n -0.000448 365.5700n -0.000464 365.5800n -0.000480 365.5900n -0.000494 365.6000n -0.000509 365.6100n -0.000523 365.6200n -0.000536 365.6300n -0.000549 365.6400n -0.000562 365.6500n -0.000574 365.6600n -0.000585 365.6700n -0.000596 365.6800n -0.000607 365.6900n -0.000617
+ 365.7000n -0.000627 365.7100n -0.000636 365.7200n -0.000645 365.7300n -0.000654 365.7400n -0.000662 365.7500n -0.000669 365.7600n -0.000676 365.7700n -0.000683 365.7800n -0.000689 365.7900n -0.000695 365.8000n -0.000701 365.8100n -0.000706 365.8200n -0.000711 365.8300n -0.000715 365.8400n -0.000719
+ 365.8500n -0.000723 365.8600n -0.000726 365.8700n -0.000729 365.8800n -0.000732 365.8900n -0.000734 365.9000n -0.000736 365.9100n -0.000738 365.9200n -0.000739 365.9300n -0.000740 365.9400n -0.000741 365.9500n -0.000742 365.9600n -0.000742 365.9700n -0.000742 365.9800n -0.000742 365.9900n -0.000742
+ 366.0000n -0.000741 366.0100n -0.000741 366.0200n -0.000740 366.0300n -0.000739 366.0400n -0.000737 366.0500n -0.000736 366.0600n -0.000735 366.0700n -0.000733 366.0800n -0.000731 366.0900n -0.000729 366.1000n -0.000727 366.1100n -0.000725 366.1200n -0.000723 366.1300n -0.000721 366.1400n -0.000719
+ 366.1500n -0.000716 366.1600n -0.000714 366.1700n -0.000712 366.1800n -0.000709 366.1900n -0.000707 366.2000n -0.000705 366.2100n -0.000703 366.2200n -0.000700 366.2300n -0.000698 366.2400n -0.000696 366.2500n -0.000694 366.2600n -0.000692 366.2700n -0.000690 366.2800n -0.000688 366.2900n -0.000687
+ 366.3000n -0.000685 366.3100n -0.000684 366.3200n -0.000682 366.3300n -0.000681 366.3400n -0.000680 366.3500n -0.000680 366.3600n -0.000679 366.3700n -0.000678 366.3800n -0.000678 366.3900n -0.000678 366.4000n -0.000678 366.4100n -0.000679 366.4200n -0.000679 366.4300n -0.000680 366.4400n -0.000681
+ 366.4500n -0.000682 366.4600n -0.000683 366.4700n -0.000685 366.4800n -0.000687 366.4900n -0.000689 366.5000n -0.000692 366.5100n -0.000694 366.5200n -0.000697 366.5300n -0.000701 366.5400n -0.000704 366.5500n -0.000708 366.5600n -0.000712 366.5700n -0.000716 366.5800n -0.000721 366.5900n -0.000726
+ 366.6000n -0.000731 366.6100n -0.000736 366.6200n -0.000742 366.6300n -0.000748 366.6400n -0.000754 366.6500n -0.000761 366.6600n -0.000768 366.6700n -0.000775 366.6800n -0.000782 366.6900n -0.000790 366.7000n -0.000798 366.7100n -0.000806 366.7200n -0.000814 366.7300n -0.000823 366.7400n -0.000832
+ 366.7500n -0.000841 366.7600n -0.000851 366.7700n -0.000860 366.7800n -0.000870 366.7900n -0.000881 366.8000n -0.000891 366.8100n -0.000902 366.8200n -0.000912 366.8300n -0.000923 366.8400n -0.000935 366.8500n -0.000946 366.8600n -0.000958 366.8700n -0.000969 366.8800n -0.000981 366.8900n -0.000993
+ 366.9000n -0.001006 366.9100n -0.001018 366.9200n -0.001031 366.9300n -0.001043 366.9400n -0.001056 366.9500n -0.001069 366.9600n -0.001082 366.9700n -0.001095 366.9800n -0.001108 366.9900n -0.001121 367.0000n -0.001135 367.0100n -0.001148 367.0200n -0.001161 367.0300n -0.001175 367.0400n -0.001188
+ 367.0500n -0.001202 367.0600n -0.001215 367.0700n -0.001228 367.0800n -0.001242 367.0900n -0.001255 367.1000n -0.001268 367.1100n -0.001281 367.1200n -0.001295 367.1300n -0.001308 367.1400n -0.001321 367.1500n -0.001333 367.1600n -0.001346 367.1700n -0.001359 367.1800n -0.001371 367.1900n -0.001383
+ 367.2000n -0.001395 367.2100n -0.001407 367.2200n -0.001419 367.2300n -0.001431 367.2400n -0.001442 367.2500n -0.001453 367.2600n -0.001464 367.2700n -0.001474 367.2800n -0.001485 367.2900n -0.001495 367.3000n -0.001504 367.3100n -0.001514 367.3200n -0.001523 367.3300n -0.001532 367.3400n -0.001540
+ 367.3500n -0.001549 367.3600n -0.001556 367.3700n -0.001564 367.3800n -0.001571 367.3900n -0.001578 367.4000n -0.001584 367.4100n -0.001590 367.4200n -0.001596 367.4300n -0.001601 367.4400n -0.001606 367.4500n -0.001610 367.4600n -0.001614 367.4700n -0.001617 367.4800n -0.001620 367.4900n -0.001623
+ 367.5000n -0.001625 367.5100n -0.001626 367.5200n -0.001627 367.5300n -0.001628 367.5400n -0.001628 367.5500n -0.001628 367.5600n -0.001627 367.5700n -0.001625 367.5800n -0.001623 367.5900n -0.001621 367.6000n -0.001618 367.6100n -0.001614 367.6200n -0.001610 367.6300n -0.001606 367.6400n -0.001601
+ 367.6500n -0.001595 367.6600n -0.001589 367.6700n -0.001582 367.6800n -0.001575 367.6900n -0.001567 367.7000n -0.001559 367.7100n -0.001550 367.7200n -0.001540 367.7300n -0.001530 367.7400n -0.001520 367.7500n -0.001508 367.7600n -0.001497 367.7700n -0.001484 367.7800n -0.001472 367.7900n -0.001458
+ 367.8000n -0.001444 367.8100n -0.001430 367.8200n -0.001415 367.8300n -0.001399 367.8400n -0.001383 367.8500n -0.001367 367.8600n -0.001350 367.8700n -0.001332 367.8800n -0.001314 367.8900n -0.001295 367.9000n -0.001276 367.9100n -0.001256 367.9200n -0.001236 367.9300n -0.001215 367.9400n -0.001194
+ 367.9500n -0.001172 367.9600n -0.001150 367.9700n -0.001128 367.9800n -0.001105 367.9900n -0.001081 368.0000n -0.001057 368.0100n -0.001033 368.0200n -0.001008 368.0300n -0.000983 368.0400n -0.000957 368.0500n -0.000931 368.0600n -0.000904 368.0700n -0.000877 368.0800n -0.000850 368.0900n -0.000822
+ 368.1000n -0.000794 368.1100n -0.000766 368.1200n -0.000737 368.1300n -0.000708 368.1400n -0.000679 368.1500n -0.000649 368.1600n -0.000619 368.1700n -0.000589 368.1800n -0.000559 368.1900n -0.000528 368.2000n -0.000497 368.2100n -0.000465 368.2200n -0.000434 368.2300n -0.000402 368.2400n -0.000370
+ 368.2500n -0.000338 368.2600n -0.000306 368.2700n -0.000273 368.2800n -0.000241 368.2900n -0.000208 368.3000n -0.000175 368.3100n -0.000142 368.3200n -0.000108 368.3300n -0.000075 368.3400n -0.000041 368.3500n -0.000008 368.3600n 0.000026 368.3700n 0.000059 368.3800n 0.000093 368.3900n 0.000127
+ 368.4000n 0.000161 368.4100n 0.000194 368.4200n 0.000228 368.4300n 0.000262 368.4400n 0.000296 368.4500n 0.000329 368.4600n 0.000363 368.4700n 0.000397 368.4800n 0.000430 368.4900n 0.000464 368.5000n 0.000497 368.5100n 0.000531 368.5200n 0.000564 368.5300n 0.000597 368.5400n 0.000630
+ 368.5500n 0.000663 368.5600n 0.000695 368.5700n 0.000728 368.5800n 0.000760 368.5900n 0.000792 368.6000n 0.000824 368.6100n 0.000856 368.6200n 0.000888 368.6300n 0.000919 368.6400n 0.000950 368.6500n 0.000981 368.6600n 0.001012 368.6700n 0.001042 368.6800n 0.001072 368.6900n 0.001102
+ 368.7000n 0.001131 368.7100n 0.001161 368.7200n 0.001190 368.7300n 0.001218 368.7400n 0.001247 368.7500n 0.001275 368.7600n 0.001303 368.7700n 0.001330 368.7800n 0.001357 368.7900n 0.001384 368.8000n 0.001410 368.8100n 0.001436 368.8200n 0.001462 368.8300n 0.001487 368.8400n 0.001512
+ 368.8500n 0.001537 368.8600n 0.001561 368.8700n 0.001585 368.8800n 0.001608 368.8900n 0.001631 368.9000n 0.001654 368.9100n 0.001676 368.9200n 0.001698 368.9300n 0.001720 368.9400n 0.001741 368.9500n 0.001761 368.9600n 0.001781 368.9700n 0.001801 368.9800n 0.001820 368.9900n 0.001839
+ 369.0000n 0.001858 369.0100n 0.001876 369.0200n 0.001893 369.0300n 0.001911 369.0400n 0.001927 369.0500n 0.001944 369.0600n 0.001959 369.0700n 0.001975 369.0800n 0.001990 369.0900n 0.002004 369.1000n 0.002019 369.1100n 0.002032 369.1200n 0.002045 369.1300n 0.002058 369.1400n 0.002071
+ 369.1500n 0.002082 369.1600n 0.002094 369.1700n 0.002105 369.1800n 0.002115 369.1900n 0.002126 369.2000n 0.002135 369.2100n 0.002145 369.2200n 0.002153 369.2300n 0.002162 369.2400n 0.002170 369.2500n 0.002177 369.2600n 0.002184 369.2700n 0.002191 369.2800n 0.002197 369.2900n 0.002203
+ 369.3000n 0.002208 369.3100n 0.002213 369.3200n 0.002218 369.3300n 0.002222 369.3400n 0.002226 369.3500n 0.002229 369.3600n 0.002232 369.3700n 0.002234 369.3800n 0.002236 369.3900n 0.002238 369.4000n 0.002239 369.4100n 0.002240 369.4200n 0.002240 369.4300n 0.002240 369.4400n 0.002240
+ 369.4500n 0.002239 369.4600n 0.002238 369.4700n 0.002237 369.4800n 0.002235 369.4900n 0.002233 369.5000n 0.002230 369.5100n 0.002227 369.5200n 0.002224 369.5300n 0.002220 369.5400n 0.002216 369.5500n 0.002211 369.5600n 0.002206 369.5700n 0.002201 369.5800n 0.002196 369.5900n 0.002190
+ 369.6000n 0.002184 369.6100n 0.002177 369.6200n 0.002170 369.6300n 0.002163 369.6400n 0.002155 369.6500n 0.002147 369.6600n 0.002139 369.6700n 0.002131 369.6800n 0.002122 369.6900n 0.002112 369.7000n 0.002103 369.7100n 0.002093 369.7200n 0.002083 369.7300n 0.002072 369.7400n 0.002062
+ 369.7500n 0.002051 369.7600n 0.002039 369.7700n 0.002027 369.7800n 0.002016 369.7900n 0.002003 369.8000n 0.001991 369.8100n 0.001978 369.8200n 0.001965 369.8300n 0.001951 369.8400n 0.001938 369.8500n 0.001924 369.8600n 0.001909 369.8700n 0.001895 369.8800n 0.001880 369.8900n 0.001865
+ 369.9000n 0.001849 369.9100n 0.001834 369.9200n 0.001818 369.9300n 0.001802 369.9400n 0.001785 369.9500n 0.001769 369.9600n 0.001752 369.9700n 0.001735 369.9800n 0.001717 369.9900n 0.001700 370.0000n 0.001682 370.0100n 0.001664 370.0200n 0.001645 370.0300n 0.001627 370.0400n 0.001608
+ 370.0500n 0.001589 370.0600n 0.001570 370.0700n 0.001550 370.0800n 0.001530 370.0900n 0.001510 370.1000n 0.001490 370.1100n 0.001470 370.1200n 0.001449 370.1300n 0.001428 370.1400n 0.001407 370.1500n 0.001386 370.1600n 0.001365 370.1700n 0.001343 370.1800n 0.001321 370.1900n 0.001299
+ 370.2000n 0.001277 370.2100n 0.001255 370.2200n 0.001232 370.2300n 0.001209 370.2400n 0.001186 370.2500n 0.001163 370.2600n 0.001140 370.2700n 0.001116 370.2800n 0.001093 370.2900n 0.001069 370.3000n 0.001045 370.3100n 0.001021 370.3200n 0.000997 370.3300n 0.000972 370.3400n 0.000948
+ 370.3500n 0.000923 370.3600n 0.000898 370.3700n 0.000873 370.3800n 0.000848 370.3900n 0.000823 370.4000n 0.000797 370.4100n 0.000772 370.4200n 0.000746 370.4300n 0.000720 370.4400n 0.000695 370.4500n 0.000669 370.4600n 0.000643 370.4700n 0.000617 370.4800n 0.000590 370.4900n 0.000564
+ 370.5000n 0.000538 370.5100n 0.000511 370.5200n 0.000485 370.5300n 0.000458 370.5400n 0.000432 370.5500n 0.000405 370.5600n 0.000379 370.5700n 0.000352 370.5800n 0.000325 370.5900n 0.000298 370.6000n 0.000271 370.6100n 0.000245 370.6200n 0.000218 370.6300n 0.000191 370.6400n 0.000164
+ 370.6500n 0.000137 370.6600n 0.000111 370.6700n 0.000084 370.6800n 0.000057 370.6900n 0.000030 370.7000n 0.000004 370.7100n -0.000023 370.7200n -0.000049 370.7300n -0.000076 370.7400n -0.000102 370.7500n -0.000129 370.7600n -0.000155 370.7700n -0.000181 370.7800n -0.000207 370.7900n -0.000233
+ 370.8000n -0.000259 370.8100n -0.000285 370.8200n -0.000310 370.8300n -0.000336 370.8400n -0.000361 370.8500n -0.000386 370.8600n -0.000411 370.8700n -0.000436 370.8800n -0.000461 370.8900n -0.000485 370.9000n -0.000509 370.9100n -0.000534 370.9200n -0.000557 370.9300n -0.000581 370.9400n -0.000605
+ 370.9500n -0.000628 370.9600n -0.000651 370.9700n -0.000674 370.9800n -0.000696 370.9900n -0.000719 371.0000n -0.000741 371.0100n -0.000762 371.0200n -0.000784 371.0300n -0.000805 371.0400n -0.000826 371.0500n -0.000846 371.0600n -0.000867 371.0700n -0.000887 371.0800n -0.000906 371.0900n -0.000926
+ 371.1000n -0.000945 371.1100n -0.000963 371.1200n -0.000982 371.1300n -0.001000 371.1400n -0.001017 371.1500n -0.001035 371.1600n -0.001051 371.1700n -0.001068 371.1800n -0.001084 371.1900n -0.001100 371.2000n -0.001115 371.2100n -0.001130 371.2200n -0.001144 371.2300n -0.001159 371.2400n -0.001172
+ 371.2500n -0.001186 371.2600n -0.001198 371.2700n -0.001211 371.2800n -0.001223 371.2900n -0.001234 371.3000n -0.001245 371.3100n -0.001256 371.3200n -0.001266 371.3300n -0.001276 371.3400n -0.001285 371.3500n -0.001294 371.3600n -0.001302 371.3700n -0.001310 371.3800n -0.001318 371.3900n -0.001325
+ 371.4000n -0.001331 371.4100n -0.001337 371.4200n -0.001343 371.4300n -0.001348 371.4400n -0.001352 371.4500n -0.001356 371.4600n -0.001360 371.4700n -0.001363 371.4800n -0.001365 371.4900n -0.001368 371.5000n -0.001369 371.5100n -0.001370 371.5200n -0.001371 371.5300n -0.001371 371.5400n -0.001371
+ 371.5500n -0.001370 371.5600n -0.001369 371.5700n -0.001367 371.5800n -0.001364 371.5900n -0.001362 371.6000n -0.001358 371.6100n -0.001355 371.6200n -0.001351 371.6300n -0.001346 371.6400n -0.001341 371.6500n -0.001335 371.6600n -0.001329 371.6700n -0.001323 371.6800n -0.001316 371.6900n -0.001308
+ 371.7000n -0.001300 371.7100n -0.001292 371.7200n -0.001283 371.7300n -0.001274 371.7400n -0.001264 371.7500n -0.001254 371.7600n -0.001244 371.7700n -0.001233 371.7800n -0.001222 371.7900n -0.001210 371.8000n -0.001198 371.8100n -0.001186 371.8200n -0.001173 371.8300n -0.001160 371.8400n -0.001146
+ 371.8500n -0.001132 371.8600n -0.001118 371.8700n -0.001103 371.8800n -0.001088 371.8900n -0.001073 371.9000n -0.001057 371.9100n -0.001041 371.9200n -0.001025 371.9300n -0.001009 371.9400n -0.000992 371.9500n -0.000975 371.9600n -0.000957 371.9700n -0.000940 371.9800n -0.000922 371.9900n -0.000904
+ 372.0000n -0.000886 372.0100n -0.000867 372.0200n -0.000848 372.0300n -0.000829 372.0400n -0.000810 372.0500n -0.000791 372.0600n -0.000771 372.0700n -0.000752 372.0800n -0.000732 372.0900n -0.000712 372.1000n -0.000692 372.1100n -0.000672 372.1200n -0.000651 372.1300n -0.000631 372.1400n -0.000611
+ 372.1500n -0.000590 372.1600n -0.000569 372.1700n -0.000549 372.1800n -0.000528 372.1900n -0.000507 372.2000n -0.000486 372.2100n -0.000465 372.2200n -0.000445 372.2300n -0.000424 372.2400n -0.000403 372.2500n -0.000382 372.2600n -0.000361 372.2700n -0.000341 372.2800n -0.000320 372.2900n -0.000299
+ 372.3000n -0.000279 372.3100n -0.000258 372.3200n -0.000238 372.3300n -0.000218 372.3400n -0.000198 372.3500n -0.000178 372.3600n -0.000158 372.3700n -0.000138 372.3800n -0.000119 372.3900n -0.000099 372.4000n -0.000080 372.4100n -0.000061 372.4200n -0.000042 372.4300n -0.000024 372.4400n -0.000005
+ 372.4500n 0.000013 372.4600n 0.000031 372.4700n 0.000049 372.4800n 0.000066 372.4900n 0.000084 372.5000n 0.000101 372.5100n 0.000117 372.5200n 0.000134 372.5300n 0.000150 372.5400n 0.000166 372.5500n 0.000181 372.5600n 0.000197 372.5700n 0.000212 372.5800n 0.000226 372.5900n 0.000241
+ 372.6000n 0.000255 372.6100n 0.000268 372.6200n 0.000282 372.6300n 0.000295 372.6400n 0.000307 372.6500n 0.000320 372.6600n 0.000332 372.6700n 0.000343 372.6800n 0.000355 372.6900n 0.000365 372.7000n 0.000376 372.7100n 0.000386 372.7200n 0.000396 372.7300n 0.000405 372.7400n 0.000414
+ 372.7500n 0.000423 372.7600n 0.000431 372.7700n 0.000438 372.7800n 0.000446 372.7900n 0.000453 372.8000n 0.000459 372.8100n 0.000466 372.8200n 0.000471 372.8300n 0.000477 372.8400n 0.000482 372.8500n 0.000486 372.8600n 0.000490 372.8700n 0.000494 372.8800n 0.000497 372.8900n 0.000500
+ 372.9000n 0.000503 372.9100n 0.000505 372.9200n 0.000507 372.9300n 0.000508 372.9400n 0.000509 372.9500n 0.000509 372.9600n 0.000509 372.9700n 0.000509 372.9800n 0.000508 372.9900n 0.000507 373.0000n 0.000506 373.0100n 0.000504 373.0200n 0.000502 373.0300n 0.000499 373.0400n 0.000496
+ 373.0500n 0.000493 373.0600n 0.000489 373.0700n 0.000485 373.0800n 0.000481 373.0900n 0.000476 373.1000n 0.000471 373.1100n 0.000465 373.1200n 0.000459 373.1300n 0.000453 373.1400n 0.000447 373.1500n 0.000440 373.1600n 0.000433 373.1700n 0.000425 373.1800n 0.000417 373.1900n 0.000409
+ 373.2000n 0.000401 373.2100n 0.000392 373.2200n 0.000383 373.2300n 0.000374 373.2400n 0.000364 373.2500n 0.000355 373.2600n 0.000344 373.2700n 0.000334 373.2800n 0.000324 373.2900n 0.000313 373.3000n 0.000302 373.3100n 0.000290 373.3200n 0.000279 373.3300n 0.000267 373.3400n 0.000255
+ 373.3500n 0.000243 373.3600n 0.000231 373.3700n 0.000219 373.3800n 0.000206 373.3900n 0.000193 373.4000n 0.000180 373.4100n 0.000167 373.4200n 0.000154 373.4300n 0.000140 373.4400n 0.000127 373.4500n 0.000113 373.4600n 0.000099 373.4700n 0.000085 373.4800n 0.000071 373.4900n 0.000057
+ 373.5000n 0.000043 373.5100n 0.000029 373.5200n 0.000015 373.5300n 0.000000 373.5400n -0.000014 373.5500n -0.000029 373.5600n -0.000043 373.5700n -0.000058 373.5800n -0.000072 373.5900n -0.000087 373.6000n -0.000102 373.6100n -0.000116 373.6200n -0.000131 373.6300n -0.000145 373.6400n -0.000160
+ 373.6500n -0.000174 373.6600n -0.000189 373.6700n -0.000203 373.6800n -0.000218 373.6900n -0.000232 373.7000n -0.000246 373.7100n -0.000261 373.7200n -0.000275 373.7300n -0.000289 373.7400n -0.000303 373.7500n -0.000317 373.7600n -0.000330 373.7700n -0.000344 373.7800n -0.000358 373.7900n -0.000371
+ 373.8000n -0.000384 373.8100n -0.000398 373.8200n -0.000411 373.8300n -0.000424 373.8400n -0.000436 373.8500n -0.000449 373.8600n -0.000461 373.8700n -0.000474 373.8800n -0.000486 373.8900n -0.000498 373.9000n -0.000510 373.9100n -0.000521 373.9200n -0.000533 373.9300n -0.000544 373.9400n -0.000555
+ 373.9500n -0.000566 373.9600n -0.000576 373.9700n -0.000587 373.9800n -0.000597 373.9900n -0.000607 374.0000n -0.000617 374.0100n -0.000626 374.0200n -0.000636 374.0300n -0.000645 374.0400n -0.000654 374.0500n -0.000662 374.0600n -0.000671 374.0700n -0.000679 374.0800n -0.000687 374.0900n -0.000695
+ 374.1000n -0.000702 374.1100n -0.000709 374.1200n -0.000716 374.1300n -0.000723 374.1400n -0.000730 374.1500n -0.000736 374.1600n -0.000742 374.1700n -0.000748 374.1800n -0.000753 374.1900n -0.000758 374.2000n -0.000763 374.2100n -0.000768 374.2200n -0.000773 374.2300n -0.000777 374.2400n -0.000781
+ 374.2500n -0.000784 374.2600n -0.000788 374.2700n -0.000791 374.2800n -0.000794 374.2900n -0.000797 374.3000n -0.000799 374.3100n -0.000801 374.3200n -0.000803 374.3300n -0.000805 374.3400n -0.000806 374.3500n -0.000808 374.3600n -0.000809 374.3700n -0.000809 374.3800n -0.000810 374.3900n -0.000810
+ 374.4000n -0.000810 374.4100n -0.000810 374.4200n -0.000809 374.4300n -0.000808 374.4400n -0.000808 374.4500n -0.000806 374.4600n -0.000805 374.4700n -0.000803 374.4800n -0.000801 374.4900n -0.000799 374.5000n -0.000797 374.5100n -0.000795 374.5200n -0.000792 374.5300n -0.000789 374.5400n -0.000786
+ 374.5500n -0.000783 374.5600n -0.000779 374.5700n -0.000776 374.5800n -0.000772 374.5900n -0.000768 374.6000n -0.000763 374.6100n -0.000759 374.6200n -0.000754 374.6300n -0.000750 374.6400n -0.000745 374.6500n -0.000740 374.6600n -0.000735 374.6700n -0.000729 374.6800n -0.000724 374.6900n -0.000718
+ 374.7000n -0.000712 374.7100n -0.000707 374.7200n -0.000701 374.7300n -0.000694 374.7400n -0.000688 374.7500n -0.000682 374.7600n -0.000675 374.7700n -0.000669 374.7800n -0.000662 374.7900n -0.000655 374.8000n -0.000649 374.8100n -0.000642 374.8200n -0.000635 374.8300n -0.000628 374.8400n -0.000621
+ 374.8500n -0.000614 374.8600n -0.000606 374.8700n -0.000599 374.8800n -0.000592 374.8900n -0.000585 374.9000n -0.000577 374.9100n -0.000570 374.9200n -0.000562 374.9300n -0.000555 374.9400n -0.000548 374.9500n -0.000540 374.9600n -0.000533 374.9700n -0.000525 374.9800n -0.000518 374.9900n -0.000511
+ 375.0000n -0.000503 375.0100n -0.000496 375.0200n -0.000489 375.0300n -0.000482 375.0400n -0.000475 375.0500n -0.000468 375.0600n -0.000461 375.0700n -0.000454 375.0800n -0.000447 375.0900n -0.000440 375.1000n -0.000433 375.1100n -0.000427 375.1200n -0.000420 375.1300n -0.000414 375.1400n -0.000407
+ 375.1500n -0.000401 375.1600n -0.000395 375.1700n -0.000389 375.1800n -0.000383 375.1900n -0.000378 375.2000n -0.000372 375.2100n -0.000367 375.2200n -0.000361 375.2300n -0.000356 375.2400n -0.000351 375.2500n -0.000346 375.2600n -0.000342 375.2700n -0.000337 375.2800n -0.000333 375.2900n -0.000329
+ 375.3000n -0.000325 375.3100n -0.000321 375.3200n -0.000318 375.3300n -0.000315 375.3400n -0.000311 375.3500n -0.000309 375.3600n -0.000306 375.3700n -0.000303 375.3800n -0.000301 375.3900n -0.000299 375.4000n -0.000297 375.4100n -0.000295 375.4200n -0.000294 375.4300n -0.000293 375.4400n -0.000292
+ 375.4500n -0.000291 375.4600n -0.000291 375.4700n -0.000291 375.4800n -0.000291 375.4900n -0.000291 375.5000n -0.000292 375.5100n -0.000292 375.5200n -0.000293 375.5300n -0.000295 375.5400n -0.000296 375.5500n -0.000298 375.5600n -0.000300 375.5700n -0.000302 375.5800n -0.000305 375.5900n -0.000308
+ 375.6000n -0.000311 375.6100n -0.000314 375.6200n -0.000318 375.6300n -0.000322 375.6400n -0.000326 375.6500n -0.000330 375.6600n -0.000335 375.6700n -0.000339 375.6800n -0.000345 375.6900n -0.000350 375.7000n -0.000355 375.7100n -0.000361 375.7200n -0.000367 375.7300n -0.000374 375.7400n -0.000380
+ 375.7500n -0.000387 375.7600n -0.000394 375.7700n -0.000401 375.7800n -0.000409 375.7900n -0.000417 375.8000n -0.000425 375.8100n -0.000433 375.8200n -0.000441 375.8300n -0.000450 375.8400n -0.000458 375.8500n -0.000467 375.8600n -0.000476 375.8700n -0.000486 375.8800n -0.000495 375.8900n -0.000505
+ 375.9000n -0.000515 375.9100n -0.000525 375.9200n -0.000535 375.9300n -0.000545 375.9400n -0.000556 375.9500n -0.000566 375.9600n -0.000577 375.9700n -0.000588 375.9800n -0.000599 375.9900n -0.000610 376.0000n -0.000621 376.0100n -0.000632 376.0200n -0.000644 376.0300n -0.000655 376.0400n -0.000667
+ 376.0500n -0.000678 376.0600n -0.000690 376.0700n -0.000701 376.0800n -0.000713 376.0900n -0.000725 376.1000n -0.000736 376.1100n -0.000748 376.1200n -0.000760 376.1300n -0.000771 376.1400n -0.000783 376.1500n -0.000794 376.1600n -0.000806 376.1700n -0.000817 376.1800n -0.000828 376.1900n -0.000840
+ 376.2000n -0.000851 376.2100n -0.000862 376.2200n -0.000873 376.2300n -0.000884 376.2400n -0.000894 376.2500n -0.000905 376.2600n -0.000915 376.2700n -0.000925 376.2800n -0.000935 376.2900n -0.000945 376.3000n -0.000954 376.3100n -0.000964 376.3200n -0.000973 376.3300n -0.000982 376.3400n -0.000990
+ 376.3500n -0.000998 376.3600n -0.001006 376.3700n -0.001014 376.3800n -0.001021 376.3900n -0.001028 376.4000n -0.001035 376.4100n -0.001041 376.4200n -0.001047 376.4300n -0.001053 376.4400n -0.001058 376.4500n -0.001063 376.4600n -0.001068 376.4700n -0.001072 376.4800n -0.001075 376.4900n -0.001078
+ 376.5000n -0.001081 376.5100n -0.001083 376.5200n -0.001085 376.5300n -0.001086 376.5400n -0.001087 376.5500n -0.001087 376.5600n -0.001087 376.5700n -0.001086 376.5800n -0.001085 376.5900n -0.001083 376.6000n -0.001080 376.6100n -0.001077 376.6200n -0.001074 376.6300n -0.001070 376.6400n -0.001065
+ 376.6500n -0.001059 376.6600n -0.001053 376.6700n -0.001047 376.6800n -0.001039 376.6900n -0.001032 376.7000n -0.001023 376.7100n -0.001014 376.7200n -0.001004 376.7300n -0.000993 376.7400n -0.000982 376.7500n -0.000970 376.7600n -0.000958 376.7700n -0.000944 376.7800n -0.000930 376.7900n -0.000916
+ 376.8000n -0.000900 376.8100n -0.000884 376.8200n -0.000867 376.8300n -0.000850 376.8400n -0.000832 376.8500n -0.000813 376.8600n -0.000793 376.8700n -0.000773 376.8800n -0.000751 376.8900n -0.000730 376.9000n -0.000707 376.9100n -0.000684 376.9200n -0.000660 376.9300n -0.000635 376.9400n -0.000609
+ 376.9500n -0.000583 376.9600n -0.000556 376.9700n -0.000529 376.9800n -0.000500 376.9900n -0.000471 377.0000n -0.000441 377.0100n -0.000411 377.0200n -0.000380 377.0300n -0.000348 377.0400n -0.000315 377.0500n -0.000282 377.0600n -0.000248 377.0700n -0.000213 377.0800n -0.000178 377.0900n -0.000142
+ 377.1000n -0.000106 377.1100n -0.000069 377.1200n -0.000031 377.1300n 0.000008 377.1400n 0.000047 377.1500n 0.000086 377.1600n 0.000127 377.1700n 0.000167 377.1800n 0.000209 377.1900n 0.000251 377.2000n 0.000293 377.2100n 0.000336 377.2200n 0.000379 377.2300n 0.000423 377.2400n 0.000468
+ 377.2500n 0.000512 377.2600n 0.000558 377.2700n 0.000603 377.2800n 0.000650 377.2900n 0.000696 377.3000n 0.000743 377.3100n 0.000790 377.3200n 0.000838 377.3300n 0.000886 377.3400n 0.000934 377.3500n 0.000983 377.3600n 0.001031 377.3700n 0.001081 377.3800n 0.001130 377.3900n 0.001179
+ 377.4000n 0.001229 377.4100n 0.001279 377.4200n 0.001329 377.4300n 0.001379 377.4400n 0.001429 377.4500n 0.001479 377.4600n 0.001530 377.4700n 0.001580 377.4800n 0.001631 377.4900n 0.001681 377.5000n 0.001731 377.5100n 0.001782 377.5200n 0.001832 377.5300n 0.001882 377.5400n 0.001932
+ 377.5500n 0.001982 377.5600n 0.002032 377.5700n 0.002081 377.5800n 0.002130 377.5900n 0.002179 377.6000n 0.002228 377.6100n 0.002277 377.6200n 0.002325 377.6300n 0.002373 377.6400n 0.002420 377.6500n 0.002467 377.6600n 0.002514 377.6700n 0.002560 377.6800n 0.002606 377.6900n 0.002651
+ 377.7000n 0.002696 377.7100n 0.002740 377.7200n 0.002783 377.7300n 0.002826 377.7400n 0.002869 377.7500n 0.002911 377.7600n 0.002952 377.7700n 0.002993 377.7800n 0.003032 377.7900n 0.003071 377.8000n 0.003110 377.8100n 0.003147 377.8200n 0.003184 377.8300n 0.003220 377.8400n 0.003256
+ 377.8500n 0.003290 377.8600n 0.003323 377.8700n 0.003356 377.8800n 0.003388 377.8900n 0.003419 377.9000n 0.003449 377.9100n 0.003477 377.9200n 0.003505 377.9300n 0.003532 377.9400n 0.003558 377.9500n 0.003583 377.9600n 0.003607 377.9700n 0.003630 377.9800n 0.003652 377.9900n 0.003672
+ 378.0000n 0.003692 378.0100n 0.003710 378.0200n 0.003728 378.0300n 0.003744 378.0400n 0.003759 378.0500n 0.003773 378.0600n 0.003785 378.0700n 0.003797 378.0800n 0.003807 378.0900n 0.003816 378.1000n 0.003824 378.1100n 0.003831 378.1200n 0.003836 378.1300n 0.003840 378.1400n 0.003843
+ 378.1500n 0.003845 378.1600n 0.003846 378.1700n 0.003845 378.1800n 0.003843 378.1900n 0.003840 378.2000n 0.003835 378.2100n 0.003830 378.2200n 0.003823 378.2300n 0.003814 378.2400n 0.003805 378.2500n 0.003794 378.2600n 0.003782 378.2700n 0.003769 378.2800n 0.003754 378.2900n 0.003739
+ 378.3000n 0.003722 378.3100n 0.003703 378.3200n 0.003684 378.3300n 0.003663 378.3400n 0.003642 378.3500n 0.003619 378.3600n 0.003594 378.3700n 0.003569 378.3800n 0.003542 378.3900n 0.003515 378.4000n 0.003486 378.4100n 0.003456 378.4200n 0.003425 378.4300n 0.003393 378.4400n 0.003359
+ 378.4500n 0.003325 378.4600n 0.003290 378.4700n 0.003253 378.4800n 0.003216 378.4900n 0.003178 378.5000n 0.003138 378.5100n 0.003098 378.5200n 0.003057 378.5300n 0.003014 378.5400n 0.002971 378.5500n 0.002927 378.5600n 0.002882 378.5700n 0.002837 378.5800n 0.002790 378.5900n 0.002743
+ 378.6000n 0.002695 378.6100n 0.002646 378.6200n 0.002596 378.6300n 0.002546 378.6400n 0.002495 378.6500n 0.002444 378.6600n 0.002392 378.6700n 0.002339 378.6800n 0.002286 378.6900n 0.002232 378.7000n 0.002178 378.7100n 0.002123 378.7200n 0.002068 378.7300n 0.002012 378.7400n 0.001956
+ 378.7500n 0.001900 378.7600n 0.001843 378.7700n 0.001786 378.7800n 0.001728 378.7900n 0.001671 378.8000n 0.001613 378.8100n 0.001555 378.8200n 0.001497 378.8300n 0.001439 378.8400n 0.001381 378.8500n 0.001322 378.8600n 0.001264 378.8700n 0.001206 378.8800n 0.001147 378.8900n 0.001089
+ 378.9000n 0.001031 378.9100n 0.000973 378.9200n 0.000915 378.9300n 0.000857 378.9400n 0.000799 378.9500n 0.000742 378.9600n 0.000685 378.9700n 0.000628 378.9800n 0.000572 378.9900n 0.000516 379.0000n 0.000460 379.0100n 0.000405 379.0200n 0.000350 379.0300n 0.000296 379.0400n 0.000242
+ 379.0500n 0.000189 379.0600n 0.000136 379.0700n 0.000084 379.0800n 0.000032 379.0900n -0.000019 379.1000n -0.000069 379.1100n -0.000118 379.1200n -0.000167 379.1300n -0.000216 379.1400n -0.000263 379.1500n -0.000310 379.1600n -0.000355 379.1700n -0.000400 379.1800n -0.000445 379.1900n -0.000488
+ 379.2000n -0.000530 379.2100n -0.000572 379.2200n -0.000613 379.2300n -0.000652 379.2400n -0.000691 379.2500n -0.000729 379.2600n -0.000765 379.2700n -0.000801 379.2800n -0.000836 379.2900n -0.000870 379.3000n -0.000902 379.3100n -0.000934 379.3200n -0.000965 379.3300n -0.000994 379.3400n -0.001022
+ 379.3500n -0.001050 379.3600n -0.001076 379.3700n -0.001101 379.3800n -0.001125 379.3900n -0.001148 379.4000n -0.001169 379.4100n -0.001190 379.4200n -0.001209 379.4300n -0.001227 379.4400n -0.001244 379.4500n -0.001260 379.4600n -0.001275 379.4700n -0.001288 379.4800n -0.001301 379.4900n -0.001312
+ 379.5000n -0.001322 379.5100n -0.001331 379.5200n -0.001339 379.5300n -0.001345 379.5400n -0.001351 379.5500n -0.001355 379.5600n -0.001358 379.5700n -0.001360 379.5800n -0.001361 379.5900n -0.001361 379.6000n -0.001359 379.6100n -0.001357 379.6200n -0.001353 379.6300n -0.001349 379.6400n -0.001343
+ 379.6500n -0.001337 379.6600n -0.001329 379.6700n -0.001320 379.6800n -0.001310 379.6900n -0.001300 379.7000n -0.001288 379.7100n -0.001275 379.7200n -0.001261 379.7300n -0.001247 379.7400n -0.001231 379.7500n -0.001215 379.7600n -0.001198 379.7700n -0.001179 379.7800n -0.001160 379.7900n -0.001141
+ 379.8000n -0.001120 379.8100n -0.001099 379.8200n -0.001077 379.8300n -0.001054 379.8400n -0.001030 379.8500n -0.001006 379.8600n -0.000981 379.8700n -0.000956 379.8800n -0.000929 379.8900n -0.000903 379.9000n -0.000875 379.9100n -0.000848 379.9200n -0.000819 379.9300n -0.000790 379.9400n -0.000761
+ 379.9500n -0.000731 379.9600n -0.000701 379.9700n -0.000671 379.9800n -0.000640 379.9900n -0.000608 380.0000n -0.000577 380.0100n -0.000545 380.0200n -0.000513 380.0300n -0.000481 380.0400n -0.000448 380.0500n -0.000416 380.0600n -0.000383 380.0700n -0.000350 380.0800n -0.000317 380.0900n -0.000284
+ 380.1000n -0.000251 380.1100n -0.000218 380.1200n -0.000184 380.1300n -0.000151 380.1400n -0.000118 380.1500n -0.000085 380.1600n -0.000053 380.1700n -0.000020 380.1800n 0.000013 380.1900n 0.000045 380.2000n 0.000077 380.2100n 0.000109 380.2200n 0.000140 380.2300n 0.000172 380.2400n 0.000203
+ 380.2500n 0.000233 380.2600n 0.000264 380.2700n 0.000294 380.2800n 0.000323 380.2900n 0.000352 380.3000n 0.000381 380.3100n 0.000409 380.3200n 0.000437 380.3300n 0.000464 380.3400n 0.000491 380.3500n 0.000517 380.3600n 0.000543 380.3700n 0.000568 380.3800n 0.000592 380.3900n 0.000616
+ 380.4000n 0.000639 380.4100n 0.000662 380.4200n 0.000684 380.4300n 0.000705 380.4400n 0.000726 380.4500n 0.000746 380.4600n 0.000765 380.4700n 0.000784 380.4800n 0.000802 380.4900n 0.000819 380.5000n 0.000835 380.5100n 0.000851 380.5200n 0.000866 380.5300n 0.000880 380.5400n 0.000894
+ 380.5500n 0.000906 380.5600n 0.000918 380.5700n 0.000929 380.5800n 0.000940 380.5900n 0.000949 380.6000n 0.000958 380.6100n 0.000966 380.6200n 0.000973 380.6300n 0.000980 380.6400n 0.000985 380.6500n 0.000990 380.6600n 0.000994 380.6700n 0.000998 380.6800n 0.001000 380.6900n 0.001002
+ 380.7000n 0.001003 380.7100n 0.001003 380.7200n 0.001003 380.7300n 0.001002 380.7400n 0.001000 380.7500n 0.000997 380.7600n 0.000994 380.7700n 0.000990 380.7800n 0.000985 380.7900n 0.000980 380.8000n 0.000974 380.8100n 0.000967 380.8200n 0.000959 380.8300n 0.000951 380.8400n 0.000943
+ 380.8500n 0.000933 380.8600n 0.000924 380.8700n 0.000913 380.8800n 0.000902 380.8900n 0.000891 380.9000n 0.000879 380.9100n 0.000866 380.9200n 0.000853 380.9300n 0.000839 380.9400n 0.000825 380.9500n 0.000811 380.9600n 0.000796 380.9700n 0.000781 380.9800n 0.000765 380.9900n 0.000749
+ 381.0000n 0.000733 381.0100n 0.000716 381.0200n 0.000699 381.0300n 0.000682 381.0400n 0.000664 381.0500n 0.000647 381.0600n 0.000629 381.0700n 0.000611 381.0800n 0.000592 381.0900n 0.000574 381.1000n 0.000555 381.1100n 0.000537 381.1200n 0.000518 381.1300n 0.000499 381.1400n 0.000480
+ 381.1500n 0.000462 381.1600n 0.000443 381.1700n 0.000424 381.1800n 0.000405 381.1900n 0.000386 381.2000n 0.000368 381.2100n 0.000349 381.2200n 0.000331 381.2300n 0.000313 381.2400n 0.000295 381.2500n 0.000277 381.2600n 0.000260 381.2700n 0.000243 381.2800n 0.000226 381.2900n 0.000209
+ 381.3000n 0.000193 381.3100n 0.000177 381.3200n 0.000161 381.3300n 0.000146 381.3400n 0.000131 381.3500n 0.000116 381.3600n 0.000102 381.3700n 0.000089 381.3800n 0.000075 381.3900n 0.000063 381.4000n 0.000051 381.4100n 0.000039 381.4200n 0.000028 381.4300n 0.000017 381.4400n 0.000007
+ 381.4500n -0.000002 381.4600n -0.000011 381.4700n -0.000019 381.4800n -0.000027 381.4900n -0.000034 381.5000n -0.000040 381.5100n -0.000046 381.5200n -0.000051 381.5300n -0.000055 381.5400n -0.000059 381.5500n -0.000062 381.5600n -0.000064 381.5700n -0.000066 381.5800n -0.000067 381.5900n -0.000067
+ 381.6000n -0.000066 381.6100n -0.000065 381.6200n -0.000063 381.6300n -0.000060 381.6400n -0.000056 381.6500n -0.000052 381.6600n -0.000047 381.6700n -0.000041 381.6800n -0.000035 381.6900n -0.000027 381.7000n -0.000019 381.7100n -0.000011 381.7200n -0.000001 381.7300n 0.000009 381.7400n 0.000020
+ 381.7500n 0.000032 381.7600n 0.000044 381.7700n 0.000058 381.7800n 0.000072 381.7900n 0.000086 381.8000n 0.000102 381.8100n 0.000118 381.8200n 0.000134 381.8300n 0.000152 381.8400n 0.000170 381.8500n 0.000189 381.8600n 0.000208 381.8700n 0.000228 381.8800n 0.000249 381.8900n 0.000270
+ 381.9000n 0.000292 381.9100n 0.000315 381.9200n 0.000338 381.9300n 0.000362 381.9400n 0.000386 381.9500n 0.000411 381.9600n 0.000436 381.9700n 0.000462 381.9800n 0.000488 381.9900n 0.000515 382.0000n 0.000542 382.0100n 0.000570 382.0200n 0.000598 382.0300n 0.000626 382.0400n 0.000655
+ 382.0500n 0.000684 382.0600n 0.000714 382.0700n 0.000743 382.0800n 0.000774 382.0900n 0.000804 382.1000n 0.000835 382.1100n 0.000866 382.1200n 0.000897 382.1300n 0.000928 382.1400n 0.000960 382.1500n 0.000991 382.1600n 0.001023 382.1700n 0.001055 382.1800n 0.001087 382.1900n 0.001119
+ 382.2000n 0.001151 382.2100n 0.001183 382.2200n 0.001216 382.2300n 0.001248 382.2400n 0.001280 382.2500n 0.001312 382.2600n 0.001344 382.2700n 0.001376 382.2800n 0.001407 382.2900n 0.001439 382.3000n 0.001470 382.3100n 0.001501 382.3200n 0.001532 382.3300n 0.001563 382.3400n 0.001593
+ 382.3500n 0.001624 382.3600n 0.001653 382.3700n 0.001683 382.3800n 0.001712 382.3900n 0.001741 382.4000n 0.001770 382.4100n 0.001798 382.4200n 0.001825 382.4300n 0.001852 382.4400n 0.001879 382.4500n 0.001905 382.4600n 0.001931 382.4700n 0.001957 382.4800n 0.001981 382.4900n 0.002006
+ 382.5000n 0.002029 382.5100n 0.002052 382.5200n 0.002075 382.5300n 0.002097 382.5400n 0.002118 382.5500n 0.002139 382.5600n 0.002159 382.5700n 0.002178 382.5800n 0.002197 382.5900n 0.002215 382.6000n 0.002232 382.6100n 0.002249 382.6200n 0.002265 382.6300n 0.002280 382.6400n 0.002295
+ 382.6500n 0.002308 382.6600n 0.002321 382.6700n 0.002334 382.6800n 0.002345 382.6900n 0.002356 382.7000n 0.002366 382.7100n 0.002375 382.7200n 0.002384 382.7300n 0.002392 382.7400n 0.002399 382.7500n 0.002405 382.7600n 0.002410 382.7700n 0.002415 382.7800n 0.002419 382.7900n 0.002422
+ 382.8000n 0.002424 382.8100n 0.002425 382.8200n 0.002426 382.8300n 0.002426 382.8400n 0.002425 382.8500n 0.002424 382.8600n 0.002422 382.8700n 0.002419 382.8800n 0.002415 382.8900n 0.002410 382.9000n 0.002405 382.9100n 0.002399 382.9200n 0.002392 382.9300n 0.002385 382.9400n 0.002377
+ 382.9500n 0.002368 382.9600n 0.002359 382.9700n 0.002349 382.9800n 0.002338 382.9900n 0.002327 383.0000n 0.002315 383.0100n 0.002302 383.0200n 0.002289 383.0300n 0.002275 383.0400n 0.002261 383.0500n 0.002246 383.0600n 0.002231 383.0700n 0.002215 383.0800n 0.002199 383.0900n 0.002182
+ 383.1000n 0.002164 383.1100n 0.002146 383.1200n 0.002128 383.1300n 0.002109 383.1400n 0.002090 383.1500n 0.002071 383.1600n 0.002051 383.1700n 0.002031 383.1800n 0.002011 383.1900n 0.001990 383.2000n 0.001969 383.2100n 0.001947 383.2200n 0.001926 383.2300n 0.001904 383.2400n 0.001882
+ 383.2500n 0.001860 383.2600n 0.001838 383.2700n 0.001815 383.2800n 0.001793 383.2900n 0.001770 383.3000n 0.001747 383.3100n 0.001725 383.3200n 0.001702 383.3300n 0.001679 383.3400n 0.001656 383.3500n 0.001633 383.3600n 0.001611 383.3700n 0.001588 383.3800n 0.001565 383.3900n 0.001543
+ 383.4000n 0.001520 383.4100n 0.001498 383.4200n 0.001476 383.4300n 0.001454 383.4400n 0.001433 383.4500n 0.001411 383.4600n 0.001390 383.4700n 0.001369 383.4800n 0.001349 383.4900n 0.001329 383.5000n 0.001309 383.5100n 0.001289 383.5200n 0.001270 383.5300n 0.001251 383.5400n 0.001232
+ 383.5500n 0.001214 383.5600n 0.001197 383.5700n 0.001180 383.5800n 0.001163 383.5900n 0.001147 383.6000n 0.001131 383.6100n 0.001115 383.6200n 0.001101 383.6300n 0.001086 383.6400n 0.001073 383.6500n 0.001059 383.6600n 0.001047 383.6700n 0.001035 383.6800n 0.001023 383.6900n 0.001012
+ 383.7000n 0.001002 383.7100n 0.000992 383.7200n 0.000983 383.7300n 0.000975 383.7400n 0.000967 383.7500n 0.000960 383.7600n 0.000953 383.7700n 0.000947 383.7800n 0.000942 383.7900n 0.000938 383.8000n 0.000934 383.8100n 0.000930 383.8200n 0.000928 383.8300n 0.000926 383.8400n 0.000925
+ 383.8500n 0.000924 383.8600n 0.000924 383.8700n 0.000925 383.8800n 0.000926 383.8900n 0.000928 383.9000n 0.000931 383.9100n 0.000934 383.9200n 0.000938 383.9300n 0.000943 383.9400n 0.000948 383.9500n 0.000954 383.9600n 0.000961 383.9700n 0.000968 383.9800n 0.000976 383.9900n 0.000985
+ 384.0000n 0.000994 384.0100n 0.001003 384.0200n 0.001014 384.0300n 0.001024 384.0400n 0.001036 384.0500n 0.001048 384.0600n 0.001060 384.0700n 0.001073 384.0800n 0.001087 384.0900n 0.001101 384.1000n 0.001116 384.1100n 0.001131 384.1200n 0.001146 384.1300n 0.001162 384.1400n 0.001179
+ 384.1500n 0.001196 384.1600n 0.001213 384.1700n 0.001231 384.1800n 0.001249 384.1900n 0.001267 384.2000n 0.001286 384.2100n 0.001305 384.2200n 0.001325 384.2300n 0.001344 384.2400n 0.001364 384.2500n 0.001385 384.2600n 0.001405 384.2700n 0.001426 384.2800n 0.001447 384.2900n 0.001468
+ 384.3000n 0.001489 384.3100n 0.001511 384.3200n 0.001532 384.3300n 0.001554 384.3400n 0.001576 384.3500n 0.001597 384.3600n 0.001619 384.3700n 0.001641 384.3800n 0.001663 384.3900n 0.001685 384.4000n 0.001707 384.4100n 0.001729 384.4200n 0.001751 384.4300n 0.001772 384.4400n 0.001794
+ 384.4500n 0.001816 384.4600n 0.001837 384.4700n 0.001858 384.4800n 0.001879 384.4900n 0.001900 384.5000n 0.001920 384.5100n 0.001941 384.5200n 0.001961 384.5300n 0.001980 384.5400n 0.002000 384.5500n 0.002019 384.5600n 0.002038 384.5700n 0.002056 384.5800n 0.002075 384.5900n 0.002092
+ 384.6000n 0.002110 384.6100n 0.002127 384.6200n 0.002143 384.6300n 0.002159 384.6400n 0.002175 384.6500n 0.002190 384.6600n 0.002205 384.6700n 0.002219 384.6800n 0.002232 384.6900n 0.002245 384.7000n 0.002258 384.7100n 0.002270 384.7200n 0.002281 384.7300n 0.002292 384.7400n 0.002303
+ 384.7500n 0.002312 384.7600n 0.002321 384.7700n 0.002330 384.7800n 0.002338 384.7900n 0.002345 384.8000n 0.002351 384.8100n 0.002357 384.8200n 0.002362 384.8300n 0.002367 384.8400n 0.002371 384.8500n 0.002374 384.8600n 0.002377 384.8700n 0.002378 384.8800n 0.002380 384.8900n 0.002380
+ 384.9000n 0.002380 384.9100n 0.002379 384.9200n 0.002377 384.9300n 0.002375 384.9400n 0.002372 384.9500n 0.002368 384.9600n 0.002364 384.9700n 0.002359 384.9800n 0.002353 384.9900n 0.002346 385.0000n 0.002339 385.0100n 0.002331 385.0200n 0.002323 385.0300n 0.002313 385.0400n 0.002303
+ 385.0500n 0.002293 385.0600n 0.002282 385.0700n 0.002270 385.0800n 0.002257 385.0900n 0.002244 385.1000n 0.002230 385.1100n 0.002215 385.1200n 0.002200 385.1300n 0.002185 385.1400n 0.002168 385.1500n 0.002151 385.1600n 0.002134 385.1700n 0.002116 385.1800n 0.002097 385.1900n 0.002078
+ 385.2000n 0.002058 385.2100n 0.002038 385.2200n 0.002017 385.2300n 0.001996 385.2400n 0.001975 385.2500n 0.001952 385.2600n 0.001930 385.2700n 0.001907 385.2800n 0.001883 385.2900n 0.001859 385.3000n 0.001835 385.3100n 0.001810 385.3200n 0.001785 385.3300n 0.001760 385.3400n 0.001734
+ 385.3500n 0.001708 385.3600n 0.001682 385.3700n 0.001655 385.3800n 0.001628 385.3900n 0.001601 385.4000n 0.001574 385.4100n 0.001546 385.4200n 0.001519 385.4300n 0.001491 385.4400n 0.001463 385.4500n 0.001434 385.4600n 0.001406 385.4700n 0.001377 385.4800n 0.001349 385.4900n 0.001320
+ 385.5000n 0.001292 385.5100n 0.001263 385.5200n 0.001234 385.5300n 0.001205 385.5400n 0.001177 385.5500n 0.001148 385.5600n 0.001119 385.5700n 0.001091 385.5800n 0.001062 385.5900n 0.001034 385.6000n 0.001006 385.6100n 0.000978 385.6200n 0.000950 385.6300n 0.000922 385.6400n 0.000894
+ 385.6500n 0.000867 385.6600n 0.000840 385.6700n 0.000813 385.6800n 0.000786 385.6900n 0.000760 385.7000n 0.000734 385.7100n 0.000708 385.7200n 0.000682 385.7300n 0.000657 385.7400n 0.000632 385.7500n 0.000607 385.7600n 0.000583 385.7700n 0.000559 385.7800n 0.000536 385.7900n 0.000513
+ 385.8000n 0.000490 385.8100n 0.000468 385.8200n 0.000446 385.8300n 0.000425 385.8400n 0.000404 385.8500n 0.000383 385.8600n 0.000363 385.8700n 0.000344 385.8800n 0.000325 385.8900n 0.000306 385.9000n 0.000288 385.9100n 0.000270 385.9200n 0.000253 385.9300n 0.000237 385.9400n 0.000221
+ 385.9500n 0.000205 385.9600n 0.000190 385.9700n 0.000176 385.9800n 0.000162 385.9900n 0.000148 386.0000n 0.000136 386.0100n 0.000123 386.0200n 0.000112 386.0300n 0.000100 386.0400n 0.000090 386.0500n 0.000080 386.0600n 0.000070 386.0700n 0.000061 386.0800n 0.000052 386.0900n 0.000044
+ 386.1000n 0.000037 386.1100n 0.000030 386.1200n 0.000024 386.1300n 0.000018 386.1400n 0.000013 386.1500n 0.000008 386.1600n 0.000004 386.1700n 0.000000 386.1800n -0.000003 386.1900n -0.000006 386.2000n -0.000008 386.2100n -0.000010 386.2200n -0.000011 386.2300n -0.000012 386.2400n -0.000012
+ 386.2500n -0.000012 386.2600n -0.000011 386.2700n -0.000010 386.2800n -0.000008 386.2900n -0.000006 386.3000n -0.000004 386.3100n -0.000001 386.3200n 0.000002 386.3300n 0.000005 386.3400n 0.000009 386.3500n 0.000014 386.3600n 0.000018 386.3700n 0.000023 386.3800n 0.000029 386.3900n 0.000035
+ 386.4000n 0.000041 386.4100n 0.000047 386.4200n 0.000053 386.4300n 0.000060 386.4400n 0.000067 386.4500n 0.000075 386.4600n 0.000082 386.4700n 0.000090 386.4800n 0.000098 386.4900n 0.000106 386.5000n 0.000115 386.5100n 0.000123 386.5200n 0.000132 386.5300n 0.000141 386.5400n 0.000150
+ 386.5500n 0.000159 386.5600n 0.000169 386.5700n 0.000178 386.5800n 0.000187 386.5900n 0.000197 386.6000n 0.000206 386.6100n 0.000216 386.6200n 0.000226 386.6300n 0.000235 386.6400n 0.000245 386.6500n 0.000255 386.6600n 0.000264 386.6700n 0.000274 386.6800n 0.000283 386.6900n 0.000293
+ 386.7000n 0.000302 386.7100n 0.000311 386.7200n 0.000321 386.7300n 0.000330 386.7400n 0.000339 386.7500n 0.000348 386.7600n 0.000356 386.7700n 0.000365 386.7800n 0.000373 386.7900n 0.000382 386.8000n 0.000390 386.8100n 0.000398 386.8200n 0.000405 386.8300n 0.000413 386.8400n 0.000420
+ 386.8500n 0.000427 386.8600n 0.000434 386.8700n 0.000441 386.8800n 0.000447 386.8900n 0.000453 386.9000n 0.000459 386.9100n 0.000465 386.9200n 0.000470 386.9300n 0.000475 386.9400n 0.000480 386.9500n 0.000484 386.9600n 0.000489 386.9700n 0.000493 386.9800n 0.000496 386.9900n 0.000500
+ 387.0000n 0.000503 387.0100n 0.000505 387.0200n 0.000508 387.0300n 0.000510 387.0400n 0.000512 387.0500n 0.000513 387.0600n 0.000514 387.0700n 0.000515 387.0800n 0.000516 387.0900n 0.000516 387.1000n 0.000516 387.1100n 0.000515 387.1200n 0.000514 387.1300n 0.000513 387.1400n 0.000512
+ 387.1500n 0.000510 387.1600n 0.000509 387.1700n 0.000506 387.1800n 0.000504 387.1900n 0.000501 387.2000n 0.000498 387.2100n 0.000494 387.2200n 0.000491 387.2300n 0.000487 387.2400n 0.000483 387.2500n 0.000478 387.2600n 0.000473 387.2700n 0.000468 387.2800n 0.000463 387.2900n 0.000458
+ 387.3000n 0.000452 387.3100n 0.000446 387.3200n 0.000440 387.3300n 0.000434 387.3400n 0.000427 387.3500n 0.000420 387.3600n 0.000413 387.3700n 0.000406 387.3800n 0.000399 387.3900n 0.000392 387.4000n 0.000384 387.4100n 0.000377 387.4200n 0.000369 387.4300n 0.000361 387.4400n 0.000353
+ 387.4500n 0.000345 387.4600n 0.000336 387.4700n 0.000328 387.4800n 0.000320 387.4900n 0.000311 387.5000n 0.000303 387.5100n 0.000295 387.5200n 0.000286 387.5300n 0.000278 387.5400n 0.000269 387.5500n 0.000260 387.5600n 0.000252 387.5700n 0.000244 387.5800n 0.000235 387.5900n 0.000227
+ 387.6000n 0.000219 387.6100n 0.000210 387.6200n 0.000202 387.6300n 0.000194 387.6400n 0.000186 387.6500n 0.000178 387.6600n 0.000171 387.6700n 0.000163 387.6800n 0.000156 387.6900n 0.000149 387.7000n 0.000141 387.7100n 0.000135 387.7200n 0.000128 387.7300n 0.000121 387.7400n 0.000115
+ 387.7500n 0.000109 387.7600n 0.000103 387.7700n 0.000098 387.7800n 0.000092 387.7900n 0.000087 387.8000n 0.000082 387.8100n 0.000078 387.8200n 0.000073 387.8300n 0.000069 387.8400n 0.000065 387.8500n 0.000062 387.8600n 0.000059 387.8700n 0.000056 387.8800n 0.000053 387.8900n 0.000051
+ 387.9000n 0.000049 387.9100n 0.000048 387.9200n 0.000047 387.9300n 0.000046 387.9400n 0.000045 387.9500n 0.000045 387.9600n 0.000045 387.9700n 0.000046 387.9800n 0.000047 387.9900n 0.000048 388.0000n 0.000049 388.0100n 0.000051 388.0200n 0.000054 388.0300n 0.000057 388.0400n 0.000060
+ 388.0500n 0.000063 388.0600n 0.000067 388.0700n 0.000071 388.0800n 0.000076 388.0900n 0.000081 388.1000n 0.000086 388.1100n 0.000092 388.1200n 0.000098 388.1300n 0.000104 388.1400n 0.000111 388.1500n 0.000118 388.1600n 0.000126 388.1700n 0.000134 388.1800n 0.000142 388.1900n 0.000151
+ 388.2000n 0.000160 388.2100n 0.000169 388.2200n 0.000178 388.2300n 0.000188 388.2400n 0.000199 388.2500n 0.000209 388.2600n 0.000220 388.2700n 0.000231 388.2800n 0.000243 388.2900n 0.000255 388.3000n 0.000267 388.3100n 0.000279 388.3200n 0.000291 388.3300n 0.000304 388.3400n 0.000317
+ 388.3500n 0.000331 388.3600n 0.000344 388.3700n 0.000358 388.3800n 0.000372 388.3900n 0.000386 388.4000n 0.000401 388.4100n 0.000415 388.4200n 0.000430 388.4300n 0.000445 388.4400n 0.000460 388.4500n 0.000476 388.4600n 0.000491 388.4700n 0.000506 388.4800n 0.000522 388.4900n 0.000538
+ 388.5000n 0.000554 388.5100n 0.000569 388.5200n 0.000585 388.5300n 0.000601 388.5400n 0.000617 388.5500n 0.000633 388.5600n 0.000649 388.5700n 0.000666 388.5800n 0.000682 388.5900n 0.000698 388.6000n 0.000714 388.6100n 0.000730 388.6200n 0.000746 388.6300n 0.000761 388.6400n 0.000777
+ 388.6500n 0.000793 388.6600n 0.000808 388.6700n 0.000824 388.6800n 0.000839 388.6900n 0.000854 388.7000n 0.000869 388.7100n 0.000884 388.7200n 0.000899 388.7300n 0.000913 388.7400n 0.000928 388.7500n 0.000942 388.7600n 0.000956 388.7700n 0.000969 388.7800n 0.000983 388.7900n 0.000996
+ 388.8000n 0.001009 388.8100n 0.001021 388.8200n 0.001033 388.8300n 0.001045 388.8400n 0.001057 388.8500n 0.001068 388.8600n 0.001079 388.8700n 0.001090 388.8800n 0.001100 388.8900n 0.001110 388.9000n 0.001120 388.9100n 0.001129 388.9200n 0.001138 388.9300n 0.001146 388.9400n 0.001154
+ 388.9500n 0.001162 388.9600n 0.001169 388.9700n 0.001176 388.9800n 0.001182 388.9900n 0.001188 389.0000n 0.001194 389.0100n 0.001199 389.0200n 0.001203 389.0300n 0.001207 389.0400n 0.001211 389.0500n 0.001214 389.0600n 0.001217 389.0700n 0.001219 389.0800n 0.001221 389.0900n 0.001222
+ 389.1000n 0.001223 389.1100n 0.001223 389.1200n 0.001223 389.1300n 0.001222 389.1400n 0.001221 389.1500n 0.001219 389.1600n 0.001217 389.1700n 0.001214 389.1800n 0.001211 389.1900n 0.001207 389.2000n 0.001203 389.2100n 0.001198 389.2200n 0.001193 389.2300n 0.001187 389.2400n 0.001181
+ 389.2500n 0.001174 389.2600n 0.001167 389.2700n 0.001159 389.2800n 0.001150 389.2900n 0.001142 389.3000n 0.001132 389.3100n 0.001122 389.3200n 0.001112 389.3300n 0.001101 389.3400n 0.001090 389.3500n 0.001078 389.3600n 0.001066 389.3700n 0.001053 389.3800n 0.001040 389.3900n 0.001027
+ 389.4000n 0.001013 389.4100n 0.000998 389.4200n 0.000983 389.4300n 0.000968 389.4400n 0.000952 389.4500n 0.000936 389.4600n 0.000919 389.4700n 0.000902 389.4800n 0.000885 389.4900n 0.000867 389.5000n 0.000848 389.5100n 0.000830 389.5200n 0.000811 389.5300n 0.000792 389.5400n 0.000772
+ 389.5500n 0.000752 389.5600n 0.000731 389.5700n 0.000711 389.5800n 0.000690 389.5900n 0.000668 389.6000n 0.000647 389.6100n 0.000625 389.6200n 0.000603 389.6300n 0.000580 389.6400n 0.000557 389.6500n 0.000535 389.6600n 0.000511 389.6700n 0.000488 389.6800n 0.000464 389.6900n 0.000440
+ 389.7000n 0.000416 389.7100n 0.000392 389.7200n 0.000367 389.7300n 0.000343 389.7400n 0.000318 389.7500n 0.000293 389.7600n 0.000268 389.7700n 0.000243 389.7800n 0.000217 389.7900n 0.000192 389.8000n 0.000166 389.8100n 0.000141 389.8200n 0.000115 389.8300n 0.000089 389.8400n 0.000063
+ 389.8500n 0.000037 389.8600n 0.000012 389.8700n -0.000014 389.8800n -0.000040 389.8900n -0.000066 389.9000n -0.000092 389.9100n -0.000118 389.9200n -0.000144 389.9300n -0.000170 389.9400n -0.000196 389.9500n -0.000222 389.9600n -0.000248 389.9700n -0.000274 389.9800n -0.000299 389.9900n -0.000325
+ 390.0000n -0.000351 390.0100n -0.000376 390.0200n -0.000401 390.0300n -0.000426 390.0400n -0.000452 390.0500n -0.000476 390.0600n -0.000501 390.0700n -0.000526 390.0800n -0.000550 390.0900n -0.000575 390.1000n -0.000599 390.1100n -0.000623 390.1200n -0.000647 390.1300n -0.000670 390.1400n -0.000694
+ 390.1500n -0.000717 390.1600n -0.000740 390.1700n -0.000763 390.1800n -0.000786 390.1900n -0.000808 390.2000n -0.000830 390.2100n -0.000852 390.2200n -0.000874 390.2300n -0.000895 390.2400n -0.000917 390.2500n -0.000938 390.2600n -0.000958 390.2700n -0.000979 390.2800n -0.000999 390.2900n -0.001019
+ 390.3000n -0.001038 390.3100n -0.001058 390.3200n -0.001077 390.3300n -0.001096 390.3400n -0.001114 390.3500n -0.001133 390.3600n -0.001151 390.3700n -0.001168 390.3800n -0.001186 390.3900n -0.001203 390.4000n -0.001220 390.4100n -0.001236 390.4200n -0.001252 390.4300n -0.001268 390.4400n -0.001284
+ 390.4500n -0.001299 390.4600n -0.001314 390.4700n -0.001329 390.4800n -0.001343 390.4900n -0.001357 390.5000n -0.001371 390.5100n -0.001385 390.5200n -0.001398 390.5300n -0.001411 390.5400n -0.001423 390.5500n -0.001436 390.5600n -0.001448 390.5700n -0.001459 390.5800n -0.001471 390.5900n -0.001482
+ 390.6000n -0.001493 390.6100n -0.001503 390.6200n -0.001513 390.6300n -0.001523 390.6400n -0.001533 390.6500n -0.001542 390.6600n -0.001551 390.6700n -0.001560 390.6800n -0.001568 390.6900n -0.001577 390.7000n -0.001584 390.7100n -0.001592 390.7200n -0.001599 390.7300n -0.001606 390.7400n -0.001613
+ 390.7500n -0.001620 390.7600n -0.001626 390.7700n -0.001632 390.7800n -0.001637 390.7900n -0.001643 390.8000n -0.001648 390.8100n -0.001653 390.8200n -0.001657 390.8300n -0.001661 390.8400n -0.001665 390.8500n -0.001669 390.8600n -0.001673 390.8700n -0.001676 390.8800n -0.001679 390.8900n -0.001682
+ 390.9000n -0.001684 390.9100n -0.001686 390.9200n -0.001689 390.9300n -0.001690 390.9400n -0.001692 390.9500n -0.001693 390.9600n -0.001694 390.9700n -0.001695 390.9800n -0.001696 390.9900n -0.001696 391.0000n -0.001696 391.0100n -0.001696 391.0200n -0.001695 391.0300n -0.001695 391.0400n -0.001694
+ 391.0500n -0.001693 391.0600n -0.001692 391.0700n -0.001690 391.0800n -0.001689 391.0900n -0.001687 391.1000n -0.001685 391.1100n -0.001682 391.1200n -0.001680 391.1300n -0.001677 391.1400n -0.001674 391.1500n -0.001671 391.1600n -0.001667 391.1700n -0.001664 391.1800n -0.001660 391.1900n -0.001656
+ 391.2000n -0.001651 391.2100n -0.001647 391.2200n -0.001642 391.2300n -0.001637 391.2400n -0.001632 391.2500n -0.001627 391.2600n -0.001621 391.2700n -0.001616 391.2800n -0.001610 391.2900n -0.001603 391.3000n -0.001597 391.3100n -0.001591 391.3200n -0.001584 391.3300n -0.001577 391.3400n -0.001570
+ 391.3500n -0.001562 391.3600n -0.001555 391.3700n -0.001547 391.3800n -0.001539 391.3900n -0.001531 391.4000n -0.001522 391.4100n -0.001514 391.4200n -0.001505 391.4300n -0.001496 391.4400n -0.001487 391.4500n -0.001478 391.4600n -0.001468 391.4700n -0.001458 391.4800n -0.001448 391.4900n -0.001438
+ 391.5000n -0.001428 391.5100n -0.001417 391.5200n -0.001406 391.5300n -0.001395 391.5400n -0.001384 391.5500n -0.001373 391.5600n -0.001361 391.5700n -0.001349 391.5800n -0.001337 391.5900n -0.001325 391.6000n -0.001313 391.6100n -0.001300 391.6200n -0.001288 391.6300n -0.001275 391.6400n -0.001261
+ 391.6500n -0.001248 391.6600n -0.001235 391.6700n -0.001221 391.6800n -0.001207 391.6900n -0.001193 391.7000n -0.001179 391.7100n -0.001164 391.7200n -0.001150 391.7300n -0.001135 391.7400n -0.001120 391.7500n -0.001105 391.7600n -0.001090 391.7700n -0.001074 391.7800n -0.001059 391.7900n -0.001043
+ 391.8000n -0.001027 391.8100n -0.001011 391.8200n -0.000994 391.8300n -0.000978 391.8400n -0.000961 391.8500n -0.000945 391.8600n -0.000928 391.8700n -0.000911 391.8800n -0.000894 391.8900n -0.000876 391.9000n -0.000859 391.9100n -0.000841 391.9200n -0.000824 391.9300n -0.000806 391.9400n -0.000788
+ 391.9500n -0.000770 391.9600n -0.000752 391.9700n -0.000734 391.9800n -0.000715 391.9900n -0.000697 392.0000n -0.000678 392.0100n -0.000660 392.0200n -0.000641 392.0300n -0.000622 392.0400n -0.000604 392.0500n -0.000585 392.0600n -0.000566 392.0700n -0.000547 392.0800n -0.000528 392.0900n -0.000509
+ 392.1000n -0.000490 392.1100n -0.000471 392.1200n -0.000451 392.1300n -0.000432 392.1400n -0.000413 392.1500n -0.000394 392.1600n -0.000375 392.1700n -0.000356 392.1800n -0.000336 392.1900n -0.000317 392.2000n -0.000298 392.2100n -0.000279 392.2200n -0.000260 392.2300n -0.000241 392.2400n -0.000222
+ 392.2500n -0.000204 392.2600n -0.000185 392.2700n -0.000166 392.2800n -0.000148 392.2900n -0.000129 392.3000n -0.000111 392.3100n -0.000092 392.3200n -0.000074 392.3300n -0.000056 392.3400n -0.000038 392.3500n -0.000021 392.3600n -0.000003 392.3700n 0.000015 392.3800n 0.000032 392.3900n 0.000049
+ 392.4000n 0.000066 392.4100n 0.000083 392.4200n 0.000099 392.4300n 0.000116 392.4400n 0.000132 392.4500n 0.000148 392.4600n 0.000164 392.4700n 0.000179 392.4800n 0.000195 392.4900n 0.000210 392.5000n 0.000225 392.5100n 0.000239 392.5200n 0.000254 392.5300n 0.000268 392.5400n 0.000281
+ 392.5500n 0.000295 392.5600n 0.000308 392.5700n 0.000321 392.5800n 0.000334 392.5900n 0.000346 392.6000n 0.000358 392.6100n 0.000370 392.6200n 0.000381 392.6300n 0.000393 392.6400n 0.000403 392.6500n 0.000414 392.6600n 0.000424 392.6700n 0.000434 392.6800n 0.000443 392.6900n 0.000452
+ 392.7000n 0.000461 392.7100n 0.000469 392.7200n 0.000477 392.7300n 0.000485 392.7400n 0.000492 392.7500n 0.000499 392.7600n 0.000505 392.7700n 0.000511 392.7800n 0.000517 392.7900n 0.000522 392.8000n 0.000527 392.8100n 0.000532 392.8200n 0.000536 392.8300n 0.000540 392.8400n 0.000543
+ 392.8500n 0.000546 392.8600n 0.000549 392.8700n 0.000551 392.8800n 0.000553 392.8900n 0.000554 392.9000n 0.000555 392.9100n 0.000556 392.9200n 0.000556 392.9300n 0.000556 392.9400n 0.000555 392.9500n 0.000554 392.9600n 0.000553 392.9700n 0.000551 392.9800n 0.000548 392.9900n 0.000546
+ 393.0000n 0.000543 393.0100n 0.000539 393.0200n 0.000536 393.0300n 0.000532 393.0400n 0.000527 393.0500n 0.000522 393.0600n 0.000517 393.0700n 0.000511 393.0800n 0.000505 393.0900n 0.000499 393.1000n 0.000492 393.1100n 0.000485 393.1200n 0.000478 393.1300n 0.000470 393.1400n 0.000462
+ 393.1500n 0.000453 393.1600n 0.000444 393.1700n 0.000435 393.1800n 0.000426 393.1900n 0.000416 393.2000n 0.000406 393.2100n 0.000396 393.2200n 0.000385 393.2300n 0.000374 393.2400n 0.000363 393.2500n 0.000352 393.2600n 0.000340 393.2700n 0.000328 393.2800n 0.000316 393.2900n 0.000303
+ 393.3000n 0.000290 393.3100n 0.000278 393.3200n 0.000264 393.3300n 0.000251 393.3400n 0.000237 393.3500n 0.000224 393.3600n 0.000210 393.3700n 0.000196 393.3800n 0.000181 393.3900n 0.000167 393.4000n 0.000152 393.4100n 0.000138 393.4200n 0.000123 393.4300n 0.000108 393.4400n 0.000093
+ 393.4500n 0.000077 393.4600n 0.000062 393.4700n 0.000047 393.4800n 0.000031 393.4900n 0.000016 393.5000n 0.000000 393.5100n -0.000016 393.5200n -0.000031 393.5300n -0.000047 393.5400n -0.000063 393.5500n -0.000079 393.5600n -0.000095 393.5700n -0.000110 393.5800n -0.000126 393.5900n -0.000142
+ 393.6000n -0.000158 393.6100n -0.000173 393.6200n -0.000189 393.6300n -0.000205 393.6400n -0.000220 393.6500n -0.000236 393.6600n -0.000251 393.6700n -0.000266 393.6800n -0.000282 393.6900n -0.000297 393.7000n -0.000312 393.7100n -0.000327 393.7200n -0.000341 393.7300n -0.000356 393.7400n -0.000371
+ 393.7500n -0.000385 393.7600n -0.000399 393.7700n -0.000413 393.7800n -0.000427 393.7900n -0.000441 393.8000n -0.000454 393.8100n -0.000468 393.8200n -0.000481 393.8300n -0.000494 393.8400n -0.000507 393.8500n -0.000519 393.8600n -0.000531 393.8700n -0.000544 393.8800n -0.000555 393.8900n -0.000567
+ 393.9000n -0.000579 393.9100n -0.000590 393.9200n -0.000601 393.9300n -0.000611 393.9400n -0.000622 393.9500n -0.000632 393.9600n -0.000642 393.9700n -0.000652 393.9800n -0.000661 393.9900n -0.000670 394.0000n -0.000679 394.0100n -0.000688 394.0200n -0.000696 394.0300n -0.000704 394.0400n -0.000712
+ 394.0500n -0.000720 394.0600n -0.000727 394.0700n -0.000734 394.0800n -0.000741 394.0900n -0.000747 394.1000n -0.000754 394.1100n -0.000759 394.1200n -0.000765 394.1300n -0.000770 394.1400n -0.000776 394.1500n -0.000780 394.1600n -0.000785 394.1700n -0.000789 394.1800n -0.000793 394.1900n -0.000797
+ 394.2000n -0.000800 394.2100n -0.000804 394.2200n -0.000807 394.2300n -0.000809 394.2400n -0.000812 394.2500n -0.000814 394.2600n -0.000816 394.2700n -0.000818 394.2800n -0.000819 394.2900n -0.000820 394.3000n -0.000821 394.3100n -0.000822 394.3200n -0.000823 394.3300n -0.000823 394.3400n -0.000823
+ 394.3500n -0.000823 394.3600n -0.000823 394.3700n -0.000822 394.3800n -0.000822 394.3900n -0.000821 394.4000n -0.000820 394.4100n -0.000818 394.4200n -0.000817 394.4300n -0.000815 394.4400n -0.000814 394.4500n -0.000812 394.4600n -0.000810 394.4700n -0.000807 394.4800n -0.000805 394.4900n -0.000802
+ 394.5000n -0.000800 394.5100n -0.000797 394.5200n -0.000794 394.5300n -0.000791 394.5400n -0.000788 394.5500n -0.000785 394.5600n -0.000781 394.5700n -0.000778 394.5800n -0.000775 394.5900n -0.000771 394.6000n -0.000767 394.6100n -0.000764 394.6200n -0.000760 394.6300n -0.000756 394.6400n -0.000752
+ 394.6500n -0.000748 394.6600n -0.000745 394.6700n -0.000741 394.6800n -0.000737 394.6900n -0.000733 394.7000n -0.000729 394.7100n -0.000725 394.7200n -0.000721 394.7300n -0.000717 394.7400n -0.000713 394.7500n -0.000709 394.7600n -0.000705 394.7700n -0.000701 394.7800n -0.000697 394.7900n -0.000693
+ 394.8000n -0.000689 394.8100n -0.000685 394.8200n -0.000681 394.8300n -0.000678 394.8400n -0.000674 394.8500n -0.000671 394.8600n -0.000667 394.8700n -0.000664 394.8800n -0.000660 394.8900n -0.000657 394.9000n -0.000654 394.9100n -0.000651 394.9200n -0.000648 394.9300n -0.000645 394.9400n -0.000642
+ 394.9500n -0.000639 394.9600n -0.000636 394.9700n -0.000634 394.9800n -0.000631 394.9900n -0.000629 395.0000n -0.000627 395.0100n -0.000624 395.0200n -0.000622 395.0300n -0.000620 395.0400n -0.000618 395.0500n -0.000617 395.0600n -0.000615 395.0700n -0.000613 395.0800n -0.000612 395.0900n -0.000611
+ 395.1000n -0.000610 395.1100n -0.000608 395.1200n -0.000607 395.1300n -0.000607 395.1400n -0.000606 395.1500n -0.000605 395.1600n -0.000605 395.1700n -0.000604 395.1800n -0.000604 395.1900n -0.000604 395.2000n -0.000603 395.2100n -0.000603 395.2200n -0.000603 395.2300n -0.000604 395.2400n -0.000604
+ 395.2500n -0.000604 395.2600n -0.000605 395.2700n -0.000605 395.2800n -0.000606 395.2900n -0.000606 395.3000n -0.000607 395.3100n -0.000608 395.3200n -0.000609 395.3300n -0.000610 395.3400n -0.000611 395.3500n -0.000612 395.3600n -0.000613 395.3700n -0.000614 395.3800n -0.000616 395.3900n -0.000617
+ 395.4000n -0.000618 395.4100n -0.000620 395.4200n -0.000621 395.4300n -0.000622 395.4400n -0.000624 395.4500n -0.000625 395.4600n -0.000627 395.4700n -0.000628 395.4800n -0.000630 395.4900n -0.000632 395.5000n -0.000633 395.5100n -0.000635 395.5200n -0.000636 395.5300n -0.000638 395.5400n -0.000639
+ 395.5500n -0.000641 395.5600n -0.000642 395.5700n -0.000644 395.5800n -0.000645 395.5900n -0.000647 395.6000n -0.000648 395.6100n -0.000650 395.6200n -0.000651 395.6300n -0.000652 395.6400n -0.000653 395.6500n -0.000655 395.6600n -0.000656 395.6700n -0.000657 395.6800n -0.000658 395.6900n -0.000659
+ 395.7000n -0.000659 395.7100n -0.000660 395.7200n -0.000661 395.7300n -0.000662 395.7400n -0.000662 395.7500n -0.000663 395.7600n -0.000663 395.7700n -0.000663 395.7800n -0.000664 395.7900n -0.000664 395.8000n -0.000664 395.8100n -0.000664 395.8200n -0.000664 395.8300n -0.000663 395.8400n -0.000663
+ 395.8500n -0.000663 395.8600n -0.000662 395.8700n -0.000661 395.8800n -0.000661 395.8900n -0.000660 395.9000n -0.000659 395.9100n -0.000658 395.9200n -0.000657 395.9300n -0.000656 395.9400n -0.000654 395.9500n -0.000653 395.9600n -0.000651 395.9700n -0.000650 395.9800n -0.000648 395.9900n -0.000646
+ 396.0000n -0.000645 396.0100n -0.000643 396.0200n -0.000641 396.0300n -0.000639 396.0400n -0.000636 396.0500n -0.000634 396.0600n -0.000632 396.0700n -0.000630 396.0800n -0.000627 396.0900n -0.000625 396.1000n -0.000622 396.1100n -0.000619 396.1200n -0.000617 396.1300n -0.000614 396.1400n -0.000611
+ 396.1500n -0.000608 396.1600n -0.000606 396.1700n -0.000603 396.1800n -0.000600 396.1900n -0.000597 396.2000n -0.000594 396.2100n -0.000591 396.2200n -0.000588 396.2300n -0.000585 396.2400n -0.000582 396.2500n -0.000579 396.2600n -0.000577 396.2700n -0.000574 396.2800n -0.000571 396.2900n -0.000568
+ 396.3000n -0.000565 396.3100n -0.000563 396.3200n -0.000560 396.3300n -0.000557 396.3400n -0.000555 396.3500n -0.000552 396.3600n -0.000550 396.3700n -0.000548 396.3800n -0.000546 396.3900n -0.000544 396.4000n -0.000542 396.4100n -0.000540 396.4200n -0.000538 396.4300n -0.000536 396.4400n -0.000535
+ 396.4500n -0.000534 396.4600n -0.000532 396.4700n -0.000531 396.4800n -0.000530 396.4900n -0.000530 396.5000n -0.000529 396.5100n -0.000529 396.5200n -0.000529 396.5300n -0.000529 396.5400n -0.000529 396.5500n -0.000529 396.5600n -0.000530 396.5700n -0.000531 396.5800n -0.000532 396.5900n -0.000533
+ 396.6000n -0.000534 396.6100n -0.000536 396.6200n -0.000538 396.6300n -0.000540 396.6400n -0.000543 396.6500n -0.000545 396.6600n -0.000548 396.6700n -0.000552 396.6800n -0.000555 396.6900n -0.000559 396.7000n -0.000563 396.7100n -0.000567 396.7200n -0.000572 396.7300n -0.000576 396.7400n -0.000582
+ 396.7500n -0.000587 396.7600n -0.000593 396.7700n -0.000599 396.7800n -0.000605 396.7900n -0.000611 396.8000n -0.000618 396.8100n -0.000625 396.8200n -0.000633 396.8300n -0.000640 396.8400n -0.000648 396.8500n -0.000657 396.8600n -0.000665 396.8700n -0.000674 396.8800n -0.000683 396.8900n -0.000693
+ 396.9000n -0.000702 396.9100n -0.000712 396.9200n -0.000723 396.9300n -0.000733 396.9400n -0.000744 396.9500n -0.000755 396.9600n -0.000766 396.9700n -0.000778 396.9800n -0.000790 396.9900n -0.000802 397.0000n -0.000814 397.0100n -0.000827 397.0200n -0.000840 397.0300n -0.000853 397.0400n -0.000866
+ 397.0500n -0.000879 397.0600n -0.000893 397.0700n -0.000907 397.0800n -0.000921 397.0900n -0.000935 397.1000n -0.000950 397.1100n -0.000964 397.1200n -0.000979 397.1300n -0.000994 397.1400n -0.001009 397.1500n -0.001024 397.1600n -0.001039 397.1700n -0.001055 397.1800n -0.001070 397.1900n -0.001086
+ 397.2000n -0.001101 397.2100n -0.001117 397.2200n -0.001133 397.2300n -0.001148 397.2400n -0.001164 397.2500n -0.001180 397.2600n -0.001196 397.2700n -0.001212 397.2800n -0.001228 397.2900n -0.001243 397.3000n -0.001259 397.3100n -0.001275 397.3200n -0.001290 397.3300n -0.001306 397.3400n -0.001321
+ 397.3500n -0.001337 397.3600n -0.001352 397.3700n -0.001367 397.3800n -0.001382 397.3900n -0.001396 397.4000n -0.001411 397.4100n -0.001425 397.4200n -0.001439 397.4300n -0.001453 397.4400n -0.001467 397.4500n -0.001480 397.4600n -0.001493 397.4700n -0.001506 397.4800n -0.001519 397.4900n -0.001531
+ 397.5000n -0.001543 397.5100n -0.001554 397.5200n -0.001565 397.5300n -0.001576 397.5400n -0.001587 397.5500n -0.001597 397.5600n -0.001606 397.5700n -0.001615 397.5800n -0.001624 397.5900n -0.001632 397.6000n -0.001640 397.6100n -0.001647 397.6200n -0.001654 397.6300n -0.001660 397.6400n -0.001666
+ 397.6500n -0.001671 397.6600n -0.001676 397.6700n -0.001680 397.6800n -0.001684 397.6900n -0.001687 397.7000n -0.001689 397.7100n -0.001691 397.7200n -0.001692 397.7300n -0.001692 397.7400n -0.001692 397.7500n -0.001691 397.7600n -0.001690 397.7700n -0.001688 397.7800n -0.001685 397.7900n -0.001681
+ 397.8000n -0.001677 397.8100n -0.001672 397.8200n -0.001666 397.8300n -0.001660 397.8400n -0.001653 397.8500n -0.001645 397.8600n -0.001636 397.8700n -0.001627 397.8800n -0.001617 397.8900n -0.001606 397.9000n -0.001595 397.9100n -0.001582 397.9200n -0.001569 397.9300n -0.001555 397.9400n -0.001541
+ 397.9500n -0.001525 397.9600n -0.001509 397.9700n -0.001492 397.9800n -0.001474 397.9900n -0.001456 398.0000n -0.001436 398.0100n -0.001416 398.0200n -0.001395 398.0300n -0.001374 398.0400n -0.001351 398.0500n -0.001328 398.0600n -0.001304 398.0700n -0.001279 398.0800n -0.001254 398.0900n -0.001228
+ 398.1000n -0.001201 398.1100n -0.001173 398.1200n -0.001144 398.1300n -0.001115 398.1400n -0.001085 398.1500n -0.001055 398.1600n -0.001023 398.1700n -0.000991 398.1800n -0.000959 398.1900n -0.000925 398.2000n -0.000891 398.2100n -0.000856 398.2200n -0.000821 398.2300n -0.000785 398.2400n -0.000748
+ 398.2500n -0.000711 398.2600n -0.000673 398.2700n -0.000635 398.2800n -0.000596 398.2900n -0.000556 398.3000n -0.000516 398.3100n -0.000476 398.3200n -0.000435 398.3300n -0.000393 398.3400n -0.000351 398.3500n -0.000308 398.3600n -0.000265 398.3700n -0.000222 398.3800n -0.000178 398.3900n -0.000134
+ 398.4000n -0.000090 398.4100n -0.000045 398.4200n 0.000001 398.4300n 0.000046 398.4400n 0.000092 398.4500n 0.000138 398.4600n 0.000184 398.4700n 0.000231 398.4800n 0.000278 398.4900n 0.000325 398.5000n 0.000372 398.5100n 0.000419 398.5200n 0.000466 398.5300n 0.000514 398.5400n 0.000561
+ 398.5500n 0.000609 398.5600n 0.000657 398.5700n 0.000704 398.5800n 0.000752 398.5900n 0.000799 398.6000n 0.000847 398.6100n 0.000894 398.6200n 0.000942 398.6300n 0.000989 398.6400n 0.001036 398.6500n 0.001083 398.6600n 0.001129 398.6700n 0.001176 398.6800n 0.001222 398.6900n 0.001268
+ 398.7000n 0.001314 398.7100n 0.001359 398.7200n 0.001404 398.7300n 0.001449 398.7400n 0.001493 398.7500n 0.001537 398.7600n 0.001580 398.7700n 0.001623 398.7800n 0.001666 398.7900n 0.001707 398.8000n 0.001749 398.8100n 0.001790 398.8200n 0.001830 398.8300n 0.001870 398.8400n 0.001909
+ 398.8500n 0.001948 398.8600n 0.001986 398.8700n 0.002023 398.8800n 0.002060 398.8900n 0.002096 398.9000n 0.002131 398.9100n 0.002165 398.9200n 0.002199 398.9300n 0.002232 398.9400n 0.002264 398.9500n 0.002296 398.9600n 0.002326 398.9700n 0.002356 398.9800n 0.002385 398.9900n 0.002413
+ 399.0000n 0.002440 399.0100n 0.002466 399.0200n 0.002491 399.0300n 0.002516 399.0400n 0.002539 399.0500n 0.002562 399.0600n 0.002583 399.0700n 0.002604 399.0800n 0.002624 399.0900n 0.002642 399.1000n 0.002660 399.1100n 0.002677 399.1200n 0.002692 399.1300n 0.002707 399.1400n 0.002720
+ 399.1500n 0.002733 399.1600n 0.002744 399.1700n 0.002755 399.1800n 0.002764 399.1900n 0.002773 399.2000n 0.002780 399.2100n 0.002786 399.2200n 0.002791 399.2300n 0.002796 399.2400n 0.002799 399.2500n 0.002801 399.2600n 0.002801 399.2700n 0.002801 399.2800n 0.002800 399.2900n 0.002798
+ 399.3000n 0.002794 399.3100n 0.002790 399.3200n 0.002785 399.3300n 0.002778 399.3400n 0.002771 399.3500n 0.002762 399.3600n 0.002752 399.3700n 0.002742 399.3800n 0.002730 399.3900n 0.002717 399.4000n 0.002704 399.4100n 0.002689 399.4200n 0.002673 399.4300n 0.002657 399.4400n 0.002639
+ 399.4500n 0.002620 399.4600n 0.002601 399.4700n 0.002580 399.4800n 0.002559 399.4900n 0.002537 399.5000n 0.002513 399.5100n 0.002489 399.5200n 0.002464 399.5300n 0.002439 399.5400n 0.002412 399.5500n 0.002385 399.5600n 0.002356 399.5700n 0.002327 399.5800n 0.002298 399.5900n 0.002267
+ 399.6000n 0.002236 399.6100n 0.002204 399.6200n 0.002171 399.6300n 0.002137 399.6400n 0.002103 399.6500n 0.002069 399.6600n 0.002033 399.6700n 0.001997 399.6800n 0.001961 399.6900n 0.001924 399.7000n 0.001886 399.7100n 0.001848 399.7200n 0.001809 399.7300n 0.001770 399.7400n 0.001731
+ 399.7500n 0.001691 399.7600n 0.001650 399.7700n 0.001609 399.7800n 0.001568 399.7900n 0.001526 399.8000n 0.001485 399.8100n 0.001442 399.8200n 0.001400 399.8300n 0.001357 399.8400n 0.001314 399.8500n 0.001271 399.8600n 0.001228 399.8700n 0.001184 399.8800n 0.001140 399.8900n 0.001096
+ 399.9000n 0.001053 399.9100n 0.001009 399.9200n 0.000964 399.9300n 0.000920 399.9400n 0.000876 399.9500n 0.000832 399.9600n 0.000788 399.9700n 0.000744 399.9800n 0.000700 399.9900n 0.000656 400.0000n 0.000612 400.0100n 0.000569 400.0200n 0.000525 400.0300n 0.000482 400.0400n 0.000439
+ 400.0500n 0.000396 400.0600n 0.000353 400.0700n 0.000311 400.0800n 0.000269 400.0900n 0.000227 400.1000n 0.000185 400.1100n 0.000144 400.1200n 0.000103 400.1300n 0.000063 400.1400n 0.000023 400.1500n -0.000017 400.1600n -0.000056 400.1700n -0.000095 400.1800n -0.000134 400.1900n -0.000172
+ 400.2000n -0.000209 400.2100n -0.000246 400.2200n -0.000283 400.2300n -0.000319 400.2400n -0.000354 400.2500n -0.000389 400.2600n -0.000424 400.2700n -0.000457 400.2800n -0.000491 400.2900n -0.000523 400.3000n -0.000555 400.3100n -0.000587 400.3200n -0.000618 400.3300n -0.000648 400.3400n -0.000678
+ 400.3500n -0.000707 400.3600n -0.000735 400.3700n -0.000762 400.3800n -0.000790 400.3900n -0.000816 400.4000n -0.000842 400.4100n -0.000867 400.4200n -0.000891 400.4300n -0.000915 400.4400n -0.000937 400.4500n -0.000960 400.4600n -0.000981 400.4700n -0.001002 400.4800n -0.001023 400.4900n -0.001042
+ 400.5000n -0.001061 400.5100n -0.001079 400.5200n -0.001096 400.5300n -0.001113 400.5400n -0.001129 400.5500n -0.001145 400.5600n -0.001159 400.5700n -0.001173 400.5800n -0.001187 400.5900n -0.001200 400.6000n -0.001212 400.6100n -0.001223 400.6200n -0.001234 400.6300n -0.001244 400.6400n -0.001253
+ 400.6500n -0.001262 400.6600n -0.001270 400.6700n -0.001278 400.6800n -0.001284 400.6900n -0.001291 400.7000n -0.001296 400.7100n -0.001302 400.7200n -0.001306 400.7300n -0.001310 400.7400n -0.001314 400.7500n -0.001316 400.7600n -0.001319 400.7700n -0.001321 400.7800n -0.001322 400.7900n -0.001323
+ 400.8000n -0.001323 400.8100n -0.001323 400.8200n -0.001322 400.8300n -0.001321 400.8400n -0.001319 400.8500n -0.001317 400.8600n -0.001315 400.8700n -0.001312 400.8800n -0.001309 400.8900n -0.001305 400.9000n -0.001301 400.9100n -0.001297 400.9200n -0.001292 400.9300n -0.001287 400.9400n -0.001282
+ 400.9500n -0.001276 400.9600n -0.001270 400.9700n -0.001264 400.9800n -0.001258 400.9900n -0.001251 401.0000n -0.001244 401.0100n -0.001237 401.0200n -0.001230 401.0300n -0.001222 401.0400n -0.001215 401.0500n -0.001207 401.0600n -0.001199 401.0700n -0.001191 401.0800n -0.001183 401.0900n -0.001174
+ 401.1000n -0.001166 401.1100n -0.001157 401.1200n -0.001149 401.1300n -0.001140 401.1400n -0.001132 401.1500n -0.001123 401.1600n -0.001115 401.1700n -0.001106 401.1800n -0.001097 401.1900n -0.001089 401.2000n -0.001080 401.2100n -0.001072 401.2200n -0.001063 401.2300n -0.001055 401.2400n -0.001047
+ 401.2500n -0.001039 401.2600n -0.001031 401.2700n -0.001023 401.2800n -0.001015 401.2900n -0.001007 401.3000n -0.001000 401.3100n -0.000992 401.3200n -0.000985 401.3300n -0.000978 401.3400n -0.000972 401.3500n -0.000965 401.3600n -0.000959 401.3700n -0.000952 401.3800n -0.000946 401.3900n -0.000941
+ 401.4000n -0.000935 401.4100n -0.000930 401.4200n -0.000925 401.4300n -0.000920 401.4400n -0.000916 401.4500n -0.000911 401.4600n -0.000907 401.4700n -0.000904 401.4800n -0.000900 401.4900n -0.000897 401.5000n -0.000894 401.5100n -0.000892 401.5200n -0.000889 401.5300n -0.000887 401.5400n -0.000886
+ 401.5500n -0.000884 401.5600n -0.000883 401.5700n -0.000882 401.5800n -0.000882 401.5900n -0.000881 401.6000n -0.000881 401.6100n -0.000882 401.6200n -0.000882 401.6300n -0.000883 401.6400n -0.000884 401.6500n -0.000886 401.6600n -0.000888 401.6700n -0.000890 401.6800n -0.000892 401.6900n -0.000895
+ 401.7000n -0.000897 401.7100n -0.000901 401.7200n -0.000904 401.7300n -0.000908 401.7400n -0.000912 401.7500n -0.000916 401.7600n -0.000920 401.7700n -0.000925 401.7800n -0.000930 401.7900n -0.000935 401.8000n -0.000941 401.8100n -0.000946 401.8200n -0.000952 401.8300n -0.000958 401.8400n -0.000964
+ 401.8500n -0.000971 401.8600n -0.000978 401.8700n -0.000984 401.8800n -0.000991 401.8900n -0.000999 401.9000n -0.001006 401.9100n -0.001013 401.9200n -0.001021 401.9300n -0.001029 401.9400n -0.001037 401.9500n -0.001045 401.9600n -0.001053 401.9700n -0.001061 401.9800n -0.001069 401.9900n -0.001078
+ 402.0000n -0.001086 402.0100n -0.001095 402.0200n -0.001104 402.0300n -0.001112 402.0400n -0.001121 402.0500n -0.001130 402.0600n -0.001139 402.0700n -0.001147 402.0800n -0.001156 402.0900n -0.001165 402.1000n -0.001174 402.1100n -0.001183 402.1200n -0.001192 402.1300n -0.001200 402.1400n -0.001209
+ 402.1500n -0.001218 402.1600n -0.001227 402.1700n -0.001235 402.1800n -0.001244 402.1900n -0.001252 402.2000n -0.001260 402.2100n -0.001269 402.2200n -0.001277 402.2300n -0.001285 402.2400n -0.001293 402.2500n -0.001301 402.2600n -0.001308 402.2700n -0.001316 402.2800n -0.001323 402.2900n -0.001331
+ 402.3000n -0.001338 402.3100n -0.001345 402.3200n -0.001352 402.3300n -0.001358 402.3400n -0.001365 402.3500n -0.001371 402.3600n -0.001377 402.3700n -0.001383 402.3800n -0.001389 402.3900n -0.001395 402.4000n -0.001400 402.4100n -0.001405 402.4200n -0.001410 402.4300n -0.001415 402.4400n -0.001419
+ 402.4500n -0.001424 402.4600n -0.001428 402.4700n -0.001432 402.4800n -0.001435 402.4900n -0.001439 402.5000n -0.001442 402.5100n -0.001445 402.5200n -0.001448 402.5300n -0.001450 402.5400n -0.001453 402.5500n -0.001455 402.5600n -0.001457 402.5700n -0.001458 402.5800n -0.001460 402.5900n -0.001461
+ 402.6000n -0.001462 402.6100n -0.001463 402.6200n -0.001463 402.6300n -0.001464 402.6400n -0.001464 402.6500n -0.001464 402.6600n -0.001464 402.6700n -0.001463 402.6800n -0.001463 402.6900n -0.001462 402.7000n -0.001461 402.7100n -0.001459 402.7200n -0.001458 402.7300n -0.001456 402.7400n -0.001454
+ 402.7500n -0.001453 402.7600n -0.001450 402.7700n -0.001448 402.7800n -0.001446 402.7900n -0.001443 402.8000n -0.001440 402.8100n -0.001437 402.8200n -0.001434 402.8300n -0.001431 402.8400n -0.001428 402.8500n -0.001424 402.8600n -0.001421 402.8700n -0.001417 402.8800n -0.001413 402.8900n -0.001410
+ 402.9000n -0.001406 402.9100n -0.001402 402.9200n -0.001398 402.9300n -0.001393 402.9400n -0.001389 402.9500n -0.001385 402.9600n -0.001381 402.9700n -0.001376 402.9800n -0.001372 402.9900n -0.001367 403.0000n -0.001363 403.0100n -0.001359 403.0200n -0.001354 403.0300n -0.001350 403.0400n -0.001345
+ 403.0500n -0.001341 403.0600n -0.001336 403.0700n -0.001332 403.0800n -0.001328 403.0900n -0.001323 403.1000n -0.001319 403.1100n -0.001315 403.1200n -0.001311 403.1300n -0.001307 403.1400n -0.001303 403.1500n -0.001299 403.1600n -0.001295 403.1700n -0.001291 403.1800n -0.001288 403.1900n -0.001284
+ 403.2000n -0.001281 403.2100n -0.001278 403.2200n -0.001274 403.2300n -0.001271 403.2400n -0.001268 403.2500n -0.001266 403.2600n -0.001263 403.2700n -0.001261 403.2800n -0.001258 403.2900n -0.001256 403.3000n -0.001254 403.3100n -0.001252 403.3200n -0.001250 403.3300n -0.001249 403.3400n -0.001248
+ 403.3500n -0.001246 403.3600n -0.001245 403.3700n -0.001244 403.3800n -0.001244 403.3900n -0.001243 403.4000n -0.001243 403.4100n -0.001243 403.4200n -0.001243 403.4300n -0.001243 403.4400n -0.001244 403.4500n -0.001245 403.4600n -0.001245 403.4700n -0.001246 403.4800n -0.001248 403.4900n -0.001249
+ 403.5000n -0.001251 403.5100n -0.001253 403.5200n -0.001255 403.5300n -0.001257 403.5400n -0.001259 403.5500n -0.001262 403.5600n -0.001264 403.5700n -0.001267 403.5800n -0.001270 403.5900n -0.001274 403.6000n -0.001277 403.6100n -0.001281 403.6200n -0.001284 403.6300n -0.001288 403.6400n -0.001292
+ 403.6500n -0.001297 403.6600n -0.001301 403.6700n -0.001306 403.6800n -0.001310 403.6900n -0.001315 403.7000n -0.001320 403.7100n -0.001325 403.7200n -0.001330 403.7300n -0.001336 403.7400n -0.001341 403.7500n -0.001346 403.7600n -0.001352 403.7700n -0.001358 403.7800n -0.001364 403.7900n -0.001369
+ 403.8000n -0.001375 403.8100n -0.001381 403.8200n -0.001387 403.8300n -0.001394 403.8400n -0.001400 403.8500n -0.001406 403.8600n -0.001412 403.8700n -0.001418 403.8800n -0.001425 403.8900n -0.001431 403.9000n -0.001437 403.9100n -0.001443 403.9200n -0.001450 403.9300n -0.001456 403.9400n -0.001462
+ 403.9500n -0.001468 403.9600n -0.001474 403.9700n -0.001480 403.9800n -0.001486 403.9900n -0.001492 404.0000n -0.001498 404.0100n -0.001504 404.0200n -0.001510 404.0300n -0.001515 404.0400n -0.001521 404.0500n -0.001526 404.0600n -0.001531 404.0700n -0.001537 404.0800n -0.001542 404.0900n -0.001546
+ 404.1000n -0.001551 404.1100n -0.001556 404.1200n -0.001560 404.1300n -0.001564 404.1400n -0.001568 404.1500n -0.001572 404.1600n -0.001576 404.1700n -0.001580 404.1800n -0.001583 404.1900n -0.001586 404.2000n -0.001589 404.2100n -0.001592 404.2200n -0.001594 404.2300n -0.001596 404.2400n -0.001598
+ 404.2500n -0.001600 404.2600n -0.001602 404.2700n -0.001603 404.2800n -0.001604 404.2900n -0.001605 404.3000n -0.001606 404.3100n -0.001606 404.3200n -0.001606 404.3300n -0.001606 404.3400n -0.001605 404.3500n -0.001605 404.3600n -0.001604 404.3700n -0.001602 404.3800n -0.001601 404.3900n -0.001599
+ 404.4000n -0.001597 404.4100n -0.001595 404.4200n -0.001592 404.4300n -0.001589 404.4400n -0.001586 404.4500n -0.001583 404.4600n -0.001579 404.4700n -0.001575 404.4800n -0.001571 404.4900n -0.001566 404.5000n -0.001562 404.5100n -0.001557 404.5200n -0.001551 404.5300n -0.001546 404.5400n -0.001540
+ 404.5500n -0.001534 404.5600n -0.001528 404.5700n -0.001521 404.5800n -0.001515 404.5900n -0.001508 404.6000n -0.001501 404.6100n -0.001493 404.6200n -0.001486 404.6300n -0.001478 404.6400n -0.001470 404.6500n -0.001461 404.6600n -0.001453 404.6700n -0.001444 404.6800n -0.001435 404.6900n -0.001426
+ 404.7000n -0.001417 404.7100n -0.001408 404.7200n -0.001398 404.7300n -0.001389 404.7400n -0.001379 404.7500n -0.001369 404.7600n -0.001359 404.7700n -0.001349 404.7800n -0.001339 404.7900n -0.001328 404.8000n -0.001318 404.8100n -0.001307 404.8200n -0.001297 404.8300n -0.001286 404.8400n -0.001275
+ 404.8500n -0.001265 404.8600n -0.001254 404.8700n -0.001243 404.8800n -0.001232 404.8900n -0.001221 404.9000n -0.001210 404.9100n -0.001199 404.9200n -0.001189 404.9300n -0.001178 404.9400n -0.001167 404.9500n -0.001156 404.9600n -0.001146 404.9700n -0.001135 404.9800n -0.001125 404.9900n -0.001114
+ 405.0000n -0.001104 405.0100n -0.001094 405.0200n -0.001083 405.0300n -0.001073 405.0400n -0.001064 405.0500n -0.001054 405.0600n -0.001044 405.0700n -0.001035 405.0800n -0.001026 405.0900n -0.001017 405.1000n -0.001008 405.1100n -0.000999 405.1200n -0.000991 405.1300n -0.000982 405.1400n -0.000974
+ 405.1500n -0.000967 405.1600n -0.000959 405.1700n -0.000952 405.1800n -0.000945 405.1900n -0.000938 405.2000n -0.000931 405.2100n -0.000925 405.2200n -0.000919 405.2300n -0.000914 405.2400n -0.000908 405.2500n -0.000903 405.2600n -0.000898 405.2700n -0.000894 405.2800n -0.000890 405.2900n -0.000886
+ 405.3000n -0.000882 405.3100n -0.000879 405.3200n -0.000876 405.3300n -0.000873 405.3400n -0.000871 405.3500n -0.000869 405.3600n -0.000868 405.3700n -0.000866 405.3800n -0.000866 405.3900n -0.000865 405.4000n -0.000865 405.4100n -0.000865 405.4200n -0.000865 405.4300n -0.000866 405.4400n -0.000867
+ 405.4500n -0.000869 405.4600n -0.000871 405.4700n -0.000873 405.4800n -0.000876 405.4900n -0.000878 405.5000n -0.000882 405.5100n -0.000885 405.5200n -0.000889 405.5300n -0.000893 405.5400n -0.000898 405.5500n -0.000903 405.5600n -0.000908 405.5700n -0.000913 405.5800n -0.000919 405.5900n -0.000925
+ 405.6000n -0.000931 405.6100n -0.000938 405.6200n -0.000945 405.6300n -0.000952 405.6400n -0.000960 405.6500n -0.000967 405.6600n -0.000975 405.6700n -0.000983 405.6800n -0.000992 405.6900n -0.001000 405.7000n -0.001009 405.7100n -0.001018 405.7200n -0.001028 405.7300n -0.001037 405.7400n -0.001047
+ 405.7500n -0.001056 405.7600n -0.001066 405.7700n -0.001076 405.7800n -0.001087 405.7900n -0.001097 405.8000n -0.001107 405.8100n -0.001118 405.8200n -0.001128 405.8300n -0.001139 405.8400n -0.001150 405.8500n -0.001161 405.8600n -0.001171 405.8700n -0.001182 405.8800n -0.001193 405.8900n -0.001204
+ 405.9000n -0.001215 405.9100n -0.001225 405.9200n -0.001236 405.9300n -0.001247 405.9400n -0.001258 405.9500n -0.001268 405.9600n -0.001278 405.9700n -0.001289 405.9800n -0.001299 405.9900n -0.001309 406.0000n -0.001319 406.0100n -0.001329 406.0200n -0.001338 406.0300n -0.001348 406.0400n -0.001357
+ 406.0500n -0.001366 406.0600n -0.001374 406.0700n -0.001383 406.0800n -0.001391 406.0900n -0.001399 406.1000n -0.001406 406.1100n -0.001414 406.1200n -0.001421 406.1300n -0.001427 406.1400n -0.001434 406.1500n -0.001440 406.1600n -0.001445 406.1700n -0.001451 406.1800n -0.001455 406.1900n -0.001460
+ 406.2000n -0.001464 406.2100n -0.001468 406.2200n -0.001471 406.2300n -0.001474 406.2400n -0.001476 406.2500n -0.001478 406.2600n -0.001479 406.2700n -0.001480 406.2800n -0.001480 406.2900n -0.001480 406.3000n -0.001480 406.3100n -0.001479 406.3200n -0.001477 406.3300n -0.001475 406.3400n -0.001472
+ 406.3500n -0.001469 406.3600n -0.001465 406.3700n -0.001461 406.3800n -0.001456 406.3900n -0.001450 406.4000n -0.001444 406.4100n -0.001438 406.4200n -0.001431 406.4300n -0.001423 406.4400n -0.001415 406.4500n -0.001406 406.4600n -0.001396 406.4700n -0.001386 406.4800n -0.001375 406.4900n -0.001364
+ 406.5000n -0.001352 406.5100n -0.001340 406.5200n -0.001327 406.5300n -0.001313 406.5400n -0.001299 406.5500n -0.001284 406.5600n -0.001269 406.5700n -0.001253 406.5800n -0.001237 406.5900n -0.001220 406.6000n -0.001202 406.6100n -0.001184 406.6200n -0.001165 406.6300n -0.001146 406.6400n -0.001126
+ 406.6500n -0.001106 406.6600n -0.001085 406.6700n -0.001063 406.6800n -0.001041 406.6900n -0.001019 406.7000n -0.000996 406.7100n -0.000973 406.7200n -0.000949 406.7300n -0.000925 406.7400n -0.000900 406.7500n -0.000875 406.7600n -0.000849 406.7700n -0.000823 406.7800n -0.000797 406.7900n -0.000770
+ 406.8000n -0.000743 406.8100n -0.000715 406.8200n -0.000687 406.8300n -0.000659 406.8400n -0.000630 406.8500n -0.000601 406.8600n -0.000572 406.8700n -0.000543 406.8800n -0.000513 406.8900n -0.000483 406.9000n -0.000453 406.9100n -0.000423 406.9200n -0.000392 406.9300n -0.000361 406.9400n -0.000330
+ 406.9500n -0.000299 406.9600n -0.000268 406.9700n -0.000237 406.9800n -0.000205 406.9900n -0.000174 407.0000n -0.000142 407.0100n -0.000111 407.0200n -0.000079 407.0300n -0.000047 407.0400n -0.000016 407.0500n 0.000016 407.0600n 0.000047 407.0700n 0.000079 407.0800n 0.000110 407.0900n 0.000141
+ 407.1000n 0.000172 407.1100n 0.000203 407.1200n 0.000234 407.1300n 0.000265 407.1400n 0.000295 407.1500n 0.000325 407.1600n 0.000355 407.1700n 0.000385 407.1800n 0.000414 407.1900n 0.000443 407.2000n 0.000472 407.2100n 0.000501 407.2200n 0.000529 407.2300n 0.000557 407.2400n 0.000584
+ 407.2500n 0.000611 407.2600n 0.000638 407.2700n 0.000664 407.2800n 0.000689 407.2900n 0.000715 407.3000n 0.000739 407.3100n 0.000764 407.3200n 0.000788 407.3300n 0.000811 407.3400n 0.000834 407.3500n 0.000856 407.3600n 0.000877 407.3700n 0.000899 407.3800n 0.000919 407.3900n 0.000939
+ 407.4000n 0.000958 407.4100n 0.000977 407.4200n 0.000995 407.4300n 0.001012 407.4400n 0.001029 407.4500n 0.001045 407.4600n 0.001061 407.4700n 0.001075 407.4800n 0.001089 407.4900n 0.001103 407.5000n 0.001115 407.5100n 0.001127 407.5200n 0.001139 407.5300n 0.001149 407.5400n 0.001159
+ 407.5500n 0.001168 407.5600n 0.001176 407.5700n 0.001184 407.5800n 0.001191 407.5900n 0.001197 407.6000n 0.001202 407.6100n 0.001207 407.6200n 0.001211 407.6300n 0.001214 407.6400n 0.001216 407.6500n 0.001218 407.6600n 0.001219 407.6700n 0.001219 407.6800n 0.001219 407.6900n 0.001217
+ 407.7000n 0.001215 407.7100n 0.001213 407.7200n 0.001209 407.7300n 0.001205 407.7400n 0.001200 407.7500n 0.001195 407.7600n 0.001188 407.7700n 0.001181 407.7800n 0.001174 407.7900n 0.001165 407.8000n 0.001156 407.8100n 0.001147 407.8200n 0.001137 407.8300n 0.001126 407.8400n 0.001114
+ 407.8500n 0.001102 407.8600n 0.001089 407.8700n 0.001076 407.8800n 0.001062 407.8900n 0.001048 407.9000n 0.001033 407.9100n 0.001017 407.9200n 0.001001 407.9300n 0.000985 407.9400n 0.000968 407.9500n 0.000950 407.9600n 0.000932 407.9700n 0.000914 407.9800n 0.000895 407.9900n 0.000876
+ 408.0000n 0.000856 408.0100n 0.000837 408.0200n 0.000816 408.0300n 0.000796 408.0400n 0.000775 408.0500n 0.000754 408.0600n 0.000732 408.0700n 0.000710 408.0800n 0.000688 408.0900n 0.000666 408.1000n 0.000644 408.1100n 0.000621 408.1200n 0.000599 408.1300n 0.000576 408.1400n 0.000553
+ 408.1500n 0.000530 408.1600n 0.000507 408.1700n 0.000484 408.1800n 0.000461 408.1900n 0.000437 408.2000n 0.000414 408.2100n 0.000391 408.2200n 0.000368 408.2300n 0.000345 408.2400n 0.000322 408.2500n 0.000299 408.2600n 0.000277 408.2700n 0.000254 408.2800n 0.000232 408.2900n 0.000210
+ 408.3000n 0.000188 408.3100n 0.000166 408.3200n 0.000145 408.3300n 0.000123 408.3400n 0.000103 408.3500n 0.000082 408.3600n 0.000062 408.3700n 0.000042 408.3800n 0.000022 408.3900n 0.000003 408.4000n -0.000015 408.4100n -0.000034 408.4200n -0.000051 408.4300n -0.000069 408.4400n -0.000086
+ 408.4500n -0.000102 408.4600n -0.000118 408.4700n -0.000134 408.4800n -0.000148 408.4900n -0.000163 408.5000n -0.000177 408.5100n -0.000190 408.5200n -0.000202 408.5300n -0.000214 408.5400n -0.000226 408.5500n -0.000237 408.5600n -0.000247 408.5700n -0.000256 408.5800n -0.000265 408.5900n -0.000273
+ 408.6000n -0.000281 408.6100n -0.000288 408.6200n -0.000294 408.6300n -0.000300 408.6400n -0.000304 408.6500n -0.000308 408.6600n -0.000312 408.6700n -0.000315 408.6800n -0.000316 408.6900n -0.000318 408.7000n -0.000318 408.7100n -0.000318 408.7200n -0.000317 408.7300n -0.000315 408.7400n -0.000313
+ 408.7500n -0.000310 408.7600n -0.000306 408.7700n -0.000301 408.7800n -0.000296 408.7900n -0.000290 408.8000n -0.000283 408.8100n -0.000276 408.8200n -0.000267 408.8300n -0.000259 408.8400n -0.000249 408.8500n -0.000239 408.8600n -0.000228 408.8700n -0.000216 408.8800n -0.000204 408.8900n -0.000190
+ 408.9000n -0.000177 408.9100n -0.000162 408.9200n -0.000147 408.9300n -0.000132 408.9400n -0.000116 408.9500n -0.000099 408.9600n -0.000081 408.9700n -0.000063 408.9800n -0.000045 408.9900n -0.000025 409.0000n -0.000006 409.0100n 0.000014 409.0200n 0.000035 409.0300n 0.000056 409.0400n 0.000078
+ 409.0500n 0.000100 409.0600n 0.000123 409.0700n 0.000146 409.0800n 0.000170 409.0900n 0.000193 409.1000n 0.000218 409.1100n 0.000242 409.1200n 0.000267 409.1300n 0.000293 409.1400n 0.000318 409.1500n 0.000344 409.1600n 0.000370 409.1700n 0.000397 409.1800n 0.000423 409.1900n 0.000450
+ 409.2000n 0.000477 409.2100n 0.000504 409.2200n 0.000531 409.2300n 0.000559 409.2400n 0.000586 409.2500n 0.000614 409.2600n 0.000642 409.2700n 0.000669 409.2800n 0.000697 409.2900n 0.000725 409.3000n 0.000752 409.3100n 0.000780 409.3200n 0.000807 409.3300n 0.000835 409.3400n 0.000862
+ 409.3500n 0.000889 409.3600n 0.000916 409.3700n 0.000943 409.3800n 0.000970 409.3900n 0.000996 409.4000n 0.001022 409.4100n 0.001048 409.4200n 0.001074 409.4300n 0.001099 409.4400n 0.001124 409.4500n 0.001149 409.4600n 0.001173 409.4700n 0.001197 409.4800n 0.001220 409.4900n 0.001244
+ 409.5000n 0.001266 409.5100n 0.001288 409.5200n 0.001310 409.5300n 0.001331 409.5400n 0.001352 409.5500n 0.001372 409.5600n 0.001392 409.5700n 0.001411 409.5800n 0.001429 409.5900n 0.001447 409.6000n 0.001464 409.6100n 0.001481 409.6200n 0.001497 409.6300n 0.001512 409.6400n 0.001527
+ 409.6500n 0.001541 409.6600n 0.001554 409.6700n 0.001567 409.6800n 0.001579 409.6900n 0.001590 409.7000n 0.001600 409.7100n 0.001610 409.7200n 0.001619 409.7300n 0.001627 409.7400n 0.001635 409.7500n 0.001642 409.7600n 0.001648 409.7700n 0.001653 409.7800n 0.001657 409.7900n 0.001661
+ 409.8000n 0.001664 409.8100n 0.001666 409.8200n 0.001667 409.8300n 0.001667 409.8400n 0.001667 409.8500n 0.001666 409.8600n 0.001664 409.8700n 0.001661 409.8800n 0.001658 409.8900n 0.001654 409.9000n 0.001649 409.9100n 0.001643 409.9200n 0.001636 409.9300n 0.001629 409.9400n 0.001621
+ 409.9500n 0.001612 409.9600n 0.001602 409.9700n 0.001591 409.9800n 0.001580 409.9900n 0.001568 410.0000n 0.001556 410.0100n 0.001542 410.0200n 0.001528 410.0300n 0.001514 410.0400n 0.001498 410.0500n 0.001482 410.0600n 0.001465 410.0700n 0.001448 410.0800n 0.001430 410.0900n 0.001411
+ 410.1000n 0.001392 410.1100n 0.001372 410.1200n 0.001352 410.1300n 0.001331 410.1400n 0.001309 410.1500n 0.001287 410.1600n 0.001264 410.1700n 0.001241 410.1800n 0.001218 410.1900n 0.001194 410.2000n 0.001169 410.2100n 0.001145 410.2200n 0.001119 410.2300n 0.001094 410.2400n 0.001068
+ 410.2500n 0.001042 410.2600n 0.001015 410.2700n 0.000988 410.2800n 0.000961 410.2900n 0.000933 410.3000n 0.000906 410.3100n 0.000878 410.3200n 0.000850 410.3300n 0.000822 410.3400n 0.000793 410.3500n 0.000765 410.3600n 0.000736 410.3700n 0.000708 410.3800n 0.000679 410.3900n 0.000650
+ 410.4000n 0.000622 410.4100n 0.000593 410.4200n 0.000564 410.4300n 0.000536 410.4400n 0.000507 410.4500n 0.000479 410.4600n 0.000451 410.4700n 0.000423 410.4800n 0.000395 410.4900n 0.000367 410.5000n 0.000340 410.5100n 0.000313 410.5200n 0.000286 410.5300n 0.000259 410.5400n 0.000233
+ 410.5500n 0.000207 410.5600n 0.000181 410.5700n 0.000156 410.5800n 0.000131 410.5900n 0.000107 410.6000n 0.000083 410.6100n 0.000059 410.6200n 0.000036 410.6300n 0.000014 410.6400n -0.000008 410.6500n -0.000029 410.6600n -0.000050 410.6700n -0.000071 410.6800n -0.000090 410.6900n -0.000110
+ 410.7000n -0.000128 410.7100n -0.000146 410.7200n -0.000163 410.7300n -0.000179 410.7400n -0.000195 410.7500n -0.000210 410.7600n -0.000225 410.7700n -0.000238 410.7800n -0.000251 410.7900n -0.000264 410.8000n -0.000275 410.8100n -0.000286 410.8200n -0.000295 410.8300n -0.000304 410.8400n -0.000313
+ 410.8500n -0.000320 410.8600n -0.000327 410.8700n -0.000332 410.8800n -0.000337 410.8900n -0.000341 410.9000n -0.000345 410.9100n -0.000347 410.9200n -0.000349 410.9300n -0.000349 410.9400n -0.000349 410.9500n -0.000348 410.9600n -0.000346 410.9700n -0.000343 410.9800n -0.000339 410.9900n -0.000335
+ 411.0000n -0.000329 411.0100n -0.000323 411.0200n -0.000316 411.0300n -0.000308 411.0400n -0.000299 411.0500n -0.000289 411.0600n -0.000279 411.0700n -0.000267 411.0800n -0.000255 411.0900n -0.000242 411.1000n -0.000228 411.1100n -0.000213 411.1200n -0.000197 411.1300n -0.000181 411.1400n -0.000164
+ 411.1500n -0.000146 411.1600n -0.000127 411.1700n -0.000107 411.1800n -0.000087 411.1900n -0.000066 411.2000n -0.000044 411.2100n -0.000022 411.2200n 0.000001 411.2300n 0.000025 411.2400n 0.000050 411.2500n 0.000075 411.2600n 0.000101 411.2700n 0.000127 411.2800n 0.000154 411.2900n 0.000182
+ 411.3000n 0.000210 411.3100n 0.000239 411.3200n 0.000268 411.3300n 0.000298 411.3400n 0.000328 411.3500n 0.000359 411.3600n 0.000390 411.3700n 0.000422 411.3800n 0.000454 411.3900n 0.000487 411.4000n 0.000519 411.4100n 0.000553 411.4200n 0.000586 411.4300n 0.000620 411.4400n 0.000654
+ 411.4500n 0.000689 411.4600n 0.000724 411.4700n 0.000759 411.4800n 0.000794 411.4900n 0.000829 411.5000n 0.000865 411.5100n 0.000900 411.5200n 0.000936 411.5300n 0.000972 411.5400n 0.001008 411.5500n 0.001043 411.5600n 0.001079 411.5700n 0.001115 411.5800n 0.001151 411.5900n 0.001187
+ 411.6000n 0.001223 411.6100n 0.001259 411.6200n 0.001294 411.6300n 0.001330 411.6400n 0.001365 411.6500n 0.001400 411.6600n 0.001435 411.6700n 0.001469 411.6800n 0.001504 411.6900n 0.001538 411.7000n 0.001572 411.7100n 0.001605 411.7200n 0.001638 411.7300n 0.001671 411.7400n 0.001704
+ 411.7500n 0.001736 411.7600n 0.001767 411.7700n 0.001798 411.7800n 0.001829 411.7900n 0.001859 411.8000n 0.001889 411.8100n 0.001918 411.8200n 0.001947 411.8300n 0.001975 411.8400n 0.002002 411.8500n 0.002029 411.8600n 0.002055 411.8700n 0.002081 411.8800n 0.002106 411.8900n 0.002130
+ 411.9000n 0.002154 411.9100n 0.002177 411.9200n 0.002200 411.9300n 0.002221 411.9400n 0.002242 411.9500n 0.002262 411.9600n 0.002282 411.9700n 0.002300 411.9800n 0.002318 411.9900n 0.002335 412.0000n 0.002352 412.0100n 0.002367 412.0200n 0.002382 412.0300n 0.002396 412.0400n 0.002409
+ 412.0500n 0.002421 412.0600n 0.002433 412.0700n 0.002444 412.0800n 0.002453 412.0900n 0.002462 412.1000n 0.002470 412.1100n 0.002477 412.1200n 0.002484 412.1300n 0.002489 412.1400n 0.002494 412.1500n 0.002498 412.1600n 0.002500 412.1700n 0.002502 412.1800n 0.002504 412.1900n 0.002504
+ 412.2000n 0.002503 412.2100n 0.002502 412.2200n 0.002499 412.2300n 0.002496 412.2400n 0.002492 412.2500n 0.002487 412.2600n 0.002482 412.2700n 0.002475 412.2800n 0.002468 412.2900n 0.002459 412.3000n 0.002450 412.3100n 0.002440 412.3200n 0.002430 412.3300n 0.002418 412.3400n 0.002406
+ 412.3500n 0.002393 412.3600n 0.002379 412.3700n 0.002364 412.3800n 0.002349 412.3900n 0.002333 412.4000n 0.002316 412.4100n 0.002298 412.4200n 0.002280 412.4300n 0.002261 412.4400n 0.002241 412.4500n 0.002221 412.4600n 0.002200 412.4700n 0.002178 412.4800n 0.002156 412.4900n 0.002133
+ 412.5000n 0.002109 412.5100n 0.002085 412.5200n 0.002060 412.5300n 0.002035 412.5400n 0.002009 412.5500n 0.001983 412.5600n 0.001956 412.5700n 0.001928 412.5800n 0.001901 412.5900n 0.001872 412.6000n 0.001844 412.6100n 0.001814 412.6200n 0.001785 412.6300n 0.001755 412.6400n 0.001724
+ 412.6500n 0.001694 412.6600n 0.001663 412.6700n 0.001631 412.6800n 0.001600 412.6900n 0.001568 412.7000n 0.001535 412.7100n 0.001503 412.7200n 0.001470 412.7300n 0.001437 412.7400n 0.001404 412.7500n 0.001370 412.7600n 0.001337 412.7700n 0.001303 412.7800n 0.001269 412.7900n 0.001235
+ 412.8000n 0.001201 412.8100n 0.001167 412.8200n 0.001133 412.8300n 0.001099 412.8400n 0.001065 412.8500n 0.001030 412.8600n 0.000996 412.8700n 0.000962 412.8800n 0.000928 412.8900n 0.000894 412.9000n 0.000860 412.9100n 0.000826 412.9200n 0.000792 412.9300n 0.000758 412.9400n 0.000724
+ 412.9500n 0.000691 412.9600n 0.000657 412.9700n 0.000624 412.9800n 0.000591 412.9900n 0.000559 413.0000n 0.000526 413.0100n 0.000494 413.0200n 0.000462 413.0300n 0.000430 413.0400n 0.000399 413.0500n 0.000367 413.0600n 0.000336 413.0700n 0.000306 413.0800n 0.000275 413.0900n 0.000245
+ 413.1000n 0.000216 413.1100n 0.000186 413.1200n 0.000157 413.1300n 0.000129 413.1400n 0.000101 413.1500n 0.000073 413.1600n 0.000045 413.1700n 0.000018 413.1800n -0.000008 413.1900n -0.000034 413.2000n -0.000060 413.2100n -0.000086 413.2200n -0.000110 413.2300n -0.000135 413.2400n -0.000159
+ 413.2500n -0.000183 413.2600n -0.000206 413.2700n -0.000228 413.2800n -0.000250 413.2900n -0.000272 413.3000n -0.000293 413.3100n -0.000314 413.3200n -0.000334 413.3300n -0.000354 413.3400n -0.000374 413.3500n -0.000392 413.3600n -0.000411 413.3700n -0.000429 413.3800n -0.000446 413.3900n -0.000463
+ 413.4000n -0.000479 413.4100n -0.000495 413.4200n -0.000510 413.4300n -0.000525 413.4400n -0.000540 413.4500n -0.000554 413.4600n -0.000567 413.4700n -0.000580 413.4800n -0.000593 413.4900n -0.000605 413.5000n -0.000616 413.5100n -0.000627 413.5200n -0.000638 413.5300n -0.000648 413.5400n -0.000658
+ 413.5500n -0.000667 413.5600n -0.000676 413.5700n -0.000684 413.5800n -0.000692 413.5900n -0.000699 413.6000n -0.000706 413.6100n -0.000713 413.6200n -0.000719 413.6300n -0.000724 413.6400n -0.000730 413.6500n -0.000735 413.6600n -0.000739 413.6700n -0.000743 413.6800n -0.000747 413.6900n -0.000750
+ 413.7000n -0.000753 413.7100n -0.000756 413.7200n -0.000758 413.7300n -0.000760 413.7400n -0.000761 413.7500n -0.000762 413.7600n -0.000763 413.7700n -0.000763 413.7800n -0.000763 413.7900n -0.000763 413.8000n -0.000763 413.8100n -0.000762 413.8200n -0.000761 413.8300n -0.000759 413.8400n -0.000758
+ 413.8500n -0.000756 413.8600n -0.000754 413.8700n -0.000751 413.8800n -0.000748 413.8900n -0.000745 413.9000n -0.000742 413.9100n -0.000739 413.9200n -0.000735 413.9300n -0.000731 413.9400n -0.000727 413.9500n -0.000722 413.9600n -0.000718 413.9700n -0.000713 413.9800n -0.000708 413.9900n -0.000703
+ 414.0000n -0.000698 414.0100n -0.000692 414.0200n -0.000687 414.0300n -0.000681 414.0400n -0.000675 414.0500n -0.000669 414.0600n -0.000662 414.0700n -0.000656 414.0800n -0.000649 414.0900n -0.000643 414.1000n -0.000636 414.1100n -0.000629 414.1200n -0.000622 414.1300n -0.000615 414.1400n -0.000608
+ 414.1500n -0.000600 414.1600n -0.000593 414.1700n -0.000586 414.1800n -0.000578 414.1900n -0.000570 414.2000n -0.000562 414.2100n -0.000555 414.2200n -0.000547 414.2300n -0.000539 414.2400n -0.000531 414.2500n -0.000522 414.2600n -0.000514 414.2700n -0.000506 414.2800n -0.000498 414.2900n -0.000489
+ 414.3000n -0.000481 414.3100n -0.000472 414.3200n -0.000464 414.3300n -0.000455 414.3400n -0.000447 414.3500n -0.000438 414.3600n -0.000429 414.3700n -0.000421 414.3800n -0.000412 414.3900n -0.000403 414.4000n -0.000394 414.4100n -0.000385 414.4200n -0.000376 414.4300n -0.000367 414.4400n -0.000358
+ 414.4500n -0.000349 414.4600n -0.000340 414.4700n -0.000331 414.4800n -0.000322 414.4900n -0.000312 414.5000n -0.000303 414.5100n -0.000294 414.5200n -0.000285 414.5300n -0.000275 414.5400n -0.000266 414.5500n -0.000256 414.5600n -0.000247 414.5700n -0.000238 414.5800n -0.000228 414.5900n -0.000218
+ 414.6000n -0.000209 414.6100n -0.000199 414.6200n -0.000189 414.6300n -0.000180 414.6400n -0.000170 414.6500n -0.000160 414.6600n -0.000150 414.6700n -0.000140 414.6800n -0.000130 414.6900n -0.000120 414.7000n -0.000110 414.7100n -0.000100 414.7200n -0.000090 414.7300n -0.000080 414.7400n -0.000070
+ 414.7500n -0.000060 414.7600n -0.000049 414.7700n -0.000039 414.7800n -0.000028 414.7900n -0.000018 414.8000n -0.000008 414.8100n 0.000003 414.8200n 0.000014 414.8300n 0.000024 414.8400n 0.000035 414.8500n 0.000046 414.8600n 0.000056 414.8700n 0.000067 414.8800n 0.000078 414.8900n 0.000089
+ 414.9000n 0.000100 414.9100n 0.000111 414.9200n 0.000122 414.9300n 0.000133 414.9400n 0.000144 414.9500n 0.000155 414.9600n 0.000166 414.9700n 0.000177 414.9800n 0.000188 414.9900n 0.000200 415.0000n 0.000211 415.0100n 0.000222 415.0200n 0.000234 415.0300n 0.000245 415.0400n 0.000256
+ 415.0500n 0.000268 415.0600n 0.000279 415.0700n 0.000290 415.0800n 0.000302 415.0900n 0.000313 415.1000n 0.000324 415.1100n 0.000336 415.1200n 0.000347 415.1300n 0.000359 415.1400n 0.000370 415.1500n 0.000381 415.1600n 0.000393 415.1700n 0.000404 415.1800n 0.000415 415.1900n 0.000426
+ 415.2000n 0.000438 415.2100n 0.000449 415.2200n 0.000460 415.2300n 0.000471 415.2400n 0.000482 415.2500n 0.000493 415.2600n 0.000504 415.2700n 0.000515 415.2800n 0.000525 415.2900n 0.000536 415.3000n 0.000547 415.3100n 0.000557 415.3200n 0.000568 415.3300n 0.000578 415.3400n 0.000588
+ 415.3500n 0.000598 415.3600n 0.000608 415.3700n 0.000618 415.3800n 0.000628 415.3900n 0.000637 415.4000n 0.000647 415.4100n 0.000656 415.4200n 0.000666 415.4300n 0.000675 415.4400n 0.000684 415.4500n 0.000692 415.4600n 0.000701 415.4700n 0.000709 415.4800n 0.000718 415.4900n 0.000726
+ 415.5000n 0.000734 415.5100n 0.000742 415.5200n 0.000749 415.5300n 0.000756 415.5400n 0.000764 415.5500n 0.000771 415.5600n 0.000777 415.5700n 0.000784 415.5800n 0.000790 415.5900n 0.000796 415.6000n 0.000802 415.6100n 0.000808 415.6200n 0.000813 415.6300n 0.000818 415.6400n 0.000823
+ 415.6500n 0.000828 415.6600n 0.000833 415.6700n 0.000837 415.6800n 0.000841 415.6900n 0.000845 415.7000n 0.000848 415.7100n 0.000851 415.7200n 0.000854 415.7300n 0.000857 415.7400n 0.000859 415.7500n 0.000861 415.7600n 0.000863 415.7700n 0.000865 415.7800n 0.000866 415.7900n 0.000867
+ 415.8000n 0.000868 415.8100n 0.000869 415.8200n 0.000869 415.8300n 0.000869 415.8400n 0.000869 415.8500n 0.000868 415.8600n 0.000868 415.8700n 0.000867 415.8800n 0.000865 415.8900n 0.000864 415.9000n 0.000862 415.9100n 0.000860 415.9200n 0.000857 415.9300n 0.000855 415.9400n 0.000852
+ 415.9500n 0.000849 415.9600n 0.000845 415.9700n 0.000842 415.9800n 0.000838 415.9900n 0.000834 416.0000n 0.000830 416.0100n 0.000825 416.0200n 0.000820 416.0300n 0.000815 416.0400n 0.000810 416.0500n 0.000805 416.0600n 0.000799 416.0700n 0.000793 416.0800n 0.000787 416.0900n 0.000781
+ 416.1000n 0.000775 416.1100n 0.000768 416.1200n 0.000761 416.1300n 0.000754 416.1400n 0.000747 416.1500n 0.000740 416.1600n 0.000733 416.1700n 0.000725 416.1800n 0.000717 416.1900n 0.000710 416.2000n 0.000702 416.2100n 0.000694 416.2200n 0.000686 416.2300n 0.000678 416.2400n 0.000669
+ 416.2500n 0.000661 416.2600n 0.000653 416.2700n 0.000644 416.2800n 0.000636 416.2900n 0.000627 416.3000n 0.000619 416.3100n 0.000610 416.3200n 0.000602 416.3300n 0.000593 416.3400n 0.000584 416.3500n 0.000576 416.3600n 0.000567 416.3700n 0.000559 416.3800n 0.000550 416.3900n 0.000542
+ 416.4000n 0.000533 416.4100n 0.000525 416.4200n 0.000517 416.4300n 0.000509 416.4400n 0.000501 416.4500n 0.000493 416.4600n 0.000485 416.4700n 0.000477 416.4800n 0.000470 416.4900n 0.000462 416.5000n 0.000455 416.5100n 0.000448 416.5200n 0.000441 416.5300n 0.000434 416.5400n 0.000427
+ 416.5500n 0.000421 416.5600n 0.000415 416.5700n 0.000409 416.5800n 0.000403 416.5900n 0.000397 416.6000n 0.000392 416.6100n 0.000387 416.6200n 0.000382 416.6300n 0.000377 416.6400n 0.000373 416.6500n 0.000369 416.6600n 0.000365 416.6700n 0.000362 416.6800n 0.000358 416.6900n 0.000355
+ 416.7000n 0.000353 416.7100n 0.000350 416.7200n 0.000348 416.7300n 0.000346 416.7400n 0.000345 416.7500n 0.000344 416.7600n 0.000343 416.7700n 0.000342 416.7800n 0.000342 416.7900n 0.000342 416.8000n 0.000342 416.8100n 0.000343 416.8200n 0.000344 416.8300n 0.000345 416.8400n 0.000347
+ 416.8500n 0.000349 416.8600n 0.000352 416.8700n 0.000354 416.8800n 0.000357 416.8900n 0.000361 416.9000n 0.000364 416.9100n 0.000368 416.9200n 0.000373 416.9300n 0.000378 416.9400n 0.000383 416.9500n 0.000388 416.9600n 0.000393 416.9700n 0.000399 416.9800n 0.000406 416.9900n 0.000412
+ 417.0000n 0.000419 417.0100n 0.000426 417.0200n 0.000434 417.0300n 0.000441 417.0400n 0.000449 417.0500n 0.000458 417.0600n 0.000466 417.0700n 0.000475 417.0800n 0.000484 417.0900n 0.000493 417.1000n 0.000503 417.1100n 0.000513 417.1200n 0.000523 417.1300n 0.000533 417.1400n 0.000543
+ 417.1500n 0.000554 417.1600n 0.000565 417.1700n 0.000575 417.1800n 0.000587 417.1900n 0.000598 417.2000n 0.000609 417.2100n 0.000621 417.2200n 0.000632 417.2300n 0.000644 417.2400n 0.000656 417.2500n 0.000668 417.2600n 0.000680 417.2700n 0.000692 417.2800n 0.000704 417.2900n 0.000716
+ 417.3000n 0.000729 417.3100n 0.000741 417.3200n 0.000753 417.3300n 0.000765 417.3400n 0.000777 417.3500n 0.000790 417.3600n 0.000802 417.3700n 0.000814 417.3800n 0.000826 417.3900n 0.000838 417.4000n 0.000849 417.4100n 0.000861 417.4200n 0.000872 417.4300n 0.000884 417.4400n 0.000895
+ 417.4500n 0.000906 417.4600n 0.000917 417.4700n 0.000927 417.4800n 0.000938 417.4900n 0.000948 417.5000n 0.000958 417.5100n 0.000967 417.5200n 0.000977 417.5300n 0.000986 417.5400n 0.000995 417.5500n 0.001003 417.5600n 0.001011 417.5700n 0.001019 417.5800n 0.001027 417.5900n 0.001034
+ 417.6000n 0.001041 417.6100n 0.001047 417.6200n 0.001053 417.6300n 0.001059 417.6400n 0.001064 417.6500n 0.001069 417.6600n 0.001073 417.6700n 0.001077 417.6800n 0.001080 417.6900n 0.001083 417.7000n 0.001086 417.7100n 0.001087 417.7200n 0.001089 417.7300n 0.001090 417.7400n 0.001090
+ 417.7500n 0.001090 417.7600n 0.001090 417.7700n 0.001088 417.7800n 0.001087 417.7900n 0.001085 417.8000n 0.001082 417.8100n 0.001078 417.8200n 0.001074 417.8300n 0.001070 417.8400n 0.001065 417.8500n 0.001059 417.8600n 0.001053 417.8700n 0.001046 417.8800n 0.001039 417.8900n 0.001031
+ 417.9000n 0.001022 417.9100n 0.001013 417.9200n 0.001003 417.9300n 0.000993 417.9400n 0.000982 417.9500n 0.000970 417.9600n 0.000958 417.9700n 0.000945 417.9800n 0.000932 417.9900n 0.000918 418.0000n 0.000903 418.0100n 0.000888 418.0200n 0.000872 418.0300n 0.000856 418.0400n 0.000839
+ 418.0500n 0.000822 418.0600n 0.000803 418.0700n 0.000785 418.0800n 0.000766 418.0900n 0.000746 418.1000n 0.000726 418.1100n 0.000705 418.1200n 0.000684 418.1300n 0.000662 418.1400n 0.000640 418.1500n 0.000617 418.1600n 0.000594 418.1700n 0.000571 418.1800n 0.000547 418.1900n 0.000522
+ 418.2000n 0.000497 418.2100n 0.000472 418.2200n 0.000446 418.2300n 0.000420 418.2400n 0.000393 418.2500n 0.000366 418.2600n 0.000339 418.2700n 0.000311 418.2800n 0.000283 418.2900n 0.000255 418.3000n 0.000226 418.3100n 0.000198 418.3200n 0.000169 418.3300n 0.000139 418.3400n 0.000110
+ 418.3500n 0.000080 418.3600n 0.000050 418.3700n 0.000020 418.3800n -0.000010 418.3900n -0.000041 418.4000n -0.000071 418.4100n -0.000102 418.4200n -0.000133 418.4300n -0.000163 418.4400n -0.000194 418.4500n -0.000225 418.4600n -0.000256 418.4700n -0.000287 418.4800n -0.000318 418.4900n -0.000348
+ 418.5000n -0.000379 418.5100n -0.000410 418.5200n -0.000440 418.5300n -0.000470 418.5400n -0.000501 418.5500n -0.000531 418.5600n -0.000561 418.5700n -0.000590 418.5800n -0.000620 418.5900n -0.000649 418.6000n -0.000678 418.6100n -0.000706 418.6200n -0.000735 418.6300n -0.000763 418.6400n -0.000790
+ 418.6500n -0.000817 418.6600n -0.000844 418.6700n -0.000871 418.6800n -0.000897 418.6900n -0.000923 418.7000n -0.000948 418.7100n -0.000973 418.7200n -0.000997 418.7300n -0.001021 418.7400n -0.001044 418.7500n -0.001067 418.7600n -0.001089 418.7700n -0.001110 418.7800n -0.001132 418.7900n -0.001152
+ 418.8000n -0.001172 418.8100n -0.001191 418.8200n -0.001210 418.8300n -0.001228 418.8400n -0.001245 418.8500n -0.001261 418.8600n -0.001277 418.8700n -0.001293 418.8800n -0.001307 418.8900n -0.001321 418.9000n -0.001334 418.9100n -0.001346 418.9200n -0.001358 418.9300n -0.001369 418.9400n -0.001379
+ 418.9500n -0.001388 418.9600n -0.001397 418.9700n -0.001405 418.9800n -0.001412 418.9900n -0.001418 419.0000n -0.001423 419.0100n -0.001428 419.0200n -0.001432 419.0300n -0.001435 419.0400n -0.001437 419.0500n -0.001438 419.0600n -0.001439 419.0700n -0.001439 419.0800n -0.001438 419.0900n -0.001436
+ 419.1000n -0.001433 419.1100n -0.001430 419.1200n -0.001426 419.1300n -0.001421 419.1400n -0.001415 419.1500n -0.001408 419.1600n -0.001401 419.1700n -0.001392 419.1800n -0.001383 419.1900n -0.001374 419.2000n -0.001363 419.2100n -0.001352 419.2200n -0.001340 419.2300n -0.001327 419.2400n -0.001313
+ 419.2500n -0.001299 419.2600n -0.001284 419.2700n -0.001268 419.2800n -0.001252 419.2900n -0.001235 419.3000n -0.001217 419.3100n -0.001199 419.3200n -0.001180 419.3300n -0.001160 419.3400n -0.001140 419.3500n -0.001119 419.3600n -0.001098 419.3700n -0.001076 419.3800n -0.001053 419.3900n -0.001030
+ 419.4000n -0.001006 419.4100n -0.000982 419.4200n -0.000957 419.4300n -0.000932 419.4400n -0.000907 419.4500n -0.000881 419.4600n -0.000854 419.4700n -0.000828 419.4800n -0.000800 419.4900n -0.000773 419.5000n -0.000745 419.5100n -0.000717 419.5200n -0.000688 419.5300n -0.000660 419.5400n -0.000631
+ 419.5500n -0.000601 419.5600n -0.000572 419.5700n -0.000542 419.5800n -0.000512 419.5900n -0.000482 419.6000n -0.000452 419.6100n -0.000422 419.6200n -0.000392 419.6300n -0.000361 419.6400n -0.000331 419.6500n -0.000300 419.6600n -0.000270 419.6700n -0.000239 419.6800n -0.000209 419.6900n -0.000179
+ 419.7000n -0.000148 419.7100n -0.000118 419.7200n -0.000088 419.7300n -0.000058 419.7400n -0.000029 419.7500n 0.000001 419.7600n 0.000030 419.7700n 0.000059 419.7800n 0.000088 419.7900n 0.000117 419.8000n 0.000145 419.8100n 0.000173 419.8200n 0.000201 419.8300n 0.000228 419.8400n 0.000255
+ 419.8500n 0.000282 419.8600n 0.000308 419.8700n 0.000333 419.8800n 0.000359 419.8900n 0.000384 419.9000n 0.000408 419.9100n 0.000432 419.9200n 0.000455 419.9300n 0.000478 419.9400n 0.000500 419.9500n 0.000522 419.9600n 0.000543 419.9700n 0.000564 419.9800n 0.000584 419.9900n 0.000604
+ 420.0000n 0.000622 420.0100n 0.000641 420.0200n 0.000658 420.0300n 0.000675 420.0400n 0.000691 420.0500n 0.000707 420.0600n 0.000722 420.0700n 0.000736 420.0800n 0.000749 420.0900n 0.000762 420.1000n 0.000774 420.1100n 0.000786 420.1200n 0.000796 420.1300n 0.000806 420.1400n 0.000815
+ 420.1500n 0.000824 420.1600n 0.000831 420.1700n 0.000838 420.1800n 0.000845 420.1900n 0.000850 420.2000n 0.000855 420.2100n 0.000859 420.2200n 0.000862 420.2300n 0.000864 420.2400n 0.000866 420.2500n 0.000867 420.2600n 0.000867 420.2700n 0.000866 420.2800n 0.000865 420.2900n 0.000863
+ 420.3000n 0.000860 420.3100n 0.000856 420.3200n 0.000852 420.3300n 0.000847 420.3400n 0.000841 420.3500n 0.000835 420.3600n 0.000828 420.3700n 0.000820 420.3800n 0.000811 420.3900n 0.000802 420.4000n 0.000792 420.4100n 0.000782 420.4200n 0.000770 420.4300n 0.000758 420.4400n 0.000746
+ 420.4500n 0.000733 420.4600n 0.000719 420.4700n 0.000705 420.4800n 0.000690 420.4900n 0.000674 420.5000n 0.000658 420.5100n 0.000641 420.5200n 0.000624 420.5300n 0.000607 420.5400n 0.000588 420.5500n 0.000570 420.5600n 0.000550 420.5700n 0.000531 420.5800n 0.000511 420.5900n 0.000490
+ 420.6000n 0.000469 420.6100n 0.000448 420.6200n 0.000426 420.6300n 0.000404 420.6400n 0.000382 420.6500n 0.000359 420.6600n 0.000336 420.6700n 0.000313 420.6800n 0.000289 420.6900n 0.000265 420.7000n 0.000241 420.7100n 0.000217 420.7200n 0.000192 420.7300n 0.000167 420.7400n 0.000142
+ 420.7500n 0.000117 420.7600n 0.000092 420.7700n 0.000067 420.7800n 0.000041 420.7900n 0.000016 420.8000n -0.000010 420.8100n -0.000036 420.8200n -0.000061 420.8300n -0.000087 420.8400n -0.000113 420.8500n -0.000139 420.8600n -0.000164 420.8700n -0.000190 420.8800n -0.000215 420.8900n -0.000241
+ 420.9000n -0.000266 420.9100n -0.000292 420.9200n -0.000317 420.9300n -0.000342 420.9400n -0.000367 420.9500n -0.000391 420.9600n -0.000416 420.9700n -0.000440 420.9800n -0.000464 420.9900n -0.000488 421.0000n -0.000512 421.0100n -0.000535 421.0200n -0.000558 421.0300n -0.000581 421.0400n -0.000603
+ 421.0500n -0.000625 421.0600n -0.000647 421.0700n -0.000669 421.0800n -0.000690 421.0900n -0.000711 421.1000n -0.000732 421.1100n -0.000752 421.1200n -0.000772 421.1300n -0.000791 421.1400n -0.000810 421.1500n -0.000829 421.1600n -0.000847 421.1700n -0.000865 421.1800n -0.000882 421.1900n -0.000899
+ 421.2000n -0.000916 421.2100n -0.000932 421.2200n -0.000948 421.2300n -0.000963 421.2400n -0.000978 421.2500n -0.000992 421.2600n -0.001006 421.2700n -0.001020 421.2800n -0.001033 421.2900n -0.001045 421.3000n -0.001058 421.3100n -0.001069 421.3200n -0.001081 421.3300n -0.001091 421.3400n -0.001102
+ 421.3500n -0.001112 421.3600n -0.001121 421.3700n -0.001130 421.3800n -0.001139 421.3900n -0.001147 421.4000n -0.001155 421.4100n -0.001162 421.4200n -0.001169 421.4300n -0.001176 421.4400n -0.001182 421.4500n -0.001188 421.4600n -0.001193 421.4700n -0.001198 421.4800n -0.001203 421.4900n -0.001207
+ 421.5000n -0.001211 421.5100n -0.001214 421.5200n -0.001217 421.5300n -0.001220 421.5400n -0.001222 421.5500n -0.001224 421.5600n -0.001226 421.5700n -0.001228 421.5800n -0.001229 421.5900n -0.001230 421.6000n -0.001230 421.6100n -0.001230 421.6200n -0.001231 421.6300n -0.001230 421.6400n -0.001230
+ 421.6500n -0.001229 421.6600n -0.001228 421.6700n -0.001227 421.6800n -0.001226 421.6900n -0.001225 421.7000n -0.001223 421.7100n -0.001221 421.7200n -0.001219 421.7300n -0.001217 421.7400n -0.001215 421.7500n -0.001213 421.7600n -0.001210 421.7700n -0.001208 421.7800n -0.001205 421.7900n -0.001203
+ 421.8000n -0.001200 421.8100n -0.001197 421.8200n -0.001195 421.8300n -0.001192 421.8400n -0.001189 421.8500n -0.001186 421.8600n -0.001183 421.8700n -0.001181 421.8800n -0.001178 421.8900n -0.001175 421.9000n -0.001172 421.9100n -0.001170 421.9200n -0.001167 421.9300n -0.001165 421.9400n -0.001163
+ 421.9500n -0.001160 421.9600n -0.001158 421.9700n -0.001156 421.9800n -0.001154 421.9900n -0.001152 422.0000n -0.001151 422.0100n -0.001149 422.0200n -0.001148 422.0300n -0.001147 422.0400n -0.001146 422.0500n -0.001145 422.0600n -0.001144 422.0700n -0.001143 422.0800n -0.001143 422.0900n -0.001143
+ 422.1000n -0.001143 422.1100n -0.001143 422.1200n -0.001144 422.1300n -0.001144 422.1400n -0.001145 422.1500n -0.001146 422.1600n -0.001147 422.1700n -0.001149 422.1800n -0.001150 422.1900n -0.001152 422.2000n -0.001154 422.2100n -0.001156 422.2200n -0.001159 422.2300n -0.001161 422.2400n -0.001164
+ 422.2500n -0.001167 422.2600n -0.001171 422.2700n -0.001174 422.2800n -0.001178 422.2900n -0.001182 422.3000n -0.001186 422.3100n -0.001190 422.3200n -0.001194 422.3300n -0.001199 422.3400n -0.001203 422.3500n -0.001208 422.3600n -0.001213 422.3700n -0.001218 422.3800n -0.001224 422.3900n -0.001229
+ 422.4000n -0.001234 422.4100n -0.001240 422.4200n -0.001246 422.4300n -0.001252 422.4400n -0.001257 422.4500n -0.001263 422.4600n -0.001269 422.4700n -0.001276 422.4800n -0.001282 422.4900n -0.001288 422.5000n -0.001294 422.5100n -0.001300 422.5200n -0.001306 422.5300n -0.001312 422.5400n -0.001319
+ 422.5500n -0.001325 422.5600n -0.001331 422.5700n -0.001337 422.5800n -0.001342 422.5900n -0.001348 422.6000n -0.001354 422.6100n -0.001360 422.6200n -0.001365 422.6300n -0.001370 422.6400n -0.001375 422.6500n -0.001380 422.6600n -0.001385 422.6700n -0.001390 422.6800n -0.001394 422.6900n -0.001398
+ 422.7000n -0.001402 422.7100n -0.001406 422.7200n -0.001409 422.7300n -0.001412 422.7400n -0.001415 422.7500n -0.001418 422.7600n -0.001420 422.7700n -0.001422 422.7800n -0.001423 422.7900n -0.001425 422.8000n -0.001425 422.8100n -0.001426 422.8200n -0.001426 422.8300n -0.001425 422.8400n -0.001425
+ 422.8500n -0.001423 422.8600n -0.001422 422.8700n -0.001420 422.8800n -0.001417 422.8900n -0.001414 422.9000n -0.001410 422.9100n -0.001406 422.9200n -0.001402 422.9300n -0.001397 422.9400n -0.001391 422.9500n -0.001385 422.9600n -0.001378 422.9700n -0.001371 422.9800n -0.001363 422.9900n -0.001355
+ 423.0000n -0.001346 423.0100n -0.001337 423.0200n -0.001327 423.0300n -0.001316 423.0400n -0.001305 423.0500n -0.001293 423.0600n -0.001281 423.0700n -0.001268 423.0800n -0.001254 423.0900n -0.001240 423.1000n -0.001225 423.1100n -0.001210 423.1200n -0.001194 423.1300n -0.001177 423.1400n -0.001160
+ 423.1500n -0.001142 423.1600n -0.001123 423.1700n -0.001104 423.1800n -0.001085 423.1900n -0.001064 423.2000n -0.001043 423.2100n -0.001022 423.2200n -0.001000 423.2300n -0.000977 423.2400n -0.000954 423.2500n -0.000930 423.2600n -0.000906 423.2700n -0.000881 423.2800n -0.000856 423.2900n -0.000830
+ 423.3000n -0.000803 423.3100n -0.000776 423.3200n -0.000748 423.3300n -0.000720 423.3400n -0.000692 423.3500n -0.000663 423.3600n -0.000633 423.3700n -0.000603 423.3800n -0.000573 423.3900n -0.000542 423.4000n -0.000511 423.4100n -0.000480 423.4200n -0.000448 423.4300n -0.000415 423.4400n -0.000383
+ 423.4500n -0.000349 423.4600n -0.000316 423.4700n -0.000283 423.4800n -0.000249 423.4900n -0.000214 423.5000n -0.000180 423.5100n -0.000145 423.5200n -0.000110 423.5300n -0.000075 423.5400n -0.000040 423.5500n -0.000005 423.5600n 0.000031 423.5700n 0.000066 423.5800n 0.000102 423.5900n 0.000138
+ 423.6000n 0.000173 423.6100n 0.000209 423.6200n 0.000245 423.6300n 0.000281 423.6400n 0.000316 423.6500n 0.000352 423.6600n 0.000387 423.6700n 0.000423 423.6800n 0.000458 423.6900n 0.000493 423.7000n 0.000528 423.7100n 0.000563 423.7200n 0.000597 423.7300n 0.000632 423.7400n 0.000666
+ 423.7500n 0.000699 423.7600n 0.000733 423.7700n 0.000766 423.7800n 0.000798 423.7900n 0.000830 423.8000n 0.000862 423.8100n 0.000894 423.8200n 0.000925 423.8300n 0.000955 423.8400n 0.000985 423.8500n 0.001014 423.8600n 0.001043 423.8700n 0.001072 423.8800n 0.001099 423.8900n 0.001126
+ 423.9000n 0.001153 423.9100n 0.001179 423.9200n 0.001204 423.9300n 0.001228 423.9400n 0.001252 423.9500n 0.001275 423.9600n 0.001297 423.9700n 0.001319 423.9800n 0.001340 423.9900n 0.001359 424.0000n 0.001379 424.0100n 0.001397 424.0200n 0.001414 424.0300n 0.001431 424.0400n 0.001447
+ 424.0500n 0.001461 424.0600n 0.001475 424.0700n 0.001488 424.0800n 0.001500 424.0900n 0.001512 424.1000n 0.001522 424.1100n 0.001531 424.1200n 0.001539 424.1300n 0.001547 424.1400n 0.001553 424.1500n 0.001558 424.1600n 0.001562 424.1700n 0.001566 424.1800n 0.001568 424.1900n 0.001569
+ 424.2000n 0.001570 424.2100n 0.001569 424.2200n 0.001567 424.2300n 0.001564 424.2400n 0.001560 424.2500n 0.001555 424.2600n 0.001549 424.2700n 0.001542 424.2800n 0.001534 424.2900n 0.001525 424.3000n 0.001515 424.3100n 0.001504 424.3200n 0.001492 424.3300n 0.001478 424.3400n 0.001464
+ 424.3500n 0.001449 424.3600n 0.001433 424.3700n 0.001416 424.3800n 0.001397 424.3900n 0.001378 424.4000n 0.001358 424.4100n 0.001337 424.4200n 0.001315 424.4300n 0.001292 424.4400n 0.001268 424.4500n 0.001243 424.4600n 0.001217 424.4700n 0.001191 424.4800n 0.001163 424.4900n 0.001135
+ 424.5000n 0.001106 424.5100n 0.001076 424.5200n 0.001045 424.5300n 0.001014 424.5400n 0.000981 424.5500n 0.000948 424.5600n 0.000915 424.5700n 0.000880 424.5800n 0.000845 424.5900n 0.000809 424.6000n 0.000773 424.6100n 0.000735 424.6200n 0.000698 424.6300n 0.000659 424.6400n 0.000621
+ 424.6500n 0.000581 424.6600n 0.000541 424.6700n 0.000501 424.6800n 0.000460 424.6900n 0.000419 424.7000n 0.000377 424.7100n 0.000335 424.7200n 0.000293 424.7300n 0.000250 424.7400n 0.000207 424.7500n 0.000164 424.7600n 0.000120 424.7700n 0.000077 424.7800n 0.000033 424.7900n -0.000011
+ 424.8000n -0.000056 424.8100n -0.000100 424.8200n -0.000144 424.8300n -0.000189 424.8400n -0.000233 424.8500n -0.000278 424.8600n -0.000322 424.8700n -0.000367 424.8800n -0.000411 424.8900n -0.000455 424.9000n -0.000499 424.9100n -0.000543 424.9200n -0.000587 424.9300n -0.000630 424.9400n -0.000673
+ 424.9500n -0.000716 424.9600n -0.000759 424.9700n -0.000801 424.9800n -0.000843 424.9900n -0.000885 425.0000n -0.000926 425.0100n -0.000967 425.0200n -0.001007 425.0300n -0.001047 425.0400n -0.001086 425.0500n -0.001125 425.0600n -0.001163 425.0700n -0.001201 425.0800n -0.001237 425.0900n -0.001274
+ 425.1000n -0.001310 425.1100n -0.001345 425.1200n -0.001379 425.1300n -0.001413 425.1400n -0.001445 425.1500n -0.001478 425.1600n -0.001509 425.1700n -0.001540 425.1800n -0.001569 425.1900n -0.001598 425.2000n -0.001626 425.2100n -0.001654 425.2200n -0.001680 425.2300n -0.001706 425.2400n -0.001730
+ 425.2500n -0.001754 425.2600n -0.001777 425.2700n -0.001798 425.2800n -0.001819 425.2900n -0.001839 425.3000n -0.001858 425.3100n -0.001876 425.3200n -0.001893 425.3300n -0.001909 425.3400n -0.001924 425.3500n -0.001938 425.3600n -0.001951 425.3700n -0.001963 425.3800n -0.001973 425.3900n -0.001983
+ 425.4000n -0.001992 425.4100n -0.002000 425.4200n -0.002006 425.4300n -0.002012 425.4400n -0.002017 425.4500n -0.002020 425.4600n -0.002023 425.4700n -0.002024 425.4800n -0.002024 425.4900n -0.002024 425.5000n -0.002022 425.5100n -0.002019 425.5200n -0.002016 425.5300n -0.002011 425.5400n -0.002005
+ 425.5500n -0.001998 425.5600n -0.001990 425.5700n -0.001982 425.5800n -0.001972 425.5900n -0.001961 425.6000n -0.001949 425.6100n -0.001937 425.6200n -0.001923 425.6300n -0.001909 425.6400n -0.001893 425.6500n -0.001877 425.6600n -0.001860 425.6700n -0.001841 425.6800n -0.001822 425.6900n -0.001803
+ 425.7000n -0.001782 425.7100n -0.001760 425.7200n -0.001738 425.7300n -0.001715 425.7400n -0.001691 425.7500n -0.001667 425.7600n -0.001641 425.7700n -0.001615 425.7800n -0.001588 425.7900n -0.001561 425.8000n -0.001533 425.8100n -0.001504 425.8200n -0.001475 425.8300n -0.001445 425.8400n -0.001414
+ 425.8500n -0.001383 425.8600n -0.001352 425.8700n -0.001319 425.8800n -0.001287 425.8900n -0.001254 425.9000n -0.001220 425.9100n -0.001186 425.9200n -0.001152 425.9300n -0.001117 425.9400n -0.001082 425.9500n -0.001046 425.9600n -0.001011 425.9700n -0.000974 425.9800n -0.000938 425.9900n -0.000901
+ 426.0000n -0.000865 426.0100n -0.000827 426.0200n -0.000790 426.0300n -0.000753 426.0400n -0.000715 426.0500n -0.000677 426.0600n -0.000640 426.0700n -0.000602 426.0800n -0.000564 426.0900n -0.000526 426.1000n -0.000488 426.1100n -0.000450 426.1200n -0.000412 426.1300n -0.000374 426.1400n -0.000336
+ 426.1500n -0.000298 426.1600n -0.000261 426.1700n -0.000223 426.1800n -0.000186 426.1900n -0.000148 426.2000n -0.000111 426.2100n -0.000074 426.2200n -0.000038 426.2300n -0.000001 426.2400n 0.000035 426.2500n 0.000071 426.2600n 0.000107 426.2700n 0.000142 426.2800n 0.000177 426.2900n 0.000212
+ 426.3000n 0.000247 426.3100n 0.000281 426.3200n 0.000315 426.3300n 0.000348 426.3400n 0.000381 426.3500n 0.000414 426.3600n 0.000446 426.3700n 0.000478 426.3800n 0.000509 426.3900n 0.000540 426.4000n 0.000571 426.4100n 0.000601 426.4200n 0.000630 426.4300n 0.000659 426.4400n 0.000688
+ 426.4500n 0.000716 426.4600n 0.000744 426.4700n 0.000771 426.4800n 0.000798 426.4900n 0.000824 426.5000n 0.000850 426.5100n 0.000875 426.5200n 0.000900 426.5300n 0.000924 426.5400n 0.000947 426.5500n 0.000971 426.5600n 0.000993 426.5700n 0.001015 426.5800n 0.001037 426.5900n 0.001058
+ 426.6000n 0.001079 426.6100n 0.001099 426.6200n 0.001118 426.6300n 0.001137 426.6400n 0.001156 426.6500n 0.001174 426.6600n 0.001192 426.6700n 0.001209 426.6800n 0.001225 426.6900n 0.001241 426.7000n 0.001257 426.7100n 0.001272 426.7200n 0.001287 426.7300n 0.001301 426.7400n 0.001315
+ 426.7500n 0.001328 426.7600n 0.001341 426.7700n 0.001353 426.7800n 0.001365 426.7900n 0.001377 426.8000n 0.001388 426.8100n 0.001399 426.8200n 0.001409 426.8300n 0.001419 426.8400n 0.001429 426.8500n 0.001438 426.8600n 0.001447 426.8700n 0.001456 426.8800n 0.001464 426.8900n 0.001472
+ 426.9000n 0.001479 426.9100n 0.001487 426.9200n 0.001494 426.9300n 0.001500 426.9400n 0.001507 426.9500n 0.001513 426.9600n 0.001519 426.9700n 0.001525 426.9800n 0.001530 426.9900n 0.001536 427.0000n 0.001541 427.0100n 0.001546 427.0200n 0.001550 427.0300n 0.001555 427.0400n 0.001559
+ 427.0500n 0.001564 427.0600n 0.001568 427.0700n 0.001572 427.0800n 0.001576 427.0900n 0.001579 427.1000n 0.001583 427.1100n 0.001586 427.1200n 0.001590 427.1300n 0.001593 427.1400n 0.001596 427.1500n 0.001600 427.1600n 0.001603 427.1700n 0.001606 427.1800n 0.001609 427.1900n 0.001612
+ 427.2000n 0.001615 427.2100n 0.001618 427.2200n 0.001621 427.2300n 0.001625 427.2400n 0.001628 427.2500n 0.001631 427.2600n 0.001634 427.2700n 0.001637 427.2800n 0.001640 427.2900n 0.001643 427.3000n 0.001646 427.3100n 0.001650 427.3200n 0.001653 427.3300n 0.001656 427.3400n 0.001660
+ 427.3500n 0.001663 427.3600n 0.001666 427.3700n 0.001670 427.3800n 0.001673 427.3900n 0.001677 427.4000n 0.001681 427.4100n 0.001684 427.4200n 0.001688 427.4300n 0.001692 427.4400n 0.001696 427.4500n 0.001700 427.4600n 0.001704 427.4700n 0.001708 427.4800n 0.001712 427.4900n 0.001716
+ 427.5000n 0.001720 427.5100n 0.001724 427.5200n 0.001728 427.5300n 0.001732 427.5400n 0.001737 427.5500n 0.001741 427.5600n 0.001745 427.5700n 0.001749 427.5800n 0.001753 427.5900n 0.001757 427.6000n 0.001761 427.6100n 0.001765 427.6200n 0.001769 427.6300n 0.001773 427.6400n 0.001777
+ 427.6500n 0.001781 427.6600n 0.001785 427.6700n 0.001788 427.6800n 0.001792 427.6900n 0.001795 427.7000n 0.001798 427.7100n 0.001801 427.7200n 0.001804 427.7300n 0.001807 427.7400n 0.001810 427.7500n 0.001812 427.7600n 0.001814 427.7700n 0.001816 427.7800n 0.001818 427.7900n 0.001820
+ 427.8000n 0.001821 427.8100n 0.001822 427.8200n 0.001823 427.8300n 0.001823 427.8400n 0.001824 427.8500n 0.001824 427.8600n 0.001823 427.8700n 0.001822 427.8800n 0.001821 427.8900n 0.001820 427.9000n 0.001818 427.9100n 0.001816 427.9200n 0.001813 427.9300n 0.001810 427.9400n 0.001807
+ 427.9500n 0.001803 427.9600n 0.001799 427.9700n 0.001794 427.9800n 0.001789 427.9900n 0.001783 428.0000n 0.001777 428.0100n 0.001770 428.0200n 0.001763 428.0300n 0.001755 428.0400n 0.001747 428.0500n 0.001738 428.0600n 0.001728 428.0700n 0.001719 428.0800n 0.001708 428.0900n 0.001697
+ 428.1000n 0.001685 428.1100n 0.001673 428.1200n 0.001660 428.1300n 0.001646 428.1400n 0.001632 428.1500n 0.001618 428.1600n 0.001602 428.1700n 0.001586 428.1800n 0.001569 428.1900n 0.001552 428.2000n 0.001534 428.2100n 0.001515 428.2200n 0.001496 428.2300n 0.001476 428.2400n 0.001455
+ 428.2500n 0.001434 428.2600n 0.001412 428.2700n 0.001389 428.2800n 0.001366 428.2900n 0.001342 428.3000n 0.001317 428.3100n 0.001292 428.3200n 0.001266 428.3300n 0.001239 428.3400n 0.001212 428.3500n 0.001184 428.3600n 0.001155 428.3700n 0.001125 428.3800n 0.001095 428.3900n 0.001065
+ 428.4000n 0.001033 428.4100n 0.001002 428.4200n 0.000969 428.4300n 0.000936 428.4400n 0.000902 428.4500n 0.000868 428.4600n 0.000833 428.4700n 0.000797 428.4800n 0.000761 428.4900n 0.000724 428.5000n 0.000687 428.5100n 0.000649 428.5200n 0.000611 428.5300n 0.000572 428.5400n 0.000533
+ 428.5500n 0.000493 428.5600n 0.000453 428.5700n 0.000412 428.5800n 0.000371 428.5900n 0.000330 428.6000n 0.000288 428.6100n 0.000246 428.6200n 0.000203 428.6300n 0.000160 428.6400n 0.000117 428.6500n 0.000073 428.6600n 0.000029 428.6700n -0.000015 428.6800n -0.000059 428.6900n -0.000104
+ 428.7000n -0.000149 428.7100n -0.000194 428.7200n -0.000239 428.7300n -0.000284 428.7400n -0.000330 428.7500n -0.000375 428.7600n -0.000421 428.7700n -0.000467 428.7800n -0.000512 428.7900n -0.000558 428.8000n -0.000604 428.8100n -0.000649 428.8200n -0.000695 428.8300n -0.000740 428.8400n -0.000786
+ 428.8500n -0.000831 428.8600n -0.000876 428.8700n -0.000921 428.8800n -0.000965 428.8900n -0.001010 428.9000n -0.001054 428.9100n -0.001097 428.9200n -0.001141 428.9300n -0.001184 428.9400n -0.001227 428.9500n -0.001269 428.9600n -0.001311 428.9700n -0.001352 428.9800n -0.001393 428.9900n -0.001434
+ 429.0000n -0.001474 429.0100n -0.001513 429.0200n -0.001552 429.0300n -0.001590 429.0400n -0.001628 429.0500n -0.001665 429.0600n -0.001701 429.0700n -0.001737 429.0800n -0.001772 429.0900n -0.001806 429.1000n -0.001840 429.1100n -0.001873 429.1200n -0.001905 429.1300n -0.001936 429.1400n -0.001966
+ 429.1500n -0.001996 429.1600n -0.002024 429.1700n -0.002052 429.1800n -0.002079 429.1900n -0.002105 429.2000n -0.002130 429.2100n -0.002154 429.2200n -0.002177 429.2300n -0.002199 429.2400n -0.002220 429.2500n -0.002240 429.2600n -0.002259 429.2700n -0.002277 429.2800n -0.002294 429.2900n -0.002310
+ 429.3000n -0.002325 429.3100n -0.002338 429.3200n -0.002351 429.3300n -0.002362 429.3400n -0.002373 429.3500n -0.002382 429.3600n -0.002390 429.3700n -0.002397 429.3800n -0.002403 429.3900n -0.002408 429.4000n -0.002411 429.4100n -0.002414 429.4200n -0.002415 429.4300n -0.002415 429.4400n -0.002414
+ 429.4500n -0.002412 429.4600n -0.002409 429.4700n -0.002404 429.4800n -0.002399 429.4900n -0.002392 429.5000n -0.002384 429.5100n -0.002375 429.5200n -0.002364 429.5300n -0.002353 429.5400n -0.002341 429.5500n -0.002327 429.5600n -0.002312 429.5700n -0.002296 429.5800n -0.002279 429.5900n -0.002261
+ 429.6000n -0.002242 429.6100n -0.002222 429.6200n -0.002201 429.6300n -0.002178 429.6400n -0.002155 429.6500n -0.002131 429.6600n -0.002105 429.6700n -0.002079 429.6800n -0.002052 429.6900n -0.002023 429.7000n -0.001994 429.7100n -0.001964 429.7200n -0.001933 429.7300n -0.001901 429.7400n -0.001868
+ 429.7500n -0.001834 429.7600n -0.001800 429.7700n -0.001765 429.7800n -0.001729 429.7900n -0.001692 429.8000n -0.001654 429.8100n -0.001616 429.8200n -0.001577 429.8300n -0.001537 429.8400n -0.001497 429.8500n -0.001456 429.8600n -0.001414 429.8700n -0.001372 429.8800n -0.001330 429.8900n -0.001286
+ 429.9000n -0.001243 429.9100n -0.001198 429.9200n -0.001154 429.9300n -0.001109 429.9400n -0.001063 429.9500n -0.001017 429.9600n -0.000971 429.9700n -0.000925 429.9800n -0.000878 429.9900n -0.000831 430.0000n -0.000783 430.0100n -0.000736 430.0200n -0.000688 430.0300n -0.000640 430.0400n -0.000592
+ 430.0500n -0.000544 430.0600n -0.000496 430.0700n -0.000448 430.0800n -0.000400 430.0900n -0.000351 430.1000n -0.000303 430.1100n -0.000255 430.1200n -0.000207 430.1300n -0.000159 430.1400n -0.000111 430.1500n -0.000064 430.1600n -0.000016 430.1700n 0.000031 430.1800n 0.000078 430.1900n 0.000125
+ 430.2000n 0.000171 430.2100n 0.000217 430.2200n 0.000263 430.2300n 0.000309 430.2400n 0.000354 430.2500n 0.000398 430.2600n 0.000443 430.2700n 0.000486 430.2800n 0.000530 430.2900n 0.000572 430.3000n 0.000615 430.3100n 0.000656 430.3200n 0.000698 430.3300n 0.000738 430.3400n 0.000778
+ 430.3500n 0.000818 430.3600n 0.000857 430.3700n 0.000895 430.3800n 0.000932 430.3900n 0.000969 430.4000n 0.001005 430.4100n 0.001041 430.4200n 0.001075 430.4300n 0.001109 430.4400n 0.001143 430.4500n 0.001175 430.4600n 0.001207 430.4700n 0.001238 430.4800n 0.001268 430.4900n 0.001298
+ 430.5000n 0.001326 430.5100n 0.001354 430.5200n 0.001381 430.5300n 0.001407 430.5400n 0.001432 430.5500n 0.001457 430.5600n 0.001480 430.5700n 0.001503 430.5800n 0.001525 430.5900n 0.001546 430.6000n 0.001566 430.6100n 0.001586 430.6200n 0.001604 430.6300n 0.001622 430.6400n 0.001639
+ 430.6500n 0.001655 430.6600n 0.001670 430.6700n 0.001684 430.6800n 0.001697 430.6900n 0.001710 430.7000n 0.001722 430.7100n 0.001732 430.7200n 0.001742 430.7300n 0.001752 430.7400n 0.001760 430.7500n 0.001767 430.7600n 0.001774 430.7700n 0.001780 430.7800n 0.001785 430.7900n 0.001790
+ 430.8000n 0.001793 430.8100n 0.001796 430.8200n 0.001798 430.8300n 0.001800 430.8400n 0.001800 430.8500n 0.001800 430.8600n 0.001799 430.8700n 0.001798 430.8800n 0.001796 430.8900n 0.001793 430.9000n 0.001789 430.9100n 0.001785 430.9200n 0.001781 430.9300n 0.001775 430.9400n 0.001769
+ 430.9500n 0.001763 430.9600n 0.001756 430.9700n 0.001748 430.9800n 0.001740 430.9900n 0.001731 431.0000n 0.001722 431.0100n 0.001712 431.0200n 0.001702 431.0300n 0.001692 431.0400n 0.001681 431.0500n 0.001669 431.0600n 0.001658 431.0700n 0.001645 431.0800n 0.001633 431.0900n 0.001620
+ 431.1000n 0.001607 431.1100n 0.001593 431.1200n 0.001579 431.1300n 0.001565 431.1400n 0.001551 431.1500n 0.001536 431.1600n 0.001521 431.1700n 0.001506 431.1800n 0.001491 431.1900n 0.001476 431.2000n 0.001460 431.2100n 0.001445 431.2200n 0.001429 431.2300n 0.001413 431.2400n 0.001397
+ 431.2500n 0.001381 431.2600n 0.001365 431.2700n 0.001348 431.2800n 0.001332 431.2900n 0.001316 431.3000n 0.001300 431.3100n 0.001283 431.3200n 0.001267 431.3300n 0.001251 431.3400n 0.001235 431.3500n 0.001219 431.3600n 0.001203 431.3700n 0.001187 431.3800n 0.001171 431.3900n 0.001155
+ 431.4000n 0.001139 431.4100n 0.001124 431.4200n 0.001108 431.4300n 0.001093 431.4400n 0.001078 431.4500n 0.001063 431.4600n 0.001049 431.4700n 0.001034 431.4800n 0.001020 431.4900n 0.001005 431.5000n 0.000991 431.5100n 0.000978 431.5200n 0.000964 431.5300n 0.000951 431.5400n 0.000937
+ 431.5500n 0.000924 431.5600n 0.000912 431.5700n 0.000899 431.5800n 0.000887 431.5900n 0.000875 431.6000n 0.000863 431.6100n 0.000851 431.6200n 0.000840 431.6300n 0.000829 431.6400n 0.000818 431.6500n 0.000807 431.6600n 0.000796 431.6700n 0.000786 431.6800n 0.000776 431.6900n 0.000766
+ 431.7000n 0.000756 431.7100n 0.000747 431.7200n 0.000738 431.7300n 0.000729 431.7400n 0.000720 431.7500n 0.000711 431.7600n 0.000702 431.7700n 0.000694 431.7800n 0.000686 431.7900n 0.000678 431.8000n 0.000670 431.8100n 0.000662 431.8200n 0.000655 431.8300n 0.000647 431.8400n 0.000640
+ 431.8500n 0.000632 431.8600n 0.000625 431.8700n 0.000618 431.8800n 0.000611 431.8900n 0.000604 431.9000n 0.000597 431.9100n 0.000590 431.9200n 0.000584 431.9300n 0.000577 431.9400n 0.000570 431.9500n 0.000563 431.9600n 0.000557 431.9700n 0.000550 431.9800n 0.000543 431.9900n 0.000536
+ 432.0000n 0.000529 432.0100n 0.000522 432.0200n 0.000515 432.0300n 0.000508 432.0400n 0.000500 432.0500n 0.000493 432.0600n 0.000485 432.0700n 0.000478 432.0800n 0.000470 432.0900n 0.000462 432.1000n 0.000454 432.1100n 0.000445 432.1200n 0.000437 432.1300n 0.000428 432.1400n 0.000419
+ 432.1500n 0.000410 432.1600n 0.000400 432.1700n 0.000390 432.1800n 0.000380 432.1900n 0.000370 432.2000n 0.000360 432.2100n 0.000349 432.2200n 0.000338 432.2300n 0.000326 432.2400n 0.000314 432.2500n 0.000302 432.2600n 0.000290 432.2700n 0.000277 432.2800n 0.000264 432.2900n 0.000251
+ 432.3000n 0.000237 432.3100n 0.000223 432.3200n 0.000208 432.3300n 0.000193 432.3400n 0.000178 432.3500n 0.000162 432.3600n 0.000146 432.3700n 0.000130 432.3800n 0.000113 432.3900n 0.000095 432.4000n 0.000078 432.4100n 0.000060 432.4200n 0.000041 432.4300n 0.000023 432.4400n 0.000003
+ 432.4500n -0.000016 432.4600n -0.000036 432.4700n -0.000057 432.4800n -0.000078 432.4900n -0.000099 432.5000n -0.000120 432.5100n -0.000142 432.5200n -0.000165 432.5300n -0.000187 432.5400n -0.000210 432.5500n -0.000234 432.5600n -0.000258 432.5700n -0.000282 432.5800n -0.000306 432.5900n -0.000331
+ 432.6000n -0.000356 432.6100n -0.000381 432.6200n -0.000407 432.6300n -0.000433 432.6400n -0.000459 432.6500n -0.000486 432.6600n -0.000513 432.6700n -0.000540 432.6800n -0.000567 432.6900n -0.000594 432.7000n -0.000622 432.7100n -0.000650 432.7200n -0.000678 432.7300n -0.000706 432.7400n -0.000734
+ 432.7500n -0.000763 432.7600n -0.000791 432.7700n -0.000820 432.7800n -0.000848 432.7900n -0.000877 432.8000n -0.000906 432.8100n -0.000935 432.8200n -0.000964 432.8300n -0.000992 432.8400n -0.001021 432.8500n -0.001050 432.8600n -0.001078 432.8700n -0.001107 432.8800n -0.001135 432.8900n -0.001163
+ 432.9000n -0.001192 432.9100n -0.001219 432.9200n -0.001247 432.9300n -0.001275 432.9400n -0.001302 432.9500n -0.001329 432.9600n -0.001356 432.9700n -0.001382 432.9800n -0.001408 432.9900n -0.001434 433.0000n -0.001459 433.0100n -0.001484 433.0200n -0.001509 433.0300n -0.001533 433.0400n -0.001557
+ 433.0500n -0.001580 433.0600n -0.001602 433.0700n -0.001625 433.0800n -0.001646 433.0900n -0.001667 433.1000n -0.001688 433.1100n -0.001708 433.1200n -0.001727 433.1300n -0.001746 433.1400n -0.001764 433.1500n -0.001781 433.1600n -0.001798 433.1700n -0.001814 433.1800n -0.001829 433.1900n -0.001844
+ 433.2000n -0.001857 433.2100n -0.001870 433.2200n -0.001883 433.2300n -0.001894 433.2400n -0.001905 433.2500n -0.001914 433.2600n -0.001923 433.2700n -0.001931 433.2800n -0.001938 433.2900n -0.001945 433.3000n -0.001950 433.3100n -0.001954 433.3200n -0.001958 433.3300n -0.001961 433.3400n -0.001962
+ 433.3500n -0.001963 433.3600n -0.001963 433.3700n -0.001961 433.3800n -0.001959 433.3900n -0.001956 433.4000n -0.001952 433.4100n -0.001947 433.4200n -0.001941 433.4300n -0.001934 433.4400n -0.001926 433.4500n -0.001917 433.4600n -0.001907 433.4700n -0.001896 433.4800n -0.001884 433.4900n -0.001871
+ 433.5000n -0.001857 433.5100n -0.001842 433.5200n -0.001826 433.5300n -0.001809 433.5400n -0.001791 433.5500n -0.001772 433.5600n -0.001752 433.5700n -0.001731 433.5800n -0.001710 433.5900n -0.001687 433.6000n -0.001663 433.6100n -0.001639 433.6200n -0.001613 433.6300n -0.001587 433.6400n -0.001560
+ 433.6500n -0.001532 433.6600n -0.001503 433.6700n -0.001474 433.6800n -0.001443 433.6900n -0.001412 433.7000n -0.001380 433.7100n -0.001347 433.7200n -0.001314 433.7300n -0.001279 433.7400n -0.001245 433.7500n -0.001209 433.7600n -0.001173 433.7700n -0.001136 433.7800n -0.001098 433.7900n -0.001060
+ 433.8000n -0.001022 433.8100n -0.000982 433.8200n -0.000943 433.8300n -0.000903 433.8400n -0.000862 433.8500n -0.000821 433.8600n -0.000780 433.8700n -0.000738 433.8800n -0.000696 433.8900n -0.000653 433.9000n -0.000611 433.9100n -0.000568 433.9200n -0.000524 433.9300n -0.000481 433.9400n -0.000437
+ 433.9500n -0.000394 433.9600n -0.000350 433.9700n -0.000306 433.9800n -0.000262 433.9900n -0.000218 434.0000n -0.000174 434.0100n -0.000130 434.0200n -0.000087 434.0300n -0.000043 434.0400n 0.000001 434.0500n 0.000044 434.0600n 0.000087 434.0700n 0.000130 434.0800n 0.000172 434.0900n 0.000215
+ 434.1000n 0.000256 434.1100n 0.000298 434.1200n 0.000339 434.1300n 0.000380 434.1400n 0.000420 434.1500n 0.000459 434.1600n 0.000498 434.1700n 0.000537 434.1800n 0.000575 434.1900n 0.000612 434.2000n 0.000649 434.2100n 0.000685 434.2200n 0.000720 434.2300n 0.000754 434.2400n 0.000788
+ 434.2500n 0.000821 434.2600n 0.000853 434.2700n 0.000884 434.2800n 0.000914 434.2900n 0.000943 434.3000n 0.000972 434.3100n 0.000999 434.3200n 0.001026 434.3300n 0.001051 434.3400n 0.001076 434.3500n 0.001099 434.3600n 0.001121 434.3700n 0.001142 434.3800n 0.001162 434.3900n 0.001181
+ 434.4000n 0.001199 434.4100n 0.001215 434.4200n 0.001230 434.4300n 0.001245 434.4400n 0.001257 434.4500n 0.001269 434.4600n 0.001279 434.4700n 0.001288 434.4800n 0.001296 434.4900n 0.001303 434.5000n 0.001308 434.5100n 0.001312 434.5200n 0.001314 434.5300n 0.001316 434.5400n 0.001315
+ 434.5500n 0.001314 434.5600n 0.001311 434.5700n 0.001307 434.5800n 0.001302 434.5900n 0.001295 434.6000n 0.001286 434.6100n 0.001277 434.6200n 0.001266 434.6300n 0.001254 434.6400n 0.001240 434.6500n 0.001225 434.6600n 0.001209 434.6700n 0.001191 434.6800n 0.001172 434.6900n 0.001152
+ 434.7000n 0.001130 434.7100n 0.001108 434.7200n 0.001083 434.7300n 0.001058 434.7400n 0.001031 434.7500n 0.001003 434.7600n 0.000974 434.7700n 0.000944 434.7800n 0.000912 434.7900n 0.000880 434.8000n 0.000846 434.8100n 0.000811 434.8200n 0.000774 434.8300n 0.000737 434.8400n 0.000699
+ 434.8500n 0.000660 434.8600n 0.000619 434.8700n 0.000578 434.8800n 0.000535 434.8900n 0.000492 434.9000n 0.000448 434.9100n 0.000403 434.9200n 0.000357 434.9300n 0.000310 434.9400n 0.000262 434.9500n 0.000214 434.9600n 0.000165 434.9700n 0.000115 434.9800n 0.000064 434.9900n 0.000013
+ 435.0000n -0.000039 435.0100n -0.000091 435.0200n -0.000144 435.0300n -0.000198 435.0400n -0.000252 435.0500n -0.000306 435.0600n -0.000361 435.0700n -0.000416 435.0800n -0.000471 435.0900n -0.000527 435.1000n -0.000583 435.1100n -0.000639 435.1200n -0.000696 435.1300n -0.000752 435.1400n -0.000809
+ 435.1500n -0.000865 435.1600n -0.000922 435.1700n -0.000979 435.1800n -0.001035 435.1900n -0.001092 435.2000n -0.001148 435.2100n -0.001205 435.2200n -0.001261 435.2300n -0.001316 435.2400n -0.001372 435.2500n -0.001427 435.2600n -0.001482 435.2700n -0.001536 435.2800n -0.001590 435.2900n -0.001644
+ 435.3000n -0.001696 435.3100n -0.001749 435.3200n -0.001801 435.3300n -0.001852 435.3400n -0.001902 435.3500n -0.001952 435.3600n -0.002001 435.3700n -0.002049 435.3800n -0.002097 435.3900n -0.002143 435.4000n -0.002189 435.4100n -0.002234 435.4200n -0.002278 435.4300n -0.002321 435.4400n -0.002363
+ 435.4500n -0.002404 435.4600n -0.002444 435.4700n -0.002483 435.4800n -0.002520 435.4900n -0.002557 435.5000n -0.002592 435.5100n -0.002626 435.5200n -0.002659 435.5300n -0.002691 435.5400n -0.002722 435.5500n -0.002751 435.5600n -0.002779 435.5700n -0.002805 435.5800n -0.002830 435.5900n -0.002854
+ 435.6000n -0.002877 435.6100n -0.002898 435.6200n -0.002917 435.6300n -0.002935 435.6400n -0.002952 435.6500n -0.002968 435.6600n -0.002981 435.6700n -0.002994 435.6800n -0.003005 435.6900n -0.003014 435.7000n -0.003022 435.7100n -0.003028 435.7200n -0.003033 435.7300n -0.003036 435.7400n -0.003038
+ 435.7500n -0.003038 435.7600n -0.003037 435.7700n -0.003034 435.7800n -0.003030 435.7900n -0.003024 435.8000n -0.003017 435.8100n -0.003008 435.8200n -0.002997 435.8300n -0.002985 435.8400n -0.002972 435.8500n -0.002957 435.8600n -0.002940 435.8700n -0.002923 435.8800n -0.002903 435.8900n -0.002882
+ 435.9000n -0.002860 435.9100n -0.002836 435.9200n -0.002811 435.9300n -0.002785 435.9400n -0.002757 435.9500n -0.002727 435.9600n -0.002697 435.9700n -0.002665 435.9800n -0.002632 435.9900n -0.002597 436.0000n -0.002561 436.0100n -0.002524 436.0200n -0.002486 436.0300n -0.002446 436.0400n -0.002406
+ 436.0500n -0.002364 436.0600n -0.002321 436.0700n -0.002277 436.0800n -0.002232 436.0900n -0.002186 436.1000n -0.002139 436.1100n -0.002091 436.1200n -0.002042 436.1300n -0.001992 436.1400n -0.001941 436.1500n -0.001890 436.1600n -0.001837 436.1700n -0.001784 436.1800n -0.001730 436.1900n -0.001675
+ 436.2000n -0.001620 436.2100n -0.001564 436.2200n -0.001507 436.2300n -0.001450 436.2400n -0.001392 436.2500n -0.001334 436.2600n -0.001275 436.2700n -0.001216 436.2800n -0.001156 436.2900n -0.001096 436.3000n -0.001036 436.3100n -0.000975 436.3200n -0.000915 436.3300n -0.000854 436.3400n -0.000792
+ 436.3500n -0.000731 436.3600n -0.000670 436.3700n -0.000608 436.3800n -0.000547 436.3900n -0.000485 436.4000n -0.000424 436.4100n -0.000362 436.4200n -0.000301 436.4300n -0.000240 436.4400n -0.000179 436.4500n -0.000118 436.4600n -0.000057 436.4700n 0.000003 436.4800n 0.000063 436.4900n 0.000122
+ 436.5000n 0.000181 436.5100n 0.000240 436.5200n 0.000298 436.5300n 0.000356 436.5400n 0.000413 436.5500n 0.000470 436.5600n 0.000526 436.5700n 0.000581 436.5800n 0.000636 436.5900n 0.000690 436.6000n 0.000743 436.6100n 0.000796 436.6200n 0.000848 436.6300n 0.000899 436.6400n 0.000949
+ 436.6500n 0.000999 436.6600n 0.001048 436.6700n 0.001095 436.6800n 0.001142 436.6900n 0.001188 436.7000n 0.001233 436.7100n 0.001277 436.7200n 0.001320 436.7300n 0.001362 436.7400n 0.001403 436.7500n 0.001443 436.7600n 0.001482 436.7700n 0.001519 436.7800n 0.001556 436.7900n 0.001591
+ 436.8000n 0.001626 436.8100n 0.001659 436.8200n 0.001691 436.8300n 0.001722 436.8400n 0.001752 436.8500n 0.001781 436.8600n 0.001808 436.8700n 0.001834 436.8800n 0.001859 436.8900n 0.001883 436.9000n 0.001906 436.9100n 0.001927 436.9200n 0.001947 436.9300n 0.001966 436.9400n 0.001984
+ 436.9500n 0.002000 436.9600n 0.002016 436.9700n 0.002030 436.9800n 0.002043 436.9900n 0.002054 437.0000n 0.002065 437.0100n 0.002074 437.0200n 0.002082 437.0300n 0.002089 437.0400n 0.002095 437.0500n 0.002099 437.0600n 0.002102 437.0700n 0.002104 437.0800n 0.002105 437.0900n 0.002105
+ 437.1000n 0.002104 437.1100n 0.002102 437.1200n 0.002098 437.1300n 0.002094 437.1400n 0.002088 437.1500n 0.002081 437.1600n 0.002073 437.1700n 0.002065 437.1800n 0.002055 437.1900n 0.002044 437.2000n 0.002032 437.2100n 0.002019 437.2200n 0.002006 437.2300n 0.001991 437.2400n 0.001976
+ 437.2500n 0.001959 437.2600n 0.001942 437.2700n 0.001924 437.2800n 0.001905 437.2900n 0.001885 437.3000n 0.001865 437.3100n 0.001843 437.3200n 0.001822 437.3300n 0.001799 437.3400n 0.001775 437.3500n 0.001751 437.3600n 0.001727 437.3700n 0.001702 437.3800n 0.001676 437.3900n 0.001649
+ 437.4000n 0.001622 437.4100n 0.001595 437.4200n 0.001567 437.4300n 0.001539 437.4400n 0.001510 437.4500n 0.001480 437.4600n 0.001451 437.4700n 0.001421 437.4800n 0.001390 437.4900n 0.001360 437.5000n 0.001329 437.5100n 0.001298 437.5200n 0.001266 437.5300n 0.001234 437.5400n 0.001203
+ 437.5500n 0.001171 437.5600n 0.001138 437.5700n 0.001106 437.5800n 0.001074 437.5900n 0.001041 437.6000n 0.001009 437.6100n 0.000976 437.6200n 0.000944 437.6300n 0.000911 437.6400n 0.000879 437.6500n 0.000846 437.6600n 0.000814 437.6700n 0.000782 437.6800n 0.000749 437.6900n 0.000717
+ 437.7000n 0.000686 437.7100n 0.000654 437.7200n 0.000623 437.7300n 0.000591 437.7400n 0.000560 437.7500n 0.000530 437.7600n 0.000499 437.7700n 0.000469 437.7800n 0.000439 437.7900n 0.000410 437.8000n 0.000380 437.8100n 0.000351 437.8200n 0.000323 437.8300n 0.000295 437.8400n 0.000267
+ 437.8500n 0.000239 437.8600n 0.000212 437.8700n 0.000186 437.8800n 0.000160 437.8900n 0.000134 437.9000n 0.000109 437.9100n 0.000084 437.9200n 0.000060 437.9300n 0.000036 437.9400n 0.000012 437.9500n -0.000011 437.9600n -0.000033 437.9700n -0.000055 437.9800n -0.000076 437.9900n -0.000097
+ 438.0000n -0.000118 438.0100n -0.000138 438.0200n -0.000157 438.0300n -0.000176 438.0400n -0.000195 438.0500n -0.000213 438.0600n -0.000230 438.0700n -0.000247 438.0800n -0.000263 438.0900n -0.000279 438.1000n -0.000295 438.1100n -0.000310 438.1200n -0.000324 438.1300n -0.000338 438.1400n -0.000351
+ 438.1500n -0.000364 438.1600n -0.000377 438.1700n -0.000389 438.1800n -0.000400 438.1900n -0.000411 438.2000n -0.000422 438.2100n -0.000432 438.2200n -0.000442 438.2300n -0.000451 438.2400n -0.000460 438.2500n -0.000469 438.2600n -0.000477 438.2700n -0.000485 438.2800n -0.000492 438.2900n -0.000499
+ 438.3000n -0.000505 438.3100n -0.000512 438.3200n -0.000518 438.3300n -0.000523 438.3400n -0.000528 438.3500n -0.000533 438.3600n -0.000538 438.3700n -0.000542 438.3800n -0.000546 438.3900n -0.000550 438.4000n -0.000554 438.4100n -0.000557 438.4200n -0.000560 438.4300n -0.000563 438.4400n -0.000566
+ 438.4500n -0.000569 438.4600n -0.000571 438.4700n -0.000573 438.4800n -0.000575 438.4900n -0.000577 438.5000n -0.000579 438.5100n -0.000581 438.5200n -0.000582 438.5300n -0.000584 438.5400n -0.000585 438.5500n -0.000587 438.5600n -0.000588 438.5700n -0.000590 438.5800n -0.000591 438.5900n -0.000592
+ 438.6000n -0.000593 438.6100n -0.000595 438.6200n -0.000596 438.6300n -0.000597 438.6400n -0.000599 438.6500n -0.000600 438.6600n -0.000602 438.6700n -0.000603 438.6800n -0.000605 438.6900n -0.000607 438.7000n -0.000609 438.7100n -0.000611 438.7200n -0.000613 438.7300n -0.000615 438.7400n -0.000617
+ 438.7500n -0.000620 438.7600n -0.000622 438.7700n -0.000625 438.7800n -0.000628 438.7900n -0.000631 438.8000n -0.000634 438.8100n -0.000637 438.8200n -0.000641 438.8300n -0.000645 438.8400n -0.000649 438.8500n -0.000653 438.8600n -0.000657 438.8700n -0.000661 438.8800n -0.000666 438.8900n -0.000671
+ 438.9000n -0.000676 438.9100n -0.000681 438.9200n -0.000686 438.9300n -0.000692 438.9400n -0.000698 438.9500n -0.000704 438.9600n -0.000710 438.9700n -0.000716 438.9800n -0.000723 438.9900n -0.000729 439.0000n -0.000736 439.0100n -0.000743 439.0200n -0.000751 439.0300n -0.000758 439.0400n -0.000765
+ 439.0500n -0.000773 439.0600n -0.000781 439.0700n -0.000789 439.0800n -0.000797 439.0900n -0.000805 439.1000n -0.000813 439.1100n -0.000822 439.1200n -0.000830 439.1300n -0.000839 439.1400n -0.000848 439.1500n -0.000856 439.1600n -0.000865 439.1700n -0.000874 439.1800n -0.000883 439.1900n -0.000892
+ 439.2000n -0.000901 439.2100n -0.000910 439.2200n -0.000919 439.2300n -0.000928 439.2400n -0.000937 439.2500n -0.000946 439.2600n -0.000954 439.2700n -0.000963 439.2800n -0.000972 439.2900n -0.000981 439.3000n -0.000989 439.3100n -0.000998 439.3200n -0.001006 439.3300n -0.001014 439.3400n -0.001022
+ 439.3500n -0.001030 439.3600n -0.001038 439.3700n -0.001045 439.3800n -0.001053 439.3900n -0.001060 439.4000n -0.001067 439.4100n -0.001073 439.4200n -0.001080 439.4300n -0.001086 439.4400n -0.001091 439.4500n -0.001097 439.4600n -0.001102 439.4700n -0.001107 439.4800n -0.001112 439.4900n -0.001116
+ 439.5000n -0.001120 439.5100n -0.001123 439.5200n -0.001127 439.5300n -0.001129 439.5400n -0.001132 439.5500n -0.001134 439.5600n -0.001135 439.5700n -0.001136 439.5800n -0.001137 439.5900n -0.001137 439.6000n -0.001137 439.6100n -0.001136 439.6200n -0.001135 439.6300n -0.001133 439.6400n -0.001131
+ 439.6500n -0.001128 439.6600n -0.001125 439.6700n -0.001121 439.6800n -0.001116 439.6900n -0.001111 439.7000n -0.001106 439.7100n -0.001100 439.7200n -0.001094 439.7300n -0.001086 439.7400n -0.001079 439.7500n -0.001070 439.7600n -0.001062 439.7700n -0.001052 439.7800n -0.001042 439.7900n -0.001032
+ 439.8000n -0.001020 439.8100n -0.001009 439.8200n -0.000996 439.8300n -0.000983 439.8400n -0.000970 439.8500n -0.000956 439.8600n -0.000941 439.8700n -0.000926 439.8800n -0.000910 439.8900n -0.000893 439.9000n -0.000876 439.9100n -0.000858 439.9200n -0.000840 439.9300n -0.000821 439.9400n -0.000802
+ 439.9500n -0.000782 439.9600n -0.000762 439.9700n -0.000741 439.9800n -0.000719 439.9900n -0.000697 440.0000n -0.000674 440.0100n -0.000651 440.0200n -0.000627 440.0300n -0.000603 440.0400n -0.000579 440.0500n -0.000554 440.0600n -0.000528 440.0700n -0.000502 440.0800n -0.000475 440.0900n -0.000448
+ 440.1000n -0.000421 440.1100n -0.000393 440.1200n -0.000365 440.1300n -0.000336 440.1400n -0.000308 440.1500n -0.000278 440.1600n -0.000249 440.1700n -0.000219 440.1800n -0.000188 440.1900n -0.000158 440.2000n -0.000127 440.2100n -0.000096 440.2200n -0.000064 440.2300n -0.000033 440.2400n -0.000001
+ 440.2500n 0.000031 440.2600n 0.000063 440.2700n 0.000096 440.2800n 0.000128 440.2900n 0.000161 440.3000n 0.000193 440.3100n 0.000226 440.3200n 0.000259 440.3300n 0.000292 440.3400n 0.000325 440.3500n 0.000358 440.3600n 0.000391 440.3700n 0.000424 440.3800n 0.000457 440.3900n 0.000490
+ 440.4000n 0.000522 440.4100n 0.000555 440.4200n 0.000588 440.4300n 0.000620 440.4400n 0.000652 440.4500n 0.000684 440.4600n 0.000716 440.4700n 0.000748 440.4800n 0.000779 440.4900n 0.000810 440.5000n 0.000841 440.5100n 0.000871 440.5200n 0.000902 440.5300n 0.000932 440.5400n 0.000961
+ 440.5500n 0.000990 440.5600n 0.001019 440.5700n 0.001047 440.5800n 0.001075 440.5900n 0.001103 440.6000n 0.001130 440.6100n 0.001156 440.6200n 0.001183 440.6300n 0.001208 440.6400n 0.001233 440.6500n 0.001258 440.6600n 0.001282 440.6700n 0.001305 440.6800n 0.001328 440.6900n 0.001350
+ 440.7000n 0.001372 440.7100n 0.001393 440.7200n 0.001413 440.7300n 0.001433 440.7400n 0.001452 440.7500n 0.001470 440.7600n 0.001488 440.7700n 0.001505 440.7800n 0.001521 440.7900n 0.001536 440.8000n 0.001551 440.8100n 0.001565 440.8200n 0.001579 440.8300n 0.001591 440.8400n 0.001603
+ 440.8500n 0.001614 440.8600n 0.001624 440.8700n 0.001634 440.8800n 0.001643 440.8900n 0.001651 440.9000n 0.001658 440.9100n 0.001664 440.9200n 0.001670 440.9300n 0.001675 440.9400n 0.001679 440.9500n 0.001682 440.9600n 0.001684 440.9700n 0.001686 440.9800n 0.001687 440.9900n 0.001687
+ 441.0000n 0.001686 441.0100n 0.001684 441.0200n 0.001682 441.0300n 0.001678 441.0400n 0.001674 441.0500n 0.001669 441.0600n 0.001664 441.0700n 0.001657 441.0800n 0.001650 441.0900n 0.001642 441.1000n 0.001634 441.1100n 0.001624 441.1200n 0.001614 441.1300n 0.001603 441.1400n 0.001591
+ 441.1500n 0.001579 441.1600n 0.001566 441.1700n 0.001552 441.1800n 0.001537 441.1900n 0.001522 441.2000n 0.001506 441.2100n 0.001489 441.2200n 0.001472 441.2300n 0.001454 441.2400n 0.001436 441.2500n 0.001416 441.2600n 0.001397 441.2700n 0.001376 441.2800n 0.001355 441.2900n 0.001334
+ 441.3000n 0.001312 441.3100n 0.001289 441.3200n 0.001266 441.3300n 0.001242 441.3400n 0.001218 441.3500n 0.001193 441.3600n 0.001168 441.3700n 0.001143 441.3800n 0.001117 441.3900n 0.001090 441.4000n 0.001063 441.4100n 0.001036 441.4200n 0.001009 441.4300n 0.000981 441.4400n 0.000952
+ 441.4500n 0.000924 441.4600n 0.000895 441.4700n 0.000866 441.4800n 0.000836 441.4900n 0.000807 441.5000n 0.000777 441.5100n 0.000746 441.5200n 0.000716 441.5300n 0.000686 441.5400n 0.000655 441.5500n 0.000624 441.5600n 0.000593 441.5700n 0.000562 441.5800n 0.000531 441.5900n 0.000499
+ 441.6000n 0.000468 441.6100n 0.000437 441.6200n 0.000405 441.6300n 0.000374 441.6400n 0.000342 441.6500n 0.000311 441.6600n 0.000280 441.6700n 0.000248 441.6800n 0.000217 441.6900n 0.000186 441.7000n 0.000155 441.7100n 0.000124 441.7200n 0.000093 441.7300n 0.000062 441.7400n 0.000031
+ 441.7500n 0.000001 441.7600n -0.000029 441.7700n -0.000059 441.7800n -0.000089 441.7900n -0.000119 441.8000n -0.000148 441.8100n -0.000178 441.8200n -0.000207 441.8300n -0.000235 441.8400n -0.000264 441.8500n -0.000292 441.8600n -0.000320 441.8700n -0.000347 441.8800n -0.000375 441.8900n -0.000401
+ 441.9000n -0.000428 441.9100n -0.000454 441.9200n -0.000480 441.9300n -0.000506 441.9400n -0.000531 441.9500n -0.000556 441.9600n -0.000580 441.9700n -0.000604 441.9800n -0.000628 441.9900n -0.000652 442.0000n -0.000674 442.0100n -0.000697 442.0200n -0.000719 442.0300n -0.000741 442.0400n -0.000762
+ 442.0500n -0.000783 442.0600n -0.000804 442.0700n -0.000824 442.0800n -0.000844 442.0900n -0.000863 442.1000n -0.000882 442.1100n -0.000900 442.1200n -0.000918 442.1300n -0.000936 442.1400n -0.000953 442.1500n -0.000970 442.1600n -0.000986 442.1700n -0.001002 442.1800n -0.001018 442.1900n -0.001033
+ 442.2000n -0.001048 442.2100n -0.001062 442.2200n -0.001076 442.2300n -0.001089 442.2400n -0.001103 442.2500n -0.001115 442.2600n -0.001128 442.2700n -0.001140 442.2800n -0.001151 442.2900n -0.001163 442.3000n -0.001173 442.3100n -0.001184 442.3200n -0.001194 442.3300n -0.001204 442.3400n -0.001213
+ 442.3500n -0.001223 442.3600n -0.001231 442.3700n -0.001240 442.3800n -0.001248 442.3900n -0.001256 442.4000n -0.001263 442.4100n -0.001271 442.4200n -0.001278 442.4300n -0.001284 442.4400n -0.001291 442.4500n -0.001297 442.4600n -0.001303 442.4700n -0.001308 442.4800n -0.001314 442.4900n -0.001319
+ 442.5000n -0.001324 442.5100n -0.001329 442.5200n -0.001333 442.5300n -0.001337 442.5400n -0.001341 442.5500n -0.001345 442.5600n -0.001349 442.5700n -0.001352 442.5800n -0.001356 442.5900n -0.001359 442.6000n -0.001362 442.6100n -0.001365 442.6200n -0.001367 442.6300n -0.001370 442.6400n -0.001372
+ 442.6500n -0.001375 442.6600n -0.001377 442.6700n -0.001379 442.6800n -0.001381 442.6900n -0.001383 442.7000n -0.001384 442.7100n -0.001386 442.7200n -0.001388 442.7300n -0.001389 442.7400n -0.001391 442.7500n -0.001392 442.7600n -0.001393 442.7700n -0.001395 442.7800n -0.001396 442.7900n -0.001397
+ 442.8000n -0.001398 442.8100n -0.001399 442.8200n -0.001400 442.8300n -0.001401 442.8400n -0.001402 442.8500n -0.001402 442.8600n -0.001403 442.8700n -0.001404 442.8800n -0.001405 442.8900n -0.001405 442.9000n -0.001406 442.9100n -0.001406 442.9200n -0.001407 442.9300n -0.001408 442.9400n -0.001408
+ 442.9500n -0.001408 442.9600n -0.001409 442.9700n -0.001409 442.9800n -0.001410 442.9900n -0.001410 443.0000n -0.001410 443.0100n -0.001410 443.0200n -0.001410 443.0300n -0.001411 443.0400n -0.001411 443.0500n -0.001411 443.0600n -0.001410 443.0700n -0.001410 443.0800n -0.001410 443.0900n -0.001410
+ 443.1000n -0.001409 443.1100n -0.001409 443.1200n -0.001408 443.1300n -0.001408 443.1400n -0.001407 443.1500n -0.001406 443.1600n -0.001405 443.1700n -0.001404 443.1800n -0.001403 443.1900n -0.001401 443.2000n -0.001400 443.2100n -0.001398 443.2200n -0.001396 443.2300n -0.001394 443.2400n -0.001392
+ 443.2500n -0.001390 443.2600n -0.001388 443.2700n -0.001385 443.2800n -0.001382 443.2900n -0.001379 443.3000n -0.001376 443.3100n -0.001372 443.3200n -0.001368 443.3300n -0.001364 443.3400n -0.001360 443.3500n -0.001356 443.3600n -0.001351 443.3700n -0.001346 443.3800n -0.001341 443.3900n -0.001335
+ 443.4000n -0.001330 443.4100n -0.001323 443.4200n -0.001317 443.4300n -0.001310 443.4400n -0.001303 443.4500n -0.001296 443.4600n -0.001288 443.4700n -0.001280 443.4800n -0.001272 443.4900n -0.001263 443.5000n -0.001254 443.5100n -0.001245 443.5200n -0.001235 443.5300n -0.001225 443.5400n -0.001214
+ 443.5500n -0.001203 443.5600n -0.001192 443.5700n -0.001180 443.5800n -0.001168 443.5900n -0.001156 443.6000n -0.001143 443.6100n -0.001129 443.6200n -0.001116 443.6300n -0.001101 443.6400n -0.001087 443.6500n -0.001072 443.6600n -0.001056 443.6700n -0.001040 443.6800n -0.001024 443.6900n -0.001007
+ 443.7000n -0.000990 443.7100n -0.000973 443.7200n -0.000955 443.7300n -0.000936 443.7400n -0.000917 443.7500n -0.000898 443.7600n -0.000878 443.7700n -0.000858 443.7800n -0.000838 443.7900n -0.000817 443.8000n -0.000795 443.8100n -0.000773 443.8200n -0.000751 443.8300n -0.000728 443.8400n -0.000705
+ 443.8500n -0.000682 443.8600n -0.000658 443.8700n -0.000634 443.8800n -0.000609 443.8900n -0.000585 443.9000n -0.000559 443.9100n -0.000534 443.9200n -0.000508 443.9300n -0.000481 443.9400n -0.000455 443.9500n -0.000428 443.9600n -0.000400 443.9700n -0.000373 443.9800n -0.000345 443.9900n -0.000317
+ 444.0000n -0.000288 444.0100n -0.000260 444.0200n -0.000231 444.0300n -0.000202 444.0400n -0.000172 444.0500n -0.000143 444.0600n -0.000113 444.0700n -0.000083 444.0800n -0.000053 444.0900n -0.000023 444.1000n 0.000008 444.1100n 0.000038 444.1200n 0.000069 444.1300n 0.000099 444.1400n 0.000130
+ 444.1500n 0.000161 444.1600n 0.000192 444.1700n 0.000222 444.1800n 0.000253 444.1900n 0.000284 444.2000n 0.000315 444.2100n 0.000345 444.2200n 0.000376 444.2300n 0.000407 444.2400n 0.000437 444.2500n 0.000467 444.2600n 0.000498 444.2700n 0.000528 444.2800n 0.000557 444.2900n 0.000587
+ 444.3000n 0.000616 444.3100n 0.000646 444.3200n 0.000674 444.3300n 0.000703 444.3400n 0.000731 444.3500n 0.000759 444.3600n 0.000787 444.3700n 0.000814 444.3800n 0.000841 444.3900n 0.000868 444.4000n 0.000894 444.4100n 0.000920 444.4200n 0.000945 444.4300n 0.000970 444.4400n 0.000994
+ 444.4500n 0.001018 444.4600n 0.001041 444.4700n 0.001064 444.4800n 0.001086 444.4900n 0.001108 444.5000n 0.001129 444.5100n 0.001149 444.5200n 0.001169 444.5300n 0.001188 444.5400n 0.001207 444.5500n 0.001224 444.5600n 0.001242 444.5700n 0.001258 444.5800n 0.001274 444.5900n 0.001289
+ 444.6000n 0.001303 444.6100n 0.001316 444.6200n 0.001329 444.6300n 0.001341 444.6400n 0.001352 444.6500n 0.001362 444.6600n 0.001372 444.6700n 0.001380 444.6800n 0.001388 444.6900n 0.001395 444.7000n 0.001401 444.7100n 0.001407 444.7200n 0.001411 444.7300n 0.001414 444.7400n 0.001417
+ 444.7500n 0.001419 444.7600n 0.001419 444.7700n 0.001419 444.7800n 0.001418 444.7900n 0.001416 444.8000n 0.001413 444.8100n 0.001410 444.8200n 0.001405 444.8300n 0.001399 444.8400n 0.001393 444.8500n 0.001385 444.8600n 0.001377 444.8700n 0.001367 444.8800n 0.001357 444.8900n 0.001346
+ 444.9000n 0.001333 444.9100n 0.001320 444.9200n 0.001306 444.9300n 0.001291 444.9400n 0.001275 444.9500n 0.001259 444.9600n 0.001241 444.9700n 0.001223 444.9800n 0.001203 444.9900n 0.001183 445.0000n 0.001162 445.0100n 0.001140 445.0200n 0.001117 445.0300n 0.001093 445.0400n 0.001069
+ 445.0500n 0.001044 445.0600n 0.001018 445.0700n 0.000991 445.0800n 0.000963 445.0900n 0.000935 445.1000n 0.000906 445.1100n 0.000876 445.1200n 0.000845 445.1300n 0.000814 445.1400n 0.000782 445.1500n 0.000750 445.1600n 0.000717 445.1700n 0.000683 445.1800n 0.000649 445.1900n 0.000614
+ 445.2000n 0.000578 445.2100n 0.000542 445.2200n 0.000506 445.2300n 0.000469 445.2400n 0.000431 445.2500n 0.000393 445.2600n 0.000355 445.2700n 0.000316 445.2800n 0.000277 445.2900n 0.000238 445.3000n 0.000198 445.3100n 0.000158 445.3200n 0.000117 445.3300n 0.000077 445.3400n 0.000036
+ 445.3500n -0.000005 445.3600n -0.000046 445.3700n -0.000088 445.3800n -0.000129 445.3900n -0.000171 445.4000n -0.000213 445.4100n -0.000254 445.4200n -0.000296 445.4300n -0.000338 445.4400n -0.000379 445.4500n -0.000421 445.4600n -0.000463 445.4700n -0.000504 445.4800n -0.000545 445.4900n -0.000586
+ 445.5000n -0.000627 445.5100n -0.000668 445.5200n -0.000708 445.5300n -0.000748 445.5400n -0.000788 445.5500n -0.000828 445.5600n -0.000867 445.5700n -0.000906 445.5800n -0.000944 445.5900n -0.000982 445.6000n -0.001020 445.6100n -0.001057 445.6200n -0.001093 445.6300n -0.001129 445.6400n -0.001165
+ 445.6500n -0.001199 445.6600n -0.001234 445.6700n -0.001267 445.6800n -0.001300 445.6900n -0.001333 445.7000n -0.001364 445.7100n -0.001395 445.7200n -0.001425 445.7300n -0.001455 445.7400n -0.001484 445.7500n -0.001512 445.7600n -0.001539 445.7700n -0.001565 445.7800n -0.001591 445.7900n -0.001615
+ 445.8000n -0.001639 445.8100n -0.001662 445.8200n -0.001684 445.8300n -0.001705 445.8400n -0.001725 445.8500n -0.001744 445.8600n -0.001762 445.8700n -0.001780 445.8800n -0.001796 445.8900n -0.001811 445.9000n -0.001826 445.9100n -0.001839 445.9200n -0.001851 445.9300n -0.001863 445.9400n -0.001873
+ 445.9500n -0.001882 445.9600n -0.001891 445.9700n -0.001898 445.9800n -0.001904 445.9900n -0.001909 446.0000n -0.001913 446.0100n -0.001916 446.0200n -0.001918 446.0300n -0.001919 446.0400n -0.001919 446.0500n -0.001918 446.0600n -0.001916 446.0700n -0.001913 446.0800n -0.001909 446.0900n -0.001903
+ 446.1000n -0.001897 446.1100n -0.001890 446.1200n -0.001882 446.1300n -0.001872 446.1400n -0.001862 446.1500n -0.001851 446.1600n -0.001839 446.1700n -0.001826 446.1800n -0.001812 446.1900n -0.001797 446.2000n -0.001781 446.2100n -0.001764 446.2200n -0.001746 446.2300n -0.001728 446.2400n -0.001708
+ 446.2500n -0.001688 446.2600n -0.001667 446.2700n -0.001645 446.2800n -0.001622 446.2900n -0.001598 446.3000n -0.001574 446.3100n -0.001549 446.3200n -0.001523 446.3300n -0.001497 446.3400n -0.001470 446.3500n -0.001442 446.3600n -0.001414 446.3700n -0.001385 446.3800n -0.001355 446.3900n -0.001325
+ 446.4000n -0.001295 446.4100n -0.001264 446.4200n -0.001232 446.4300n -0.001200 446.4400n -0.001167 446.4500n -0.001134 446.4600n -0.001101 446.4700n -0.001068 446.4800n -0.001034 446.4900n -0.000999 446.5000n -0.000965 446.5100n -0.000930 446.5200n -0.000895 446.5300n -0.000860 446.5400n -0.000824
+ 446.5500n -0.000789 446.5600n -0.000753 446.5700n -0.000718 446.5800n -0.000682 446.5900n -0.000646 446.6000n -0.000611 446.6100n -0.000575 446.6200n -0.000539 446.6300n -0.000504 446.6400n -0.000468 446.6500n -0.000433 446.6600n -0.000398 446.6700n -0.000363 446.6800n -0.000328 446.6900n -0.000294
+ 446.7000n -0.000260 446.7100n -0.000226 446.7200n -0.000192 446.7300n -0.000159 446.7400n -0.000127 446.7500n -0.000094 446.7600n -0.000062 446.7700n -0.000031 446.7800n 0.000000 446.7900n 0.000031 446.8000n 0.000060 446.8100n 0.000090 446.8200n 0.000118 446.8300n 0.000147 446.8400n 0.000174
+ 446.8500n 0.000201 446.8600n 0.000227 446.8700n 0.000253 446.8800n 0.000278 446.8900n 0.000302 446.9000n 0.000325 446.9100n 0.000348 446.9200n 0.000369 446.9300n 0.000390 446.9400n 0.000411 446.9500n 0.000430 446.9600n 0.000448 446.9700n 0.000466 446.9800n 0.000483 446.9900n 0.000499
+ 447.0000n 0.000514 447.0100n 0.000528 447.0200n 0.000541 447.0300n 0.000553 447.0400n 0.000564 447.0500n 0.000575 447.0600n 0.000584 447.0700n 0.000593 447.0800n 0.000600 447.0900n 0.000607 447.1000n 0.000612 447.1100n 0.000617 447.1200n 0.000620 447.1300n 0.000623 447.1400n 0.000624
+ 447.1500n 0.000625 447.1600n 0.000624 447.1700n 0.000623 447.1800n 0.000620 447.1900n 0.000617 447.2000n 0.000613 447.2100n 0.000607 447.2200n 0.000601 447.2300n 0.000594 447.2400n 0.000585 447.2500n 0.000576 447.2600n 0.000566 447.2700n 0.000555 447.2800n 0.000543 447.2900n 0.000530
+ 447.3000n 0.000516 447.3100n 0.000501 447.3200n 0.000485 447.3300n 0.000468 447.3400n 0.000451 447.3500n 0.000433 447.3600n 0.000413 447.3700n 0.000393 447.3800n 0.000373 447.3900n 0.000351 447.4000n 0.000329 447.4100n 0.000305 447.4200n 0.000282 447.4300n 0.000257 447.4400n 0.000232
+ 447.4500n 0.000206 447.4600n 0.000179 447.4700n 0.000152 447.4800n 0.000124 447.4900n 0.000095 447.5000n 0.000066 447.5100n 0.000036 447.5200n 0.000006 447.5300n -0.000025 447.5400n -0.000056 447.5500n -0.000087 447.5600n -0.000120 447.5700n -0.000152 447.5800n -0.000185 447.5900n -0.000218
+ 447.6000n -0.000252 447.6100n -0.000286 447.6200n -0.000320 447.6300n -0.000355 447.6400n -0.000389 447.6500n -0.000424 447.6600n -0.000459 447.6700n -0.000495 447.6800n -0.000530 447.6900n -0.000565 447.7000n -0.000601 447.7100n -0.000637 447.7200n -0.000672 447.7300n -0.000708 447.7400n -0.000743
+ 447.7500n -0.000779 447.7600n -0.000814 447.7700n -0.000850 447.7800n -0.000885 447.7900n -0.000920 447.8000n -0.000955 447.8100n -0.000989 447.8200n -0.001024 447.8300n -0.001058 447.8400n -0.001091 447.8500n -0.001125 447.8600n -0.001158 447.8700n -0.001191 447.8800n -0.001223 447.8900n -0.001255
+ 447.9000n -0.001286 447.9100n -0.001317 447.9200n -0.001348 447.9300n -0.001378 447.9400n -0.001407 447.9500n -0.001436 447.9600n -0.001464 447.9700n -0.001492 447.9800n -0.001519 447.9900n -0.001545 448.0000n -0.001571 448.0100n -0.001596 448.0200n -0.001620 448.0300n -0.001644 448.0400n -0.001667
+ 448.0500n -0.001689 448.0600n -0.001710 448.0700n -0.001731 448.0800n -0.001751 448.0900n -0.001770 448.1000n -0.001788 448.1100n -0.001805 448.1200n -0.001821 448.1300n -0.001837 448.1400n -0.001851 448.1500n -0.001865 448.1600n -0.001878 448.1700n -0.001890 448.1800n -0.001901 448.1900n -0.001911
+ 448.2000n -0.001920 448.2100n -0.001929 448.2200n -0.001936 448.2300n -0.001942 448.2400n -0.001947 448.2500n -0.001952 448.2600n -0.001955 448.2700n -0.001958 448.2800n -0.001959 448.2900n -0.001960 448.3000n -0.001959 448.3100n -0.001958 448.3200n -0.001956 448.3300n -0.001952 448.3400n -0.001948
+ 448.3500n -0.001943 448.3600n -0.001936 448.3700n -0.001929 448.3800n -0.001921 448.3900n -0.001912 448.4000n -0.001902 448.4100n -0.001891 448.4200n -0.001879 448.4300n -0.001867 448.4400n -0.001853 448.4500n -0.001838 448.4600n -0.001823 448.4700n -0.001807 448.4800n -0.001790 448.4900n -0.001772
+ 448.5000n -0.001753 448.5100n -0.001733 448.5200n -0.001713 448.5300n -0.001691 448.5400n -0.001669 448.5500n -0.001647 448.5600n -0.001623 448.5700n -0.001599 448.5800n -0.001574 448.5900n -0.001548 448.6000n -0.001522 448.6100n -0.001495 448.6200n -0.001467 448.6300n -0.001439 448.6400n -0.001410
+ 448.6500n -0.001381 448.6600n -0.001351 448.6700n -0.001321 448.6800n -0.001290 448.6900n -0.001258 448.7000n -0.001226 448.7100n -0.001194 448.7200n -0.001161 448.7300n -0.001128 448.7400n -0.001094 448.7500n -0.001060 448.7600n -0.001026 448.7700n -0.000991 448.7800n -0.000956 448.7900n -0.000921
+ 448.8000n -0.000886 448.8100n -0.000850 448.8200n -0.000814 448.8300n -0.000778 448.8400n -0.000742 448.8500n -0.000706 448.8600n -0.000669 448.8700n -0.000633 448.8800n -0.000596 448.8900n -0.000560 448.9000n -0.000523 448.9100n -0.000487 448.9200n -0.000450 448.9300n -0.000414 448.9400n -0.000378
+ 448.9500n -0.000341 448.9600n -0.000305 448.9700n -0.000269 448.9800n -0.000234 448.9900n -0.000198 449.0000n -0.000163 449.0100n -0.000128 449.0200n -0.000093 449.0300n -0.000059 449.0400n -0.000025 449.0500n 0.000009 449.0600n 0.000043 449.0700n 0.000076 449.0800n 0.000109 449.0900n 0.000141
+ 449.1000n 0.000173 449.1100n 0.000204 449.1200n 0.000235 449.1300n 0.000266 449.1400n 0.000296 449.1500n 0.000325 449.1600n 0.000354 449.1700n 0.000382 449.1800n 0.000410 449.1900n 0.000437 449.2000n 0.000464 449.2100n 0.000490 449.2200n 0.000515 449.2300n 0.000540 449.2400n 0.000564
+ 449.2500n 0.000588 449.2600n 0.000611 449.2700n 0.000633 449.2800n 0.000654 449.2900n 0.000675 449.3000n 0.000695 449.3100n 0.000714 449.3200n 0.000733 449.3300n 0.000751 449.3400n 0.000768 449.3500n 0.000784 449.3600n 0.000800 449.3700n 0.000815 449.3800n 0.000829 449.3900n 0.000842
+ 449.4000n 0.000855 449.4100n 0.000867 449.4200n 0.000878 449.4300n 0.000888 449.4400n 0.000898 449.4500n 0.000907 449.4600n 0.000915 449.4700n 0.000922 449.4800n 0.000928 449.4900n 0.000934 449.5000n 0.000939 449.5100n 0.000943 449.5200n 0.000947 449.5300n 0.000950 449.5400n 0.000952
+ 449.5500n 0.000953 449.5600n 0.000954 449.5700n 0.000953 449.5800n 0.000953 449.5900n 0.000951 449.6000n 0.000949 449.6100n 0.000946 449.6200n 0.000942 449.6300n 0.000938 449.6400n 0.000933 449.6500n 0.000927 449.6600n 0.000921 449.6700n 0.000914 449.6800n 0.000907 449.6900n 0.000899
+ 449.7000n 0.000890 449.7100n 0.000881 449.7200n 0.000871 449.7300n 0.000861 449.7400n 0.000850 449.7500n 0.000839 449.7600n 0.000827 449.7700n 0.000815 449.7800n 0.000802 449.7900n 0.000789 449.8000n 0.000775 449.8100n 0.000761 449.8200n 0.000747 449.8300n 0.000732 449.8400n 0.000717
+ 449.8500n 0.000701 449.8600n 0.000685 449.8700n 0.000669 449.8800n 0.000653 449.8900n 0.000636 449.9000n 0.000619 449.9100n 0.000602 449.9200n 0.000584 449.9300n 0.000567 449.9400n 0.000549 449.9500n 0.000531 449.9600n 0.000513 449.9700n 0.000494 449.9800n 0.000476 449.9900n 0.000458
+ 450.0000n 0.000439 450.0100n 0.000421 450.0200n 0.000402 450.0300n 0.000383 450.0400n 0.000365 450.0500n 0.000346 450.0600n 0.000328 450.0700n 0.000309 450.0800n 0.000291 450.0900n 0.000273 450.1000n 0.000254 450.1100n 0.000236 450.1200n 0.000218 450.1300n 0.000201 450.1400n 0.000183
+ 450.1500n 0.000166 450.1600n 0.000149 450.1700n 0.000132 450.1800n 0.000115 450.1900n 0.000099 450.2000n 0.000083 450.2100n 0.000067 450.2200n 0.000051 450.2300n 0.000036 450.2400n 0.000021 450.2500n 0.000007 450.2600n -0.000007 450.2700n -0.000021 450.2800n -0.000035 450.2900n -0.000047
+ 450.3000n -0.000060 450.3100n -0.000072 450.3200n -0.000084 450.3300n -0.000095 450.3400n -0.000106 450.3500n -0.000116 450.3600n -0.000126 450.3700n -0.000135 450.3800n -0.000144 450.3900n -0.000153 450.4000n -0.000161 450.4100n -0.000168 450.4200n -0.000175 450.4300n -0.000181 450.4400n -0.000187
+ 450.4500n -0.000192 450.4600n -0.000197 450.4700n -0.000201 450.4800n -0.000204 450.4900n -0.000208 450.5000n -0.000210 450.5100n -0.000212 450.5200n -0.000213 450.5300n -0.000214 450.5400n -0.000215 450.5500n -0.000214 450.5600n -0.000213 450.5700n -0.000212 450.5800n -0.000210 450.5900n -0.000208
+ 450.6000n -0.000204 450.6100n -0.000201 450.6200n -0.000197 450.6300n -0.000192 450.6400n -0.000187 450.6500n -0.000181 450.6600n -0.000175 450.6700n -0.000168 450.6800n -0.000161 450.6900n -0.000153 450.7000n -0.000144 450.7100n -0.000136 450.7200n -0.000126 450.7300n -0.000116 450.7400n -0.000106
+ 450.7500n -0.000095 450.7600n -0.000084 450.7700n -0.000073 450.7800n -0.000061 450.7900n -0.000048 450.8000n -0.000035 450.8100n -0.000022 450.8200n -0.000008 450.8300n 0.000006 450.8400n 0.000020 450.8500n 0.000035 450.8600n 0.000050 450.8700n 0.000066 450.8800n 0.000082 450.8900n 0.000098
+ 450.9000n 0.000114 450.9100n 0.000131 450.9200n 0.000147 450.9300n 0.000165 450.9400n 0.000182 450.9500n 0.000200 450.9600n 0.000217 450.9700n 0.000235 450.9800n 0.000253 450.9900n 0.000272 451.0000n 0.000290 451.0100n 0.000309 451.0200n 0.000327 451.0300n 0.000346 451.0400n 0.000365
+ 451.0500n 0.000384 451.0600n 0.000403 451.0700n 0.000422 451.0800n 0.000441 451.0900n 0.000460 451.1000n 0.000479 451.1100n 0.000498 451.1200n 0.000517 451.1300n 0.000535 451.1400n 0.000554 451.1500n 0.000573 451.1600n 0.000591 451.1700n 0.000610 451.1800n 0.000628 451.1900n 0.000646
+ 451.2000n 0.000664 451.2100n 0.000682 451.2200n 0.000699 451.2300n 0.000716 451.2400n 0.000733 451.2500n 0.000750 451.2600n 0.000767 451.2700n 0.000783 451.2800n 0.000799 451.2900n 0.000814 451.3000n 0.000830 451.3100n 0.000845 451.3200n 0.000859 451.3300n 0.000874 451.3400n 0.000888
+ 451.3500n 0.000901 451.3600n 0.000914 451.3700n 0.000927 451.3800n 0.000939 451.3900n 0.000951 451.4000n 0.000962 451.4100n 0.000973 451.4200n 0.000984 451.4300n 0.000994 451.4400n 0.001003 451.4500n 0.001012 451.4600n 0.001021 451.4700n 0.001029 451.4800n 0.001036 451.4900n 0.001043
+ 451.5000n 0.001050 451.5100n 0.001056 451.5200n 0.001061 451.5300n 0.001066 451.5400n 0.001070 451.5500n 0.001074 451.5600n 0.001077 451.5700n 0.001080 451.5800n 0.001082 451.5900n 0.001083 451.6000n 0.001084 451.6100n 0.001084 451.6200n 0.001084 451.6300n 0.001083 451.6400n 0.001082
+ 451.6500n 0.001080 451.6600n 0.001077 451.6700n 0.001074 451.6800n 0.001070 451.6900n 0.001065 451.7000n 0.001060 451.7100n 0.001055 451.7200n 0.001048 451.7300n 0.001042 451.7400n 0.001034 451.7500n 0.001026 451.7600n 0.001018 451.7700n 0.001009 451.7800n 0.000999 451.7900n 0.000989
+ 451.8000n 0.000978 451.8100n 0.000967 451.8200n 0.000955 451.8300n 0.000943 451.8400n 0.000930 451.8500n 0.000916 451.8600n 0.000902 451.8700n 0.000888 451.8800n 0.000873 451.8900n 0.000858 451.9000n 0.000842 451.9100n 0.000825 451.9200n 0.000808 451.9300n 0.000791 451.9400n 0.000773
+ 451.9500n 0.000755 451.9600n 0.000736 451.9700n 0.000717 451.9800n 0.000698 451.9900n 0.000678 452.0000n 0.000658 452.0100n 0.000638 452.0200n 0.000617 452.0300n 0.000595 452.0400n 0.000574 452.0500n 0.000552 452.0600n 0.000530 452.0700n 0.000507 452.0800n 0.000485 452.0900n 0.000462
+ 452.1000n 0.000438 452.1100n 0.000415 452.1200n 0.000391 452.1300n 0.000368 452.1400n 0.000344 452.1500n 0.000319 452.1600n 0.000295 452.1700n 0.000270 452.1800n 0.000246 452.1900n 0.000221 452.2000n 0.000196 452.2100n 0.000171 452.2200n 0.000146 452.2300n 0.000121 452.2400n 0.000096
+ 452.2500n 0.000071 452.2600n 0.000046 452.2700n 0.000021 452.2800n -0.000004 452.2900n -0.000029 452.3000n -0.000054 452.3100n -0.000078 452.3200n -0.000103 452.3300n -0.000128 452.3400n -0.000152 452.3500n -0.000177 452.3600n -0.000201 452.3700n -0.000225 452.3800n -0.000249 452.3900n -0.000272
+ 452.4000n -0.000296 452.4100n -0.000319 452.4200n -0.000342 452.4300n -0.000365 452.4400n -0.000387 452.4500n -0.000409 452.4600n -0.000431 452.4700n -0.000453 452.4800n -0.000474 452.4900n -0.000495 452.5000n -0.000515 452.5100n -0.000536 452.5200n -0.000555 452.5300n -0.000575 452.5400n -0.000594
+ 452.5500n -0.000612 452.5600n -0.000631 452.5700n -0.000648 452.5800n -0.000666 452.5900n -0.000682 452.6000n -0.000699 452.6100n -0.000715 452.6200n -0.000730 452.6300n -0.000745 452.6400n -0.000759 452.6500n -0.000773 452.6600n -0.000787 452.6700n -0.000799 452.6800n -0.000812 452.6900n -0.000823
+ 452.7000n -0.000835 452.7100n -0.000845 452.7200n -0.000855 452.7300n -0.000865 452.7400n -0.000874 452.7500n -0.000882 452.7600n -0.000890 452.7700n -0.000897 452.7800n -0.000904 452.7900n -0.000910 452.8000n -0.000915 452.8100n -0.000920 452.8200n -0.000924 452.8300n -0.000927 452.8400n -0.000930
+ 452.8500n -0.000933 452.8600n -0.000934 452.8700n -0.000936 452.8800n -0.000936 452.8900n -0.000936 452.9000n -0.000935 452.9100n -0.000934 452.9200n -0.000932 452.9300n -0.000929 452.9400n -0.000926 452.9500n -0.000922 452.9600n -0.000918 452.9700n -0.000913 452.9800n -0.000907 452.9900n -0.000901
+ 453.0000n -0.000894 453.0100n -0.000887 453.0200n -0.000879 453.0300n -0.000870 453.0400n -0.000861 453.0500n -0.000851 453.0600n -0.000841 453.0700n -0.000830 453.0800n -0.000819 453.0900n -0.000807 453.1000n -0.000795 453.1100n -0.000782 453.1200n -0.000768 453.1300n -0.000754 453.1400n -0.000740
+ 453.1500n -0.000725 453.1600n -0.000710 453.1700n -0.000694 453.1800n -0.000677 453.1900n -0.000661 453.2000n -0.000644 453.2100n -0.000626 453.2200n -0.000608 453.2300n -0.000589 453.2400n -0.000571 453.2500n -0.000552 453.2600n -0.000532 453.2700n -0.000512 453.2800n -0.000492 453.2900n -0.000471
+ 453.3000n -0.000450 453.3100n -0.000429 453.3200n -0.000408 453.3300n -0.000386 453.3400n -0.000364 453.3500n -0.000342 453.3600n -0.000320 453.3700n -0.000297 453.3800n -0.000274 453.3900n -0.000251 453.4000n -0.000228 453.4100n -0.000204 453.4200n -0.000181 453.4300n -0.000157 453.4400n -0.000134
+ 453.4500n -0.000110 453.4600n -0.000086 453.4700n -0.000062 453.4800n -0.000038 453.4900n -0.000014 453.5000n 0.000010 453.5100n 0.000034 453.5200n 0.000058 453.5300n 0.000082 453.5400n 0.000106 453.5500n 0.000130 453.5600n 0.000154 453.5700n 0.000178 453.5800n 0.000201 453.5900n 0.000225
+ 453.6000n 0.000248 453.6100n 0.000272 453.6200n 0.000295 453.6300n 0.000317 453.6400n 0.000340 453.6500n 0.000363 453.6600n 0.000385 453.6700n 0.000407 453.6800n 0.000429 453.6900n 0.000450 453.7000n 0.000471 453.7100n 0.000492 453.7200n 0.000513 453.7300n 0.000533 453.7400n 0.000553
+ 453.7500n 0.000572 453.7600n 0.000591 453.7700n 0.000610 453.7800n 0.000628 453.7900n 0.000646 453.8000n 0.000664 453.8100n 0.000681 453.8200n 0.000698 453.8300n 0.000714 453.8400n 0.000730 453.8500n 0.000745 453.8600n 0.000760 453.8700n 0.000774 453.8800n 0.000788 453.8900n 0.000801
+ 453.9000n 0.000814 453.9100n 0.000826 453.9200n 0.000838 453.9300n 0.000849 453.9400n 0.000859 453.9500n 0.000869 453.9600n 0.000879 453.9700n 0.000888 453.9800n 0.000896 453.9900n 0.000903 454.0000n 0.000910 454.0100n 0.000917 454.0200n 0.000923 454.0300n 0.000928 454.0400n 0.000932
+ 454.0500n 0.000936 454.0600n 0.000939 454.0700n 0.000942 454.0800n 0.000944 454.0900n 0.000945 454.1000n 0.000946 454.1100n 0.000946 454.1200n 0.000946 454.1300n 0.000944 454.1400n 0.000942 454.1500n 0.000940 454.1600n 0.000937 454.1700n 0.000933 454.1800n 0.000928 454.1900n 0.000923
+ 454.2000n 0.000917 454.2100n 0.000911 454.2200n 0.000903 454.2300n 0.000896 454.2400n 0.000887 454.2500n 0.000878 454.2600n 0.000868 454.2700n 0.000858 454.2800n 0.000847 454.2900n 0.000835 454.3000n 0.000823 454.3100n 0.000810 454.3200n 0.000797 454.3300n 0.000783 454.3400n 0.000768
+ 454.3500n 0.000753 454.3600n 0.000737 454.3700n 0.000721 454.3800n 0.000704 454.3900n 0.000687 454.4000n 0.000669 454.4100n 0.000650 454.4200n 0.000631 454.4300n 0.000612 454.4400n 0.000592 454.4500n 0.000571 454.4600n 0.000550 454.4700n 0.000529 454.4800n 0.000507 454.4900n 0.000484
+ 454.5000n 0.000461 454.5100n 0.000438 454.5200n 0.000415 454.5300n 0.000391 454.5400n 0.000366 454.5500n 0.000341 454.5600n 0.000316 454.5700n 0.000291 454.5800n 0.000265 454.5900n 0.000239 454.6000n 0.000213 454.6100n 0.000186 454.6200n 0.000159 454.6300n 0.000132 454.6400n 0.000105
+ 454.6500n 0.000077 454.6600n 0.000049 454.6700n 0.000021 454.6800n -0.000007 454.6900n -0.000035 454.7000n -0.000063 454.7100n -0.000092 454.7200n -0.000120 454.7300n -0.000149 454.7400n -0.000178 454.7500n -0.000206 454.7600n -0.000235 454.7700n -0.000264 454.7800n -0.000292 454.7900n -0.000321
+ 454.8000n -0.000350 454.8100n -0.000378 454.8200n -0.000407 454.8300n -0.000435 454.8400n -0.000463 454.8500n -0.000491 454.8600n -0.000519 454.8700n -0.000547 454.8800n -0.000574 454.8900n -0.000602 454.9000n -0.000629 454.9100n -0.000656 454.9200n -0.000682 454.9300n -0.000708 454.9400n -0.000734
+ 454.9500n -0.000760 454.9600n -0.000785 454.9700n -0.000810 454.9800n -0.000834 454.9900n -0.000858 455.0000n -0.000882 455.0100n -0.000905 455.0200n -0.000928 455.0300n -0.000950 455.0400n -0.000972 455.0500n -0.000993 455.0600n -0.001014 455.0700n -0.001035 455.0800n -0.001054 455.0900n -0.001073
+ 455.1000n -0.001092 455.1100n -0.001110 455.1200n -0.001127 455.1300n -0.001144 455.1400n -0.001160 455.1500n -0.001175 455.1600n -0.001190 455.1700n -0.001204 455.1800n -0.001218 455.1900n -0.001230 455.2000n -0.001242 455.2100n -0.001253 455.2200n -0.001264 455.2300n -0.001274 455.2400n -0.001283
+ 455.2500n -0.001291 455.2600n -0.001298 455.2700n -0.001305 455.2800n -0.001311 455.2900n -0.001315 455.3000n -0.001320 455.3100n -0.001323 455.3200n -0.001325 455.3300n -0.001327 455.3400n -0.001328 455.3500n -0.001328 455.3600n -0.001327 455.3700n -0.001325 455.3800n -0.001322 455.3900n -0.001319
+ 455.4000n -0.001314 455.4100n -0.001309 455.4200n -0.001302 455.4300n -0.001295 455.4400n -0.001287 455.4500n -0.001278 455.4600n -0.001268 455.4700n -0.001257 455.4800n -0.001246 455.4900n -0.001233 455.5000n -0.001220 455.5100n -0.001205 455.5200n -0.001190 455.5300n -0.001174 455.5400n -0.001157
+ 455.5500n -0.001139 455.5600n -0.001120 455.5700n -0.001100 455.5800n -0.001079 455.5900n -0.001058 455.6000n -0.001035 455.6100n -0.001012 455.6200n -0.000988 455.6300n -0.000963 455.6400n -0.000937 455.6500n -0.000910 455.6600n -0.000883 455.6700n -0.000854 455.6800n -0.000825 455.6900n -0.000795
+ 455.7000n -0.000764 455.7100n -0.000733 455.7200n -0.000700 455.7300n -0.000667 455.7400n -0.000633 455.7500n -0.000599 455.7600n -0.000563 455.7700n -0.000527 455.7800n -0.000490 455.7900n -0.000453 455.8000n -0.000415 455.8100n -0.000376 455.8200n -0.000337 455.8300n -0.000297 455.8400n -0.000256
+ 455.8500n -0.000215 455.8600n -0.000173 455.8700n -0.000130 455.8800n -0.000087 455.8900n -0.000044 455.9000n 0.000000 455.9100n 0.000045 455.9200n 0.000090 455.9300n 0.000135 455.9400n 0.000181 455.9500n 0.000227 455.9600n 0.000274 455.9700n 0.000321 455.9800n 0.000369 455.9900n 0.000416
+ 456.0000n 0.000464 456.0100n 0.000513 456.0200n 0.000562 456.0300n 0.000611 456.0400n 0.000660 456.0500n 0.000709 456.0600n 0.000759 456.0700n 0.000808 456.0800n 0.000858 456.0900n 0.000908 456.1000n 0.000959 456.1100n 0.001009 456.1200n 0.001059 456.1300n 0.001110 456.1400n 0.001160
+ 456.1500n 0.001210 456.1600n 0.001261 456.1700n 0.001311 456.1800n 0.001361 456.1900n 0.001411 456.2000n 0.001461 456.2100n 0.001511 456.2200n 0.001561 456.2300n 0.001611 456.2400n 0.001660 456.2500n 0.001709 456.2600n 0.001758 456.2700n 0.001807 456.2800n 0.001855 456.2900n 0.001903
+ 456.3000n 0.001951 456.3100n 0.001998 456.3200n 0.002045 456.3300n 0.002092 456.3400n 0.002138 456.3500n 0.002183 456.3600n 0.002229 456.3700n 0.002273 456.3800n 0.002318 456.3900n 0.002361 456.4000n 0.002405 456.4100n 0.002447 456.4200n 0.002489 456.4300n 0.002531 456.4400n 0.002572
+ 456.4500n 0.002612 456.4600n 0.002652 456.4700n 0.002691 456.4800n 0.002729 456.4900n 0.002767 456.5000n 0.002803 456.5100n 0.002840 456.5200n 0.002875 456.5300n 0.002910 456.5400n 0.002943 456.5500n 0.002976 456.5600n 0.003009 456.5700n 0.003040 456.5800n 0.003071 456.5900n 0.003101
+ 456.6000n 0.003129 456.6100n 0.003158 456.6200n 0.003185 456.6300n 0.003211 456.6400n 0.003236 456.6500n 0.003261 456.6600n 0.003284 456.6700n 0.003307 456.6800n 0.003329 456.6900n 0.003349 456.7000n 0.003369 456.7100n 0.003388 456.7200n 0.003406 456.7300n 0.003423 456.7400n 0.003439
+ 456.7500n 0.003454 456.7600n 0.003468 456.7700n 0.003480 456.7800n 0.003492 456.7900n 0.003503 456.8000n 0.003513 456.8100n 0.003522 456.8200n 0.003530 456.8300n 0.003537 456.8400n 0.003543 456.8500n 0.003548 456.8600n 0.003552 456.8700n 0.003555 456.8800n 0.003557 456.8900n 0.003558
+ 456.9000n 0.003557 456.9100n 0.003556 456.9200n 0.003554 456.9300n 0.003551 456.9400n 0.003547 456.9500n 0.003542 456.9600n 0.003536 456.9700n 0.003529 456.9800n 0.003521 456.9900n 0.003512 457.0000n 0.003502 457.0100n 0.003492 457.0200n 0.003480 457.0300n 0.003467 457.0400n 0.003454
+ 457.0500n 0.003439 457.0600n 0.003424 457.0700n 0.003408 457.0800n 0.003390 457.0900n 0.003372 457.1000n 0.003354 457.1100n 0.003334 457.1200n 0.003313 457.1300n 0.003292 457.1400n 0.003270 457.1500n 0.003247 457.1600n 0.003223 457.1700n 0.003199 457.1800n 0.003174 457.1900n 0.003148
+ 457.2000n 0.003121 457.2100n 0.003094 457.2200n 0.003066 457.2300n 0.003037 457.2400n 0.003008 457.2500n 0.002978 457.2600n 0.002948 457.2700n 0.002916 457.2800n 0.002885 457.2900n 0.002852 457.3000n 0.002820 457.3100n 0.002786 457.3200n 0.002752 457.3300n 0.002718 457.3400n 0.002683
+ 457.3500n 0.002648 457.3600n 0.002612 457.3700n 0.002576 457.3800n 0.002540 457.3900n 0.002503 457.4000n 0.002465 457.4100n 0.002428 457.4200n 0.002390 457.4300n 0.002352 457.4400n 0.002313 457.4500n 0.002274 457.4600n 0.002235 457.4700n 0.002196 457.4800n 0.002157 457.4900n 0.002117
+ 457.5000n 0.002077 457.5100n 0.002037 457.5200n 0.001997 457.5300n 0.001957 457.5400n 0.001917 457.5500n 0.001877 457.5600n 0.001837 457.5700n 0.001796 457.5800n 0.001756 457.5900n 0.001716 457.6000n 0.001675 457.6100n 0.001635 457.6200n 0.001595 457.6300n 0.001555 457.6400n 0.001515
+ 457.6500n 0.001475 457.6600n 0.001435 457.6700n 0.001396 457.6800n 0.001357 457.6900n 0.001317 457.7000n 0.001279 457.7100n 0.001240 457.7200n 0.001201 457.7300n 0.001163 457.7400n 0.001125 457.7500n 0.001088 457.7600n 0.001050 457.7700n 0.001013 457.7800n 0.000977 457.7900n 0.000941
+ 457.8000n 0.000905 457.8100n 0.000869 457.8200n 0.000834 457.8300n 0.000799 457.8400n 0.000765 457.8500n 0.000731 457.8600n 0.000698 457.8700n 0.000665 457.8800n 0.000633 457.8900n 0.000601 457.9000n 0.000569 457.9100n 0.000539 457.9200n 0.000508 457.9300n 0.000478 457.9400n 0.000449
+ 457.9500n 0.000420 457.9600n 0.000392 457.9700n 0.000365 457.9800n 0.000337 457.9900n 0.000311 458.0000n 0.000285 458.0100n 0.000260 458.0200n 0.000235 458.0300n 0.000211 458.0400n 0.000188 458.0500n 0.000165 458.0600n 0.000143 458.0700n 0.000121 458.0800n 0.000101 458.0900n 0.000080
+ 458.1000n 0.000061 458.1100n 0.000042 458.1200n 0.000024 458.1300n 0.000006 458.1400n -0.000011 458.1500n -0.000027 458.1600n -0.000043 458.1700n -0.000058 458.1800n -0.000072 458.1900n -0.000086 458.2000n -0.000099 458.2100n -0.000111 458.2200n -0.000123 458.2300n -0.000134 458.2400n -0.000144
+ 458.2500n -0.000154 458.2600n -0.000163 458.2700n -0.000171 458.2800n -0.000179 458.2900n -0.000186 458.3000n -0.000192 458.3100n -0.000198 458.3200n -0.000203 458.3300n -0.000208 458.3400n -0.000212 458.3500n -0.000215 458.3600n -0.000218 458.3700n -0.000220 458.3800n -0.000221 458.3900n -0.000222
+ 458.4000n -0.000222 458.4100n -0.000222 458.4200n -0.000221 458.4300n -0.000219 458.4400n -0.000217 458.4500n -0.000215 458.4600n -0.000211 458.4700n -0.000208 458.4800n -0.000203 458.4900n -0.000199 458.5000n -0.000193 458.5100n -0.000187 458.5200n -0.000181 458.5300n -0.000174 458.5400n -0.000167
+ 458.5500n -0.000159 458.5600n -0.000151 458.5700n -0.000143 458.5800n -0.000133 458.5900n -0.000124 458.6000n -0.000114 458.6100n -0.000104 458.6200n -0.000093 458.6300n -0.000082 458.6400n -0.000070 458.6500n -0.000058 458.6600n -0.000046 458.6700n -0.000034 458.6800n -0.000021 458.6900n -0.000007
+ 458.7000n 0.000006 458.7100n 0.000020 458.7200n 0.000034 458.7300n 0.000049 458.7400n 0.000063 458.7500n 0.000078 458.7600n 0.000093 458.7700n 0.000109 458.7800n 0.000125 458.7900n 0.000140 458.8000n 0.000157 458.8100n 0.000173 458.8200n 0.000189 458.8300n 0.000206 458.8400n 0.000223
+ 458.8500n 0.000240 458.8600n 0.000257 458.8700n 0.000274 458.8800n 0.000291 458.8900n 0.000309 458.9000n 0.000326 458.9100n 0.000344 458.9200n 0.000361 458.9300n 0.000379 458.9400n 0.000397 458.9500n 0.000415 458.9600n 0.000433 458.9700n 0.000451 458.9800n 0.000469 458.9900n 0.000486
+ 459.0000n 0.000504 459.0100n 0.000522 459.0200n 0.000540 459.0300n 0.000558 459.0400n 0.000576 459.0500n 0.000594 459.0600n 0.000611 459.0700n 0.000629 459.0800n 0.000647 459.0900n 0.000664 459.1000n 0.000682 459.1100n 0.000699 459.1200n 0.000716 459.1300n 0.000733 459.1400n 0.000750
+ 459.1500n 0.000767 459.1600n 0.000784 459.1700n 0.000801 459.1800n 0.000817 459.1900n 0.000833 459.2000n 0.000849 459.2100n 0.000865 459.2200n 0.000881 459.2300n 0.000897 459.2400n 0.000912 459.2500n 0.000928 459.2600n 0.000943 459.2700n 0.000958 459.2800n 0.000972 459.2900n 0.000987
+ 459.3000n 0.001001 459.3100n 0.001015 459.3200n 0.001029 459.3300n 0.001043 459.3400n 0.001056 459.3500n 0.001069 459.3600n 0.001082 459.3700n 0.001095 459.3800n 0.001107 459.3900n 0.001120 459.4000n 0.001132 459.4100n 0.001143 459.4200n 0.001155 459.4300n 0.001166 459.4400n 0.001177
+ 459.4500n 0.001188 459.4600n 0.001198 459.4700n 0.001208 459.4800n 0.001218 459.4900n 0.001228 459.5000n 0.001237 459.5100n 0.001246 459.5200n 0.001255 459.5300n 0.001264 459.5400n 0.001272 459.5500n 0.001280 459.5600n 0.001288 459.5700n 0.001296 459.5800n 0.001303 459.5900n 0.001310
+ 459.6000n 0.001316 459.6100n 0.001323 459.6200n 0.001329 459.6300n 0.001335 459.6400n 0.001340 459.6500n 0.001346 459.6600n 0.001351 459.6700n 0.001355 459.6800n 0.001360 459.6900n 0.001364 459.7000n 0.001368 459.7100n 0.001372 459.7200n 0.001375 459.7300n 0.001378 459.7400n 0.001381
+ 459.7500n 0.001384 459.7600n 0.001386 459.7700n 0.001388 459.7800n 0.001390 459.7900n 0.001391 459.8000n 0.001392 459.8100n 0.001393 459.8200n 0.001394 459.8300n 0.001394 459.8400n 0.001395 459.8500n 0.001395 459.8600n 0.001394 459.8700n 0.001394 459.8800n 0.001393 459.8900n 0.001392
+ 459.9000n 0.001391 459.9100n 0.001389 459.9200n 0.001387 459.9300n 0.001385 459.9400n 0.001383 459.9500n 0.001380 459.9600n 0.001377 459.9700n 0.001374 459.9800n 0.001371 459.9900n 0.001368 460.0000n 0.001364 460.0100n 0.001360 460.0200n 0.001356 460.0300n 0.001351 460.0400n 0.001347
+ 460.0500n 0.001342 460.0600n 0.001337 460.0700n 0.001332 460.0800n 0.001326 460.0900n 0.001321 460.1000n 0.001315 460.1100n 0.001308 460.1200n 0.001302 460.1300n 0.001296 460.1400n 0.001289 460.1500n 0.001282 460.1600n 0.001275 460.1700n 0.001268 460.1800n 0.001260 460.1900n 0.001252
+ 460.2000n 0.001244 460.2100n 0.001236 460.2200n 0.001228 460.2300n 0.001220 460.2400n 0.001211 460.2500n 0.001202 460.2600n 0.001193 460.2700n 0.001184 460.2800n 0.001175 460.2900n 0.001166 460.3000n 0.001156 460.3100n 0.001146 460.3200n 0.001136 460.3300n 0.001126 460.3400n 0.001116
+ 460.3500n 0.001106 460.3600n 0.001095 460.3700n 0.001085 460.3800n 0.001074 460.3900n 0.001063 460.4000n 0.001052 460.4100n 0.001041 460.4200n 0.001029 460.4300n 0.001018 460.4400n 0.001007 460.4500n 0.000995 460.4600n 0.000983 460.4700n 0.000971 460.4800n 0.000959 460.4900n 0.000947
+ 460.5000n 0.000935 460.5100n 0.000923 460.5200n 0.000911 460.5300n 0.000898 460.5400n 0.000886 460.5500n 0.000873 460.5600n 0.000861 460.5700n 0.000848 460.5800n 0.000835 460.5900n 0.000823 460.6000n 0.000810 460.6100n 0.000797 460.6200n 0.000784 460.6300n 0.000771 460.6400n 0.000758
+ 460.6500n 0.000745 460.6600n 0.000732 460.6700n 0.000719 460.6800n 0.000706 460.6900n 0.000693 460.7000n 0.000680 460.7100n 0.000667 460.7200n 0.000653 460.7300n 0.000640 460.7400n 0.000627 460.7500n 0.000614 460.7600n 0.000601 460.7700n 0.000588 460.7800n 0.000575 460.7900n 0.000563
+ 460.8000n 0.000550 460.8100n 0.000537 460.8200n 0.000524 460.8300n 0.000512 460.8400n 0.000499 460.8500n 0.000487 460.8600n 0.000474 460.8700n 0.000462 460.8800n 0.000450 460.8900n 0.000438 460.9000n 0.000426 460.9100n 0.000414 460.9200n 0.000402 460.9300n 0.000391 460.9400n 0.000379
+ 460.9500n 0.000368 460.9600n 0.000357 460.9700n 0.000346 460.9800n 0.000335 460.9900n 0.000324 461.0000n 0.000314 461.0100n 0.000303 461.0200n 0.000293 461.0300n 0.000283 461.0400n 0.000274 461.0500n 0.000264 461.0600n 0.000255 461.0700n 0.000246 461.0800n 0.000237 461.0900n 0.000228
+ 461.1000n 0.000220 461.1100n 0.000212 461.1200n 0.000204 461.1300n 0.000196 461.1400n 0.000189 461.1500n 0.000182 461.1600n 0.000175 461.1700n 0.000168 461.1800n 0.000162 461.1900n 0.000156 461.2000n 0.000150 461.2100n 0.000145 461.2200n 0.000140 461.2300n 0.000135 461.2400n 0.000131
+ 461.2500n 0.000127 461.2600n 0.000123 461.2700n 0.000120 461.2800n 0.000117 461.2900n 0.000114 461.3000n 0.000111 461.3100n 0.000109 461.3200n 0.000108 461.3300n 0.000106 461.3400n 0.000105 461.3500n 0.000105 461.3600n 0.000104 461.3700n 0.000105 461.3800n 0.000105 461.3900n 0.000106
+ 461.4000n 0.000107 461.4100n 0.000109 461.4200n 0.000111 461.4300n 0.000113 461.4400n 0.000116 461.4500n 0.000119 461.4600n 0.000123 461.4700n 0.000127 461.4800n 0.000131 461.4900n 0.000136 461.5000n 0.000141 461.5100n 0.000147 461.5200n 0.000153 461.5300n 0.000159 461.5400n 0.000166
+ 461.5500n 0.000173 461.5600n 0.000181 461.5700n 0.000189 461.5800n 0.000197 461.5900n 0.000206 461.6000n 0.000215 461.6100n 0.000225 461.6200n 0.000235 461.6300n 0.000245 461.6400n 0.000256 461.6500n 0.000267 461.6600n 0.000279 461.6700n 0.000290 461.6800n 0.000303 461.6900n 0.000315
+ 461.7000n 0.000328 461.7100n 0.000342 461.7200n 0.000355 461.7300n 0.000369 461.7400n 0.000384 461.7500n 0.000398 461.7600n 0.000413 461.7700n 0.000429 461.7800n 0.000444 461.7900n 0.000460 461.8000n 0.000477 461.8100n 0.000493 461.8200n 0.000510 461.8300n 0.000527 461.8400n 0.000545
+ 461.8500n 0.000562 461.8600n 0.000580 461.8700n 0.000599 461.8800n 0.000617 461.8900n 0.000636 461.9000n 0.000655 461.9100n 0.000674 461.9200n 0.000693 461.9300n 0.000713 461.9400n 0.000732 461.9500n 0.000752 461.9600n 0.000772 461.9700n 0.000793 461.9800n 0.000813 461.9900n 0.000833
+ 462.0000n 0.000854 462.0100n 0.000875 462.0200n 0.000896 462.0300n 0.000917 462.0400n 0.000938 462.0500n 0.000959 462.0600n 0.000980 462.0700n 0.001001 462.0800n 0.001022 462.0900n 0.001044 462.1000n 0.001065 462.1100n 0.001086 462.1200n 0.001107 462.1300n 0.001129 462.1400n 0.001150
+ 462.1500n 0.001171 462.1600n 0.001192 462.1700n 0.001213 462.1800n 0.001234 462.1900n 0.001255 462.2000n 0.001275 462.2100n 0.001296 462.2200n 0.001316 462.2300n 0.001336 462.2400n 0.001356 462.2500n 0.001376 462.2600n 0.001396 462.2700n 0.001415 462.2800n 0.001435 462.2900n 0.001454
+ 462.3000n 0.001473 462.3100n 0.001491 462.3200n 0.001509 462.3300n 0.001527 462.3400n 0.001545 462.3500n 0.001563 462.3600n 0.001580 462.3700n 0.001596 462.3800n 0.001613 462.3900n 0.001629 462.4000n 0.001645 462.4100n 0.001660 462.4200n 0.001675 462.4300n 0.001690 462.4400n 0.001704
+ 462.4500n 0.001718 462.4600n 0.001731 462.4700n 0.001744 462.4800n 0.001756 462.4900n 0.001769 462.5000n 0.001780 462.5100n 0.001791 462.5200n 0.001802 462.5300n 0.001812 462.5400n 0.001822 462.5500n 0.001831 462.5600n 0.001840 462.5700n 0.001848 462.5800n 0.001856 462.5900n 0.001863
+ 462.6000n 0.001869 462.6100n 0.001875 462.6200n 0.001881 462.6300n 0.001886 462.6400n 0.001890 462.6500n 0.001894 462.6600n 0.001898 462.6700n 0.001901 462.6800n 0.001903 462.6900n 0.001904 462.7000n 0.001905 462.7100n 0.001906 462.7200n 0.001906 462.7300n 0.001905 462.7400n 0.001904
+ 462.7500n 0.001902 462.7600n 0.001900 462.7700n 0.001897 462.7800n 0.001894 462.7900n 0.001889 462.8000n 0.001885 462.8100n 0.001880 462.8200n 0.001874 462.8300n 0.001867 462.8400n 0.001860 462.8500n 0.001853 462.8600n 0.001845 462.8700n 0.001836 462.8800n 0.001827 462.8900n 0.001817
+ 462.9000n 0.001807 462.9100n 0.001796 462.9200n 0.001785 462.9300n 0.001773 462.9400n 0.001761 462.9500n 0.001748 462.9600n 0.001735 462.9700n 0.001721 462.9800n 0.001706 462.9900n 0.001692 463.0000n 0.001676 463.0100n 0.001661 463.0200n 0.001644 463.0300n 0.001628 463.0400n 0.001611
+ 463.0500n 0.001593 463.0600n 0.001575 463.0700n 0.001557 463.0800n 0.001538 463.0900n 0.001519 463.1000n 0.001500 463.1100n 0.001480 463.1200n 0.001460 463.1300n 0.001439 463.1400n 0.001418 463.1500n 0.001397 463.1600n 0.001376 463.1700n 0.001354 463.1800n 0.001332 463.1900n 0.001310
+ 463.2000n 0.001287 463.2100n 0.001265 463.2200n 0.001242 463.2300n 0.001219 463.2400n 0.001196 463.2500n 0.001172 463.2600n 0.001148 463.2700n 0.001125 463.2800n 0.001101 463.2900n 0.001077 463.3000n 0.001053 463.3100n 0.001029 463.3200n 0.001004 463.3300n 0.000980 463.3400n 0.000956
+ 463.3500n 0.000932 463.3600n 0.000907 463.3700n 0.000883 463.3800n 0.000859 463.3900n 0.000834 463.4000n 0.000810 463.4100n 0.000786 463.4200n 0.000762 463.4300n 0.000738 463.4400n 0.000714 463.4500n 0.000691 463.4600n 0.000667 463.4700n 0.000644 463.4800n 0.000620 463.4900n 0.000597
+ 463.5000n 0.000574 463.5100n 0.000552 463.5200n 0.000529 463.5300n 0.000507 463.5400n 0.000485 463.5500n 0.000464 463.5600n 0.000442 463.5700n 0.000421 463.5800n 0.000400 463.5900n 0.000380 463.6000n 0.000360 463.6100n 0.000340 463.6200n 0.000320 463.6300n 0.000301 463.6400n 0.000282
+ 463.6500n 0.000264 463.6600n 0.000246 463.6700n 0.000229 463.6800n 0.000211 463.6900n 0.000195 463.7000n 0.000178 463.7100n 0.000162 463.7200n 0.000147 463.7300n 0.000132 463.7400n 0.000117 463.7500n 0.000103 463.7600n 0.000090 463.7700n 0.000077 463.7800n 0.000064 463.7900n 0.000052
+ 463.8000n 0.000040 463.8100n 0.000029 463.8200n 0.000018 463.8300n 0.000008 463.8400n -0.000002 463.8500n -0.000011 463.8600n -0.000019 463.8700n -0.000028 463.8800n -0.000035 463.8900n -0.000042 463.9000n -0.000049 463.9100n -0.000055 463.9200n -0.000060 463.9300n -0.000066 463.9400n -0.000070
+ 463.9500n -0.000074 463.9600n -0.000078 463.9700n -0.000081 463.9800n -0.000083 463.9900n -0.000085 464.0000n -0.000087 464.0100n -0.000088 464.0200n -0.000088 464.0300n -0.000088 464.0400n -0.000088 464.0500n -0.000087 464.0600n -0.000085 464.0700n -0.000084 464.0800n -0.000081 464.0900n -0.000078
+ 464.1000n -0.000075 464.1100n -0.000072 464.1200n -0.000068 464.1300n -0.000063 464.1400n -0.000058 464.1500n -0.000053 464.1600n -0.000047 464.1700n -0.000041 464.1800n -0.000035 464.1900n -0.000028 464.2000n -0.000021 464.2100n -0.000014 464.2200n -0.000006 464.2300n 0.000002 464.2400n 0.000010
+ 464.2500n 0.000019 464.2600n 0.000028 464.2700n 0.000037 464.2800n 0.000046 464.2900n 0.000056 464.3000n 0.000066 464.3100n 0.000076 464.3200n 0.000086 464.3300n 0.000097 464.3400n 0.000107 464.3500n 0.000118 464.3600n 0.000129 464.3700n 0.000140 464.3800n 0.000151 464.3900n 0.000162
+ 464.4000n 0.000174 464.4100n 0.000185 464.4200n 0.000196 464.4300n 0.000208 464.4400n 0.000219 464.4500n 0.000231 464.4600n 0.000242 464.4700n 0.000253 464.4800n 0.000265 464.4900n 0.000276 464.5000n 0.000287 464.5100n 0.000298 464.5200n 0.000309 464.5300n 0.000320 464.5400n 0.000331
+ 464.5500n 0.000342 464.5600n 0.000352 464.5700n 0.000362 464.5800n 0.000373 464.5900n 0.000382 464.6000n 0.000392 464.6100n 0.000402 464.6200n 0.000411 464.6300n 0.000420 464.6400n 0.000428 464.6500n 0.000437 464.6600n 0.000445 464.6700n 0.000453 464.6800n 0.000460 464.6900n 0.000467
+ 464.7000n 0.000474 464.7100n 0.000481 464.7200n 0.000487 464.7300n 0.000492 464.7400n 0.000498 464.7500n 0.000503 464.7600n 0.000507 464.7700n 0.000511 464.7800n 0.000515 464.7900n 0.000518 464.8000n 0.000521 464.8100n 0.000523 464.8200n 0.000525 464.8300n 0.000527 464.8400n 0.000528
+ 464.8500n 0.000528 464.8600n 0.000528 464.8700n 0.000528 464.8800n 0.000527 464.8900n 0.000525 464.9000n 0.000523 464.9100n 0.000521 464.9200n 0.000518 464.9300n 0.000514 464.9400n 0.000510 464.9500n 0.000505 464.9600n 0.000500 464.9700n 0.000495 464.9800n 0.000489 464.9900n 0.000482
+ 465.0000n 0.000475 465.0100n 0.000467 465.0200n 0.000459 465.0300n 0.000450 465.0400n 0.000441 465.0500n 0.000431 465.0600n 0.000421 465.0700n 0.000410 465.0800n 0.000398 465.0900n 0.000387 465.1000n 0.000374 465.1100n 0.000361 465.1200n 0.000348 465.1300n 0.000334 465.1400n 0.000320
+ 465.1500n 0.000305 465.1600n 0.000290 465.1700n 0.000274 465.1800n 0.000258 465.1900n 0.000241 465.2000n 0.000224 465.2100n 0.000207 465.2200n 0.000189 465.2300n 0.000170 465.2400n 0.000152 465.2500n 0.000132 465.2600n 0.000113 465.2700n 0.000093 465.2800n 0.000073 465.2900n 0.000052
+ 465.3000n 0.000031 465.3100n 0.000010 465.3200n -0.000012 465.3300n -0.000034 465.3400n -0.000056 465.3500n -0.000079 465.3600n -0.000102 465.3700n -0.000125 465.3800n -0.000148 465.3900n -0.000172 465.4000n -0.000195 465.4100n -0.000219 465.4200n -0.000244 465.4300n -0.000268 465.4400n -0.000292
+ 465.4500n -0.000317 465.4600n -0.000342 465.4700n -0.000367 465.4800n -0.000392 465.4900n -0.000417 465.5000n -0.000442 465.5100n -0.000468 465.5200n -0.000493 465.5300n -0.000518 465.5400n -0.000544 465.5500n -0.000569 465.5600n -0.000595 465.5700n -0.000620 465.5800n -0.000646 465.5900n -0.000671
+ 465.6000n -0.000696 465.6100n -0.000721 465.6200n -0.000746 465.6300n -0.000771 465.6400n -0.000796 465.6500n -0.000821 465.6600n -0.000846 465.6700n -0.000870 465.6800n -0.000894 465.6900n -0.000919 465.7000n -0.000943 465.7100n -0.000966 465.7200n -0.000990 465.7300n -0.001013 465.7400n -0.001036
+ 465.7500n -0.001059 465.7600n -0.001081 465.7700n -0.001103 465.7800n -0.001125 465.7900n -0.001147 465.8000n -0.001168 465.8100n -0.001189 465.8200n -0.001210 465.8300n -0.001230 465.8400n -0.001250 465.8500n -0.001270 465.8600n -0.001289 465.8700n -0.001308 465.8800n -0.001327 465.8900n -0.001345
+ 465.9000n -0.001362 465.9100n -0.001380 465.9200n -0.001397 465.9300n -0.001413 465.9400n -0.001429 465.9500n -0.001445 465.9600n -0.001460 465.9700n -0.001475 465.9800n -0.001489 465.9900n -0.001503 466.0000n -0.001517 466.0100n -0.001530 466.0200n -0.001542 466.0300n -0.001554 466.0400n -0.001566
+ 466.0500n -0.001577 466.0600n -0.001588 466.0700n -0.001598 466.0800n -0.001608 466.0900n -0.001618 466.1000n -0.001627 466.1100n -0.001635 466.1200n -0.001643 466.1300n -0.001651 466.1400n -0.001658 466.1500n -0.001665 466.1600n -0.001671 466.1700n -0.001677 466.1800n -0.001682 466.1900n -0.001687
+ 466.2000n -0.001692 466.2100n -0.001696 466.2200n -0.001700 466.2300n -0.001703 466.2400n -0.001706 466.2500n -0.001708 466.2600n -0.001710 466.2700n -0.001712 466.2800n -0.001713 466.2900n -0.001714 466.3000n -0.001715 466.3100n -0.001715 466.3200n -0.001715 466.3300n -0.001715 466.3400n -0.001714
+ 466.3500n -0.001713 466.3600n -0.001711 466.3700n -0.001710 466.3800n -0.001707 466.3900n -0.001705 466.4000n -0.001703 466.4100n -0.001700 466.4200n -0.001697 466.4300n -0.001693 466.4400n -0.001690 466.4500n -0.001686 466.4600n -0.001682 466.4700n -0.001678 466.4800n -0.001673 466.4900n -0.001669
+ 466.5000n -0.001664 466.5100n -0.001659 466.5200n -0.001654 466.5300n -0.001649 466.5400n -0.001644 466.5500n -0.001638 466.5600n -0.001633 466.5700n -0.001627 466.5800n -0.001622 466.5900n -0.001616 466.6000n -0.001610 466.6100n -0.001604 466.6200n -0.001599 466.6300n -0.001593 466.6400n -0.001587
+ 466.6500n -0.001581 466.6600n -0.001575 466.6700n -0.001569 466.6800n -0.001564 466.6900n -0.001558 466.7000n -0.001552 466.7100n -0.001547 466.7200n -0.001541 466.7300n -0.001535 466.7400n -0.001530 466.7500n -0.001525 466.7600n -0.001520 466.7700n -0.001515 466.7800n -0.001510 466.7900n -0.001505
+ 466.8000n -0.001500 466.8100n -0.001496 466.8200n -0.001491 466.8300n -0.001487 466.8400n -0.001483 466.8500n -0.001479 466.8600n -0.001476 466.8700n -0.001472 466.8800n -0.001469 466.8900n -0.001466 466.9000n -0.001463 466.9100n -0.001461 466.9200n -0.001458 466.9300n -0.001456 466.9400n -0.001454
+ 466.9500n -0.001453 466.9600n -0.001451 466.9700n -0.001450 466.9800n -0.001449 466.9900n -0.001448 467.0000n -0.001448 467.0100n -0.001447 467.0200n -0.001447 467.0300n -0.001447 467.0400n -0.001448 467.0500n -0.001449 467.0600n -0.001449 467.0700n -0.001451 467.0800n -0.001452 467.0900n -0.001454
+ 467.1000n -0.001456 467.1100n -0.001458 467.1200n -0.001460 467.1300n -0.001462 467.1400n -0.001465 467.1500n -0.001468 467.1600n -0.001471 467.1700n -0.001475 467.1800n -0.001478 467.1900n -0.001482 467.2000n -0.001486 467.2100n -0.001490 467.2200n -0.001495 467.2300n -0.001499 467.2400n -0.001504
+ 467.2500n -0.001509 467.2600n -0.001514 467.2700n -0.001519 467.2800n -0.001524 467.2900n -0.001530 467.3000n -0.001535 467.3100n -0.001541 467.3200n -0.001547 467.3300n -0.001552 467.3400n -0.001558 467.3500n -0.001564 467.3600n -0.001570 467.3700n -0.001577 467.3800n -0.001583 467.3900n -0.001589
+ 467.4000n -0.001595 467.4100n -0.001601 467.4200n -0.001607 467.4300n -0.001614 467.4400n -0.001620 467.4500n -0.001626 467.4600n -0.001632 467.4700n -0.001638 467.4800n -0.001644 467.4900n -0.001650 467.5000n -0.001655 467.5100n -0.001661 467.5200n -0.001667 467.5300n -0.001672 467.5400n -0.001677
+ 467.5500n -0.001682 467.5600n -0.001687 467.5700n -0.001692 467.5800n -0.001697 467.5900n -0.001701 467.6000n -0.001705 467.6100n -0.001709 467.6200n -0.001713 467.6300n -0.001717 467.6400n -0.001720 467.6500n -0.001723 467.6600n -0.001726 467.6700n -0.001728 467.6800n -0.001730 467.6900n -0.001732
+ 467.7000n -0.001734 467.7100n -0.001735 467.7200n -0.001736 467.7300n -0.001736 467.7400n -0.001737 467.7500n -0.001736 467.7600n -0.001736 467.7700n -0.001735 467.7800n -0.001734 467.7900n -0.001732 467.8000n -0.001730 467.8100n -0.001728 467.8200n -0.001725 467.8300n -0.001722 467.8400n -0.001718
+ 467.8500n -0.001714 467.8600n -0.001710 467.8700n -0.001705 467.8800n -0.001700 467.8900n -0.001694 467.9000n -0.001688 467.9100n -0.001681 467.9200n -0.001674 467.9300n -0.001667 467.9400n -0.001659 467.9500n -0.001650 467.9600n -0.001642 467.9700n -0.001632 467.9800n -0.001623 467.9900n -0.001613
+ 468.0000n -0.001602 468.0100n -0.001591 468.0200n -0.001580 468.0300n -0.001568 468.0400n -0.001556 468.0500n -0.001543 468.0600n -0.001530 468.0700n -0.001516 468.0800n -0.001503 468.0900n -0.001488 468.1000n -0.001474 468.1100n -0.001458 468.1200n -0.001443 468.1300n -0.001427 468.1400n -0.001411
+ 468.1500n -0.001394 468.1600n -0.001377 468.1700n -0.001360 468.1800n -0.001343 468.1900n -0.001325 468.2000n -0.001307 468.2100n -0.001288 468.2200n -0.001269 468.2300n -0.001250 468.2400n -0.001231 468.2500n -0.001211 468.2600n -0.001192 468.2700n -0.001172 468.2800n -0.001151 468.2900n -0.001131
+ 468.3000n -0.001110 468.3100n -0.001090 468.3200n -0.001069 468.3300n -0.001048 468.3400n -0.001027 468.3500n -0.001005 468.3600n -0.000984 468.3700n -0.000963 468.3800n -0.000941 468.3900n -0.000920 468.4000n -0.000898 468.4100n -0.000877 468.4200n -0.000855 468.4300n -0.000834 468.4400n -0.000812
+ 468.4500n -0.000791 468.4600n -0.000769 468.4700n -0.000748 468.4800n -0.000727 468.4900n -0.000706 468.5000n -0.000685 468.5100n -0.000665 468.5200n -0.000644 468.5300n -0.000624 468.5400n -0.000604 468.5500n -0.000584 468.5600n -0.000565 468.5700n -0.000546 468.5800n -0.000527 468.5900n -0.000508
+ 468.6000n -0.000490 468.6100n -0.000472 468.6200n -0.000454 468.6300n -0.000437 468.6400n -0.000420 468.6500n -0.000404 468.6600n -0.000388 468.6700n -0.000373 468.6800n -0.000358 468.6900n -0.000343 468.7000n -0.000329 468.7100n -0.000315 468.7200n -0.000302 468.7300n -0.000290 468.7400n -0.000278
+ 468.7500n -0.000267 468.7600n -0.000256 468.7700n -0.000246 468.7800n -0.000236 468.7900n -0.000227 468.8000n -0.000219 468.8100n -0.000211 468.8200n -0.000204 468.8300n -0.000198 468.8400n -0.000192 468.8500n -0.000187 468.8600n -0.000183 468.8700n -0.000179 468.8800n -0.000176 468.8900n -0.000174
+ 468.9000n -0.000172 468.9100n -0.000171 468.9200n -0.000171 468.9300n -0.000172 468.9400n -0.000174 468.9500n -0.000176 468.9600n -0.000179 468.9700n -0.000182 468.9800n -0.000187 468.9900n -0.000192 469.0000n -0.000198 469.0100n -0.000204 469.0200n -0.000212 469.0300n -0.000220 469.0400n -0.000229
+ 469.0500n -0.000238 469.0600n -0.000249 469.0700n -0.000260 469.0800n -0.000272 469.0900n -0.000284 469.1000n -0.000298 469.1100n -0.000312 469.1200n -0.000327 469.1300n -0.000342 469.1400n -0.000358 469.1500n -0.000375 469.1600n -0.000393 469.1700n -0.000411 469.1800n -0.000430 469.1900n -0.000449
+ 469.2000n -0.000469 469.2100n -0.000490 469.2200n -0.000511 469.2300n -0.000533 469.2400n -0.000556 469.2500n -0.000579 469.2600n -0.000603 469.2700n -0.000627 469.2800n -0.000652 469.2900n -0.000677 469.3000n -0.000702 469.3100n -0.000729 469.3200n -0.000755 469.3300n -0.000782 469.3400n -0.000810
+ 469.3500n -0.000837 469.3600n -0.000866 469.3700n -0.000894 469.3800n -0.000923 469.3900n -0.000952 469.4000n -0.000982 469.4100n -0.001011 469.4200n -0.001041 469.4300n -0.001072 469.4400n -0.001102 469.4500n -0.001132 469.4600n -0.001163 469.4700n -0.001194 469.4800n -0.001225 469.4900n -0.001256
+ 469.5000n -0.001287 469.5100n -0.001318 469.5200n -0.001349 469.5300n -0.001380 469.5400n -0.001410 469.5500n -0.001441 469.5600n -0.001472 469.5700n -0.001503 469.5800n -0.001533 469.5900n -0.001563 469.6000n -0.001593 469.6100n -0.001623 469.6200n -0.001653 469.6300n -0.001682 469.6400n -0.001711
+ 469.6500n -0.001739 469.6600n -0.001768 469.6700n -0.001795 469.6800n -0.001823 469.6900n -0.001850 469.7000n -0.001876 469.7100n -0.001902 469.7200n -0.001928 469.7300n -0.001953 469.7400n -0.001977 469.7500n -0.002001 469.7600n -0.002024 469.7700n -0.002047 469.7800n -0.002069 469.7900n -0.002090
+ 469.8000n -0.002110 469.8100n -0.002130 469.8200n -0.002149 469.8300n -0.002168 469.8400n -0.002185 469.8500n -0.002202 469.8600n -0.002218 469.8700n -0.002233 469.8800n -0.002247 469.8900n -0.002260 469.9000n -0.002273 469.9100n -0.002285 469.9200n -0.002295 469.9300n -0.002305 469.9400n -0.002314
+ 469.9500n -0.002322 469.9600n -0.002328 469.9700n -0.002334 469.9800n -0.002339 469.9900n -0.002343 470.0000n -0.002346 470.0100n -0.002348 470.0200n -0.002349 470.0300n -0.002349 470.0400n -0.002347 470.0500n -0.002345 470.0600n -0.002342 470.0700n -0.002337 470.0800n -0.002332 470.0900n -0.002325
+ 470.1000n -0.002318 470.1100n -0.002309 470.1200n -0.002299 470.1300n -0.002288 470.1400n -0.002276 470.1500n -0.002264 470.1600n -0.002250 470.1700n -0.002234 470.1800n -0.002218 470.1900n -0.002201 470.2000n -0.002183 470.2100n -0.002164 470.2200n -0.002143 470.2300n -0.002122 470.2400n -0.002100
+ 470.2500n -0.002077 470.2600n -0.002052 470.2700n -0.002027 470.2800n -0.002001 470.2900n -0.001974 470.3000n -0.001946 470.3100n -0.001917 470.3200n -0.001887 470.3300n -0.001856 470.3400n -0.001824 470.3500n -0.001792 470.3600n -0.001758 470.3700n -0.001724 470.3800n -0.001689 470.3900n -0.001653
+ 470.4000n -0.001617 470.4100n -0.001580 470.4200n -0.001542 470.4300n -0.001503 470.4400n -0.001464 470.4500n -0.001424 470.4600n -0.001384 470.4700n -0.001342 470.4800n -0.001301 470.4900n -0.001259 470.5000n -0.001216 470.5100n -0.001173 470.5200n -0.001129 470.5300n -0.001085 470.5400n -0.001041
+ 470.5500n -0.000996 470.5600n -0.000951 470.5700n -0.000906 470.5800n -0.000860 470.5900n -0.000814 470.6000n -0.000768 470.6100n -0.000721 470.6200n -0.000675 470.6300n -0.000628 470.6400n -0.000582 470.6500n -0.000535 470.6600n -0.000488 470.6700n -0.000442 470.6800n -0.000395 470.6900n -0.000348
+ 470.7000n -0.000302 470.7100n -0.000256 470.7200n -0.000209 470.7300n -0.000163 470.7400n -0.000118 470.7500n -0.000072 470.7600n -0.000027 470.7700n 0.000018 470.7800n 0.000062 470.7900n 0.000106 470.8000n 0.000150 470.8100n 0.000193 470.8200n 0.000236 470.8300n 0.000278 470.8400n 0.000320
+ 470.8500n 0.000361 470.8600n 0.000401 470.8700n 0.000441 470.8800n 0.000480 470.8900n 0.000519 470.9000n 0.000557 470.9100n 0.000594 470.9200n 0.000630 470.9300n 0.000666 470.9400n 0.000700 470.9500n 0.000734 470.9600n 0.000767 470.9700n 0.000799 470.9800n 0.000830 470.9900n 0.000860
+ 471.0000n 0.000890 471.0100n 0.000918 471.0200n 0.000945 471.0300n 0.000971 471.0400n 0.000997 471.0500n 0.001021 471.0600n 0.001044 471.0700n 0.001066 471.0800n 0.001087 471.0900n 0.001107 471.1000n 0.001125 471.1100n 0.001143 471.1200n 0.001159 471.1300n 0.001174 471.1400n 0.001188
+ 471.1500n 0.001201 471.1600n 0.001213 471.1700n 0.001223 471.1800n 0.001232 471.1900n 0.001240 471.2000n 0.001247 471.2100n 0.001253 471.2200n 0.001257 471.2300n 0.001260 471.2400n 0.001262 471.2500n 0.001263 471.2600n 0.001262 471.2700n 0.001260 471.2800n 0.001257 471.2900n 0.001253
+ 471.3000n 0.001248 471.3100n 0.001241 471.3200n 0.001233 471.3300n 0.001224 471.3400n 0.001214 471.3500n 0.001202 471.3600n 0.001190 471.3700n 0.001176 471.3800n 0.001161 471.3900n 0.001145 471.4000n 0.001128 471.4100n 0.001110 471.4200n 0.001091 471.4300n 0.001070 471.4400n 0.001049
+ 471.4500n 0.001026 471.4600n 0.001003 471.4700n 0.000979 471.4800n 0.000953 471.4900n 0.000927 471.5000n 0.000900 471.5100n 0.000871 471.5200n 0.000842 471.5300n 0.000812 471.5400n 0.000782 471.5500n 0.000750 471.5600n 0.000718 471.5700n 0.000685 471.5800n 0.000651 471.5900n 0.000616
+ 471.6000n 0.000581 471.6100n 0.000545 471.6200n 0.000509 471.6300n 0.000472 471.6400n 0.000434 471.6500n 0.000396 471.6600n 0.000358 471.6700n 0.000319 471.6800n 0.000280 471.6900n 0.000240 471.7000n 0.000200 471.7100n 0.000159 471.7200n 0.000119 471.7300n 0.000078 471.7400n 0.000037
+ 471.7500n -0.000005 471.7600n -0.000046 471.7700n -0.000088 471.7800n -0.000129 471.7900n -0.000171 471.8000n -0.000213 471.8100n -0.000254 471.8200n -0.000296 471.8300n -0.000337 471.8400n -0.000379 471.8500n -0.000420 471.8600n -0.000461 471.8700n -0.000501 471.8800n -0.000542 471.8900n -0.000582
+ 471.9000n -0.000622 471.9100n -0.000661 471.9200n -0.000700 471.9300n -0.000738 471.9400n -0.000776 471.9500n -0.000814 471.9600n -0.000851 471.9700n -0.000887 471.9800n -0.000923 471.9900n -0.000958 472.0000n -0.000992 472.0100n -0.001026 472.0200n -0.001059 472.0300n -0.001091 472.0400n -0.001122
+ 472.0500n -0.001153 472.0600n -0.001183 472.0700n -0.001211 472.0800n -0.001239 472.0900n -0.001266 472.1000n -0.001293 472.1100n -0.001318 472.1200n -0.001342 472.1300n -0.001365 472.1400n -0.001387 472.1500n -0.001408 472.1600n -0.001428 472.1700n -0.001447 472.1800n -0.001464 472.1900n -0.001481
+ 472.2000n -0.001496 472.2100n -0.001510 472.2200n -0.001524 472.2300n -0.001535 472.2400n -0.001546 472.2500n -0.001556 472.2600n -0.001564 472.2700n -0.001571 472.2800n -0.001577 472.2900n -0.001581 472.3000n -0.001584 472.3100n -0.001586 472.3200n -0.001587 472.3300n -0.001586 472.3400n -0.001584
+ 472.3500n -0.001581 472.3600n -0.001577 472.3700n -0.001571 472.3800n -0.001564 472.3900n -0.001556 472.4000n -0.001547 472.4100n -0.001536 472.4200n -0.001524 472.4300n -0.001511 472.4400n -0.001496 472.4500n -0.001480 472.4600n -0.001463 472.4700n -0.001445 472.4800n -0.001426 472.4900n -0.001405
+ 472.5000n -0.001384 472.5100n -0.001361 472.5200n -0.001337 472.5300n -0.001312 472.5400n -0.001285 472.5500n -0.001258 472.5600n -0.001230 472.5700n -0.001200 472.5800n -0.001170 472.5900n -0.001138 472.6000n -0.001106 472.6100n -0.001072 472.6200n -0.001038 472.6300n -0.001003 472.6400n -0.000967
+ 472.6500n -0.000930 472.6600n -0.000892 472.6700n -0.000853 472.6800n -0.000814 472.6900n -0.000774 472.7000n -0.000733 472.7100n -0.000691 472.7200n -0.000649 472.7300n -0.000606 472.7400n -0.000563 472.7500n -0.000519 472.7600n -0.000475 472.7700n -0.000430 472.7800n -0.000384 472.7900n -0.000339
+ 472.8000n -0.000292 472.8100n -0.000246 472.8200n -0.000199 472.8300n -0.000152 472.8400n -0.000105 472.8500n -0.000058 472.8600n -0.000010 472.8700n 0.000038 472.8800n 0.000086 472.8900n 0.000133 472.9000n 0.000181 472.9100n 0.000229 472.9200n 0.000277 472.9300n 0.000324 472.9400n 0.000372
+ 472.9500n 0.000419 472.9600n 0.000466 472.9700n 0.000513 472.9800n 0.000559 472.9900n 0.000606 473.0000n 0.000651 473.0100n 0.000697 473.0200n 0.000742 473.0300n 0.000786 473.0400n 0.000830 473.0500n 0.000873 473.0600n 0.000916 473.0700n 0.000958 473.0800n 0.001000 473.0900n 0.001041
+ 473.1000n 0.001081 473.1100n 0.001120 473.1200n 0.001159 473.1300n 0.001196 473.1400n 0.001233 473.1500n 0.001269 473.1600n 0.001304 473.1700n 0.001338 473.1800n 0.001371 473.1900n 0.001403 473.2000n 0.001434 473.2100n 0.001464 473.2200n 0.001493 473.2300n 0.001521 473.2400n 0.001548
+ 473.2500n 0.001573 473.2600n 0.001598 473.2700n 0.001621 473.2800n 0.001643 473.2900n 0.001663 473.3000n 0.001683 473.3100n 0.001701 473.3200n 0.001718 473.3300n 0.001733 473.3400n 0.001747 473.3500n 0.001760 473.3600n 0.001772 473.3700n 0.001782 473.3800n 0.001791 473.3900n 0.001798
+ 473.4000n 0.001804 473.4100n 0.001809 473.4200n 0.001812 473.4300n 0.001814 473.4400n 0.001814 473.4500n 0.001813 473.4600n 0.001811 473.4700n 0.001807 473.4800n 0.001801 473.4900n 0.001795 473.5000n 0.001786 473.5100n 0.001777 473.5200n 0.001766 473.5300n 0.001753 473.5400n 0.001739
+ 473.5500n 0.001724 473.5600n 0.001708 473.5700n 0.001690 473.5800n 0.001670 473.5900n 0.001650 473.6000n 0.001627 473.6100n 0.001604 473.6200n 0.001579 473.6300n 0.001553 473.6400n 0.001526 473.6500n 0.001497 473.6600n 0.001468 473.6700n 0.001437 473.6800n 0.001404 473.6900n 0.001371
+ 473.7000n 0.001336 473.7100n 0.001301 473.7200n 0.001264 473.7300n 0.001226 473.7400n 0.001187 473.7500n 0.001147 473.7600n 0.001106 473.7700n 0.001064 473.7800n 0.001021 473.7900n 0.000977 473.8000n 0.000932 473.8100n 0.000886 473.8200n 0.000840 473.8300n 0.000792 473.8400n 0.000744
+ 473.8500n 0.000695 473.8600n 0.000646 473.8700n 0.000596 473.8800n 0.000545 473.8900n 0.000493 473.9000n 0.000441 473.9100n 0.000389 473.9200n 0.000336 473.9300n 0.000283 473.9400n 0.000229 473.9500n 0.000175 473.9600n 0.000120 473.9700n 0.000065 473.9800n 0.000010 473.9900n -0.000045
+ 474.0000n -0.000101 474.0100n -0.000156 474.0200n -0.000212 474.0300n -0.000268 474.0400n -0.000323 474.0500n -0.000379 474.0600n -0.000435 474.0700n -0.000490 474.0800n -0.000546 474.0900n -0.000601 474.1000n -0.000656 474.1100n -0.000711 474.1200n -0.000765 474.1300n -0.000820 474.1400n -0.000873
+ 474.1500n -0.000927 474.1600n -0.000980 474.1700n -0.001032 474.1800n -0.001084 474.1900n -0.001135 474.2000n -0.001186 474.2100n -0.001236 474.2200n -0.001286 474.2300n -0.001335 474.2400n -0.001383 474.2500n -0.001430 474.2600n -0.001476 474.2700n -0.001522 474.2800n -0.001567 474.2900n -0.001611
+ 474.3000n -0.001654 474.3100n -0.001696 474.3200n -0.001737 474.3300n -0.001777 474.3400n -0.001815 474.3500n -0.001853 474.3600n -0.001890 474.3700n -0.001926 474.3800n -0.001960 474.3900n -0.001994 474.4000n -0.002026 474.4100n -0.002057 474.4200n -0.002087 474.4300n -0.002115 474.4400n -0.002142
+ 474.4500n -0.002168 474.4600n -0.002193 474.4700n -0.002216 474.4800n -0.002238 474.4900n -0.002259 474.5000n -0.002278 474.5100n -0.002296 474.5200n -0.002312 474.5300n -0.002328 474.5400n -0.002341 474.5500n -0.002354 474.5600n -0.002364 474.5700n -0.002374 474.5800n -0.002382 474.5900n -0.002389
+ 474.6000n -0.002394 474.6100n -0.002397 474.6200n -0.002400 474.6300n -0.002401 474.6400n -0.002400 474.6500n -0.002398 474.6600n -0.002395 474.6700n -0.002390 474.6800n -0.002384 474.6900n -0.002376 474.7000n -0.002367 474.7100n -0.002357 474.7200n -0.002345 474.7300n -0.002332 474.7400n -0.002317
+ 474.7500n -0.002301 474.7600n -0.002284 474.7700n -0.002266 474.7800n -0.002246 474.7900n -0.002225 474.8000n -0.002203 474.8100n -0.002179 474.8200n -0.002154 474.8300n -0.002128 474.8400n -0.002101 474.8500n -0.002073 474.8600n -0.002044 474.8700n -0.002013 474.8800n -0.001981 474.8900n -0.001949
+ 474.9000n -0.001915 474.9100n -0.001880 474.9200n -0.001845 474.9300n -0.001808 474.9400n -0.001771 474.9500n -0.001732 474.9600n -0.001693 474.9700n -0.001653 474.9800n -0.001612 474.9900n -0.001570 475.0000n -0.001528 475.0100n -0.001485 475.0200n -0.001441 475.0300n -0.001397 475.0400n -0.001352
+ 475.0500n -0.001306 475.0600n -0.001260 475.0700n -0.001213 475.0800n -0.001166 475.0900n -0.001119 475.1000n -0.001071 475.1100n -0.001023 475.1200n -0.000975 475.1300n -0.000926 475.1400n -0.000877 475.1500n -0.000828 475.1600n -0.000778 475.1700n -0.000729 475.1800n -0.000679 475.1900n -0.000630
+ 475.2000n -0.000580 475.2100n -0.000531 475.2200n -0.000481 475.2300n -0.000432 475.2400n -0.000382 475.2500n -0.000333 475.2600n -0.000284 475.2700n -0.000235 475.2800n -0.000187 475.2900n -0.000139 475.3000n -0.000091 475.3100n -0.000044 475.3200n 0.000003 475.3300n 0.000050 475.3400n 0.000096
+ 475.3500n 0.000141 475.3600n 0.000186 475.3700n 0.000231 475.3800n 0.000275 475.3900n 0.000318 475.4000n 0.000360 475.4100n 0.000402 475.4200n 0.000443 475.4300n 0.000484 475.4400n 0.000523 475.4500n 0.000562 475.4600n 0.000600 475.4700n 0.000637 475.4800n 0.000673 475.4900n 0.000708
+ 475.5000n 0.000743 475.5100n 0.000776 475.5200n 0.000808 475.5300n 0.000840 475.5400n 0.000870 475.5500n 0.000900 475.5600n 0.000928 475.5700n 0.000955 475.5800n 0.000981 475.5900n 0.001006 475.6000n 0.001030 475.6100n 0.001053 475.6200n 0.001075 475.6300n 0.001095 475.6400n 0.001114
+ 475.6500n 0.001132 475.6600n 0.001149 475.6700n 0.001165 475.6800n 0.001180 475.6900n 0.001193 475.7000n 0.001205 475.7100n 0.001216 475.7200n 0.001226 475.7300n 0.001234 475.7400n 0.001241 475.7500n 0.001247 475.7600n 0.001252 475.7700n 0.001256 475.7800n 0.001258 475.7900n 0.001259
+ 475.8000n 0.001259 475.8100n 0.001257 475.8200n 0.001255 475.8300n 0.001251 475.8400n 0.001246 475.8500n 0.001240 475.8600n 0.001233 475.8700n 0.001225 475.8800n 0.001215 475.8900n 0.001204 475.9000n 0.001192 475.9100n 0.001180 475.9200n 0.001166 475.9300n 0.001150 475.9400n 0.001134
+ 475.9500n 0.001117 475.9600n 0.001099 475.9700n 0.001080 475.9800n 0.001059 475.9900n 0.001038 476.0000n 0.001016 476.0100n 0.000993 476.0200n 0.000969 476.0300n 0.000944 476.0400n 0.000919 476.0500n 0.000892 476.0600n 0.000865 476.0700n 0.000837 476.0800n 0.000808 476.0900n 0.000778
+ 476.1000n 0.000748 476.1100n 0.000717 476.1200n 0.000686 476.1300n 0.000653 476.1400n 0.000621 476.1500n 0.000587 476.1600n 0.000553 476.1700n 0.000519 476.1800n 0.000484 476.1900n 0.000449 476.2000n 0.000413 476.2100n 0.000377 476.2200n 0.000341 476.2300n 0.000304 476.2400n 0.000267
+ 476.2500n 0.000230 476.2600n 0.000193 476.2700n 0.000155 476.2800n 0.000117 476.2900n 0.000079 476.3000n 0.000041 476.3100n 0.000003 476.3200n -0.000035 476.3300n -0.000073 476.3400n -0.000111 476.3500n -0.000149 476.3600n -0.000187 476.3700n -0.000225 476.3800n -0.000262 476.3900n -0.000300
+ 476.4000n -0.000337 476.4100n -0.000374 476.4200n -0.000411 476.4300n -0.000447 476.4400n -0.000483 476.4500n -0.000519 476.4600n -0.000554 476.4700n -0.000589 476.4800n -0.000623 476.4900n -0.000657 476.5000n -0.000690 476.5100n -0.000723 476.5200n -0.000756 476.5300n -0.000787 476.5400n -0.000818
+ 476.5500n -0.000849 476.5600n -0.000879 476.5700n -0.000908 476.5800n -0.000936 476.5900n -0.000964 476.6000n -0.000991 476.6100n -0.001017 476.6200n -0.001042 476.6300n -0.001067 476.6400n -0.001091 476.6500n -0.001114 476.6600n -0.001136 476.6700n -0.001157 476.6800n -0.001177 476.6900n -0.001197
+ 476.7000n -0.001215 476.7100n -0.001233 476.7200n -0.001249 476.7300n -0.001265 476.7400n -0.001280 476.7500n -0.001293 476.7600n -0.001306 476.7700n -0.001318 476.7800n -0.001328 476.7900n -0.001338 476.8000n -0.001347 476.8100n -0.001354 476.8200n -0.001361 476.8300n -0.001367 476.8400n -0.001371
+ 476.8500n -0.001375 476.8600n -0.001377 476.8700n -0.001379 476.8800n -0.001379 476.8900n -0.001378 476.9000n -0.001377 476.9100n -0.001374 476.9200n -0.001370 476.9300n -0.001365 476.9400n -0.001359 476.9500n -0.001352 476.9600n -0.001345 476.9700n -0.001336 476.9800n -0.001326 476.9900n -0.001315
+ 477.0000n -0.001303 477.0100n -0.001290 477.0200n -0.001277 477.0300n -0.001262 477.0400n -0.001246 477.0500n -0.001230 477.0600n -0.001212 477.0700n -0.001194 477.0800n -0.001175 477.0900n -0.001154 477.1000n -0.001134 477.1100n -0.001112 477.1200n -0.001089 477.1300n -0.001066 477.1400n -0.001042
+ 477.1500n -0.001017 477.1600n -0.000991 477.1700n -0.000964 477.1800n -0.000937 477.1900n -0.000910 477.2000n -0.000881 477.2100n -0.000852 477.2200n -0.000822 477.2300n -0.000792 477.2400n -0.000761 477.2500n -0.000730 477.2600n -0.000698 477.2700n -0.000665 477.2800n -0.000632 477.2900n -0.000599
+ 477.3000n -0.000565 477.3100n -0.000531 477.3200n -0.000496 477.3300n -0.000461 477.3400n -0.000426 477.3500n -0.000391 477.3600n -0.000355 477.3700n -0.000319 477.3800n -0.000282 477.3900n -0.000246 477.4000n -0.000209 477.4100n -0.000172 477.4200n -0.000135 477.4300n -0.000098 477.4400n -0.000061
+ 477.4500n -0.000023 477.4600n 0.000014 477.4700n 0.000051 477.4800n 0.000089 477.4900n 0.000126 477.5000n 0.000163 477.5100n 0.000200 477.5200n 0.000237 477.5300n 0.000274 477.5400n 0.000310 477.5500n 0.000347 477.5600n 0.000383 477.5700n 0.000419 477.5800n 0.000455 477.5900n 0.000490
+ 477.6000n 0.000525 477.6100n 0.000560 477.6200n 0.000594 477.6300n 0.000628 477.6400n 0.000662 477.6500n 0.000695 477.6600n 0.000728 477.6700n 0.000760 477.6800n 0.000792 477.6900n 0.000824 477.7000n 0.000855 477.7100n 0.000885 477.7200n 0.000915 477.7300n 0.000944 477.7400n 0.000973
+ 477.7500n 0.001001 477.7600n 0.001029 477.7700n 0.001055 477.7800n 0.001082 477.7900n 0.001107 477.8000n 0.001132 477.8100n 0.001157 477.8200n 0.001180 477.8300n 0.001203 477.8400n 0.001225 477.8500n 0.001247 477.8600n 0.001268 477.8700n 0.001288 477.8800n 0.001307 477.8900n 0.001326
+ 477.9000n 0.001344 477.9100n 0.001361 477.9200n 0.001377 477.9300n 0.001393 477.9400n 0.001407 477.9500n 0.001421 477.9600n 0.001434 477.9700n 0.001447 477.9800n 0.001459 477.9900n 0.001469 478.0000n 0.001480 478.0100n 0.001489 478.0200n 0.001497 478.0300n 0.001505 478.0400n 0.001512
+ 478.0500n 0.001518 478.0600n 0.001523 478.0700n 0.001528 478.0800n 0.001532 478.0900n 0.001535 478.1000n 0.001537 478.1100n 0.001539 478.1200n 0.001540 478.1300n 0.001540 478.1400n 0.001539 478.1500n 0.001537 478.1600n 0.001535 478.1700n 0.001532 478.1800n 0.001529 478.1900n 0.001525
+ 478.2000n 0.001520 478.2100n 0.001514 478.2200n 0.001508 478.2300n 0.001501 478.2400n 0.001493 478.2500n 0.001485 478.2600n 0.001476 478.2700n 0.001466 478.2800n 0.001456 478.2900n 0.001446 478.3000n 0.001434 478.3100n 0.001422 478.3200n 0.001410 478.3300n 0.001397 478.3400n 0.001384
+ 478.3500n 0.001370 478.3600n 0.001355 478.3700n 0.001341 478.3800n 0.001325 478.3900n 0.001309 478.4000n 0.001293 478.4100n 0.001277 478.4200n 0.001260 478.4300n 0.001242 478.4400n 0.001224 478.4500n 0.001206 478.4600n 0.001188 478.4700n 0.001169 478.4800n 0.001150 478.4900n 0.001131
+ 478.5000n 0.001111 478.5100n 0.001091 478.5200n 0.001071 478.5300n 0.001050 478.5400n 0.001030 478.5500n 0.001009 478.5600n 0.000988 478.5700n 0.000967 478.5800n 0.000946 478.5900n 0.000924 478.6000n 0.000903 478.6100n 0.000881 478.6200n 0.000860 478.6300n 0.000838 478.6400n 0.000816
+ 478.6500n 0.000794 478.6600n 0.000772 478.6700n 0.000751 478.6800n 0.000729 478.6900n 0.000707 478.7000n 0.000685 478.7100n 0.000663 478.7200n 0.000642 478.7300n 0.000620 478.7400n 0.000598 478.7500n 0.000577 478.7600n 0.000555 478.7700n 0.000534 478.7800n 0.000513 478.7900n 0.000492
+ 478.8000n 0.000471 478.8100n 0.000451 478.8200n 0.000430 478.8300n 0.000410 478.8400n 0.000390 478.8500n 0.000370 478.8600n 0.000350 478.8700n 0.000330 478.8800n 0.000311 478.8900n 0.000292 478.9000n 0.000273 478.9100n 0.000255 478.9200n 0.000236 478.9300n 0.000218 478.9400n 0.000201
+ 478.9500n 0.000183 478.9600n 0.000166 478.9700n 0.000149 478.9800n 0.000132 478.9900n 0.000116 479.0000n 0.000100 479.0100n 0.000084 479.0200n 0.000069 479.0300n 0.000053 479.0400n 0.000039 479.0500n 0.000024 479.0600n 0.000010 479.0700n -0.000004 479.0800n -0.000018 479.0900n -0.000031
+ 479.1000n -0.000044 479.1100n -0.000057 479.1200n -0.000069 479.1300n -0.000081 479.1400n -0.000093 479.1500n -0.000104 479.1600n -0.000115 479.1700n -0.000126 479.1800n -0.000136 479.1900n -0.000147 479.2000n -0.000156 479.2100n -0.000166 479.2200n -0.000175 479.2300n -0.000184 479.2400n -0.000193
+ 479.2500n -0.000201 479.2600n -0.000209 479.2700n -0.000217 479.2800n -0.000225 479.2900n -0.000232 479.3000n -0.000239 479.3100n -0.000245 479.3200n -0.000252 479.3300n -0.000258 479.3400n -0.000264 479.3500n -0.000269 479.3600n -0.000275 479.3700n -0.000280 479.3800n -0.000285 479.3900n -0.000290
+ 479.4000n -0.000294 479.4100n -0.000298 479.4200n -0.000302 479.4300n -0.000306 479.4400n -0.000310 479.4500n -0.000313 479.4600n -0.000316 479.4700n -0.000319 479.4800n -0.000322 479.4900n -0.000324 479.5000n -0.000327 479.5100n -0.000329 479.5200n -0.000331 479.5300n -0.000333 479.5400n -0.000335
+ 479.5500n -0.000336 479.5600n -0.000338 479.5700n -0.000339 479.5800n -0.000340 479.5900n -0.000341 479.6000n -0.000342 479.6100n -0.000343 479.6200n -0.000344 479.6300n -0.000344 479.6400n -0.000345 479.6500n -0.000345 479.6600n -0.000345 479.6700n -0.000345 479.6800n -0.000345 479.6900n -0.000345
+ 479.7000n -0.000344 479.7100n -0.000344 479.7200n -0.000344 479.7300n -0.000343 479.7400n -0.000342 479.7500n -0.000342 479.7600n -0.000341 479.7700n -0.000340 479.7800n -0.000339 479.7900n -0.000337 479.8000n -0.000336 479.8100n -0.000335 479.8200n -0.000333 479.8300n -0.000332 479.8400n -0.000330
+ 479.8500n -0.000328 479.8600n -0.000327 479.8700n -0.000325 479.8800n -0.000323 479.8900n -0.000320 479.9000n -0.000318 479.9100n -0.000316 479.9200n -0.000313 479.9300n -0.000311 479.9400n -0.000308 479.9500n -0.000305 479.9600n -0.000302 479.9700n -0.000299 479.9800n -0.000296 479.9900n -0.000292
+ 480.0000n -0.000289 480.0100n -0.000285 480.0200n -0.000281 480.0300n -0.000277 480.0400n -0.000273 480.0500n -0.000269 480.0600n -0.000264 480.0700n -0.000259 480.0800n -0.000255 480.0900n -0.000250 480.1000n -0.000244 480.1100n -0.000239 480.1200n -0.000233 480.1300n -0.000227 480.1400n -0.000221
+ 480.1500n -0.000215 480.1600n -0.000208 480.1700n -0.000201 480.1800n -0.000194 480.1900n -0.000187 480.2000n -0.000179 480.2100n -0.000171 480.2200n -0.000163 480.2300n -0.000154 480.2400n -0.000146 480.2500n -0.000137 480.2600n -0.000127 480.2700n -0.000117 480.2800n -0.000107 480.2900n -0.000097
+ 480.3000n -0.000086 480.3100n -0.000075 480.3200n -0.000064 480.3300n -0.000052 480.3400n -0.000040 480.3500n -0.000028 480.3600n -0.000015 480.3700n -0.000002 480.3800n 0.000012 480.3900n 0.000026 480.4000n 0.000041 480.4100n 0.000055 480.4200n 0.000071 480.4300n 0.000086 480.4400n 0.000102
+ 480.4500n 0.000119 480.4600n 0.000136 480.4700n 0.000153 480.4800n 0.000171 480.4900n 0.000189 480.5000n 0.000207 480.5100n 0.000226 480.5200n 0.000246 480.5300n 0.000266 480.5400n 0.000286 480.5500n 0.000307 480.5600n 0.000328 480.5700n 0.000350 480.5800n 0.000372 480.5900n 0.000395
+ 480.6000n 0.000418 480.6100n 0.000442 480.6200n 0.000466 480.6300n 0.000490 480.6400n 0.000515 480.6500n 0.000540 480.6600n 0.000566 480.6700n 0.000592 480.6800n 0.000619 480.6900n 0.000646 480.7000n 0.000673 480.7100n 0.000701 480.7200n 0.000730 480.7300n 0.000758 480.7400n 0.000787
+ 480.7500n 0.000817 480.7600n 0.000847 480.7700n 0.000877 480.7800n 0.000908 480.7900n 0.000938 480.8000n 0.000970 480.8100n 0.001001 480.8200n 0.001033 480.8300n 0.001066 480.8400n 0.001098 480.8500n 0.001131 480.8600n 0.001164 480.8700n 0.001198 480.8800n 0.001232 480.8900n 0.001266
+ 480.9000n 0.001300 480.9100n 0.001334 480.9200n 0.001369 480.9300n 0.001404 480.9400n 0.001439 480.9500n 0.001474 480.9600n 0.001509 480.9700n 0.001545 480.9800n 0.001580 480.9900n 0.001616 481.0000n 0.001651 481.0100n 0.001687 481.0200n 0.001723 481.0300n 0.001759 481.0400n 0.001795
+ 481.0500n 0.001830 481.0600n 0.001866 481.0700n 0.001902 481.0800n 0.001937 481.0900n 0.001973 481.1000n 0.002008 481.1100n 0.002044 481.1200n 0.002079 481.1300n 0.002114 481.1400n 0.002148 481.1500n 0.002183 481.1600n 0.002217 481.1700n 0.002251 481.1800n 0.002285 481.1900n 0.002318
+ 481.2000n 0.002351 481.2100n 0.002384 481.2200n 0.002416 481.2300n 0.002448 481.2400n 0.002479 481.2500n 0.002510 481.2600n 0.002541 481.2700n 0.002571 481.2800n 0.002600 481.2900n 0.002629 481.3000n 0.002657 481.3100n 0.002685 481.3200n 0.002712 481.3300n 0.002739 481.3400n 0.002765
+ 481.3500n 0.002790 481.3600n 0.002815 481.3700n 0.002839 481.3800n 0.002862 481.3900n 0.002884 481.4000n 0.002905 481.4100n 0.002926 481.4200n 0.002946 481.4300n 0.002965 481.4400n 0.002983 481.4500n 0.003001 481.4600n 0.003017 481.4700n 0.003033 481.4800n 0.003047 481.4900n 0.003061
+ 481.5000n 0.003073 481.5100n 0.003085 481.5200n 0.003096 481.5300n 0.003105 481.5400n 0.003114 481.5500n 0.003121 481.5600n 0.003128 481.5700n 0.003133 481.5800n 0.003137 481.5900n 0.003140 481.6000n 0.003142 481.6100n 0.003143 481.6200n 0.003143 481.6300n 0.003141 481.6400n 0.003139
+ 481.6500n 0.003135 481.6600n 0.003130 481.6700n 0.003123 481.6800n 0.003116 481.6900n 0.003107 481.7000n 0.003097 481.7100n 0.003086 481.7200n 0.003074 481.7300n 0.003060 481.7400n 0.003045 481.7500n 0.003029 481.7600n 0.003012 481.7700n 0.002994 481.7800n 0.002974 481.7900n 0.002953
+ 481.8000n 0.002930 481.8100n 0.002907 481.8200n 0.002882 481.8300n 0.002856 481.8400n 0.002829 481.8500n 0.002800 481.8600n 0.002770 481.8700n 0.002739 481.8800n 0.002707 481.8900n 0.002674 481.9000n 0.002639 481.9100n 0.002603 481.9200n 0.002566 481.9300n 0.002528 481.9400n 0.002489
+ 481.9500n 0.002448 481.9600n 0.002407 481.9700n 0.002364 481.9800n 0.002320 481.9900n 0.002275 482.0000n 0.002229 482.0100n 0.002182 482.0200n 0.002134 482.0300n 0.002085 482.0400n 0.002035 482.0500n 0.001984 482.0600n 0.001932 482.0700n 0.001879 482.0800n 0.001825 482.0900n 0.001771
+ 482.1000n 0.001715 482.1100n 0.001658 482.1200n 0.001601 482.1300n 0.001543 482.1400n 0.001484 482.1500n 0.001424 482.1600n 0.001364 482.1700n 0.001303 482.1800n 0.001241 482.1900n 0.001179 482.2000n 0.001116 482.2100n 0.001052 482.2200n 0.000988 482.2300n 0.000924 482.2400n 0.000859
+ 482.2500n 0.000793 482.2600n 0.000727 482.2700n 0.000661 482.2800n 0.000594 482.2900n 0.000527 482.3000n 0.000459 482.3100n 0.000392 482.3200n 0.000324 482.3300n 0.000256 482.3400n 0.000188 482.3500n 0.000119 482.3600n 0.000051 482.3700n -0.000018 482.3800n -0.000086 482.3900n -0.000155
+ 482.4000n -0.000223 482.4100n -0.000291 482.4200n -0.000360 482.4300n -0.000428 482.4400n -0.000496 482.4500n -0.000563 482.4600n -0.000631 482.4700n -0.000698 482.4800n -0.000765 482.4900n -0.000831 482.5000n -0.000897 482.5100n -0.000963 482.5200n -0.001028 482.5300n -0.001092 482.5400n -0.001156
+ 482.5500n -0.001220 482.5600n -0.001283 482.5700n -0.001345 482.5800n -0.001407 482.5900n -0.001468 482.6000n -0.001528 482.6100n -0.001587 482.6200n -0.001646 482.6300n -0.001703 482.6400n -0.001760 482.6500n -0.001816 482.6600n -0.001871 482.6700n -0.001925 482.6800n -0.001979 482.6900n -0.002031
+ 482.7000n -0.002082 482.7100n -0.002132 482.7200n -0.002181 482.7300n -0.002228 482.7400n -0.002275 482.7500n -0.002321 482.7600n -0.002365 482.7700n -0.002408 482.7800n -0.002450 482.7900n -0.002490 482.8000n -0.002530 482.8100n -0.002568 482.8200n -0.002604 482.8300n -0.002640 482.8400n -0.002674
+ 482.8500n -0.002706 482.8600n -0.002738 482.8700n -0.002767 482.8800n -0.002796 482.8900n -0.002823 482.9000n -0.002848 482.9100n -0.002872 482.9200n -0.002895 482.9300n -0.002916 482.9400n -0.002936 482.9500n -0.002954 482.9600n -0.002970 482.9700n -0.002985 482.9800n -0.002999 482.9900n -0.003011
+ 483.0000n -0.003021 483.0100n -0.003030 483.0200n -0.003038 483.0300n -0.003043 483.0400n -0.003048 483.0500n -0.003051 483.0600n -0.003052 483.0700n -0.003052 483.0800n -0.003050 483.0900n -0.003046 483.1000n -0.003042 483.1100n -0.003035 483.1200n -0.003027 483.1300n -0.003018 483.1400n -0.003007
+ 483.1500n -0.002995 483.1600n -0.002981 483.1700n -0.002966 483.1800n -0.002949 483.1900n -0.002931 483.2000n -0.002911 483.2100n -0.002890 483.2200n -0.002868 483.2300n -0.002844 483.2400n -0.002819 483.2500n -0.002793 483.2600n -0.002765 483.2700n -0.002736 483.2800n -0.002706 483.2900n -0.002674
+ 483.3000n -0.002641 483.3100n -0.002607 483.3200n -0.002572 483.3300n -0.002536 483.3400n -0.002499 483.3500n -0.002460 483.3600n -0.002420 483.3700n -0.002380 483.3800n -0.002338 483.3900n -0.002295 483.4000n -0.002252 483.4100n -0.002207 483.4200n -0.002162 483.4300n -0.002115 483.4400n -0.002068
+ 483.4500n -0.002020 483.4600n -0.001971 483.4700n -0.001922 483.4800n -0.001871 483.4900n -0.001820 483.5000n -0.001769 483.5100n -0.001717 483.5200n -0.001664 483.5300n -0.001611 483.5400n -0.001557 483.5500n -0.001502 483.5600n -0.001448 483.5700n -0.001393 483.5800n -0.001337 483.5900n -0.001281
+ 483.6000n -0.001225 483.6100n -0.001169 483.6200n -0.001112 483.6300n -0.001055 483.6400n -0.000998 483.6500n -0.000941 483.6600n -0.000884 483.6700n -0.000827 483.6800n -0.000770 483.6900n -0.000713 483.7000n -0.000656 483.7100n -0.000599 483.7200n -0.000542 483.7300n -0.000485 483.7400n -0.000429
+ 483.7500n -0.000373 483.7600n -0.000317 483.7700n -0.000261 483.7800n -0.000206 483.7900n -0.000151 483.8000n -0.000097 483.8100n -0.000043 483.8200n 0.000011 483.8300n 0.000063 483.8400n 0.000116 483.8500n 0.000168 483.8600n 0.000219 483.8700n 0.000269 483.8800n 0.000319 483.8900n 0.000368
+ 483.9000n 0.000417 483.9100n 0.000464 483.9200n 0.000511 483.9300n 0.000557 483.9400n 0.000602 483.9500n 0.000647 483.9600n 0.000690 483.9700n 0.000733 483.9800n 0.000774 483.9900n 0.000815 484.0000n 0.000854 484.0100n 0.000893 484.0200n 0.000930 484.0300n 0.000967 484.0400n 0.001002
+ 484.0500n 0.001036 484.0600n 0.001069 484.0700n 0.001101 484.0800n 0.001132 484.0900n 0.001162 484.1000n 0.001191 484.1100n 0.001218 484.1200n 0.001244 484.1300n 0.001269 484.1400n 0.001293 484.1500n 0.001315 484.1600n 0.001336 484.1700n 0.001356 484.1800n 0.001375 484.1900n 0.001392
+ 484.2000n 0.001408 484.2100n 0.001423 484.2200n 0.001436 484.2300n 0.001448 484.2400n 0.001459 484.2500n 0.001469 484.2600n 0.001477 484.2700n 0.001484 484.2800n 0.001490 484.2900n 0.001494 484.3000n 0.001497 484.3100n 0.001499 484.3200n 0.001500 484.3300n 0.001499 484.3400n 0.001497
+ 484.3500n 0.001493 484.3600n 0.001489 484.3700n 0.001483 484.3800n 0.001476 484.3900n 0.001467 484.4000n 0.001458 484.4100n 0.001447 484.4200n 0.001435 484.4300n 0.001422 484.4400n 0.001407 484.4500n 0.001392 484.4600n 0.001375 484.4700n 0.001357 484.4800n 0.001338 484.4900n 0.001318
+ 484.5000n 0.001297 484.5100n 0.001275 484.5200n 0.001252 484.5300n 0.001228 484.5400n 0.001203 484.5500n 0.001176 484.5600n 0.001149 484.5700n 0.001121 484.5800n 0.001092 484.5900n 0.001062 484.6000n 0.001032 484.6100n 0.001000 484.6200n 0.000968 484.6300n 0.000935 484.6400n 0.000901
+ 484.6500n 0.000866 484.6600n 0.000831 484.6700n 0.000795 484.6800n 0.000758 484.6900n 0.000721 484.7000n 0.000683 484.7100n 0.000645 484.7200n 0.000606 484.7300n 0.000566 484.7400n 0.000526 484.7500n 0.000486 484.7600n 0.000445 484.7700n 0.000404 484.7800n 0.000362 484.7900n 0.000320
+ 484.8000n 0.000278 484.8100n 0.000236 484.8200n 0.000193 484.8300n 0.000150 484.8400n 0.000107 484.8500n 0.000064 484.8600n 0.000020 484.8700n -0.000023 484.8800n -0.000066 484.8900n -0.000110 484.9000n -0.000153 484.9100n -0.000197 484.9200n -0.000240 484.9300n -0.000283 484.9400n -0.000326
+ 484.9500n -0.000369 484.9600n -0.000412 484.9700n -0.000455 484.9800n -0.000497 484.9900n -0.000539 485.0000n -0.000581 485.0100n -0.000622 485.0200n -0.000663 485.0300n -0.000704 485.0400n -0.000744 485.0500n -0.000784 485.0600n -0.000823 485.0700n -0.000862 485.0800n -0.000900 485.0900n -0.000938
+ 485.1000n -0.000976 485.1100n -0.001012 485.1200n -0.001048 485.1300n -0.001084 485.1400n -0.001118 485.1500n -0.001152 485.1600n -0.001186 485.1700n -0.001218 485.1800n -0.001250 485.1900n -0.001281 485.2000n -0.001312 485.2100n -0.001341 485.2200n -0.001370 485.2300n -0.001398 485.2400n -0.001425
+ 485.2500n -0.001451 485.2600n -0.001477 485.2700n -0.001501 485.2800n -0.001525 485.2900n -0.001547 485.3000n -0.001569 485.3100n -0.001590 485.3200n -0.001610 485.3300n -0.001629 485.3400n -0.001647 485.3500n -0.001663 485.3600n -0.001679 485.3700n -0.001694 485.3800n -0.001708 485.3900n -0.001721
+ 485.4000n -0.001733 485.4100n -0.001744 485.4200n -0.001754 485.4300n -0.001763 485.4400n -0.001771 485.4500n -0.001777 485.4600n -0.001783 485.4700n -0.001788 485.4800n -0.001792 485.4900n -0.001794 485.5000n -0.001796 485.5100n -0.001797 485.5200n -0.001796 485.5300n -0.001795 485.5400n -0.001792
+ 485.5500n -0.001789 485.5600n -0.001785 485.5700n -0.001779 485.5800n -0.001773 485.5900n -0.001766 485.6000n -0.001757 485.6100n -0.001748 485.6200n -0.001738 485.6300n -0.001727 485.6400n -0.001715 485.6500n -0.001702 485.6600n -0.001688 485.6700n -0.001673 485.6800n -0.001657 485.6900n -0.001641
+ 485.7000n -0.001623 485.7100n -0.001605 485.7200n -0.001586 485.7300n -0.001566 485.7400n -0.001546 485.7500n -0.001524 485.7600n -0.001502 485.7700n -0.001480 485.7800n -0.001456 485.7900n -0.001432 485.8000n -0.001407 485.8100n -0.001381 485.8200n -0.001355 485.8300n -0.001328 485.8400n -0.001301
+ 485.8500n -0.001273 485.8600n -0.001244 485.8700n -0.001215 485.8800n -0.001185 485.8900n -0.001155 485.9000n -0.001125 485.9100n -0.001094 485.9200n -0.001062 485.9300n -0.001030 485.9400n -0.000998 485.9500n -0.000965 485.9600n -0.000932 485.9700n -0.000899 485.9800n -0.000866 485.9900n -0.000832
+ 486.0000n -0.000798 486.0100n -0.000764 486.0200n -0.000729 486.0300n -0.000694 486.0400n -0.000660 486.0500n -0.000625 486.0600n -0.000590 486.0700n -0.000555 486.0800n -0.000519 486.0900n -0.000484 486.1000n -0.000449 486.1100n -0.000414 486.1200n -0.000379 486.1300n -0.000343 486.1400n -0.000308
+ 486.1500n -0.000274 486.1600n -0.000239 486.1700n -0.000204 486.1800n -0.000170 486.1900n -0.000135 486.2000n -0.000101 486.2100n -0.000067 486.2200n -0.000034 486.2300n -0.000000 486.2400n 0.000033 486.2500n 0.000066 486.2600n 0.000098 486.2700n 0.000130 486.2800n 0.000162 486.2900n 0.000193
+ 486.3000n 0.000224 486.3100n 0.000255 486.3200n 0.000285 486.3300n 0.000314 486.3400n 0.000343 486.3500n 0.000372 486.3600n 0.000400 486.3700n 0.000428 486.3800n 0.000455 486.3900n 0.000481 486.4000n 0.000507 486.4100n 0.000533 486.4200n 0.000558 486.4300n 0.000582 486.4400n 0.000606
+ 486.4500n 0.000629 486.4600n 0.000651 486.4700n 0.000673 486.4800n 0.000694 486.4900n 0.000714 486.5000n 0.000734 486.5100n 0.000753 486.5200n 0.000772 486.5300n 0.000789 486.5400n 0.000806 486.5500n 0.000823 486.5600n 0.000838 486.5700n 0.000853 486.5800n 0.000867 486.5900n 0.000881
+ 486.6000n 0.000893 486.6100n 0.000905 486.6200n 0.000916 486.6300n 0.000927 486.6400n 0.000937 486.6500n 0.000946 486.6600n 0.000954 486.6700n 0.000961 486.6800n 0.000968 486.6900n 0.000974 486.7000n 0.000980 486.7100n 0.000984 486.7200n 0.000988 486.7300n 0.000991 486.7400n 0.000993
+ 486.7500n 0.000995 486.7600n 0.000996 486.7700n 0.000996 486.7800n 0.000996 486.7900n 0.000994 486.8000n 0.000992 486.8100n 0.000990 486.8200n 0.000987 486.8300n 0.000983 486.8400n 0.000978 486.8500n 0.000973 486.8600n 0.000967 486.8700n 0.000960 486.8800n 0.000953 486.8900n 0.000945
+ 486.9000n 0.000937 486.9100n 0.000927 486.9200n 0.000918 486.9300n 0.000907 486.9400n 0.000897 486.9500n 0.000885 486.9600n 0.000873 486.9700n 0.000861 486.9800n 0.000848 486.9900n 0.000834 487.0000n 0.000820 487.0100n 0.000806 487.0200n 0.000791 487.0300n 0.000775 487.0400n 0.000759
+ 487.0500n 0.000743 487.0600n 0.000726 487.0700n 0.000709 487.0800n 0.000692 487.0900n 0.000674 487.1000n 0.000655 487.1100n 0.000637 487.1200n 0.000618 487.1300n 0.000599 487.1400n 0.000579 487.1500n 0.000559 487.1600n 0.000539 487.1700n 0.000519 487.1800n 0.000498 487.1900n 0.000477
+ 487.2000n 0.000456 487.2100n 0.000435 487.2200n 0.000414 487.2300n 0.000392 487.2400n 0.000371 487.2500n 0.000349 487.2600n 0.000327 487.2700n 0.000305 487.2800n 0.000283 487.2900n 0.000261 487.3000n 0.000239 487.3100n 0.000216 487.3200n 0.000194 487.3300n 0.000172 487.3400n 0.000150
+ 487.3500n 0.000128 487.3600n 0.000106 487.3700n 0.000084 487.3800n 0.000062 487.3900n 0.000040 487.4000n 0.000018 487.4100n -0.000004 487.4200n -0.000025 487.4300n -0.000047 487.4400n -0.000068 487.4500n -0.000089 487.4600n -0.000110 487.4700n -0.000130 487.4800n -0.000151 487.4900n -0.000171
+ 487.5000n -0.000191 487.5100n -0.000211 487.5200n -0.000230 487.5300n -0.000250 487.5400n -0.000268 487.5500n -0.000287 487.5600n -0.000305 487.5700n -0.000323 487.5800n -0.000341 487.5900n -0.000358 487.6000n -0.000375 487.6100n -0.000392 487.6200n -0.000408 487.6300n -0.000424 487.6400n -0.000440
+ 487.6500n -0.000455 487.6600n -0.000469 487.6700n -0.000484 487.6800n -0.000498 487.6900n -0.000511 487.7000n -0.000524 487.7100n -0.000537 487.7200n -0.000549 487.7300n -0.000560 487.7400n -0.000572 487.7500n -0.000583 487.7600n -0.000593 487.7700n -0.000603 487.7800n -0.000612 487.7900n -0.000621
+ 487.8000n -0.000629 487.8100n -0.000637 487.8200n -0.000645 487.8300n -0.000652 487.8400n -0.000658 487.8500n -0.000664 487.8600n -0.000670 487.8700n -0.000675 487.8800n -0.000679 487.8900n -0.000683 487.9000n -0.000687 487.9100n -0.000690 487.9200n -0.000692 487.9300n -0.000694 487.9400n -0.000696
+ 487.9500n -0.000697 487.9600n -0.000697 487.9700n -0.000697 487.9800n -0.000697 487.9900n -0.000696 488.0000n -0.000694 488.0100n -0.000692 488.0200n -0.000690 488.0300n -0.000687 488.0400n -0.000683 488.0500n -0.000679 488.0600n -0.000675 488.0700n -0.000670 488.0800n -0.000665 488.0900n -0.000659
+ 488.1000n -0.000653 488.1100n -0.000646 488.1200n -0.000639 488.1300n -0.000631 488.1400n -0.000623 488.1500n -0.000615 488.1600n -0.000606 488.1700n -0.000597 488.1800n -0.000587 488.1900n -0.000577 488.2000n -0.000567 488.2100n -0.000556 488.2200n -0.000544 488.2300n -0.000533 488.2400n -0.000521
+ 488.2500n -0.000508 488.2600n -0.000495 488.2700n -0.000482 488.2800n -0.000469 488.2900n -0.000455 488.3000n -0.000441 488.3100n -0.000426 488.3200n -0.000412 488.3300n -0.000396 488.3400n -0.000381 488.3500n -0.000365 488.3600n -0.000349 488.3700n -0.000333 488.3800n -0.000317 488.3900n -0.000300
+ 488.4000n -0.000283 488.4100n -0.000266 488.4200n -0.000248 488.4300n -0.000230 488.4400n -0.000212 488.4500n -0.000194 488.4600n -0.000176 488.4700n -0.000157 488.4800n -0.000139 488.4900n -0.000120 488.5000n -0.000101 488.5100n -0.000081 488.5200n -0.000062 488.5300n -0.000043 488.5400n -0.000023
+ 488.5500n -0.000003 488.5600n 0.000017 488.5700n 0.000037 488.5800n 0.000057 488.5900n 0.000077 488.6000n 0.000097 488.6100n 0.000118 488.6200n 0.000138 488.6300n 0.000158 488.6400n 0.000179 488.6500n 0.000199 488.6600n 0.000220 488.6700n 0.000241 488.6800n 0.000261 488.6900n 0.000282
+ 488.7000n 0.000302 488.7100n 0.000323 488.7200n 0.000344 488.7300n 0.000364 488.7400n 0.000385 488.7500n 0.000405 488.7600n 0.000426 488.7700n 0.000446 488.7800n 0.000467 488.7900n 0.000487 488.8000n 0.000507 488.8100n 0.000527 488.8200n 0.000547 488.8300n 0.000567 488.8400n 0.000587
+ 488.8500n 0.000607 488.8600n 0.000627 488.8700n 0.000646 488.8800n 0.000666 488.8900n 0.000685 488.9000n 0.000704 488.9100n 0.000723 488.9200n 0.000742 488.9300n 0.000761 488.9400n 0.000780 488.9500n 0.000798 488.9600n 0.000816 488.9700n 0.000834 488.9800n 0.000852 488.9900n 0.000870
+ 489.0000n 0.000888 489.0100n 0.000905 489.0200n 0.000922 489.0300n 0.000939 489.0400n 0.000956 489.0500n 0.000973 489.0600n 0.000989 489.0700n 0.001005 489.0800n 0.001021 489.0900n 0.001037 489.1000n 0.001052 489.1100n 0.001068 489.1200n 0.001083 489.1300n 0.001098 489.1400n 0.001112
+ 489.1500n 0.001126 489.1600n 0.001140 489.1700n 0.001154 489.1800n 0.001168 489.1900n 0.001181 489.2000n 0.001194 489.2100n 0.001207 489.2200n 0.001220 489.2300n 0.001232 489.2400n 0.001244 489.2500n 0.001256 489.2600n 0.001267 489.2700n 0.001279 489.2800n 0.001290 489.2900n 0.001300
+ 489.3000n 0.001311 489.3100n 0.001321 489.3200n 0.001331 489.3300n 0.001340 489.3400n 0.001350 489.3500n 0.001359 489.3600n 0.001367 489.3700n 0.001376 489.3800n 0.001384 489.3900n 0.001392 489.4000n 0.001400 489.4100n 0.001407 489.4200n 0.001414 489.4300n 0.001421 489.4400n 0.001427
+ 489.4500n 0.001433 489.4600n 0.001439 489.4700n 0.001445 489.4800n 0.001450 489.4900n 0.001455 489.5000n 0.001460 489.5100n 0.001464 489.5200n 0.001468 489.5300n 0.001472 489.5400n 0.001476 489.5500n 0.001479 489.5600n 0.001482 489.5700n 0.001485 489.5800n 0.001487 489.5900n 0.001489
+ 489.6000n 0.001491 489.6100n 0.001493 489.6200n 0.001494 489.6300n 0.001495 489.6400n 0.001496 489.6500n 0.001496 489.6600n 0.001496 489.6700n 0.001496 489.6800n 0.001496 489.6900n 0.001495 489.7000n 0.001494 489.7100n 0.001493 489.7200n 0.001491 489.7300n 0.001489 489.7400n 0.001487
+ 489.7500n 0.001485 489.7600n 0.001482 489.7700n 0.001479 489.7800n 0.001476 489.7900n 0.001473 489.8000n 0.001469 489.8100n 0.001465 489.8200n 0.001461 489.8300n 0.001456 489.8400n 0.001452 489.8500n 0.001447 489.8600n 0.001441 489.8700n 0.001436 489.8800n 0.001430 489.8900n 0.001424
+ 489.9000n 0.001418 489.9100n 0.001411 489.9200n 0.001405 489.9300n 0.001398 489.9400n 0.001391 489.9500n 0.001383 489.9600n 0.001375 489.9700n 0.001368 489.9800n 0.001359 489.9900n 0.001351 490.0000n 0.001342 490.0100n 0.001334 490.0200n 0.001325 490.0300n 0.001315 490.0400n 0.001306
+ 490.0500n 0.001296 490.0600n 0.001286 490.0700n 0.001276 490.0800n 0.001266 490.0900n 0.001256 490.1000n 0.001245 490.1100n 0.001234 490.1200n 0.001223 490.1300n 0.001212 490.1400n 0.001200 490.1500n 0.001189 490.1600n 0.001177 490.1700n 0.001165 490.1800n 0.001153 490.1900n 0.001141
+ 490.2000n 0.001128 490.2100n 0.001116 490.2200n 0.001103 490.2300n 0.001090 490.2400n 0.001077 490.2500n 0.001064 490.2600n 0.001051 490.2700n 0.001037 490.2800n 0.001024 490.2900n 0.001010 490.3000n 0.000996 490.3100n 0.000982 490.3200n 0.000968 490.3300n 0.000954 490.3400n 0.000939
+ 490.3500n 0.000925 490.3600n 0.000911 490.3700n 0.000896 490.3800n 0.000881 490.3900n 0.000867 490.4000n 0.000852 490.4100n 0.000837 490.4200n 0.000822 490.4300n 0.000807 490.4400n 0.000791 490.4500n 0.000776 490.4600n 0.000761 490.4700n 0.000746 490.4800n 0.000730 490.4900n 0.000715
+ 490.5000n 0.000699 490.5100n 0.000684 490.5200n 0.000669 490.5300n 0.000653 490.5400n 0.000637 490.5500n 0.000622 490.5600n 0.000606 490.5700n 0.000591 490.5800n 0.000575 490.5900n 0.000560 490.6000n 0.000544 490.6100n 0.000528 490.6200n 0.000513 490.6300n 0.000497 490.6400n 0.000482
+ 490.6500n 0.000466 490.6600n 0.000451 490.6700n 0.000436 490.6800n 0.000420 490.6900n 0.000405 490.7000n 0.000390 490.7100n 0.000375 490.7200n 0.000360 490.7300n 0.000345 490.7400n 0.000330 490.7500n 0.000315 490.7600n 0.000300 490.7700n 0.000285 490.7800n 0.000271 490.7900n 0.000256
+ 490.8000n 0.000242 490.8100n 0.000227 490.8200n 0.000213 490.8300n 0.000199 490.8400n 0.000185 490.8500n 0.000171 490.8600n 0.000158 490.8700n 0.000144 490.8800n 0.000131 490.8900n 0.000117 490.9000n 0.000104 490.9100n 0.000091 490.9200n 0.000078 490.9300n 0.000066 490.9400n 0.000053
+ 490.9500n 0.000041 490.9600n 0.000029 490.9700n 0.000016 490.9800n 0.000005 490.9900n -0.000007 491.0000n -0.000019 491.0100n -0.000030 491.0200n -0.000041 491.0300n -0.000052 491.0400n -0.000063 491.0500n -0.000073 491.0600n -0.000084 491.0700n -0.000094 491.0800n -0.000104 491.0900n -0.000113
+ 491.1000n -0.000123 491.1100n -0.000132 491.1200n -0.000141 491.1300n -0.000150 491.1400n -0.000159 491.1500n -0.000167 491.1600n -0.000175 491.1700n -0.000183 491.1800n -0.000191 491.1900n -0.000198 491.2000n -0.000206 491.2100n -0.000213 491.2200n -0.000219 491.2300n -0.000226 491.2400n -0.000232
+ 491.2500n -0.000238 491.2600n -0.000244 491.2700n -0.000250 491.2800n -0.000255 491.2900n -0.000260 491.3000n -0.000265 491.3100n -0.000270 491.3200n -0.000274 491.3300n -0.000278 491.3400n -0.000282 491.3500n -0.000285 491.3600n -0.000289 491.3700n -0.000292 491.3800n -0.000295 491.3900n -0.000297
+ 491.4000n -0.000300 491.4100n -0.000302 491.4200n -0.000304 491.4300n -0.000305 491.4400n -0.000307 491.4500n -0.000308 491.4600n -0.000309 491.4700n -0.000309 491.4800n -0.000310 491.4900n -0.000310 491.5000n -0.000310 491.5100n -0.000310 491.5200n -0.000309 491.5300n -0.000308 491.5400n -0.000307
+ 491.5500n -0.000306 491.5600n -0.000305 491.5700n -0.000303 491.5800n -0.000301 491.5900n -0.000299 491.6000n -0.000297 491.6100n -0.000294 491.6200n -0.000292 491.6300n -0.000289 491.6400n -0.000286 491.6500n -0.000282 491.6600n -0.000279 491.6700n -0.000275 491.6800n -0.000271 491.6900n -0.000267
+ 491.7000n -0.000263 491.7100n -0.000258 491.7200n -0.000253 491.7300n -0.000249 491.7400n -0.000244 491.7500n -0.000238 491.7600n -0.000233 491.7700n -0.000228 491.7800n -0.000222 491.7900n -0.000216 491.8000n -0.000210 491.8100n -0.000204 491.8200n -0.000198 491.8300n -0.000191 491.8400n -0.000185
+ 491.8500n -0.000178 491.8600n -0.000172 491.8700n -0.000165 491.8800n -0.000158 491.8900n -0.000151 491.9000n -0.000144 491.9100n -0.000136 491.9200n -0.000129 491.9300n -0.000122 491.9400n -0.000114 491.9500n -0.000106 491.9600n -0.000099 491.9700n -0.000091 491.9800n -0.000083 491.9900n -0.000075
+ 492.0000n -0.000067 492.0100n -0.000059 492.0200n -0.000051 492.0300n -0.000043 492.0400n -0.000035 492.0500n -0.000027 492.0600n -0.000019 492.0700n -0.000011 492.0800n -0.000003 492.0900n 0.000005 492.1000n 0.000014 492.1100n 0.000022 492.1200n 0.000030 492.1300n 0.000038 492.1400n 0.000046
+ 492.1500n 0.000054 492.1600n 0.000062 492.1700n 0.000070 492.1800n 0.000079 492.1900n 0.000086 492.2000n 0.000094 492.2100n 0.000102 492.2200n 0.000110 492.2300n 0.000118 492.2400n 0.000126 492.2500n 0.000133 492.2600n 0.000141 492.2700n 0.000148 492.2800n 0.000156 492.2900n 0.000163
+ 492.3000n 0.000170 492.3100n 0.000177 492.3200n 0.000184 492.3300n 0.000191 492.3400n 0.000198 492.3500n 0.000205 492.3600n 0.000211 492.3700n 0.000218 492.3800n 0.000224 492.3900n 0.000230 492.4000n 0.000236 492.4100n 0.000242 492.4200n 0.000248 492.4300n 0.000254 492.4400n 0.000259
+ 492.4500n 0.000264 492.4600n 0.000270 492.4700n 0.000275 492.4800n 0.000280 492.4900n 0.000284 492.5000n 0.000289 492.5100n 0.000293 492.5200n 0.000297 492.5300n 0.000302 492.5400n 0.000305 492.5500n 0.000309 492.5600n 0.000313 492.5700n 0.000316 492.5800n 0.000319 492.5900n 0.000322
+ 492.6000n 0.000325 492.6100n 0.000328 492.6200n 0.000330 492.6300n 0.000332 492.6400n 0.000334 492.6500n 0.000336 492.6600n 0.000338 492.6700n 0.000339 492.6800n 0.000340 492.6900n 0.000341 492.7000n 0.000342 492.7100n 0.000343 492.7200n 0.000343 492.7300n 0.000344 492.7400n 0.000344
+ 492.7500n 0.000344 492.7600n 0.000343 492.7700n 0.000343 492.7800n 0.000342 492.7900n 0.000341 492.8000n 0.000340 492.8100n 0.000339 492.8200n 0.000337 492.8300n 0.000335 492.8400n 0.000333 492.8500n 0.000331 492.8600n 0.000329 492.8700n 0.000326 492.8800n 0.000324 492.8900n 0.000321
+ 492.9000n 0.000318 492.9100n 0.000314 492.9200n 0.000311 492.9300n 0.000307 492.9400n 0.000304 492.9500n 0.000300 492.9600n 0.000295 492.9700n 0.000291 492.9800n 0.000286 492.9900n 0.000282 493.0000n 0.000277 493.0100n 0.000272 493.0200n 0.000267 493.0300n 0.000261 493.0400n 0.000256
+ 493.0500n 0.000250 493.0600n 0.000244 493.0700n 0.000238 493.0800n 0.000232 493.0900n 0.000226 493.1000n 0.000220 493.1100n 0.000213 493.1200n 0.000206 493.1300n 0.000200 493.1400n 0.000193 493.1500n 0.000186 493.1600n 0.000179 493.1700n 0.000171 493.1800n 0.000164 493.1900n 0.000156
+ 493.2000n 0.000149 493.2100n 0.000141 493.2200n 0.000134 493.2300n 0.000126 493.2400n 0.000118 493.2500n 0.000110 493.2600n 0.000102 493.2700n 0.000094 493.2800n 0.000085 493.2900n 0.000077 493.3000n 0.000069 493.3100n 0.000061 493.3200n 0.000052 493.3300n 0.000044 493.3400n 0.000035
+ 493.3500n 0.000027 493.3600n 0.000018 493.3700n 0.000010 493.3800n 0.000001 493.3900n -0.000007 493.4000n -0.000016 493.4100n -0.000024 493.4200n -0.000033 493.4300n -0.000041 493.4400n -0.000050 493.4500n -0.000058 493.4600n -0.000066 493.4700n -0.000075 493.4800n -0.000083 493.4900n -0.000091
+ 493.5000n -0.000100 493.5100n -0.000108 493.5200n -0.000116 493.5300n -0.000124 493.5400n -0.000132 493.5500n -0.000140 493.5600n -0.000148 493.5700n -0.000155 493.5800n -0.000163 493.5900n -0.000171 493.6000n -0.000178 493.6100n -0.000185 493.6200n -0.000192 493.6300n -0.000199 493.6400n -0.000206
+ 493.6500n -0.000213 493.6600n -0.000220 493.6700n -0.000226 493.6800n -0.000233 493.6900n -0.000239 493.7000n -0.000245 493.7100n -0.000251 493.7200n -0.000257 493.7300n -0.000262 493.7400n -0.000268 493.7500n -0.000273 493.7600n -0.000278 493.7700n -0.000283 493.7800n -0.000287 493.7900n -0.000292
+ 493.8000n -0.000296 493.8100n -0.000300 493.8200n -0.000304 493.8300n -0.000308 493.8400n -0.000311 493.8500n -0.000314 493.8600n -0.000317 493.8700n -0.000320 493.8800n -0.000322 493.8900n -0.000325 493.9000n -0.000327 493.9100n -0.000329 493.9200n -0.000330 493.9300n -0.000332 493.9400n -0.000333
+ 493.9500n -0.000333 493.9600n -0.000334 493.9700n -0.000334 493.9800n -0.000334 493.9900n -0.000334 494.0000n -0.000334 494.0100n -0.000333 494.0200n -0.000332 494.0300n -0.000331 494.0400n -0.000330 494.0500n -0.000328 494.0600n -0.000326 494.0700n -0.000324 494.0800n -0.000321 494.0900n -0.000318
+ 494.1000n -0.000315 494.1100n -0.000312 494.1200n -0.000308 494.1300n -0.000305 494.1400n -0.000301 494.1500n -0.000296 494.1600n -0.000292 494.1700n -0.000287 494.1800n -0.000282 494.1900n -0.000276 494.2000n -0.000270 494.2100n -0.000265 494.2200n -0.000258 494.2300n -0.000252 494.2400n -0.000245
+ 494.2500n -0.000238 494.2600n -0.000231 494.2700n -0.000224 494.2800n -0.000216 494.2900n -0.000208 494.3000n -0.000200 494.3100n -0.000192 494.3200n -0.000183 494.3300n -0.000175 494.3400n -0.000166 494.3500n -0.000156 494.3600n -0.000147 494.3700n -0.000137 494.3800n -0.000128 494.3900n -0.000118
+ 494.4000n -0.000107 494.4100n -0.000097 494.4200n -0.000086 494.4300n -0.000076 494.4400n -0.000065 494.4500n -0.000054 494.4600n -0.000042 494.4700n -0.000031 494.4800n -0.000020 494.4900n -0.000008 494.5000n 0.000004 494.5100n 0.000016 494.5200n 0.000028 494.5300n 0.000040 494.5400n 0.000052
+ 494.5500n 0.000064 494.5600n 0.000077 494.5700n 0.000089 494.5800n 0.000102 494.5900n 0.000114 494.6000n 0.000127 494.6100n 0.000140 494.6200n 0.000153 494.6300n 0.000165 494.6400n 0.000178 494.6500n 0.000191 494.6600n 0.000204 494.6700n 0.000217 494.6800n 0.000230 494.6900n 0.000242
+ 494.7000n 0.000255 494.7100n 0.000268 494.7200n 0.000281 494.7300n 0.000293 494.7400n 0.000306 494.7500n 0.000318 494.7600n 0.000331 494.7700n 0.000343 494.7800n 0.000355 494.7900n 0.000367 494.8000n 0.000379 494.8100n 0.000391 494.8200n 0.000403 494.8300n 0.000414 494.8400n 0.000426
+ 494.8500n 0.000437 494.8600n 0.000448 494.8700n 0.000459 494.8800n 0.000469 494.8900n 0.000480 494.9000n 0.000490 494.9100n 0.000500 494.9200n 0.000510 494.9300n 0.000519 494.9400n 0.000528 494.9500n 0.000537 494.9600n 0.000546 494.9700n 0.000554 494.9800n 0.000563 494.9900n 0.000570
+ 495.0000n 0.000578 495.0100n 0.000585 495.0200n 0.000592 495.0300n 0.000598 495.0400n 0.000605 495.0500n 0.000610 495.0600n 0.000616 495.0700n 0.000621 495.0800n 0.000626 495.0900n 0.000630 495.1000n 0.000634 495.1100n 0.000638 495.1200n 0.000641 495.1300n 0.000643 495.1400n 0.000646
+ 495.1500n 0.000648 495.1600n 0.000649 495.1700n 0.000650 495.1800n 0.000650 495.1900n 0.000651 495.2000n 0.000650 495.2100n 0.000649 495.2200n 0.000648 495.2300n 0.000646 495.2400n 0.000644 495.2500n 0.000641 495.2600n 0.000638 495.2700n 0.000634 495.2800n 0.000630 495.2900n 0.000625
+ 495.3000n 0.000620 495.3100n 0.000614 495.3200n 0.000608 495.3300n 0.000601 495.3400n 0.000594 495.3500n 0.000586 495.3600n 0.000578 495.3700n 0.000569 495.3800n 0.000559 495.3900n 0.000549 495.4000n 0.000539 495.4100n 0.000528 495.4200n 0.000517 495.4300n 0.000505 495.4400n 0.000492
+ 495.4500n 0.000479 495.4600n 0.000465 495.4700n 0.000451 495.4800n 0.000437 495.4900n 0.000422 495.5000n 0.000406 495.5100n 0.000390 495.5200n 0.000373 495.5300n 0.000356 495.5400n 0.000338 495.5500n 0.000320 495.5600n 0.000302 495.5700n 0.000283 495.5800n 0.000263 495.5900n 0.000243
+ 495.6000n 0.000222 495.6100n 0.000201 495.6200n 0.000180 495.6300n 0.000158 495.6400n 0.000136 495.6500n 0.000113 495.6600n 0.000090 495.6700n 0.000066 495.6800n 0.000042 495.6900n 0.000018 495.7000n -0.000007 495.7100n -0.000032 495.7200n -0.000058 495.7300n -0.000084 495.7400n -0.000110
+ 495.7500n -0.000137 495.7600n -0.000164 495.7700n -0.000191 495.7800n -0.000218 495.7900n -0.000246 495.8000n -0.000274 495.8100n -0.000303 495.8200n -0.000331 495.8300n -0.000360 495.8400n -0.000390 495.8500n -0.000419 495.8600n -0.000448 495.8700n -0.000478 495.8800n -0.000508 495.8900n -0.000538
+ 495.9000n -0.000568 495.9100n -0.000599 495.9200n -0.000629 495.9300n -0.000660 495.9400n -0.000691 495.9500n -0.000721 495.9600n -0.000752 495.9700n -0.000783 495.9800n -0.000814 495.9900n -0.000845 496.0000n -0.000876 496.0100n -0.000907 496.0200n -0.000938 496.0300n -0.000969 496.0400n -0.000999
+ 496.0500n -0.001030 496.0600n -0.001060 496.0700n -0.001091 496.0800n -0.001121 496.0900n -0.001151 496.1000n -0.001181 496.1100n -0.001211 496.1200n -0.001241 496.1300n -0.001270 496.1400n -0.001299 496.1500n -0.001328 496.1600n -0.001357 496.1700n -0.001385 496.1800n -0.001413 496.1900n -0.001441
+ 496.2000n -0.001468 496.2100n -0.001495 496.2200n -0.001522 496.2300n -0.001548 496.2400n -0.001574 496.2500n -0.001600 496.2600n -0.001625 496.2700n -0.001649 496.2800n -0.001673 496.2900n -0.001697 496.3000n -0.001720 496.3100n -0.001743 496.3200n -0.001765 496.3300n -0.001787 496.3400n -0.001808
+ 496.3500n -0.001828 496.3600n -0.001848 496.3700n -0.001867 496.3800n -0.001886 496.3900n -0.001904 496.4000n -0.001922 496.4100n -0.001938 496.4200n -0.001955 496.4300n -0.001970 496.4400n -0.001985 496.4500n -0.001999 496.4600n -0.002013 496.4700n -0.002025 496.4800n -0.002037 496.4900n -0.002048
+ 496.5000n -0.002059 496.5100n -0.002069 496.5200n -0.002078 496.5300n -0.002086 496.5400n -0.002093 496.5500n -0.002100 496.5600n -0.002106 496.5700n -0.002111 496.5800n -0.002115 496.5900n -0.002119 496.6000n -0.002122 496.6100n -0.002123 496.6200n -0.002124 496.6300n -0.002125 496.6400n -0.002124
+ 496.6500n -0.002122 496.6600n -0.002120 496.6700n -0.002117 496.6800n -0.002113 496.6900n -0.002108 496.7000n -0.002102 496.7100n -0.002096 496.7200n -0.002088 496.7300n -0.002080 496.7400n -0.002071 496.7500n -0.002061 496.7600n -0.002050 496.7700n -0.002039 496.7800n -0.002026 496.7900n -0.002013
+ 496.8000n -0.001999 496.8100n -0.001984 496.8200n -0.001968 496.8300n -0.001951 496.8400n -0.001934 496.8500n -0.001916 496.8600n -0.001897 496.8700n -0.001877 496.8800n -0.001856 496.8900n -0.001835 496.9000n -0.001813 496.9100n -0.001790 496.9200n -0.001766 496.9300n -0.001742 496.9400n -0.001717
+ 496.9500n -0.001691 496.9600n -0.001665 496.9700n -0.001637 496.9800n -0.001609 496.9900n -0.001581 497.0000n -0.001552 497.0100n -0.001522 497.0200n -0.001491 497.0300n -0.001460 497.0400n -0.001428 497.0500n -0.001396 497.0600n -0.001363 497.0700n -0.001329 497.0800n -0.001295 497.0900n -0.001261
+ 497.1000n -0.001225 497.1100n -0.001190 497.1200n -0.001154 497.1300n -0.001117 497.1400n -0.001080 497.1500n -0.001043 497.1600n -0.001005 497.1700n -0.000966 497.1800n -0.000928 497.1900n -0.000889 497.2000n -0.000849 497.2100n -0.000810 497.2200n -0.000770 497.2300n -0.000730 497.2400n -0.000689
+ 497.2500n -0.000648 497.2600n -0.000607 497.2700n -0.000566 497.2800n -0.000525 497.2900n -0.000483 497.3000n -0.000441 497.3100n -0.000399 497.3200n -0.000357 497.3300n -0.000315 497.3400n -0.000273 497.3500n -0.000231 497.3600n -0.000189 497.3700n -0.000147 497.3800n -0.000104 497.3900n -0.000062
+ 497.4000n -0.000020 497.4100n 0.000022 497.4200n 0.000064 497.4300n 0.000106 497.4400n 0.000148 497.4500n 0.000189 497.4600n 0.000231 497.4700n 0.000272 497.4800n 0.000313 497.4900n 0.000354 497.5000n 0.000394 497.5100n 0.000435 497.5200n 0.000475 497.5300n 0.000514 497.5400n 0.000554
+ 497.5500n 0.000593 497.5600n 0.000632 497.5700n 0.000670 497.5800n 0.000708 497.5900n 0.000746 497.6000n 0.000783 497.6100n 0.000820 497.6200n 0.000856 497.6300n 0.000892 497.6400n 0.000927 497.6500n 0.000962 497.6600n 0.000996 497.6700n 0.001030 497.6800n 0.001064 497.6900n 0.001096
+ 497.7000n 0.001129 497.7100n 0.001160 497.7200n 0.001191 497.7300n 0.001222 497.7400n 0.001252 497.7500n 0.001281 497.7600n 0.001310 497.7700n 0.001338 497.7800n 0.001366 497.7900n 0.001392 497.8000n 0.001418 497.8100n 0.001444 497.8200n 0.001469 497.8300n 0.001493 497.8400n 0.001516
+ 497.8500n 0.001539 497.8600n 0.001561 497.8700n 0.001583 497.8800n 0.001604 497.8900n 0.001624 497.9000n 0.001643 497.9100n 0.001662 497.9200n 0.001679 497.9300n 0.001697 497.9400n 0.001713 497.9500n 0.001729 497.9600n 0.001744 497.9700n 0.001759 497.9800n 0.001772 497.9900n 0.001785
+ 498.0000n 0.001798 498.0100n 0.001809 498.0200n 0.001820 498.0300n 0.001830 498.0400n 0.001840 498.0500n 0.001849 498.0600n 0.001857 498.0700n 0.001864 498.0800n 0.001871 498.0900n 0.001877 498.1000n 0.001883 498.1100n 0.001888 498.1200n 0.001892 498.1300n 0.001896 498.1400n 0.001899
+ 498.1500n 0.001901 498.1600n 0.001903 498.1700n 0.001904 498.1800n 0.001905 498.1900n 0.001905 498.2000n 0.001905 498.2100n 0.001904 498.2200n 0.001902 498.2300n 0.001900 498.2400n 0.001898 498.2500n 0.001895 498.2600n 0.001891 498.2700n 0.001887 498.2800n 0.001883 498.2900n 0.001878
+ 498.3000n 0.001873 498.3100n 0.001867 498.3200n 0.001861 498.3300n 0.001855 498.3400n 0.001848 498.3500n 0.001841 498.3600n 0.001834 498.3700n 0.001826 498.3800n 0.001818 498.3900n 0.001810 498.4000n 0.001802 498.4100n 0.001793 498.4200n 0.001784 498.4300n 0.001775 498.4400n 0.001766
+ 498.4500n 0.001756 498.4600n 0.001746 498.4700n 0.001737 498.4800n 0.001727 498.4900n 0.001717 498.5000n 0.001707 498.5100n 0.001697 498.5200n 0.001687 498.5300n 0.001676 498.5400n 0.001666 498.5500n 0.001656 498.5600n 0.001646 498.5700n 0.001636 498.5800n 0.001626 498.5900n 0.001616
+ 498.6000n 0.001606 498.6100n 0.001596 498.6200n 0.001587 498.6300n 0.001577 498.6400n 0.001568 498.6500n 0.001559 498.6600n 0.001550 498.6700n 0.001541 498.6800n 0.001532 498.6900n 0.001524 498.7000n 0.001516 498.7100n 0.001508 498.7200n 0.001501 498.7300n 0.001494 498.7400n 0.001487
+ 498.7500n 0.001480 498.7600n 0.001474 498.7700n 0.001468 498.7800n 0.001463 498.7900n 0.001458 498.8000n 0.001453 498.8100n 0.001448 498.8200n 0.001445 498.8300n 0.001441 498.8400n 0.001438 498.8500n 0.001435 498.8600n 0.001433 498.8700n 0.001431 498.8800n 0.001430 498.8900n 0.001429
+ 498.9000n 0.001429 498.9100n 0.001429 498.9200n 0.001429 498.9300n 0.001430 498.9400n 0.001432 498.9500n 0.001434 498.9600n 0.001437 498.9700n 0.001440 498.9800n 0.001443 498.9900n 0.001447 499.0000n 0.001452 499.0100n 0.001457 499.0200n 0.001463 499.0300n 0.001469 499.0400n 0.001476
+ 499.0500n 0.001483 499.0600n 0.001491 499.0700n 0.001499 499.0800n 0.001508 499.0900n 0.001517 499.1000n 0.001527 499.1100n 0.001537 499.1200n 0.001548 499.1300n 0.001559 499.1400n 0.001571 499.1500n 0.001583 499.1600n 0.001596 499.1700n 0.001609 499.1800n 0.001623 499.1900n 0.001637
+ 499.2000n 0.001651 499.2100n 0.001666 499.2200n 0.001682 499.2300n 0.001697 499.2400n 0.001714 499.2500n 0.001730 499.2600n 0.001747 499.2700n 0.001765 499.2800n 0.001783 499.2900n 0.001801 499.3000n 0.001819 499.3100n 0.001838 499.3200n 0.001857 499.3300n 0.001876 499.3400n 0.001896
+ 499.3500n 0.001916 499.3600n 0.001936 499.3700n 0.001957 499.3800n 0.001978 499.3900n 0.001999 499.4000n 0.002020 499.4100n 0.002041 499.4200n 0.002062 499.4300n 0.002084 499.4400n 0.002106 499.4500n 0.002128 499.4600n 0.002150 499.4700n 0.002172 499.4800n 0.002194 499.4900n 0.002216
+ 499.5000n 0.002238 499.5100n 0.002260 499.5200n 0.002282 499.5300n 0.002305 499.5400n 0.002327 499.5500n 0.002349 499.5600n 0.002371 499.5700n 0.002393 499.5800n 0.002414 499.5900n 0.002436 499.6000n 0.002457 499.6100n 0.002479 499.6200n 0.002500 499.6300n 0.002521 499.6400n 0.002541
+ 499.6500n 0.002562 499.6600n 0.002582 499.6700n 0.002602 499.6800n 0.002621 499.6900n 0.002641 499.7000n 0.002659 499.7100n 0.002678 499.7200n 0.002696 499.7300n 0.002714 499.7400n 0.002731 499.7500n 0.002748 499.7600n 0.002765 499.7700n 0.002781 499.7800n 0.002797 499.7900n 0.002812
+ 499.8000n 0.002827 499.8100n 0.002841 499.8200n 0.002855 499.8300n 0.002868 499.8400n 0.002880 499.8500n 0.002892 499.8600n 0.002904 499.8700n 0.002915 499.8800n 0.002925 499.8900n 0.002935 499.9000n 0.002944 499.9100n 0.002952 499.9200n 0.002960 499.9300n 0.002967 499.9400n 0.002973
+ 499.9500n 0.002979 499.9600n 0.002984 499.9700n 0.002989 499.9800n 0.002992 499.9900n 0.002995 500.0000n 0.002998 500.0100n 0.002999 500.0200n 0.003000 500.0300n 0.003000 500.0400n 0.003000 )
V_NOISE_N b1_src b_cm DC 0 PWL ( 0.0000n -0.001153 0.0100n -0.001132 0.0200n -0.001109 0.0300n -0.001087 0.0400n -0.001064 0.0500n -0.001040 0.0600n -0.001016 0.0700n -0.000992 0.0800n -0.000967 0.0900n -0.000942 0.1000n -0.000917 0.1100n -0.000891 0.1200n -0.000866 0.1300n -0.000839 0.1400n -0.000813
+ 0.1500n -0.000786 0.1600n -0.000759 0.1700n -0.000732 0.1800n -0.000705 0.1900n -0.000678 0.2000n -0.000650 0.2100n -0.000622 0.2200n -0.000595 0.2300n -0.000567 0.2400n -0.000539 0.2500n -0.000511 0.2600n -0.000483 0.2700n -0.000455 0.2800n -0.000427 0.2900n -0.000399
+ 0.3000n -0.000371 0.3100n -0.000343 0.3200n -0.000315 0.3300n -0.000287 0.3400n -0.000260 0.3500n -0.000232 0.3600n -0.000205 0.3700n -0.000178 0.3800n -0.000151 0.3900n -0.000124 0.4000n -0.000098 0.4100n -0.000071 0.4200n -0.000045 0.4300n -0.000020 0.4400n 0.000006
+ 0.4500n 0.000031 0.4600n 0.000055 0.4700n 0.000080 0.4800n 0.000104 0.4900n 0.000127 0.5000n 0.000150 0.5100n 0.000173 0.5200n 0.000196 0.5300n 0.000218 0.5400n 0.000239 0.5500n 0.000260 0.5600n 0.000280 0.5700n 0.000300 0.5800n 0.000320 0.5900n 0.000339
+ 0.6000n 0.000357 0.6100n 0.000375 0.6200n 0.000392 0.6300n 0.000409 0.6400n 0.000425 0.6500n 0.000441 0.6600n 0.000456 0.6700n 0.000470 0.6800n 0.000484 0.6900n 0.000497 0.7000n 0.000509 0.7100n 0.000521 0.7200n 0.000532 0.7300n 0.000543 0.7400n 0.000553
+ 0.7500n 0.000562 0.7600n 0.000571 0.7700n 0.000578 0.7800n 0.000586 0.7900n 0.000592 0.8000n 0.000598 0.8100n 0.000603 0.8200n 0.000608 0.8300n 0.000612 0.8400n 0.000615 0.8500n 0.000618 0.8600n 0.000620 0.8700n 0.000621 0.8800n 0.000621 0.8900n 0.000621
+ 0.9000n 0.000620 0.9100n 0.000619 0.9200n 0.000617 0.9300n 0.000614 0.9400n 0.000611 0.9500n 0.000607 0.9600n 0.000602 0.9700n 0.000597 0.9800n 0.000591 0.9900n 0.000585 1.0000n 0.000578 1.0100n 0.000570 1.0200n 0.000562 1.0300n 0.000553 1.0400n 0.000544
+ 1.0500n 0.000534 1.0600n 0.000524 1.0700n 0.000513 1.0800n 0.000502 1.0900n 0.000490 1.1000n 0.000478 1.1100n 0.000465 1.1200n 0.000452 1.1300n 0.000438 1.1400n 0.000424 1.1500n 0.000410 1.1600n 0.000395 1.1700n 0.000380 1.1800n 0.000364 1.1900n 0.000349
+ 1.2000n 0.000332 1.2100n 0.000316 1.2200n 0.000299 1.2300n 0.000282 1.2400n 0.000265 1.2500n 0.000247 1.2600n 0.000230 1.2700n 0.000212 1.2800n 0.000194 1.2900n 0.000175 1.3000n 0.000157 1.3100n 0.000139 1.3200n 0.000120 1.3300n 0.000101 1.3400n 0.000083
+ 1.3500n 0.000064 1.3600n 0.000045 1.3700n 0.000026 1.3800n 0.000007 1.3900n -0.000011 1.4000n -0.000030 1.4100n -0.000049 1.4200n -0.000067 1.4300n -0.000086 1.4400n -0.000104 1.4500n -0.000122 1.4600n -0.000140 1.4700n -0.000158 1.4800n -0.000176 1.4900n -0.000193
+ 1.5000n -0.000211 1.5100n -0.000228 1.5200n -0.000245 1.5300n -0.000261 1.5400n -0.000277 1.5500n -0.000293 1.5600n -0.000309 1.5700n -0.000324 1.5800n -0.000339 1.5900n -0.000353 1.6000n -0.000368 1.6100n -0.000381 1.6200n -0.000395 1.6300n -0.000408 1.6400n -0.000420
+ 1.6500n -0.000432 1.6600n -0.000444 1.6700n -0.000455 1.6800n -0.000466 1.6900n -0.000476 1.7000n -0.000486 1.7100n -0.000495 1.7200n -0.000504 1.7300n -0.000512 1.7400n -0.000519 1.7500n -0.000527 1.7600n -0.000533 1.7700n -0.000539 1.7800n -0.000545 1.7900n -0.000550
+ 1.8000n -0.000554 1.8100n -0.000558 1.8200n -0.000562 1.8300n -0.000564 1.8400n -0.000567 1.8500n -0.000568 1.8600n -0.000569 1.8700n -0.000570 1.8800n -0.000570 1.8900n -0.000569 1.9000n -0.000568 1.9100n -0.000567 1.9200n -0.000564 1.9300n -0.000562 1.9400n -0.000558
+ 1.9500n -0.000554 1.9600n -0.000550 1.9700n -0.000545 1.9800n -0.000540 1.9900n -0.000534 2.0000n -0.000527 2.0100n -0.000520 2.0200n -0.000513 2.0300n -0.000505 2.0400n -0.000497 2.0500n -0.000488 2.0600n -0.000478 2.0700n -0.000469 2.0800n -0.000459 2.0900n -0.000448
+ 2.1000n -0.000437 2.1100n -0.000426 2.1200n -0.000414 2.1300n -0.000402 2.1400n -0.000389 2.1500n -0.000377 2.1600n -0.000364 2.1700n -0.000350 2.1800n -0.000336 2.1900n -0.000322 2.2000n -0.000308 2.2100n -0.000294 2.2200n -0.000279 2.2300n -0.000264 2.2400n -0.000249
+ 2.2500n -0.000234 2.2600n -0.000219 2.2700n -0.000203 2.2800n -0.000188 2.2900n -0.000172 2.3000n -0.000156 2.3100n -0.000140 2.3200n -0.000124 2.3300n -0.000108 2.3400n -0.000092 2.3500n -0.000076 2.3600n -0.000061 2.3700n -0.000045 2.3800n -0.000029 2.3900n -0.000013
+ 2.4000n 0.000002 2.4100n 0.000018 2.4200n 0.000033 2.4300n 0.000048 2.4400n 0.000063 2.4500n 0.000078 2.4600n 0.000092 2.4700n 0.000107 2.4800n 0.000121 2.4900n 0.000135 2.5000n 0.000148 2.5100n 0.000161 2.5200n 0.000174 2.5300n 0.000187 2.5400n 0.000199
+ 2.5500n 0.000211 2.5600n 0.000222 2.5700n 0.000233 2.5800n 0.000244 2.5900n 0.000254 2.6000n 0.000264 2.6100n 0.000273 2.6200n 0.000282 2.6300n 0.000291 2.6400n 0.000299 2.6500n 0.000306 2.6600n 0.000313 2.6700n 0.000319 2.6800n 0.000325 2.6900n 0.000330
+ 2.7000n 0.000335 2.7100n 0.000339 2.7200n 0.000343 2.7300n 0.000346 2.7400n 0.000348 2.7500n 0.000350 2.7600n 0.000352 2.7700n 0.000352 2.7800n 0.000352 2.7900n 0.000352 2.8000n 0.000351 2.8100n 0.000349 2.8200n 0.000347 2.8300n 0.000344 2.8400n 0.000340
+ 2.8500n 0.000336 2.8600n 0.000331 2.8700n 0.000326 2.8800n 0.000320 2.8900n 0.000313 2.9000n 0.000306 2.9100n 0.000298 2.9200n 0.000290 2.9300n 0.000281 2.9400n 0.000271 2.9500n 0.000261 2.9600n 0.000251 2.9700n 0.000239 2.9800n 0.000228 2.9900n 0.000215
+ 3.0000n 0.000202 3.0100n 0.000189 3.0200n 0.000175 3.0300n 0.000161 3.0400n 0.000146 3.0500n 0.000131 3.0600n 0.000115 3.0700n 0.000099 3.0800n 0.000082 3.0900n 0.000065 3.1000n 0.000047 3.1100n 0.000029 3.1200n 0.000011 3.1300n -0.000007 3.1400n -0.000026
+ 3.1500n -0.000045 3.1600n -0.000065 3.1700n -0.000085 3.1800n -0.000105 3.1900n -0.000125 3.2000n -0.000146 3.2100n -0.000166 3.2200n -0.000187 3.2300n -0.000208 3.2400n -0.000229 3.2500n -0.000251 3.2600n -0.000272 3.2700n -0.000294 3.2800n -0.000315 3.2900n -0.000337
+ 3.3000n -0.000358 3.3100n -0.000380 3.3200n -0.000401 3.3300n -0.000422 3.3400n -0.000444 3.3500n -0.000465 3.3600n -0.000486 3.3700n -0.000507 3.3800n -0.000527 3.3900n -0.000548 3.4000n -0.000568 3.4100n -0.000588 3.4200n -0.000608 3.4300n -0.000627 3.4400n -0.000647
+ 3.4500n -0.000665 3.4600n -0.000684 3.4700n -0.000702 3.4800n -0.000719 3.4900n -0.000737 3.5000n -0.000753 3.5100n -0.000770 3.5200n -0.000785 3.5300n -0.000801 3.5400n -0.000815 3.5500n -0.000829 3.5600n -0.000843 3.5700n -0.000856 3.5800n -0.000868 3.5900n -0.000880
+ 3.6000n -0.000891 3.6100n -0.000902 3.6200n -0.000911 3.6300n -0.000920 3.6400n -0.000929 3.6500n -0.000936 3.6600n -0.000943 3.6700n -0.000949 3.6800n -0.000954 3.6900n -0.000959 3.7000n -0.000963 3.7100n -0.000966 3.7200n -0.000968 3.7300n -0.000969 3.7400n -0.000969
+ 3.7500n -0.000969 3.7600n -0.000968 3.7700n -0.000965 3.7800n -0.000962 3.7900n -0.000959 3.8000n -0.000954 3.8100n -0.000948 3.8200n -0.000942 3.8300n -0.000934 3.8400n -0.000926 3.8500n -0.000917 3.8600n -0.000906 3.8700n -0.000895 3.8800n -0.000884 3.8900n -0.000871
+ 3.9000n -0.000857 3.9100n -0.000842 3.9200n -0.000827 3.9300n -0.000811 3.9400n -0.000793 3.9500n -0.000775 3.9600n -0.000757 3.9700n -0.000737 3.9800n -0.000716 3.9900n -0.000695 4.0000n -0.000672 4.0100n -0.000649 4.0200n -0.000626 4.0300n -0.000601 4.0400n -0.000576
+ 4.0500n -0.000550 4.0600n -0.000523 4.0700n -0.000495 4.0800n -0.000467 4.0900n -0.000438 4.1000n -0.000408 4.1100n -0.000378 4.1200n -0.000347 4.1300n -0.000316 4.1400n -0.000283 4.1500n -0.000251 4.1600n -0.000218 4.1700n -0.000184 4.1800n -0.000150 4.1900n -0.000115
+ 4.2000n -0.000080 4.2100n -0.000044 4.2200n -0.000009 4.2300n 0.000028 4.2400n 0.000064 4.2500n 0.000101 4.2600n 0.000139 4.2700n 0.000176 4.2800n 0.000214 4.2900n 0.000252 4.3000n 0.000290 4.3100n 0.000328 4.3200n 0.000366 4.3300n 0.000405 4.3400n 0.000443
+ 4.3500n 0.000482 4.3600n 0.000520 4.3700n 0.000559 4.3800n 0.000597 4.3900n 0.000636 4.4000n 0.000674 4.4100n 0.000712 4.4200n 0.000750 4.4300n 0.000787 4.4400n 0.000825 4.4500n 0.000862 4.4600n 0.000899 4.4700n 0.000935 4.4800n 0.000971 4.4900n 0.001007
+ 4.5000n 0.001042 4.5100n 0.001077 4.5200n 0.001111 4.5300n 0.001145 4.5400n 0.001178 4.5500n 0.001210 4.5600n 0.001242 4.5700n 0.001274 4.5800n 0.001304 4.5900n 0.001334 4.6000n 0.001363 4.6100n 0.001392 4.6200n 0.001420 4.6300n 0.001446 4.6400n 0.001473
+ 4.6500n 0.001498 4.6600n 0.001522 4.6700n 0.001546 4.6800n 0.001568 4.6900n 0.001590 4.7000n 0.001610 4.7100n 0.001630 4.7200n 0.001648 4.7300n 0.001666 4.7400n 0.001683 4.7500n 0.001698 4.7600n 0.001713 4.7700n 0.001726 4.7800n 0.001738 4.7900n 0.001749
+ 4.8000n 0.001759 4.8100n 0.001768 4.8200n 0.001775 4.8300n 0.001782 4.8400n 0.001787 4.8500n 0.001791 4.8600n 0.001794 4.8700n 0.001796 4.8800n 0.001796 4.8900n 0.001795 4.9000n 0.001793 4.9100n 0.001790 4.9200n 0.001786 4.9300n 0.001780 4.9400n 0.001773
+ 4.9500n 0.001765 4.9600n 0.001755 4.9700n 0.001745 4.9800n 0.001733 4.9900n 0.001720 5.0000n 0.001705 5.0100n 0.001690 5.0200n 0.001673 5.0300n 0.001655 5.0400n 0.001636 5.0500n 0.001616 5.0600n 0.001594 5.0700n 0.001572 5.0800n 0.001548 5.0900n 0.001523
+ 5.1000n 0.001497 5.1100n 0.001470 5.1200n 0.001441 5.1300n 0.001412 5.1400n 0.001382 5.1500n 0.001350 5.1600n 0.001318 5.1700n 0.001284 5.1800n 0.001250 5.1900n 0.001215 5.2000n 0.001178 5.2100n 0.001141 5.2200n 0.001103 5.2300n 0.001064 5.2400n 0.001025
+ 5.2500n 0.000984 5.2600n 0.000943 5.2700n 0.000901 5.2800n 0.000858 5.2900n 0.000815 5.3000n 0.000771 5.3100n 0.000726 5.3200n 0.000681 5.3300n 0.000635 5.3400n 0.000589 5.3500n 0.000542 5.3600n 0.000495 5.3700n 0.000447 5.3800n 0.000399 5.3900n 0.000351
+ 5.4000n 0.000302 5.4100n 0.000253 5.4200n 0.000203 5.4300n 0.000154 5.4400n 0.000104 5.4500n 0.000054 5.4600n 0.000004 5.4700n -0.000046 5.4800n -0.000096 5.4900n -0.000146 5.5000n -0.000196 5.5100n -0.000246 5.5200n -0.000296 5.5300n -0.000345 5.5400n -0.000395
+ 5.5500n -0.000444 5.5600n -0.000493 5.5700n -0.000542 5.5800n -0.000590 5.5900n -0.000638 5.6000n -0.000686 5.6100n -0.000733 5.6200n -0.000780 5.6300n -0.000826 5.6400n -0.000872 5.6500n -0.000917 5.6600n -0.000962 5.6700n -0.001006 5.6800n -0.001049 5.6900n -0.001092
+ 5.7000n -0.001133 5.7100n -0.001174 5.7200n -0.001215 5.7300n -0.001254 5.7400n -0.001293 5.7500n -0.001330 5.7600n -0.001367 5.7700n -0.001403 5.7800n -0.001438 5.7900n -0.001472 5.8000n -0.001505 5.8100n -0.001537 5.8200n -0.001568 5.8300n -0.001597 5.8400n -0.001626
+ 5.8500n -0.001654 5.8600n -0.001680 5.8700n -0.001705 5.8800n -0.001729 5.8900n -0.001752 5.9000n -0.001774 5.9100n -0.001794 5.9200n -0.001813 5.9300n -0.001831 5.9400n -0.001848 5.9500n -0.001863 5.9600n -0.001877 5.9700n -0.001890 5.9800n -0.001902 5.9900n -0.001912
+ 6.0000n -0.001921 6.0100n -0.001929 6.0200n -0.001935 6.0300n -0.001940 6.0400n -0.001943 6.0500n -0.001946 6.0600n -0.001947 6.0700n -0.001946 6.0800n -0.001945 6.0900n -0.001942 6.1000n -0.001937 6.1100n -0.001932 6.1200n -0.001925 6.1300n -0.001916 6.1400n -0.001907
+ 6.1500n -0.001896 6.1600n -0.001884 6.1700n -0.001871 6.1800n -0.001856 6.1900n -0.001841 6.2000n -0.001824 6.2100n -0.001806 6.2200n -0.001786 6.2300n -0.001766 6.2400n -0.001744 6.2500n -0.001721 6.2600n -0.001698 6.2700n -0.001673 6.2800n -0.001647 6.2900n -0.001620
+ 6.3000n -0.001592 6.3100n -0.001563 6.3200n -0.001533 6.3300n -0.001502 6.3400n -0.001470 6.3500n -0.001438 6.3600n -0.001404 6.3700n -0.001370 6.3800n -0.001335 6.3900n -0.001299 6.4000n -0.001262 6.4100n -0.001225 6.4200n -0.001187 6.4300n -0.001149 6.4400n -0.001109
+ 6.4500n -0.001070 6.4600n -0.001030 6.4700n -0.000989 6.4800n -0.000948 6.4900n -0.000906 6.5000n -0.000864 6.5100n -0.000822 6.5200n -0.000779 6.5300n -0.000736 6.5400n -0.000693 6.5500n -0.000650 6.5600n -0.000606 6.5700n -0.000562 6.5800n -0.000519 6.5900n -0.000475
+ 6.6000n -0.000431 6.6100n -0.000387 6.6200n -0.000343 6.6300n -0.000300 6.6400n -0.000256 6.6500n -0.000213 6.6600n -0.000170 6.6700n -0.000127 6.6800n -0.000084 6.6900n -0.000042 6.7000n 0.000000 6.7100n 0.000042 6.7200n 0.000083 6.7300n 0.000124 6.7400n 0.000164
+ 6.7500n 0.000204 6.7600n 0.000243 6.7700n 0.000282 6.7800n 0.000320 6.7900n 0.000357 6.8000n 0.000394 6.8100n 0.000430 6.8200n 0.000465 6.8300n 0.000500 6.8400n 0.000533 6.8500n 0.000566 6.8600n 0.000598 6.8700n 0.000629 6.8800n 0.000660 6.8900n 0.000689
+ 6.9000n 0.000717 6.9100n 0.000745 6.9200n 0.000771 6.9300n 0.000796 6.9400n 0.000821 6.9500n 0.000844 6.9600n 0.000866 6.9700n 0.000887 6.9800n 0.000907 6.9900n 0.000926 7.0000n 0.000944 7.0100n 0.000960 7.0200n 0.000976 7.0300n 0.000990 7.0400n 0.001003
+ 7.0500n 0.001015 7.0600n 0.001025 7.0700n 0.001035 7.0800n 0.001043 7.0900n 0.001050 7.1000n 0.001055 7.1100n 0.001060 7.1200n 0.001063 7.1300n 0.001065 7.1400n 0.001066 7.1500n 0.001065 7.1600n 0.001063 7.1700n 0.001060 7.1800n 0.001056 7.1900n 0.001051
+ 7.2000n 0.001044 7.2100n 0.001036 7.2200n 0.001027 7.2300n 0.001016 7.2400n 0.001005 7.2500n 0.000992 7.2600n 0.000978 7.2700n 0.000963 7.2800n 0.000947 7.2900n 0.000930 7.3000n 0.000911 7.3100n 0.000892 7.3200n 0.000871 7.3300n 0.000850 7.3400n 0.000827
+ 7.3500n 0.000803 7.3600n 0.000779 7.3700n 0.000753 7.3800n 0.000726 7.3900n 0.000699 7.4000n 0.000670 7.4100n 0.000641 7.4200n 0.000611 7.4300n 0.000580 7.4400n 0.000548 7.4500n 0.000515 7.4600n 0.000482 7.4700n 0.000448 7.4800n 0.000413 7.4900n 0.000378
+ 7.5000n 0.000342 7.5100n 0.000305 7.5200n 0.000268 7.5300n 0.000230 7.5400n 0.000192 7.5500n 0.000153 7.5600n 0.000114 7.5700n 0.000075 7.5800n 0.000035 7.5900n -0.000005 7.6000n -0.000046 7.6100n -0.000086 7.6200n -0.000127 7.6300n -0.000169 7.6400n -0.000210
+ 7.6500n -0.000251 7.6600n -0.000293 7.6700n -0.000334 7.6800n -0.000376 7.6900n -0.000417 7.7000n -0.000459 7.7100n -0.000500 7.7200n -0.000542 7.7300n -0.000583 7.7400n -0.000624 7.7500n -0.000664 7.7600n -0.000705 7.7700n -0.000745 7.7800n -0.000785 7.7900n -0.000824
+ 7.8000n -0.000863 7.8100n -0.000902 7.8200n -0.000940 7.8300n -0.000977 7.8400n -0.001014 7.8500n -0.001051 7.8600n -0.001087 7.8700n -0.001122 7.8800n -0.001157 7.8900n -0.001191 7.9000n -0.001224 7.9100n -0.001256 7.9200n -0.001288 7.9300n -0.001319 7.9400n -0.001349
+ 7.9500n -0.001378 7.9600n -0.001407 7.9700n -0.001434 7.9800n -0.001461 7.9900n -0.001487 8.0000n -0.001512 8.0100n -0.001535 8.0200n -0.001558 8.0300n -0.001580 8.0400n -0.001601 8.0500n -0.001620 8.0600n -0.001639 8.0700n -0.001657 8.0800n -0.001673 8.0900n -0.001688
+ 8.1000n -0.001703 8.1100n -0.001716 8.1200n -0.001728 8.1300n -0.001739 8.1400n -0.001748 8.1500n -0.001757 8.1600n -0.001764 8.1700n -0.001770 8.1800n -0.001775 8.1900n -0.001779 8.2000n -0.001782 8.2100n -0.001783 8.2200n -0.001784 8.2300n -0.001783 8.2400n -0.001781
+ 8.2500n -0.001777 8.2600n -0.001773 8.2700n -0.001767 8.2800n -0.001761 8.2900n -0.001753 8.3000n -0.001744 8.3100n -0.001733 8.3200n -0.001722 8.3300n -0.001709 8.3400n -0.001696 8.3500n -0.001681 8.3600n -0.001665 8.3700n -0.001649 8.3800n -0.001631 8.3900n -0.001612
+ 8.4000n -0.001592 8.4100n -0.001571 8.4200n -0.001549 8.4300n -0.001526 8.4400n -0.001502 8.4500n -0.001477 8.4600n -0.001451 8.4700n -0.001425 8.4800n -0.001397 8.4900n -0.001369 8.5000n -0.001340 8.5100n -0.001310 8.5200n -0.001279 8.5300n -0.001248 8.5400n -0.001216
+ 8.5500n -0.001183 8.5600n -0.001150 8.5700n -0.001115 8.5800n -0.001081 8.5900n -0.001045 8.6000n -0.001010 8.6100n -0.000973 8.6200n -0.000937 8.6300n -0.000899 8.6400n -0.000862 8.6500n -0.000824 8.6600n -0.000785 8.6700n -0.000747 8.6800n -0.000708 8.6900n -0.000668
+ 8.7000n -0.000629 8.7100n -0.000589 8.7200n -0.000549 8.7300n -0.000510 8.7400n -0.000470 8.7500n -0.000429 8.7600n -0.000389 8.7700n -0.000349 8.7800n -0.000309 8.7900n -0.000269 8.8000n -0.000229 8.8100n -0.000189 8.8200n -0.000150 8.8300n -0.000111 8.8400n -0.000071
+ 8.8500n -0.000033 8.8600n 0.000006 8.8700n 0.000044 8.8800n 0.000082 8.8900n 0.000120 8.9000n 0.000157 8.9100n 0.000193 8.9200n 0.000229 8.9300n 0.000265 8.9400n 0.000300 8.9500n 0.000335 8.9600n 0.000369 8.9700n 0.000402 8.9800n 0.000435 8.9900n 0.000467
+ 9.0000n 0.000498 9.0100n 0.000528 9.0200n 0.000558 9.0300n 0.000587 9.0400n 0.000615 9.0500n 0.000643 9.0600n 0.000669 9.0700n 0.000695 9.0800n 0.000720 9.0900n 0.000744 9.1000n 0.000767 9.1100n 0.000789 9.1200n 0.000810 9.1300n 0.000830 9.1400n 0.000850
+ 9.1500n 0.000868 9.1600n 0.000885 9.1700n 0.000901 9.1800n 0.000916 9.1900n 0.000930 9.2000n 0.000943 9.2100n 0.000955 9.2200n 0.000966 9.2300n 0.000976 9.2400n 0.000985 9.2500n 0.000992 9.2600n 0.000999 9.2700n 0.001004 9.2800n 0.001008 9.2900n 0.001012
+ 9.3000n 0.001014 9.3100n 0.001015 9.3200n 0.001014 9.3300n 0.001013 9.3400n 0.001011 9.3500n 0.001007 9.3600n 0.001003 9.3700n 0.000997 9.3800n 0.000990 9.3900n 0.000982 9.4000n 0.000973 9.4100n 0.000963 9.4200n 0.000952 9.4300n 0.000940 9.4400n 0.000927
+ 9.4500n 0.000912 9.4600n 0.000897 9.4700n 0.000881 9.4800n 0.000864 9.4900n 0.000845 9.5000n 0.000826 9.5100n 0.000806 9.5200n 0.000785 9.5300n 0.000763 9.5400n 0.000740 9.5500n 0.000716 9.5600n 0.000691 9.5700n 0.000665 9.5800n 0.000639 9.5900n 0.000612
+ 9.6000n 0.000584 9.6100n 0.000555 9.6200n 0.000525 9.6300n 0.000495 9.6400n 0.000464 9.6500n 0.000432 9.6600n 0.000400 9.6700n 0.000367 9.6800n 0.000334 9.6900n 0.000299 9.7000n 0.000265 9.7100n 0.000229 9.7200n 0.000194 9.7300n 0.000157 9.7400n 0.000121
+ 9.7500n 0.000084 9.7600n 0.000046 9.7700n 0.000008 9.7800n -0.000030 9.7900n -0.000069 9.8000n -0.000108 9.8100n -0.000147 9.8200n -0.000187 9.8300n -0.000226 9.8400n -0.000266 9.8500n -0.000306 9.8600n -0.000346 9.8700n -0.000387 9.8800n -0.000427 9.8900n -0.000468
+ 9.9000n -0.000508 9.9100n -0.000549 9.9200n -0.000589 9.9300n -0.000630 9.9400n -0.000670 9.9500n -0.000711 9.9600n -0.000751 9.9700n -0.000791 9.9800n -0.000831 9.9900n -0.000871 10.0000n -0.000910 10.0100n -0.000950 10.0200n -0.000989 10.0300n -0.001027 10.0400n -0.001066
+ 10.0500n -0.001104 10.0600n -0.001142 10.0700n -0.001179 10.0800n -0.001217 10.0900n -0.001253 10.1000n -0.001290 10.1100n -0.001325 10.1200n -0.001361 10.1300n -0.001396 10.1400n -0.001430 10.1500n -0.001464 10.1600n -0.001497 10.1700n -0.001530 10.1800n -0.001563 10.1900n -0.001594
+ 10.2000n -0.001626 10.2100n -0.001656 10.2200n -0.001686 10.2300n -0.001715 10.2400n -0.001744 10.2500n -0.001772 10.2600n -0.001800 10.2700n -0.001827 10.2800n -0.001853 10.2900n -0.001878 10.3000n -0.001903 10.3100n -0.001927 10.3200n -0.001950 10.3300n -0.001973 10.3400n -0.001995
+ 10.3500n -0.002017 10.3600n -0.002037 10.3700n -0.002057 10.3800n -0.002076 10.3900n -0.002095 10.4000n -0.002113 10.4100n -0.002130 10.4200n -0.002146 10.4300n -0.002162 10.4400n -0.002177 10.4500n -0.002191 10.4600n -0.002204 10.4700n -0.002217 10.4800n -0.002229 10.4900n -0.002241
+ 10.5000n -0.002252 10.5100n -0.002262 10.5200n -0.002271 10.5300n -0.002280 10.5400n -0.002288 10.5500n -0.002296 10.5600n -0.002303 10.5700n -0.002309 10.5800n -0.002315 10.5900n -0.002320 10.6000n -0.002324 10.6100n -0.002328 10.6200n -0.002331 10.6300n -0.002334 10.6400n -0.002336
+ 10.6500n -0.002338 10.6600n -0.002339 10.6700n -0.002339 10.6800n -0.002339 10.6900n -0.002339 10.7000n -0.002338 10.7100n -0.002337 10.7200n -0.002335 10.7300n -0.002333 10.7400n -0.002330 10.7500n -0.002327 10.7600n -0.002324 10.7700n -0.002320 10.7800n -0.002316 10.7900n -0.002312
+ 10.8000n -0.002307 10.8100n -0.002302 10.8200n -0.002297 10.8300n -0.002291 10.8400n -0.002285 10.8500n -0.002279 10.8600n -0.002273 10.8700n -0.002266 10.8800n -0.002259 10.8900n -0.002253 10.9000n -0.002245 10.9100n -0.002238 10.9200n -0.002231 10.9300n -0.002224 10.9400n -0.002216
+ 10.9500n -0.002208 10.9600n -0.002201 10.9700n -0.002193 10.9800n -0.002185 10.9900n -0.002177 11.0000n -0.002169 11.0100n -0.002162 11.0200n -0.002154 11.0300n -0.002146 11.0400n -0.002138 11.0500n -0.002131 11.0600n -0.002123 11.0700n -0.002116 11.0800n -0.002108 11.0900n -0.002101
+ 11.1000n -0.002093 11.1100n -0.002086 11.1200n -0.002079 11.1300n -0.002072 11.1400n -0.002066 11.1500n -0.002059 11.1600n -0.002053 11.1700n -0.002047 11.1800n -0.002041 11.1900n -0.002035 11.2000n -0.002029 11.2100n -0.002024 11.2200n -0.002018 11.2300n -0.002013 11.2400n -0.002008
+ 11.2500n -0.002004 11.2600n -0.001999 11.2700n -0.001995 11.2800n -0.001991 11.2900n -0.001988 11.3000n -0.001984 11.3100n -0.001981 11.3200n -0.001978 11.3300n -0.001975 11.3400n -0.001973 11.3500n -0.001970 11.3600n -0.001968 11.3700n -0.001966 11.3800n -0.001965 11.3900n -0.001963
+ 11.4000n -0.001962 11.4100n -0.001961 11.4200n -0.001960 11.4300n -0.001960 11.4400n -0.001960 11.4500n -0.001959 11.4600n -0.001959 11.4700n -0.001960 11.4800n -0.001960 11.4900n -0.001961 11.5000n -0.001961 11.5100n -0.001962 11.5200n -0.001963 11.5300n -0.001964 11.5400n -0.001966
+ 11.5500n -0.001967 11.5600n -0.001969 11.5700n -0.001970 11.5800n -0.001972 11.5900n -0.001974 11.6000n -0.001976 11.6100n -0.001978 11.6200n -0.001980 11.6300n -0.001982 11.6400n -0.001984 11.6500n -0.001986 11.6600n -0.001988 11.6700n -0.001990 11.6800n -0.001992 11.6900n -0.001994
+ 11.7000n -0.001996 11.7100n -0.001998 11.7200n -0.001999 11.7300n -0.002001 11.7400n -0.002003 11.7500n -0.002004 11.7600n -0.002006 11.7700n -0.002007 11.7800n -0.002008 11.7900n -0.002009 11.8000n -0.002009 11.8100n -0.002010 11.8200n -0.002010 11.8300n -0.002010 11.8400n -0.002010
+ 11.8500n -0.002010 11.8600n -0.002009 11.8700n -0.002008 11.8800n -0.002007 11.8900n -0.002005 11.9000n -0.002003 11.9100n -0.002001 11.9200n -0.001999 11.9300n -0.001996 11.9400n -0.001993 11.9500n -0.001989 11.9600n -0.001985 11.9700n -0.001981 11.9800n -0.001976 11.9900n -0.001971
+ 12.0000n -0.001965 12.0100n -0.001959 12.0200n -0.001953 12.0300n -0.001946 12.0400n -0.001939 12.0500n -0.001931 12.0600n -0.001923 12.0700n -0.001914 12.0800n -0.001905 12.0900n -0.001895 12.1000n -0.001885 12.1100n -0.001874 12.1200n -0.001863 12.1300n -0.001851 12.1400n -0.001839
+ 12.1500n -0.001826 12.1600n -0.001813 12.1700n -0.001799 12.1800n -0.001785 12.1900n -0.001770 12.2000n -0.001754 12.2100n -0.001738 12.2200n -0.001722 12.2300n -0.001705 12.2400n -0.001687 12.2500n -0.001669 12.2600n -0.001651 12.2700n -0.001632 12.2800n -0.001612 12.2900n -0.001592
+ 12.3000n -0.001571 12.3100n -0.001550 12.3200n -0.001528 12.3300n -0.001506 12.3400n -0.001484 12.3500n -0.001460 12.3600n -0.001437 12.3700n -0.001413 12.3800n -0.001388 12.3900n -0.001363 12.4000n -0.001337 12.4100n -0.001311 12.4200n -0.001285 12.4300n -0.001258 12.4400n -0.001231
+ 12.4500n -0.001203 12.4600n -0.001175 12.4700n -0.001147 12.4800n -0.001118 12.4900n -0.001089 12.5000n -0.001059 12.5100n -0.001029 12.5200n -0.000999 12.5300n -0.000968 12.5400n -0.000938 12.5500n -0.000907 12.5600n -0.000875 12.5700n -0.000844 12.5800n -0.000812 12.5900n -0.000780
+ 12.6000n -0.000747 12.6100n -0.000715 12.6200n -0.000682 12.6300n -0.000649 12.6400n -0.000616 12.6500n -0.000583 12.6600n -0.000550 12.6700n -0.000516 12.6800n -0.000483 12.6900n -0.000449 12.7000n -0.000416 12.7100n -0.000382 12.7200n -0.000349 12.7300n -0.000315 12.7400n -0.000281
+ 12.7500n -0.000248 12.7600n -0.000214 12.7700n -0.000181 12.7800n -0.000148 12.7900n -0.000114 12.8000n -0.000081 12.8100n -0.000048 12.8200n -0.000015 12.8300n 0.000017 12.8400n 0.000050 12.8500n 0.000082 12.8600n 0.000114 12.8700n 0.000146 12.8800n 0.000178 12.8900n 0.000209
+ 12.9000n 0.000240 12.9100n 0.000271 12.9200n 0.000301 12.9300n 0.000332 12.9400n 0.000361 12.9500n 0.000391 12.9600n 0.000420 12.9700n 0.000449 12.9800n 0.000477 12.9900n 0.000505 13.0000n 0.000532 13.0100n 0.000559 13.0200n 0.000586 13.0300n 0.000612 13.0400n 0.000638
+ 13.0500n 0.000663 13.0600n 0.000688 13.0700n 0.000712 13.0800n 0.000736 13.0900n 0.000759 13.1000n 0.000782 13.1100n 0.000804 13.1200n 0.000826 13.1300n 0.000847 13.1400n 0.000868 13.1500n 0.000888 13.1600n 0.000907 13.1700n 0.000926 13.1800n 0.000945 13.1900n 0.000962
+ 13.2000n 0.000980 13.2100n 0.000996 13.2200n 0.001012 13.2300n 0.001028 13.2400n 0.001043 13.2500n 0.001057 13.2600n 0.001071 13.2700n 0.001084 13.2800n 0.001097 13.2900n 0.001109 13.3000n 0.001120 13.3100n 0.001131 13.3200n 0.001141 13.3300n 0.001151 13.3400n 0.001160
+ 13.3500n 0.001168 13.3600n 0.001176 13.3700n 0.001184 13.3800n 0.001191 13.3900n 0.001197 13.4000n 0.001203 13.4100n 0.001208 13.4200n 0.001213 13.4300n 0.001217 13.4400n 0.001221 13.4500n 0.001224 13.4600n 0.001227 13.4700n 0.001229 13.4800n 0.001231 13.4900n 0.001233
+ 13.5000n 0.001233 13.5100n 0.001234 13.5200n 0.001234 13.5300n 0.001234 13.5400n 0.001233 13.5500n 0.001232 13.5600n 0.001230 13.5700n 0.001228 13.5800n 0.001226 13.5900n 0.001224 13.6000n 0.001221 13.6100n 0.001218 13.6200n 0.001214 13.6300n 0.001210 13.6400n 0.001207
+ 13.6500n 0.001202 13.6600n 0.001198 13.6700n 0.001193 13.6800n 0.001188 13.6900n 0.001183 13.7000n 0.001178 13.7100n 0.001173 13.7200n 0.001167 13.7300n 0.001161 13.7400n 0.001156 13.7500n 0.001150 13.7600n 0.001144 13.7700n 0.001138 13.7800n 0.001132 13.7900n 0.001126
+ 13.8000n 0.001120 13.8100n 0.001114 13.8200n 0.001108 13.8300n 0.001102 13.8400n 0.001096 13.8500n 0.001090 13.8600n 0.001084 13.8700n 0.001078 13.8800n 0.001073 13.8900n 0.001067 13.9000n 0.001062 13.9100n 0.001057 13.9200n 0.001052 13.9300n 0.001047 13.9400n 0.001043
+ 13.9500n 0.001038 13.9600n 0.001034 13.9700n 0.001030 13.9800n 0.001027 13.9900n 0.001023 14.0000n 0.001020 14.0100n 0.001017 14.0200n 0.001015 14.0300n 0.001012 14.0400n 0.001010 14.0500n 0.001009 14.0600n 0.001008 14.0700n 0.001007 14.0800n 0.001006 14.0900n 0.001006
+ 14.1000n 0.001006 14.1100n 0.001007 14.1200n 0.001007 14.1300n 0.001009 14.1400n 0.001011 14.1500n 0.001013 14.1600n 0.001015 14.1700n 0.001018 14.1800n 0.001021 14.1900n 0.001025 14.2000n 0.001029 14.2100n 0.001034 14.2200n 0.001039 14.2300n 0.001044 14.2400n 0.001050
+ 14.2500n 0.001057 14.2600n 0.001063 14.2700n 0.001070 14.2800n 0.001078 14.2900n 0.001086 14.3000n 0.001094 14.3100n 0.001103 14.3200n 0.001113 14.3300n 0.001122 14.3400n 0.001132 14.3500n 0.001143 14.3600n 0.001154 14.3700n 0.001165 14.3800n 0.001177 14.3900n 0.001189
+ 14.4000n 0.001201 14.4100n 0.001214 14.4200n 0.001227 14.4300n 0.001241 14.4400n 0.001255 14.4500n 0.001269 14.4600n 0.001283 14.4700n 0.001298 14.4800n 0.001313 14.4900n 0.001329 14.5000n 0.001344 14.5100n 0.001360 14.5200n 0.001377 14.5300n 0.001393 14.5400n 0.001410
+ 14.5500n 0.001427 14.5600n 0.001444 14.5700n 0.001461 14.5800n 0.001479 14.5900n 0.001496 14.6000n 0.001514 14.6100n 0.001532 14.6200n 0.001550 14.6300n 0.001568 14.6400n 0.001587 14.6500n 0.001605 14.6600n 0.001624 14.6700n 0.001642 14.6800n 0.001661 14.6900n 0.001679
+ 14.7000n 0.001698 14.7100n 0.001716 14.7200n 0.001735 14.7300n 0.001753 14.7400n 0.001771 14.7500n 0.001790 14.7600n 0.001808 14.7700n 0.001826 14.7800n 0.001844 14.7900n 0.001862 14.8000n 0.001879 14.8100n 0.001897 14.8200n 0.001914 14.8300n 0.001931 14.8400n 0.001948
+ 14.8500n 0.001964 14.8600n 0.001980 14.8700n 0.001996 14.8800n 0.002012 14.8900n 0.002027 14.9000n 0.002043 14.9100n 0.002057 14.9200n 0.002072 14.9300n 0.002086 14.9400n 0.002099 14.9500n 0.002112 14.9600n 0.002125 14.9700n 0.002138 14.9800n 0.002150 14.9900n 0.002161
+ 15.0000n 0.002172 15.0100n 0.002183 15.0200n 0.002193 15.0300n 0.002202 15.0400n 0.002211 15.0500n 0.002220 15.0600n 0.002228 15.0700n 0.002235 15.0800n 0.002242 15.0900n 0.002249 15.1000n 0.002254 15.1100n 0.002260 15.1200n 0.002264 15.1300n 0.002268 15.1400n 0.002272
+ 15.1500n 0.002275 15.1600n 0.002277 15.1700n 0.002279 15.1800n 0.002280 15.1900n 0.002280 15.2000n 0.002280 15.2100n 0.002279 15.2200n 0.002277 15.2300n 0.002275 15.2400n 0.002272 15.2500n 0.002269 15.2600n 0.002265 15.2700n 0.002260 15.2800n 0.002255 15.2900n 0.002249
+ 15.3000n 0.002242 15.3100n 0.002235 15.3200n 0.002227 15.3300n 0.002218 15.3400n 0.002209 15.3500n 0.002199 15.3600n 0.002189 15.3700n 0.002178 15.3800n 0.002166 15.3900n 0.002153 15.4000n 0.002141 15.4100n 0.002127 15.4200n 0.002113 15.4300n 0.002098 15.4400n 0.002083
+ 15.4500n 0.002067 15.4600n 0.002051 15.4700n 0.002034 15.4800n 0.002016 15.4900n 0.001998 15.5000n 0.001980 15.5100n 0.001961 15.5200n 0.001941 15.5300n 0.001921 15.5400n 0.001901 15.5500n 0.001880 15.5600n 0.001858 15.5700n 0.001836 15.5800n 0.001814 15.5900n 0.001791
+ 15.6000n 0.001768 15.6100n 0.001744 15.6200n 0.001721 15.6300n 0.001696 15.6400n 0.001672 15.6500n 0.001647 15.6600n 0.001621 15.6700n 0.001596 15.6800n 0.001570 15.6900n 0.001544 15.7000n 0.001518 15.7100n 0.001491 15.7200n 0.001464 15.7300n 0.001437 15.7400n 0.001410
+ 15.7500n 0.001383 15.7600n 0.001355 15.7700n 0.001327 15.7800n 0.001299 15.7900n 0.001272 15.8000n 0.001244 15.8100n 0.001215 15.8200n 0.001187 15.8300n 0.001159 15.8400n 0.001131 15.8500n 0.001103 15.8600n 0.001074 15.8700n 0.001046 15.8800n 0.001018 15.8900n 0.000990
+ 15.9000n 0.000962 15.9100n 0.000934 15.9200n 0.000906 15.9300n 0.000878 15.9400n 0.000850 15.9500n 0.000823 15.9600n 0.000795 15.9700n 0.000768 15.9800n 0.000741 15.9900n 0.000714 16.0000n 0.000688 16.0100n 0.000661 16.0200n 0.000635 16.0300n 0.000609 16.0400n 0.000584
+ 16.0500n 0.000558 16.0600n 0.000533 16.0700n 0.000508 16.0800n 0.000484 16.0900n 0.000460 16.1000n 0.000436 16.1100n 0.000412 16.1200n 0.000389 16.1300n 0.000366 16.1400n 0.000344 16.1500n 0.000322 16.1600n 0.000300 16.1700n 0.000279 16.1800n 0.000258 16.1900n 0.000237
+ 16.2000n 0.000217 16.2100n 0.000198 16.2200n 0.000178 16.2300n 0.000159 16.2400n 0.000141 16.2500n 0.000123 16.2600n 0.000105 16.2700n 0.000088 16.2800n 0.000071 16.2900n 0.000055 16.3000n 0.000039 16.3100n 0.000024 16.3200n 0.000009 16.3300n -0.000006 16.3400n -0.000020
+ 16.3500n -0.000034 16.3600n -0.000047 16.3700n -0.000059 16.3800n -0.000072 16.3900n -0.000084 16.4000n -0.000095 16.4100n -0.000106 16.4200n -0.000117 16.4300n -0.000127 16.4400n -0.000137 16.4500n -0.000146 16.4600n -0.000155 16.4700n -0.000164 16.4800n -0.000172 16.4900n -0.000180
+ 16.5000n -0.000187 16.5100n -0.000194 16.5200n -0.000201 16.5300n -0.000207 16.5400n -0.000213 16.5500n -0.000218 16.5600n -0.000223 16.5700n -0.000228 16.5800n -0.000233 16.5900n -0.000237 16.6000n -0.000241 16.6100n -0.000245 16.6200n -0.000248 16.6300n -0.000251 16.6400n -0.000254
+ 16.6500n -0.000257 16.6600n -0.000259 16.6700n -0.000261 16.6800n -0.000263 16.6900n -0.000265 16.7000n -0.000266 16.7100n -0.000267 16.7200n -0.000269 16.7300n -0.000269 16.7400n -0.000270 16.7500n -0.000271 16.7600n -0.000271 16.7700n -0.000272 16.7800n -0.000272 16.7900n -0.000272
+ 16.8000n -0.000272 16.8100n -0.000272 16.8200n -0.000272 16.8300n -0.000272 16.8400n -0.000272 16.8500n -0.000272 16.8600n -0.000272 16.8700n -0.000272 16.8800n -0.000272 16.8900n -0.000271 16.9000n -0.000271 16.9100n -0.000271 16.9200n -0.000271 16.9300n -0.000271 16.9400n -0.000271
+ 16.9500n -0.000271 16.9600n -0.000272 16.9700n -0.000272 16.9800n -0.000272 16.9900n -0.000273 17.0000n -0.000274 17.0100n -0.000274 17.0200n -0.000275 17.0300n -0.000276 17.0400n -0.000278 17.0500n -0.000279 17.0600n -0.000281 17.0700n -0.000282 17.0800n -0.000284 17.0900n -0.000286
+ 17.1000n -0.000289 17.1100n -0.000291 17.1200n -0.000294 17.1300n -0.000297 17.1400n -0.000300 17.1500n -0.000303 17.1600n -0.000307 17.1700n -0.000310 17.1800n -0.000314 17.1900n -0.000318 17.2000n -0.000323 17.2100n -0.000327 17.2200n -0.000332 17.2300n -0.000337 17.2400n -0.000343
+ 17.2500n -0.000348 17.2600n -0.000354 17.2700n -0.000360 17.2800n -0.000366 17.2900n -0.000372 17.3000n -0.000379 17.3100n -0.000386 17.3200n -0.000393 17.3300n -0.000400 17.3400n -0.000408 17.3500n -0.000415 17.3600n -0.000423 17.3700n -0.000431 17.3800n -0.000440 17.3900n -0.000448
+ 17.4000n -0.000457 17.4100n -0.000465 17.4200n -0.000474 17.4300n -0.000484 17.4400n -0.000493 17.4500n -0.000502 17.4600n -0.000512 17.4700n -0.000521 17.4800n -0.000531 17.4900n -0.000541 17.5000n -0.000551 17.5100n -0.000561 17.5200n -0.000571 17.5300n -0.000581 17.5400n -0.000591
+ 17.5500n -0.000602 17.5600n -0.000612 17.5700n -0.000622 17.5800n -0.000633 17.5900n -0.000643 17.6000n -0.000653 17.6100n -0.000664 17.6200n -0.000674 17.6300n -0.000684 17.6400n -0.000695 17.6500n -0.000705 17.6600n -0.000715 17.6700n -0.000725 17.6800n -0.000735 17.6900n -0.000744
+ 17.7000n -0.000754 17.7100n -0.000763 17.7200n -0.000773 17.7300n -0.000782 17.7400n -0.000791 17.7500n -0.000800 17.7600n -0.000808 17.7700n -0.000817 17.7800n -0.000825 17.7900n -0.000833 17.8000n -0.000840 17.8100n -0.000848 17.8200n -0.000855 17.8300n -0.000862 17.8400n -0.000868
+ 17.8500n -0.000874 17.8600n -0.000880 17.8700n -0.000886 17.8800n -0.000891 17.8900n -0.000896 17.9000n -0.000900 17.9100n -0.000904 17.9200n -0.000908 17.9300n -0.000911 17.9400n -0.000914 17.9500n -0.000917 17.9600n -0.000919 17.9700n -0.000921 17.9800n -0.000922 17.9900n -0.000923
+ 18.0000n -0.000923 18.0100n -0.000923 18.0200n -0.000922 18.0300n -0.000921 18.0400n -0.000919 18.0500n -0.000917 18.0600n -0.000915 18.0700n -0.000912 18.0800n -0.000908 18.0900n -0.000904 18.1000n -0.000900 18.1100n -0.000895 18.1200n -0.000889 18.1300n -0.000883 18.1400n -0.000876
+ 18.1500n -0.000869 18.1600n -0.000861 18.1700n -0.000853 18.1800n -0.000844 18.1900n -0.000835 18.2000n -0.000825 18.2100n -0.000815 18.2200n -0.000804 18.2300n -0.000793 18.2400n -0.000781 18.2500n -0.000769 18.2600n -0.000756 18.2700n -0.000742 18.2800n -0.000728 18.2900n -0.000714
+ 18.3000n -0.000699 18.3100n -0.000684 18.3200n -0.000668 18.3300n -0.000651 18.3400n -0.000634 18.3500n -0.000617 18.3600n -0.000599 18.3700n -0.000581 18.3800n -0.000562 18.3900n -0.000543 18.4000n -0.000524 18.4100n -0.000504 18.4200n -0.000484 18.4300n -0.000463 18.4400n -0.000442
+ 18.4500n -0.000420 18.4600n -0.000399 18.4700n -0.000376 18.4800n -0.000354 18.4900n -0.000331 18.5000n -0.000308 18.5100n -0.000284 18.5200n -0.000261 18.5300n -0.000237 18.5400n -0.000213 18.5500n -0.000188 18.5600n -0.000163 18.5700n -0.000138 18.5800n -0.000113 18.5900n -0.000088
+ 18.6000n -0.000063 18.6100n -0.000037 18.6200n -0.000011 18.6300n 0.000015 18.6400n 0.000041 18.6500n 0.000067 18.6600n 0.000093 18.6700n 0.000119 18.6800n 0.000145 18.6900n 0.000172 18.7000n 0.000198 18.7100n 0.000224 18.7200n 0.000251 18.7300n 0.000277 18.7400n 0.000303
+ 18.7500n 0.000329 18.7600n 0.000355 18.7700n 0.000381 18.7800n 0.000407 18.7900n 0.000432 18.8000n 0.000458 18.8100n 0.000483 18.8200n 0.000508 18.8300n 0.000533 18.8400n 0.000557 18.8500n 0.000582 18.8600n 0.000606 18.8700n 0.000630 18.8800n 0.000654 18.8900n 0.000677
+ 18.9000n 0.000700 18.9100n 0.000723 18.9200n 0.000745 18.9300n 0.000767 18.9400n 0.000789 18.9500n 0.000810 18.9600n 0.000831 18.9700n 0.000851 18.9800n 0.000871 18.9900n 0.000891 19.0000n 0.000910 19.0100n 0.000929 19.0200n 0.000947 19.0300n 0.000965 19.0400n 0.000982
+ 19.0500n 0.000999 19.0600n 0.001015 19.0700n 0.001031 19.0800n 0.001046 19.0900n 0.001061 19.1000n 0.001075 19.1100n 0.001089 19.1200n 0.001102 19.1300n 0.001114 19.1400n 0.001126 19.1500n 0.001137 19.1600n 0.001148 19.1700n 0.001159 19.1800n 0.001168 19.1900n 0.001177
+ 19.2000n 0.001186 19.2100n 0.001194 19.2200n 0.001201 19.2300n 0.001207 19.2400n 0.001214 19.2500n 0.001219 19.2600n 0.001224 19.2700n 0.001228 19.2800n 0.001232 19.2900n 0.001235 19.3000n 0.001237 19.3100n 0.001239 19.3200n 0.001240 19.3300n 0.001241 19.3400n 0.001241
+ 19.3500n 0.001241 19.3600n 0.001240 19.3700n 0.001238 19.3800n 0.001236 19.3900n 0.001233 19.4000n 0.001230 19.4100n 0.001226 19.4200n 0.001221 19.4300n 0.001216 19.4400n 0.001211 19.4500n 0.001205 19.4600n 0.001198 19.4700n 0.001191 19.4800n 0.001184 19.4900n 0.001176
+ 19.5000n 0.001167 19.5100n 0.001158 19.5200n 0.001149 19.5300n 0.001139 19.5400n 0.001129 19.5500n 0.001118 19.5600n 0.001107 19.5700n 0.001096 19.5800n 0.001084 19.5900n 0.001071 19.6000n 0.001059 19.6100n 0.001046 19.6200n 0.001032 19.6300n 0.001019 19.6400n 0.001005
+ 19.6500n 0.000991 19.6600n 0.000976 19.6700n 0.000961 19.6800n 0.000946 19.6900n 0.000931 19.7000n 0.000916 19.7100n 0.000900 19.7200n 0.000884 19.7300n 0.000868 19.7400n 0.000852 19.7500n 0.000836 19.7600n 0.000819 19.7700n 0.000802 19.7800n 0.000786 19.7900n 0.000769
+ 19.8000n 0.000752 19.8100n 0.000735 19.8200n 0.000718 19.8300n 0.000701 19.8400n 0.000684 19.8500n 0.000667 19.8600n 0.000650 19.8700n 0.000633 19.8800n 0.000616 19.8900n 0.000599 19.9000n 0.000582 19.9100n 0.000566 19.9200n 0.000549 19.9300n 0.000533 19.9400n 0.000516
+ 19.9500n 0.000500 19.9600n 0.000484 19.9700n 0.000468 19.9800n 0.000452 19.9900n 0.000436 20.0000n 0.000421 20.0100n 0.000406 20.0200n 0.000391 20.0300n 0.000376 20.0400n 0.000361 20.0500n 0.000347 20.0600n 0.000333 20.0700n 0.000319 20.0800n 0.000306 20.0900n 0.000292
+ 20.1000n 0.000279 20.1100n 0.000267 20.1200n 0.000254 20.1300n 0.000242 20.1400n 0.000230 20.1500n 0.000219 20.1600n 0.000208 20.1700n 0.000197 20.1800n 0.000186 20.1900n 0.000176 20.2000n 0.000167 20.2100n 0.000157 20.2200n 0.000148 20.2300n 0.000139 20.2400n 0.000131
+ 20.2500n 0.000123 20.2600n 0.000115 20.2700n 0.000108 20.2800n 0.000101 20.2900n 0.000094 20.3000n 0.000088 20.3100n 0.000082 20.3200n 0.000076 20.3300n 0.000071 20.3400n 0.000066 20.3500n 0.000061 20.3600n 0.000057 20.3700n 0.000053 20.3800n 0.000050 20.3900n 0.000046
+ 20.4000n 0.000044 20.4100n 0.000041 20.4200n 0.000039 20.4300n 0.000037 20.4400n 0.000035 20.4500n 0.000034 20.4600n 0.000032 20.4700n 0.000032 20.4800n 0.000031 20.4900n 0.000031 20.5000n 0.000031 20.5100n 0.000031 20.5200n 0.000031 20.5300n 0.000032 20.5400n 0.000033
+ 20.5500n 0.000034 20.5600n 0.000035 20.5700n 0.000037 20.5800n 0.000038 20.5900n 0.000040 20.6000n 0.000042 20.6100n 0.000044 20.6200n 0.000047 20.6300n 0.000049 20.6400n 0.000051 20.6500n 0.000054 20.6600n 0.000057 20.6700n 0.000059 20.6800n 0.000062 20.6900n 0.000065
+ 20.7000n 0.000068 20.7100n 0.000071 20.7200n 0.000074 20.7300n 0.000077 20.7400n 0.000080 20.7500n 0.000082 20.7600n 0.000085 20.7700n 0.000088 20.7800n 0.000091 20.7900n 0.000094 20.8000n 0.000096 20.8100n 0.000099 20.8200n 0.000101 20.8300n 0.000103 20.8400n 0.000105
+ 20.8500n 0.000107 20.8600n 0.000109 20.8700n 0.000111 20.8800n 0.000112 20.8900n 0.000114 20.9000n 0.000115 20.9100n 0.000116 20.9200n 0.000116 20.9300n 0.000117 20.9400n 0.000117 20.9500n 0.000117 20.9600n 0.000116 20.9700n 0.000116 20.9800n 0.000115 20.9900n 0.000114
+ 21.0000n 0.000112 21.0100n 0.000110 21.0200n 0.000108 21.0300n 0.000106 21.0400n 0.000103 21.0500n 0.000100 21.0600n 0.000097 21.0700n 0.000093 21.0800n 0.000089 21.0900n 0.000084 21.1000n 0.000079 21.1100n 0.000074 21.1200n 0.000069 21.1300n 0.000063 21.1400n 0.000056
+ 21.1500n 0.000050 21.1600n 0.000043 21.1700n 0.000035 21.1800n 0.000027 21.1900n 0.000019 21.2000n 0.000010 21.2100n 0.000001 21.2200n -0.000008 21.2300n -0.000018 21.2400n -0.000028 21.2500n -0.000038 21.2600n -0.000049 21.2700n -0.000061 21.2800n -0.000072 21.2900n -0.000085
+ 21.3000n -0.000097 21.3100n -0.000110 21.3200n -0.000123 21.3300n -0.000136 21.3400n -0.000150 21.3500n -0.000165 21.3600n -0.000179 21.3700n -0.000194 21.3800n -0.000209 21.3900n -0.000225 21.4000n -0.000241 21.4100n -0.000257 21.4200n -0.000273 21.4300n -0.000290 21.4400n -0.000307
+ 21.4500n -0.000325 21.4600n -0.000342 21.4700n -0.000360 21.4800n -0.000378 21.4900n -0.000396 21.5000n -0.000415 21.5100n -0.000433 21.5200n -0.000452 21.5300n -0.000472 21.5400n -0.000491 21.5500n -0.000510 21.5600n -0.000530 21.5700n -0.000549 21.5800n -0.000569 21.5900n -0.000589
+ 21.6000n -0.000609 21.6100n -0.000629 21.6200n -0.000650 21.6300n -0.000670 21.6400n -0.000690 21.6500n -0.000710 21.6600n -0.000731 21.6700n -0.000751 21.6800n -0.000771 21.6900n -0.000792 21.7000n -0.000812 21.7100n -0.000832 21.7200n -0.000852 21.7300n -0.000872 21.7400n -0.000892
+ 21.7500n -0.000912 21.7600n -0.000932 21.7700n -0.000951 21.7800n -0.000970 21.7900n -0.000990 21.8000n -0.001009 21.8100n -0.001027 21.8200n -0.001046 21.8300n -0.001064 21.8400n -0.001083 21.8500n -0.001100 21.8600n -0.001118 21.8700n -0.001135 21.8800n -0.001152 21.8900n -0.001169
+ 21.9000n -0.001185 21.9100n -0.001201 21.9200n -0.001217 21.9300n -0.001233 21.9400n -0.001248 21.9500n -0.001262 21.9600n -0.001276 21.9700n -0.001290 21.9800n -0.001304 21.9900n -0.001317 22.0000n -0.001329 22.0100n -0.001341 22.0200n -0.001353 22.0300n -0.001364 22.0400n -0.001375
+ 22.0500n -0.001385 22.0600n -0.001395 22.0700n -0.001405 22.0800n -0.001413 22.0900n -0.001422 22.1000n -0.001430 22.1100n -0.001437 22.1200n -0.001444 22.1300n -0.001450 22.1400n -0.001456 22.1500n -0.001461 22.1600n -0.001466 22.1700n -0.001470 22.1800n -0.001474 22.1900n -0.001477
+ 22.2000n -0.001479 22.2100n -0.001482 22.2200n -0.001483 22.2300n -0.001484 22.2400n -0.001484 22.2500n -0.001484 22.2600n -0.001484 22.2700n -0.001483 22.2800n -0.001481 22.2900n -0.001479 22.3000n -0.001476 22.3100n -0.001473 22.3200n -0.001469 22.3300n -0.001465 22.3400n -0.001460
+ 22.3500n -0.001455 22.3600n -0.001449 22.3700n -0.001443 22.3800n -0.001436 22.3900n -0.001429 22.4000n -0.001421 22.4100n -0.001413 22.4200n -0.001404 22.4300n -0.001395 22.4400n -0.001386 22.4500n -0.001376 22.4600n -0.001366 22.4700n -0.001355 22.4800n -0.001344 22.4900n -0.001333
+ 22.5000n -0.001321 22.5100n -0.001309 22.5200n -0.001296 22.5300n -0.001283 22.5400n -0.001270 22.5500n -0.001257 22.5600n -0.001243 22.5700n -0.001229 22.5800n -0.001215 22.5900n -0.001200 22.6000n -0.001185 22.6100n -0.001170 22.6200n -0.001155 22.6300n -0.001139 22.6400n -0.001124
+ 22.6500n -0.001108 22.6600n -0.001092 22.6700n -0.001076 22.6800n -0.001060 22.6900n -0.001043 22.7000n -0.001027 22.7100n -0.001011 22.7200n -0.000994 22.7300n -0.000977 22.7400n -0.000961 22.7500n -0.000944 22.7600n -0.000927 22.7700n -0.000911 22.7800n -0.000894 22.7900n -0.000878
+ 22.8000n -0.000861 22.8100n -0.000845 22.8200n -0.000828 22.8300n -0.000812 22.8400n -0.000796 22.8500n -0.000780 22.8600n -0.000764 22.8700n -0.000748 22.8800n -0.000733 22.8900n -0.000717 22.9000n -0.000702 22.9100n -0.000687 22.9200n -0.000673 22.9300n -0.000658 22.9400n -0.000644
+ 22.9500n -0.000630 22.9600n -0.000616 22.9700n -0.000603 22.9800n -0.000590 22.9900n -0.000577 23.0000n -0.000565 23.0100n -0.000553 23.0200n -0.000541 23.0300n -0.000530 23.0400n -0.000518 23.0500n -0.000508 23.0600n -0.000497 23.0700n -0.000488 23.0800n -0.000478 23.0900n -0.000469
+ 23.1000n -0.000460 23.1100n -0.000452 23.1200n -0.000444 23.1300n -0.000437 23.1400n -0.000429 23.1500n -0.000423 23.1600n -0.000417 23.1700n -0.000411 23.1800n -0.000406 23.1900n -0.000401 23.2000n -0.000397 23.2100n -0.000393 23.2200n -0.000389 23.2300n -0.000386 23.2400n -0.000384
+ 23.2500n -0.000382 23.2600n -0.000380 23.2700n -0.000379 23.2800n -0.000378 23.2900n -0.000378 23.3000n -0.000378 23.3100n -0.000379 23.3200n -0.000380 23.3300n -0.000382 23.3400n -0.000384 23.3500n -0.000386 23.3600n -0.000389 23.3700n -0.000392 23.3800n -0.000396 23.3900n -0.000400
+ 23.4000n -0.000405 23.4100n -0.000410 23.4200n -0.000415 23.4300n -0.000421 23.4400n -0.000427 23.4500n -0.000433 23.4600n -0.000440 23.4700n -0.000447 23.4800n -0.000455 23.4900n -0.000463 23.5000n -0.000471 23.5100n -0.000480 23.5200n -0.000488 23.5300n -0.000498 23.5400n -0.000507
+ 23.5500n -0.000517 23.5600n -0.000527 23.5700n -0.000537 23.5800n -0.000547 23.5900n -0.000558 23.6000n -0.000569 23.6100n -0.000580 23.6200n -0.000591 23.6300n -0.000603 23.6400n -0.000614 23.6500n -0.000626 23.6600n -0.000638 23.6700n -0.000650 23.6800n -0.000662 23.6900n -0.000674
+ 23.7000n -0.000686 23.7100n -0.000699 23.7200n -0.000711 23.7300n -0.000724 23.7400n -0.000736 23.7500n -0.000748 23.7600n -0.000761 23.7700n -0.000773 23.7800n -0.000786 23.7900n -0.000798 23.8000n -0.000810 23.8100n -0.000823 23.8200n -0.000835 23.8300n -0.000847 23.8400n -0.000859
+ 23.8500n -0.000871 23.8600n -0.000882 23.8700n -0.000894 23.8800n -0.000905 23.8900n -0.000916 23.9000n -0.000927 23.9100n -0.000938 23.9200n -0.000949 23.9300n -0.000959 23.9400n -0.000969 23.9500n -0.000979 23.9600n -0.000989 23.9700n -0.000998 23.9800n -0.001007 23.9900n -0.001016
+ 24.0000n -0.001024 24.0100n -0.001032 24.0200n -0.001040 24.0300n -0.001048 24.0400n -0.001055 24.0500n -0.001062 24.0600n -0.001068 24.0700n -0.001075 24.0800n -0.001080 24.0900n -0.001086 24.1000n -0.001091 24.1100n -0.001096 24.1200n -0.001100 24.1300n -0.001104 24.1400n -0.001107
+ 24.1500n -0.001111 24.1600n -0.001113 24.1700n -0.001116 24.1800n -0.001118 24.1900n -0.001119 24.2000n -0.001120 24.2100n -0.001121 24.2200n -0.001122 24.2300n -0.001121 24.2400n -0.001121 24.2500n -0.001120 24.2600n -0.001119 24.2700n -0.001117 24.2800n -0.001115 24.2900n -0.001113
+ 24.3000n -0.001110 24.3100n -0.001107 24.3200n -0.001103 24.3300n -0.001099 24.3400n -0.001094 24.3500n -0.001090 24.3600n -0.001085 24.3700n -0.001079 24.3800n -0.001073 24.3900n -0.001067 24.4000n -0.001060 24.4100n -0.001054 24.4200n -0.001046 24.4300n -0.001039 24.4400n -0.001031
+ 24.4500n -0.001023 24.4600n -0.001014 24.4700n -0.001006 24.4800n -0.000997 24.4900n -0.000987 24.5000n -0.000978 24.5100n -0.000968 24.5200n -0.000958 24.5300n -0.000948 24.5400n -0.000938 24.5500n -0.000927 24.5600n -0.000916 24.5700n -0.000905 24.5800n -0.000894 24.5900n -0.000883
+ 24.6000n -0.000872 24.6100n -0.000860 24.6200n -0.000849 24.6300n -0.000837 24.6400n -0.000825 24.6500n -0.000813 24.6600n -0.000801 24.6700n -0.000790 24.6800n -0.000778 24.6900n -0.000766 24.7000n -0.000754 24.7100n -0.000742 24.7200n -0.000730 24.7300n -0.000718 24.7400n -0.000706
+ 24.7500n -0.000694 24.7600n -0.000683 24.7700n -0.000671 24.7800n -0.000660 24.7900n -0.000649 24.8000n -0.000637 24.8100n -0.000626 24.8200n -0.000616 24.8300n -0.000605 24.8400n -0.000594 24.8500n -0.000584 24.8600n -0.000574 24.8700n -0.000564 24.8800n -0.000555 24.8900n -0.000546
+ 24.9000n -0.000536 24.9100n -0.000528 24.9200n -0.000519 24.9300n -0.000511 24.9400n -0.000503 24.9500n -0.000496 24.9600n -0.000488 24.9700n -0.000482 24.9800n -0.000475 24.9900n -0.000469 25.0000n -0.000463 25.0100n -0.000458 25.0200n -0.000453 25.0300n -0.000448 25.0400n -0.000444
+ 25.0500n -0.000440 25.0600n -0.000436 25.0700n -0.000433 25.0800n -0.000431 25.0900n -0.000428 25.1000n -0.000427 25.1100n -0.000425 25.1200n -0.000424 25.1300n -0.000424 25.1400n -0.000424 25.1500n -0.000424 25.1600n -0.000425 25.1700n -0.000427 25.1800n -0.000428 25.1900n -0.000431
+ 25.2000n -0.000433 25.2100n -0.000437 25.2200n -0.000440 25.2300n -0.000444 25.2400n -0.000449 25.2500n -0.000454 25.2600n -0.000459 25.2700n -0.000465 25.2800n -0.000471 25.2900n -0.000478 25.3000n -0.000485 25.3100n -0.000492 25.3200n -0.000500 25.3300n -0.000509 25.3400n -0.000518
+ 25.3500n -0.000527 25.3600n -0.000536 25.3700n -0.000546 25.3800n -0.000557 25.3900n -0.000567 25.4000n -0.000578 25.4100n -0.000590 25.4200n -0.000601 25.4300n -0.000613 25.4400n -0.000626 25.4500n -0.000638 25.4600n -0.000651 25.4700n -0.000665 25.4800n -0.000678 25.4900n -0.000692
+ 25.5000n -0.000706 25.5100n -0.000720 25.5200n -0.000735 25.5300n -0.000749 25.5400n -0.000764 25.5500n -0.000779 25.5600n -0.000795 25.5700n -0.000810 25.5800n -0.000826 25.5900n -0.000841 25.6000n -0.000857 25.6100n -0.000873 25.6200n -0.000889 25.6300n -0.000905 25.6400n -0.000921
+ 25.6500n -0.000937 25.6600n -0.000954 25.6700n -0.000970 25.6800n -0.000986 25.6900n -0.001002 25.7000n -0.001018 25.7100n -0.001034 25.7200n -0.001050 25.7300n -0.001066 25.7400n -0.001082 25.7500n -0.001098 25.7600n -0.001113 25.7700n -0.001129 25.7800n -0.001144 25.7900n -0.001159
+ 25.8000n -0.001174 25.8100n -0.001189 25.8200n -0.001203 25.8300n -0.001217 25.8400n -0.001231 25.8500n -0.001245 25.8600n -0.001258 25.8700n -0.001272 25.8800n -0.001285 25.8900n -0.001297 25.9000n -0.001309 25.9100n -0.001321 25.9200n -0.001333 25.9300n -0.001344 25.9400n -0.001355
+ 25.9500n -0.001365 25.9600n -0.001375 25.9700n -0.001385 25.9800n -0.001394 25.9900n -0.001403 26.0000n -0.001412 26.0100n -0.001419 26.0200n -0.001427 26.0300n -0.001434 26.0400n -0.001441 26.0500n -0.001447 26.0600n -0.001452 26.0700n -0.001457 26.0800n -0.001462 26.0900n -0.001466
+ 26.1000n -0.001470 26.1100n -0.001473 26.1200n -0.001476 26.1300n -0.001478 26.1400n -0.001480 26.1500n -0.001481 26.1600n -0.001481 26.1700n -0.001481 26.1800n -0.001481 26.1900n -0.001480 26.2000n -0.001478 26.2100n -0.001476 26.2200n -0.001474 26.2300n -0.001471 26.2400n -0.001467
+ 26.2500n -0.001463 26.2600n -0.001459 26.2700n -0.001454 26.2800n -0.001448 26.2900n -0.001442 26.3000n -0.001436 26.3100n -0.001429 26.3200n -0.001421 26.3300n -0.001413 26.3400n -0.001405 26.3500n -0.001396 26.3600n -0.001386 26.3700n -0.001377 26.3800n -0.001366 26.3900n -0.001356
+ 26.4000n -0.001345 26.4100n -0.001333 26.4200n -0.001321 26.4300n -0.001309 26.4400n -0.001297 26.4500n -0.001284 26.4600n -0.001270 26.4700n -0.001257 26.4800n -0.001243 26.4900n -0.001229 26.5000n -0.001214 26.5100n -0.001199 26.5200n -0.001184 26.5300n -0.001169 26.5400n -0.001153
+ 26.5500n -0.001137 26.5600n -0.001121 26.5700n -0.001105 26.5800n -0.001089 26.5900n -0.001072 26.6000n -0.001056 26.6100n -0.001039 26.6200n -0.001022 26.6300n -0.001005 26.6400n -0.000988 26.6500n -0.000971 26.6600n -0.000954 26.6700n -0.000936 26.6800n -0.000919 26.6900n -0.000902
+ 26.7000n -0.000885 26.7100n -0.000867 26.7200n -0.000850 26.7300n -0.000833 26.7400n -0.000816 26.7500n -0.000799 26.7600n -0.000783 26.7700n -0.000766 26.7800n -0.000749 26.7900n -0.000733 26.8000n -0.000717 26.8100n -0.000701 26.8200n -0.000685 26.8300n -0.000670 26.8400n -0.000655
+ 26.8500n -0.000640 26.8600n -0.000625 26.8700n -0.000610 26.8800n -0.000596 26.8900n -0.000582 26.9000n -0.000569 26.9100n -0.000556 26.9200n -0.000543 26.9300n -0.000531 26.9400n -0.000518 26.9500n -0.000507 26.9600n -0.000496 26.9700n -0.000485 26.9800n -0.000474 26.9900n -0.000464
+ 27.0000n -0.000455 27.0100n -0.000445 27.0200n -0.000437 27.0300n -0.000428 27.0400n -0.000421 27.0500n -0.000413 27.0600n -0.000407 27.0700n -0.000400 27.0800n -0.000395 27.0900n -0.000389 27.1000n -0.000384 27.1100n -0.000380 27.1200n -0.000376 27.1300n -0.000373 27.1400n -0.000370
+ 27.1500n -0.000368 27.1600n -0.000366 27.1700n -0.000365 27.1800n -0.000365 27.1900n -0.000365 27.2000n -0.000365 27.2100n -0.000366 27.2200n -0.000367 27.2300n -0.000369 27.2400n -0.000372 27.2500n -0.000375 27.2600n -0.000378 27.2700n -0.000382 27.2800n -0.000386 27.2900n -0.000391
+ 27.3000n -0.000397 27.3100n -0.000403 27.3200n -0.000409 27.3300n -0.000416 27.3400n -0.000423 27.3500n -0.000431 27.3600n -0.000439 27.3700n -0.000447 27.3800n -0.000456 27.3900n -0.000466 27.4000n -0.000475 27.4100n -0.000485 27.4200n -0.000496 27.4300n -0.000507 27.4400n -0.000518
+ 27.4500n -0.000529 27.4600n -0.000541 27.4700n -0.000553 27.4800n -0.000565 27.4900n -0.000578 27.5000n -0.000591 27.5100n -0.000604 27.5200n -0.000617 27.5300n -0.000630 27.5400n -0.000644 27.5500n -0.000658 27.5600n -0.000672 27.5700n -0.000686 27.5800n -0.000700 27.5900n -0.000714
+ 27.6000n -0.000728 27.6100n -0.000743 27.6200n -0.000757 27.6300n -0.000771 27.6400n -0.000786 27.6500n -0.000800 27.6600n -0.000814 27.6700n -0.000829 27.6800n -0.000843 27.6900n -0.000857 27.7000n -0.000871 27.7100n -0.000884 27.7200n -0.000898 27.7300n -0.000911 27.7400n -0.000925
+ 27.7500n -0.000938 27.7600n -0.000950 27.7700n -0.000963 27.7800n -0.000975 27.7900n -0.000987 27.8000n -0.000998 27.8100n -0.001010 27.8200n -0.001021 27.8300n -0.001031 27.8400n -0.001041 27.8500n -0.001051 27.8600n -0.001060 27.8700n -0.001069 27.8800n -0.001077 27.8900n -0.001085
+ 27.9000n -0.001092 27.9100n -0.001099 27.9200n -0.001106 27.9300n -0.001111 27.9400n -0.001117 27.9500n -0.001121 27.9600n -0.001125 27.9700n -0.001129 27.9800n -0.001132 27.9900n -0.001134 28.0000n -0.001135 28.0100n -0.001136 28.0200n -0.001137 28.0300n -0.001136 28.0400n -0.001135
+ 28.0500n -0.001133 28.0600n -0.001131 28.0700n -0.001128 28.0800n -0.001124 28.0900n -0.001119 28.1000n -0.001114 28.1100n -0.001108 28.1200n -0.001101 28.1300n -0.001094 28.1400n -0.001085 28.1500n -0.001076 28.1600n -0.001067 28.1700n -0.001056 28.1800n -0.001045 28.1900n -0.001033
+ 28.2000n -0.001020 28.2100n -0.001006 28.2200n -0.000992 28.2300n -0.000977 28.2400n -0.000961 28.2500n -0.000944 28.2600n -0.000927 28.2700n -0.000909 28.2800n -0.000890 28.2900n -0.000871 28.3000n -0.000851 28.3100n -0.000830 28.3200n -0.000808 28.3300n -0.000785 28.3400n -0.000762
+ 28.3500n -0.000739 28.3600n -0.000714 28.3700n -0.000689 28.3800n -0.000663 28.3900n -0.000637 28.4000n -0.000610 28.4100n -0.000582 28.4200n -0.000554 28.4300n -0.000525 28.4400n -0.000496 28.4500n -0.000466 28.4600n -0.000435 28.4700n -0.000404 28.4800n -0.000373 28.4900n -0.000341
+ 28.5000n -0.000308 28.5100n -0.000275 28.5200n -0.000242 28.5300n -0.000208 28.5400n -0.000174 28.5500n -0.000139 28.5600n -0.000104 28.5700n -0.000069 28.5800n -0.000033 28.5900n 0.000003 28.6000n 0.000039 28.6100n 0.000075 28.6200n 0.000112 28.6300n 0.000149 28.6400n 0.000186
+ 28.6500n 0.000223 28.6600n 0.000261 28.6700n 0.000298 28.6800n 0.000336 28.6900n 0.000374 28.7000n 0.000412 28.7100n 0.000449 28.7200n 0.000487 28.7300n 0.000525 28.7400n 0.000563 28.7500n 0.000601 28.7600n 0.000638 28.7700n 0.000676 28.7800n 0.000713 28.7900n 0.000751
+ 28.8000n 0.000788 28.8100n 0.000825 28.8200n 0.000861 28.8300n 0.000898 28.8400n 0.000934 28.8500n 0.000970 28.8600n 0.001005 28.8700n 0.001041 28.8800n 0.001076 28.8900n 0.001110 28.9000n 0.001144 28.9100n 0.001178 28.9200n 0.001211 28.9300n 0.001244 28.9400n 0.001276
+ 28.9500n 0.001308 28.9600n 0.001340 28.9700n 0.001371 28.9800n 0.001401 28.9900n 0.001431 29.0000n 0.001460 29.0100n 0.001488 29.0200n 0.001516 29.0300n 0.001543 29.0400n 0.001570 29.0500n 0.001596 29.0600n 0.001621 29.0700n 0.001646 29.0800n 0.001670 29.0900n 0.001693
+ 29.1000n 0.001716 29.1100n 0.001737 29.1200n 0.001758 29.1300n 0.001779 29.1400n 0.001798 29.1500n 0.001817 29.1600n 0.001835 29.1700n 0.001852 29.1800n 0.001869 29.1900n 0.001884 29.2000n 0.001899 29.2100n 0.001913 29.2200n 0.001926 29.2300n 0.001939 29.2400n 0.001950
+ 29.2500n 0.001961 29.2600n 0.001971 29.2700n 0.001980 29.2800n 0.001988 29.2900n 0.001996 29.3000n 0.002002 29.3100n 0.002008 29.3200n 0.002013 29.3300n 0.002017 29.3400n 0.002021 29.3500n 0.002023 29.3600n 0.002025 29.3700n 0.002026 29.3800n 0.002026 29.3900n 0.002026
+ 29.4000n 0.002024 29.4100n 0.002022 29.4200n 0.002020 29.4300n 0.002016 29.4400n 0.002012 29.4500n 0.002007 29.4600n 0.002001 29.4700n 0.001995 29.4800n 0.001988 29.4900n 0.001980 29.5000n 0.001972 29.5100n 0.001963 29.5200n 0.001953 29.5300n 0.001943 29.5400n 0.001932
+ 29.5500n 0.001921 29.5600n 0.001909 29.5700n 0.001897 29.5800n 0.001884 29.5900n 0.001870 29.6000n 0.001856 29.6100n 0.001842 29.6200n 0.001827 29.6300n 0.001812 29.6400n 0.001796 29.6500n 0.001780 29.6600n 0.001763 29.6700n 0.001746 29.6800n 0.001729 29.6900n 0.001712
+ 29.7000n 0.001694 29.7100n 0.001676 29.7200n 0.001658 29.7300n 0.001639 29.7400n 0.001621 29.7500n 0.001602 29.7600n 0.001583 29.7700n 0.001564 29.7800n 0.001544 29.7900n 0.001525 29.8000n 0.001506 29.8100n 0.001486 29.8200n 0.001467 29.8300n 0.001447 29.8400n 0.001428
+ 29.8500n 0.001408 29.8600n 0.001389 29.8700n 0.001369 29.8800n 0.001350 29.8900n 0.001331 29.9000n 0.001312 29.9100n 0.001293 29.9200n 0.001275 29.9300n 0.001256 29.9400n 0.001238 29.9500n 0.001220 29.9600n 0.001202 29.9700n 0.001185 29.9800n 0.001167 29.9900n 0.001150
+ 30.0000n 0.001134 30.0100n 0.001117 30.0200n 0.001102 30.0300n 0.001086 30.0400n 0.001071 30.0500n 0.001056 30.0600n 0.001042 30.0700n 0.001028 30.0800n 0.001014 30.0900n 0.001001 30.1000n 0.000988 30.1100n 0.000976 30.1200n 0.000964 30.1300n 0.000953 30.1400n 0.000943
+ 30.1500n 0.000932 30.1600n 0.000923 30.1700n 0.000913 30.1800n 0.000905 30.1900n 0.000897 30.2000n 0.000889 30.2100n 0.000882 30.2200n 0.000876 30.2300n 0.000870 30.2400n 0.000864 30.2500n 0.000859 30.2600n 0.000855 30.2700n 0.000851 30.2800n 0.000848 30.2900n 0.000845
+ 30.3000n 0.000843 30.3100n 0.000842 30.3200n 0.000841 30.3300n 0.000840 30.3400n 0.000840 30.3500n 0.000841 30.3600n 0.000842 30.3700n 0.000844 30.3800n 0.000846 30.3900n 0.000849 30.4000n 0.000852 30.4100n 0.000855 30.4200n 0.000860 30.4300n 0.000864 30.4400n 0.000869
+ 30.4500n 0.000875 30.4600n 0.000881 30.4700n 0.000887 30.4800n 0.000894 30.4900n 0.000901 30.5000n 0.000909 30.5100n 0.000917 30.5200n 0.000925 30.5300n 0.000933 30.5400n 0.000942 30.5500n 0.000952 30.5600n 0.000961 30.5700n 0.000971 30.5800n 0.000981 30.5900n 0.000991
+ 30.6000n 0.001002 30.6100n 0.001013 30.6200n 0.001023 30.6300n 0.001035 30.6400n 0.001046 30.6500n 0.001057 30.6600n 0.001068 30.6700n 0.001080 30.6800n 0.001091 30.6900n 0.001103 30.7000n 0.001115 30.7100n 0.001126 30.7200n 0.001138 30.7300n 0.001149 30.7400n 0.001161
+ 30.7500n 0.001172 30.7600n 0.001183 30.7700n 0.001194 30.7800n 0.001205 30.7900n 0.001216 30.8000n 0.001226 30.8100n 0.001236 30.8200n 0.001246 30.8300n 0.001256 30.8400n 0.001266 30.8500n 0.001275 30.8600n 0.001284 30.8700n 0.001292 30.8800n 0.001300 30.8900n 0.001308
+ 30.9000n 0.001315 30.9100n 0.001322 30.9200n 0.001328 30.9300n 0.001334 30.9400n 0.001339 30.9500n 0.001344 30.9600n 0.001348 30.9700n 0.001352 30.9800n 0.001355 30.9900n 0.001358 31.0000n 0.001360 31.0100n 0.001361 31.0200n 0.001362 31.0300n 0.001362 31.0400n 0.001361
+ 31.0500n 0.001360 31.0600n 0.001358 31.0700n 0.001355 31.0800n 0.001352 31.0900n 0.001348 31.1000n 0.001343 31.1100n 0.001337 31.1200n 0.001331 31.1300n 0.001323 31.1400n 0.001315 31.1500n 0.001307 31.1600n 0.001297 31.1700n 0.001287 31.1800n 0.001275 31.1900n 0.001263
+ 31.2000n 0.001250 31.2100n 0.001237 31.2200n 0.001222 31.2300n 0.001207 31.2400n 0.001191 31.2500n 0.001174 31.2600n 0.001156 31.2700n 0.001137 31.2800n 0.001118 31.2900n 0.001097 31.3000n 0.001076 31.3100n 0.001054 31.3200n 0.001031 31.3300n 0.001008 31.3400n 0.000983
+ 31.3500n 0.000958 31.3600n 0.000932 31.3700n 0.000905 31.3800n 0.000878 31.3900n 0.000849 31.4000n 0.000820 31.4100n 0.000790 31.4200n 0.000760 31.4300n 0.000728 31.4400n 0.000696 31.4500n 0.000664 31.4600n 0.000630 31.4700n 0.000596 31.4800n 0.000562 31.4900n 0.000527
+ 31.5000n 0.000491 31.5100n 0.000454 31.5200n 0.000417 31.5300n 0.000380 31.5400n 0.000341 31.5500n 0.000303 31.5600n 0.000264 31.5700n 0.000224 31.5800n 0.000184 31.5900n 0.000144 31.6000n 0.000103 31.6100n 0.000062 31.6200n 0.000020 31.6300n -0.000022 31.6400n -0.000064
+ 31.6500n -0.000106 31.6600n -0.000149 31.6700n -0.000192 31.6800n -0.000235 31.6900n -0.000278 31.7000n -0.000322 31.7100n -0.000365 31.7200n -0.000409 31.7300n -0.000452 31.7400n -0.000496 31.7500n -0.000540 31.7600n -0.000583 31.7700n -0.000627 31.7800n -0.000670 31.7900n -0.000714
+ 31.8000n -0.000757 31.8100n -0.000800 31.8200n -0.000843 31.8300n -0.000885 31.8400n -0.000927 31.8500n -0.000969 31.8600n -0.001011 31.8700n -0.001052 31.8800n -0.001093 31.8900n -0.001134 31.9000n -0.001174 31.9100n -0.001214 31.9200n -0.001253 31.9300n -0.001291 31.9400n -0.001329
+ 31.9500n -0.001367 31.9600n -0.001404 31.9700n -0.001440 31.9800n -0.001476 31.9900n -0.001511 32.0000n -0.001545 32.0100n -0.001578 32.0200n -0.001611 32.0300n -0.001643 32.0400n -0.001674 32.0500n -0.001704 32.0600n -0.001734 32.0700n -0.001762 32.0800n -0.001790 32.0900n -0.001817
+ 32.1000n -0.001842 32.1100n -0.001867 32.1200n -0.001891 32.1300n -0.001914 32.1400n -0.001936 32.1500n -0.001957 32.1600n -0.001977 32.1700n -0.001995 32.1800n -0.002013 32.1900n -0.002030 32.2000n -0.002045 32.2100n -0.002059 32.2200n -0.002073 32.2300n -0.002085 32.2400n -0.002096
+ 32.2500n -0.002105 32.2600n -0.002114 32.2700n -0.002122 32.2800n -0.002128 32.2900n -0.002133 32.3000n -0.002137 32.3100n -0.002140 32.3200n -0.002141 32.3300n -0.002141 32.3400n -0.002141 32.3500n -0.002139 32.3600n -0.002135 32.3700n -0.002131 32.3800n -0.002125 32.3900n -0.002118
+ 32.4000n -0.002110 32.4100n -0.002101 32.4200n -0.002090 32.4300n -0.002079 32.4400n -0.002066 32.4500n -0.002052 32.4600n -0.002037 32.4700n -0.002021 32.4800n -0.002003 32.4900n -0.001985 32.5000n -0.001965 32.5100n -0.001944 32.5200n -0.001923 32.5300n -0.001900 32.5400n -0.001876
+ 32.5500n -0.001851 32.5600n -0.001825 32.5700n -0.001798 32.5800n -0.001770 32.5900n -0.001741 32.6000n -0.001711 32.6100n -0.001680 32.6200n -0.001648 32.6300n -0.001615 32.6400n -0.001582 32.6500n -0.001547 32.6600n -0.001512 32.6700n -0.001476 32.6800n -0.001439 32.6900n -0.001402
+ 32.7000n -0.001364 32.7100n -0.001325 32.7200n -0.001285 32.7300n -0.001245 32.7400n -0.001204 32.7500n -0.001162 32.7600n -0.001120 32.7700n -0.001078 32.7800n -0.001034 32.7900n -0.000991 32.8000n -0.000947 32.8100n -0.000902 32.8200n -0.000857 32.8300n -0.000812 32.8400n -0.000767
+ 32.8500n -0.000721 32.8600n -0.000674 32.8700n -0.000628 32.8800n -0.000581 32.8900n -0.000535 32.9000n -0.000488 32.9100n -0.000441 32.9200n -0.000393 32.9300n -0.000346 32.9400n -0.000299 32.9500n -0.000252 32.9600n -0.000204 32.9700n -0.000157 32.9800n -0.000110 32.9900n -0.000063
+ 33.0000n -0.000016 33.0100n 0.000030 33.0200n 0.000077 33.0300n 0.000123 33.0400n 0.000169 33.0500n 0.000215 33.0600n 0.000260 33.0700n 0.000305 33.0800n 0.000350 33.0900n 0.000394 33.1000n 0.000438 33.1100n 0.000481 33.1200n 0.000524 33.1300n 0.000566 33.1400n 0.000608
+ 33.1500n 0.000649 33.1600n 0.000690 33.1700n 0.000730 33.1800n 0.000770 33.1900n 0.000808 33.2000n 0.000847 33.2100n 0.000884 33.2200n 0.000921 33.2300n 0.000957 33.2400n 0.000992 33.2500n 0.001027 33.2600n 0.001061 33.2700n 0.001094 33.2800n 0.001126 33.2900n 0.001157
+ 33.3000n 0.001188 33.3100n 0.001218 33.3200n 0.001247 33.3300n 0.001275 33.3400n 0.001302 33.3500n 0.001328 33.3600n 0.001353 33.3700n 0.001378 33.3800n 0.001401 33.3900n 0.001424 33.4000n 0.001445 33.4100n 0.001466 33.4200n 0.001486 33.4300n 0.001504 33.4400n 0.001522
+ 33.4500n 0.001539 33.4600n 0.001555 33.4700n 0.001570 33.4800n 0.001584 33.4900n 0.001596 33.5000n 0.001609 33.5100n 0.001620 33.5200n 0.001630 33.5300n 0.001639 33.5400n 0.001647 33.5500n 0.001654 33.5600n 0.001660 33.5700n 0.001666 33.5800n 0.001670 33.5900n 0.001674
+ 33.6000n 0.001676 33.6100n 0.001678 33.6200n 0.001679 33.6300n 0.001679 33.6400n 0.001678 33.6500n 0.001676 33.6600n 0.001673 33.6700n 0.001670 33.6800n 0.001665 33.6900n 0.001660 33.7000n 0.001654 33.7100n 0.001648 33.7200n 0.001640 33.7300n 0.001632 33.7400n 0.001623
+ 33.7500n 0.001613 33.7600n 0.001603 33.7700n 0.001592 33.7800n 0.001580 33.7900n 0.001568 33.8000n 0.001555 33.8100n 0.001541 33.8200n 0.001527 33.8300n 0.001513 33.8400n 0.001497 33.8500n 0.001482 33.8600n 0.001465 33.8700n 0.001449 33.8800n 0.001431 33.8900n 0.001414
+ 33.9000n 0.001396 33.9100n 0.001377 33.9200n 0.001358 33.9300n 0.001339 33.9400n 0.001320 33.9500n 0.001300 33.9600n 0.001280 33.9700n 0.001260 33.9800n 0.001239 33.9900n 0.001218 34.0000n 0.001197 34.0100n 0.001176 34.0200n 0.001155 34.0300n 0.001133 34.0400n 0.001112
+ 34.0500n 0.001090 34.0600n 0.001068 34.0700n 0.001047 34.0800n 0.001025 34.0900n 0.001003 34.1000n 0.000982 34.1100n 0.000960 34.1200n 0.000938 34.1300n 0.000917 34.1400n 0.000895 34.1500n 0.000874 34.1600n 0.000853 34.1700n 0.000832 34.1800n 0.000811 34.1900n 0.000790
+ 34.2000n 0.000770 34.2100n 0.000750 34.2200n 0.000730 34.2300n 0.000710 34.2400n 0.000691 34.2500n 0.000672 34.2600n 0.000653 34.2700n 0.000635 34.2800n 0.000617 34.2900n 0.000599 34.3000n 0.000581 34.3100n 0.000564 34.3200n 0.000548 34.3300n 0.000532 34.3400n 0.000516
+ 34.3500n 0.000500 34.3600n 0.000485 34.3700n 0.000471 34.3800n 0.000457 34.3900n 0.000443 34.4000n 0.000430 34.4100n 0.000417 34.4200n 0.000405 34.4300n 0.000393 34.4400n 0.000382 34.4500n 0.000371 34.4600n 0.000361 34.4700n 0.000351 34.4800n 0.000341 34.4900n 0.000333
+ 34.5000n 0.000324 34.5100n 0.000316 34.5200n 0.000309 34.5300n 0.000302 34.5400n 0.000296 34.5500n 0.000290 34.5600n 0.000284 34.5700n 0.000279 34.5800n 0.000275 34.5900n 0.000271 34.6000n 0.000268 34.6100n 0.000265 34.6200n 0.000262 34.6300n 0.000260 34.6400n 0.000258
+ 34.6500n 0.000257 34.6600n 0.000256 34.6700n 0.000256 34.6800n 0.000256 34.6900n 0.000256 34.7000n 0.000257 34.7100n 0.000258 34.7200n 0.000260 34.7300n 0.000262 34.7400n 0.000264 34.7500n 0.000267 34.7600n 0.000270 34.7700n 0.000273 34.7800n 0.000277 34.7900n 0.000281
+ 34.8000n 0.000285 34.8100n 0.000289 34.8200n 0.000294 34.8300n 0.000299 34.8400n 0.000304 34.8500n 0.000310 34.8600n 0.000315 34.8700n 0.000321 34.8800n 0.000327 34.8900n 0.000333 34.9000n 0.000339 34.9100n 0.000346 34.9200n 0.000352 34.9300n 0.000359 34.9400n 0.000365
+ 34.9500n 0.000372 34.9600n 0.000379 34.9700n 0.000386 34.9800n 0.000392 34.9900n 0.000399 35.0000n 0.000406 35.0100n 0.000413 35.0200n 0.000419 35.0300n 0.000426 35.0400n 0.000433 35.0500n 0.000439 35.0600n 0.000446 35.0700n 0.000452 35.0800n 0.000458 35.0900n 0.000464
+ 35.1000n 0.000470 35.1100n 0.000476 35.1200n 0.000481 35.1300n 0.000487 35.1400n 0.000492 35.1500n 0.000497 35.1600n 0.000502 35.1700n 0.000506 35.1800n 0.000511 35.1900n 0.000515 35.2000n 0.000518 35.2100n 0.000522 35.2200n 0.000525 35.2300n 0.000528 35.2400n 0.000531
+ 35.2500n 0.000533 35.2600n 0.000535 35.2700n 0.000537 35.2800n 0.000538 35.2900n 0.000539 35.3000n 0.000540 35.3100n 0.000541 35.3200n 0.000541 35.3300n 0.000540 35.3400n 0.000540 35.3500n 0.000539 35.3600n 0.000538 35.3700n 0.000536 35.3800n 0.000534 35.3900n 0.000532
+ 35.4000n 0.000529 35.4100n 0.000526 35.4200n 0.000523 35.4300n 0.000519 35.4400n 0.000515 35.4500n 0.000511 35.4600n 0.000506 35.4700n 0.000501 35.4800n 0.000496 35.4900n 0.000490 35.5000n 0.000484 35.5100n 0.000478 35.5200n 0.000471 35.5300n 0.000464 35.5400n 0.000457
+ 35.5500n 0.000450 35.5600n 0.000442 35.5700n 0.000434 35.5800n 0.000426 35.5900n 0.000418 35.6000n 0.000409 35.6100n 0.000401 35.6200n 0.000392 35.6300n 0.000382 35.6400n 0.000373 35.6500n 0.000364 35.6600n 0.000354 35.6700n 0.000344 35.6800n 0.000334 35.6900n 0.000324
+ 35.7000n 0.000314 35.7100n 0.000304 35.7200n 0.000294 35.7300n 0.000284 35.7400n 0.000273 35.7500n 0.000263 35.7600n 0.000253 35.7700n 0.000243 35.7800n 0.000233 35.7900n 0.000223 35.8000n 0.000213 35.8100n 0.000203 35.8200n 0.000193 35.8300n 0.000183 35.8400n 0.000174
+ 35.8500n 0.000164 35.8600n 0.000155 35.8700n 0.000146 35.8800n 0.000138 35.8900n 0.000129 35.9000n 0.000121 35.9100n 0.000113 35.9200n 0.000106 35.9300n 0.000098 35.9400n 0.000092 35.9500n 0.000085 35.9600n 0.000079 35.9700n 0.000073 35.9800n 0.000068 35.9900n 0.000063
+ 36.0000n 0.000058 36.0100n 0.000054 36.0200n 0.000051 36.0300n 0.000047 36.0400n 0.000045 36.0500n 0.000043 36.0600n 0.000041 36.0700n 0.000040 36.0800n 0.000040 36.0900n 0.000040 36.1000n 0.000041 36.1100n 0.000042 36.1200n 0.000044 36.1300n 0.000047 36.1400n 0.000050
+ 36.1500n 0.000054 36.1600n 0.000059 36.1700n 0.000064 36.1800n 0.000070 36.1900n 0.000077 36.2000n 0.000085 36.2100n 0.000093 36.2200n 0.000102 36.2300n 0.000111 36.2400n 0.000122 36.2500n 0.000133 36.2600n 0.000144 36.2700n 0.000157 36.2800n 0.000170 36.2900n 0.000185
+ 36.3000n 0.000199 36.3100n 0.000215 36.3200n 0.000232 36.3300n 0.000249 36.3400n 0.000267 36.3500n 0.000286 36.3600n 0.000305 36.3700n 0.000325 36.3800n 0.000346 36.3900n 0.000368 36.4000n 0.000391 36.4100n 0.000414 36.4200n 0.000438 36.4300n 0.000463 36.4400n 0.000489
+ 36.4500n 0.000515 36.4600n 0.000542 36.4700n 0.000570 36.4800n 0.000598 36.4900n 0.000627 36.5000n 0.000657 36.5100n 0.000687 36.5200n 0.000719 36.5300n 0.000750 36.5400n 0.000783 36.5500n 0.000816 36.5600n 0.000849 36.5700n 0.000883 36.5800n 0.000918 36.5900n 0.000953
+ 36.6000n 0.000989 36.6100n 0.001026 36.6200n 0.001062 36.6300n 0.001100 36.6400n 0.001137 36.6500n 0.001176 36.6600n 0.001214 36.6700n 0.001253 36.6800n 0.001293 36.6900n 0.001332 36.7000n 0.001372 36.7100n 0.001413 36.7200n 0.001453 36.7300n 0.001494 36.7400n 0.001535
+ 36.7500n 0.001577 36.7600n 0.001618 36.7700n 0.001660 36.7800n 0.001702 36.7900n 0.001744 36.8000n 0.001786 36.8100n 0.001828 36.8200n 0.001870 36.8300n 0.001912 36.8400n 0.001954 36.8500n 0.001996 36.8600n 0.002038 36.8700n 0.002079 36.8800n 0.002121 36.8900n 0.002162
+ 36.9000n 0.002204 36.9100n 0.002245 36.9200n 0.002286 36.9300n 0.002326 36.9400n 0.002366 36.9500n 0.002406 36.9600n 0.002446 36.9700n 0.002485 36.9800n 0.002523 36.9900n 0.002562 37.0000n 0.002599 37.0100n 0.002637 37.0200n 0.002673 37.0300n 0.002710 37.0400n 0.002745
+ 37.0500n 0.002780 37.0600n 0.002815 37.0700n 0.002848 37.0800n 0.002881 37.0900n 0.002914 37.1000n 0.002945 37.1100n 0.002976 37.1200n 0.003006 37.1300n 0.003035 37.1400n 0.003064 37.1500n 0.003091 37.1600n 0.003118 37.1700n 0.003144 37.1800n 0.003169 37.1900n 0.003193
+ 37.2000n 0.003216 37.2100n 0.003238 37.2200n 0.003259 37.2300n 0.003279 37.2400n 0.003298 37.2500n 0.003316 37.2600n 0.003333 37.2700n 0.003349 37.2800n 0.003364 37.2900n 0.003378 37.3000n 0.003391 37.3100n 0.003402 37.3200n 0.003413 37.3300n 0.003422 37.3400n 0.003430
+ 37.3500n 0.003437 37.3600n 0.003443 37.3700n 0.003448 37.3800n 0.003451 37.3900n 0.003453 37.4000n 0.003455 37.4100n 0.003455 37.4200n 0.003453 37.4300n 0.003451 37.4400n 0.003447 37.4500n 0.003442 37.4600n 0.003436 37.4700n 0.003429 37.4800n 0.003421 37.4900n 0.003411
+ 37.5000n 0.003400 37.5100n 0.003388 37.5200n 0.003375 37.5300n 0.003361 37.5400n 0.003346 37.5500n 0.003329 37.5600n 0.003311 37.5700n 0.003292 37.5800n 0.003272 37.5900n 0.003251 37.6000n 0.003229 37.6100n 0.003206 37.6200n 0.003182 37.6300n 0.003156 37.6400n 0.003130
+ 37.6500n 0.003102 37.6600n 0.003074 37.6700n 0.003044 37.6800n 0.003014 37.6900n 0.002982 37.7000n 0.002950 37.7100n 0.002917 37.7200n 0.002883 37.7300n 0.002847 37.7400n 0.002812 37.7500n 0.002775 37.7600n 0.002737 37.7700n 0.002699 37.7800n 0.002660 37.7900n 0.002620
+ 37.8000n 0.002580 37.8100n 0.002539 37.8200n 0.002497 37.8300n 0.002454 37.8400n 0.002411 37.8500n 0.002368 37.8600n 0.002323 37.8700n 0.002279 37.8800n 0.002233 37.8900n 0.002188 37.9000n 0.002142 37.9100n 0.002095 37.9200n 0.002048 37.9300n 0.002001 37.9400n 0.001954
+ 37.9500n 0.001906 37.9600n 0.001858 37.9700n 0.001810 37.9800n 0.001761 37.9900n 0.001713 38.0000n 0.001664 38.0100n 0.001615 38.0200n 0.001566 38.0300n 0.001517 38.0400n 0.001468 38.0500n 0.001420 38.0600n 0.001371 38.0700n 0.001322 38.0800n 0.001273 38.0900n 0.001225
+ 38.1000n 0.001177 38.1100n 0.001129 38.1200n 0.001081 38.1300n 0.001033 38.1400n 0.000986 38.1500n 0.000939 38.1600n 0.000892 38.1700n 0.000846 38.1800n 0.000800 38.1900n 0.000755 38.2000n 0.000710 38.2100n 0.000666 38.2200n 0.000622 38.2300n 0.000579 38.2400n 0.000536
+ 38.2500n 0.000494 38.2600n 0.000452 38.2700n 0.000411 38.2800n 0.000371 38.2900n 0.000332 38.3000n 0.000293 38.3100n 0.000255 38.3200n 0.000218 38.3300n 0.000181 38.3400n 0.000145 38.3500n 0.000111 38.3600n 0.000076 38.3700n 0.000043 38.3800n 0.000011 38.3900n -0.000021
+ 38.4000n -0.000051 38.4100n -0.000081 38.4200n -0.000110 38.4300n -0.000137 38.4400n -0.000164 38.4500n -0.000190 38.4600n -0.000215 38.4700n -0.000239 38.4800n -0.000262 38.4900n -0.000284 38.5000n -0.000305 38.5100n -0.000324 38.5200n -0.000343 38.5300n -0.000361 38.5400n -0.000378
+ 38.5500n -0.000394 38.5600n -0.000408 38.5700n -0.000422 38.5800n -0.000435 38.5900n -0.000446 38.6000n -0.000457 38.6100n -0.000466 38.6200n -0.000475 38.6300n -0.000482 38.6400n -0.000488 38.6500n -0.000494 38.6600n -0.000498 38.6700n -0.000501 38.6800n -0.000504 38.6900n -0.000505
+ 38.7000n -0.000505 38.7100n -0.000504 38.7200n -0.000503 38.7300n -0.000500 38.7400n -0.000496 38.7500n -0.000492 38.7600n -0.000486 38.7700n -0.000480 38.7800n -0.000472 38.7900n -0.000464 38.8000n -0.000455 38.8100n -0.000445 38.8200n -0.000434 38.8300n -0.000422 38.8400n -0.000410
+ 38.8500n -0.000397 38.8600n -0.000383 38.8700n -0.000368 38.8800n -0.000352 38.8900n -0.000336 38.9000n -0.000319 38.9100n -0.000301 38.9200n -0.000283 38.9300n -0.000264 38.9400n -0.000244 38.9500n -0.000224 38.9600n -0.000203 38.9700n -0.000182 38.9800n -0.000160 38.9900n -0.000138
+ 39.0000n -0.000115 39.0100n -0.000092 39.0200n -0.000068 39.0300n -0.000044 39.0400n -0.000019 39.0500n 0.000006 39.0600n 0.000031 39.0700n 0.000057 39.0800n 0.000082 39.0900n 0.000109 39.1000n 0.000135 39.1100n 0.000161 39.1200n 0.000188 39.1300n 0.000215 39.1400n 0.000242
+ 39.1500n 0.000269 39.1600n 0.000296 39.1700n 0.000324 39.1800n 0.000351 39.1900n 0.000379 39.2000n 0.000406 39.2100n 0.000433 39.2200n 0.000461 39.2300n 0.000488 39.2400n 0.000515 39.2500n 0.000542 39.2600n 0.000569 39.2700n 0.000595 39.2800n 0.000622 39.2900n 0.000648
+ 39.3000n 0.000674 39.3100n 0.000700 39.3200n 0.000725 39.3300n 0.000751 39.3400n 0.000776 39.3500n 0.000800 39.3600n 0.000824 39.3700n 0.000848 39.3800n 0.000872 39.3900n 0.000895 39.4000n 0.000917 39.4100n 0.000940 39.4200n 0.000961 39.4300n 0.000983 39.4400n 0.001004
+ 39.4500n 0.001024 39.4600n 0.001044 39.4700n 0.001063 39.4800n 0.001082 39.4900n 0.001100 39.5000n 0.001118 39.5100n 0.001135 39.5200n 0.001151 39.5300n 0.001167 39.5400n 0.001183 39.5500n 0.001197 39.5600n 0.001211 39.5700n 0.001225 39.5800n 0.001238 39.5900n 0.001250
+ 39.6000n 0.001262 39.6100n 0.001273 39.6200n 0.001283 39.6300n 0.001293 39.6400n 0.001302 39.6500n 0.001310 39.6600n 0.001318 39.6700n 0.001325 39.6800n 0.001332 39.6900n 0.001338 39.7000n 0.001343 39.7100n 0.001347 39.7200n 0.001351 39.7300n 0.001355 39.7400n 0.001357
+ 39.7500n 0.001359 39.7600n 0.001361 39.7700n 0.001361 39.7800n 0.001362 39.7900n 0.001361 39.8000n 0.001360 39.8100n 0.001359 39.8200n 0.001356 39.8300n 0.001354 39.8400n 0.001350 39.8500n 0.001346 39.8600n 0.001342 39.8700n 0.001337 39.8800n 0.001332 39.8900n 0.001326
+ 39.9000n 0.001319 39.9100n 0.001312 39.9200n 0.001305 39.9300n 0.001297 39.9400n 0.001289 39.9500n 0.001280 39.9600n 0.001271 39.9700n 0.001261 39.9800n 0.001251 39.9900n 0.001241 40.0000n 0.001230 40.0100n 0.001219 40.0200n 0.001208 40.0300n 0.001196 40.0400n 0.001184
+ 40.0500n 0.001172 40.0600n 0.001159 40.0700n 0.001147 40.0800n 0.001134 40.0900n 0.001120 40.1000n 0.001107 40.1100n 0.001093 40.1200n 0.001080 40.1300n 0.001066 40.1400n 0.001052 40.1500n 0.001038 40.1600n 0.001024 40.1700n 0.001009 40.1800n 0.000995 40.1900n 0.000981
+ 40.2000n 0.000966 40.2100n 0.000952 40.2200n 0.000937 40.2300n 0.000923 40.2400n 0.000909 40.2500n 0.000895 40.2600n 0.000880 40.2700n 0.000866 40.2800n 0.000852 40.2900n 0.000838 40.3000n 0.000825 40.3100n 0.000811 40.3200n 0.000797 40.3300n 0.000784 40.3400n 0.000771
+ 40.3500n 0.000758 40.3600n 0.000746 40.3700n 0.000733 40.3800n 0.000721 40.3900n 0.000709 40.4000n 0.000697 40.4100n 0.000686 40.4200n 0.000675 40.4300n 0.000664 40.4400n 0.000653 40.4500n 0.000643 40.4600n 0.000633 40.4700n 0.000623 40.4800n 0.000614 40.4900n 0.000605
+ 40.5000n 0.000597 40.5100n 0.000589 40.5200n 0.000581 40.5300n 0.000573 40.5400n 0.000566 40.5500n 0.000560 40.5600n 0.000553 40.5700n 0.000547 40.5800n 0.000542 40.5900n 0.000537 40.6000n 0.000532 40.6100n 0.000528 40.6200n 0.000524 40.6300n 0.000520 40.6400n 0.000517
+ 40.6500n 0.000514 40.6600n 0.000512 40.6700n 0.000510 40.6800n 0.000508 40.6900n 0.000507 40.7000n 0.000506 40.7100n 0.000506 40.7200n 0.000506 40.7300n 0.000506 40.7400n 0.000507 40.7500n 0.000508 40.7600n 0.000510 40.7700n 0.000512 40.7800n 0.000514 40.7900n 0.000517
+ 40.8000n 0.000519 40.8100n 0.000523 40.8200n 0.000526 40.8300n 0.000530 40.8400n 0.000534 40.8500n 0.000539 40.8600n 0.000543 40.8700n 0.000549 40.8800n 0.000554 40.8900n 0.000559 40.9000n 0.000565 40.9100n 0.000571 40.9200n 0.000577 40.9300n 0.000584 40.9400n 0.000591
+ 40.9500n 0.000597 40.9600n 0.000604 40.9700n 0.000612 40.9800n 0.000619 40.9900n 0.000626 41.0000n 0.000634 41.0100n 0.000642 41.0200n 0.000650 41.0300n 0.000657 41.0400n 0.000665 41.0500n 0.000673 41.0600n 0.000682 41.0700n 0.000690 41.0800n 0.000698 41.0900n 0.000706
+ 41.1000n 0.000714 41.1100n 0.000722 41.1200n 0.000730 41.1300n 0.000738 41.1400n 0.000746 41.1500n 0.000754 41.1600n 0.000761 41.1700n 0.000769 41.1800n 0.000777 41.1900n 0.000784 41.2000n 0.000791 41.2100n 0.000798 41.2200n 0.000805 41.2300n 0.000812 41.2400n 0.000818
+ 41.2500n 0.000824 41.2600n 0.000831 41.2700n 0.000836 41.2800n 0.000842 41.2900n 0.000847 41.3000n 0.000852 41.3100n 0.000857 41.3200n 0.000862 41.3300n 0.000866 41.3400n 0.000870 41.3500n 0.000873 41.3600n 0.000876 41.3700n 0.000879 41.3800n 0.000882 41.3900n 0.000884
+ 41.4000n 0.000886 41.4100n 0.000887 41.4200n 0.000889 41.4300n 0.000889 41.4400n 0.000890 41.4500n 0.000890 41.4600n 0.000889 41.4700n 0.000888 41.4800n 0.000887 41.4900n 0.000886 41.5000n 0.000884 41.5100n 0.000881 41.5200n 0.000878 41.5300n 0.000875 41.5400n 0.000871
+ 41.5500n 0.000867 41.5600n 0.000863 41.5700n 0.000858 41.5800n 0.000853 41.5900n 0.000847 41.6000n 0.000841 41.6100n 0.000834 41.6200n 0.000827 41.6300n 0.000820 41.6400n 0.000812 41.6500n 0.000804 41.6600n 0.000796 41.6700n 0.000787 41.6800n 0.000778 41.6900n 0.000768
+ 41.7000n 0.000758 41.7100n 0.000748 41.7200n 0.000737 41.7300n 0.000726 41.7400n 0.000715 41.7500n 0.000703 41.7600n 0.000691 41.7700n 0.000679 41.7800n 0.000666 41.7900n 0.000653 41.8000n 0.000640 41.8100n 0.000627 41.8200n 0.000613 41.8300n 0.000599 41.8400n 0.000585
+ 41.8500n 0.000571 41.8600n 0.000556 41.8700n 0.000542 41.8800n 0.000527 41.8900n 0.000512 41.9000n 0.000497 41.9100n 0.000482 41.9200n 0.000466 41.9300n 0.000451 41.9400n 0.000435 41.9500n 0.000419 41.9600n 0.000404 41.9700n 0.000388 41.9800n 0.000372 41.9900n 0.000357
+ 42.0000n 0.000341 42.0100n 0.000325 42.0200n 0.000309 42.0300n 0.000294 42.0400n 0.000278 42.0500n 0.000263 42.0600n 0.000247 42.0700n 0.000232 42.0800n 0.000217 42.0900n 0.000202 42.1000n 0.000188 42.1100n 0.000173 42.1200n 0.000159 42.1300n 0.000145 42.1400n 0.000131
+ 42.1500n 0.000117 42.1600n 0.000104 42.1700n 0.000091 42.1800n 0.000078 42.1900n 0.000065 42.2000n 0.000053 42.2100n 0.000041 42.2200n 0.000030 42.2300n 0.000019 42.2400n 0.000008 42.2500n -0.000002 42.2600n -0.000012 42.2700n -0.000021 42.2800n -0.000030 42.2900n -0.000039
+ 42.3000n -0.000047 42.3100n -0.000055 42.3200n -0.000062 42.3300n -0.000068 42.3400n -0.000074 42.3500n -0.000080 42.3600n -0.000085 42.3700n -0.000090 42.3800n -0.000094 42.3900n -0.000097 42.4000n -0.000100 42.4100n -0.000102 42.4200n -0.000104 42.4300n -0.000105 42.4400n -0.000106
+ 42.4500n -0.000106 42.4600n -0.000105 42.4700n -0.000104 42.4800n -0.000102 42.4900n -0.000099 42.5000n -0.000096 42.5100n -0.000093 42.5200n -0.000088 42.5300n -0.000083 42.5400n -0.000078 42.5500n -0.000072 42.5600n -0.000065 42.5700n -0.000058 42.5800n -0.000049 42.5900n -0.000041
+ 42.6000n -0.000032 42.6100n -0.000022 42.6200n -0.000011 42.6300n -0.000000 42.6400n 0.000011 42.6500n 0.000023 42.6600n 0.000036 42.6700n 0.000050 42.6800n 0.000064 42.6900n 0.000078 42.7000n 0.000093 42.7100n 0.000109 42.7200n 0.000125 42.7300n 0.000141 42.7400n 0.000159
+ 42.7500n 0.000176 42.7600n 0.000194 42.7700n 0.000213 42.7800n 0.000232 42.7900n 0.000252 42.8000n 0.000272 42.8100n 0.000292 42.8200n 0.000313 42.8300n 0.000334 42.8400n 0.000356 42.8500n 0.000377 42.8600n 0.000400 42.8700n 0.000422 42.8800n 0.000445 42.8900n 0.000469
+ 42.9000n 0.000492 42.9100n 0.000516 42.9200n 0.000540 42.9300n 0.000564 42.9400n 0.000589 42.9500n 0.000613 42.9600n 0.000638 42.9700n 0.000663 42.9800n 0.000688 42.9900n 0.000713 43.0000n 0.000739 43.0100n 0.000764 43.0200n 0.000790 43.0300n 0.000815 43.0400n 0.000841
+ 43.0500n 0.000866 43.0600n 0.000892 43.0700n 0.000917 43.0800n 0.000942 43.0900n 0.000968 43.1000n 0.000993 43.1100n 0.001018 43.1200n 0.001043 43.1300n 0.001067 43.1400n 0.001092 43.1500n 0.001116 43.1600n 0.001140 43.1700n 0.001164 43.1800n 0.001187 43.1900n 0.001211
+ 43.2000n 0.001234 43.2100n 0.001256 43.2200n 0.001278 43.2300n 0.001300 43.2400n 0.001322 43.2500n 0.001343 43.2600n 0.001363 43.2700n 0.001384 43.2800n 0.001403 43.2900n 0.001422 43.3000n 0.001441 43.3100n 0.001459 43.3200n 0.001477 43.3300n 0.001494 43.3400n 0.001511
+ 43.3500n 0.001527 43.3600n 0.001542 43.3700n 0.001557 43.3800n 0.001571 43.3900n 0.001585 43.4000n 0.001598 43.4100n 0.001610 43.4200n 0.001622 43.4300n 0.001633 43.4400n 0.001643 43.4500n 0.001652 43.4600n 0.001661 43.4700n 0.001669 43.4800n 0.001677 43.4900n 0.001683
+ 43.5000n 0.001689 43.5100n 0.001694 43.5200n 0.001699 43.5300n 0.001702 43.5400n 0.001705 43.5500n 0.001707 43.5600n 0.001708 43.5700n 0.001709 43.5800n 0.001709 43.5900n 0.001708 43.6000n 0.001706 43.6100n 0.001703 43.6200n 0.001700 43.6300n 0.001695 43.6400n 0.001690
+ 43.6500n 0.001685 43.6600n 0.001678 43.6700n 0.001671 43.6800n 0.001663 43.6900n 0.001654 43.7000n 0.001644 43.7100n 0.001634 43.7200n 0.001623 43.7300n 0.001611 43.7400n 0.001598 43.7500n 0.001585 43.7600n 0.001571 43.7700n 0.001556 43.7800n 0.001541 43.7900n 0.001524
+ 43.8000n 0.001508 43.8100n 0.001490 43.8200n 0.001472 43.8300n 0.001453 43.8400n 0.001434 43.8500n 0.001414 43.8600n 0.001393 43.8700n 0.001372 43.8800n 0.001350 43.8900n 0.001328 43.9000n 0.001305 43.9100n 0.001281 43.9200n 0.001257 43.9300n 0.001233 43.9400n 0.001208
+ 43.9500n 0.001183 43.9600n 0.001157 43.9700n 0.001131 43.9800n 0.001104 43.9900n 0.001077 44.0000n 0.001050 44.0100n 0.001023 44.0200n 0.000995 44.0300n 0.000966 44.0400n 0.000938 44.0500n 0.000909 44.0600n 0.000880 44.0700n 0.000851 44.0800n 0.000822 44.0900n 0.000792
+ 44.1000n 0.000762 44.1100n 0.000733 44.1200n 0.000703 44.1300n 0.000673 44.1400n 0.000643 44.1500n 0.000613 44.1600n 0.000583 44.1700n 0.000553 44.1800n 0.000523 44.1900n 0.000493 44.2000n 0.000463 44.2100n 0.000434 44.2200n 0.000404 44.2300n 0.000375 44.2400n 0.000345
+ 44.2500n 0.000316 44.2600n 0.000288 44.2700n 0.000259 44.2800n 0.000231 44.2900n 0.000203 44.3000n 0.000175 44.3100n 0.000148 44.3200n 0.000121 44.3300n 0.000094 44.3400n 0.000068 44.3500n 0.000042 44.3600n 0.000017 44.3700n -0.000008 44.3800n -0.000033 44.3900n -0.000057
+ 44.4000n -0.000080 44.4100n -0.000103 44.4200n -0.000125 44.4300n -0.000147 44.4400n -0.000168 44.4500n -0.000189 44.4600n -0.000209 44.4700n -0.000229 44.4800n -0.000247 44.4900n -0.000266 44.5000n -0.000283 44.5100n -0.000300 44.5200n -0.000316 44.5300n -0.000332 44.5400n -0.000346
+ 44.5500n -0.000360 44.5600n -0.000374 44.5700n -0.000386 44.5800n -0.000398 44.5900n -0.000409 44.6000n -0.000419 44.6100n -0.000429 44.6200n -0.000437 44.6300n -0.000445 44.6400n -0.000452 44.6500n -0.000459 44.6600n -0.000464 44.6700n -0.000469 44.6800n -0.000473 44.6900n -0.000476
+ 44.7000n -0.000479 44.7100n -0.000480 44.7200n -0.000481 44.7300n -0.000481 44.7400n -0.000480 44.7500n -0.000478 44.7600n -0.000476 44.7700n -0.000473 44.7800n -0.000469 44.7900n -0.000464 44.8000n -0.000458 44.8100n -0.000452 44.8200n -0.000445 44.8300n -0.000437 44.8400n -0.000428
+ 44.8500n -0.000419 44.8600n -0.000409 44.8700n -0.000398 44.8800n -0.000386 44.8900n -0.000374 44.9000n -0.000361 44.9100n -0.000347 44.9200n -0.000333 44.9300n -0.000318 44.9400n -0.000303 44.9500n -0.000286 44.9600n -0.000270 44.9700n -0.000252 44.9800n -0.000234 44.9900n -0.000216
+ 45.0000n -0.000196 45.0100n -0.000177 45.0200n -0.000157 45.0300n -0.000136 45.0400n -0.000115 45.0500n -0.000093 45.0600n -0.000071 45.0700n -0.000049 45.0800n -0.000026 45.0900n -0.000003 45.1000n 0.000021 45.1100n 0.000044 45.1200n 0.000069 45.1300n 0.000093 45.1400n 0.000118
+ 45.1500n 0.000143 45.1600n 0.000168 45.1700n 0.000193 45.1800n 0.000219 45.1900n 0.000245 45.2000n 0.000271 45.2100n 0.000297 45.2200n 0.000323 45.2300n 0.000349 45.2400n 0.000375 45.2500n 0.000401 45.2600n 0.000428 45.2700n 0.000454 45.2800n 0.000480 45.2900n 0.000506
+ 45.3000n 0.000532 45.3100n 0.000558 45.3200n 0.000584 45.3300n 0.000609 45.3400n 0.000635 45.3500n 0.000660 45.3600n 0.000685 45.3700n 0.000709 45.3800n 0.000734 45.3900n 0.000758 45.4000n 0.000782 45.4100n 0.000805 45.4200n 0.000828 45.4300n 0.000851 45.4400n 0.000873
+ 45.4500n 0.000895 45.4600n 0.000916 45.4700n 0.000937 45.4800n 0.000958 45.4900n 0.000978 45.5000n 0.000997 45.5100n 0.001016 45.5200n 0.001034 45.5300n 0.001052 45.5400n 0.001069 45.5500n 0.001086 45.5600n 0.001102 45.5700n 0.001117 45.5800n 0.001131 45.5900n 0.001145
+ 45.6000n 0.001158 45.6100n 0.001171 45.6200n 0.001183 45.6300n 0.001194 45.6400n 0.001204 45.6500n 0.001214 45.6600n 0.001223 45.6700n 0.001231 45.6800n 0.001238 45.6900n 0.001244 45.7000n 0.001250 45.7100n 0.001255 45.7200n 0.001259 45.7300n 0.001262 45.7400n 0.001264
+ 45.7500n 0.001266 45.7600n 0.001266 45.7700n 0.001266 45.7800n 0.001265 45.7900n 0.001263 45.8000n 0.001260 45.8100n 0.001257 45.8200n 0.001252 45.8300n 0.001247 45.8400n 0.001240 45.8500n 0.001233 45.8600n 0.001225 45.8700n 0.001216 45.8800n 0.001207 45.8900n 0.001196
+ 45.9000n 0.001185 45.9100n 0.001172 45.9200n 0.001159 45.9300n 0.001145 45.9400n 0.001130 45.9500n 0.001114 45.9600n 0.001098 45.9700n 0.001081 45.9800n 0.001062 45.9900n 0.001043 46.0000n 0.001024 46.0100n 0.001003 46.0200n 0.000982 46.0300n 0.000960 46.0400n 0.000937
+ 46.0500n 0.000913 46.0600n 0.000889 46.0700n 0.000864 46.0800n 0.000838 46.0900n 0.000811 46.1000n 0.000784 46.1100n 0.000756 46.1200n 0.000728 46.1300n 0.000699 46.1400n 0.000669 46.1500n 0.000639 46.1600n 0.000608 46.1700n 0.000576 46.1800n 0.000544 46.1900n 0.000511
+ 46.2000n 0.000478 46.2100n 0.000444 46.2200n 0.000410 46.2300n 0.000376 46.2400n 0.000341 46.2500n 0.000305 46.2600n 0.000269 46.2700n 0.000233 46.2800n 0.000196 46.2900n 0.000159 46.3000n 0.000122 46.3100n 0.000084 46.3200n 0.000046 46.3300n 0.000008 46.3400n -0.000031
+ 46.3500n -0.000070 46.3600n -0.000109 46.3700n -0.000148 46.3800n -0.000187 46.3900n -0.000227 46.4000n -0.000266 46.4100n -0.000306 46.4200n -0.000346 46.4300n -0.000386 46.4400n -0.000426 46.4500n -0.000466 46.4600n -0.000506 46.4700n -0.000546 46.4800n -0.000585 46.4900n -0.000625
+ 46.5000n -0.000665 46.5100n -0.000705 46.5200n -0.000744 46.5300n -0.000784 46.5400n -0.000823 46.5500n -0.000862 46.5600n -0.000901 46.5700n -0.000939 46.5800n -0.000978 46.5900n -0.001016 46.6000n -0.001054 46.6100n -0.001091 46.6200n -0.001129 46.6300n -0.001166 46.6400n -0.001202
+ 46.6500n -0.001239 46.6600n -0.001274 46.6700n -0.001310 46.6800n -0.001345 46.6900n -0.001379 46.7000n -0.001414 46.7100n -0.001447 46.7200n -0.001480 46.7300n -0.001513 46.7400n -0.001545 46.7500n -0.001577 46.7600n -0.001608 46.7700n -0.001639 46.7800n -0.001669 46.7900n -0.001698
+ 46.8000n -0.001727 46.8100n -0.001756 46.8200n -0.001783 46.8300n -0.001810 46.8400n -0.001837 46.8500n -0.001862 46.8600n -0.001888 46.8700n -0.001912 46.8800n -0.001936 46.8900n -0.001959 46.9000n -0.001982 46.9100n -0.002003 46.9200n -0.002024 46.9300n -0.002045 46.9400n -0.002064
+ 46.9500n -0.002083 46.9600n -0.002101 46.9700n -0.002119 46.9800n -0.002136 46.9900n -0.002152 47.0000n -0.002167 47.0100n -0.002182 47.0200n -0.002195 47.0300n -0.002208 47.0400n -0.002221 47.0500n -0.002232 47.0600n -0.002243 47.0700n -0.002253 47.0800n -0.002262 47.0900n -0.002271
+ 47.1000n -0.002279 47.1100n -0.002286 47.1200n -0.002292 47.1300n -0.002297 47.1400n -0.002302 47.1500n -0.002306 47.1600n -0.002310 47.1700n -0.002312 47.1800n -0.002314 47.1900n -0.002315 47.2000n -0.002316 47.2100n -0.002315 47.2200n -0.002314 47.2300n -0.002312 47.2400n -0.002310
+ 47.2500n -0.002307 47.2600n -0.002303 47.2700n -0.002298 47.2800n -0.002293 47.2900n -0.002287 47.3000n -0.002281 47.3100n -0.002273 47.3200n -0.002265 47.3300n -0.002257 47.3400n -0.002248 47.3500n -0.002238 47.3600n -0.002227 47.3700n -0.002216 47.3800n -0.002205 47.3900n -0.002193
+ 47.4000n -0.002180 47.4100n -0.002166 47.4200n -0.002152 47.4300n -0.002138 47.4400n -0.002123 47.4500n -0.002107 47.4600n -0.002091 47.4700n -0.002074 47.4800n -0.002057 47.4900n -0.002040 47.5000n -0.002021 47.5100n -0.002003 47.5200n -0.001984 47.5300n -0.001964 47.5400n -0.001944
+ 47.5500n -0.001924 47.5600n -0.001903 47.5700n -0.001882 47.5800n -0.001860 47.5900n -0.001838 47.6000n -0.001815 47.6100n -0.001793 47.6200n -0.001769 47.6300n -0.001746 47.6400n -0.001722 47.6500n -0.001698 47.6600n -0.001673 47.6700n -0.001648 47.6800n -0.001623 47.6900n -0.001598
+ 47.7000n -0.001572 47.7100n -0.001546 47.7200n -0.001520 47.7300n -0.001493 47.7400n -0.001467 47.7500n -0.001440 47.7600n -0.001412 47.7700n -0.001385 47.7800n -0.001358 47.7900n -0.001330 47.8000n -0.001302 47.8100n -0.001274 47.8200n -0.001245 47.8300n -0.001217 47.8400n -0.001188
+ 47.8500n -0.001159 47.8600n -0.001130 47.8700n -0.001101 47.8800n -0.001072 47.8900n -0.001043 47.9000n -0.001014 47.9100n -0.000984 47.9200n -0.000955 47.9300n -0.000925 47.9400n -0.000895 47.9500n -0.000866 47.9600n -0.000836 47.9700n -0.000806 47.9800n -0.000776 47.9900n -0.000746
+ 48.0000n -0.000716 48.0100n -0.000686 48.0200n -0.000656 48.0300n -0.000626 48.0400n -0.000596 48.0500n -0.000566 48.0600n -0.000536 48.0700n -0.000506 48.0800n -0.000476 48.0900n -0.000446 48.1000n -0.000416 48.1100n -0.000386 48.1200n -0.000356 48.1300n -0.000326 48.1400n -0.000296
+ 48.1500n -0.000266 48.1600n -0.000236 48.1700n -0.000206 48.1800n -0.000177 48.1900n -0.000147 48.2000n -0.000117 48.2100n -0.000088 48.2200n -0.000058 48.2300n -0.000029 48.2400n 0.000000 48.2500n 0.000030 48.2600n 0.000059 48.2700n 0.000088 48.2800n 0.000117 48.2900n 0.000146
+ 48.3000n 0.000175 48.3100n 0.000204 48.3200n 0.000232 48.3300n 0.000261 48.3400n 0.000289 48.3500n 0.000318 48.3600n 0.000346 48.3700n 0.000374 48.3800n 0.000402 48.3900n 0.000430 48.4000n 0.000458 48.4100n 0.000485 48.4200n 0.000513 48.4300n 0.000540 48.4400n 0.000568
+ 48.4500n 0.000595 48.4600n 0.000622 48.4700n 0.000649 48.4800n 0.000676 48.4900n 0.000703 48.5000n 0.000729 48.5100n 0.000756 48.5200n 0.000782 48.5300n 0.000808 48.5400n 0.000834 48.5500n 0.000860 48.5600n 0.000885 48.5700n 0.000911 48.5800n 0.000936 48.5900n 0.000961
+ 48.6000n 0.000986 48.6100n 0.001011 48.6200n 0.001036 48.6300n 0.001061 48.6400n 0.001085 48.6500n 0.001109 48.6600n 0.001133 48.6700n 0.001157 48.6800n 0.001180 48.6900n 0.001204 48.7000n 0.001227 48.7100n 0.001250 48.7200n 0.001273 48.7300n 0.001295 48.7400n 0.001318
+ 48.7500n 0.001340 48.7600n 0.001362 48.7700n 0.001384 48.7800n 0.001405 48.7900n 0.001426 48.8000n 0.001448 48.8100n 0.001468 48.8200n 0.001489 48.8300n 0.001509 48.8400n 0.001529 48.8500n 0.001549 48.8600n 0.001568 48.8700n 0.001588 48.8800n 0.001607 48.8900n 0.001625
+ 48.9000n 0.001644 48.9100n 0.001662 48.9200n 0.001680 48.9300n 0.001697 48.9400n 0.001714 48.9500n 0.001731 48.9600n 0.001748 48.9700n 0.001764 48.9800n 0.001780 48.9900n 0.001795 49.0000n 0.001811 49.0100n 0.001826 49.0200n 0.001840 49.0300n 0.001854 49.0400n 0.001868
+ 49.0500n 0.001881 49.0600n 0.001894 49.0700n 0.001907 49.0800n 0.001919 49.0900n 0.001931 49.1000n 0.001943 49.1100n 0.001954 49.1200n 0.001964 49.1300n 0.001975 49.1400n 0.001984 49.1500n 0.001994 49.1600n 0.002003 49.1700n 0.002011 49.1800n 0.002019 49.1900n 0.002027
+ 49.2000n 0.002034 49.2100n 0.002041 49.2200n 0.002047 49.2300n 0.002052 49.2400n 0.002058 49.2500n 0.002062 49.2600n 0.002067 49.2700n 0.002070 49.2800n 0.002074 49.2900n 0.002076 49.3000n 0.002078 49.3100n 0.002080 49.3200n 0.002081 49.3300n 0.002082 49.3400n 0.002082
+ 49.3500n 0.002082 49.3600n 0.002081 49.3700n 0.002079 49.3800n 0.002077 49.3900n 0.002075 49.4000n 0.002071 49.4100n 0.002068 49.4200n 0.002063 49.4300n 0.002059 49.4400n 0.002053 49.4500n 0.002047 49.4600n 0.002041 49.4700n 0.002034 49.4800n 0.002026 49.4900n 0.002018
+ 49.5000n 0.002009 49.5100n 0.002000 49.5200n 0.001990 49.5300n 0.001979 49.5400n 0.001968 49.5500n 0.001956 49.5600n 0.001944 49.5700n 0.001931 49.5800n 0.001918 49.5900n 0.001904 49.6000n 0.001889 49.6100n 0.001874 49.6200n 0.001858 49.6300n 0.001842 49.6400n 0.001825
+ 49.6500n 0.001808 49.6600n 0.001790 49.6700n 0.001771 49.6800n 0.001752 49.6900n 0.001732 49.7000n 0.001712 49.7100n 0.001691 49.7200n 0.001670 49.7300n 0.001648 49.7400n 0.001626 49.7500n 0.001603 49.7600n 0.001579 49.7700n 0.001555 49.7800n 0.001531 49.7900n 0.001506
+ 49.8000n 0.001480 49.8100n 0.001454 49.8200n 0.001428 49.8300n 0.001401 49.8400n 0.001374 49.8500n 0.001346 49.8600n 0.001317 49.8700n 0.001289 49.8800n 0.001259 49.8900n 0.001230 49.9000n 0.001200 49.9100n 0.001169 49.9200n 0.001138 49.9300n 0.001107 49.9400n 0.001075
+ 49.9500n 0.001043 49.9600n 0.001011 49.9700n 0.000978 49.9800n 0.000945 49.9900n 0.000912 50.0000n 0.000878 50.0100n 0.000844 50.0200n 0.000809 50.0300n 0.000775 50.0400n 0.000740 50.0500n 0.000704 50.0600n 0.000669 50.0700n 0.000633 50.0800n 0.000597 50.0900n 0.000561
+ 50.1000n 0.000525 50.1100n 0.000488 50.1200n 0.000451 50.1300n 0.000415 50.1400n 0.000377 50.1500n 0.000340 50.1600n 0.000303 50.1700n 0.000265 50.1800n 0.000228 50.1900n 0.000190 50.2000n 0.000153 50.2100n 0.000115 50.2200n 0.000077 50.2300n 0.000039 50.2400n 0.000001
+ 50.2500n -0.000037 50.2600n -0.000075 50.2700n -0.000113 50.2800n -0.000150 50.2900n -0.000188 50.3000n -0.000226 50.3100n -0.000264 50.3200n -0.000301 50.3300n -0.000339 50.3400n -0.000376 50.3500n -0.000413 50.3600n -0.000450 50.3700n -0.000487 50.3800n -0.000524 50.3900n -0.000561
+ 50.4000n -0.000597 50.4100n -0.000634 50.4200n -0.000670 50.4300n -0.000705 50.4400n -0.000741 50.4500n -0.000776 50.4600n -0.000811 50.4700n -0.000846 50.4800n -0.000881 50.4900n -0.000915 50.5000n -0.000949 50.5100n -0.000982 50.5200n -0.001016 50.5300n -0.001049 50.5400n -0.001081
+ 50.5500n -0.001113 50.5600n -0.001145 50.5700n -0.001177 50.5800n -0.001208 50.5900n -0.001238 50.6000n -0.001269 50.6100n -0.001298 50.6200n -0.001328 50.6300n -0.001357 50.6400n -0.001385 50.6500n -0.001413 50.6600n -0.001441 50.6700n -0.001468 50.6800n -0.001495 50.6900n -0.001521
+ 50.7000n -0.001547 50.7100n -0.001572 50.7200n -0.001597 50.7300n -0.001621 50.7400n -0.001645 50.7500n -0.001668 50.7600n -0.001691 50.7700n -0.001713 50.7800n -0.001734 50.7900n -0.001756 50.8000n -0.001776 50.8100n -0.001796 50.8200n -0.001816 50.8300n -0.001835 50.8400n -0.001853
+ 50.8500n -0.001871 50.8600n -0.001888 50.8700n -0.001905 50.8800n -0.001921 50.8900n -0.001937 50.9000n -0.001952 50.9100n -0.001966 50.9200n -0.001980 50.9300n -0.001994 50.9400n -0.002007 50.9500n -0.002019 50.9600n -0.002031 50.9700n -0.002042 50.9800n -0.002052 50.9900n -0.002063
+ 51.0000n -0.002072 51.0100n -0.002081 51.0200n -0.002090 51.0300n -0.002098 51.0400n -0.002105 51.0500n -0.002112 51.0600n -0.002118 51.0700n -0.002124 51.0800n -0.002129 51.0900n -0.002134 51.1000n -0.002138 51.1100n -0.002142 51.1200n -0.002146 51.1300n -0.002148 51.1400n -0.002151
+ 51.1500n -0.002153 51.1600n -0.002154 51.1700n -0.002155 51.1800n -0.002155 51.1900n -0.002155 51.2000n -0.002155 51.2100n -0.002154 51.2200n -0.002152 51.2300n -0.002151 51.2400n -0.002148 51.2500n -0.002146 51.2600n -0.002143 51.2700n -0.002139 51.2800n -0.002136 51.2900n -0.002131
+ 51.3000n -0.002127 51.3100n -0.002122 51.3200n -0.002117 51.3300n -0.002111 51.3400n -0.002105 51.3500n -0.002099 51.3600n -0.002092 51.3700n -0.002085 51.3800n -0.002078 51.3900n -0.002070 51.4000n -0.002063 51.4100n -0.002055 51.4200n -0.002046 51.4300n -0.002038 51.4400n -0.002029
+ 51.4500n -0.002020 51.4600n -0.002010 51.4700n -0.002001 51.4800n -0.001991 51.4900n -0.001981 51.5000n -0.001971 51.5100n -0.001961 51.5200n -0.001950 51.5300n -0.001939 51.5400n -0.001929 51.5500n -0.001918 51.5600n -0.001906 51.5700n -0.001895 51.5800n -0.001884 51.5900n -0.001872
+ 51.6000n -0.001861 51.6100n -0.001849 51.6200n -0.001837 51.6300n -0.001825 51.6400n -0.001813 51.6500n -0.001801 51.6600n -0.001789 51.6700n -0.001777 51.6800n -0.001765 51.6900n -0.001752 51.7000n -0.001740 51.7100n -0.001728 51.7200n -0.001716 51.7300n -0.001703 51.7400n -0.001691
+ 51.7500n -0.001679 51.7600n -0.001666 51.7700n -0.001654 51.7800n -0.001642 51.7900n -0.001629 51.8000n -0.001617 51.8100n -0.001605 51.8200n -0.001593 51.8300n -0.001581 51.8400n -0.001568 51.8500n -0.001556 51.8600n -0.001544 51.8700n -0.001533 51.8800n -0.001521 51.8900n -0.001509
+ 51.9000n -0.001497 51.9100n -0.001486 51.9200n -0.001474 51.9300n -0.001462 51.9400n -0.001451 51.9500n -0.001440 51.9600n -0.001428 51.9700n -0.001417 51.9800n -0.001406 51.9900n -0.001395 52.0000n -0.001384 52.0100n -0.001373 52.0200n -0.001363 52.0300n -0.001352 52.0400n -0.001342
+ 52.0500n -0.001331 52.0600n -0.001321 52.0700n -0.001310 52.0800n -0.001300 52.0900n -0.001290 52.1000n -0.001280 52.1100n -0.001270 52.1200n -0.001260 52.1300n -0.001251 52.1400n -0.001241 52.1500n -0.001231 52.1600n -0.001222 52.1700n -0.001212 52.1800n -0.001203 52.1900n -0.001194
+ 52.2000n -0.001185 52.2100n -0.001175 52.2200n -0.001166 52.2300n -0.001157 52.2400n -0.001148 52.2500n -0.001139 52.2600n -0.001130 52.2700n -0.001121 52.2800n -0.001113 52.2900n -0.001104 52.3000n -0.001095 52.3100n -0.001086 52.3200n -0.001077 52.3300n -0.001069 52.3400n -0.001060
+ 52.3500n -0.001051 52.3600n -0.001042 52.3700n -0.001034 52.3800n -0.001025 52.3900n -0.001016 52.4000n -0.001007 52.4100n -0.000999 52.4200n -0.000990 52.4300n -0.000981 52.4400n -0.000972 52.4500n -0.000963 52.4600n -0.000954 52.4700n -0.000945 52.4800n -0.000935 52.4900n -0.000926
+ 52.5000n -0.000917 52.5100n -0.000907 52.5200n -0.000898 52.5300n -0.000888 52.5400n -0.000878 52.5500n -0.000868 52.5600n -0.000858 52.5700n -0.000848 52.5800n -0.000838 52.5900n -0.000828 52.6000n -0.000817 52.6100n -0.000806 52.6200n -0.000796 52.6300n -0.000785 52.6400n -0.000773
+ 52.6500n -0.000762 52.6600n -0.000751 52.6700n -0.000739 52.6800n -0.000727 52.6900n -0.000715 52.7000n -0.000703 52.7100n -0.000690 52.7200n -0.000677 52.7300n -0.000664 52.7400n -0.000651 52.7500n -0.000638 52.7600n -0.000624 52.7700n -0.000610 52.7800n -0.000596 52.7900n -0.000582
+ 52.8000n -0.000567 52.8100n -0.000553 52.8200n -0.000538 52.8300n -0.000522 52.8400n -0.000507 52.8500n -0.000491 52.8600n -0.000475 52.8700n -0.000458 52.8800n -0.000441 52.8900n -0.000424 52.9000n -0.000407 52.9100n -0.000390 52.9200n -0.000372 52.9300n -0.000354 52.9400n -0.000335
+ 52.9500n -0.000317 52.9600n -0.000298 52.9700n -0.000278 52.9800n -0.000259 52.9900n -0.000239 53.0000n -0.000219 53.0100n -0.000198 53.0200n -0.000177 53.0300n -0.000156 53.0400n -0.000135 53.0500n -0.000113 53.0600n -0.000091 53.0700n -0.000069 53.0800n -0.000047 53.0900n -0.000024
+ 53.1000n -0.000001 53.1100n 0.000023 53.1200n 0.000047 53.1300n 0.000071 53.1400n 0.000095 53.1500n 0.000120 53.1600n 0.000144 53.1700n 0.000170 53.1800n 0.000195 53.1900n 0.000221 53.2000n 0.000247 53.2100n 0.000273 53.2200n 0.000300 53.2300n 0.000326 53.2400n 0.000353
+ 53.2500n 0.000381 53.2600n 0.000408 53.2700n 0.000436 53.2800n 0.000464 53.2900n 0.000492 53.3000n 0.000521 53.3100n 0.000549 53.3200n 0.000578 53.3300n 0.000607 53.3400n 0.000637 53.3500n 0.000666 53.3600n 0.000696 53.3700n 0.000726 53.3800n 0.000756 53.3900n 0.000786
+ 53.4000n 0.000817 53.4100n 0.000847 53.4200n 0.000878 53.4300n 0.000909 53.4400n 0.000940 53.4500n 0.000971 53.4600n 0.001002 53.4700n 0.001034 53.4800n 0.001065 53.4900n 0.001097 53.5000n 0.001129 53.5100n 0.001160 53.5200n 0.001192 53.5300n 0.001224 53.5400n 0.001256
+ 53.5500n 0.001288 53.5600n 0.001320 53.5700n 0.001352 53.5800n 0.001384 53.5900n 0.001416 53.6000n 0.001448 53.6100n 0.001480 53.6200n 0.001512 53.6300n 0.001544 53.6400n 0.001576 53.6500n 0.001608 53.6600n 0.001640 53.6700n 0.001671 53.6800n 0.001703 53.6900n 0.001735
+ 53.7000n 0.001766 53.7100n 0.001798 53.7200n 0.001829 53.7300n 0.001860 53.7400n 0.001891 53.7500n 0.001922 53.7600n 0.001952 53.7700n 0.001983 53.7800n 0.002013 53.7900n 0.002043 53.8000n 0.002073 53.8100n 0.002103 53.8200n 0.002132 53.8300n 0.002162 53.8400n 0.002191
+ 53.8500n 0.002219 53.8600n 0.002248 53.8700n 0.002276 53.8800n 0.002304 53.8900n 0.002331 53.9000n 0.002359 53.9100n 0.002386 53.9200n 0.002412 53.9300n 0.002439 53.9400n 0.002465 53.9500n 0.002490 53.9600n 0.002516 53.9700n 0.002541 53.9800n 0.002565 53.9900n 0.002589
+ 54.0000n 0.002613 54.0100n 0.002636 54.0200n 0.002659 54.0300n 0.002682 54.0400n 0.002704 54.0500n 0.002725 54.0600n 0.002746 54.0700n 0.002767 54.0800n 0.002787 54.0900n 0.002807 54.1000n 0.002826 54.1100n 0.002845 54.1200n 0.002863 54.1300n 0.002881 54.1400n 0.002898
+ 54.1500n 0.002915 54.1600n 0.002931 54.1700n 0.002947 54.1800n 0.002962 54.1900n 0.002976 54.2000n 0.002990 54.2100n 0.003004 54.2200n 0.003016 54.2300n 0.003029 54.2400n 0.003040 54.2500n 0.003052 54.2600n 0.003062 54.2700n 0.003072 54.2800n 0.003081 54.2900n 0.003090
+ 54.3000n 0.003098 54.3100n 0.003106 54.3200n 0.003113 54.3300n 0.003119 54.3400n 0.003125 54.3500n 0.003130 54.3600n 0.003134 54.3700n 0.003138 54.3800n 0.003141 54.3900n 0.003143 54.4000n 0.003145 54.4100n 0.003146 54.4200n 0.003147 54.4300n 0.003147 54.4400n 0.003146
+ 54.4500n 0.003145 54.4600n 0.003143 54.4700n 0.003140 54.4800n 0.003137 54.4900n 0.003133 54.5000n 0.003128 54.5100n 0.003123 54.5200n 0.003117 54.5300n 0.003110 54.5400n 0.003103 54.5500n 0.003095 54.5600n 0.003087 54.5700n 0.003078 54.5800n 0.003068 54.5900n 0.003058
+ 54.6000n 0.003047 54.6100n 0.003035 54.6200n 0.003023 54.6300n 0.003010 54.6400n 0.002996 54.6500n 0.002982 54.6600n 0.002967 54.6700n 0.002952 54.6800n 0.002936 54.6900n 0.002919 54.7000n 0.002902 54.7100n 0.002885 54.7200n 0.002866 54.7300n 0.002847 54.7400n 0.002828
+ 54.7500n 0.002808 54.7600n 0.002787 54.7700n 0.002766 54.7800n 0.002744 54.7900n 0.002722 54.8000n 0.002699 54.8100n 0.002676 54.8200n 0.002652 54.8300n 0.002628 54.8400n 0.002603 54.8500n 0.002578 54.8600n 0.002552 54.8700n 0.002526 54.8800n 0.002499 54.8900n 0.002472
+ 54.9000n 0.002445 54.9100n 0.002417 54.9200n 0.002388 54.9300n 0.002359 54.9400n 0.002330 54.9500n 0.002300 54.9600n 0.002270 54.9700n 0.002240 54.9800n 0.002209 54.9900n 0.002178 55.0000n 0.002147 55.0100n 0.002115 55.0200n 0.002083 55.0300n 0.002050 55.0400n 0.002018
+ 55.0500n 0.001985 55.0600n 0.001951 55.0700n 0.001918 55.0800n 0.001884 55.0900n 0.001850 55.1000n 0.001816 55.1100n 0.001782 55.1200n 0.001747 55.1300n 0.001712 55.1400n 0.001677 55.1500n 0.001642 55.1600n 0.001607 55.1700n 0.001572 55.1800n 0.001536 55.1900n 0.001500
+ 55.2000n 0.001465 55.2100n 0.001429 55.2200n 0.001393 55.2300n 0.001357 55.2400n 0.001321 55.2500n 0.001286 55.2600n 0.001250 55.2700n 0.001214 55.2800n 0.001178 55.2900n 0.001142 55.3000n 0.001106 55.3100n 0.001070 55.3200n 0.001035 55.3300n 0.000999 55.3400n 0.000964
+ 55.3500n 0.000928 55.3600n 0.000893 55.3700n 0.000858 55.3800n 0.000823 55.3900n 0.000788 55.4000n 0.000753 55.4100n 0.000719 55.4200n 0.000685 55.4300n 0.000651 55.4400n 0.000617 55.4500n 0.000584 55.4600n 0.000550 55.4700n 0.000517 55.4800n 0.000485 55.4900n 0.000452
+ 55.5000n 0.000420 55.5100n 0.000388 55.5200n 0.000357 55.5300n 0.000326 55.5400n 0.000295 55.5500n 0.000265 55.5600n 0.000235 55.5700n 0.000205 55.5800n 0.000176 55.5900n 0.000147 55.6000n 0.000119 55.6100n 0.000091 55.6200n 0.000063 55.6300n 0.000036 55.6400n 0.000010
+ 55.6500n -0.000017 55.6600n -0.000042 55.6700n -0.000067 55.6800n -0.000092 55.6900n -0.000116 55.7000n -0.000140 55.7100n -0.000163 55.7200n -0.000185 55.7300n -0.000207 55.7400n -0.000229 55.7500n -0.000250 55.7600n -0.000270 55.7700n -0.000290 55.7800n -0.000309 55.7900n -0.000328
+ 55.8000n -0.000346 55.8100n -0.000364 55.8200n -0.000380 55.8300n -0.000397 55.8400n -0.000412 55.8500n -0.000427 55.8600n -0.000442 55.8700n -0.000456 55.8800n -0.000469 55.8900n -0.000482 55.9000n -0.000494 55.9100n -0.000505 55.9200n -0.000516 55.9300n -0.000526 55.9400n -0.000535
+ 55.9500n -0.000544 55.9600n -0.000552 55.9700n -0.000560 55.9800n -0.000567 55.9900n -0.000573 56.0000n -0.000579 56.0100n -0.000584 56.0200n -0.000588 56.0300n -0.000592 56.0400n -0.000595 56.0500n -0.000598 56.0600n -0.000599 56.0700n -0.000601 56.0800n -0.000601 56.0900n -0.000601
+ 56.1000n -0.000601 56.1100n -0.000600 56.1200n -0.000598 56.1300n -0.000596 56.1400n -0.000593 56.1500n -0.000589 56.1600n -0.000585 56.1700n -0.000581 56.1800n -0.000575 56.1900n -0.000570 56.2000n -0.000563 56.2100n -0.000556 56.2200n -0.000549 56.2300n -0.000541 56.2400n -0.000533
+ 56.2500n -0.000524 56.2600n -0.000514 56.2700n -0.000504 56.2800n -0.000494 56.2900n -0.000483 56.3000n -0.000472 56.3100n -0.000460 56.3200n -0.000448 56.3300n -0.000435 56.3400n -0.000422 56.3500n -0.000409 56.3600n -0.000395 56.3700n -0.000380 56.3800n -0.000366 56.3900n -0.000351
+ 56.4000n -0.000335 56.4100n -0.000320 56.4200n -0.000304 56.4300n -0.000288 56.4400n -0.000271 56.4500n -0.000254 56.4600n -0.000237 56.4700n -0.000220 56.4800n -0.000202 56.4900n -0.000184 56.5000n -0.000166 56.5100n -0.000148 56.5200n -0.000129 56.5300n -0.000111 56.5400n -0.000092
+ 56.5500n -0.000073 56.5600n -0.000054 56.5700n -0.000035 56.5800n -0.000016 56.5900n 0.000003 56.6000n 0.000023 56.6100n 0.000042 56.6200n 0.000062 56.6300n 0.000081 56.6400n 0.000101 56.6500n 0.000120 56.6600n 0.000139 56.6700n 0.000159 56.6800n 0.000178 56.6900n 0.000197
+ 56.7000n 0.000217 56.7100n 0.000236 56.7200n 0.000255 56.7300n 0.000273 56.7400n 0.000292 56.7500n 0.000311 56.7600n 0.000329 56.7700n 0.000347 56.7800n 0.000365 56.7900n 0.000383 56.8000n 0.000400 56.8100n 0.000417 56.8200n 0.000434 56.8300n 0.000451 56.8400n 0.000467
+ 56.8500n 0.000484 56.8600n 0.000499 56.8700n 0.000515 56.8800n 0.000530 56.8900n 0.000545 56.9000n 0.000559 56.9100n 0.000573 56.9200n 0.000587 56.9300n 0.000600 56.9400n 0.000613 56.9500n 0.000625 56.9600n 0.000637 56.9700n 0.000648 56.9800n 0.000659 56.9900n 0.000670
+ 57.0000n 0.000680 57.0100n 0.000690 57.0200n 0.000699 57.0300n 0.000707 57.0400n 0.000715 57.0500n 0.000723 57.0600n 0.000730 57.0700n 0.000737 57.0800n 0.000742 57.0900n 0.000748 57.1000n 0.000753 57.1100n 0.000757 57.1200n 0.000761 57.1300n 0.000764 57.1400n 0.000766
+ 57.1500n 0.000768 57.1600n 0.000769 57.1700n 0.000770 57.1800n 0.000770 57.1900n 0.000770 57.2000n 0.000769 57.2100n 0.000767 57.2200n 0.000764 57.2300n 0.000761 57.2400n 0.000758 57.2500n 0.000754 57.2600n 0.000749 57.2700n 0.000743 57.2800n 0.000737 57.2900n 0.000730
+ 57.3000n 0.000723 57.3100n 0.000715 57.3200n 0.000707 57.3300n 0.000697 57.3400n 0.000687 57.3500n 0.000677 57.3600n 0.000666 57.3700n 0.000654 57.3800n 0.000642 57.3900n 0.000629 57.4000n 0.000616 57.4100n 0.000601 57.4200n 0.000587 57.4300n 0.000571 57.4400n 0.000556
+ 57.4500n 0.000539 57.4600n 0.000522 57.4700n 0.000504 57.4800n 0.000486 57.4900n 0.000468 57.5000n 0.000448 57.5100n 0.000429 57.5200n 0.000408 57.5300n 0.000388 57.5400n 0.000366 57.5500n 0.000344 57.5600n 0.000322 57.5700n 0.000299 57.5800n 0.000276 57.5900n 0.000252
+ 57.6000n 0.000228 57.6100n 0.000203 57.6200n 0.000178 57.6300n 0.000153 57.6400n 0.000127 57.6500n 0.000101 57.6600n 0.000074 57.6700n 0.000047 57.6800n 0.000020 57.6900n -0.000008 57.7000n -0.000036 57.7100n -0.000064 57.7200n -0.000093 57.7300n -0.000122 57.7400n -0.000151
+ 57.7500n -0.000181 57.7600n -0.000211 57.7700n -0.000241 57.7800n -0.000271 57.7900n -0.000301 57.8000n -0.000332 57.8100n -0.000363 57.8200n -0.000394 57.8300n -0.000425 57.8400n -0.000456 57.8500n -0.000488 57.8600n -0.000519 57.8700n -0.000551 57.8800n -0.000582 57.8900n -0.000614
+ 57.9000n -0.000646 57.9100n -0.000678 57.9200n -0.000710 57.9300n -0.000742 57.9400n -0.000773 57.9500n -0.000805 57.9600n -0.000837 57.9700n -0.000869 57.9800n -0.000901 57.9900n -0.000932 58.0000n -0.000964 58.0100n -0.000995 58.0200n -0.001026 58.0300n -0.001057 58.0400n -0.001088
+ 58.0500n -0.001119 58.0600n -0.001150 58.0700n -0.001180 58.0800n -0.001210 58.0900n -0.001240 58.1000n -0.001270 58.1100n -0.001300 58.1200n -0.001329 58.1300n -0.001358 58.1400n -0.001386 58.1500n -0.001415 58.1600n -0.001443 58.1700n -0.001471 58.1800n -0.001498 58.1900n -0.001525
+ 58.2000n -0.001552 58.2100n -0.001578 58.2200n -0.001604 58.2300n -0.001629 58.2400n -0.001655 58.2500n -0.001679 58.2600n -0.001704 58.2700n -0.001727 58.2800n -0.001751 58.2900n -0.001774 58.3000n -0.001796 58.3100n -0.001818 58.3200n -0.001840 58.3300n -0.001861 58.3400n -0.001882
+ 58.3500n -0.001902 58.3600n -0.001921 58.3700n -0.001940 58.3800n -0.001959 58.3900n -0.001977 58.4000n -0.001994 58.4100n -0.002011 58.4200n -0.002028 58.4300n -0.002044 58.4400n -0.002059 58.4500n -0.002074 58.4600n -0.002088 58.4700n -0.002102 58.4800n -0.002115 58.4900n -0.002127
+ 58.5000n -0.002139 58.5100n -0.002150 58.5200n -0.002161 58.5300n -0.002171 58.5400n -0.002181 58.5500n -0.002190 58.5600n -0.002198 58.5700n -0.002206 58.5800n -0.002214 58.5900n -0.002220 58.6000n -0.002226 58.6100n -0.002232 58.6200n -0.002237 58.6300n -0.002241 58.6400n -0.002245
+ 58.6500n -0.002248 58.6600n -0.002251 58.6700n -0.002253 58.6800n -0.002255 58.6900n -0.002256 58.7000n -0.002256 58.7100n -0.002256 58.7200n -0.002255 58.7300n -0.002254 58.7400n -0.002252 58.7500n -0.002250 58.7600n -0.002247 58.7700n -0.002244 58.7800n -0.002240 58.7900n -0.002235
+ 58.8000n -0.002230 58.8100n -0.002225 58.8200n -0.002219 58.8300n -0.002213 58.8400n -0.002206 58.8500n -0.002198 58.8600n -0.002191 58.8700n -0.002182 58.8800n -0.002174 58.8900n -0.002164 58.9000n -0.002155 58.9100n -0.002145 58.9200n -0.002134 58.9300n -0.002123 58.9400n -0.002112
+ 58.9500n -0.002100 58.9600n -0.002088 58.9700n -0.002076 58.9800n -0.002063 58.9900n -0.002050 59.0000n -0.002036 59.0100n -0.002023 59.0200n -0.002008 59.0300n -0.001994 59.0400n -0.001979 59.0500n -0.001964 59.0600n -0.001949 59.0700n -0.001933 59.0800n -0.001917 59.0900n -0.001901
+ 59.1000n -0.001884 59.1100n -0.001868 59.1200n -0.001851 59.1300n -0.001833 59.1400n -0.001816 59.1500n -0.001799 59.1600n -0.001781 59.1700n -0.001763 59.1800n -0.001745 59.1900n -0.001726 59.2000n -0.001708 59.2100n -0.001689 59.2200n -0.001671 59.2300n -0.001652 59.2400n -0.001633
+ 59.2500n -0.001614 59.2600n -0.001595 59.2700n -0.001576 59.2800n -0.001556 59.2900n -0.001537 59.3000n -0.001518 59.3100n -0.001498 59.3200n -0.001479 59.3300n -0.001459 59.3400n -0.001440 59.3500n -0.001420 59.3600n -0.001401 59.3700n -0.001381 59.3800n -0.001362 59.3900n -0.001342
+ 59.4000n -0.001323 59.4100n -0.001303 59.4200n -0.001284 59.4300n -0.001264 59.4400n -0.001245 59.4500n -0.001226 59.4600n -0.001207 59.4700n -0.001188 59.4800n -0.001169 59.4900n -0.001150 59.5000n -0.001131 59.5100n -0.001113 59.5200n -0.001094 59.5300n -0.001076 59.5400n -0.001057
+ 59.5500n -0.001039 59.5600n -0.001021 59.5700n -0.001003 59.5800n -0.000985 59.5900n -0.000968 59.6000n -0.000950 59.6100n -0.000933 59.6200n -0.000916 59.6300n -0.000899 59.6400n -0.000882 59.6500n -0.000866 59.6600n -0.000849 59.6700n -0.000833 59.6800n -0.000817 59.6900n -0.000801
+ 59.7000n -0.000785 59.7100n -0.000770 59.7200n -0.000755 59.7300n -0.000739 59.7400n -0.000725 59.7500n -0.000710 59.7600n -0.000695 59.7700n -0.000681 59.7800n -0.000667 59.7900n -0.000653 59.8000n -0.000639 59.8100n -0.000626 59.8200n -0.000613 59.8300n -0.000600 59.8400n -0.000587
+ 59.8500n -0.000574 59.8600n -0.000562 59.8700n -0.000549 59.8800n -0.000537 59.8900n -0.000526 59.9000n -0.000514 59.9100n -0.000503 59.9200n -0.000491 59.9300n -0.000480 59.9400n -0.000470 59.9500n -0.000459 59.9600n -0.000449 59.9700n -0.000439 59.9800n -0.000429 59.9900n -0.000419
+ 60.0000n -0.000409 60.0100n -0.000400 60.0200n -0.000391 60.0300n -0.000382 60.0400n -0.000373 60.0500n -0.000364 60.0600n -0.000355 60.0700n -0.000347 60.0800n -0.000339 60.0900n -0.000331 60.1000n -0.000323 60.1100n -0.000316 60.1200n -0.000308 60.1300n -0.000301 60.1400n -0.000294
+ 60.1500n -0.000287 60.1600n -0.000280 60.1700n -0.000273 60.1800n -0.000267 60.1900n -0.000260 60.2000n -0.000254 60.2100n -0.000248 60.2200n -0.000242 60.2300n -0.000236 60.2400n -0.000230 60.2500n -0.000224 60.2600n -0.000219 60.2700n -0.000213 60.2800n -0.000208 60.2900n -0.000203
+ 60.3000n -0.000198 60.3100n -0.000193 60.3200n -0.000188 60.3300n -0.000183 60.3400n -0.000179 60.3500n -0.000174 60.3600n -0.000169 60.3700n -0.000165 60.3800n -0.000161 60.3900n -0.000156 60.4000n -0.000152 60.4100n -0.000148 60.4200n -0.000144 60.4300n -0.000140 60.4400n -0.000136
+ 60.4500n -0.000132 60.4600n -0.000128 60.4700n -0.000125 60.4800n -0.000121 60.4900n -0.000117 60.5000n -0.000114 60.5100n -0.000110 60.5200n -0.000106 60.5300n -0.000103 60.5400n -0.000099 60.5500n -0.000096 60.5600n -0.000093 60.5700n -0.000089 60.5800n -0.000086 60.5900n -0.000083
+ 60.6000n -0.000079 60.6100n -0.000076 60.6200n -0.000073 60.6300n -0.000069 60.6400n -0.000066 60.6500n -0.000063 60.6600n -0.000060 60.6700n -0.000057 60.6800n -0.000053 60.6900n -0.000050 60.7000n -0.000047 60.7100n -0.000044 60.7200n -0.000041 60.7300n -0.000038 60.7400n -0.000035
+ 60.7500n -0.000032 60.7600n -0.000028 60.7700n -0.000025 60.7800n -0.000022 60.7900n -0.000019 60.8000n -0.000016 60.8100n -0.000013 60.8200n -0.000010 60.8300n -0.000007 60.8400n -0.000003 60.8500n -0.000000 60.8600n 0.000003 60.8700n 0.000006 60.8800n 0.000009 60.8900n 0.000012
+ 60.9000n 0.000015 60.9100n 0.000018 60.9200n 0.000022 60.9300n 0.000025 60.9400n 0.000028 60.9500n 0.000031 60.9600n 0.000034 60.9700n 0.000037 60.9800n 0.000041 60.9900n 0.000044 61.0000n 0.000047 61.0100n 0.000050 61.0200n 0.000053 61.0300n 0.000056 61.0400n 0.000060
+ 61.0500n 0.000063 61.0600n 0.000066 61.0700n 0.000069 61.0800n 0.000072 61.0900n 0.000075 61.1000n 0.000079 61.1100n 0.000082 61.1200n 0.000085 61.1300n 0.000088 61.1400n 0.000091 61.1500n 0.000094 61.1600n 0.000097 61.1700n 0.000101 61.1800n 0.000104 61.1900n 0.000107
+ 61.2000n 0.000110 61.2100n 0.000113 61.2200n 0.000116 61.2300n 0.000119 61.2400n 0.000122 61.2500n 0.000126 61.2600n 0.000129 61.2700n 0.000132 61.2800n 0.000135 61.2900n 0.000138 61.3000n 0.000141 61.3100n 0.000144 61.3200n 0.000147 61.3300n 0.000150 61.3400n 0.000153
+ 61.3500n 0.000156 61.3600n 0.000159 61.3700n 0.000162 61.3800n 0.000165 61.3900n 0.000168 61.4000n 0.000171 61.4100n 0.000174 61.4200n 0.000177 61.4300n 0.000180 61.4400n 0.000183 61.4500n 0.000186 61.4600n 0.000189 61.4700n 0.000192 61.4800n 0.000195 61.4900n 0.000198
+ 61.5000n 0.000201 61.5100n 0.000204 61.5200n 0.000207 61.5300n 0.000210 61.5400n 0.000213 61.5500n 0.000217 61.5600n 0.000220 61.5700n 0.000223 61.5800n 0.000226 61.5900n 0.000229 61.6000n 0.000232 61.6100n 0.000235 61.6200n 0.000238 61.6300n 0.000241 61.6400n 0.000244
+ 61.6500n 0.000247 61.6600n 0.000251 61.6700n 0.000254 61.6800n 0.000257 61.6900n 0.000260 61.7000n 0.000263 61.7100n 0.000267 61.7200n 0.000270 61.7300n 0.000273 61.7400n 0.000277 61.7500n 0.000280 61.7600n 0.000284 61.7700n 0.000287 61.7800n 0.000291 61.7900n 0.000294
+ 61.8000n 0.000298 61.8100n 0.000301 61.8200n 0.000305 61.8300n 0.000309 61.8400n 0.000313 61.8500n 0.000316 61.8600n 0.000320 61.8700n 0.000324 61.8800n 0.000328 61.8900n 0.000332 61.9000n 0.000336 61.9100n 0.000340 61.9200n 0.000344 61.9300n 0.000349 61.9400n 0.000353
+ 61.9500n 0.000357 61.9600n 0.000362 61.9700n 0.000366 61.9800n 0.000371 61.9900n 0.000375 62.0000n 0.000380 62.0100n 0.000385 62.0200n 0.000390 62.0300n 0.000395 62.0400n 0.000400 62.0500n 0.000405 62.0600n 0.000410 62.0700n 0.000415 62.0800n 0.000420 62.0900n 0.000426
+ 62.1000n 0.000431 62.1100n 0.000436 62.1200n 0.000442 62.1300n 0.000448 62.1400n 0.000453 62.1500n 0.000459 62.1600n 0.000465 62.1700n 0.000471 62.1800n 0.000477 62.1900n 0.000483 62.2000n 0.000489 62.2100n 0.000495 62.2200n 0.000502 62.2300n 0.000508 62.2400n 0.000514
+ 62.2500n 0.000521 62.2600n 0.000528 62.2700n 0.000534 62.2800n 0.000541 62.2900n 0.000548 62.3000n 0.000555 62.3100n 0.000562 62.3200n 0.000569 62.3300n 0.000576 62.3400n 0.000583 62.3500n 0.000590 62.3600n 0.000597 62.3700n 0.000604 62.3800n 0.000612 62.3900n 0.000619
+ 62.4000n 0.000627 62.4100n 0.000634 62.4200n 0.000642 62.4300n 0.000649 62.4400n 0.000657 62.4500n 0.000665 62.4600n 0.000672 62.4700n 0.000680 62.4800n 0.000688 62.4900n 0.000696 62.5000n 0.000703 62.5100n 0.000711 62.5200n 0.000719 62.5300n 0.000727 62.5400n 0.000735
+ 62.5500n 0.000743 62.5600n 0.000750 62.5700n 0.000758 62.5800n 0.000766 62.5900n 0.000774 62.6000n 0.000782 62.6100n 0.000790 62.6200n 0.000798 62.6300n 0.000805 62.6400n 0.000813 62.6500n 0.000821 62.6600n 0.000829 62.6700n 0.000836 62.6800n 0.000844 62.6900n 0.000852
+ 62.7000n 0.000859 62.7100n 0.000867 62.7200n 0.000874 62.7300n 0.000881 62.7400n 0.000889 62.7500n 0.000896 62.7600n 0.000903 62.7700n 0.000910 62.7800n 0.000917 62.7900n 0.000924 62.8000n 0.000931 62.8100n 0.000937 62.8200n 0.000944 62.8300n 0.000950 62.8400n 0.000957
+ 62.8500n 0.000963 62.8600n 0.000969 62.8700n 0.000975 62.8800n 0.000981 62.8900n 0.000987 62.9000n 0.000992 62.9100n 0.000998 62.9200n 0.001003 62.9300n 0.001008 62.9400n 0.001013 62.9500n 0.001018 62.9600n 0.001023 62.9700n 0.001027 62.9800n 0.001032 62.9900n 0.001036
+ 63.0000n 0.001040 63.0100n 0.001043 63.0200n 0.001047 63.0300n 0.001050 63.0400n 0.001054 63.0500n 0.001057 63.0600n 0.001059 63.0700n 0.001062 63.0800n 0.001064 63.0900n 0.001067 63.1000n 0.001069 63.1100n 0.001070 63.1200n 0.001072 63.1300n 0.001073 63.1400n 0.001074
+ 63.1500n 0.001075 63.1600n 0.001076 63.1700n 0.001076 63.1800n 0.001076 63.1900n 0.001076 63.2000n 0.001076 63.2100n 0.001075 63.2200n 0.001074 63.2300n 0.001073 63.2400n 0.001072 63.2500n 0.001070 63.2600n 0.001069 63.2700n 0.001067 63.2800n 0.001064 63.2900n 0.001062
+ 63.3000n 0.001059 63.3100n 0.001056 63.3200n 0.001053 63.3300n 0.001049 63.3400n 0.001045 63.3500n 0.001041 63.3600n 0.001037 63.3700n 0.001032 63.3800n 0.001027 63.3900n 0.001022 63.4000n 0.001017 63.4100n 0.001011 63.4200n 0.001006 63.4300n 0.001000 63.4400n 0.000993
+ 63.4500n 0.000987 63.4600n 0.000980 63.4700n 0.000973 63.4800n 0.000966 63.4900n 0.000958 63.5000n 0.000950 63.5100n 0.000942 63.5200n 0.000934 63.5300n 0.000926 63.5400n 0.000917 63.5500n 0.000908 63.5600n 0.000899 63.5700n 0.000890 63.5800n 0.000880 63.5900n 0.000871
+ 63.6000n 0.000861 63.6100n 0.000851 63.6200n 0.000840 63.6300n 0.000830 63.6400n 0.000819 63.6500n 0.000808 63.6600n 0.000797 63.6700n 0.000786 63.6800n 0.000775 63.6900n 0.000763 63.7000n 0.000751 63.7100n 0.000740 63.7200n 0.000728 63.7300n 0.000715 63.7400n 0.000703
+ 63.7500n 0.000691 63.7600n 0.000678 63.7700n 0.000666 63.7800n 0.000653 63.7900n 0.000640 63.8000n 0.000627 63.8100n 0.000614 63.8200n 0.000601 63.8300n 0.000587 63.8400n 0.000574 63.8500n 0.000560 63.8600n 0.000547 63.8700n 0.000533 63.8800n 0.000520 63.8900n 0.000506
+ 63.9000n 0.000492 63.9100n 0.000479 63.9200n 0.000465 63.9300n 0.000451 63.9400n 0.000437 63.9500n 0.000423 63.9600n 0.000409 63.9700n 0.000396 63.9800n 0.000382 63.9900n 0.000368 64.0000n 0.000354 64.0100n 0.000340 64.0200n 0.000326 64.0300n 0.000313 64.0400n 0.000299
+ 64.0500n 0.000285 64.0600n 0.000272 64.0700n 0.000258 64.0800n 0.000245 64.0900n 0.000232 64.1000n 0.000218 64.1100n 0.000205 64.1200n 0.000192 64.1300n 0.000179 64.1400n 0.000166 64.1500n 0.000153 64.1600n 0.000141 64.1700n 0.000128 64.1800n 0.000116 64.1900n 0.000103
+ 64.2000n 0.000091 64.2100n 0.000079 64.2200n 0.000067 64.2300n 0.000056 64.2400n 0.000044 64.2500n 0.000033 64.2600n 0.000022 64.2700n 0.000011 64.2800n -0.000000 64.2900n -0.000011 64.3000n -0.000021 64.3100n -0.000032 64.3200n -0.000042 64.3300n -0.000051 64.3400n -0.000061
+ 64.3500n -0.000070 64.3600n -0.000080 64.3700n -0.000089 64.3800n -0.000097 64.3900n -0.000106 64.4000n -0.000114 64.4100n -0.000122 64.4200n -0.000130 64.4300n -0.000138 64.4400n -0.000145 64.4500n -0.000152 64.4600n -0.000159 64.4700n -0.000166 64.4800n -0.000172 64.4900n -0.000178
+ 64.5000n -0.000184 64.5100n -0.000190 64.5200n -0.000195 64.5300n -0.000200 64.5400n -0.000205 64.5500n -0.000209 64.5600n -0.000214 64.5700n -0.000218 64.5800n -0.000221 64.5900n -0.000225 64.6000n -0.000228 64.6100n -0.000231 64.6200n -0.000234 64.6300n -0.000236 64.6400n -0.000238
+ 64.6500n -0.000240 64.6600n -0.000242 64.6700n -0.000243 64.6800n -0.000244 64.6900n -0.000245 64.7000n -0.000245 64.7100n -0.000245 64.7200n -0.000245 64.7300n -0.000245 64.7400n -0.000245 64.7500n -0.000244 64.7600n -0.000243 64.7700n -0.000241 64.7800n -0.000240 64.7900n -0.000238
+ 64.8000n -0.000236 64.8100n -0.000234 64.8200n -0.000231 64.8300n -0.000228 64.8400n -0.000225 64.8500n -0.000222 64.8600n -0.000218 64.8700n -0.000214 64.8800n -0.000210 64.8900n -0.000206 64.9000n -0.000202 64.9100n -0.000197 64.9200n -0.000192 64.9300n -0.000187 64.9400n -0.000182
+ 64.9500n -0.000176 64.9600n -0.000170 64.9700n -0.000165 64.9800n -0.000158 64.9900n -0.000152 65.0000n -0.000146 65.0100n -0.000139 65.0200n -0.000132 65.0300n -0.000125 65.0400n -0.000118 65.0500n -0.000110 65.0600n -0.000103 65.0700n -0.000095 65.0800n -0.000087 65.0900n -0.000080
+ 65.1000n -0.000071 65.1100n -0.000063 65.1200n -0.000055 65.1300n -0.000046 65.1400n -0.000038 65.1500n -0.000029 65.1600n -0.000020 65.1700n -0.000011 65.1800n -0.000002 65.1900n 0.000007 65.2000n 0.000016 65.2100n 0.000026 65.2200n 0.000035 65.2300n 0.000044 65.2400n 0.000054
+ 65.2500n 0.000064 65.2600n 0.000073 65.2700n 0.000083 65.2800n 0.000093 65.2900n 0.000102 65.3000n 0.000112 65.3100n 0.000122 65.3200n 0.000132 65.3300n 0.000142 65.3400n 0.000152 65.3500n 0.000162 65.3600n 0.000172 65.3700n 0.000182 65.3800n 0.000192 65.3900n 0.000201
+ 65.4000n 0.000211 65.4100n 0.000221 65.4200n 0.000231 65.4300n 0.000241 65.4400n 0.000251 65.4500n 0.000260 65.4600n 0.000270 65.4700n 0.000280 65.4800n 0.000289 65.4900n 0.000299 65.5000n 0.000308 65.5100n 0.000318 65.5200n 0.000327 65.5300n 0.000336 65.5400n 0.000345
+ 65.5500n 0.000354 65.5600n 0.000363 65.5700n 0.000372 65.5800n 0.000381 65.5900n 0.000390 65.6000n 0.000398 65.6100n 0.000407 65.6200n 0.000415 65.6300n 0.000423 65.6400n 0.000431 65.6500n 0.000439 65.6600n 0.000447 65.6700n 0.000455 65.6800n 0.000462 65.6900n 0.000469
+ 65.7000n 0.000477 65.7100n 0.000484 65.7200n 0.000491 65.7300n 0.000497 65.7400n 0.000504 65.7500n 0.000510 65.7600n 0.000517 65.7700n 0.000523 65.7800n 0.000529 65.7900n 0.000534 65.8000n 0.000540 65.8100n 0.000545 65.8200n 0.000550 65.8300n 0.000555 65.8400n 0.000560
+ 65.8500n 0.000565 65.8600n 0.000569 65.8700n 0.000573 65.8800n 0.000577 65.8900n 0.000581 65.9000n 0.000584 65.9100n 0.000588 65.9200n 0.000591 65.9300n 0.000594 65.9400n 0.000596 65.9500n 0.000599 65.9600n 0.000601 65.9700n 0.000603 65.9800n 0.000605 65.9900n 0.000607
+ 66.0000n 0.000608 66.0100n 0.000609 66.0200n 0.000610 66.0300n 0.000611 66.0400n 0.000611 66.0500n 0.000612 66.0600n 0.000612 66.0700n 0.000611 66.0800n 0.000611 66.0900n 0.000610 66.1000n 0.000609 66.1100n 0.000608 66.1200n 0.000607 66.1300n 0.000605 66.1400n 0.000604
+ 66.1500n 0.000602 66.1600n 0.000599 66.1700n 0.000597 66.1800n 0.000594 66.1900n 0.000591 66.2000n 0.000588 66.2100n 0.000585 66.2200n 0.000581 66.2300n 0.000577 66.2400n 0.000573 66.2500n 0.000569 66.2600n 0.000564 66.2700n 0.000559 66.2800n 0.000554 66.2900n 0.000549
+ 66.3000n 0.000544 66.3100n 0.000538 66.3200n 0.000532 66.3300n 0.000526 66.3400n 0.000520 66.3500n 0.000514 66.3600n 0.000507 66.3700n 0.000500 66.3800n 0.000493 66.3900n 0.000486 66.4000n 0.000478 66.4100n 0.000470 66.4200n 0.000462 66.4300n 0.000454 66.4400n 0.000446
+ 66.4500n 0.000438 66.4600n 0.000429 66.4700n 0.000420 66.4800n 0.000411 66.4900n 0.000402 66.5000n 0.000393 66.5100n 0.000383 66.5200n 0.000373 66.5300n 0.000364 66.5400n 0.000354 66.5500n 0.000343 66.5600n 0.000333 66.5700n 0.000323 66.5800n 0.000312 66.5900n 0.000301
+ 66.6000n 0.000290 66.6100n 0.000279 66.6200n 0.000268 66.6300n 0.000257 66.6400n 0.000245 66.6500n 0.000234 66.6600n 0.000222 66.6700n 0.000210 66.6800n 0.000198 66.6900n 0.000187 66.7000n 0.000174 66.7100n 0.000162 66.7200n 0.000150 66.7300n 0.000138 66.7400n 0.000125
+ 66.7500n 0.000113 66.7600n 0.000100 66.7700n 0.000087 66.7800n 0.000075 66.7900n 0.000062 66.8000n 0.000049 66.8100n 0.000036 66.8200n 0.000023 66.8300n 0.000010 66.8400n -0.000003 66.8500n -0.000016 66.8600n -0.000029 66.8700n -0.000042 66.8800n -0.000055 66.8900n -0.000068
+ 66.9000n -0.000081 66.9100n -0.000094 66.9200n -0.000107 66.9300n -0.000120 66.9400n -0.000133 66.9500n -0.000146 66.9600n -0.000159 66.9700n -0.000172 66.9800n -0.000185 66.9900n -0.000198 67.0000n -0.000211 67.0100n -0.000224 67.0200n -0.000237 67.0300n -0.000249 67.0400n -0.000262
+ 67.0500n -0.000275 67.0600n -0.000287 67.0700n -0.000300 67.0800n -0.000312 67.0900n -0.000324 67.1000n -0.000336 67.1100n -0.000348 67.1200n -0.000360 67.1300n -0.000372 67.1400n -0.000384 67.1500n -0.000395 67.1600n -0.000407 67.1700n -0.000418 67.1800n -0.000430 67.1900n -0.000441
+ 67.2000n -0.000452 67.2100n -0.000462 67.2200n -0.000473 67.2300n -0.000484 67.2400n -0.000494 67.2500n -0.000504 67.2600n -0.000514 67.2700n -0.000524 67.2800n -0.000534 67.2900n -0.000544 67.3000n -0.000553 67.3100n -0.000562 67.3200n -0.000571 67.3300n -0.000580 67.3400n -0.000589
+ 67.3500n -0.000597 67.3600n -0.000605 67.3700n -0.000613 67.3800n -0.000621 67.3900n -0.000629 67.4000n -0.000636 67.4100n -0.000644 67.4200n -0.000651 67.4300n -0.000658 67.4400n -0.000664 67.4500n -0.000671 67.4600n -0.000677 67.4700n -0.000683 67.4800n -0.000689 67.4900n -0.000694
+ 67.5000n -0.000700 67.5100n -0.000705 67.5200n -0.000710 67.5300n -0.000714 67.5400n -0.000719 67.5500n -0.000723 67.5600n -0.000727 67.5700n -0.000731 67.5800n -0.000735 67.5900n -0.000738 67.6000n -0.000741 67.6100n -0.000744 67.6200n -0.000747 67.6300n -0.000750 67.6400n -0.000752
+ 67.6500n -0.000754 67.6600n -0.000756 67.6700n -0.000758 67.6800n -0.000759 67.6900n -0.000761 67.7000n -0.000762 67.7100n -0.000763 67.7200n -0.000763 67.7300n -0.000764 67.7400n -0.000764 67.7500n -0.000764 67.7600n -0.000764 67.7700n -0.000764 67.7800n -0.000764 67.7900n -0.000763
+ 67.8000n -0.000763 67.8100n -0.000762 67.8200n -0.000761 67.8300n -0.000760 67.8400n -0.000759 67.8500n -0.000757 67.8600n -0.000756 67.8700n -0.000754 67.8800n -0.000752 67.8900n -0.000750 67.9000n -0.000748 67.9100n -0.000746 67.9200n -0.000744 67.9300n -0.000741 67.9400n -0.000739
+ 67.9500n -0.000736 67.9600n -0.000734 67.9700n -0.000731 67.9800n -0.000728 67.9900n -0.000726 68.0000n -0.000723 68.0100n -0.000720 68.0200n -0.000717 68.0300n -0.000714 68.0400n -0.000711 68.0500n -0.000708 68.0600n -0.000705 68.0700n -0.000702 68.0800n -0.000699 68.0900n -0.000696
+ 68.1000n -0.000694 68.1100n -0.000691 68.1200n -0.000688 68.1300n -0.000685 68.1400n -0.000682 68.1500n -0.000680 68.1600n -0.000677 68.1700n -0.000675 68.1800n -0.000672 68.1900n -0.000670 68.2000n -0.000668 68.2100n -0.000666 68.2200n -0.000664 68.2300n -0.000662 68.2400n -0.000660
+ 68.2500n -0.000659 68.2600n -0.000658 68.2700n -0.000656 68.2800n -0.000655 68.2900n -0.000654 68.3000n -0.000654 68.3100n -0.000653 68.3200n -0.000653 68.3300n -0.000653 68.3400n -0.000653 68.3500n -0.000654 68.3600n -0.000654 68.3700n -0.000655 68.3800n -0.000656 68.3900n -0.000658
+ 68.4000n -0.000659 68.4100n -0.000661 68.4200n -0.000663 68.4300n -0.000666 68.4400n -0.000669 68.4500n -0.000672 68.4600n -0.000675 68.4700n -0.000679 68.4800n -0.000683 68.4900n -0.000687 68.5000n -0.000692 68.5100n -0.000697 68.5200n -0.000702 68.5300n -0.000707 68.5400n -0.000713
+ 68.5500n -0.000720 68.5600n -0.000726 68.5700n -0.000733 68.5800n -0.000741 68.5900n -0.000748 68.6000n -0.000757 68.6100n -0.000765 68.6200n -0.000774 68.6300n -0.000783 68.6400n -0.000793 68.6500n -0.000803 68.6600n -0.000813 68.6700n -0.000824 68.6800n -0.000835 68.6900n -0.000846
+ 68.7000n -0.000858 68.7100n -0.000871 68.7200n -0.000883 68.7300n -0.000896 68.7400n -0.000910 68.7500n -0.000924 68.7600n -0.000938 68.7700n -0.000952 68.7800n -0.000967 68.7900n -0.000983 68.8000n -0.000998 68.8100n -0.001014 68.8200n -0.001031 68.8300n -0.001048 68.8400n -0.001065
+ 68.8500n -0.001082 68.8600n -0.001100 68.8700n -0.001118 68.8800n -0.001137 68.8900n -0.001156 68.9000n -0.001175 68.9100n -0.001195 68.9200n -0.001215 68.9300n -0.001235 68.9400n -0.001255 68.9500n -0.001276 68.9600n -0.001297 68.9700n -0.001319 68.9800n -0.001341 68.9900n -0.001363
+ 69.0000n -0.001385 69.0100n -0.001407 69.0200n -0.001430 69.0300n -0.001453 69.0400n -0.001476 69.0500n -0.001500 69.0600n -0.001523 69.0700n -0.001547 69.0800n -0.001571 69.0900n -0.001595 69.1000n -0.001620 69.1100n -0.001644 69.1200n -0.001669 69.1300n -0.001694 69.1400n -0.001719
+ 69.1500n -0.001744 69.1600n -0.001769 69.1700n -0.001794 69.1800n -0.001820 69.1900n -0.001845 69.2000n -0.001870 69.2100n -0.001896 69.2200n -0.001921 69.2300n -0.001947 69.2400n -0.001972 69.2500n -0.001998 69.2600n -0.002023 69.2700n -0.002048 69.2800n -0.002074 69.2900n -0.002099
+ 69.3000n -0.002124 69.3100n -0.002149 69.3200n -0.002174 69.3300n -0.002199 69.3400n -0.002224 69.3500n -0.002248 69.3600n -0.002272 69.3700n -0.002296 69.3800n -0.002320 69.3900n -0.002344 69.4000n -0.002368 69.4100n -0.002391 69.4200n -0.002414 69.4300n -0.002436 69.4400n -0.002459
+ 69.4500n -0.002481 69.4600n -0.002503 69.4700n -0.002524 69.4800n -0.002545 69.4900n -0.002566 69.5000n -0.002586 69.5100n -0.002606 69.5200n -0.002626 69.5300n -0.002645 69.5400n -0.002664 69.5500n -0.002682 69.5600n -0.002700 69.5700n -0.002717 69.5800n -0.002734 69.5900n -0.002750
+ 69.6000n -0.002766 69.6100n -0.002782 69.6200n -0.002796 69.6300n -0.002811 69.6400n -0.002824 69.6500n -0.002837 69.6600n -0.002850 69.6700n -0.002862 69.6800n -0.002873 69.6900n -0.002884 69.7000n -0.002894 69.7100n -0.002904 69.7200n -0.002913 69.7300n -0.002921 69.7400n -0.002929
+ 69.7500n -0.002935 69.7600n -0.002942 69.7700n -0.002947 69.7800n -0.002952 69.7900n -0.002956 69.8000n -0.002960 69.8100n -0.002963 69.8200n -0.002965 69.8300n -0.002966 69.8400n -0.002967 69.8500n -0.002967 69.8600n -0.002966 69.8700n -0.002964 69.8800n -0.002962 69.8900n -0.002959
+ 69.9000n -0.002955 69.9100n -0.002951 69.9200n -0.002946 69.9300n -0.002939 69.9400n -0.002933 69.9500n -0.002925 69.9600n -0.002917 69.9700n -0.002908 69.9800n -0.002898 69.9900n -0.002888 70.0000n -0.002876 70.0100n -0.002864 70.0200n -0.002852 70.0300n -0.002838 70.0400n -0.002824
+ 70.0500n -0.002809 70.0600n -0.002793 70.0700n -0.002777 70.0800n -0.002760 70.0900n -0.002742 70.1000n -0.002723 70.1100n -0.002704 70.1200n -0.002684 70.1300n -0.002663 70.1400n -0.002642 70.1500n -0.002620 70.1600n -0.002597 70.1700n -0.002574 70.1800n -0.002550 70.1900n -0.002525
+ 70.2000n -0.002500 70.2100n -0.002474 70.2200n -0.002447 70.2300n -0.002420 70.2400n -0.002392 70.2500n -0.002364 70.2600n -0.002335 70.2700n -0.002306 70.2800n -0.002276 70.2900n -0.002245 70.3000n -0.002214 70.3100n -0.002182 70.3200n -0.002150 70.3300n -0.002118 70.3400n -0.002085
+ 70.3500n -0.002051 70.3600n -0.002018 70.3700n -0.001983 70.3800n -0.001949 70.3900n -0.001913 70.4000n -0.001878 70.4100n -0.001842 70.4200n -0.001806 70.4300n -0.001769 70.4400n -0.001733 70.4500n -0.001695 70.4600n -0.001658 70.4700n -0.001620 70.4800n -0.001582 70.4900n -0.001544
+ 70.5000n -0.001506 70.5100n -0.001467 70.5200n -0.001428 70.5300n -0.001390 70.5400n -0.001351 70.5500n -0.001311 70.5600n -0.001272 70.5700n -0.001233 70.5800n -0.001193 70.5900n -0.001154 70.6000n -0.001114 70.6100n -0.001074 70.6200n -0.001035 70.6300n -0.000995 70.6400n -0.000956
+ 70.6500n -0.000916 70.6600n -0.000877 70.6700n -0.000837 70.6800n -0.000798 70.6900n -0.000759 70.7000n -0.000720 70.7100n -0.000681 70.7200n -0.000642 70.7300n -0.000604 70.7400n -0.000565 70.7500n -0.000527 70.7600n -0.000489 70.7700n -0.000452 70.7800n -0.000414 70.7900n -0.000377
+ 70.8000n -0.000340 70.8100n -0.000304 70.8200n -0.000267 70.8300n -0.000231 70.8400n -0.000196 70.8500n -0.000161 70.8600n -0.000126 70.8700n -0.000091 70.8800n -0.000057 70.8900n -0.000024 70.9000n 0.000010 70.9100n 0.000042 70.9200n 0.000075 70.9300n 0.000107 70.9400n 0.000138
+ 70.9500n 0.000169 70.9600n 0.000199 70.9700n 0.000229 70.9800n 0.000259 70.9900n 0.000288 71.0000n 0.000316 71.0100n 0.000344 71.0200n 0.000372 71.0300n 0.000398 71.0400n 0.000425 71.0500n 0.000450 71.0600n 0.000475 71.0700n 0.000500 71.0800n 0.000524 71.0900n 0.000547
+ 71.1000n 0.000570 71.1100n 0.000592 71.1200n 0.000614 71.1300n 0.000635 71.1400n 0.000655 71.1500n 0.000675 71.1600n 0.000694 71.1700n 0.000712 71.1800n 0.000730 71.1900n 0.000748 71.2000n 0.000764 71.2100n 0.000780 71.2200n 0.000796 71.2300n 0.000811 71.2400n 0.000825
+ 71.2500n 0.000838 71.2600n 0.000851 71.2700n 0.000864 71.2800n 0.000876 71.2900n 0.000887 71.3000n 0.000897 71.3100n 0.000907 71.3200n 0.000916 71.3300n 0.000925 71.3400n 0.000933 71.3500n 0.000941 71.3600n 0.000948 71.3700n 0.000954 71.3800n 0.000960 71.3900n 0.000965
+ 71.4000n 0.000970 71.4100n 0.000974 71.4200n 0.000978 71.4300n 0.000981 71.4400n 0.000983 71.4500n 0.000985 71.4600n 0.000987 71.4700n 0.000988 71.4800n 0.000989 71.4900n 0.000989 71.5000n 0.000988 71.5100n 0.000987 71.5200n 0.000986 71.5300n 0.000984 71.5400n 0.000982
+ 71.5500n 0.000979 71.5600n 0.000976 71.5700n 0.000972 71.5800n 0.000968 71.5900n 0.000964 71.6000n 0.000960 71.6100n 0.000954 71.6200n 0.000949 71.6300n 0.000943 71.6400n 0.000937 71.6500n 0.000931 71.6600n 0.000924 71.6700n 0.000917 71.6800n 0.000910 71.6900n 0.000902
+ 71.7000n 0.000894 71.7100n 0.000886 71.7200n 0.000878 71.7300n 0.000870 71.7400n 0.000861 71.7500n 0.000852 71.7600n 0.000843 71.7700n 0.000833 71.7800n 0.000824 71.7900n 0.000814 71.8000n 0.000805 71.8100n 0.000795 71.8200n 0.000785 71.8300n 0.000774 71.8400n 0.000764
+ 71.8500n 0.000754 71.8600n 0.000743 71.8700n 0.000733 71.8800n 0.000722 71.8900n 0.000712 71.9000n 0.000701 71.9100n 0.000691 71.9200n 0.000680 71.9300n 0.000669 71.9400n 0.000659 71.9500n 0.000648 71.9600n 0.000638 71.9700n 0.000627 71.9800n 0.000617 71.9900n 0.000606
+ 72.0000n 0.000596 72.0100n 0.000585 72.0200n 0.000575 72.0300n 0.000565 72.0400n 0.000555 72.0500n 0.000545 72.0600n 0.000535 72.0700n 0.000526 72.0800n 0.000516 72.0900n 0.000507 72.1000n 0.000497 72.1100n 0.000488 72.1200n 0.000479 72.1300n 0.000471 72.1400n 0.000462
+ 72.1500n 0.000453 72.1600n 0.000445 72.1700n 0.000437 72.1800n 0.000429 72.1900n 0.000421 72.2000n 0.000414 72.2100n 0.000406 72.2200n 0.000399 72.2300n 0.000392 72.2400n 0.000385 72.2500n 0.000379 72.2600n 0.000373 72.2700n 0.000366 72.2800n 0.000361 72.2900n 0.000355
+ 72.3000n 0.000349 72.3100n 0.000344 72.3200n 0.000339 72.3300n 0.000334 72.3400n 0.000330 72.3500n 0.000325 72.3600n 0.000321 72.3700n 0.000317 72.3800n 0.000313 72.3900n 0.000310 72.4000n 0.000307 72.4100n 0.000304 72.4200n 0.000301 72.4300n 0.000298 72.4400n 0.000296
+ 72.4500n 0.000294 72.4600n 0.000291 72.4700n 0.000290 72.4800n 0.000288 72.4900n 0.000287 72.5000n 0.000285 72.5100n 0.000284 72.5200n 0.000284 72.5300n 0.000283 72.5400n 0.000283 72.5500n 0.000282 72.5600n 0.000282 72.5700n 0.000282 72.5800n 0.000282 72.5900n 0.000283
+ 72.6000n 0.000283 72.6100n 0.000284 72.6200n 0.000285 72.6300n 0.000286 72.6400n 0.000287 72.6500n 0.000288 72.6600n 0.000290 72.6700n 0.000291 72.6800n 0.000293 72.6900n 0.000295 72.7000n 0.000297 72.7100n 0.000299 72.7200n 0.000301 72.7300n 0.000303 72.7400n 0.000305
+ 72.7500n 0.000308 72.7600n 0.000310 72.7700n 0.000313 72.7800n 0.000315 72.7900n 0.000318 72.8000n 0.000321 72.8100n 0.000324 72.8200n 0.000326 72.8300n 0.000329 72.8400n 0.000332 72.8500n 0.000335 72.8600n 0.000338 72.8700n 0.000341 72.8800n 0.000345 72.8900n 0.000348
+ 72.9000n 0.000351 72.9100n 0.000354 72.9200n 0.000357 72.9300n 0.000361 72.9400n 0.000364 72.9500n 0.000367 72.9600n 0.000370 72.9700n 0.000373 72.9800n 0.000377 72.9900n 0.000380 73.0000n 0.000383 73.0100n 0.000386 73.0200n 0.000390 73.0300n 0.000393 73.0400n 0.000396
+ 73.0500n 0.000399 73.0600n 0.000402 73.0700n 0.000405 73.0800n 0.000409 73.0900n 0.000412 73.1000n 0.000415 73.1100n 0.000418 73.1200n 0.000421 73.1300n 0.000424 73.1400n 0.000427 73.1500n 0.000430 73.1600n 0.000433 73.1700n 0.000436 73.1800n 0.000439 73.1900n 0.000441
+ 73.2000n 0.000444 73.2100n 0.000447 73.2200n 0.000450 73.2300n 0.000453 73.2400n 0.000456 73.2500n 0.000459 73.2600n 0.000461 73.2700n 0.000464 73.2800n 0.000467 73.2900n 0.000470 73.3000n 0.000472 73.3100n 0.000475 73.3200n 0.000478 73.3300n 0.000481 73.3400n 0.000484
+ 73.3500n 0.000487 73.3600n 0.000489 73.3700n 0.000492 73.3800n 0.000495 73.3900n 0.000498 73.4000n 0.000501 73.4100n 0.000504 73.4200n 0.000507 73.4300n 0.000510 73.4400n 0.000514 73.4500n 0.000517 73.4600n 0.000520 73.4700n 0.000524 73.4800n 0.000527 73.4900n 0.000531
+ 73.5000n 0.000534 73.5100n 0.000538 73.5200n 0.000542 73.5300n 0.000545 73.5400n 0.000549 73.5500n 0.000553 73.5600n 0.000558 73.5700n 0.000562 73.5800n 0.000566 73.5900n 0.000571 73.6000n 0.000575 73.6100n 0.000580 73.6200n 0.000585 73.6300n 0.000590 73.6400n 0.000595
+ 73.6500n 0.000601 73.6600n 0.000606 73.6700n 0.000612 73.6800n 0.000617 73.6900n 0.000623 73.7000n 0.000629 73.7100n 0.000636 73.7200n 0.000642 73.7300n 0.000649 73.7400n 0.000655 73.7500n 0.000662 73.7600n 0.000670 73.7700n 0.000677 73.7800n 0.000684 73.7900n 0.000692
+ 73.8000n 0.000700 73.8100n 0.000708 73.8200n 0.000716 73.8300n 0.000725 73.8400n 0.000733 73.8500n 0.000742 73.8600n 0.000751 73.8700n 0.000760 73.8800n 0.000770 73.8900n 0.000780 73.9000n 0.000789 73.9100n 0.000799 73.9200n 0.000810 73.9300n 0.000820 73.9400n 0.000830
+ 73.9500n 0.000841 73.9600n 0.000852 73.9700n 0.000863 73.9800n 0.000875 73.9900n 0.000886 74.0000n 0.000898 74.0100n 0.000910 74.0200n 0.000922 74.0300n 0.000934 74.0400n 0.000946 74.0500n 0.000959 74.0600n 0.000971 74.0700n 0.000984 74.0800n 0.000997 74.0900n 0.001010
+ 74.1000n 0.001023 74.1100n 0.001036 74.1200n 0.001050 74.1300n 0.001063 74.1400n 0.001077 74.1500n 0.001090 74.1600n 0.001104 74.1700n 0.001118 74.1800n 0.001132 74.1900n 0.001146 74.2000n 0.001160 74.2100n 0.001174 74.2200n 0.001188 74.2300n 0.001202 74.2400n 0.001216
+ 74.2500n 0.001231 74.2600n 0.001245 74.2700n 0.001259 74.2800n 0.001273 74.2900n 0.001287 74.3000n 0.001301 74.3100n 0.001315 74.3200n 0.001329 74.3300n 0.001343 74.3400n 0.001356 74.3500n 0.001370 74.3600n 0.001383 74.3700n 0.001397 74.3800n 0.001410 74.3900n 0.001423
+ 74.4000n 0.001436 74.4100n 0.001449 74.4200n 0.001461 74.4300n 0.001474 74.4400n 0.001486 74.4500n 0.001498 74.4600n 0.001509 74.4700n 0.001521 74.4800n 0.001532 74.4900n 0.001543 74.5000n 0.001553 74.5100n 0.001564 74.5200n 0.001574 74.5300n 0.001583 74.5400n 0.001593
+ 74.5500n 0.001602 74.5600n 0.001610 74.5700n 0.001619 74.5800n 0.001626 74.5900n 0.001634 74.6000n 0.001641 74.6100n 0.001647 74.6200n 0.001654 74.6300n 0.001659 74.6400n 0.001665 74.6500n 0.001669 74.6600n 0.001674 74.6700n 0.001678 74.6800n 0.001681 74.6900n 0.001684
+ 74.7000n 0.001686 74.7100n 0.001688 74.7200n 0.001689 74.7300n 0.001690 74.7400n 0.001690 74.7500n 0.001690 74.7600n 0.001689 74.7700n 0.001687 74.7800n 0.001685 74.7900n 0.001682 74.8000n 0.001679 74.8100n 0.001675 74.8200n 0.001670 74.8300n 0.001665 74.8400n 0.001660
+ 74.8500n 0.001653 74.8600n 0.001646 74.8700n 0.001638 74.8800n 0.001630 74.8900n 0.001621 74.9000n 0.001611 74.9100n 0.001601 74.9200n 0.001590 74.9300n 0.001579 74.9400n 0.001566 74.9500n 0.001553 74.9600n 0.001540 74.9700n 0.001526 74.9800n 0.001511 74.9900n 0.001495
+ 75.0000n 0.001479 75.0100n 0.001462 75.0200n 0.001445 75.0300n 0.001427 75.0400n 0.001408 75.0500n 0.001389 75.0600n 0.001369 75.0700n 0.001348 75.0800n 0.001327 75.0900n 0.001305 75.1000n 0.001283 75.1100n 0.001260 75.1200n 0.001236 75.1300n 0.001212 75.1400n 0.001187
+ 75.1500n 0.001162 75.1600n 0.001136 75.1700n 0.001110 75.1800n 0.001083 75.1900n 0.001055 75.2000n 0.001027 75.2100n 0.000999 75.2200n 0.000970 75.2300n 0.000941 75.2400n 0.000911 75.2500n 0.000880 75.2600n 0.000850 75.2700n 0.000819 75.2800n 0.000787 75.2900n 0.000755
+ 75.3000n 0.000723 75.3100n 0.000690 75.3200n 0.000657 75.3300n 0.000624 75.3400n 0.000590 75.3500n 0.000556 75.3600n 0.000522 75.3700n 0.000488 75.3800n 0.000453 75.3900n 0.000418 75.4000n 0.000383 75.4100n 0.000348 75.4200n 0.000313 75.4300n 0.000277 75.4400n 0.000241
+ 75.4500n 0.000206 75.4600n 0.000170 75.4700n 0.000134 75.4800n 0.000098 75.4900n 0.000062 75.5000n 0.000027 75.5100n -0.000009 75.5200n -0.000045 75.5300n -0.000081 75.5400n -0.000116 75.5500n -0.000152 75.5600n -0.000187 75.5700n -0.000222 75.5800n -0.000257 75.5900n -0.000292
+ 75.6000n -0.000326 75.6100n -0.000361 75.6200n -0.000395 75.6300n -0.000428 75.6400n -0.000462 75.6500n -0.000495 75.6600n -0.000528 75.6700n -0.000560 75.6800n -0.000592 75.6900n -0.000623 75.7000n -0.000655 75.7100n -0.000685 75.7200n -0.000715 75.7300n -0.000745 75.7400n -0.000774
+ 75.7500n -0.000803 75.7600n -0.000831 75.7700n -0.000858 75.7800n -0.000885 75.7900n -0.000912 75.8000n -0.000937 75.8100n -0.000962 75.8200n -0.000987 75.8300n -0.001010 75.8400n -0.001033 75.8500n -0.001056 75.8600n -0.001077 75.8700n -0.001098 75.8800n -0.001118 75.8900n -0.001137
+ 75.9000n -0.001156 75.9100n -0.001174 75.9200n -0.001191 75.9300n -0.001207 75.9400n -0.001222 75.9500n -0.001237 75.9600n -0.001251 75.9700n -0.001263 75.9800n -0.001275 75.9900n -0.001286 76.0000n -0.001297 76.0100n -0.001306 76.0200n -0.001315 76.0300n -0.001322 76.0400n -0.001329
+ 76.0500n -0.001335 76.0600n -0.001340 76.0700n -0.001344 76.0800n -0.001347 76.0900n -0.001349 76.1000n -0.001350 76.1100n -0.001350 76.1200n -0.001350 76.1300n -0.001349 76.1400n -0.001346 76.1500n -0.001343 76.1600n -0.001339 76.1700n -0.001334 76.1800n -0.001328 76.1900n -0.001321
+ 76.2000n -0.001313 76.2100n -0.001305 76.2200n -0.001295 76.2300n -0.001285 76.2400n -0.001274 76.2500n -0.001262 76.2600n -0.001249 76.2700n -0.001236 76.2800n -0.001221 76.2900n -0.001206 76.3000n -0.001190 76.3100n -0.001173 76.3200n -0.001156 76.3300n -0.001137 76.3400n -0.001118
+ 76.3500n -0.001099 76.3600n -0.001078 76.3700n -0.001057 76.3800n -0.001036 76.3900n -0.001013 76.4000n -0.000990 76.4100n -0.000967 76.4200n -0.000943 76.4300n -0.000918 76.4400n -0.000893 76.4500n -0.000867 76.4600n -0.000841 76.4700n -0.000814 76.4800n -0.000787 76.4900n -0.000759
+ 76.5000n -0.000731 76.5100n -0.000702 76.5200n -0.000674 76.5300n -0.000644 76.5400n -0.000615 76.5500n -0.000585 76.5600n -0.000555 76.5700n -0.000525 76.5800n -0.000494 76.5900n -0.000464 76.6000n -0.000433 76.6100n -0.000402 76.6200n -0.000371 76.6300n -0.000339 76.6400n -0.000308
+ 76.6500n -0.000277 76.6600n -0.000246 76.6700n -0.000214 76.6800n -0.000183 76.6900n -0.000152 76.7000n -0.000121 76.7100n -0.000090 76.7200n -0.000059 76.7300n -0.000028 76.7400n 0.000002 76.7500n 0.000032 76.7600n 0.000062 76.7700n 0.000092 76.7800n 0.000121 76.7900n 0.000150
+ 76.8000n 0.000179 76.8100n 0.000207 76.8200n 0.000235 76.8300n 0.000263 76.8400n 0.000290 76.8500n 0.000316 76.8600n 0.000342 76.8700n 0.000368 76.8800n 0.000393 76.8900n 0.000417 76.9000n 0.000441 76.9100n 0.000464 76.9200n 0.000487 76.9300n 0.000509 76.9400n 0.000530
+ 76.9500n 0.000550 76.9600n 0.000570 76.9700n 0.000589 76.9800n 0.000608 76.9900n 0.000625 77.0000n 0.000642 77.0100n 0.000658 77.0200n 0.000673 77.0300n 0.000688 77.0400n 0.000701 77.0500n 0.000714 77.0600n 0.000725 77.0700n 0.000736 77.0800n 0.000746 77.0900n 0.000755
+ 77.1000n 0.000764 77.1100n 0.000771 77.1200n 0.000777 77.1300n 0.000782 77.1400n 0.000787 77.1500n 0.000790 77.1600n 0.000793 77.1700n 0.000794 77.1800n 0.000795 77.1900n 0.000794 77.2000n 0.000793 77.2100n 0.000790 77.2200n 0.000787 77.2300n 0.000783 77.2400n 0.000777
+ 77.2500n 0.000771 77.2600n 0.000763 77.2700n 0.000755 77.2800n 0.000746 77.2900n 0.000735 77.3000n 0.000724 77.3100n 0.000712 77.3200n 0.000699 77.3300n 0.000685 77.3400n 0.000670 77.3500n 0.000654 77.3600n 0.000637 77.3700n 0.000619 77.3800n 0.000600 77.3900n 0.000581
+ 77.4000n 0.000560 77.4100n 0.000539 77.4200n 0.000517 77.4300n 0.000494 77.4400n 0.000470 77.4500n 0.000445 77.4600n 0.000420 77.4700n 0.000394 77.4800n 0.000367 77.4900n 0.000339 77.5000n 0.000311 77.5100n 0.000281 77.5200n 0.000252 77.5300n 0.000221 77.5400n 0.000190
+ 77.5500n 0.000159 77.5600n 0.000126 77.5700n 0.000094 77.5800n 0.000060 77.5900n 0.000026 77.6000n -0.000008 77.6100n -0.000043 77.6200n -0.000078 77.6300n -0.000114 77.6400n -0.000150 77.6500n -0.000186 77.6600n -0.000223 77.6700n -0.000260 77.6800n -0.000297 77.6900n -0.000335
+ 77.7000n -0.000373 77.7100n -0.000411 77.7200n -0.000449 77.7300n -0.000487 77.7400n -0.000525 77.7500n -0.000564 77.7600n -0.000603 77.7700n -0.000641 77.7800n -0.000680 77.7900n -0.000718 77.8000n -0.000757 77.8100n -0.000795 77.8200n -0.000833 77.8300n -0.000872 77.8400n -0.000909
+ 77.8500n -0.000947 77.8600n -0.000985 77.8700n -0.001022 77.8800n -0.001059 77.8900n -0.001096 77.9000n -0.001132 77.9100n -0.001168 77.9200n -0.001203 77.9300n -0.001238 77.9400n -0.001273 77.9500n -0.001307 77.9600n -0.001341 77.9700n -0.001374 77.9800n -0.001406 77.9900n -0.001438
+ 78.0000n -0.001469 78.0100n -0.001500 78.0200n -0.001530 78.0300n -0.001560 78.0400n -0.001588 78.0500n -0.001616 78.0600n -0.001643 78.0700n -0.001670 78.0800n -0.001695 78.0900n -0.001720 78.1000n -0.001744 78.1100n -0.001767 78.1200n -0.001789 78.1300n -0.001811 78.1400n -0.001831
+ 78.1500n -0.001851 78.1600n -0.001869 78.1700n -0.001887 78.1800n -0.001903 78.1900n -0.001919 78.2000n -0.001934 78.2100n -0.001948 78.2200n -0.001960 78.2300n -0.001972 78.2400n -0.001982 78.2500n -0.001992 78.2600n -0.002001 78.2700n -0.002008 78.2800n -0.002015 78.2900n -0.002020
+ 78.3000n -0.002024 78.3100n -0.002027 78.3200n -0.002029 78.3300n -0.002030 78.3400n -0.002030 78.3500n -0.002029 78.3600n -0.002027 78.3700n -0.002024 78.3800n -0.002019 78.3900n -0.002014 78.4000n -0.002007 78.4100n -0.002000 78.4200n -0.001991 78.4300n -0.001981 78.4400n -0.001970
+ 78.4500n -0.001958 78.4600n -0.001946 78.4700n -0.001932 78.4800n -0.001917 78.4900n -0.001901 78.5000n -0.001884 78.5100n -0.001866 78.5200n -0.001847 78.5300n -0.001827 78.5400n -0.001806 78.5500n -0.001784 78.5600n -0.001762 78.5700n -0.001738 78.5800n -0.001713 78.5900n -0.001688
+ 78.6000n -0.001662 78.6100n -0.001635 78.6200n -0.001607 78.6300n -0.001578 78.6400n -0.001549 78.6500n -0.001519 78.6600n -0.001488 78.6700n -0.001456 78.6800n -0.001424 78.6900n -0.001391 78.7000n -0.001358 78.7100n -0.001324 78.7200n -0.001289 78.7300n -0.001254 78.7400n -0.001218
+ 78.7500n -0.001181 78.7600n -0.001145 78.7700n -0.001107 78.7800n -0.001070 78.7900n -0.001031 78.8000n -0.000993 78.8100n -0.000954 78.8200n -0.000915 78.8300n -0.000876 78.8400n -0.000836 78.8500n -0.000796 78.8600n -0.000756 78.8700n -0.000716 78.8800n -0.000675 78.8900n -0.000635
+ 78.9000n -0.000594 78.9100n -0.000553 78.9200n -0.000512 78.9300n -0.000472 78.9400n -0.000431 78.9500n -0.000390 78.9600n -0.000350 78.9700n -0.000309 78.9800n -0.000269 78.9900n -0.000229 79.0000n -0.000189 79.0100n -0.000149 79.0200n -0.000110 79.0300n -0.000071 79.0400n -0.000032
+ 79.0500n 0.000007 79.0600n 0.000045 79.0700n 0.000083 79.0800n 0.000120 79.0900n 0.000157 79.1000n 0.000194 79.1100n 0.000230 79.1200n 0.000265 79.1300n 0.000300 79.1400n 0.000334 79.1500n 0.000368 79.1600n 0.000401 79.1700n 0.000434 79.1800n 0.000466 79.1900n 0.000497
+ 79.2000n 0.000527 79.2100n 0.000557 79.2200n 0.000586 79.2300n 0.000615 79.2400n 0.000642 79.2500n 0.000669 79.2600n 0.000695 79.2700n 0.000720 79.2800n 0.000745 79.2900n 0.000768 79.3000n 0.000791 79.3100n 0.000812 79.3200n 0.000833 79.3300n 0.000853 79.3400n 0.000872
+ 79.3500n 0.000891 79.3600n 0.000908 79.3700n 0.000924 79.3800n 0.000939 79.3900n 0.000954 79.4000n 0.000967 79.4100n 0.000980 79.4200n 0.000991 79.4300n 0.001002 79.4400n 0.001011 79.4500n 0.001020 79.4600n 0.001027 79.4700n 0.001034 79.4800n 0.001040 79.4900n 0.001044
+ 79.5000n 0.001048 79.5100n 0.001051 79.5200n 0.001052 79.5300n 0.001053 79.5400n 0.001053 79.5500n 0.001051 79.5600n 0.001049 79.5700n 0.001046 79.5800n 0.001042 79.5900n 0.001037 79.6000n 0.001031 79.6100n 0.001024 79.6200n 0.001017 79.6300n 0.001008 79.6400n 0.000998
+ 79.6500n 0.000988 79.6600n 0.000977 79.6700n 0.000964 79.6800n 0.000951 79.6900n 0.000938 79.7000n 0.000923 79.7100n 0.000908 79.7200n 0.000891 79.7300n 0.000874 79.7400n 0.000857 79.7500n 0.000838 79.7600n 0.000819 79.7700n 0.000799 79.7800n 0.000779 79.7900n 0.000758
+ 79.8000n 0.000736 79.8100n 0.000714 79.8200n 0.000691 79.8300n 0.000667 79.8400n 0.000643 79.8500n 0.000619 79.8600n 0.000594 79.8700n 0.000568 79.8800n 0.000542 79.8900n 0.000516 79.9000n 0.000489 79.9100n 0.000461 79.9200n 0.000434 79.9300n 0.000406 79.9400n 0.000378
+ 79.9500n 0.000349 79.9600n 0.000320 79.9700n 0.000291 79.9800n 0.000262 79.9900n 0.000233 80.0000n 0.000203 80.0100n 0.000173 80.0200n 0.000143 80.0300n 0.000113 80.0400n 0.000083 80.0500n 0.000053 80.0600n 0.000023 80.0700n -0.000007 80.0800n -0.000037 80.0900n -0.000067
+ 80.1000n -0.000097 80.1100n -0.000127 80.1200n -0.000157 80.1300n -0.000187 80.1400n -0.000216 80.1500n -0.000245 80.1600n -0.000274 80.1700n -0.000303 80.1800n -0.000332 80.1900n -0.000360 80.2000n -0.000388 80.2100n -0.000416 80.2200n -0.000443 80.2300n -0.000470 80.2400n -0.000496
+ 80.2500n -0.000523 80.2600n -0.000548 80.2700n -0.000574 80.2800n -0.000599 80.2900n -0.000623 80.3000n -0.000647 80.3100n -0.000671 80.3200n -0.000694 80.3300n -0.000716 80.3400n -0.000738 80.3500n -0.000759 80.3600n -0.000780 80.3700n -0.000800 80.3800n -0.000820 80.3900n -0.000839
+ 80.4000n -0.000857 80.4100n -0.000875 80.4200n -0.000892 80.4300n -0.000908 80.4400n -0.000924 80.4500n -0.000939 80.4600n -0.000954 80.4700n -0.000968 80.4800n -0.000981 80.4900n -0.000993 80.5000n -0.001005 80.5100n -0.001016 80.5200n -0.001026 80.5300n -0.001036 80.5400n -0.001045
+ 80.5500n -0.001053 80.5600n -0.001061 80.5700n -0.001068 80.5800n -0.001074 80.5900n -0.001079 80.6000n -0.001084 80.6100n -0.001088 80.6200n -0.001091 80.6300n -0.001094 80.6400n -0.001096 80.6500n -0.001097 80.6600n -0.001098 80.6700n -0.001098 80.6800n -0.001097 80.6900n -0.001096
+ 80.7000n -0.001094 80.7100n -0.001091 80.7200n -0.001088 80.7300n -0.001084 80.7400n -0.001080 80.7500n -0.001074 80.7600n -0.001069 80.7700n -0.001063 80.7800n -0.001056 80.7900n -0.001048 80.8000n -0.001040 80.8100n -0.001032 80.8200n -0.001023 80.8300n -0.001014 80.8400n -0.001004
+ 80.8500n -0.000993 80.8600n -0.000983 80.8700n -0.000971 80.8800n -0.000960 80.8900n -0.000948 80.9000n -0.000935 80.9100n -0.000922 80.9200n -0.000909 80.9300n -0.000895 80.9400n -0.000882 80.9500n -0.000867 80.9600n -0.000853 80.9700n -0.000838 80.9800n -0.000823 80.9900n -0.000808
+ 81.0000n -0.000793 81.0100n -0.000777 81.0200n -0.000762 81.0300n -0.000746 81.0400n -0.000730 81.0500n -0.000713 81.0600n -0.000697 81.0700n -0.000681 81.0800n -0.000664 81.0900n -0.000648 81.1000n -0.000632 81.1100n -0.000615 81.1200n -0.000599 81.1300n -0.000582 81.1400n -0.000566
+ 81.1500n -0.000550 81.1600n -0.000533 81.1700n -0.000517 81.1800n -0.000501 81.1900n -0.000486 81.2000n -0.000470 81.2100n -0.000454 81.2200n -0.000439 81.2300n -0.000424 81.2400n -0.000409 81.2500n -0.000394 81.2600n -0.000380 81.2700n -0.000366 81.2800n -0.000352 81.2900n -0.000338
+ 81.3000n -0.000325 81.3100n -0.000312 81.3200n -0.000300 81.3300n -0.000287 81.3400n -0.000275 81.3500n -0.000264 81.3600n -0.000253 81.3700n -0.000242 81.3800n -0.000232 81.3900n -0.000222 81.4000n -0.000212 81.4100n -0.000203 81.4200n -0.000194 81.4300n -0.000186 81.4400n -0.000179
+ 81.4500n -0.000171 81.4600n -0.000164 81.4700n -0.000158 81.4800n -0.000152 81.4900n -0.000147 81.5000n -0.000142 81.5100n -0.000138 81.5200n -0.000134 81.5300n -0.000130 81.5400n -0.000127 81.5500n -0.000125 81.5600n -0.000123 81.5700n -0.000121 81.5800n -0.000121 81.5900n -0.000120
+ 81.6000n -0.000120 81.6100n -0.000121 81.6200n -0.000122 81.6300n -0.000123 81.6400n -0.000125 81.6500n -0.000128 81.6600n -0.000131 81.6700n -0.000134 81.6800n -0.000138 81.6900n -0.000143 81.7000n -0.000147 81.7100n -0.000153 81.7200n -0.000158 81.7300n -0.000164 81.7400n -0.000171
+ 81.7500n -0.000178 81.7600n -0.000185 81.7700n -0.000193 81.7800n -0.000201 81.7900n -0.000210 81.8000n -0.000219 81.8100n -0.000228 81.8200n -0.000237 81.8300n -0.000247 81.8400n -0.000257 81.8500n -0.000268 81.8600n -0.000279 81.8700n -0.000290 81.8800n -0.000301 81.8900n -0.000313
+ 81.9000n -0.000324 81.9100n -0.000336 81.9200n -0.000348 81.9300n -0.000361 81.9400n -0.000373 81.9500n -0.000386 81.9600n -0.000399 81.9700n -0.000412 81.9800n -0.000425 81.9900n -0.000438 82.0000n -0.000451 82.0100n -0.000464 82.0200n -0.000477 82.0300n -0.000491 82.0400n -0.000504
+ 82.0500n -0.000517 82.0600n -0.000531 82.0700n -0.000544 82.0800n -0.000557 82.0900n -0.000570 82.1000n -0.000583 82.1100n -0.000596 82.1200n -0.000608 82.1300n -0.000621 82.1400n -0.000633 82.1500n -0.000646 82.1600n -0.000658 82.1700n -0.000669 82.1800n -0.000681 82.1900n -0.000692
+ 82.2000n -0.000703 82.2100n -0.000714 82.2200n -0.000725 82.2300n -0.000735 82.2400n -0.000745 82.2500n -0.000754 82.2600n -0.000763 82.2700n -0.000772 82.2800n -0.000781 82.2900n -0.000789 82.3000n -0.000797 82.3100n -0.000804 82.3200n -0.000811 82.3300n -0.000817 82.3400n -0.000823
+ 82.3500n -0.000829 82.3600n -0.000834 82.3700n -0.000838 82.3800n -0.000842 82.3900n -0.000846 82.4000n -0.000849 82.4100n -0.000852 82.4200n -0.000854 82.4300n -0.000855 82.4400n -0.000856 82.4500n -0.000857 82.4600n -0.000857 82.4700n -0.000856 82.4800n -0.000855 82.4900n -0.000854
+ 82.5000n -0.000851 82.5100n -0.000849 82.5200n -0.000845 82.5300n -0.000841 82.5400n -0.000837 82.5500n -0.000832 82.5600n -0.000826 82.5700n -0.000820 82.5800n -0.000813 82.5900n -0.000806 82.6000n -0.000798 82.6100n -0.000790 82.6200n -0.000781 82.6300n -0.000771 82.6400n -0.000761
+ 82.6500n -0.000751 82.6600n -0.000740 82.6700n -0.000728 82.6800n -0.000716 82.6900n -0.000703 82.7000n -0.000690 82.7100n -0.000676 82.7200n -0.000662 82.7300n -0.000647 82.7400n -0.000632 82.7500n -0.000617 82.7600n -0.000601 82.7700n -0.000584 82.7800n -0.000567 82.7900n -0.000550
+ 82.8000n -0.000532 82.8100n -0.000514 82.8200n -0.000495 82.8300n -0.000476 82.8400n -0.000457 82.8500n -0.000437 82.8600n -0.000417 82.8700n -0.000397 82.8800n -0.000376 82.8900n -0.000355 82.9000n -0.000334 82.9100n -0.000313 82.9200n -0.000291 82.9300n -0.000269 82.9400n -0.000247
+ 82.9500n -0.000225 82.9600n -0.000202 82.9700n -0.000179 82.9800n -0.000156 82.9900n -0.000134 83.0000n -0.000110 83.0100n -0.000087 83.0200n -0.000064 83.0300n -0.000041 83.0400n -0.000017 83.0500n 0.000006 83.0600n 0.000029 83.0700n 0.000053 83.0800n 0.000076 83.0900n 0.000099
+ 83.1000n 0.000122 83.1100n 0.000146 83.1200n 0.000169 83.1300n 0.000192 83.1400n 0.000214 83.1500n 0.000237 83.1600n 0.000259 83.1700n 0.000282 83.1800n 0.000304 83.1900n 0.000326 83.2000n 0.000347 83.2100n 0.000369 83.2200n 0.000390 83.2300n 0.000411 83.2400n 0.000431
+ 83.2500n 0.000451 83.2600n 0.000471 83.2700n 0.000491 83.2800n 0.000510 83.2900n 0.000529 83.3000n 0.000547 83.3100n 0.000565 83.3200n 0.000583 83.3300n 0.000600 83.3400n 0.000617 83.3500n 0.000633 83.3600n 0.000649 83.3700n 0.000664 83.3800n 0.000679 83.3900n 0.000693
+ 83.4000n 0.000707 83.4100n 0.000721 83.4200n 0.000734 83.4300n 0.000746 83.4400n 0.000758 83.4500n 0.000769 83.4600n 0.000780 83.4700n 0.000790 83.4800n 0.000799 83.4900n 0.000808 83.5000n 0.000817 83.5100n 0.000825 83.5200n 0.000832 83.5300n 0.000839 83.5400n 0.000845
+ 83.5500n 0.000850 83.5600n 0.000855 83.5700n 0.000860 83.5800n 0.000864 83.5900n 0.000867 83.6000n 0.000869 83.6100n 0.000871 83.6200n 0.000873 83.6300n 0.000874 83.6400n 0.000874 83.6500n 0.000874 83.6600n 0.000873 83.6700n 0.000872 83.6800n 0.000870 83.6900n 0.000867
+ 83.7000n 0.000864 83.7100n 0.000860 83.7200n 0.000856 83.7300n 0.000852 83.7400n 0.000847 83.7500n 0.000841 83.7600n 0.000835 83.7700n 0.000828 83.7800n 0.000821 83.7900n 0.000813 83.8000n 0.000805 83.8100n 0.000797 83.8200n 0.000788 83.8300n 0.000779 83.8400n 0.000769
+ 83.8500n 0.000759 83.8600n 0.000749 83.8700n 0.000738 83.8800n 0.000727 83.8900n 0.000715 83.9000n 0.000703 83.9100n 0.000691 83.9200n 0.000679 83.9300n 0.000666 83.9400n 0.000654 83.9500n 0.000641 83.9600n 0.000627 83.9700n 0.000614 83.9800n 0.000600 83.9900n 0.000586
+ 84.0000n 0.000572 84.0100n 0.000558 84.0200n 0.000544 84.0300n 0.000530 84.0400n 0.000516 84.0500n 0.000501 84.0600n 0.000487 84.0700n 0.000473 84.0800n 0.000458 84.0900n 0.000444 84.1000n 0.000430 84.1100n 0.000416 84.1200n 0.000402 84.1300n 0.000388 84.1400n 0.000374
+ 84.1500n 0.000360 84.1600n 0.000347 84.1700n 0.000334 84.1800n 0.000321 84.1900n 0.000308 84.2000n 0.000295 84.2100n 0.000283 84.2200n 0.000271 84.2300n 0.000259 84.2400n 0.000248 84.2500n 0.000237 84.2600n 0.000226 84.2700n 0.000216 84.2800n 0.000206 84.2900n 0.000197
+ 84.3000n 0.000188 84.3100n 0.000179 84.3200n 0.000171 84.3300n 0.000163 84.3400n 0.000156 84.3500n 0.000150 84.3600n 0.000144 84.3700n 0.000138 84.3800n 0.000133 84.3900n 0.000129 84.4000n 0.000125 84.4100n 0.000122 84.4200n 0.000119 84.4300n 0.000117 84.4400n 0.000116
+ 84.4500n 0.000115 84.4600n 0.000115 84.4700n 0.000116 84.4800n 0.000117 84.4900n 0.000119 84.5000n 0.000122 84.5100n 0.000125 84.5200n 0.000129 84.5300n 0.000134 84.5400n 0.000139 84.5500n 0.000145 84.5600n 0.000152 84.5700n 0.000160 84.5800n 0.000168 84.5900n 0.000177
+ 84.6000n 0.000187 84.6100n 0.000198 84.6200n 0.000209 84.6300n 0.000221 84.6400n 0.000234 84.6500n 0.000247 84.6600n 0.000262 84.6700n 0.000277 84.6800n 0.000292 84.6900n 0.000309 84.7000n 0.000326 84.7100n 0.000344 84.7200n 0.000362 84.7300n 0.000382 84.7400n 0.000402
+ 84.7500n 0.000423 84.7600n 0.000444 84.7700n 0.000466 84.7800n 0.000489 84.7900n 0.000512 84.8000n 0.000536 84.8100n 0.000561 84.8200n 0.000586 84.8300n 0.000612 84.8400n 0.000639 84.8500n 0.000666 84.8600n 0.000694 84.8700n 0.000722 84.8800n 0.000751 84.8900n 0.000780
+ 84.9000n 0.000810 84.9100n 0.000841 84.9200n 0.000872 84.9300n 0.000903 84.9400n 0.000935 84.9500n 0.000967 84.9600n 0.001000 84.9700n 0.001033 84.9800n 0.001066 84.9900n 0.001100 85.0000n 0.001134 85.0100n 0.001169 85.0200n 0.001203 85.0300n 0.001238 85.0400n 0.001274
+ 85.0500n 0.001309 85.0600n 0.001345 85.0700n 0.001381 85.0800n 0.001417 85.0900n 0.001454 85.1000n 0.001490 85.1100n 0.001527 85.1200n 0.001563 85.1300n 0.001600 85.1400n 0.001637 85.1500n 0.001673 85.1600n 0.001710 85.1700n 0.001747 85.1800n 0.001783 85.1900n 0.001820
+ 85.2000n 0.001856 85.2100n 0.001893 85.2200n 0.001929 85.2300n 0.001965 85.2400n 0.002000 85.2500n 0.002036 85.2600n 0.002071 85.2700n 0.002106 85.2800n 0.002141 85.2900n 0.002176 85.3000n 0.002210 85.3100n 0.002243 85.3200n 0.002277 85.3300n 0.002310 85.3400n 0.002342
+ 85.3500n 0.002374 85.3600n 0.002406 85.3700n 0.002437 85.3800n 0.002468 85.3900n 0.002498 85.4000n 0.002527 85.4100n 0.002556 85.4200n 0.002584 85.4300n 0.002612 85.4400n 0.002639 85.4500n 0.002665 85.4600n 0.002691 85.4700n 0.002716 85.4800n 0.002741 85.4900n 0.002764
+ 85.5000n 0.002787 85.5100n 0.002809 85.5200n 0.002830 85.5300n 0.002851 85.5400n 0.002871 85.5500n 0.002890 85.5600n 0.002908 85.5700n 0.002925 85.5800n 0.002941 85.5900n 0.002957 85.6000n 0.002971 85.6100n 0.002985 85.6200n 0.002998 85.6300n 0.003010 85.6400n 0.003021
+ 85.6500n 0.003031 85.6600n 0.003040 85.6700n 0.003048 85.6800n 0.003055 85.6900n 0.003061 85.7000n 0.003066 85.7100n 0.003071 85.7200n 0.003074 85.7300n 0.003076 85.7400n 0.003078 85.7500n 0.003078 85.7600n 0.003077 85.7700n 0.003075 85.7800n 0.003073 85.7900n 0.003069
+ 85.8000n 0.003064 85.8100n 0.003059 85.8200n 0.003052 85.8300n 0.003044 85.8400n 0.003036 85.8500n 0.003026 85.8600n 0.003016 85.8700n 0.003004 85.8800n 0.002991 85.8900n 0.002978 85.9000n 0.002963 85.9100n 0.002948 85.9200n 0.002932 85.9300n 0.002914 85.9400n 0.002896
+ 85.9500n 0.002877 85.9600n 0.002857 85.9700n 0.002836 85.9800n 0.002814 85.9900n 0.002791 86.0000n 0.002768 86.0100n 0.002743 86.0200n 0.002718 86.0300n 0.002692 86.0400n 0.002665 86.0500n 0.002637 86.0600n 0.002609 86.0700n 0.002580 86.0800n 0.002550 86.0900n 0.002519
+ 86.1000n 0.002487 86.1100n 0.002455 86.1200n 0.002422 86.1300n 0.002389 86.1400n 0.002355 86.1500n 0.002320 86.1600n 0.002284 86.1700n 0.002248 86.1800n 0.002212 86.1900n 0.002175 86.2000n 0.002137 86.2100n 0.002099 86.2200n 0.002060 86.2300n 0.002021 86.2400n 0.001981
+ 86.2500n 0.001941 86.2600n 0.001901 86.2700n 0.001860 86.2800n 0.001819 86.2900n 0.001777 86.3000n 0.001735 86.3100n 0.001693 86.3200n 0.001651 86.3300n 0.001608 86.3400n 0.001565 86.3500n 0.001522 86.3600n 0.001478 86.3700n 0.001435 86.3800n 0.001391 86.3900n 0.001347
+ 86.4000n 0.001303 86.4100n 0.001259 86.4200n 0.001215 86.4300n 0.001171 86.4400n 0.001127 86.4500n 0.001082 86.4600n 0.001038 86.4700n 0.000994 86.4800n 0.000950 86.4900n 0.000906 86.5000n 0.000862 86.5100n 0.000818 86.5200n 0.000775 86.5300n 0.000731 86.5400n 0.000688
+ 86.5500n 0.000645 86.5600n 0.000602 86.5700n 0.000559 86.5800n 0.000517 86.5900n 0.000475 86.6000n 0.000433 86.6100n 0.000392 86.6200n 0.000350 86.6300n 0.000310 86.6400n 0.000269 86.6500n 0.000229 86.6600n 0.000189 86.6700n 0.000150 86.6800n 0.000111 86.6900n 0.000073
+ 86.7000n 0.000035 86.7100n -0.000003 86.7200n -0.000040 86.7300n -0.000076 86.7400n -0.000112 86.7500n -0.000148 86.7600n -0.000183 86.7700n -0.000217 86.7800n -0.000251 86.7900n -0.000284 86.8000n -0.000317 86.8100n -0.000349 86.8200n -0.000381 86.8300n -0.000412 86.8400n -0.000442
+ 86.8500n -0.000472 86.8600n -0.000501 86.8700n -0.000529 86.8800n -0.000557 86.8900n -0.000584 86.9000n -0.000611 86.9100n -0.000637 86.9200n -0.000662 86.9300n -0.000687 86.9400n -0.000711 86.9500n -0.000734 86.9600n -0.000756 86.9700n -0.000778 86.9800n -0.000800 86.9900n -0.000820
+ 87.0000n -0.000840 87.0100n -0.000859 87.0200n -0.000878 87.0300n -0.000896 87.0400n -0.000913 87.0500n -0.000929 87.0600n -0.000945 87.0700n -0.000960 87.0800n -0.000975 87.0900n -0.000989 87.1000n -0.001002 87.1100n -0.001015 87.1200n -0.001027 87.1300n -0.001038 87.1400n -0.001049
+ 87.1500n -0.001059 87.1600n -0.001068 87.1700n -0.001077 87.1800n -0.001085 87.1900n -0.001092 87.2000n -0.001099 87.2100n -0.001106 87.2200n -0.001112 87.2300n -0.001117 87.2400n -0.001121 87.2500n -0.001126 87.2600n -0.001129 87.2700n -0.001132 87.2800n -0.001135 87.2900n -0.001137
+ 87.3000n -0.001138 87.3100n -0.001139 87.3200n -0.001139 87.3300n -0.001139 87.3400n -0.001139 87.3500n -0.001138 87.3600n -0.001137 87.3700n -0.001135 87.3800n -0.001133 87.3900n -0.001130 87.4000n -0.001127 87.4100n -0.001124 87.4200n -0.001120 87.4300n -0.001116 87.4400n -0.001111
+ 87.4500n -0.001106 87.4600n -0.001101 87.4700n -0.001096 87.4800n -0.001090 87.4900n -0.001084 87.5000n -0.001078 87.5100n -0.001071 87.5200n -0.001064 87.5300n -0.001057 87.5400n -0.001050 87.5500n -0.001042 87.5600n -0.001035 87.5700n -0.001027 87.5800n -0.001019 87.5900n -0.001011
+ 87.6000n -0.001002 87.6100n -0.000994 87.6200n -0.000985 87.6300n -0.000976 87.6400n -0.000967 87.6500n -0.000958 87.6600n -0.000949 87.6700n -0.000940 87.6800n -0.000931 87.6900n -0.000922 87.7000n -0.000913 87.7100n -0.000903 87.7200n -0.000894 87.7300n -0.000885 87.7400n -0.000876
+ 87.7500n -0.000866 87.7600n -0.000857 87.7700n -0.000848 87.7800n -0.000839 87.7900n -0.000830 87.8000n -0.000821 87.8100n -0.000812 87.8200n -0.000803 87.8300n -0.000794 87.8400n -0.000785 87.8500n -0.000777 87.8600n -0.000768 87.8700n -0.000760 87.8800n -0.000751 87.8900n -0.000743
+ 87.9000n -0.000735 87.9100n -0.000727 87.9200n -0.000720 87.9300n -0.000712 87.9400n -0.000705 87.9500n -0.000698 87.9600n -0.000691 87.9700n -0.000684 87.9800n -0.000677 87.9900n -0.000671 88.0000n -0.000664 88.0100n -0.000658 88.0200n -0.000653 88.0300n -0.000647 88.0400n -0.000641
+ 88.0500n -0.000636 88.0600n -0.000631 88.0700n -0.000626 88.0800n -0.000622 88.0900n -0.000617 88.1000n -0.000613 88.1100n -0.000609 88.1200n -0.000605 88.1300n -0.000602 88.1400n -0.000598 88.1500n -0.000595 88.1600n -0.000593 88.1700n -0.000590 88.1800n -0.000588 88.1900n -0.000585
+ 88.2000n -0.000583 88.2100n -0.000582 88.2200n -0.000580 88.2300n -0.000579 88.2400n -0.000578 88.2500n -0.000577 88.2600n -0.000576 88.2700n -0.000576 88.2800n -0.000576 88.2900n -0.000576 88.3000n -0.000576 88.3100n -0.000576 88.3200n -0.000577 88.3300n -0.000578 88.3400n -0.000579
+ 88.3500n -0.000580 88.3600n -0.000581 88.3700n -0.000583 88.3800n -0.000585 88.3900n -0.000587 88.4000n -0.000589 88.4100n -0.000591 88.4200n -0.000593 88.4300n -0.000596 88.4400n -0.000599 88.4500n -0.000602 88.4600n -0.000605 88.4700n -0.000608 88.4800n -0.000612 88.4900n -0.000615
+ 88.5000n -0.000619 88.5100n -0.000623 88.5200n -0.000626 88.5300n -0.000631 88.5400n -0.000635 88.5500n -0.000639 88.5600n -0.000643 88.5700n -0.000648 88.5800n -0.000653 88.5900n -0.000657 88.6000n -0.000662 88.6100n -0.000667 88.6200n -0.000672 88.6300n -0.000677 88.6400n -0.000682
+ 88.6500n -0.000688 88.6600n -0.000693 88.6700n -0.000698 88.6800n -0.000704 88.6900n -0.000709 88.7000n -0.000715 88.7100n -0.000720 88.7200n -0.000726 88.7300n -0.000732 88.7400n -0.000737 88.7500n -0.000743 88.7600n -0.000749 88.7700n -0.000755 88.7800n -0.000760 88.7900n -0.000766
+ 88.8000n -0.000772 88.8100n -0.000778 88.8200n -0.000784 88.8300n -0.000790 88.8400n -0.000796 88.8500n -0.000802 88.8600n -0.000808 88.8700n -0.000814 88.8800n -0.000820 88.8900n -0.000826 88.9000n -0.000832 88.9100n -0.000837 88.9200n -0.000843 88.9300n -0.000849 88.9400n -0.000855
+ 88.9500n -0.000861 88.9600n -0.000867 88.9700n -0.000873 88.9800n -0.000878 88.9900n -0.000884 89.0000n -0.000890 89.0100n -0.000896 89.0200n -0.000901 89.0300n -0.000907 89.0400n -0.000913 89.0500n -0.000918 89.0600n -0.000924 89.0700n -0.000929 89.0800n -0.000935 89.0900n -0.000940
+ 89.1000n -0.000946 89.1100n -0.000951 89.1200n -0.000957 89.1300n -0.000962 89.1400n -0.000967 89.1500n -0.000973 89.1600n -0.000978 89.1700n -0.000983 89.1800n -0.000988 89.1900n -0.000993 89.2000n -0.000999 89.2100n -0.001004 89.2200n -0.001009 89.2300n -0.001014 89.2400n -0.001019
+ 89.2500n -0.001024 89.2600n -0.001029 89.2700n -0.001033 89.2800n -0.001038 89.2900n -0.001043 89.3000n -0.001048 89.3100n -0.001053 89.3200n -0.001057 89.3300n -0.001062 89.3400n -0.001067 89.3500n -0.001071 89.3600n -0.001076 89.3700n -0.001080 89.3800n -0.001085 89.3900n -0.001089
+ 89.4000n -0.001094 89.4100n -0.001098 89.4200n -0.001103 89.4300n -0.001107 89.4400n -0.001112 89.4500n -0.001116 89.4600n -0.001120 89.4700n -0.001124 89.4800n -0.001129 89.4900n -0.001133 89.5000n -0.001137 89.5100n -0.001141 89.5200n -0.001146 89.5300n -0.001150 89.5400n -0.001154
+ 89.5500n -0.001158 89.5600n -0.001162 89.5700n -0.001166 89.5800n -0.001170 89.5900n -0.001174 89.6000n -0.001178 89.6100n -0.001182 89.6200n -0.001185 89.6300n -0.001189 89.6400n -0.001193 89.6500n -0.001197 89.6600n -0.001200 89.6700n -0.001204 89.6800n -0.001208 89.6900n -0.001211
+ 89.7000n -0.001215 89.7100n -0.001218 89.7200n -0.001222 89.7300n -0.001225 89.7400n -0.001229 89.7500n -0.001232 89.7600n -0.001235 89.7700n -0.001238 89.7800n -0.001241 89.7900n -0.001244 89.8000n -0.001247 89.8100n -0.001250 89.8200n -0.001253 89.8300n -0.001256 89.8400n -0.001259
+ 89.8500n -0.001261 89.8600n -0.001264 89.8700n -0.001267 89.8800n -0.001269 89.8900n -0.001271 89.9000n -0.001273 89.9100n -0.001276 89.9200n -0.001278 89.9300n -0.001280 89.9400n -0.001281 89.9500n -0.001283 89.9600n -0.001285 89.9700n -0.001286 89.9800n -0.001288 89.9900n -0.001289
+ 90.0000n -0.001290 90.0100n -0.001291 90.0200n -0.001292 90.0300n -0.001292 90.0400n -0.001293 90.0500n -0.001293 90.0600n -0.001294 90.0700n -0.001294 90.0800n -0.001294 90.0900n -0.001294 90.1000n -0.001293 90.1100n -0.001293 90.1200n -0.001292 90.1300n -0.001291 90.1400n -0.001290
+ 90.1500n -0.001289 90.1600n -0.001288 90.1700n -0.001286 90.1800n -0.001284 90.1900n -0.001283 90.2000n -0.001280 90.2100n -0.001278 90.2200n -0.001275 90.2300n -0.001273 90.2400n -0.001270 90.2500n -0.001267 90.2600n -0.001263 90.2700n -0.001260 90.2800n -0.001256 90.2900n -0.001252
+ 90.3000n -0.001247 90.3100n -0.001243 90.3200n -0.001238 90.3300n -0.001233 90.3400n -0.001228 90.3500n -0.001222 90.3600n -0.001217 90.3700n -0.001211 90.3800n -0.001204 90.3900n -0.001198 90.4000n -0.001191 90.4100n -0.001184 90.4200n -0.001177 90.4300n -0.001170 90.4400n -0.001162
+ 90.4500n -0.001154 90.4600n -0.001146 90.4700n -0.001137 90.4800n -0.001128 90.4900n -0.001119 90.5000n -0.001110 90.5100n -0.001101 90.5200n -0.001091 90.5300n -0.001081 90.5400n -0.001070 90.5500n -0.001060 90.5600n -0.001049 90.5700n -0.001038 90.5800n -0.001027 90.5900n -0.001015
+ 90.6000n -0.001003 90.6100n -0.000991 90.6200n -0.000979 90.6300n -0.000967 90.6400n -0.000954 90.6500n -0.000941 90.6600n -0.000928 90.6700n -0.000914 90.6800n -0.000900 90.6900n -0.000886 90.7000n -0.000872 90.7100n -0.000858 90.7200n -0.000843 90.7300n -0.000829 90.7400n -0.000814
+ 90.7500n -0.000798 90.7600n -0.000783 90.7700n -0.000767 90.7800n -0.000752 90.7900n -0.000736 90.8000n -0.000719 90.8100n -0.000703 90.8200n -0.000687 90.8300n -0.000670 90.8400n -0.000653 90.8500n -0.000636 90.8600n -0.000619 90.8700n -0.000602 90.8800n -0.000585 90.8900n -0.000567
+ 90.9000n -0.000549 90.9100n -0.000532 90.9200n -0.000514 90.9300n -0.000496 90.9400n -0.000478 90.9500n -0.000460 90.9600n -0.000442 90.9700n -0.000423 90.9800n -0.000405 90.9900n -0.000387 91.0000n -0.000368 91.0100n -0.000350 91.0200n -0.000331 91.0300n -0.000313 91.0400n -0.000294
+ 91.0500n -0.000276 91.0600n -0.000257 91.0700n -0.000239 91.0800n -0.000220 91.0900n -0.000202 91.1000n -0.000184 91.1100n -0.000165 91.1200n -0.000147 91.1300n -0.000129 91.1400n -0.000110 91.1500n -0.000092 91.1600n -0.000074 91.1700n -0.000056 91.1800n -0.000038 91.1900n -0.000021
+ 91.2000n -0.000003 91.2100n 0.000014 91.2200n 0.000032 91.2300n 0.000049 91.2400n 0.000066 91.2500n 0.000083 91.2600n 0.000100 91.2700n 0.000116 91.2800n 0.000133 91.2900n 0.000149 91.3000n 0.000165 91.3100n 0.000181 91.3200n 0.000196 91.3300n 0.000212 91.3400n 0.000227
+ 91.3500n 0.000242 91.3600n 0.000257 91.3700n 0.000271 91.3800n 0.000285 91.3900n 0.000299 91.4000n 0.000313 91.4100n 0.000326 91.4200n 0.000339 91.4300n 0.000352 91.4400n 0.000365 91.4500n 0.000377 91.4600n 0.000389 91.4700n 0.000400 91.4800n 0.000412 91.4900n 0.000423
+ 91.5000n 0.000433 91.5100n 0.000444 91.5200n 0.000454 91.5300n 0.000463 91.5400n 0.000473 91.5500n 0.000482 91.5600n 0.000490 91.5700n 0.000499 91.5800n 0.000507 91.5900n 0.000514 91.6000n 0.000521 91.6100n 0.000528 91.6200n 0.000535 91.6300n 0.000541 91.6400n 0.000547
+ 91.6500n 0.000552 91.6600n 0.000557 91.6700n 0.000562 91.6800n 0.000566 91.6900n 0.000570 91.7000n 0.000574 91.7100n 0.000577 91.7200n 0.000580 91.7300n 0.000582 91.7400n 0.000584 91.7500n 0.000586 91.7600n 0.000588 91.7700n 0.000589 91.7800n 0.000589 91.7900n 0.000589
+ 91.8000n 0.000589 91.8100n 0.000589 91.8200n 0.000588 91.8300n 0.000587 91.8400n 0.000585 91.8500n 0.000583 91.8600n 0.000581 91.8700n 0.000579 91.8800n 0.000576 91.8900n 0.000573 91.9000n 0.000569 91.9100n 0.000565 91.9200n 0.000561 91.9300n 0.000556 91.9400n 0.000551
+ 91.9500n 0.000546 91.9600n 0.000541 91.9700n 0.000535 91.9800n 0.000529 91.9900n 0.000523 92.0000n 0.000516 92.0100n 0.000509 92.0200n 0.000502 92.0300n 0.000495 92.0400n 0.000487 92.0500n 0.000479 92.0600n 0.000471 92.0700n 0.000462 92.0800n 0.000454 92.0900n 0.000445
+ 92.1000n 0.000436 92.1100n 0.000426 92.1200n 0.000417 92.1300n 0.000407 92.1400n 0.000397 92.1500n 0.000387 92.1600n 0.000377 92.1700n 0.000367 92.1800n 0.000356 92.1900n 0.000345 92.2000n 0.000335 92.2100n 0.000324 92.2200n 0.000313 92.2300n 0.000301 92.2400n 0.000290
+ 92.2500n 0.000279 92.2600n 0.000267 92.2700n 0.000255 92.2800n 0.000244 92.2900n 0.000232 92.3000n 0.000220 92.3100n 0.000208 92.3200n 0.000196 92.3300n 0.000184 92.3400n 0.000172 92.3500n 0.000160 92.3600n 0.000148 92.3700n 0.000136 92.3800n 0.000124 92.3900n 0.000112
+ 92.4000n 0.000100 92.4100n 0.000088 92.4200n 0.000076 92.4300n 0.000064 92.4400n 0.000052 92.4500n 0.000040 92.4600n 0.000029 92.4700n 0.000017 92.4800n 0.000005 92.4900n -0.000006 92.5000n -0.000018 92.5100n -0.000029 92.5200n -0.000041 92.5300n -0.000052 92.5400n -0.000063
+ 92.5500n -0.000074 92.5600n -0.000085 92.5700n -0.000096 92.5800n -0.000107 92.5900n -0.000117 92.6000n -0.000128 92.6100n -0.000138 92.6200n -0.000148 92.6300n -0.000158 92.6400n -0.000168 92.6500n -0.000177 92.6600n -0.000187 92.6700n -0.000196 92.6800n -0.000206 92.6900n -0.000215
+ 92.7000n -0.000223 92.7100n -0.000232 92.7200n -0.000241 92.7300n -0.000249 92.7400n -0.000257 92.7500n -0.000265 92.7600n -0.000273 92.7700n -0.000280 92.7800n -0.000288 92.7900n -0.000295 92.8000n -0.000302 92.8100n -0.000309 92.8200n -0.000315 92.8300n -0.000322 92.8400n -0.000328
+ 92.8500n -0.000334 92.8600n -0.000340 92.8700n -0.000345 92.8800n -0.000351 92.8900n -0.000356 92.9000n -0.000361 92.9100n -0.000366 92.9200n -0.000371 92.9300n -0.000375 92.9400n -0.000380 92.9500n -0.000384 92.9600n -0.000388 92.9700n -0.000391 92.9800n -0.000395 92.9900n -0.000398
+ 93.0000n -0.000401 93.0100n -0.000404 93.0200n -0.000407 93.0300n -0.000410 93.0400n -0.000413 93.0500n -0.000415 93.0600n -0.000417 93.0700n -0.000419 93.0800n -0.000421 93.0900n -0.000423 93.1000n -0.000424 93.1100n -0.000426 93.1200n -0.000427 93.1300n -0.000428 93.1400n -0.000429
+ 93.1500n -0.000430 93.1600n -0.000431 93.1700n -0.000432 93.1800n -0.000432 93.1900n -0.000433 93.2000n -0.000433 93.2100n -0.000433 93.2200n -0.000433 93.2300n -0.000433 93.2400n -0.000433 93.2500n -0.000433 93.2600n -0.000433 93.2700n -0.000432 93.2800n -0.000432 93.2900n -0.000431
+ 93.3000n -0.000431 93.3100n -0.000430 93.3200n -0.000430 93.3300n -0.000429 93.3400n -0.000428 93.3500n -0.000427 93.3600n -0.000426 93.3700n -0.000426 93.3800n -0.000425 93.3900n -0.000424 93.4000n -0.000423 93.4100n -0.000422 93.4200n -0.000421 93.4300n -0.000420 93.4400n -0.000418
+ 93.4500n -0.000417 93.4600n -0.000416 93.4700n -0.000415 93.4800n -0.000414 93.4900n -0.000413 93.5000n -0.000412 93.5100n -0.000411 93.5200n -0.000410 93.5300n -0.000409 93.5400n -0.000408 93.5500n -0.000407 93.5600n -0.000406 93.5700n -0.000405 93.5800n -0.000404 93.5900n -0.000403
+ 93.6000n -0.000403 93.6100n -0.000402 93.6200n -0.000401 93.6300n -0.000400 93.6400n -0.000400 93.6500n -0.000399 93.6600n -0.000398 93.6700n -0.000398 93.6800n -0.000397 93.6900n -0.000397 93.7000n -0.000396 93.7100n -0.000396 93.7200n -0.000396 93.7300n -0.000395 93.7400n -0.000395
+ 93.7500n -0.000395 93.7600n -0.000395 93.7700n -0.000395 93.7800n -0.000395 93.7900n -0.000395 93.8000n -0.000395 93.8100n -0.000395 93.8200n -0.000395 93.8300n -0.000395 93.8400n -0.000395 93.8500n -0.000395 93.8600n -0.000395 93.8700n -0.000395 93.8800n -0.000396 93.8900n -0.000396
+ 93.9000n -0.000396 93.9100n -0.000397 93.9200n -0.000397 93.9300n -0.000397 93.9400n -0.000398 93.9500n -0.000398 93.9600n -0.000398 93.9700n -0.000399 93.9800n -0.000399 93.9900n -0.000400 94.0000n -0.000400 94.0100n -0.000400 94.0200n -0.000401 94.0300n -0.000401 94.0400n -0.000401
+ 94.0500n -0.000401 94.0600n -0.000402 94.0700n -0.000402 94.0800n -0.000402 94.0900n -0.000402 94.1000n -0.000402 94.1100n -0.000402 94.1200n -0.000402 94.1300n -0.000402 94.1400n -0.000402 94.1500n -0.000401 94.1600n -0.000401 94.1700n -0.000401 94.1800n -0.000400 94.1900n -0.000400
+ 94.2000n -0.000399 94.2100n -0.000398 94.2200n -0.000397 94.2300n -0.000396 94.2400n -0.000395 94.2500n -0.000394 94.2600n -0.000393 94.2700n -0.000391 94.2800n -0.000390 94.2900n -0.000388 94.3000n -0.000386 94.3100n -0.000384 94.3200n -0.000382 94.3300n -0.000379 94.3400n -0.000377
+ 94.3500n -0.000374 94.3600n -0.000372 94.3700n -0.000369 94.3800n -0.000366 94.3900n -0.000362 94.4000n -0.000359 94.4100n -0.000355 94.4200n -0.000351 94.4300n -0.000347 94.4400n -0.000343 94.4500n -0.000339 94.4600n -0.000334 94.4700n -0.000330 94.4800n -0.000325 94.4900n -0.000320
+ 94.5000n -0.000314 94.5100n -0.000309 94.5200n -0.000303 94.5300n -0.000297 94.5400n -0.000291 94.5500n -0.000284 94.5600n -0.000278 94.5700n -0.000271 94.5800n -0.000264 94.5900n -0.000257 94.6000n -0.000250 94.6100n -0.000242 94.6200n -0.000234 94.6300n -0.000226 94.6400n -0.000218
+ 94.6500n -0.000209 94.6600n -0.000201 94.6700n -0.000192 94.6800n -0.000183 94.6900n -0.000174 94.7000n -0.000164 94.7100n -0.000155 94.7200n -0.000145 94.7300n -0.000135 94.7400n -0.000124 94.7500n -0.000114 94.7600n -0.000103 94.7700n -0.000093 94.7800n -0.000082 94.7900n -0.000071
+ 94.8000n -0.000059 94.8100n -0.000048 94.8200n -0.000036 94.8300n -0.000024 94.8400n -0.000013 94.8500n -0.000000 94.8600n 0.000012 94.8700n 0.000024 94.8800n 0.000037 94.8900n 0.000049 94.9000n 0.000062 94.9100n 0.000075 94.9200n 0.000088 94.9300n 0.000101 94.9400n 0.000114
+ 94.9500n 0.000127 94.9600n 0.000140 94.9700n 0.000154 94.9800n 0.000167 94.9900n 0.000181 95.0000n 0.000194 95.0100n 0.000208 95.0200n 0.000221 95.0300n 0.000235 95.0400n 0.000249 95.0500n 0.000262 95.0600n 0.000276 95.0700n 0.000290 95.0800n 0.000303 95.0900n 0.000317
+ 95.1000n 0.000331 95.1100n 0.000344 95.1200n 0.000358 95.1300n 0.000371 95.1400n 0.000384 95.1500n 0.000398 95.1600n 0.000411 95.1700n 0.000424 95.1800n 0.000437 95.1900n 0.000450 95.2000n 0.000463 95.2100n 0.000475 95.2200n 0.000488 95.2300n 0.000500 95.2400n 0.000512
+ 95.2500n 0.000524 95.2600n 0.000536 95.2700n 0.000547 95.2800n 0.000559 95.2900n 0.000570 95.3000n 0.000581 95.3100n 0.000592 95.3200n 0.000602 95.3300n 0.000612 95.3400n 0.000622 95.3500n 0.000632 95.3600n 0.000641 95.3700n 0.000650 95.3800n 0.000659 95.3900n 0.000668
+ 95.4000n 0.000676 95.4100n 0.000684 95.4200n 0.000691 95.4300n 0.000698 95.4400n 0.000705 95.4500n 0.000711 95.4600n 0.000718 95.4700n 0.000723 95.4800n 0.000728 95.4900n 0.000733 95.5000n 0.000738 95.5100n 0.000742 95.5200n 0.000746 95.5300n 0.000749 95.5400n 0.000752
+ 95.5500n 0.000754 95.5600n 0.000756 95.5700n 0.000757 95.5800n 0.000758 95.5900n 0.000759 95.6000n 0.000759 95.6100n 0.000759 95.6200n 0.000758 95.6300n 0.000756 95.6400n 0.000754 95.6500n 0.000752 95.6600n 0.000749 95.6700n 0.000746 95.6800n 0.000742 95.6900n 0.000737
+ 95.7000n 0.000732 95.7100n 0.000727 95.7200n 0.000721 95.7300n 0.000714 95.7400n 0.000707 95.7500n 0.000700 95.7600n 0.000691 95.7700n 0.000683 95.7800n 0.000673 95.7900n 0.000664 95.8000n 0.000653 95.8100n 0.000642 95.8200n 0.000631 95.8300n 0.000619 95.8400n 0.000606
+ 95.8500n 0.000593 95.8600n 0.000580 95.8700n 0.000565 95.8800n 0.000551 95.8900n 0.000535 95.9000n 0.000519 95.9100n 0.000503 95.9200n 0.000486 95.9300n 0.000469 95.9400n 0.000450 95.9500n 0.000432 95.9600n 0.000413 95.9700n 0.000393 95.9800n 0.000373 95.9900n 0.000352
+ 96.0000n 0.000331 96.0100n 0.000309 96.0200n 0.000287 96.0300n 0.000264 96.0400n 0.000241 96.0500n 0.000217 96.0600n 0.000193 96.0700n 0.000168 96.0800n 0.000143 96.0900n 0.000117 96.1000n 0.000091 96.1100n 0.000064 96.1200n 0.000037 96.1300n 0.000010 96.1400n -0.000018
+ 96.1500n -0.000047 96.1600n -0.000075 96.1700n -0.000105 96.1800n -0.000134 96.1900n -0.000164 96.2000n -0.000195 96.2100n -0.000226 96.2200n -0.000257 96.2300n -0.000289 96.2400n -0.000321 96.2500n -0.000353 96.2600n -0.000385 96.2700n -0.000418 96.2800n -0.000452 96.2900n -0.000485
+ 96.3000n -0.000519 96.3100n -0.000553 96.3200n -0.000588 96.3300n -0.000623 96.3400n -0.000658 96.3500n -0.000693 96.3600n -0.000728 96.3700n -0.000764 96.3800n -0.000800 96.3900n -0.000836 96.4000n -0.000872 96.4100n -0.000909 96.4200n -0.000945 96.4300n -0.000982 96.4400n -0.001019
+ 96.4500n -0.001056 96.4600n -0.001094 96.4700n -0.001131 96.4800n -0.001168 96.4900n -0.001206 96.5000n -0.001243 96.5100n -0.001281 96.5200n -0.001319 96.5300n -0.001356 96.5400n -0.001394 96.5500n -0.001432 96.5600n -0.001470 96.5700n -0.001507 96.5800n -0.001545 96.5900n -0.001583
+ 96.6000n -0.001620 96.6100n -0.001658 96.6200n -0.001695 96.6300n -0.001733 96.6400n -0.001770 96.6500n -0.001807 96.6600n -0.001844 96.6700n -0.001881 96.6800n -0.001918 96.6900n -0.001955 96.7000n -0.001991 96.7100n -0.002027 96.7200n -0.002063 96.7300n -0.002099 96.7400n -0.002135
+ 96.7500n -0.002170 96.7600n -0.002206 96.7700n -0.002241 96.7800n -0.002275 96.7900n -0.002310 96.8000n -0.002344 96.8100n -0.002378 96.8200n -0.002411 96.8300n -0.002444 96.8400n -0.002477 96.8500n -0.002510 96.8600n -0.002542 96.8700n -0.002574 96.8800n -0.002605 96.8900n -0.002637
+ 96.9000n -0.002667 96.9100n -0.002698 96.9200n -0.002727 96.9300n -0.002757 96.9400n -0.002786 96.9500n -0.002815 96.9600n -0.002843 96.9700n -0.002871 96.9800n -0.002898 96.9900n -0.002925 97.0000n -0.002951 97.0100n -0.002977 97.0200n -0.003002 97.0300n -0.003027 97.0400n -0.003051
+ 97.0500n -0.003075 97.0600n -0.003098 97.0700n -0.003121 97.0800n -0.003143 97.0900n -0.003165 97.1000n -0.003186 97.1100n -0.003206 97.1200n -0.003226 97.1300n -0.003246 97.1400n -0.003264 97.1500n -0.003283 97.1600n -0.003300 97.1700n -0.003317 97.1800n -0.003334 97.1900n -0.003349
+ 97.2000n -0.003364 97.2100n -0.003379 97.2200n -0.003393 97.2300n -0.003406 97.2400n -0.003419 97.2500n -0.003431 97.2600n -0.003442 97.2700n -0.003453 97.2800n -0.003463 97.2900n -0.003472 97.3000n -0.003481 97.3100n -0.003489 97.3200n -0.003497 97.3300n -0.003503 97.3400n -0.003509
+ 97.3500n -0.003515 97.3600n -0.003519 97.3700n -0.003523 97.3800n -0.003527 97.3900n -0.003530 97.4000n -0.003532 97.4100n -0.003533 97.4200n -0.003533 97.4300n -0.003533 97.4400n -0.003533 97.4500n -0.003531 97.4600n -0.003529 97.4700n -0.003526 97.4800n -0.003523 97.4900n -0.003518
+ 97.5000n -0.003513 97.5100n -0.003508 97.5200n -0.003502 97.5300n -0.003495 97.5400n -0.003487 97.5500n -0.003478 97.5600n -0.003469 97.5700n -0.003460 97.5800n -0.003449 97.5900n -0.003438 97.6000n -0.003426 97.6100n -0.003414 97.6200n -0.003401 97.6300n -0.003387 97.6400n -0.003372
+ 97.6500n -0.003357 97.6600n -0.003341 97.6700n -0.003325 97.6800n -0.003308 97.6900n -0.003290 97.7000n -0.003271 97.7100n -0.003252 97.7200n -0.003232 97.7300n -0.003212 97.7400n -0.003191 97.7500n -0.003169 97.7600n -0.003147 97.7700n -0.003124 97.7800n -0.003100 97.7900n -0.003076
+ 97.8000n -0.003051 97.8100n -0.003026 97.8200n -0.003000 97.8300n -0.002973 97.8400n -0.002946 97.8500n -0.002918 97.8600n -0.002890 97.8700n -0.002861 97.8800n -0.002831 97.8900n -0.002801 97.9000n -0.002770 97.9100n -0.002739 97.9200n -0.002708 97.9300n -0.002675 97.9400n -0.002643
+ 97.9500n -0.002609 97.9600n -0.002576 97.9700n -0.002541 97.9800n -0.002506 97.9900n -0.002471 98.0000n -0.002436 98.0100n -0.002399 98.0200n -0.002363 98.0300n -0.002326 98.0400n -0.002288 98.0500n -0.002250 98.0600n -0.002212 98.0700n -0.002173 98.0800n -0.002134 98.0900n -0.002094
+ 98.1000n -0.002054 98.1100n -0.002014 98.1200n -0.001973 98.1300n -0.001932 98.1400n -0.001891 98.1500n -0.001849 98.1600n -0.001807 98.1700n -0.001765 98.1800n -0.001722 98.1900n -0.001679 98.2000n -0.001636 98.2100n -0.001593 98.2200n -0.001549 98.2300n -0.001505 98.2400n -0.001461
+ 98.2500n -0.001417 98.2600n -0.001372 98.2700n -0.001328 98.2800n -0.001283 98.2900n -0.001238 98.3000n -0.001192 98.3100n -0.001147 98.3200n -0.001102 98.3300n -0.001056 98.3400n -0.001010 98.3500n -0.000965 98.3600n -0.000919 98.3700n -0.000873 98.3800n -0.000827 98.3900n -0.000781
+ 98.4000n -0.000735 98.4100n -0.000689 98.4200n -0.000643 98.4300n -0.000597 98.4400n -0.000551 98.4500n -0.000506 98.4600n -0.000460 98.4700n -0.000414 98.4800n -0.000369 98.4900n -0.000323 98.5000n -0.000278 98.5100n -0.000233 98.5200n -0.000188 98.5300n -0.000143 98.5400n -0.000098
+ 98.5500n -0.000054 98.5600n -0.000009 98.5700n 0.000035 98.5800n 0.000078 98.5900n 0.000122 98.6000n 0.000165 98.6100n 0.000208 98.6200n 0.000251 98.6300n 0.000293 98.6400n 0.000335 98.6500n 0.000377 98.6600n 0.000418 98.6700n 0.000459 98.6800n 0.000500 98.6900n 0.000540
+ 98.7000n 0.000579 98.7100n 0.000619 98.7200n 0.000658 98.7300n 0.000696 98.7400n 0.000734 98.7500n 0.000771 98.7600n 0.000808 98.7700n 0.000845 98.7800n 0.000881 98.7900n 0.000916 98.8000n 0.000951 98.8100n 0.000985 98.8200n 0.001018 98.8300n 0.001052 98.8400n 0.001084
+ 98.8500n 0.001116 98.8600n 0.001147 98.8700n 0.001178 98.8800n 0.001207 98.8900n 0.001237 98.9000n 0.001265 98.9100n 0.001293 98.9200n 0.001320 98.9300n 0.001347 98.9400n 0.001372 98.9500n 0.001397 98.9600n 0.001422 98.9700n 0.001445 98.9800n 0.001468 98.9900n 0.001490
+ 99.0000n 0.001511 99.0100n 0.001531 99.0200n 0.001551 99.0300n 0.001570 99.0400n 0.001588 99.0500n 0.001605 99.0600n 0.001621 99.0700n 0.001637 99.0800n 0.001651 99.0900n 0.001665 99.1000n 0.001678 99.1100n 0.001690 99.1200n 0.001701 99.1300n 0.001712 99.1400n 0.001721
+ 99.1500n 0.001730 99.1600n 0.001737 99.1700n 0.001744 99.1800n 0.001750 99.1900n 0.001755 99.2000n 0.001759 99.2100n 0.001763 99.2200n 0.001765 99.2300n 0.001766 99.2400n 0.001767 99.2500n 0.001766 99.2600n 0.001765 99.2700n 0.001763 99.2800n 0.001760 99.2900n 0.001756
+ 99.3000n 0.001751 99.3100n 0.001745 99.3200n 0.001739 99.3300n 0.001731 99.3400n 0.001722 99.3500n 0.001713 99.3600n 0.001703 99.3700n 0.001692 99.3800n 0.001680 99.3900n 0.001667 99.4000n 0.001653 99.4100n 0.001638 99.4200n 0.001623 99.4300n 0.001606 99.4400n 0.001589
+ 99.4500n 0.001571 99.4600n 0.001552 99.4700n 0.001533 99.4800n 0.001512 99.4900n 0.001491 99.5000n 0.001469 99.5100n 0.001446 99.5200n 0.001423 99.5300n 0.001398 99.5400n 0.001373 99.5500n 0.001347 99.5600n 0.001321 99.5700n 0.001293 99.5800n 0.001265 99.5900n 0.001237
+ 99.6000n 0.001207 99.6100n 0.001177 99.6200n 0.001146 99.6300n 0.001115 99.6400n 0.001083 99.6500n 0.001050 99.6600n 0.001017 99.6700n 0.000984 99.6800n 0.000949 99.6900n 0.000914 99.7000n 0.000879 99.7100n 0.000843 99.7200n 0.000807 99.7300n 0.000770 99.7400n 0.000732
+ 99.7500n 0.000695 99.7600n 0.000656 99.7700n 0.000618 99.7800n 0.000579 99.7900n 0.000539 99.8000n 0.000499 99.8100n 0.000459 99.8200n 0.000419 99.8300n 0.000378 99.8400n 0.000337 99.8500n 0.000296 99.8600n 0.000254 99.8700n 0.000213 99.8800n 0.000171 99.8900n 0.000129
+ 99.9000n 0.000086 99.9100n 0.000044 99.9200n 0.000002 99.9300n -0.000041 99.9400n -0.000084 99.9500n -0.000127 99.9600n -0.000169 99.9700n -0.000212 99.9800n -0.000255 99.9900n -0.000298 100.0000n -0.000341 100.0100n -0.000383 100.0200n -0.000426 100.0300n -0.000468 100.0400n -0.000511
+ 100.0500n -0.000553 100.0600n -0.000595 100.0700n -0.000637 100.0800n -0.000679 100.0900n -0.000720 100.1000n -0.000762 100.1100n -0.000803 100.1200n -0.000843 100.1300n -0.000884 100.1400n -0.000924 100.1500n -0.000963 100.1600n -0.001003 100.1700n -0.001042 100.1800n -0.001080 100.1900n -0.001119
+ 100.2000n -0.001156 100.2100n -0.001194 100.2200n -0.001231 100.2300n -0.001267 100.2400n -0.001303 100.2500n -0.001338 100.2600n -0.001373 100.2700n -0.001407 100.2800n -0.001441 100.2900n -0.001474 100.3000n -0.001507 100.3100n -0.001539 100.3200n -0.001570 100.3300n -0.001601 100.3400n -0.001631
+ 100.3500n -0.001660 100.3600n -0.001689 100.3700n -0.001717 100.3800n -0.001744 100.3900n -0.001771 100.4000n -0.001797 100.4100n -0.001822 100.4200n -0.001847 100.4300n -0.001870 100.4400n -0.001893 100.4500n -0.001915 100.4600n -0.001937 100.4700n -0.001957 100.4800n -0.001977 100.4900n -0.001996
+ 100.5000n -0.002014 100.5100n -0.002031 100.5200n -0.002048 100.5300n -0.002064 100.5400n -0.002079 100.5500n -0.002093 100.5600n -0.002106 100.5700n -0.002118 100.5800n -0.002130 100.5900n -0.002140 100.6000n -0.002150 100.6100n -0.002159 100.6200n -0.002167 100.6300n -0.002175 100.6400n -0.002181
+ 100.6500n -0.002186 100.6600n -0.002191 100.6700n -0.002195 100.6800n -0.002198 100.6900n -0.002200 100.7000n -0.002201 100.7100n -0.002202 100.7200n -0.002201 100.7300n -0.002200 100.7400n -0.002198 100.7500n -0.002195 100.7600n -0.002192 100.7700n -0.002187 100.7800n -0.002182 100.7900n -0.002176
+ 100.8000n -0.002169 100.8100n -0.002161 100.8200n -0.002153 100.8300n -0.002143 100.8400n -0.002133 100.8500n -0.002123 100.8600n -0.002111 100.8700n -0.002099 100.8800n -0.002086 100.8900n -0.002072 100.9000n -0.002058 100.9100n -0.002043 100.9200n -0.002027 100.9300n -0.002011 100.9400n -0.001994
+ 100.9500n -0.001976 100.9600n -0.001958 100.9700n -0.001939 100.9800n -0.001919 100.9900n -0.001899 101.0000n -0.001878 101.0100n -0.001857 101.0200n -0.001835 101.0300n -0.001813 101.0400n -0.001790 101.0500n -0.001767 101.0600n -0.001743 101.0700n -0.001718 101.0800n -0.001694 101.0900n -0.001668
+ 101.1000n -0.001643 101.1100n -0.001617 101.1200n -0.001590 101.1300n -0.001564 101.1400n -0.001536 101.1500n -0.001509 101.1600n -0.001481 101.1700n -0.001453 101.1800n -0.001425 101.1900n -0.001396 101.2000n -0.001367 101.2100n -0.001338 101.2200n -0.001308 101.2300n -0.001279 101.2400n -0.001249
+ 101.2500n -0.001219 101.2600n -0.001189 101.2700n -0.001159 101.2800n -0.001128 101.2900n -0.001098 101.3000n -0.001067 101.3100n -0.001037 101.3200n -0.001006 101.3300n -0.000975 101.3400n -0.000944 101.3500n -0.000914 101.3600n -0.000883 101.3700n -0.000852 101.3800n -0.000821 101.3900n -0.000791
+ 101.4000n -0.000760 101.4100n -0.000730 101.4200n -0.000699 101.4300n -0.000669 101.4400n -0.000639 101.4500n -0.000609 101.4600n -0.000579 101.4700n -0.000549 101.4800n -0.000520 101.4900n -0.000490 101.5000n -0.000461 101.5100n -0.000432 101.5200n -0.000404 101.5300n -0.000375 101.5400n -0.000347
+ 101.5500n -0.000319 101.5600n -0.000292 101.5700n -0.000264 101.5800n -0.000237 101.5900n -0.000210 101.6000n -0.000184 101.6100n -0.000158 101.6200n -0.000132 101.6300n -0.000107 101.6400n -0.000081 101.6500n -0.000057 101.6600n -0.000032 101.6700n -0.000008 101.6800n 0.000015 101.6900n 0.000039
+ 101.7000n 0.000062 101.7100n 0.000084 101.7200n 0.000106 101.7300n 0.000128 101.7400n 0.000149 101.7500n 0.000170 101.7600n 0.000191 101.7700n 0.000211 101.7800n 0.000230 101.7900n 0.000249 101.8000n 0.000268 101.8100n 0.000287 101.8200n 0.000305 101.8300n 0.000322 101.8400n 0.000339
+ 101.8500n 0.000356 101.8600n 0.000372 101.8700n 0.000388 101.8800n 0.000403 101.8900n 0.000418 101.9000n 0.000433 101.9100n 0.000447 101.9200n 0.000461 101.9300n 0.000474 101.9400n 0.000487 101.9500n 0.000500 101.9600n 0.000512 101.9700n 0.000524 101.9800n 0.000535 101.9900n 0.000546
+ 102.0000n 0.000557 102.0100n 0.000567 102.0200n 0.000577 102.0300n 0.000586 102.0400n 0.000596 102.0500n 0.000604 102.0600n 0.000613 102.0700n 0.000621 102.0800n 0.000629 102.0900n 0.000636 102.1000n 0.000643 102.1100n 0.000650 102.1200n 0.000657 102.1300n 0.000663 102.1400n 0.000669
+ 102.1500n 0.000675 102.1600n 0.000680 102.1700n 0.000686 102.1800n 0.000691 102.1900n 0.000695 102.2000n 0.000700 102.2100n 0.000704 102.2200n 0.000709 102.2300n 0.000712 102.2400n 0.000716 102.2500n 0.000720 102.2600n 0.000723 102.2700n 0.000727 102.2800n 0.000730 102.2900n 0.000733
+ 102.3000n 0.000736 102.3100n 0.000738 102.3200n 0.000741 102.3300n 0.000744 102.3400n 0.000746 102.3500n 0.000748 102.3600n 0.000751 102.3700n 0.000753 102.3800n 0.000755 102.3900n 0.000758 102.4000n 0.000760 102.4100n 0.000762 102.4200n 0.000764 102.4300n 0.000766 102.4400n 0.000769
+ 102.4500n 0.000771 102.4600n 0.000773 102.4700n 0.000775 102.4800n 0.000778 102.4900n 0.000780 102.5000n 0.000783 102.5100n 0.000785 102.5200n 0.000788 102.5300n 0.000791 102.5400n 0.000793 102.5500n 0.000796 102.5600n 0.000799 102.5700n 0.000803 102.5800n 0.000806 102.5900n 0.000809
+ 102.6000n 0.000813 102.6100n 0.000817 102.6200n 0.000820 102.6300n 0.000825 102.6400n 0.000829 102.6500n 0.000833 102.6600n 0.000838 102.6700n 0.000842 102.6800n 0.000847 102.6900n 0.000852 102.7000n 0.000857 102.7100n 0.000863 102.7200n 0.000868 102.7300n 0.000874 102.7400n 0.000880
+ 102.7500n 0.000886 102.7600n 0.000893 102.7700n 0.000899 102.7800n 0.000906 102.7900n 0.000913 102.8000n 0.000920 102.8100n 0.000928 102.8200n 0.000935 102.8300n 0.000943 102.8400n 0.000951 102.8500n 0.000959 102.8600n 0.000968 102.8700n 0.000976 102.8800n 0.000985 102.8900n 0.000994
+ 102.9000n 0.001003 102.9100n 0.001012 102.9200n 0.001022 102.9300n 0.001031 102.9400n 0.001041 102.9500n 0.001051 102.9600n 0.001061 102.9700n 0.001071 102.9800n 0.001082 102.9900n 0.001092 103.0000n 0.001103 103.0100n 0.001114 103.0200n 0.001125 103.0300n 0.001136 103.0400n 0.001147
+ 103.0500n 0.001158 103.0600n 0.001169 103.0700n 0.001181 103.0800n 0.001192 103.0900n 0.001204 103.1000n 0.001216 103.1100n 0.001227 103.1200n 0.001239 103.1300n 0.001251 103.1400n 0.001263 103.1500n 0.001274 103.1600n 0.001286 103.1700n 0.001298 103.1800n 0.001310 103.1900n 0.001322
+ 103.2000n 0.001333 103.2100n 0.001345 103.2200n 0.001357 103.2300n 0.001368 103.2400n 0.001380 103.2500n 0.001391 103.2600n 0.001403 103.2700n 0.001414 103.2800n 0.001425 103.2900n 0.001436 103.3000n 0.001447 103.3100n 0.001458 103.3200n 0.001468 103.3300n 0.001479 103.3400n 0.001489
+ 103.3500n 0.001499 103.3600n 0.001509 103.3700n 0.001518 103.3800n 0.001528 103.3900n 0.001537 103.4000n 0.001546 103.4100n 0.001555 103.4200n 0.001563 103.4300n 0.001571 103.4400n 0.001579 103.4500n 0.001587 103.4600n 0.001594 103.4700n 0.001601 103.4800n 0.001608 103.4900n 0.001614
+ 103.5000n 0.001620 103.5100n 0.001626 103.5200n 0.001631 103.5300n 0.001636 103.5400n 0.001641 103.5500n 0.001645 103.5600n 0.001649 103.5700n 0.001653 103.5800n 0.001656 103.5900n 0.001659 103.6000n 0.001661 103.6100n 0.001663 103.6200n 0.001665 103.6300n 0.001666 103.6400n 0.001666
+ 103.6500n 0.001667 103.6600n 0.001667 103.6700n 0.001666 103.6800n 0.001665 103.6900n 0.001663 103.7000n 0.001662 103.7100n 0.001659 103.7200n 0.001656 103.7300n 0.001653 103.7400n 0.001649 103.7500n 0.001645 103.7600n 0.001640 103.7700n 0.001635 103.7800n 0.001630 103.7900n 0.001624
+ 103.8000n 0.001617 103.8100n 0.001610 103.8200n 0.001603 103.8300n 0.001595 103.8400n 0.001587 103.8500n 0.001578 103.8600n 0.001569 103.8700n 0.001559 103.8800n 0.001549 103.8900n 0.001539 103.9000n 0.001528 103.9100n 0.001517 103.9200n 0.001505 103.9300n 0.001493 103.9400n 0.001480
+ 103.9500n 0.001467 103.9600n 0.001454 103.9700n 0.001440 103.9800n 0.001426 103.9900n 0.001411 104.0000n 0.001396 104.0100n 0.001381 104.0200n 0.001366 104.0300n 0.001350 104.0400n 0.001333 104.0500n 0.001317 104.0600n 0.001300 104.0700n 0.001283 104.0800n 0.001265 104.0900n 0.001247
+ 104.1000n 0.001229 104.1100n 0.001211 104.1200n 0.001192 104.1300n 0.001173 104.1400n 0.001154 104.1500n 0.001135 104.1600n 0.001116 104.1700n 0.001096 104.1800n 0.001076 104.1900n 0.001056 104.2000n 0.001036 104.2100n 0.001016 104.2200n 0.000995 104.2300n 0.000975 104.2400n 0.000954
+ 104.2500n 0.000934 104.2600n 0.000913 104.2700n 0.000892 104.2800n 0.000871 104.2900n 0.000850 104.3000n 0.000830 104.3100n 0.000809 104.3200n 0.000788 104.3300n 0.000767 104.3400n 0.000746 104.3500n 0.000725 104.3600n 0.000705 104.3700n 0.000684 104.3800n 0.000664 104.3900n 0.000643
+ 104.4000n 0.000623 104.4100n 0.000603 104.4200n 0.000583 104.4300n 0.000564 104.4400n 0.000544 104.4500n 0.000525 104.4600n 0.000506 104.4700n 0.000487 104.4800n 0.000468 104.4900n 0.000450 104.5000n 0.000432 104.5100n 0.000414 104.5200n 0.000396 104.5300n 0.000379 104.5400n 0.000362
+ 104.5500n 0.000346 104.5600n 0.000329 104.5700n 0.000314 104.5800n 0.000298 104.5900n 0.000283 104.6000n 0.000268 104.6100n 0.000254 104.6200n 0.000240 104.6300n 0.000227 104.6400n 0.000214 104.6500n 0.000201 104.6600n 0.000189 104.6700n 0.000177 104.6800n 0.000166 104.6900n 0.000155
+ 104.7000n 0.000145 104.7100n 0.000136 104.7200n 0.000126 104.7300n 0.000118 104.7400n 0.000110 104.7500n 0.000102 104.7600n 0.000095 104.7700n 0.000088 104.7800n 0.000082 104.7900n 0.000077 104.8000n 0.000072 104.8100n 0.000067 104.8200n 0.000064 104.8300n 0.000060 104.8400n 0.000058
+ 104.8500n 0.000055 104.8600n 0.000054 104.8700n 0.000053 104.8800n 0.000052 104.8900n 0.000053 104.9000n 0.000053 104.9100n 0.000055 104.9200n 0.000056 104.9300n 0.000059 104.9400n 0.000062 104.9500n 0.000065 104.9600n 0.000069 104.9700n 0.000074 104.9800n 0.000079 104.9900n 0.000085
+ 105.0000n 0.000091 105.0100n 0.000098 105.0200n 0.000105 105.0300n 0.000113 105.0400n 0.000121 105.0500n 0.000130 105.0600n 0.000140 105.0700n 0.000150 105.0800n 0.000160 105.0900n 0.000171 105.1000n 0.000182 105.1100n 0.000194 105.1200n 0.000207 105.1300n 0.000219 105.1400n 0.000232
+ 105.1500n 0.000246 105.1600n 0.000260 105.1700n 0.000274 105.1800n 0.000289 105.1900n 0.000304 105.2000n 0.000320 105.2100n 0.000336 105.2200n 0.000352 105.2300n 0.000369 105.2400n 0.000386 105.2500n 0.000403 105.2600n 0.000421 105.2700n 0.000438 105.2800n 0.000456 105.2900n 0.000475
+ 105.3000n 0.000493 105.3100n 0.000512 105.3200n 0.000531 105.3300n 0.000550 105.3400n 0.000570 105.3500n 0.000589 105.3600n 0.000609 105.3700n 0.000629 105.3800n 0.000649 105.3900n 0.000669 105.4000n 0.000689 105.4100n 0.000709 105.4200n 0.000729 105.4300n 0.000749 105.4400n 0.000769
+ 105.4500n 0.000790 105.4600n 0.000810 105.4700n 0.000830 105.4800n 0.000850 105.4900n 0.000870 105.5000n 0.000890 105.5100n 0.000910 105.5200n 0.000930 105.5300n 0.000950 105.5400n 0.000969 105.5500n 0.000989 105.5600n 0.001008 105.5700n 0.001027 105.5800n 0.001046 105.5900n 0.001064
+ 105.6000n 0.001083 105.6100n 0.001101 105.6200n 0.001119 105.6300n 0.001136 105.6400n 0.001154 105.6500n 0.001171 105.6600n 0.001187 105.6700n 0.001204 105.6800n 0.001220 105.6900n 0.001235 105.7000n 0.001250 105.7100n 0.001265 105.7200n 0.001280 105.7300n 0.001294 105.7400n 0.001307
+ 105.7500n 0.001321 105.7600n 0.001333 105.7700n 0.001346 105.7800n 0.001357 105.7900n 0.001369 105.8000n 0.001380 105.8100n 0.001390 105.8200n 0.001400 105.8300n 0.001409 105.8400n 0.001418 105.8500n 0.001427 105.8600n 0.001434 105.8700n 0.001442 105.8800n 0.001449 105.8900n 0.001455
+ 105.9000n 0.001460 105.9100n 0.001465 105.9200n 0.001470 105.9300n 0.001474 105.9400n 0.001477 105.9500n 0.001480 105.9600n 0.001482 105.9700n 0.001484 105.9800n 0.001485 105.9900n 0.001486 106.0000n 0.001486 106.0100n 0.001485 106.0200n 0.001484 106.0300n 0.001482 106.0400n 0.001480
+ 106.0500n 0.001477 106.0600n 0.001473 106.0700n 0.001469 106.0800n 0.001464 106.0900n 0.001459 106.1000n 0.001453 106.1100n 0.001447 106.1200n 0.001440 106.1300n 0.001433 106.1400n 0.001425 106.1500n 0.001416 106.1600n 0.001407 106.1700n 0.001398 106.1800n 0.001388 106.1900n 0.001377
+ 106.2000n 0.001366 106.2100n 0.001354 106.2200n 0.001342 106.2300n 0.001330 106.2400n 0.001317 106.2500n 0.001304 106.2600n 0.001290 106.2700n 0.001275 106.2800n 0.001261 106.2900n 0.001246 106.3000n 0.001230 106.3100n 0.001214 106.3200n 0.001198 106.3300n 0.001181 106.3400n 0.001164
+ 106.3500n 0.001147 106.3600n 0.001129 106.3700n 0.001112 106.3800n 0.001093 106.3900n 0.001075 106.4000n 0.001056 106.4100n 0.001037 106.4200n 0.001018 106.4300n 0.000999 106.4400n 0.000979 106.4500n 0.000959 106.4600n 0.000939 106.4700n 0.000919 106.4800n 0.000899 106.4900n 0.000878
+ 106.5000n 0.000858 106.5100n 0.000837 106.5200n 0.000817 106.5300n 0.000796 106.5400n 0.000775 106.5500n 0.000754 106.5600n 0.000733 106.5700n 0.000713 106.5800n 0.000692 106.5900n 0.000671 106.6000n 0.000650 106.6100n 0.000630 106.6200n 0.000609 106.6300n 0.000589 106.6400n 0.000568
+ 106.6500n 0.000548 106.6600n 0.000528 106.6700n 0.000508 106.6800n 0.000488 106.6900n 0.000469 106.7000n 0.000450 106.7100n 0.000430 106.7200n 0.000412 106.7300n 0.000393 106.7400n 0.000375 106.7500n 0.000356 106.7600n 0.000339 106.7700n 0.000321 106.7800n 0.000304 106.7900n 0.000287
+ 106.8000n 0.000271 106.8100n 0.000255 106.8200n 0.000239 106.8300n 0.000223 106.8400n 0.000208 106.8500n 0.000194 106.8600n 0.000179 106.8700n 0.000166 106.8800n 0.000152 106.8900n 0.000139 106.9000n 0.000127 106.9100n 0.000115 106.9200n 0.000103 106.9300n 0.000092 106.9400n 0.000082
+ 106.9500n 0.000071 106.9600n 0.000062 106.9700n 0.000053 106.9800n 0.000044 106.9900n 0.000036 107.0000n 0.000028 107.0100n 0.000021 107.0200n 0.000014 107.0300n 0.000008 107.0400n 0.000003 107.0500n -0.000002 107.0600n -0.000007 107.0700n -0.000011 107.0800n -0.000014 107.0900n -0.000017
+ 107.1000n -0.000020 107.1100n -0.000022 107.1200n -0.000023 107.1300n -0.000024 107.1400n -0.000024 107.1500n -0.000024 107.1600n -0.000023 107.1700n -0.000022 107.1800n -0.000020 107.1900n -0.000018 107.2000n -0.000015 107.2100n -0.000011 107.2200n -0.000008 107.2300n -0.000003 107.2400n 0.000001
+ 107.2500n 0.000007 107.2600n 0.000012 107.2700n 0.000018 107.2800n 0.000025 107.2900n 0.000032 107.3000n 0.000040 107.3100n 0.000047 107.3200n 0.000056 107.3300n 0.000064 107.3400n 0.000074 107.3500n 0.000083 107.3600n 0.000093 107.3700n 0.000103 107.3800n 0.000114 107.3900n 0.000125
+ 107.4000n 0.000136 107.4100n 0.000147 107.4200n 0.000159 107.4300n 0.000171 107.4400n 0.000184 107.4500n 0.000196 107.4600n 0.000209 107.4700n 0.000222 107.4800n 0.000235 107.4900n 0.000249 107.5000n 0.000263 107.5100n 0.000276 107.5200n 0.000290 107.5300n 0.000305 107.5400n 0.000319
+ 107.5500n 0.000333 107.5600n 0.000348 107.5700n 0.000362 107.5800n 0.000377 107.5900n 0.000391 107.6000n 0.000406 107.6100n 0.000421 107.6200n 0.000435 107.6300n 0.000450 107.6400n 0.000464 107.6500n 0.000479 107.6600n 0.000493 107.6700n 0.000508 107.6800n 0.000522 107.6900n 0.000536
+ 107.7000n 0.000550 107.7100n 0.000564 107.7200n 0.000578 107.7300n 0.000591 107.7400n 0.000604 107.7500n 0.000617 107.7600n 0.000630 107.7700n 0.000643 107.7800n 0.000655 107.7900n 0.000667 107.8000n 0.000679 107.8100n 0.000690 107.8200n 0.000701 107.8300n 0.000712 107.8400n 0.000722
+ 107.8500n 0.000733 107.8600n 0.000742 107.8700n 0.000752 107.8800n 0.000760 107.8900n 0.000769 107.9000n 0.000777 107.9100n 0.000785 107.9200n 0.000792 107.9300n 0.000799 107.9400n 0.000805 107.9500n 0.000811 107.9600n 0.000816 107.9700n 0.000821 107.9800n 0.000825 107.9900n 0.000829
+ 108.0000n 0.000832 108.0100n 0.000835 108.0200n 0.000837 108.0300n 0.000839 108.0400n 0.000840 108.0500n 0.000840 108.0600n 0.000840 108.0700n 0.000840 108.0800n 0.000839 108.0900n 0.000837 108.1000n 0.000835 108.1100n 0.000832 108.1200n 0.000829 108.1300n 0.000825 108.1400n 0.000820
+ 108.1500n 0.000815 108.1600n 0.000809 108.1700n 0.000803 108.1800n 0.000796 108.1900n 0.000789 108.2000n 0.000781 108.2100n 0.000772 108.2200n 0.000763 108.2300n 0.000753 108.2400n 0.000743 108.2500n 0.000732 108.2600n 0.000720 108.2700n 0.000708 108.2800n 0.000696 108.2900n 0.000683
+ 108.3000n 0.000669 108.3100n 0.000655 108.3200n 0.000640 108.3300n 0.000625 108.3400n 0.000609 108.3500n 0.000593 108.3600n 0.000577 108.3700n 0.000560 108.3800n 0.000542 108.3900n 0.000524 108.4000n 0.000505 108.4100n 0.000487 108.4200n 0.000467 108.4300n 0.000447 108.4400n 0.000427
+ 108.4500n 0.000407 108.4600n 0.000386 108.4700n 0.000365 108.4800n 0.000343 108.4900n 0.000321 108.5000n 0.000299 108.5100n 0.000276 108.5200n 0.000254 108.5300n 0.000231 108.5400n 0.000207 108.5500n 0.000184 108.5600n 0.000160 108.5700n 0.000136 108.5800n 0.000112 108.5900n 0.000088
+ 108.6000n 0.000063 108.6100n 0.000039 108.6200n 0.000014 108.6300n -0.000011 108.6400n -0.000036 108.6500n -0.000061 108.6600n -0.000086 108.6700n -0.000111 108.6800n -0.000136 108.6900n -0.000161 108.7000n -0.000186 108.7100n -0.000211 108.7200n -0.000235 108.7300n -0.000260 108.7400n -0.000285
+ 108.7500n -0.000309 108.7600n -0.000334 108.7700n -0.000358 108.7800n -0.000382 108.7900n -0.000406 108.8000n -0.000430 108.8100n -0.000453 108.8200n -0.000476 108.8300n -0.000499 108.8400n -0.000522 108.8500n -0.000544 108.8600n -0.000566 108.8700n -0.000588 108.8800n -0.000610 108.8900n -0.000631
+ 108.9000n -0.000651 108.9100n -0.000672 108.9200n -0.000691 108.9300n -0.000711 108.9400n -0.000730 108.9500n -0.000748 108.9600n -0.000766 108.9700n -0.000784 108.9800n -0.000801 108.9900n -0.000818 109.0000n -0.000834 109.0100n -0.000849 109.0200n -0.000864 109.0300n -0.000879 109.0400n -0.000892
+ 109.0500n -0.000906 109.0600n -0.000918 109.0700n -0.000931 109.0800n -0.000942 109.0900n -0.000953 109.1000n -0.000963 109.1100n -0.000973 109.1200n -0.000982 109.1300n -0.000990 109.1400n -0.000998 109.1500n -0.001005 109.1600n -0.001011 109.1700n -0.001017 109.1800n -0.001022 109.1900n -0.001026
+ 109.2000n -0.001030 109.2100n -0.001033 109.2200n -0.001035 109.2300n -0.001037 109.2400n -0.001038 109.2500n -0.001038 109.2600n -0.001038 109.2700n -0.001037 109.2800n -0.001035 109.2900n -0.001033 109.3000n -0.001029 109.3100n -0.001026 109.3200n -0.001021 109.3300n -0.001016 109.3400n -0.001010
+ 109.3500n -0.001004 109.3600n -0.000997 109.3700n -0.000989 109.3800n -0.000980 109.3900n -0.000971 109.4000n -0.000962 109.4100n -0.000951 109.4200n -0.000941 109.4300n -0.000929 109.4400n -0.000917 109.4500n -0.000904 109.4600n -0.000891 109.4700n -0.000877 109.4800n -0.000863 109.4900n -0.000848
+ 109.5000n -0.000833 109.5100n -0.000817 109.5200n -0.000800 109.5300n -0.000784 109.5400n -0.000766 109.5500n -0.000749 109.5600n -0.000730 109.5700n -0.000712 109.5800n -0.000693 109.5900n -0.000673 109.6000n -0.000653 109.6100n -0.000633 109.6200n -0.000613 109.6300n -0.000592 109.6400n -0.000571
+ 109.6500n -0.000550 109.6600n -0.000528 109.6700n -0.000506 109.6800n -0.000484 109.6900n -0.000462 109.7000n -0.000439 109.7100n -0.000417 109.7200n -0.000394 109.7300n -0.000371 109.7400n -0.000348 109.7500n -0.000325 109.7600n -0.000301 109.7700n -0.000278 109.7800n -0.000255 109.7900n -0.000232
+ 109.8000n -0.000208 109.8100n -0.000185 109.8200n -0.000162 109.8300n -0.000139 109.8400n -0.000116 109.8500n -0.000093 109.8600n -0.000070 109.8700n -0.000048 109.8800n -0.000025 109.8900n -0.000003 109.9000n 0.000019 109.9100n 0.000041 109.9200n 0.000062 109.9300n 0.000084 109.9400n 0.000104
+ 109.9500n 0.000125 109.9600n 0.000145 109.9700n 0.000165 109.9800n 0.000185 109.9900n 0.000204 110.0000n 0.000223 110.0100n 0.000241 110.0200n 0.000259 110.0300n 0.000276 110.0400n 0.000293 110.0500n 0.000310 110.0600n 0.000325 110.0700n 0.000341 110.0800n 0.000356 110.0900n 0.000370
+ 110.1000n 0.000384 110.1100n 0.000397 110.1200n 0.000409 110.1300n 0.000421 110.1400n 0.000432 110.1500n 0.000443 110.1600n 0.000453 110.1700n 0.000462 110.1800n 0.000471 110.1900n 0.000479 110.2000n 0.000486 110.2100n 0.000493 110.2200n 0.000499 110.2300n 0.000504 110.2400n 0.000508
+ 110.2500n 0.000512 110.2600n 0.000515 110.2700n 0.000517 110.2800n 0.000519 110.2900n 0.000519 110.3000n 0.000519 110.3100n 0.000518 110.3200n 0.000517 110.3300n 0.000514 110.3400n 0.000511 110.3500n 0.000507 110.3600n 0.000503 110.3700n 0.000497 110.3800n 0.000491 110.3900n 0.000484
+ 110.4000n 0.000476 110.4100n 0.000468 110.4200n 0.000458 110.4300n 0.000448 110.4400n 0.000438 110.4500n 0.000426 110.4600n 0.000414 110.4700n 0.000401 110.4800n 0.000387 110.4900n 0.000373 110.5000n 0.000357 110.5100n 0.000342 110.5200n 0.000325 110.5300n 0.000308 110.5400n 0.000290
+ 110.5500n 0.000271 110.5600n 0.000252 110.5700n 0.000232 110.5800n 0.000212 110.5900n 0.000191 110.6000n 0.000169 110.6100n 0.000147 110.6200n 0.000124 110.6300n 0.000100 110.6400n 0.000076 110.6500n 0.000052 110.6600n 0.000027 110.6700n 0.000001 110.6800n -0.000024 110.6900n -0.000051
+ 110.7000n -0.000078 110.7100n -0.000105 110.7200n -0.000132 110.7300n -0.000160 110.7400n -0.000189 110.7500n -0.000217 110.7600n -0.000246 110.7700n -0.000276 110.7800n -0.000305 110.7900n -0.000335 110.8000n -0.000365 110.8100n -0.000395 110.8200n -0.000426 110.8300n -0.000456 110.8400n -0.000487
+ 110.8500n -0.000518 110.8600n -0.000549 110.8700n -0.000580 110.8800n -0.000611 110.8900n -0.000642 110.9000n -0.000673 110.9100n -0.000704 110.9200n -0.000734 110.9300n -0.000765 110.9400n -0.000796 110.9500n -0.000827 110.9600n -0.000857 110.9700n -0.000887 110.9800n -0.000918 110.9900n -0.000947
+ 111.0000n -0.000977 111.0100n -0.001006 111.0200n -0.001035 111.0300n -0.001064 111.0400n -0.001093 111.0500n -0.001121 111.0600n -0.001148 111.0700n -0.001176 111.0800n -0.001202 111.0900n -0.001229 111.1000n -0.001255 111.1100n -0.001280 111.1200n -0.001305 111.1300n -0.001329 111.1400n -0.001353
+ 111.1500n -0.001376 111.1600n -0.001399 111.1700n -0.001421 111.1800n -0.001442 111.1900n -0.001463 111.2000n -0.001483 111.2100n -0.001502 111.2200n -0.001521 111.2300n -0.001539 111.2400n -0.001556 111.2500n -0.001572 111.2600n -0.001588 111.2700n -0.001602 111.2800n -0.001616 111.2900n -0.001629
+ 111.3000n -0.001642 111.3100n -0.001653 111.3200n -0.001664 111.3300n -0.001673 111.3400n -0.001682 111.3500n -0.001690 111.3600n -0.001697 111.3700n -0.001703 111.3800n -0.001708 111.3900n -0.001713 111.4000n -0.001716 111.4100n -0.001718 111.4200n -0.001720 111.4300n -0.001720 111.4400n -0.001719
+ 111.4500n -0.001718 111.4600n -0.001715 111.4700n -0.001712 111.4800n -0.001707 111.4900n -0.001702 111.5000n -0.001695 111.5100n -0.001688 111.5200n -0.001679 111.5300n -0.001670 111.5400n -0.001660 111.5500n -0.001648 111.5600n -0.001636 111.5700n -0.001623 111.5800n -0.001608 111.5900n -0.001593
+ 111.6000n -0.001577 111.6100n -0.001560 111.6200n -0.001541 111.6300n -0.001522 111.6400n -0.001502 111.6500n -0.001481 111.6600n -0.001460 111.6700n -0.001437 111.6800n -0.001413 111.6900n -0.001389 111.7000n -0.001363 111.7100n -0.001337 111.7200n -0.001310 111.7300n -0.001282 111.7400n -0.001254
+ 111.7500n -0.001224 111.7600n -0.001194 111.7700n -0.001163 111.7800n -0.001131 111.7900n -0.001098 111.8000n -0.001065 111.8100n -0.001031 111.8200n -0.000997 111.8300n -0.000961 111.8400n -0.000926 111.8500n -0.000889 111.8600n -0.000852 111.8700n -0.000814 111.8800n -0.000776 111.8900n -0.000737
+ 111.9000n -0.000698 111.9100n -0.000658 111.9200n -0.000618 111.9300n -0.000578 111.9400n -0.000537 111.9500n -0.000495 111.9600n -0.000453 111.9700n -0.000411 111.9800n -0.000369 111.9900n -0.000326 112.0000n -0.000283 112.0100n -0.000240 112.0200n -0.000196 112.0300n -0.000153 112.0400n -0.000109
+ 112.0500n -0.000065 112.0600n -0.000021 112.0700n 0.000023 112.0800n 0.000067 112.0900n 0.000111 112.1000n 0.000156 112.1100n 0.000200 112.1200n 0.000244 112.1300n 0.000288 112.1400n 0.000332 112.1500n 0.000376 112.1600n 0.000419 112.1700n 0.000463 112.1800n 0.000506 112.1900n 0.000549
+ 112.2000n 0.000592 112.2100n 0.000634 112.2200n 0.000677 112.2300n 0.000718 112.2400n 0.000760 112.2500n 0.000801 112.2600n 0.000842 112.2700n 0.000882 112.2800n 0.000922 112.2900n 0.000961 112.3000n 0.001000 112.3100n 0.001038 112.3200n 0.001076 112.3300n 0.001113 112.3400n 0.001149
+ 112.3500n 0.001185 112.3600n 0.001220 112.3700n 0.001255 112.3800n 0.001289 112.3900n 0.001322 112.4000n 0.001354 112.4100n 0.001386 112.4200n 0.001417 112.4300n 0.001447 112.4400n 0.001477 112.4500n 0.001505 112.4600n 0.001533 112.4700n 0.001560 112.4800n 0.001586 112.4900n 0.001611
+ 112.5000n 0.001636 112.5100n 0.001659 112.5200n 0.001682 112.5300n 0.001703 112.5400n 0.001724 112.5500n 0.001743 112.5600n 0.001762 112.5700n 0.001780 112.5800n 0.001797 112.5900n 0.001812 112.6000n 0.001827 112.6100n 0.001841 112.6200n 0.001854 112.6300n 0.001866 112.6400n 0.001876
+ 112.6500n 0.001886 112.6600n 0.001895 112.6700n 0.001903 112.6800n 0.001909 112.6900n 0.001915 112.7000n 0.001919 112.7100n 0.001923 112.7200n 0.001925 112.7300n 0.001927 112.7400n 0.001927 112.7500n 0.001927 112.7600n 0.001925 112.7700n 0.001923 112.7800n 0.001919 112.7900n 0.001914
+ 112.8000n 0.001909 112.8100n 0.001902 112.8200n 0.001894 112.8300n 0.001886 112.8400n 0.001876 112.8500n 0.001866 112.8600n 0.001854 112.8700n 0.001841 112.8800n 0.001828 112.8900n 0.001814 112.9000n 0.001798 112.9100n 0.001782 112.9200n 0.001765 112.9300n 0.001747 112.9400n 0.001728
+ 112.9500n 0.001709 112.9600n 0.001688 112.9700n 0.001667 112.9800n 0.001645 112.9900n 0.001622 113.0000n 0.001598 113.0100n 0.001574 113.0200n 0.001549 113.0300n 0.001523 113.0400n 0.001496 113.0500n 0.001469 113.0600n 0.001441 113.0700n 0.001413 113.0800n 0.001383 113.0900n 0.001354
+ 113.1000n 0.001323 113.1100n 0.001293 113.1200n 0.001261 113.1300n 0.001229 113.1400n 0.001197 113.1500n 0.001164 113.1600n 0.001131 113.1700n 0.001097 113.1800n 0.001063 113.1900n 0.001028 113.2000n 0.000994 113.2100n 0.000958 113.2200n 0.000923 113.2300n 0.000887 113.2400n 0.000851
+ 113.2500n 0.000815 113.2600n 0.000778 113.2700n 0.000742 113.2800n 0.000705 113.2900n 0.000668 113.3000n 0.000631 113.3100n 0.000594 113.3200n 0.000557 113.3300n 0.000519 113.3400n 0.000482 113.3500n 0.000445 113.3600n 0.000408 113.3700n 0.000371 113.3800n 0.000333 113.3900n 0.000297
+ 113.4000n 0.000260 113.4100n 0.000223 113.4200n 0.000186 113.4300n 0.000150 113.4400n 0.000114 113.4500n 0.000078 113.4600n 0.000042 113.4700n 0.000007 113.4800n -0.000028 113.4900n -0.000063 113.5000n -0.000097 113.5100n -0.000131 113.5200n -0.000165 113.5300n -0.000198 113.5400n -0.000231
+ 113.5500n -0.000263 113.5600n -0.000295 113.5700n -0.000327 113.5800n -0.000358 113.5900n -0.000388 113.6000n -0.000418 113.6100n -0.000448 113.6200n -0.000477 113.6300n -0.000505 113.6400n -0.000533 113.6500n -0.000560 113.6600n -0.000586 113.6700n -0.000612 113.6800n -0.000637 113.6900n -0.000662
+ 113.7000n -0.000686 113.7100n -0.000709 113.7200n -0.000732 113.7300n -0.000753 113.7400n -0.000775 113.7500n -0.000795 113.7600n -0.000815 113.7700n -0.000834 113.7800n -0.000852 113.7900n -0.000870 113.8000n -0.000886 113.8100n -0.000902 113.8200n -0.000918 113.8300n -0.000932 113.8400n -0.000946
+ 113.8500n -0.000959 113.8600n -0.000971 113.8700n -0.000982 113.8800n -0.000993 113.8900n -0.001003 113.9000n -0.001012 113.9100n -0.001020 113.9200n -0.001028 113.9300n -0.001035 113.9400n -0.001041 113.9500n -0.001046 113.9600n -0.001050 113.9700n -0.001054 113.9800n -0.001057 113.9900n -0.001059
+ 114.0000n -0.001061 114.0100n -0.001061 114.0200n -0.001061 114.0300n -0.001060 114.0400n -0.001059 114.0500n -0.001057 114.0600n -0.001054 114.0700n -0.001050 114.0800n -0.001046 114.0900n -0.001041 114.1000n -0.001035 114.1100n -0.001029 114.1200n -0.001022 114.1300n -0.001014 114.1400n -0.001006
+ 114.1500n -0.000997 114.1600n -0.000987 114.1700n -0.000977 114.1800n -0.000967 114.1900n -0.000956 114.2000n -0.000944 114.2100n -0.000932 114.2200n -0.000919 114.2300n -0.000905 114.2400n -0.000892 114.2500n -0.000877 114.2600n -0.000863 114.2700n -0.000847 114.2800n -0.000832 114.2900n -0.000816
+ 114.3000n -0.000799 114.3100n -0.000783 114.3200n -0.000765 114.3300n -0.000748 114.3400n -0.000730 114.3500n -0.000712 114.3600n -0.000694 114.3700n -0.000675 114.3800n -0.000656 114.3900n -0.000637 114.4000n -0.000617 114.4100n -0.000598 114.4200n -0.000578 114.4300n -0.000558 114.4400n -0.000538
+ 114.4500n -0.000518 114.4600n -0.000497 114.4700n -0.000477 114.4800n -0.000456 114.4900n -0.000436 114.5000n -0.000415 114.5100n -0.000394 114.5200n -0.000374 114.5300n -0.000353 114.5400n -0.000333 114.5500n -0.000312 114.5600n -0.000291 114.5700n -0.000271 114.5800n -0.000251 114.5900n -0.000230
+ 114.6000n -0.000210 114.6100n -0.000190 114.6200n -0.000170 114.6300n -0.000151 114.6400n -0.000131 114.6500n -0.000112 114.6600n -0.000093 114.6700n -0.000074 114.6800n -0.000056 114.6900n -0.000038 114.7000n -0.000020 114.7100n -0.000002 114.7200n 0.000016 114.7300n 0.000033 114.7400n 0.000049
+ 114.7500n 0.000066 114.7600n 0.000082 114.7700n 0.000098 114.7800n 0.000113 114.7900n 0.000128 114.8000n 0.000142 114.8100n 0.000157 114.8200n 0.000170 114.8300n 0.000184 114.8400n 0.000197 114.8500n 0.000209 114.8600n 0.000221 114.8700n 0.000233 114.8800n 0.000244 114.8900n 0.000254
+ 114.9000n 0.000264 114.9100n 0.000274 114.9200n 0.000283 114.9300n 0.000292 114.9400n 0.000300 114.9500n 0.000308 114.9600n 0.000315 114.9700n 0.000322 114.9800n 0.000328 114.9900n 0.000334 115.0000n 0.000339 115.0100n 0.000343 115.0200n 0.000348 115.0300n 0.000351 115.0400n 0.000354
+ 115.0500n 0.000357 115.0600n 0.000359 115.0700n 0.000361 115.0800n 0.000362 115.0900n 0.000362 115.1000n 0.000362 115.1100n 0.000362 115.1200n 0.000361 115.1300n 0.000359 115.1400n 0.000358 115.1500n 0.000355 115.1600n 0.000352 115.1700n 0.000349 115.1800n 0.000345 115.1900n 0.000341
+ 115.2000n 0.000336 115.2100n 0.000331 115.2200n 0.000325 115.2300n 0.000319 115.2400n 0.000312 115.2500n 0.000305 115.2600n 0.000298 115.2700n 0.000290 115.2800n 0.000282 115.2900n 0.000273 115.3000n 0.000264 115.3100n 0.000255 115.3200n 0.000245 115.3300n 0.000235 115.3400n 0.000225
+ 115.3500n 0.000214 115.3600n 0.000203 115.3700n 0.000191 115.3800n 0.000180 115.3900n 0.000168 115.4000n 0.000156 115.4100n 0.000143 115.4200n 0.000130 115.4300n 0.000117 115.4400n 0.000104 115.4500n 0.000090 115.4600n 0.000077 115.4700n 0.000063 115.4800n 0.000049 115.4900n 0.000035
+ 115.5000n 0.000020 115.5100n 0.000006 115.5200n -0.000009 115.5300n -0.000024 115.5400n -0.000039 115.5500n -0.000054 115.5600n -0.000069 115.5700n -0.000084 115.5800n -0.000099 115.5900n -0.000114 115.6000n -0.000130 115.6100n -0.000145 115.6200n -0.000160 115.6300n -0.000176 115.6400n -0.000191
+ 115.6500n -0.000206 115.6600n -0.000222 115.6700n -0.000237 115.6800n -0.000252 115.6900n -0.000267 115.7000n -0.000282 115.7100n -0.000297 115.7200n -0.000312 115.7300n -0.000326 115.7400n -0.000341 115.7500n -0.000355 115.7600n -0.000370 115.7700n -0.000384 115.7800n -0.000398 115.7900n -0.000412
+ 115.8000n -0.000425 115.8100n -0.000438 115.8200n -0.000452 115.8300n -0.000465 115.8400n -0.000477 115.8500n -0.000490 115.8600n -0.000502 115.8700n -0.000514 115.8800n -0.000526 115.8900n -0.000537 115.9000n -0.000549 115.9100n -0.000560 115.9200n -0.000570 115.9300n -0.000581 115.9400n -0.000591
+ 115.9500n -0.000600 115.9600n -0.000610 115.9700n -0.000619 115.9800n -0.000628 115.9900n -0.000637 116.0000n -0.000645 116.0100n -0.000653 116.0200n -0.000660 116.0300n -0.000667 116.0400n -0.000674 116.0500n -0.000681 116.0600n -0.000687 116.0700n -0.000693 116.0800n -0.000698 116.0900n -0.000704
+ 116.1000n -0.000708 116.1100n -0.000713 116.1200n -0.000717 116.1300n -0.000721 116.1400n -0.000724 116.1500n -0.000727 116.1600n -0.000730 116.1700n -0.000732 116.1800n -0.000734 116.1900n -0.000736 116.2000n -0.000738 116.2100n -0.000739 116.2200n -0.000739 116.2300n -0.000740 116.2400n -0.000740
+ 116.2500n -0.000739 116.2600n -0.000739 116.2700n -0.000738 116.2800n -0.000736 116.2900n -0.000735 116.3000n -0.000733 116.3100n -0.000731 116.3200n -0.000728 116.3300n -0.000725 116.3400n -0.000722 116.3500n -0.000719 116.3600n -0.000715 116.3700n -0.000711 116.3800n -0.000707 116.3900n -0.000702
+ 116.4000n -0.000698 116.4100n -0.000693 116.4200n -0.000687 116.4300n -0.000682 116.4400n -0.000676 116.4500n -0.000670 116.4600n -0.000664 116.4700n -0.000658 116.4800n -0.000651 116.4900n -0.000645 116.5000n -0.000638 116.5100n -0.000631 116.5200n -0.000623 116.5300n -0.000616 116.5400n -0.000608
+ 116.5500n -0.000601 116.5600n -0.000593 116.5700n -0.000585 116.5800n -0.000577 116.5900n -0.000568 116.6000n -0.000560 116.6100n -0.000552 116.6200n -0.000543 116.6300n -0.000535 116.6400n -0.000526 116.6500n -0.000517 116.6600n -0.000508 116.6700n -0.000499 116.6800n -0.000491 116.6900n -0.000482
+ 116.7000n -0.000473 116.7100n -0.000464 116.7200n -0.000455 116.7300n -0.000446 116.7400n -0.000437 116.7500n -0.000428 116.7600n -0.000419 116.7700n -0.000410 116.7800n -0.000401 116.7900n -0.000392 116.8000n -0.000383 116.8100n -0.000374 116.8200n -0.000366 116.8300n -0.000357 116.8400n -0.000348
+ 116.8500n -0.000340 116.8600n -0.000331 116.8700n -0.000323 116.8800n -0.000315 116.8900n -0.000307 116.9000n -0.000299 116.9100n -0.000291 116.9200n -0.000283 116.9300n -0.000275 116.9400n -0.000268 116.9500n -0.000260 116.9600n -0.000253 116.9700n -0.000246 116.9800n -0.000239 116.9900n -0.000232
+ 117.0000n -0.000225 117.0100n -0.000218 117.0200n -0.000212 117.0300n -0.000206 117.0400n -0.000200 117.0500n -0.000194 117.0600n -0.000188 117.0700n -0.000182 117.0800n -0.000177 117.0900n -0.000171 117.1000n -0.000166 117.1100n -0.000161 117.1200n -0.000157 117.1300n -0.000152 117.1400n -0.000147
+ 117.1500n -0.000143 117.1600n -0.000139 117.1700n -0.000135 117.1800n -0.000131 117.1900n -0.000128 117.2000n -0.000124 117.2100n -0.000121 117.2200n -0.000118 117.2300n -0.000115 117.2400n -0.000113 117.2500n -0.000110 117.2600n -0.000108 117.2700n -0.000105 117.2800n -0.000103 117.2900n -0.000102
+ 117.3000n -0.000100 117.3100n -0.000098 117.3200n -0.000097 117.3300n -0.000095 117.3400n -0.000094 117.3500n -0.000093 117.3600n -0.000092 117.3700n -0.000092 117.3800n -0.000091 117.3900n -0.000091 117.4000n -0.000090 117.4100n -0.000090 117.4200n -0.000090 117.4300n -0.000090 117.4400n -0.000090
+ 117.4500n -0.000090 117.4600n -0.000091 117.4700n -0.000091 117.4800n -0.000092 117.4900n -0.000092 117.5000n -0.000093 117.5100n -0.000094 117.5200n -0.000095 117.5300n -0.000096 117.5400n -0.000097 117.5500n -0.000098 117.5600n -0.000099 117.5700n -0.000100 117.5800n -0.000101 117.5900n -0.000102
+ 117.6000n -0.000104 117.6100n -0.000105 117.6200n -0.000106 117.6300n -0.000108 117.6400n -0.000109 117.6500n -0.000110 117.6600n -0.000112 117.6700n -0.000113 117.6800n -0.000115 117.6900n -0.000116 117.7000n -0.000117 117.7100n -0.000119 117.7200n -0.000120 117.7300n -0.000122 117.7400n -0.000123
+ 117.7500n -0.000124 117.7600n -0.000125 117.7700n -0.000127 117.7800n -0.000128 117.7900n -0.000129 117.8000n -0.000130 117.8100n -0.000131 117.8200n -0.000132 117.8300n -0.000133 117.8400n -0.000134 117.8500n -0.000135 117.8600n -0.000135 117.8700n -0.000136 117.8800n -0.000137 117.8900n -0.000137
+ 117.9000n -0.000137 117.9100n -0.000138 117.9200n -0.000138 117.9300n -0.000138 117.9400n -0.000138 117.9500n -0.000138 117.9600n -0.000138 117.9700n -0.000138 117.9800n -0.000138 117.9900n -0.000138 118.0000n -0.000137 118.0100n -0.000137 118.0200n -0.000136 118.0300n -0.000136 118.0400n -0.000135
+ 118.0500n -0.000134 118.0600n -0.000133 118.0700n -0.000132 118.0800n -0.000131 118.0900n -0.000130 118.1000n -0.000129 118.1100n -0.000127 118.1200n -0.000126 118.1300n -0.000124 118.1400n -0.000123 118.1500n -0.000121 118.1600n -0.000119 118.1700n -0.000118 118.1800n -0.000116 118.1900n -0.000114
+ 118.2000n -0.000112 118.2100n -0.000110 118.2200n -0.000108 118.2300n -0.000105 118.2400n -0.000103 118.2500n -0.000101 118.2600n -0.000099 118.2700n -0.000096 118.2800n -0.000094 118.2900n -0.000092 118.3000n -0.000089 118.3100n -0.000087 118.3200n -0.000084 118.3300n -0.000082 118.3400n -0.000079
+ 118.3500n -0.000077 118.3600n -0.000074 118.3700n -0.000072 118.3800n -0.000070 118.3900n -0.000067 118.4000n -0.000065 118.4100n -0.000062 118.4200n -0.000060 118.4300n -0.000058 118.4400n -0.000055 118.4500n -0.000053 118.4600n -0.000051 118.4700n -0.000049 118.4800n -0.000047 118.4900n -0.000045
+ 118.5000n -0.000043 118.5100n -0.000042 118.5200n -0.000040 118.5300n -0.000038 118.5400n -0.000037 118.5500n -0.000036 118.5600n -0.000035 118.5700n -0.000033 118.5800n -0.000033 118.5900n -0.000032 118.6000n -0.000031 118.6100n -0.000031 118.6200n -0.000030 118.6300n -0.000030 118.6400n -0.000030
+ 118.6500n -0.000030 118.6600n -0.000030 118.6700n -0.000031 118.6800n -0.000032 118.6900n -0.000033 118.7000n -0.000034 118.7100n -0.000035 118.7200n -0.000036 118.7300n -0.000038 118.7400n -0.000040 118.7500n -0.000042 118.7600n -0.000045 118.7700n -0.000047 118.7800n -0.000050 118.7900n -0.000053
+ 118.8000n -0.000057 118.8100n -0.000060 118.8200n -0.000064 118.8300n -0.000068 118.8400n -0.000073 118.8500n -0.000078 118.8600n -0.000083 118.8700n -0.000088 118.8800n -0.000093 118.8900n -0.000099 118.9000n -0.000105 118.9100n -0.000112 118.9200n -0.000118 118.9300n -0.000125 118.9400n -0.000132
+ 118.9500n -0.000140 118.9600n -0.000148 118.9700n -0.000156 118.9800n -0.000165 118.9900n -0.000173 119.0000n -0.000182 119.0100n -0.000192 119.0200n -0.000201 119.0300n -0.000211 119.0400n -0.000222 119.0500n -0.000232 119.0600n -0.000243 119.0700n -0.000254 119.0800n -0.000266 119.0900n -0.000278
+ 119.1000n -0.000290 119.1100n -0.000302 119.1200n -0.000315 119.1300n -0.000328 119.1400n -0.000342 119.1500n -0.000355 119.1600n -0.000369 119.1700n -0.000383 119.1800n -0.000398 119.1900n -0.000413 119.2000n -0.000428 119.2100n -0.000443 119.2200n -0.000459 119.2300n -0.000475 119.2400n -0.000491
+ 119.2500n -0.000507 119.2600n -0.000524 119.2700n -0.000541 119.2800n -0.000558 119.2900n -0.000576 119.3000n -0.000594 119.3100n -0.000612 119.3200n -0.000630 119.3300n -0.000648 119.3400n -0.000667 119.3500n -0.000686 119.3600n -0.000705 119.3700n -0.000724 119.3800n -0.000744 119.3900n -0.000763
+ 119.4000n -0.000783 119.4100n -0.000803 119.4200n -0.000824 119.4300n -0.000844 119.4400n -0.000865 119.4500n -0.000885 119.4600n -0.000906 119.4700n -0.000927 119.4800n -0.000948 119.4900n -0.000970 119.5000n -0.000991 119.5100n -0.001012 119.5200n -0.001034 119.5300n -0.001056 119.5400n -0.001078
+ 119.5500n -0.001099 119.5600n -0.001121 119.5700n -0.001143 119.5800n -0.001165 119.5900n -0.001187 119.6000n -0.001210 119.6100n -0.001232 119.6200n -0.001254 119.6300n -0.001276 119.6400n -0.001298 119.6500n -0.001321 119.6600n -0.001343 119.6700n -0.001365 119.6800n -0.001387 119.6900n -0.001409
+ 119.7000n -0.001431 119.7100n -0.001453 119.7200n -0.001475 119.7300n -0.001497 119.7400n -0.001519 119.7500n -0.001541 119.7600n -0.001562 119.7700n -0.001584 119.7800n -0.001605 119.7900n -0.001626 119.8000n -0.001648 119.8100n -0.001669 119.8200n -0.001689 119.8300n -0.001710 119.8400n -0.001731
+ 119.8500n -0.001751 119.8600n -0.001771 119.8700n -0.001791 119.8800n -0.001811 119.8900n -0.001831 119.9000n -0.001850 119.9100n -0.001869 119.9200n -0.001888 119.9300n -0.001907 119.9400n -0.001926 119.9500n -0.001944 119.9600n -0.001962 119.9700n -0.001980 119.9800n -0.001997 119.9900n -0.002015
+ 120.0000n -0.002032 120.0100n -0.002048 120.0200n -0.002065 120.0300n -0.002081 120.0400n -0.002097 120.0500n -0.002112 120.0600n -0.002127 120.0700n -0.002142 120.0800n -0.002157 120.0900n -0.002171 120.1000n -0.002185 120.1100n -0.002199 120.1200n -0.002212 120.1300n -0.002225 120.1400n -0.002237
+ 120.1500n -0.002249 120.1600n -0.002261 120.1700n -0.002273 120.1800n -0.002284 120.1900n -0.002294 120.2000n -0.002305 120.2100n -0.002315 120.2200n -0.002324 120.2300n -0.002334 120.2400n -0.002342 120.2500n -0.002351 120.2600n -0.002359 120.2700n -0.002367 120.2800n -0.002374 120.2900n -0.002381
+ 120.3000n -0.002387 120.3100n -0.002393 120.3200n -0.002399 120.3300n -0.002404 120.3400n -0.002409 120.3500n -0.002413 120.3600n -0.002417 120.3700n -0.002421 120.3800n -0.002424 120.3900n -0.002427 120.4000n -0.002429 120.4100n -0.002431 120.4200n -0.002433 120.4300n -0.002434 120.4400n -0.002435
+ 120.4500n -0.002435 120.4600n -0.002435 120.4700n -0.002434 120.4800n -0.002433 120.4900n -0.002432 120.5000n -0.002430 120.5100n -0.002428 120.5200n -0.002426 120.5300n -0.002423 120.5400n -0.002419 120.5500n -0.002415 120.5600n -0.002411 120.5700n -0.002406 120.5800n -0.002401 120.5900n -0.002396
+ 120.6000n -0.002390 120.6100n -0.002384 120.6200n -0.002377 120.6300n -0.002370 120.6400n -0.002363 120.6500n -0.002355 120.6600n -0.002347 120.6700n -0.002338 120.6800n -0.002329 120.6900n -0.002320 120.7000n -0.002310 120.7100n -0.002300 120.7200n -0.002290 120.7300n -0.002279 120.7400n -0.002268
+ 120.7500n -0.002256 120.7600n -0.002244 120.7700n -0.002232 120.7800n -0.002219 120.7900n -0.002206 120.8000n -0.002193 120.8100n -0.002179 120.8200n -0.002165 120.8300n -0.002151 120.8400n -0.002136 120.8500n -0.002121 120.8600n -0.002106 120.8700n -0.002090 120.8800n -0.002074 120.8900n -0.002058
+ 120.9000n -0.002041 120.9100n -0.002024 120.9200n -0.002007 120.9300n -0.001989 120.9400n -0.001972 120.9500n -0.001953 120.9600n -0.001935 120.9700n -0.001916 120.9800n -0.001897 120.9900n -0.001878 121.0000n -0.001859 121.0100n -0.001839 121.0200n -0.001819 121.0300n -0.001798 121.0400n -0.001778
+ 121.0500n -0.001757 121.0600n -0.001736 121.0700n -0.001714 121.0800n -0.001693 121.0900n -0.001671 121.1000n -0.001649 121.1100n -0.001626 121.1200n -0.001604 121.1300n -0.001581 121.1400n -0.001558 121.1500n -0.001535 121.1600n -0.001512 121.1700n -0.001488 121.1800n -0.001464 121.1900n -0.001440
+ 121.2000n -0.001416 121.2100n -0.001392 121.2200n -0.001367 121.2300n -0.001343 121.2400n -0.001318 121.2500n -0.001293 121.2600n -0.001267 121.2700n -0.001242 121.2800n -0.001216 121.2900n -0.001191 121.3000n -0.001165 121.3100n -0.001139 121.3200n -0.001113 121.3300n -0.001087 121.3400n -0.001060
+ 121.3500n -0.001034 121.3600n -0.001007 121.3700n -0.000981 121.3800n -0.000954 121.3900n -0.000927 121.4000n -0.000900 121.4100n -0.000873 121.4200n -0.000846 121.4300n -0.000819 121.4400n -0.000791 121.4500n -0.000764 121.4600n -0.000736 121.4700n -0.000709 121.4800n -0.000681 121.4900n -0.000654
+ 121.5000n -0.000626 121.5100n -0.000598 121.5200n -0.000571 121.5300n -0.000543 121.5400n -0.000515 121.5500n -0.000487 121.5600n -0.000460 121.5700n -0.000432 121.5800n -0.000404 121.5900n -0.000376 121.6000n -0.000349 121.6100n -0.000321 121.6200n -0.000293 121.6300n -0.000266 121.6400n -0.000238
+ 121.6500n -0.000210 121.6600n -0.000183 121.6700n -0.000155 121.6800n -0.000128 121.6900n -0.000101 121.7000n -0.000073 121.7100n -0.000046 121.7200n -0.000019 121.7300n 0.000008 121.7400n 0.000035 121.7500n 0.000062 121.7600n 0.000088 121.7700n 0.000115 121.7800n 0.000141 121.7900n 0.000167
+ 121.8000n 0.000194 121.8100n 0.000220 121.8200n 0.000245 121.8300n 0.000271 121.8400n 0.000297 121.8500n 0.000322 121.8600n 0.000347 121.8700n 0.000372 121.8800n 0.000397 121.8900n 0.000421 121.9000n 0.000446 121.9100n 0.000470 121.9200n 0.000494 121.9300n 0.000517 121.9400n 0.000541
+ 121.9500n 0.000564 121.9600n 0.000587 121.9700n 0.000609 121.9800n 0.000632 121.9900n 0.000654 122.0000n 0.000676 122.0100n 0.000697 122.0200n 0.000719 122.0300n 0.000740 122.0400n 0.000760 122.0500n 0.000781 122.0600n 0.000801 122.0700n 0.000820 122.0800n 0.000840 122.0900n 0.000859
+ 122.1000n 0.000877 122.1100n 0.000896 122.1200n 0.000914 122.1300n 0.000931 122.1400n 0.000949 122.1500n 0.000965 122.1600n 0.000982 122.1700n 0.000998 122.1800n 0.001014 122.1900n 0.001029 122.2000n 0.001044 122.2100n 0.001058 122.2200n 0.001072 122.2300n 0.001086 122.2400n 0.001099
+ 122.2500n 0.001112 122.2600n 0.001124 122.2700n 0.001136 122.2800n 0.001148 122.2900n 0.001159 122.3000n 0.001169 122.3100n 0.001179 122.3200n 0.001189 122.3300n 0.001198 122.3400n 0.001207 122.3500n 0.001215 122.3600n 0.001223 122.3700n 0.001230 122.3800n 0.001237 122.3900n 0.001243
+ 122.4000n 0.001249 122.4100n 0.001254 122.4200n 0.001259 122.4300n 0.001263 122.4400n 0.001267 122.4500n 0.001270 122.4600n 0.001273 122.4700n 0.001275 122.4800n 0.001277 122.4900n 0.001278 122.5000n 0.001279 122.5100n 0.001279 122.5200n 0.001279 122.5300n 0.001278 122.5400n 0.001277
+ 122.5500n 0.001275 122.5600n 0.001273 122.5700n 0.001270 122.5800n 0.001267 122.5900n 0.001263 122.6000n 0.001259 122.6100n 0.001254 122.6200n 0.001249 122.6300n 0.001243 122.6400n 0.001237 122.6500n 0.001230 122.6600n 0.001223 122.6700n 0.001215 122.6800n 0.001207 122.6900n 0.001198
+ 122.7000n 0.001189 122.7100n 0.001179 122.7200n 0.001169 122.7300n 0.001158 122.7400n 0.001147 122.7500n 0.001136 122.7600n 0.001124 122.7700n 0.001112 122.7800n 0.001099 122.7900n 0.001086 122.8000n 0.001072 122.8100n 0.001058 122.8200n 0.001044 122.8300n 0.001029 122.8400n 0.001014
+ 122.8500n 0.000998 122.8600n 0.000982 122.8700n 0.000966 122.8800n 0.000949 122.8900n 0.000933 122.9000n 0.000915 122.9100n 0.000898 122.9200n 0.000880 122.9300n 0.000861 122.9400n 0.000843 122.9500n 0.000824 122.9600n 0.000805 122.9700n 0.000786 122.9800n 0.000766 122.9900n 0.000746
+ 123.0000n 0.000726 123.0100n 0.000706 123.0200n 0.000685 123.0300n 0.000664 123.0400n 0.000644 123.0500n 0.000622 123.0600n 0.000601 123.0700n 0.000580 123.0800n 0.000558 123.0900n 0.000537 123.1000n 0.000515 123.1100n 0.000493 123.1200n 0.000471 123.1300n 0.000449 123.1400n 0.000427
+ 123.1500n 0.000405 123.1600n 0.000383 123.1700n 0.000361 123.1800n 0.000338 123.1900n 0.000316 123.2000n 0.000294 123.2100n 0.000272 123.2200n 0.000250 123.2300n 0.000228 123.2400n 0.000206 123.2500n 0.000184 123.2600n 0.000162 123.2700n 0.000141 123.2800n 0.000119 123.2900n 0.000098
+ 123.3000n 0.000077 123.3100n 0.000056 123.3200n 0.000035 123.3300n 0.000014 123.3400n -0.000006 123.3500n -0.000027 123.3600n -0.000047 123.3700n -0.000066 123.3800n -0.000086 123.3900n -0.000105 123.4000n -0.000124 123.4100n -0.000143 123.4200n -0.000161 123.4300n -0.000179 123.4400n -0.000197
+ 123.4500n -0.000214 123.4600n -0.000231 123.4700n -0.000248 123.4800n -0.000264 123.4900n -0.000280 123.5000n -0.000296 123.5100n -0.000311 123.5200n -0.000325 123.5300n -0.000340 123.5400n -0.000353 123.5500n -0.000367 123.5600n -0.000380 123.5700n -0.000392 123.5800n -0.000404 123.5900n -0.000416
+ 123.6000n -0.000427 123.6100n -0.000437 123.6200n -0.000447 123.6300n -0.000457 123.6400n -0.000465 123.6500n -0.000474 123.6600n -0.000482 123.6700n -0.000489 123.6800n -0.000496 123.6900n -0.000502 123.7000n -0.000508 123.7100n -0.000513 123.7200n -0.000518 123.7300n -0.000522 123.7400n -0.000525
+ 123.7500n -0.000528 123.7600n -0.000530 123.7700n -0.000532 123.7800n -0.000533 123.7900n -0.000534 123.8000n -0.000534 123.8100n -0.000533 123.8200n -0.000532 123.8300n -0.000530 123.8400n -0.000528 123.8500n -0.000525 123.8600n -0.000522 123.8700n -0.000518 123.8800n -0.000513 123.8900n -0.000508
+ 123.9000n -0.000502 123.9100n -0.000496 123.9200n -0.000489 123.9300n -0.000481 123.9400n -0.000473 123.9500n -0.000465 123.9600n -0.000456 123.9700n -0.000446 123.9800n -0.000436 123.9900n -0.000425 124.0000n -0.000414 124.0100n -0.000402 124.0200n -0.000390 124.0300n -0.000377 124.0400n -0.000364
+ 124.0500n -0.000350 124.0600n -0.000336 124.0700n -0.000321 124.0800n -0.000306 124.0900n -0.000290 124.1000n -0.000274 124.1100n -0.000258 124.1200n -0.000241 124.1300n -0.000224 124.1400n -0.000206 124.1500n -0.000188 124.1600n -0.000169 124.1700n -0.000151 124.1800n -0.000132 124.1900n -0.000112
+ 124.2000n -0.000092 124.2100n -0.000072 124.2200n -0.000052 124.2300n -0.000031 124.2400n -0.000011 124.2500n 0.000011 124.2600n 0.000032 124.2700n 0.000054 124.2800n 0.000075 124.2900n 0.000097 124.3000n 0.000119 124.3100n 0.000142 124.3200n 0.000164 124.3300n 0.000187 124.3400n 0.000209
+ 124.3500n 0.000232 124.3600n 0.000255 124.3700n 0.000278 124.3800n 0.000301 124.3900n 0.000324 124.4000n 0.000347 124.4100n 0.000370 124.4200n 0.000393 124.4300n 0.000416 124.4400n 0.000438 124.4500n 0.000461 124.4600n 0.000484 124.4700n 0.000506 124.4800n 0.000529 124.4900n 0.000551
+ 124.5000n 0.000573 124.5100n 0.000595 124.5200n 0.000617 124.5300n 0.000639 124.5400n 0.000660 124.5500n 0.000681 124.5600n 0.000702 124.5700n 0.000723 124.5800n 0.000743 124.5900n 0.000763 124.6000n 0.000783 124.6100n 0.000802 124.6200n 0.000821 124.6300n 0.000840 124.6400n 0.000858
+ 124.6500n 0.000876 124.6600n 0.000894 124.6700n 0.000911 124.6800n 0.000927 124.6900n 0.000944 124.7000n 0.000959 124.7100n 0.000975 124.7200n 0.000989 124.7300n 0.001004 124.7400n 0.001017 124.7500n 0.001031 124.7600n 0.001043 124.7700n 0.001055 124.7800n 0.001067 124.7900n 0.001078
+ 124.8000n 0.001088 124.8100n 0.001098 124.8200n 0.001107 124.8300n 0.001116 124.8400n 0.001124 124.8500n 0.001131 124.8600n 0.001138 124.8700n 0.001144 124.8800n 0.001149 124.8900n 0.001154 124.9000n 0.001158 124.9100n 0.001161 124.9200n 0.001164 124.9300n 0.001166 124.9400n 0.001168
+ 124.9500n 0.001168 124.9600n 0.001168 124.9700n 0.001167 124.9800n 0.001166 124.9900n 0.001164 125.0000n 0.001161 125.0100n 0.001157 125.0200n 0.001153 125.0300n 0.001148 125.0400n 0.001142 125.0500n 0.001135 125.0600n 0.001128 125.0700n 0.001120 125.0800n 0.001112 125.0900n 0.001102
+ 125.1000n 0.001092 125.1100n 0.001081 125.1200n 0.001070 125.1300n 0.001058 125.1400n 0.001045 125.1500n 0.001031 125.1600n 0.001017 125.1700n 0.001002 125.1800n 0.000986 125.1900n 0.000970 125.2000n 0.000953 125.2100n 0.000935 125.2200n 0.000917 125.2300n 0.000898 125.2400n 0.000878
+ 125.2500n 0.000858 125.2600n 0.000837 125.2700n 0.000815 125.2800n 0.000793 125.2900n 0.000770 125.3000n 0.000747 125.3100n 0.000723 125.3200n 0.000698 125.3300n 0.000673 125.3400n 0.000648 125.3500n 0.000622 125.3600n 0.000595 125.3700n 0.000568 125.3800n 0.000540 125.3900n 0.000512
+ 125.4000n 0.000484 125.4100n 0.000455 125.4200n 0.000425 125.4300n 0.000395 125.4400n 0.000365 125.4500n 0.000334 125.4600n 0.000303 125.4700n 0.000272 125.4800n 0.000240 125.4900n 0.000208 125.5000n 0.000176 125.5100n 0.000143 125.5200n 0.000110 125.5300n 0.000077 125.5400n 0.000043
+ 125.5500n 0.000009 125.5600n -0.000025 125.5700n -0.000059 125.5800n -0.000093 125.5900n -0.000128 125.6000n -0.000162 125.6100n -0.000197 125.6200n -0.000232 125.6300n -0.000267 125.6400n -0.000302 125.6500n -0.000337 125.6600n -0.000372 125.6700n -0.000407 125.6800n -0.000443 125.6900n -0.000478
+ 125.7000n -0.000513 125.7100n -0.000548 125.7200n -0.000583 125.7300n -0.000618 125.7400n -0.000653 125.7500n -0.000688 125.7600n -0.000722 125.7700n -0.000756 125.7800n -0.000791 125.7900n -0.000825 125.8000n -0.000859 125.8100n -0.000892 125.8200n -0.000926 125.8300n -0.000959 125.8400n -0.000991
+ 125.8500n -0.001024 125.8600n -0.001056 125.8700n -0.001088 125.8800n -0.001120 125.8900n -0.001151 125.9000n -0.001182 125.9100n -0.001212 125.9200n -0.001242 125.9300n -0.001272 125.9400n -0.001301 125.9500n -0.001330 125.9600n -0.001358 125.9700n -0.001386 125.9800n -0.001413 125.9900n -0.001440
+ 126.0000n -0.001466 126.0100n -0.001492 126.0200n -0.001517 126.0300n -0.001541 126.0400n -0.001565 126.0500n -0.001589 126.0600n -0.001612 126.0700n -0.001634 126.0800n -0.001656 126.0900n -0.001677 126.1000n -0.001697 126.1100n -0.001717 126.1200n -0.001736 126.1300n -0.001755 126.1400n -0.001772
+ 126.1500n -0.001789 126.1600n -0.001806 126.1700n -0.001822 126.1800n -0.001837 126.1900n -0.001851 126.2000n -0.001865 126.2100n -0.001878 126.2200n -0.001890 126.2300n -0.001901 126.2400n -0.001912 126.2500n -0.001922 126.2600n -0.001931 126.2700n -0.001940 126.2800n -0.001947 126.2900n -0.001954
+ 126.3000n -0.001961 126.3100n -0.001966 126.3200n -0.001971 126.3300n -0.001975 126.3400n -0.001978 126.3500n -0.001980 126.3600n -0.001982 126.3700n -0.001983 126.3800n -0.001983 126.3900n -0.001982 126.4000n -0.001981 126.4100n -0.001979 126.4200n -0.001976 126.4300n -0.001972 126.4400n -0.001968
+ 126.4500n -0.001963 126.4600n -0.001957 126.4700n -0.001950 126.4800n -0.001943 126.4900n -0.001935 126.5000n -0.001926 126.5100n -0.001917 126.5200n -0.001906 126.5300n -0.001895 126.5400n -0.001884 126.5500n -0.001871 126.5600n -0.001858 126.5700n -0.001844 126.5800n -0.001830 126.5900n -0.001815
+ 126.6000n -0.001799 126.6100n -0.001783 126.6200n -0.001766 126.6300n -0.001748 126.6400n -0.001730 126.6500n -0.001711 126.6600n -0.001691 126.6700n -0.001671 126.6800n -0.001650 126.6900n -0.001629 126.7000n -0.001607 126.7100n -0.001585 126.7200n -0.001562 126.7300n -0.001538 126.7400n -0.001514
+ 126.7500n -0.001489 126.7600n -0.001464 126.7700n -0.001439 126.7800n -0.001413 126.7900n -0.001386 126.8000n -0.001359 126.8100n -0.001332 126.8200n -0.001304 126.8300n -0.001275 126.8400n -0.001247 126.8500n -0.001217 126.8600n -0.001188 126.8700n -0.001158 126.8800n -0.001128 126.8900n -0.001097
+ 126.9000n -0.001066 126.9100n -0.001035 126.9200n -0.001004 126.9300n -0.000972 126.9400n -0.000940 126.9500n -0.000907 126.9600n -0.000875 126.9700n -0.000842 126.9800n -0.000809 126.9900n -0.000775 127.0000n -0.000742 127.0100n -0.000708 127.0200n -0.000674 127.0300n -0.000640 127.0400n -0.000606
+ 127.0500n -0.000572 127.0600n -0.000537 127.0700n -0.000503 127.0800n -0.000468 127.0900n -0.000433 127.1000n -0.000399 127.1100n -0.000364 127.1200n -0.000329 127.1300n -0.000294 127.1400n -0.000259 127.1500n -0.000224 127.1600n -0.000189 127.1700n -0.000154 127.1800n -0.000119 127.1900n -0.000085
+ 127.2000n -0.000050 127.2100n -0.000015 127.2200n 0.000020 127.2300n 0.000054 127.2400n 0.000089 127.2500n 0.000123 127.2600n 0.000157 127.2700n 0.000191 127.2800n 0.000225 127.2900n 0.000259 127.3000n 0.000292 127.3100n 0.000326 127.3200n 0.000359 127.3300n 0.000392 127.3400n 0.000425
+ 127.3500n 0.000457 127.3600n 0.000489 127.3700n 0.000521 127.3800n 0.000553 127.3900n 0.000585 127.4000n 0.000616 127.4100n 0.000647 127.4200n 0.000678 127.4300n 0.000708 127.4400n 0.000738 127.4500n 0.000768 127.4600n 0.000797 127.4700n 0.000827 127.4800n 0.000855 127.4900n 0.000884
+ 127.5000n 0.000912 127.5100n 0.000940 127.5200n 0.000967 127.5300n 0.000994 127.5400n 0.001021 127.5500n 0.001047 127.5600n 0.001073 127.5700n 0.001098 127.5800n 0.001123 127.5900n 0.001148 127.6000n 0.001172 127.6100n 0.001195 127.6200n 0.001219 127.6300n 0.001242 127.6400n 0.001264
+ 127.6500n 0.001286 127.6600n 0.001307 127.6700n 0.001329 127.6800n 0.001349 127.6900n 0.001369 127.7000n 0.001389 127.7100n 0.001408 127.7200n 0.001427 127.7300n 0.001445 127.7400n 0.001463 127.7500n 0.001480 127.7600n 0.001497 127.7700n 0.001514 127.7800n 0.001529 127.7900n 0.001545
+ 127.8000n 0.001560 127.8100n 0.001574 127.8200n 0.001588 127.8300n 0.001601 127.8400n 0.001614 127.8500n 0.001626 127.8600n 0.001638 127.8700n 0.001650 127.8800n 0.001660 127.8900n 0.001671 127.9000n 0.001681 127.9100n 0.001690 127.9200n 0.001699 127.9300n 0.001707 127.9400n 0.001715
+ 127.9500n 0.001722 127.9600n 0.001729 127.9700n 0.001735 127.9800n 0.001741 127.9900n 0.001747 128.0000n 0.001751 128.0100n 0.001756 128.0200n 0.001760 128.0300n 0.001763 128.0400n 0.001766 128.0500n 0.001768 128.0600n 0.001770 128.0700n 0.001771 128.0800n 0.001772 128.0900n 0.001773
+ 128.1000n 0.001773 128.1100n 0.001772 128.1200n 0.001771 128.1300n 0.001769 128.1400n 0.001768 128.1500n 0.001765 128.1600n 0.001762 128.1700n 0.001759 128.1800n 0.001755 128.1900n 0.001751 128.2000n 0.001746 128.2100n 0.001741 128.2200n 0.001736 128.2300n 0.001730 128.2400n 0.001723
+ 128.2500n 0.001717 128.2600n 0.001709 128.2700n 0.001702 128.2800n 0.001694 128.2900n 0.001685 128.3000n 0.001676 128.3100n 0.001667 128.3200n 0.001658 128.3300n 0.001648 128.3400n 0.001637 128.3500n 0.001627 128.3600n 0.001616 128.3700n 0.001604 128.3800n 0.001593 128.3900n 0.001581
+ 128.4000n 0.001568 128.4100n 0.001555 128.4200n 0.001542 128.4300n 0.001529 128.4400n 0.001515 128.4500n 0.001501 128.4600n 0.001487 128.4700n 0.001473 128.4800n 0.001458 128.4900n 0.001443 128.5000n 0.001427 128.5100n 0.001412 128.5200n 0.001396 128.5300n 0.001380 128.5400n 0.001364
+ 128.5500n 0.001347 128.5600n 0.001331 128.5700n 0.001314 128.5800n 0.001297 128.5900n 0.001279 128.6000n 0.001262 128.6100n 0.001244 128.6200n 0.001227 128.6300n 0.001209 128.6400n 0.001191 128.6500n 0.001173 128.6600n 0.001154 128.6700n 0.001136 128.6800n 0.001117 128.6900n 0.001099
+ 128.7000n 0.001080 128.7100n 0.001062 128.7200n 0.001043 128.7300n 0.001024 128.7400n 0.001005 128.7500n 0.000986 128.7600n 0.000967 128.7700n 0.000948 128.7800n 0.000929 128.7900n 0.000911 128.8000n 0.000892 128.8100n 0.000873 128.8200n 0.000854 128.8300n 0.000835 128.8400n 0.000816
+ 128.8500n 0.000798 128.8600n 0.000779 128.8700n 0.000761 128.8800n 0.000742 128.8900n 0.000724 128.9000n 0.000706 128.9100n 0.000688 128.9200n 0.000670 128.9300n 0.000653 128.9400n 0.000635 128.9500n 0.000618 128.9600n 0.000601 128.9700n 0.000584 128.9800n 0.000567 128.9900n 0.000550
+ 129.0000n 0.000534 129.0100n 0.000518 129.0200n 0.000502 129.0300n 0.000487 129.0400n 0.000471 129.0500n 0.000456 129.0600n 0.000441 129.0700n 0.000427 129.0800n 0.000413 129.0900n 0.000399 129.1000n 0.000386 129.1100n 0.000372 129.1200n 0.000360 129.1300n 0.000347 129.1400n 0.000335
+ 129.1500n 0.000323 129.1600n 0.000312 129.1700n 0.000301 129.1800n 0.000290 129.1900n 0.000280 129.2000n 0.000270 129.2100n 0.000261 129.2200n 0.000252 129.2300n 0.000243 129.2400n 0.000235 129.2500n 0.000228 129.2600n 0.000220 129.2700n 0.000214 129.2800n 0.000208 129.2900n 0.000202
+ 129.3000n 0.000196 129.3100n 0.000192 129.3200n 0.000187 129.3300n 0.000184 129.3400n 0.000180 129.3500n 0.000177 129.3600n 0.000175 129.3700n 0.000173 129.3800n 0.000172 129.3900n 0.000171 129.4000n 0.000171 129.4100n 0.000171 129.4200n 0.000172 129.4300n 0.000174 129.4400n 0.000176
+ 129.4500n 0.000178 129.4600n 0.000181 129.4700n 0.000185 129.4800n 0.000189 129.4900n 0.000194 129.5000n 0.000199 129.5100n 0.000205 129.5200n 0.000211 129.5300n 0.000218 129.5400n 0.000225 129.5500n 0.000233 129.5600n 0.000242 129.5700n 0.000251 129.5800n 0.000260 129.5900n 0.000270
+ 129.6000n 0.000281 129.6100n 0.000292 129.6200n 0.000304 129.6300n 0.000316 129.6400n 0.000329 129.6500n 0.000343 129.6600n 0.000356 129.6700n 0.000371 129.6800n 0.000386 129.6900n 0.000401 129.7000n 0.000417 129.7100n 0.000433 129.7200n 0.000450 129.7300n 0.000468 129.7400n 0.000485
+ 129.7500n 0.000504 129.7600n 0.000522 129.7700n 0.000542 129.7800n 0.000561 129.7900n 0.000581 129.8000n 0.000602 129.8100n 0.000623 129.8200n 0.000644 129.8300n 0.000666 129.8400n 0.000688 129.8500n 0.000710 129.8600n 0.000733 129.8700n 0.000756 129.8800n 0.000780 129.8900n 0.000804
+ 129.9000n 0.000828 129.9100n 0.000852 129.9200n 0.000877 129.9300n 0.000902 129.9400n 0.000927 129.9500n 0.000953 129.9600n 0.000979 129.9700n 0.001005 129.9800n 0.001031 129.9900n 0.001057 130.0000n 0.001084 130.0100n 0.001111 130.0200n 0.001138 130.0300n 0.001165 130.0400n 0.001192
+ 130.0500n 0.001219 130.0600n 0.001247 130.0700n 0.001274 130.0800n 0.001302 130.0900n 0.001330 130.1000n 0.001357 130.1100n 0.001385 130.1200n 0.001413 130.1300n 0.001440 130.1400n 0.001468 130.1500n 0.001495 130.1600n 0.001523 130.1700n 0.001550 130.1800n 0.001578 130.1900n 0.001605
+ 130.2000n 0.001632 130.2100n 0.001659 130.2200n 0.001686 130.2300n 0.001712 130.2400n 0.001739 130.2500n 0.001765 130.2600n 0.001791 130.2700n 0.001817 130.2800n 0.001842 130.2900n 0.001867 130.3000n 0.001892 130.3100n 0.001917 130.3200n 0.001941 130.3300n 0.001965 130.3400n 0.001989
+ 130.3500n 0.002012 130.3600n 0.002035 130.3700n 0.002057 130.3800n 0.002079 130.3900n 0.002100 130.4000n 0.002122 130.4100n 0.002142 130.4200n 0.002162 130.4300n 0.002182 130.4400n 0.002201 130.4500n 0.002220 130.4600n 0.002238 130.4700n 0.002255 130.4800n 0.002272 130.4900n 0.002289
+ 130.5000n 0.002305 130.5100n 0.002320 130.5200n 0.002335 130.5300n 0.002349 130.5400n 0.002362 130.5500n 0.002375 130.5600n 0.002387 130.5700n 0.002399 130.5800n 0.002409 130.5900n 0.002419 130.6000n 0.002429 130.6100n 0.002438 130.6200n 0.002446 130.6300n 0.002453 130.6400n 0.002460
+ 130.6500n 0.002466 130.6600n 0.002471 130.6700n 0.002475 130.6800n 0.002479 130.6900n 0.002482 130.7000n 0.002484 130.7100n 0.002486 130.7200n 0.002487 130.7300n 0.002487 130.7400n 0.002486 130.7500n 0.002485 130.7600n 0.002482 130.7700n 0.002479 130.7800n 0.002476 130.7900n 0.002471
+ 130.8000n 0.002466 130.8100n 0.002460 130.8200n 0.002453 130.8300n 0.002445 130.8400n 0.002437 130.8500n 0.002428 130.8600n 0.002418 130.8700n 0.002408 130.8800n 0.002397 130.8900n 0.002385 130.9000n 0.002372 130.9100n 0.002358 130.9200n 0.002344 130.9300n 0.002329 130.9400n 0.002314
+ 130.9500n 0.002298 130.9600n 0.002281 130.9700n 0.002263 130.9800n 0.002245 130.9900n 0.002226 131.0000n 0.002207 131.0100n 0.002186 131.0200n 0.002166 131.0300n 0.002144 131.0400n 0.002122 131.0500n 0.002100 131.0600n 0.002077 131.0700n 0.002053 131.0800n 0.002029 131.0900n 0.002004
+ 131.1000n 0.001979 131.1100n 0.001953 131.1200n 0.001927 131.1300n 0.001900 131.1400n 0.001873 131.1500n 0.001845 131.1600n 0.001818 131.1700n 0.001789 131.1800n 0.001760 131.1900n 0.001731 131.2000n 0.001702 131.2100n 0.001672 131.2200n 0.001642 131.2300n 0.001611 131.2400n 0.001581
+ 131.2500n 0.001550 131.2600n 0.001518 131.2700n 0.001487 131.2800n 0.001455 131.2900n 0.001424 131.3000n 0.001392 131.3100n 0.001360 131.3200n 0.001327 131.3300n 0.001295 131.3400n 0.001263 131.3500n 0.001230 131.3600n 0.001198 131.3700n 0.001165 131.3800n 0.001133 131.3900n 0.001100
+ 131.4000n 0.001068 131.4100n 0.001036 131.4200n 0.001003 131.4300n 0.000971 131.4400n 0.000939 131.4500n 0.000907 131.4600n 0.000876 131.4700n 0.000844 131.4800n 0.000813 131.4900n 0.000782 131.5000n 0.000751 131.5100n 0.000720 131.5200n 0.000690 131.5300n 0.000660 131.5400n 0.000630
+ 131.5500n 0.000601 131.5600n 0.000572 131.5700n 0.000543 131.5800n 0.000515 131.5900n 0.000487 131.6000n 0.000460 131.6100n 0.000433 131.6200n 0.000407 131.6300n 0.000381 131.6400n 0.000355 131.6500n 0.000330 131.6600n 0.000306 131.6700n 0.000282 131.6800n 0.000258 131.6900n 0.000236
+ 131.7000n 0.000213 131.7100n 0.000192 131.7200n 0.000171 131.7300n 0.000150 131.7400n 0.000130 131.7500n 0.000111 131.7600n 0.000093 131.7700n 0.000075 131.7800n 0.000058 131.7900n 0.000041 131.8000n 0.000025 131.8100n 0.000010 131.8200n -0.000004 131.8300n -0.000018 131.8400n -0.000031
+ 131.8500n -0.000043 131.8600n -0.000054 131.8700n -0.000065 131.8800n -0.000075 131.8900n -0.000085 131.9000n -0.000093 131.9100n -0.000101 131.9200n -0.000108 131.9300n -0.000114 131.9400n -0.000120 131.9500n -0.000125 131.9600n -0.000129 131.9700n -0.000132 131.9800n -0.000135 131.9900n -0.000136
+ 132.0000n -0.000138 132.0100n -0.000138 132.0200n -0.000137 132.0300n -0.000136 132.0400n -0.000135 132.0500n -0.000132 132.0600n -0.000129 132.0700n -0.000125 132.0800n -0.000120 132.0900n -0.000115 132.1000n -0.000109 132.1100n -0.000102 132.1200n -0.000094 132.1300n -0.000086 132.1400n -0.000078
+ 132.1500n -0.000068 132.1600n -0.000058 132.1700n -0.000048 132.1800n -0.000037 132.1900n -0.000025 132.2000n -0.000013 132.2100n 0.000000 132.2200n 0.000014 132.2300n 0.000027 132.2400n 0.000042 132.2500n 0.000057 132.2600n 0.000072 132.2700n 0.000088 132.2800n 0.000104 132.2900n 0.000121
+ 132.3000n 0.000138 132.3100n 0.000156 132.3200n 0.000174 132.3300n 0.000192 132.3400n 0.000210 132.3500n 0.000229 132.3600n 0.000248 132.3700n 0.000268 132.3800n 0.000288 132.3900n 0.000308 132.4000n 0.000328 132.4100n 0.000348 132.4200n 0.000369 132.4300n 0.000389 132.4400n 0.000410
+ 132.4500n 0.000431 132.4600n 0.000452 132.4700n 0.000473 132.4800n 0.000494 132.4900n 0.000515 132.5000n 0.000537 132.5100n 0.000558 132.5200n 0.000579 132.5300n 0.000600 132.5400n 0.000621 132.5500n 0.000642 132.5600n 0.000662 132.5700n 0.000683 132.5800n 0.000703 132.5900n 0.000724
+ 132.6000n 0.000744 132.6100n 0.000763 132.6200n 0.000783 132.6300n 0.000802 132.6400n 0.000821 132.6500n 0.000840 132.6600n 0.000858 132.6700n 0.000876 132.6800n 0.000894 132.6900n 0.000911 132.7000n 0.000928 132.7100n 0.000944 132.7200n 0.000960 132.7300n 0.000976 132.7400n 0.000991
+ 132.7500n 0.001005 132.7600n 0.001019 132.7700n 0.001033 132.7800n 0.001046 132.7900n 0.001058 132.8000n 0.001070 132.8100n 0.001081 132.8200n 0.001092 132.8300n 0.001102 132.8400n 0.001111 132.8500n 0.001120 132.8600n 0.001128 132.8700n 0.001136 132.8800n 0.001143 132.8900n 0.001149
+ 132.9000n 0.001154 132.9100n 0.001159 132.9200n 0.001163 132.9300n 0.001167 132.9400n 0.001169 132.9500n 0.001171 132.9600n 0.001173 132.9700n 0.001173 132.9800n 0.001173 132.9900n 0.001172 133.0000n 0.001170 133.0100n 0.001168 133.0200n 0.001165 133.0300n 0.001161 133.0400n 0.001156
+ 133.0500n 0.001151 133.0600n 0.001145 133.0700n 0.001138 133.0800n 0.001131 133.0900n 0.001122 133.1000n 0.001113 133.1100n 0.001104 133.1200n 0.001093 133.1300n 0.001082 133.1400n 0.001070 133.1500n 0.001058 133.1600n 0.001044 133.1700n 0.001030 133.1800n 0.001016 133.1900n 0.001001
+ 133.2000n 0.000985 133.2100n 0.000968 133.2200n 0.000951 133.2300n 0.000933 133.2400n 0.000915 133.2500n 0.000896 133.2600n 0.000877 133.2700n 0.000857 133.2800n 0.000836 133.2900n 0.000815 133.3000n 0.000793 133.3100n 0.000771 133.3200n 0.000748 133.3300n 0.000725 133.3400n 0.000702
+ 133.3500n 0.000678 133.3600n 0.000654 133.3700n 0.000629 133.3800n 0.000604 133.3900n 0.000579 133.4000n 0.000553 133.4100n 0.000527 133.4200n 0.000501 133.4300n 0.000474 133.4400n 0.000447 133.4500n 0.000420 133.4600n 0.000393 133.4700n 0.000366 133.4800n 0.000338 133.4900n 0.000311
+ 133.5000n 0.000283 133.5100n 0.000256 133.5200n 0.000228 133.5300n 0.000200 133.5400n 0.000172 133.5500n 0.000145 133.5600n 0.000117 133.5700n 0.000089 133.5800n 0.000062 133.5900n 0.000035 133.6000n 0.000008 133.6100n -0.000019 133.6200n -0.000046 133.6300n -0.000073 133.6400n -0.000099
+ 133.6500n -0.000125 133.6600n -0.000150 133.6700n -0.000176 133.6800n -0.000201 133.6900n -0.000225 133.7000n -0.000249 133.7100n -0.000273 133.7200n -0.000296 133.7300n -0.000319 133.7400n -0.000341 133.7500n -0.000363 133.7600n -0.000384 133.7700n -0.000404 133.7800n -0.000424 133.7900n -0.000443
+ 133.8000n -0.000462 133.8100n -0.000480 133.8200n -0.000497 133.8300n -0.000514 133.8400n -0.000530 133.8500n -0.000545 133.8600n -0.000559 133.8700n -0.000573 133.8800n -0.000586 133.8900n -0.000597 133.9000n -0.000608 133.9100n -0.000619 133.9200n -0.000628 133.9300n -0.000637 133.9400n -0.000644
+ 133.9500n -0.000651 133.9600n -0.000656 133.9700n -0.000661 133.9800n -0.000665 133.9900n -0.000668 134.0000n -0.000670 134.0100n -0.000671 134.0200n -0.000671 134.0300n -0.000669 134.0400n -0.000667 134.0500n -0.000664 134.0600n -0.000660 134.0700n -0.000655 134.0800n -0.000649 134.0900n -0.000641
+ 134.1000n -0.000633 134.1100n -0.000624 134.1200n -0.000613 134.1300n -0.000602 134.1400n -0.000589 134.1500n -0.000576 134.1600n -0.000561 134.1700n -0.000545 134.1800n -0.000529 134.1900n -0.000511 134.2000n -0.000492 134.2100n -0.000472 134.2200n -0.000451 134.2300n -0.000430 134.2400n -0.000407
+ 134.2500n -0.000383 134.2600n -0.000358 134.2700n -0.000332 134.2800n -0.000305 134.2900n -0.000278 134.3000n -0.000249 134.3100n -0.000219 134.3200n -0.000189 134.3300n -0.000157 134.3400n -0.000125 134.3500n -0.000092 134.3600n -0.000058 134.3700n -0.000023 134.3800n 0.000013 134.3900n 0.000050
+ 134.4000n 0.000087 134.4100n 0.000125 134.4200n 0.000164 134.4300n 0.000203 134.4400n 0.000244 134.4500n 0.000285 134.4600n 0.000326 134.4700n 0.000368 134.4800n 0.000411 134.4900n 0.000455 134.5000n 0.000499 134.5100n 0.000543 134.5200n 0.000588 134.5300n 0.000633 134.5400n 0.000679
+ 134.5500n 0.000726 134.5600n 0.000772 134.5700n 0.000820 134.5800n 0.000867 134.5900n 0.000915 134.6000n 0.000963 134.6100n 0.001011 134.6200n 0.001059 134.6300n 0.001108 134.6400n 0.001157 134.6500n 0.001206 134.6600n 0.001255 134.6700n 0.001304 134.6800n 0.001353 134.6900n 0.001402
+ 134.7000n 0.001451 134.7100n 0.001500 134.7200n 0.001549 134.7300n 0.001598 134.7400n 0.001647 134.7500n 0.001695 134.7600n 0.001743 134.7700n 0.001791 134.7800n 0.001839 134.7900n 0.001887 134.8000n 0.001934 134.8100n 0.001980 134.8200n 0.002027 134.8300n 0.002072 134.8400n 0.002118
+ 134.8500n 0.002163 134.8600n 0.002207 134.8700n 0.002251 134.8800n 0.002294 134.8900n 0.002336 134.9000n 0.002378 134.9100n 0.002419 134.9200n 0.002460 134.9300n 0.002500 134.9400n 0.002539 134.9500n 0.002577 134.9600n 0.002614 134.9700n 0.002651 134.9800n 0.002687 134.9900n 0.002721
+ 135.0000n 0.002755 135.0100n 0.002788 135.0200n 0.002820 135.0300n 0.002851 135.0400n 0.002881 135.0500n 0.002910 135.0600n 0.002938 135.0700n 0.002965 135.0800n 0.002991 135.0900n 0.003016 135.1000n 0.003039 135.1100n 0.003062 135.1200n 0.003083 135.1300n 0.003103 135.1400n 0.003122
+ 135.1500n 0.003140 135.1600n 0.003156 135.1700n 0.003171 135.1800n 0.003185 135.1900n 0.003198 135.2000n 0.003210 135.2100n 0.003220 135.2200n 0.003229 135.2300n 0.003237 135.2400n 0.003243 135.2500n 0.003248 135.2600n 0.003252 135.2700n 0.003254 135.2800n 0.003256 135.2900n 0.003256
+ 135.3000n 0.003254 135.3100n 0.003251 135.3200n 0.003247 135.3300n 0.003242 135.3400n 0.003235 135.3500n 0.003227 135.3600n 0.003218 135.3700n 0.003207 135.3800n 0.003196 135.3900n 0.003182 135.4000n 0.003168 135.4100n 0.003152 135.4200n 0.003135 135.4300n 0.003117 135.4400n 0.003098
+ 135.4500n 0.003077 135.4600n 0.003055 135.4700n 0.003032 135.4800n 0.003008 135.4900n 0.002982 135.5000n 0.002956 135.5100n 0.002928 135.5200n 0.002899 135.5300n 0.002869 135.5400n 0.002838 135.5500n 0.002806 135.5600n 0.002772 135.5700n 0.002738 135.5800n 0.002703 135.5900n 0.002667
+ 135.6000n 0.002630 135.6100n 0.002591 135.6200n 0.002552 135.6300n 0.002512 135.6400n 0.002472 135.6500n 0.002430 135.6600n 0.002387 135.6700n 0.002344 135.6800n 0.002300 135.6900n 0.002255 135.7000n 0.002210 135.7100n 0.002164 135.7200n 0.002117 135.7300n 0.002070 135.7400n 0.002022
+ 135.7500n 0.001973 135.7600n 0.001924 135.7700n 0.001874 135.7800n 0.001824 135.7900n 0.001774 135.8000n 0.001723 135.8100n 0.001672 135.8200n 0.001620 135.8300n 0.001568 135.8400n 0.001516 135.8500n 0.001463 135.8600n 0.001411 135.8700n 0.001358 135.8800n 0.001305 135.8900n 0.001252
+ 135.9000n 0.001199 135.9100n 0.001146 135.9200n 0.001092 135.9300n 0.001039 135.9400n 0.000986 135.9500n 0.000933 135.9600n 0.000880 135.9700n 0.000827 135.9800n 0.000774 135.9900n 0.000722 136.0000n 0.000670 136.0100n 0.000618 136.0200n 0.000566 136.0300n 0.000515 136.0400n 0.000464
+ 136.0500n 0.000414 136.0600n 0.000364 136.0700n 0.000314 136.0800n 0.000265 136.0900n 0.000216 136.1000n 0.000168 136.1100n 0.000121 136.1200n 0.000074 136.1300n 0.000027 136.1400n -0.000018 136.1500n -0.000063 136.1600n -0.000108 136.1700n -0.000151 136.1800n -0.000194 136.1900n -0.000236
+ 136.2000n -0.000277 136.2100n -0.000318 136.2200n -0.000357 136.2300n -0.000396 136.2400n -0.000434 136.2500n -0.000471 136.2600n -0.000507 136.2700n -0.000542 136.2800n -0.000576 136.2900n -0.000609 136.3000n -0.000642 136.3100n -0.000673 136.3200n -0.000703 136.3300n -0.000732 136.3400n -0.000760
+ 136.3500n -0.000787 136.3600n -0.000813 136.3700n -0.000838 136.3800n -0.000862 136.3900n -0.000885 136.4000n -0.000907 136.4100n -0.000927 136.4200n -0.000947 136.4300n -0.000965 136.4400n -0.000982 136.4500n -0.000999 136.4600n -0.001013 136.4700n -0.001027 136.4800n -0.001040 136.4900n -0.001052
+ 136.5000n -0.001062 136.5100n -0.001071 136.5200n -0.001080 136.5300n -0.001087 136.5400n -0.001093 136.5500n -0.001098 136.5600n -0.001101 136.5700n -0.001104 136.5800n -0.001106 136.5900n -0.001106 136.6000n -0.001105 136.6100n -0.001104 136.6200n -0.001101 136.6300n -0.001097 136.6400n -0.001092
+ 136.6500n -0.001086 136.6600n -0.001079 136.6700n -0.001072 136.6800n -0.001063 136.6900n -0.001053 136.7000n -0.001042 136.7100n -0.001030 136.7200n -0.001018 136.7300n -0.001004 136.7400n -0.000990 136.7500n -0.000974 136.7600n -0.000958 136.7700n -0.000941 136.7800n -0.000924 136.7900n -0.000905
+ 136.8000n -0.000886 136.8100n -0.000866 136.8200n -0.000845 136.8300n -0.000823 136.8400n -0.000801 136.8500n -0.000779 136.8600n -0.000755 136.8700n -0.000731 136.8800n -0.000707 136.8900n -0.000682 136.9000n -0.000656 136.9100n -0.000630 136.9200n -0.000603 136.9300n -0.000576 136.9400n -0.000549
+ 136.9500n -0.000521 136.9600n -0.000493 136.9700n -0.000464 136.9800n -0.000436 136.9900n -0.000406 137.0000n -0.000377 137.0100n -0.000348 137.0200n -0.000318 137.0300n -0.000288 137.0400n -0.000258 137.0500n -0.000228 137.0600n -0.000198 137.0700n -0.000167 137.0800n -0.000137 137.0900n -0.000107
+ 137.1000n -0.000076 137.1100n -0.000046 137.1200n -0.000016 137.1300n 0.000014 137.1400n 0.000044 137.1500n 0.000073 137.1600n 0.000103 137.1700n 0.000132 137.1800n 0.000161 137.1900n 0.000190 137.2000n 0.000218 137.2100n 0.000246 137.2200n 0.000274 137.2300n 0.000301 137.2400n 0.000328
+ 137.2500n 0.000355 137.2600n 0.000381 137.2700n 0.000407 137.2800n 0.000432 137.2900n 0.000457 137.3000n 0.000481 137.3100n 0.000504 137.3200n 0.000527 137.3300n 0.000550 137.3400n 0.000571 137.3500n 0.000592 137.3600n 0.000613 137.3700n 0.000633 137.3800n 0.000652 137.3900n 0.000670
+ 137.4000n 0.000688 137.4100n 0.000705 137.4200n 0.000721 137.4300n 0.000737 137.4400n 0.000751 137.4500n 0.000765 137.4600n 0.000778 137.4700n 0.000791 137.4800n 0.000802 137.4900n 0.000813 137.5000n 0.000823 137.5100n 0.000832 137.5200n 0.000840 137.5300n 0.000847 137.5400n 0.000853
+ 137.5500n 0.000859 137.5600n 0.000864 137.5700n 0.000867 137.5800n 0.000870 137.5900n 0.000872 137.6000n 0.000873 137.6100n 0.000874 137.6200n 0.000873 137.6300n 0.000871 137.6400n 0.000869 137.6500n 0.000866 137.6600n 0.000861 137.6700n 0.000856 137.6800n 0.000850 137.6900n 0.000843
+ 137.7000n 0.000836 137.7100n 0.000827 137.7200n 0.000818 137.7300n 0.000808 137.7400n 0.000797 137.7500n 0.000785 137.7600n 0.000772 137.7700n 0.000758 137.7800n 0.000744 137.7900n 0.000729 137.8000n 0.000713 137.8100n 0.000696 137.8200n 0.000679 137.8300n 0.000661 137.8400n 0.000642
+ 137.8500n 0.000623 137.8600n 0.000602 137.8700n 0.000582 137.8800n 0.000560 137.8900n 0.000538 137.9000n 0.000515 137.9100n 0.000492 137.9200n 0.000468 137.9300n 0.000443 137.9400n 0.000418 137.9500n 0.000393 137.9600n 0.000367 137.9700n 0.000340 137.9800n 0.000313 137.9900n 0.000286
+ 138.0000n 0.000258 138.0100n 0.000230 138.0200n 0.000201 138.0300n 0.000172 138.0400n 0.000143 138.0500n 0.000113 138.0600n 0.000083 138.0700n 0.000053 138.0800n 0.000023 138.0900n -0.000008 138.1000n -0.000039 138.1100n -0.000069 138.1200n -0.000100 138.1300n -0.000132 138.1400n -0.000163
+ 138.1500n -0.000194 138.1600n -0.000225 138.1700n -0.000257 138.1800n -0.000288 138.1900n -0.000319 138.2000n -0.000351 138.2100n -0.000382 138.2200n -0.000413 138.2300n -0.000444 138.2400n -0.000474 138.2500n -0.000505 138.2600n -0.000535 138.2700n -0.000565 138.2800n -0.000595 138.2900n -0.000625
+ 138.3000n -0.000654 138.3100n -0.000683 138.3200n -0.000711 138.3300n -0.000740 138.3400n -0.000767 138.3500n -0.000795 138.3600n -0.000822 138.3700n -0.000848 138.3800n -0.000874 138.3900n -0.000900 138.4000n -0.000925 138.4100n -0.000950 138.4200n -0.000974 138.4300n -0.000997 138.4400n -0.001020
+ 138.4500n -0.001042 138.4600n -0.001064 138.4700n -0.001085 138.4800n -0.001105 138.4900n -0.001124 138.5000n -0.001143 138.5100n -0.001162 138.5200n -0.001179 138.5300n -0.001196 138.5400n -0.001212 138.5500n -0.001227 138.5600n -0.001242 138.5700n -0.001256 138.5800n -0.001269 138.5900n -0.001281
+ 138.6000n -0.001292 138.6100n -0.001303 138.6200n -0.001312 138.6300n -0.001321 138.6400n -0.001329 138.6500n -0.001337 138.6600n -0.001343 138.6700n -0.001348 138.6800n -0.001353 138.6900n -0.001357 138.7000n -0.001360 138.7100n -0.001362 138.7200n -0.001363 138.7300n -0.001364 138.7400n -0.001363
+ 138.7500n -0.001362 138.7600n -0.001359 138.7700n -0.001356 138.7800n -0.001352 138.7900n -0.001348 138.8000n -0.001342 138.8100n -0.001335 138.8200n -0.001328 138.8300n -0.001320 138.8400n -0.001311 138.8500n -0.001301 138.8600n -0.001290 138.8700n -0.001278 138.8800n -0.001266 138.8900n -0.001253
+ 138.9000n -0.001239 138.9100n -0.001224 138.9200n -0.001209 138.9300n -0.001193 138.9400n -0.001176 138.9500n -0.001158 138.9600n -0.001140 138.9700n -0.001120 138.9800n -0.001101 138.9900n -0.001080 139.0000n -0.001059 139.0100n -0.001037 139.0200n -0.001015 139.0300n -0.000992 139.0400n -0.000968
+ 139.0500n -0.000944 139.0600n -0.000919 139.0700n -0.000894 139.0800n -0.000868 139.0900n -0.000842 139.1000n -0.000815 139.1100n -0.000787 139.1200n -0.000760 139.1300n -0.000731 139.1400n -0.000703 139.1500n -0.000674 139.1600n -0.000644 139.1700n -0.000615 139.1800n -0.000584 139.1900n -0.000554
+ 139.2000n -0.000523 139.2100n -0.000492 139.2200n -0.000461 139.2300n -0.000430 139.2400n -0.000398 139.2500n -0.000367 139.2600n -0.000335 139.2700n -0.000302 139.2800n -0.000270 139.2900n -0.000238 139.3000n -0.000206 139.3100n -0.000173 139.3200n -0.000141 139.3300n -0.000108 139.3400n -0.000076
+ 139.3500n -0.000044 139.3600n -0.000011 139.3700n 0.000021 139.3800n 0.000053 139.3900n 0.000085 139.4000n 0.000117 139.4100n 0.000148 139.4200n 0.000180 139.4300n 0.000211 139.4400n 0.000242 139.4500n 0.000273 139.4600n 0.000303 139.4700n 0.000333 139.4800n 0.000363 139.4900n 0.000393
+ 139.5000n 0.000422 139.5100n 0.000451 139.5200n 0.000479 139.5300n 0.000507 139.5400n 0.000534 139.5500n 0.000562 139.5600n 0.000588 139.5700n 0.000614 139.5800n 0.000640 139.5900n 0.000665 139.6000n 0.000690 139.6100n 0.000714 139.6200n 0.000737 139.6300n 0.000760 139.6400n 0.000782
+ 139.6500n 0.000804 139.6600n 0.000825 139.6700n 0.000846 139.6800n 0.000865 139.6900n 0.000885 139.7000n 0.000903 139.7100n 0.000921 139.7200n 0.000938 139.7300n 0.000954 139.7400n 0.000970 139.7500n 0.000985 139.7600n 0.000999 139.7700n 0.001013 139.7800n 0.001026 139.7900n 0.001038
+ 139.8000n 0.001049 139.8100n 0.001060 139.8200n 0.001069 139.8300n 0.001078 139.8400n 0.001087 139.8500n 0.001094 139.8600n 0.001101 139.8700n 0.001107 139.8800n 0.001112 139.8900n 0.001116 139.9000n 0.001120 139.9100n 0.001123 139.9200n 0.001125 139.9300n 0.001126 139.9400n 0.001126
+ 139.9500n 0.001126 139.9600n 0.001125 139.9700n 0.001123 139.9800n 0.001121 139.9900n 0.001117 140.0000n 0.001113 140.0100n 0.001108 140.0200n 0.001102 140.0300n 0.001096 140.0400n 0.001089 140.0500n 0.001081 140.0600n 0.001072 140.0700n 0.001063 140.0800n 0.001053 140.0900n 0.001042
+ 140.1000n 0.001031 140.1100n 0.001019 140.1200n 0.001006 140.1300n 0.000992 140.1400n 0.000978 140.1500n 0.000964 140.1600n 0.000948 140.1700n 0.000932 140.1800n 0.000916 140.1900n 0.000899 140.2000n 0.000881 140.2100n 0.000863 140.2200n 0.000844 140.2300n 0.000824 140.2400n 0.000804
+ 140.2500n 0.000784 140.2600n 0.000763 140.2700n 0.000742 140.2800n 0.000720 140.2900n 0.000698 140.3000n 0.000675 140.3100n 0.000652 140.3200n 0.000628 140.3300n 0.000605 140.3400n 0.000580 140.3500n 0.000556 140.3600n 0.000531 140.3700n 0.000506 140.3800n 0.000480 140.3900n 0.000454
+ 140.4000n 0.000428 140.4100n 0.000402 140.4200n 0.000376 140.4300n 0.000349 140.4400n 0.000322 140.4500n 0.000295 140.4600n 0.000268 140.4700n 0.000240 140.4800n 0.000213 140.4900n 0.000185 140.5000n 0.000158 140.5100n 0.000130 140.5200n 0.000102 140.5300n 0.000074 140.5400n 0.000047
+ 140.5500n 0.000019 140.5600n -0.000009 140.5700n -0.000037 140.5800n -0.000064 140.5900n -0.000092 140.6000n -0.000119 140.6100n -0.000147 140.6200n -0.000174 140.6300n -0.000201 140.6400n -0.000228 140.6500n -0.000255 140.6600n -0.000281 140.6700n -0.000308 140.6800n -0.000334 140.6900n -0.000360
+ 140.7000n -0.000385 140.7100n -0.000411 140.7200n -0.000436 140.7300n -0.000461 140.7400n -0.000485 140.7500n -0.000510 140.7600n -0.000533 140.7700n -0.000557 140.7800n -0.000580 140.7900n -0.000603 140.8000n -0.000625 140.8100n -0.000647 140.8200n -0.000669 140.8300n -0.000690 140.8400n -0.000711
+ 140.8500n -0.000731 140.8600n -0.000751 140.8700n -0.000770 140.8800n -0.000789 140.8900n -0.000807 140.9000n -0.000825 140.9100n -0.000843 140.9200n -0.000860 140.9300n -0.000876 140.9400n -0.000892 140.9500n -0.000907 140.9600n -0.000922 140.9700n -0.000937 140.9800n -0.000950 140.9900n -0.000964
+ 141.0000n -0.000976 141.0100n -0.000988 141.0200n -0.001000 141.0300n -0.001011 141.0400n -0.001021 141.0500n -0.001031 141.0600n -0.001041 141.0700n -0.001049 141.0800n -0.001057 141.0900n -0.001065 141.1000n -0.001072 141.1100n -0.001078 141.1200n -0.001084 141.1300n -0.001090 141.1400n -0.001094
+ 141.1500n -0.001098 141.1600n -0.001102 141.1700n -0.001105 141.1800n -0.001107 141.1900n -0.001109 141.2000n -0.001111 141.2100n -0.001111 141.2200n -0.001111 141.2300n -0.001111 141.2400n -0.001110 141.2500n -0.001109 141.2600n -0.001107 141.2700n -0.001104 141.2800n -0.001101 141.2900n -0.001097
+ 141.3000n -0.001093 141.3100n -0.001089 141.3200n -0.001084 141.3300n -0.001078 141.3400n -0.001072 141.3500n -0.001065 141.3600n -0.001058 141.3700n -0.001051 141.3800n -0.001043 141.3900n -0.001035 141.4000n -0.001026 141.4100n -0.001016 141.4200n -0.001007 141.4300n -0.000997 141.4400n -0.000986
+ 141.4500n -0.000975 141.4600n -0.000964 141.4700n -0.000952 141.4800n -0.000940 141.4900n -0.000928 141.5000n -0.000915 141.5100n -0.000902 141.5200n -0.000889 141.5300n -0.000875 141.5400n -0.000861 141.5500n -0.000847 141.5600n -0.000832 141.5700n -0.000818 141.5800n -0.000803 141.5900n -0.000787
+ 141.6000n -0.000772 141.6100n -0.000756 141.6200n -0.000740 141.6300n -0.000724 141.6400n -0.000708 141.6500n -0.000691 141.6600n -0.000674 141.6700n -0.000658 141.6800n -0.000641 141.6900n -0.000624 141.7000n -0.000606 141.7100n -0.000589 141.7200n -0.000572 141.7300n -0.000554 141.7400n -0.000537
+ 141.7500n -0.000519 141.7600n -0.000501 141.7700n -0.000484 141.7800n -0.000466 141.7900n -0.000448 141.8000n -0.000430 141.8100n -0.000413 141.8200n -0.000395 141.8300n -0.000377 141.8400n -0.000360 141.8500n -0.000342 141.8600n -0.000324 141.8700n -0.000307 141.8800n -0.000290 141.8900n -0.000272
+ 141.9000n -0.000255 141.9100n -0.000238 141.9200n -0.000221 141.9300n -0.000204 141.9400n -0.000187 141.9500n -0.000171 141.9600n -0.000154 141.9700n -0.000138 141.9800n -0.000122 141.9900n -0.000106 142.0000n -0.000090 142.0100n -0.000074 142.0200n -0.000059 142.0300n -0.000044 142.0400n -0.000029
+ 142.0500n -0.000014 142.0600n 0.000000 142.0700n 0.000015 142.0800n 0.000029 142.0900n 0.000043 142.1000n 0.000056 142.1100n 0.000070 142.1200n 0.000083 142.1300n 0.000096 142.1400n 0.000108 142.1500n 0.000120 142.1600n 0.000132 142.1700n 0.000144 142.1800n 0.000156 142.1900n 0.000167
+ 142.2000n 0.000178 142.2100n 0.000188 142.2200n 0.000199 142.2300n 0.000209 142.2400n 0.000218 142.2500n 0.000228 142.2600n 0.000237 142.2700n 0.000245 142.2800n 0.000254 142.2900n 0.000262 142.3000n 0.000270 142.3100n 0.000278 142.3200n 0.000285 142.3300n 0.000292 142.3400n 0.000298
+ 142.3500n 0.000305 142.3600n 0.000311 142.3700n 0.000316 142.3800n 0.000322 142.3900n 0.000327 142.4000n 0.000331 142.4100n 0.000336 142.4200n 0.000340 142.4300n 0.000344 142.4400n 0.000347 142.4500n 0.000351 142.4600n 0.000354 142.4700n 0.000356 142.4800n 0.000358 142.4900n 0.000361
+ 142.5000n 0.000362 142.5100n 0.000364 142.5200n 0.000365 142.5300n 0.000366 142.5400n 0.000366 142.5500n 0.000367 142.5600n 0.000367 142.5700n 0.000367 142.5800n 0.000366 142.5900n 0.000365 142.6000n 0.000364 142.6100n 0.000363 142.6200n 0.000362 142.6300n 0.000360 142.6400n 0.000358
+ 142.6500n 0.000356 142.6600n 0.000354 142.6700n 0.000351 142.6800n 0.000348 142.6900n 0.000345 142.7000n 0.000342 142.7100n 0.000338 142.7200n 0.000334 142.7300n 0.000331 142.7400n 0.000326 142.7500n 0.000322 142.7600n 0.000318 142.7700n 0.000313 142.7800n 0.000308 142.7900n 0.000303
+ 142.8000n 0.000298 142.8100n 0.000293 142.8200n 0.000288 142.8300n 0.000282 142.8400n 0.000276 142.8500n 0.000271 142.8600n 0.000265 142.8700n 0.000258 142.8800n 0.000252 142.8900n 0.000246 142.9000n 0.000240 142.9100n 0.000233 142.9200n 0.000226 142.9300n 0.000220 142.9400n 0.000213
+ 142.9500n 0.000206 142.9600n 0.000199 142.9700n 0.000192 142.9800n 0.000185 142.9900n 0.000178 143.0000n 0.000171 143.0100n 0.000164 143.0200n 0.000156 143.0300n 0.000149 143.0400n 0.000142 143.0500n 0.000134 143.0600n 0.000127 143.0700n 0.000120 143.0800n 0.000112 143.0900n 0.000105
+ 143.1000n 0.000097 143.1100n 0.000090 143.1200n 0.000083 143.1300n 0.000075 143.1400n 0.000068 143.1500n 0.000060 143.1600n 0.000053 143.1700n 0.000046 143.1800n 0.000038 143.1900n 0.000031 143.2000n 0.000024 143.2100n 0.000017 143.2200n 0.000010 143.2300n 0.000003 143.2400n -0.000004
+ 143.2500n -0.000011 143.2600n -0.000018 143.2700n -0.000025 143.2800n -0.000032 143.2900n -0.000038 143.3000n -0.000045 143.3100n -0.000052 143.3200n -0.000058 143.3300n -0.000064 143.3400n -0.000071 143.3500n -0.000077 143.3600n -0.000083 143.3700n -0.000089 143.3800n -0.000095 143.3900n -0.000101
+ 143.4000n -0.000107 143.4100n -0.000112 143.4200n -0.000118 143.4300n -0.000123 143.4400n -0.000128 143.4500n -0.000133 143.4600n -0.000139 143.4700n -0.000143 143.4800n -0.000148 143.4900n -0.000153 143.5000n -0.000158 143.5100n -0.000162 143.5200n -0.000166 143.5300n -0.000171 143.5400n -0.000175
+ 143.5500n -0.000179 143.5600n -0.000182 143.5700n -0.000186 143.5800n -0.000190 143.5900n -0.000193 143.6000n -0.000196 143.6100n -0.000199 143.6200n -0.000202 143.6300n -0.000205 143.6400n -0.000208 143.6500n -0.000211 143.6600n -0.000213 143.6700n -0.000215 143.6800n -0.000218 143.6900n -0.000220
+ 143.7000n -0.000222 143.7100n -0.000223 143.7200n -0.000225 143.7300n -0.000226 143.7400n -0.000228 143.7500n -0.000229 143.7600n -0.000230 143.7700n -0.000231 143.7800n -0.000231 143.7900n -0.000232 143.8000n -0.000233 143.8100n -0.000233 143.8200n -0.000233 143.8300n -0.000233 143.8400n -0.000233
+ 143.8500n -0.000233 143.8600n -0.000232 143.8700n -0.000232 143.8800n -0.000231 143.8900n -0.000230 143.9000n -0.000229 143.9100n -0.000228 143.9200n -0.000227 143.9300n -0.000225 143.9400n -0.000224 143.9500n -0.000222 143.9600n -0.000220 143.9700n -0.000218 143.9800n -0.000216 143.9900n -0.000214
+ 144.0000n -0.000211 144.0100n -0.000209 144.0200n -0.000206 144.0300n -0.000203 144.0400n -0.000200 144.0500n -0.000197 144.0600n -0.000194 144.0700n -0.000191 144.0800n -0.000187 144.0900n -0.000184 144.1000n -0.000180 144.1100n -0.000176 144.1200n -0.000172 144.1300n -0.000168 144.1400n -0.000164
+ 144.1500n -0.000159 144.1600n -0.000155 144.1700n -0.000150 144.1800n -0.000145 144.1900n -0.000140 144.2000n -0.000135 144.2100n -0.000130 144.2200n -0.000125 144.2300n -0.000120 144.2400n -0.000114 144.2500n -0.000109 144.2600n -0.000103 144.2700n -0.000097 144.2800n -0.000091 144.2900n -0.000085
+ 144.3000n -0.000079 144.3100n -0.000073 144.3200n -0.000066 144.3300n -0.000060 144.3400n -0.000053 144.3500n -0.000046 144.3600n -0.000040 144.3700n -0.000033 144.3800n -0.000026 144.3900n -0.000019 144.4000n -0.000011 144.4100n -0.000004 144.4200n 0.000003 144.4300n 0.000011 144.4400n 0.000018
+ 144.4500n 0.000026 144.4600n 0.000033 144.4700n 0.000041 144.4800n 0.000049 144.4900n 0.000057 144.5000n 0.000065 144.5100n 0.000073 144.5200n 0.000081 144.5300n 0.000090 144.5400n 0.000098 144.5500n 0.000106 144.5600n 0.000115 144.5700n 0.000123 144.5800n 0.000132 144.5900n 0.000140
+ 144.6000n 0.000149 144.6100n 0.000158 144.6200n 0.000166 144.6300n 0.000175 144.6400n 0.000184 144.6500n 0.000193 144.6600n 0.000202 144.6700n 0.000211 144.6800n 0.000220 144.6900n 0.000229 144.7000n 0.000238 144.7100n 0.000247 144.7200n 0.000256 144.7300n 0.000265 144.7400n 0.000274
+ 144.7500n 0.000283 144.7600n 0.000292 144.7700n 0.000301 144.7800n 0.000311 144.7900n 0.000320 144.8000n 0.000329 144.8100n 0.000338 144.8200n 0.000347 144.8300n 0.000356 144.8400n 0.000365 144.8500n 0.000374 144.8600n 0.000383 144.8700n 0.000392 144.8800n 0.000401 144.8900n 0.000410
+ 144.9000n 0.000419 144.9100n 0.000428 144.9200n 0.000436 144.9300n 0.000445 144.9400n 0.000454 144.9500n 0.000462 144.9600n 0.000471 144.9700n 0.000479 144.9800n 0.000488 144.9900n 0.000496 145.0000n 0.000504 145.0100n 0.000512 145.0200n 0.000520 145.0300n 0.000528 145.0400n 0.000536
+ 145.0500n 0.000544 145.0600n 0.000552 145.0700n 0.000559 145.0800n 0.000567 145.0900n 0.000574 145.1000n 0.000581 145.1100n 0.000588 145.1200n 0.000595 145.1300n 0.000602 145.1400n 0.000609 145.1500n 0.000616 145.1600n 0.000622 145.1700n 0.000628 145.1800n 0.000634 145.1900n 0.000641
+ 145.2000n 0.000646 145.2100n 0.000652 145.2200n 0.000658 145.2300n 0.000663 145.2400n 0.000668 145.2500n 0.000673 145.2600n 0.000678 145.2700n 0.000683 145.2800n 0.000688 145.2900n 0.000692 145.3000n 0.000696 145.3100n 0.000700 145.3200n 0.000704 145.3300n 0.000707 145.3400n 0.000711
+ 145.3500n 0.000714 145.3600n 0.000717 145.3700n 0.000720 145.3800n 0.000722 145.3900n 0.000725 145.4000n 0.000727 145.4100n 0.000729 145.4200n 0.000731 145.4300n 0.000732 145.4400n 0.000734 145.4500n 0.000735 145.4600n 0.000736 145.4700n 0.000736 145.4800n 0.000737 145.4900n 0.000737
+ 145.5000n 0.000737 145.5100n 0.000737 145.5200n 0.000736 145.5300n 0.000736 145.5400n 0.000735 145.5500n 0.000734 145.5600n 0.000732 145.5700n 0.000731 145.5800n 0.000729 145.5900n 0.000727 145.6000n 0.000724 145.6100n 0.000722 145.6200n 0.000719 145.6300n 0.000716 145.6400n 0.000713
+ 145.6500n 0.000709 145.6600n 0.000706 145.6700n 0.000702 145.6800n 0.000697 145.6900n 0.000693 145.7000n 0.000689 145.7100n 0.000684 145.7200n 0.000679 145.7300n 0.000673 145.7400n 0.000668 145.7500n 0.000662 145.7600n 0.000656 145.7700n 0.000650 145.7800n 0.000644 145.7900n 0.000637
+ 145.8000n 0.000631 145.8100n 0.000624 145.8200n 0.000616 145.8300n 0.000609 145.8400n 0.000601 145.8500n 0.000594 145.8600n 0.000586 145.8700n 0.000578 145.8800n 0.000569 145.8900n 0.000561 145.9000n 0.000552 145.9100n 0.000544 145.9200n 0.000535 145.9300n 0.000525 145.9400n 0.000516
+ 145.9500n 0.000507 145.9600n 0.000497 145.9700n 0.000487 145.9800n 0.000478 145.9900n 0.000468 146.0000n 0.000457 146.0100n 0.000447 146.0200n 0.000437 146.0300n 0.000426 146.0400n 0.000416 146.0500n 0.000405 146.0600n 0.000394 146.0700n 0.000383 146.0800n 0.000372 146.0900n 0.000361
+ 146.1000n 0.000350 146.1100n 0.000339 146.1200n 0.000328 146.1300n 0.000316 146.1400n 0.000305 146.1500n 0.000294 146.1600n 0.000282 146.1700n 0.000271 146.1800n 0.000259 146.1900n 0.000248 146.2000n 0.000236 146.2100n 0.000225 146.2200n 0.000213 146.2300n 0.000201 146.2400n 0.000190
+ 146.2500n 0.000178 146.2600n 0.000167 146.2700n 0.000155 146.2800n 0.000144 146.2900n 0.000133 146.3000n 0.000121 146.3100n 0.000110 146.3200n 0.000099 146.3300n 0.000088 146.3400n 0.000077 146.3500n 0.000066 146.3600n 0.000055 146.3700n 0.000044 146.3800n 0.000033 146.3900n 0.000023
+ 146.4000n 0.000012 146.4100n 0.000002 146.4200n -0.000009 146.4300n -0.000019 146.4400n -0.000029 146.4500n -0.000039 146.4600n -0.000048 146.4700n -0.000058 146.4800n -0.000067 146.4900n -0.000076 146.5000n -0.000085 146.5100n -0.000094 146.5200n -0.000103 146.5300n -0.000112 146.5400n -0.000120
+ 146.5500n -0.000128 146.5600n -0.000136 146.5700n -0.000144 146.5800n -0.000151 146.5900n -0.000159 146.6000n -0.000166 146.6100n -0.000173 146.6200n -0.000179 146.6300n -0.000186 146.6400n -0.000192 146.6500n -0.000198 146.6600n -0.000203 146.6700n -0.000209 146.6800n -0.000214 146.6900n -0.000219
+ 146.7000n -0.000224 146.7100n -0.000228 146.7200n -0.000233 146.7300n -0.000236 146.7400n -0.000240 146.7500n -0.000244 146.7600n -0.000247 146.7700n -0.000250 146.7800n -0.000252 146.7900n -0.000255 146.8000n -0.000257 146.8100n -0.000258 146.8200n -0.000260 146.8300n -0.000261 146.8400n -0.000262
+ 146.8500n -0.000263 146.8600n -0.000263 146.8700n -0.000264 146.8800n -0.000263 146.8900n -0.000263 146.9000n -0.000262 146.9100n -0.000261 146.9200n -0.000260 146.9300n -0.000259 146.9400n -0.000257 146.9500n -0.000255 146.9600n -0.000253 146.9700n -0.000250 146.9800n -0.000247 146.9900n -0.000244
+ 147.0000n -0.000241 147.0100n -0.000237 147.0200n -0.000233 147.0300n -0.000229 147.0400n -0.000225 147.0500n -0.000220 147.0600n -0.000216 147.0700n -0.000210 147.0800n -0.000205 147.0900n -0.000200 147.1000n -0.000194 147.1100n -0.000188 147.1200n -0.000182 147.1300n -0.000175 147.1400n -0.000169
+ 147.1500n -0.000162 147.1600n -0.000155 147.1700n -0.000147 147.1800n -0.000140 147.1900n -0.000132 147.2000n -0.000125 147.2100n -0.000117 147.2200n -0.000109 147.2300n -0.000100 147.2400n -0.000092 147.2500n -0.000083 147.2600n -0.000074 147.2700n -0.000065 147.2800n -0.000056 147.2900n -0.000047
+ 147.3000n -0.000038 147.3100n -0.000028 147.3200n -0.000019 147.3300n -0.000009 147.3400n 0.000000 147.3500n 0.000010 147.3600n 0.000020 147.3700n 0.000030 147.3800n 0.000040 147.3900n 0.000050 147.4000n 0.000061 147.4100n 0.000071 147.4200n 0.000081 147.4300n 0.000091 147.4400n 0.000102
+ 147.4500n 0.000112 147.4600n 0.000123 147.4700n 0.000133 147.4800n 0.000143 147.4900n 0.000154 147.5000n 0.000164 147.5100n 0.000175 147.5200n 0.000185 147.5300n 0.000195 147.5400n 0.000206 147.5500n 0.000216 147.5600n 0.000226 147.5700n 0.000236 147.5800n 0.000246 147.5900n 0.000257
+ 147.6000n 0.000266 147.6100n 0.000276 147.6200n 0.000286 147.6300n 0.000296 147.6400n 0.000306 147.6500n 0.000315 147.6600n 0.000325 147.6700n 0.000334 147.6800n 0.000343 147.6900n 0.000352 147.7000n 0.000361 147.7100n 0.000370 147.7200n 0.000378 147.7300n 0.000387 147.7400n 0.000395
+ 147.7500n 0.000404 147.7600n 0.000412 147.7700n 0.000420 147.7800n 0.000427 147.7900n 0.000435 147.8000n 0.000442 147.8100n 0.000450 147.8200n 0.000457 147.8300n 0.000463 147.8400n 0.000470 147.8500n 0.000477 147.8600n 0.000483 147.8700n 0.000489 147.8800n 0.000495 147.8900n 0.000501
+ 147.9000n 0.000506 147.9100n 0.000511 147.9200n 0.000516 147.9300n 0.000521 147.9400n 0.000526 147.9500n 0.000530 147.9600n 0.000535 147.9700n 0.000539 147.9800n 0.000542 147.9900n 0.000546 148.0000n 0.000549 148.0100n 0.000553 148.0200n 0.000556 148.0300n 0.000558 148.0400n 0.000561
+ 148.0500n 0.000563 148.0600n 0.000565 148.0700n 0.000567 148.0800n 0.000569 148.0900n 0.000570 148.1000n 0.000572 148.1100n 0.000573 148.1200n 0.000574 148.1300n 0.000574 148.1400n 0.000575 148.1500n 0.000575 148.1600n 0.000575 148.1700n 0.000575 148.1800n 0.000575 148.1900n 0.000574
+ 148.2000n 0.000573 148.2100n 0.000573 148.2200n 0.000571 148.2300n 0.000570 148.2400n 0.000569 148.2500n 0.000567 148.2600n 0.000566 148.2700n 0.000564 148.2800n 0.000562 148.2900n 0.000560 148.3000n 0.000557 148.3100n 0.000555 148.3200n 0.000552 148.3300n 0.000549 148.3400n 0.000547
+ 148.3500n 0.000544 148.3600n 0.000540 148.3700n 0.000537 148.3800n 0.000534 148.3900n 0.000531 148.4000n 0.000527 148.4100n 0.000523 148.4200n 0.000520 148.4300n 0.000516 148.4400n 0.000512 148.4500n 0.000508 148.4600n 0.000504 148.4700n 0.000500 148.4800n 0.000496 148.4900n 0.000492
+ 148.5000n 0.000488 148.5100n 0.000484 148.5200n 0.000480 148.5300n 0.000475 148.5400n 0.000471 148.5500n 0.000467 148.5600n 0.000463 148.5700n 0.000459 148.5800n 0.000454 148.5900n 0.000450 148.6000n 0.000446 148.6100n 0.000442 148.6200n 0.000438 148.6300n 0.000433 148.6400n 0.000429
+ 148.6500n 0.000425 148.6600n 0.000421 148.6700n 0.000418 148.6800n 0.000414 148.6900n 0.000410 148.7000n 0.000406 148.7100n 0.000403 148.7200n 0.000399 148.7300n 0.000396 148.7400n 0.000392 148.7500n 0.000389 148.7600n 0.000386 148.7700n 0.000383 148.7800n 0.000380 148.7900n 0.000377
+ 148.8000n 0.000375 148.8100n 0.000372 148.8200n 0.000370 148.8300n 0.000367 148.8400n 0.000365 148.8500n 0.000363 148.8600n 0.000361 148.8700n 0.000359 148.8800n 0.000358 148.8900n 0.000356 148.9000n 0.000355 148.9100n 0.000354 148.9200n 0.000353 148.9300n 0.000352 148.9400n 0.000351
+ 148.9500n 0.000351 148.9600n 0.000350 148.9700n 0.000350 148.9800n 0.000350 148.9900n 0.000350 149.0000n 0.000350 149.0100n 0.000351 149.0200n 0.000351 149.0300n 0.000352 149.0400n 0.000353 149.0500n 0.000354 149.0600n 0.000355 149.0700n 0.000356 149.0800n 0.000358 149.0900n 0.000360
+ 149.1000n 0.000361 149.1100n 0.000363 149.1200n 0.000365 149.1300n 0.000368 149.1400n 0.000370 149.1500n 0.000373 149.1600n 0.000375 149.1700n 0.000378 149.1800n 0.000381 149.1900n 0.000384 149.2000n 0.000387 149.2100n 0.000390 149.2200n 0.000394 149.2300n 0.000397 149.2400n 0.000401
+ 149.2500n 0.000405 149.2600n 0.000408 149.2700n 0.000412 149.2800n 0.000416 149.2900n 0.000420 149.3000n 0.000424 149.3100n 0.000429 149.3200n 0.000433 149.3300n 0.000437 149.3400n 0.000441 149.3500n 0.000446 149.3600n 0.000450 149.3700n 0.000455 149.3800n 0.000459 149.3900n 0.000464
+ 149.4000n 0.000468 149.4100n 0.000473 149.4200n 0.000477 149.4300n 0.000481 149.4400n 0.000486 149.4500n 0.000490 149.4600n 0.000495 149.4700n 0.000499 149.4800n 0.000503 149.4900n 0.000507 149.5000n 0.000512 149.5100n 0.000516 149.5200n 0.000520 149.5300n 0.000523 149.5400n 0.000527
+ 149.5500n 0.000531 149.5600n 0.000534 149.5700n 0.000538 149.5800n 0.000541 149.5900n 0.000544 149.6000n 0.000547 149.6100n 0.000550 149.6200n 0.000552 149.6300n 0.000555 149.6400n 0.000557 149.6500n 0.000559 149.6600n 0.000561 149.6700n 0.000563 149.6800n 0.000564 149.6900n 0.000565
+ 149.7000n 0.000566 149.7100n 0.000567 149.7200n 0.000568 149.7300n 0.000568 149.7400n 0.000568 149.7500n 0.000568 149.7600n 0.000567 149.7700n 0.000566 149.7800n 0.000565 149.7900n 0.000564 149.8000n 0.000562 149.8100n 0.000560 149.8200n 0.000557 149.8300n 0.000555 149.8400n 0.000551
+ 149.8500n 0.000548 149.8600n 0.000544 149.8700n 0.000540 149.8800n 0.000536 149.8900n 0.000531 149.9000n 0.000526 149.9100n 0.000520 149.9200n 0.000514 149.9300n 0.000508 149.9400n 0.000501 149.9500n 0.000494 149.9600n 0.000487 149.9700n 0.000479 149.9800n 0.000471 149.9900n 0.000462
+ 150.0000n 0.000453 150.0100n 0.000443 150.0200n 0.000434 150.0300n 0.000423 150.0400n 0.000413 150.0500n 0.000402 150.0600n 0.000390 150.0700n 0.000378 150.0800n 0.000366 150.0900n 0.000353 150.1000n 0.000340 150.1100n 0.000326 150.1200n 0.000312 150.1300n 0.000298 150.1400n 0.000283
+ 150.1500n 0.000268 150.1600n 0.000252 150.1700n 0.000236 150.1800n 0.000220 150.1900n 0.000203 150.2000n 0.000186 150.2100n 0.000168 150.2200n 0.000150 150.2300n 0.000132 150.2400n 0.000113 150.2500n 0.000094 150.2600n 0.000074 150.2700n 0.000054 150.2800n 0.000034 150.2900n 0.000013
+ 150.3000n -0.000008 150.3100n -0.000029 150.3200n -0.000051 150.3300n -0.000073 150.3400n -0.000095 150.3500n -0.000118 150.3600n -0.000141 150.3700n -0.000164 150.3800n -0.000188 150.3900n -0.000212 150.4000n -0.000236 150.4100n -0.000261 150.4200n -0.000285 150.4300n -0.000310 150.4400n -0.000336
+ 150.4500n -0.000361 150.4600n -0.000387 150.4700n -0.000413 150.4800n -0.000439 150.4900n -0.000465 150.5000n -0.000492 150.5100n -0.000519 150.5200n -0.000545 150.5300n -0.000572 150.5400n -0.000600 150.5500n -0.000627 150.5600n -0.000654 150.5700n -0.000682 150.5800n -0.000710 150.5900n -0.000738
+ 150.6000n -0.000765 150.6100n -0.000793 150.6200n -0.000821 150.6300n -0.000849 150.6400n -0.000877 150.6500n -0.000906 150.6600n -0.000934 150.6700n -0.000962 150.6800n -0.000990 150.6900n -0.001018 150.7000n -0.001046 150.7100n -0.001074 150.7200n -0.001102 150.7300n -0.001130 150.7400n -0.001157
+ 150.7500n -0.001185 150.7600n -0.001213 150.7700n -0.001240 150.7800n -0.001267 150.7900n -0.001294 150.8000n -0.001321 150.8100n -0.001348 150.8200n -0.001375 150.8300n -0.001401 150.8400n -0.001427 150.8500n -0.001453 150.8600n -0.001479 150.8700n -0.001505 150.8800n -0.001530 150.8900n -0.001555
+ 150.9000n -0.001580 150.9100n -0.001604 150.9200n -0.001628 150.9300n -0.001652 150.9400n -0.001675 150.9500n -0.001699 150.9600n -0.001721 150.9700n -0.001744 150.9800n -0.001766 150.9900n -0.001788 151.0000n -0.001809 151.0100n -0.001830 151.0200n -0.001851 151.0300n -0.001871 151.0400n -0.001891
+ 151.0500n -0.001910 151.0600n -0.001929 151.0700n -0.001947 151.0800n -0.001965 151.0900n -0.001983 151.1000n -0.002000 151.1100n -0.002017 151.1200n -0.002033 151.1300n -0.002048 151.1400n -0.002064 151.1500n -0.002078 151.1600n -0.002093 151.1700n -0.002106 151.1800n -0.002119 151.1900n -0.002132
+ 151.2000n -0.002144 151.2100n -0.002156 151.2200n -0.002167 151.2300n -0.002178 151.2400n -0.002188 151.2500n -0.002197 151.2600n -0.002206 151.2700n -0.002215 151.2800n -0.002223 151.2900n -0.002230 151.3000n -0.002237 151.3100n -0.002243 151.3200n -0.002249 151.3300n -0.002254 151.3400n -0.002259
+ 151.3500n -0.002263 151.3600n -0.002267 151.3700n -0.002270 151.3800n -0.002272 151.3900n -0.002274 151.4000n -0.002276 151.4100n -0.002277 151.4200n -0.002277 151.4300n -0.002277 151.4400n -0.002276 151.4500n -0.002275 151.4600n -0.002273 151.4700n -0.002271 151.4800n -0.002268 151.4900n -0.002264
+ 151.5000n -0.002261 151.5100n -0.002256 151.5200n -0.002251 151.5300n -0.002246 151.5400n -0.002240 151.5500n -0.002234 151.5600n -0.002227 151.5700n -0.002220 151.5800n -0.002212 151.5900n -0.002204 151.6000n -0.002195 151.6100n -0.002186 151.6200n -0.002176 151.6300n -0.002166 151.6400n -0.002156
+ 151.6500n -0.002145 151.6600n -0.002134 151.6700n -0.002122 151.6800n -0.002110 151.6900n -0.002097 151.7000n -0.002085 151.7100n -0.002071 151.7200n -0.002058 151.7300n -0.002044 151.7400n -0.002029 151.7500n -0.002015 151.7600n -0.002000 151.7700n -0.001984 151.7800n -0.001968 151.7900n -0.001952
+ 151.8000n -0.001936 151.8100n -0.001919 151.8200n -0.001903 151.8300n -0.001885 151.8400n -0.001868 151.8500n -0.001850 151.8600n -0.001832 151.8700n -0.001814 151.8800n -0.001795 151.8900n -0.001777 151.9000n -0.001758 151.9100n -0.001738 151.9200n -0.001719 151.9300n -0.001699 151.9400n -0.001680
+ 151.9500n -0.001660 151.9600n -0.001639 151.9700n -0.001619 151.9800n -0.001599 151.9900n -0.001578 152.0000n -0.001557 152.0100n -0.001536 152.0200n -0.001515 152.0300n -0.001494 152.0400n -0.001472 152.0500n -0.001451 152.0600n -0.001429 152.0700n -0.001407 152.0800n -0.001386 152.0900n -0.001364
+ 152.1000n -0.001342 152.1100n -0.001320 152.1200n -0.001297 152.1300n -0.001275 152.1400n -0.001253 152.1500n -0.001230 152.1600n -0.001208 152.1700n -0.001185 152.1800n -0.001163 152.1900n -0.001140 152.2000n -0.001117 152.2100n -0.001095 152.2200n -0.001072 152.2300n -0.001049 152.2400n -0.001026
+ 152.2500n -0.001003 152.2600n -0.000980 152.2700n -0.000957 152.2800n -0.000934 152.2900n -0.000911 152.3000n -0.000888 152.3100n -0.000865 152.3200n -0.000842 152.3300n -0.000818 152.3400n -0.000795 152.3500n -0.000772 152.3600n -0.000749 152.3700n -0.000725 152.3800n -0.000702 152.3900n -0.000678
+ 152.4000n -0.000655 152.4100n -0.000631 152.4200n -0.000608 152.4300n -0.000584 152.4400n -0.000561 152.4500n -0.000537 152.4600n -0.000513 152.4700n -0.000489 152.4800n -0.000466 152.4900n -0.000442 152.5000n -0.000418 152.5100n -0.000394 152.5200n -0.000370 152.5300n -0.000345 152.5400n -0.000321
+ 152.5500n -0.000297 152.5600n -0.000272 152.5700n -0.000248 152.5800n -0.000223 152.5900n -0.000198 152.6000n -0.000173 152.6100n -0.000148 152.6200n -0.000123 152.6300n -0.000098 152.6400n -0.000072 152.6500n -0.000047 152.6600n -0.000021 152.6700n 0.000005 152.6800n 0.000031 152.6900n 0.000057
+ 152.7000n 0.000083 152.7100n 0.000109 152.7200n 0.000136 152.7300n 0.000163 152.7400n 0.000190 152.7500n 0.000217 152.7600n 0.000245 152.7700n 0.000272 152.7800n 0.000300 152.7900n 0.000328 152.8000n 0.000356 152.8100n 0.000385 152.8200n 0.000413 152.8300n 0.000442 152.8400n 0.000472
+ 152.8500n 0.000501 152.8600n 0.000531 152.8700n 0.000561 152.8800n 0.000591 152.8900n 0.000621 152.9000n 0.000652 152.9100n 0.000683 152.9200n 0.000714 152.9300n 0.000746 152.9400n 0.000778 152.9500n 0.000810 152.9600n 0.000842 152.9700n 0.000875 152.9800n 0.000908 152.9900n 0.000941
+ 153.0000n 0.000975 153.0100n 0.001009 153.0200n 0.001043 153.0300n 0.001077 153.0400n 0.001112 153.0500n 0.001147 153.0600n 0.001182 153.0700n 0.001218 153.0800n 0.001254 153.0900n 0.001290 153.1000n 0.001326 153.1100n 0.001363 153.1200n 0.001400 153.1300n 0.001438 153.1400n 0.001475
+ 153.1500n 0.001513 153.1600n 0.001551 153.1700n 0.001590 153.1800n 0.001628 153.1900n 0.001667 153.2000n 0.001706 153.2100n 0.001746 153.2200n 0.001786 153.2300n 0.001825 153.2400n 0.001866 153.2500n 0.001906 153.2600n 0.001946 153.2700n 0.001987 153.2800n 0.002028 153.2900n 0.002069
+ 153.3000n 0.002110 153.3100n 0.002152 153.3200n 0.002193 153.3300n 0.002235 153.3400n 0.002277 153.3500n 0.002319 153.3600n 0.002361 153.3700n 0.002403 153.3800n 0.002445 153.3900n 0.002488 153.4000n 0.002530 153.4100n 0.002572 153.4200n 0.002615 153.4300n 0.002657 153.4400n 0.002700
+ 153.4500n 0.002742 153.4600n 0.002784 153.4700n 0.002826 153.4800n 0.002869 153.4900n 0.002911 153.5000n 0.002952 153.5100n 0.002994 153.5200n 0.003036 153.5300n 0.003077 153.5400n 0.003119 153.5500n 0.003160 153.5600n 0.003201 153.5700n 0.003241 153.5800n 0.003282 153.5900n 0.003322
+ 153.6000n 0.003361 153.6100n 0.003401 153.6200n 0.003440 153.6300n 0.003478 153.6400n 0.003517 153.6500n 0.003555 153.6600n 0.003592 153.6700n 0.003629 153.6800n 0.003665 153.6900n 0.003701 153.7000n 0.003737 153.7100n 0.003772 153.7200n 0.003806 153.7300n 0.003840 153.7400n 0.003873
+ 153.7500n 0.003905 153.7600n 0.003937 153.7700n 0.003968 153.7800n 0.003999 153.7900n 0.004028 153.8000n 0.004057 153.8100n 0.004085 153.8200n 0.004113 153.8300n 0.004139 153.8400n 0.004165 153.8500n 0.004190 153.8600n 0.004214 153.8700n 0.004237 153.8800n 0.004259 153.8900n 0.004280
+ 153.9000n 0.004300 153.9100n 0.004319 153.9200n 0.004338 153.9300n 0.004355 153.9400n 0.004371 153.9500n 0.004386 153.9600n 0.004400 153.9700n 0.004413 153.9800n 0.004424 153.9900n 0.004435 154.0000n 0.004444 154.0100n 0.004453 154.0200n 0.004460 154.0300n 0.004465 154.0400n 0.004470
+ 154.0500n 0.004473 154.0600n 0.004476 154.0700n 0.004476 154.0800n 0.004476 154.0900n 0.004474 154.1000n 0.004471 154.1100n 0.004467 154.1200n 0.004461 154.1300n 0.004454 154.1400n 0.004445 154.1500n 0.004436 154.1600n 0.004424 154.1700n 0.004412 154.1800n 0.004398 154.1900n 0.004382
+ 154.2000n 0.004366 154.2100n 0.004348 154.2200n 0.004328 154.2300n 0.004307 154.2400n 0.004285 154.2500n 0.004261 154.2600n 0.004235 154.2700n 0.004209 154.2800n 0.004181 154.2900n 0.004151 154.3000n 0.004120 154.3100n 0.004088 154.3200n 0.004054 154.3300n 0.004019 154.3400n 0.003982
+ 154.3500n 0.003944 154.3600n 0.003904 154.3700n 0.003864 154.3800n 0.003821 154.3900n 0.003778 154.4000n 0.003733 154.4100n 0.003687 154.4200n 0.003639 154.4300n 0.003590 154.4400n 0.003540 154.4500n 0.003488 154.4600n 0.003435 154.4700n 0.003381 154.4800n 0.003325 154.4900n 0.003269
+ 154.5000n 0.003211 154.5100n 0.003152 154.5200n 0.003091 154.5300n 0.003030 154.5400n 0.002967 154.5500n 0.002903 154.5600n 0.002839 154.5700n 0.002773 154.5800n 0.002706 154.5900n 0.002638 154.6000n 0.002569 154.6100n 0.002499 154.6200n 0.002428 154.6300n 0.002356 154.6400n 0.002283
+ 154.6500n 0.002209 154.6600n 0.002135 154.6700n 0.002060 154.6800n 0.001984 154.6900n 0.001907 154.7000n 0.001829 154.7100n 0.001751 154.7200n 0.001672 154.7300n 0.001593 154.7400n 0.001513 154.7500n 0.001432 154.7600n 0.001351 154.7700n 0.001270 154.7800n 0.001188 154.7900n 0.001106
+ 154.8000n 0.001023 154.8100n 0.000940 154.8200n 0.000857 154.8300n 0.000773 154.8400n 0.000689 154.8500n 0.000605 154.8600n 0.000521 154.8700n 0.000437 154.8800n 0.000353 154.8900n 0.000269 154.9000n 0.000185 154.9100n 0.000101 154.9200n 0.000017 154.9300n -0.000067 154.9400n -0.000151
+ 154.9500n -0.000234 154.9600n -0.000317 154.9700n -0.000400 154.9800n -0.000482 154.9900n -0.000564 155.0000n -0.000646 155.0100n -0.000727 155.0200n -0.000807 155.0300n -0.000887 155.0400n -0.000967 155.0500n -0.001046 155.0600n -0.001124 155.0700n -0.001201 155.0800n -0.001277 155.0900n -0.001353
+ 155.1000n -0.001428 155.1100n -0.001502 155.1200n -0.001575 155.1300n -0.001647 155.1400n -0.001718 155.1500n -0.001789 155.1600n -0.001858 155.1700n -0.001926 155.1800n -0.001992 155.1900n -0.002058 155.2000n -0.002122 155.2100n -0.002185 155.2200n -0.002247 155.2300n -0.002308 155.2400n -0.002367
+ 155.2500n -0.002425 155.2600n -0.002481 155.2700n -0.002536 155.2800n -0.002590 155.2900n -0.002642 155.3000n -0.002692 155.3100n -0.002741 155.3200n -0.002789 155.3300n -0.002834 155.3400n -0.002878 155.3500n -0.002921 155.3600n -0.002962 155.3700n -0.003001 155.3800n -0.003038 155.3900n -0.003074
+ 155.4000n -0.003108 155.4100n -0.003140 155.4200n -0.003170 155.4300n -0.003199 155.4400n -0.003226 155.4500n -0.003250 155.4600n -0.003274 155.4700n -0.003295 155.4800n -0.003314 155.4900n -0.003331 155.5000n -0.003347 155.5100n -0.003361 155.5200n -0.003372 155.5300n -0.003382 155.5400n -0.003390
+ 155.5500n -0.003396 155.5600n -0.003400 155.5700n -0.003402 155.5800n -0.003402 155.5900n -0.003401 155.6000n -0.003397 155.6100n -0.003391 155.6200n -0.003384 155.6300n -0.003375 155.6400n -0.003363 155.6500n -0.003350 155.6600n -0.003335 155.6700n -0.003318 155.6800n -0.003299 155.6900n -0.003279
+ 155.7000n -0.003256 155.7100n -0.003232 155.7200n -0.003206 155.7300n -0.003178 155.7400n -0.003148 155.7500n -0.003116 155.7600n -0.003083 155.7700n -0.003048 155.7800n -0.003012 155.7900n -0.002973 155.8000n -0.002933 155.8100n -0.002892 155.8200n -0.002848 155.8300n -0.002804 155.8400n -0.002757
+ 155.8500n -0.002709 155.8600n -0.002660 155.8700n -0.002609 155.8800n -0.002557 155.8900n -0.002503 155.9000n -0.002448 155.9100n -0.002392 155.9200n -0.002334 155.9300n -0.002275 155.9400n -0.002215 155.9500n -0.002153 155.9600n -0.002091 155.9700n -0.002027 155.9800n -0.001962 155.9900n -0.001897
+ 156.0000n -0.001830 156.0100n -0.001762 156.0200n -0.001693 156.0300n -0.001623 156.0400n -0.001553 156.0500n -0.001482 156.0600n -0.001410 156.0700n -0.001337 156.0800n -0.001263 156.0900n -0.001189 156.1000n -0.001114 156.1100n -0.001039 156.1200n -0.000963 156.1300n -0.000887 156.1400n -0.000810
+ 156.1500n -0.000733 156.1600n -0.000656 156.1700n -0.000578 156.1800n -0.000501 156.1900n -0.000422 156.2000n -0.000344 156.2100n -0.000266 156.2200n -0.000187 156.2300n -0.000109 156.2400n -0.000031 156.2500n 0.000048 156.2600n 0.000126 156.2700n 0.000204 156.2800n 0.000282 156.2900n 0.000359
+ 156.3000n 0.000436 156.3100n 0.000513 156.3200n 0.000590 156.3300n 0.000666 156.3400n 0.000742 156.3500n 0.000817 156.3600n 0.000891 156.3700n 0.000965 156.3800n 0.001039 156.3900n 0.001111 156.4000n 0.001183 156.4100n 0.001254 156.4200n 0.001325 156.4300n 0.001394 156.4400n 0.001463
+ 156.4500n 0.001531 156.4600n 0.001598 156.4700n 0.001664 156.4800n 0.001728 156.4900n 0.001792 156.5000n 0.001855 156.5100n 0.001917 156.5200n 0.001977 156.5300n 0.002036 156.5400n 0.002094 156.5500n 0.002151 156.5600n 0.002207 156.5700n 0.002261 156.5800n 0.002314 156.5900n 0.002366
+ 156.6000n 0.002416 156.6100n 0.002465 156.6200n 0.002512 156.6300n 0.002558 156.6400n 0.002603 156.6500n 0.002646 156.6600n 0.002688 156.6700n 0.002728 156.6800n 0.002766 156.6900n 0.002803 156.7000n 0.002839 156.7100n 0.002872 156.7200n 0.002905 156.7300n 0.002935 156.7400n 0.002964
+ 156.7500n 0.002992 156.7600n 0.003018 156.7700n 0.003042 156.7800n 0.003064 156.7900n 0.003085 156.8000n 0.003104 156.8100n 0.003122 156.8200n 0.003138 156.8300n 0.003152 156.8400n 0.003165 156.8500n 0.003176 156.8600n 0.003185 156.8700n 0.003193 156.8800n 0.003199 156.8900n 0.003203
+ 156.9000n 0.003206 156.9100n 0.003207 156.9200n 0.003206 156.9300n 0.003204 156.9400n 0.003200 156.9500n 0.003195 156.9600n 0.003188 156.9700n 0.003180 156.9800n 0.003170 156.9900n 0.003158 157.0000n 0.003145 157.0100n 0.003130 157.0200n 0.003114 157.0300n 0.003097 157.0400n 0.003078
+ 157.0500n 0.003058 157.0600n 0.003036 157.0700n 0.003013 157.0800n 0.002988 157.0900n 0.002962 157.1000n 0.002935 157.1100n 0.002907 157.1200n 0.002877 157.1300n 0.002846 157.1400n 0.002814 157.1500n 0.002781 157.1600n 0.002746 157.1700n 0.002711 157.1800n 0.002674 157.1900n 0.002636
+ 157.2000n 0.002597 157.2100n 0.002558 157.2200n 0.002517 157.2300n 0.002475 157.2400n 0.002433 157.2500n 0.002389 157.2600n 0.002345 157.2700n 0.002300 157.2800n 0.002254 157.2900n 0.002208 157.3000n 0.002161 157.3100n 0.002113 157.3200n 0.002064 157.3300n 0.002015 157.3400n 0.001966
+ 157.3500n 0.001915 157.3600n 0.001865 157.3700n 0.001814 157.3800n 0.001762 157.3900n 0.001710 157.4000n 0.001658 157.4100n 0.001605 157.4200n 0.001553 157.4300n 0.001500 157.4400n 0.001446 157.4500n 0.001393 157.4600n 0.001339 157.4700n 0.001286 157.4800n 0.001232 157.4900n 0.001178
+ 157.5000n 0.001125 157.5100n 0.001071 157.5200n 0.001018 157.5300n 0.000964 157.5400n 0.000911 157.5500n 0.000858 157.5600n 0.000805 157.5700n 0.000752 157.5800n 0.000700 157.5900n 0.000648 157.6000n 0.000596 157.6100n 0.000544 157.6200n 0.000493 157.6300n 0.000443 157.6400n 0.000393
+ 157.6500n 0.000343 157.6600n 0.000294 157.6700n 0.000245 157.6800n 0.000197 157.6900n 0.000150 157.7000n 0.000103 157.7100n 0.000057 157.7200n 0.000012 157.7300n -0.000033 157.7400n -0.000077 157.7500n -0.000121 157.7600n -0.000163 157.7700n -0.000205 157.7800n -0.000246 157.7900n -0.000287
+ 157.8000n -0.000326 157.8100n -0.000365 157.8200n -0.000403 157.8300n -0.000440 157.8400n -0.000476 157.8500n -0.000511 157.8600n -0.000545 157.8700n -0.000578 157.8800n -0.000611 157.8900n -0.000642 157.9000n -0.000672 157.9100n -0.000702 157.9200n -0.000730 157.9300n -0.000758 157.9400n -0.000785
+ 157.9500n -0.000810 157.9600n -0.000835 157.9700n -0.000858 157.9800n -0.000881 157.9900n -0.000903 158.0000n -0.000923 158.0100n -0.000943 158.0200n -0.000962 158.0300n -0.000979 158.0400n -0.000996 158.0500n -0.001011 158.0600n -0.001026 158.0700n -0.001040 158.0800n -0.001052 158.0900n -0.001064
+ 158.1000n -0.001075 158.1100n -0.001085 158.1200n -0.001094 158.1300n -0.001102 158.1400n -0.001109 158.1500n -0.001115 158.1600n -0.001120 158.1700n -0.001124 158.1800n -0.001128 158.1900n -0.001130 158.2000n -0.001132 158.2100n -0.001133 158.2200n -0.001133 158.2300n -0.001132 158.2400n -0.001130
+ 158.2500n -0.001128 158.2600n -0.001125 158.2700n -0.001121 158.2800n -0.001117 158.2900n -0.001111 158.3000n -0.001105 158.3100n -0.001099 158.3200n -0.001091 158.3300n -0.001084 158.3400n -0.001075 158.3500n -0.001066 158.3600n -0.001057 158.3700n -0.001046 158.3800n -0.001036 158.3900n -0.001025
+ 158.4000n -0.001013 158.4100n -0.001001 158.4200n -0.000989 158.4300n -0.000976 158.4400n -0.000962 158.4500n -0.000949 158.4600n -0.000935 158.4700n -0.000921 158.4800n -0.000906 158.4900n -0.000891 158.5000n -0.000876 158.5100n -0.000861 158.5200n -0.000846 158.5300n -0.000830 158.5400n -0.000815
+ 158.5500n -0.000799 158.5600n -0.000783 158.5700n -0.000767 158.5800n -0.000751 158.5900n -0.000735 158.6000n -0.000719 158.6100n -0.000703 158.6200n -0.000687 158.6300n -0.000671 158.6400n -0.000655 158.6500n -0.000640 158.6600n -0.000624 158.6700n -0.000609 158.6800n -0.000594 158.6900n -0.000579
+ 158.7000n -0.000564 158.7100n -0.000549 158.7200n -0.000535 158.7300n -0.000521 158.7400n -0.000507 158.7500n -0.000494 158.7600n -0.000481 158.7700n -0.000468 158.7800n -0.000456 158.7900n -0.000444 158.8000n -0.000433 158.8100n -0.000421 158.8200n -0.000411 158.8300n -0.000401 158.8400n -0.000391
+ 158.8500n -0.000381 158.8600n -0.000373 158.8700n -0.000364 158.8800n -0.000356 158.8900n -0.000349 158.9000n -0.000342 158.9100n -0.000336 158.9200n -0.000330 158.9300n -0.000325 158.9400n -0.000321 158.9500n -0.000317 158.9600n -0.000313 158.9700n -0.000311 158.9800n -0.000308 158.9900n -0.000307
+ 159.0000n -0.000306 159.0100n -0.000305 159.0200n -0.000305 159.0300n -0.000306 159.0400n -0.000307 159.0500n -0.000309 159.0600n -0.000312 159.0700n -0.000315 159.0800n -0.000319 159.0900n -0.000323 159.1000n -0.000328 159.1100n -0.000334 159.1200n -0.000340 159.1300n -0.000347 159.1400n -0.000354
+ 159.1500n -0.000362 159.1600n -0.000370 159.1700n -0.000379 159.1800n -0.000389 159.1900n -0.000399 159.2000n -0.000410 159.2100n -0.000421 159.2200n -0.000433 159.2300n -0.000445 159.2400n -0.000458 159.2500n -0.000471 159.2600n -0.000485 159.2700n -0.000499 159.2800n -0.000514 159.2900n -0.000529
+ 159.3000n -0.000545 159.3100n -0.000561 159.3200n -0.000577 159.3300n -0.000594 159.3400n -0.000611 159.3500n -0.000628 159.3600n -0.000646 159.3700n -0.000665 159.3800n -0.000683 159.3900n -0.000702 159.4000n -0.000721 159.4100n -0.000740 159.4200n -0.000760 159.4300n -0.000780 159.4400n -0.000800
+ 159.4500n -0.000820 159.4600n -0.000841 159.4700n -0.000861 159.4800n -0.000882 159.4900n -0.000903 159.5000n -0.000924 159.5100n -0.000945 159.5200n -0.000966 159.5300n -0.000987 159.5400n -0.001008 159.5500n -0.001029 159.5600n -0.001051 159.5700n -0.001072 159.5800n -0.001093 159.5900n -0.001114
+ 159.6000n -0.001135 159.6100n -0.001156 159.6200n -0.001176 159.6300n -0.001197 159.6400n -0.001217 159.6500n -0.001238 159.6600n -0.001258 159.6700n -0.001278 159.6800n -0.001297 159.6900n -0.001317 159.7000n -0.001336 159.7100n -0.001355 159.7200n -0.001373 159.7300n -0.001391 159.7400n -0.001409
+ 159.7500n -0.001427 159.7600n -0.001444 159.7700n -0.001461 159.7800n -0.001477 159.7900n -0.001493 159.8000n -0.001509 159.8100n -0.001524 159.8200n -0.001539 159.8300n -0.001553 159.8400n -0.001567 159.8500n -0.001581 159.8600n -0.001593 159.8700n -0.001606 159.8800n -0.001618 159.8900n -0.001629
+ 159.9000n -0.001640 159.9100n -0.001650 159.9200n -0.001660 159.9300n -0.001669 159.9400n -0.001677 159.9500n -0.001685 159.9600n -0.001693 159.9700n -0.001699 159.9800n -0.001706 159.9900n -0.001711 160.0000n -0.001716 160.0100n -0.001721 160.0200n -0.001724 160.0300n -0.001728 160.0400n -0.001730
+ 160.0500n -0.001732 160.0600n -0.001733 160.0700n -0.001734 160.0800n -0.001734 160.0900n -0.001733 160.1000n -0.001732 160.1100n -0.001730 160.1200n -0.001728 160.1300n -0.001725 160.1400n -0.001721 160.1500n -0.001717 160.1600n -0.001712 160.1700n -0.001706 160.1800n -0.001700 160.1900n -0.001693
+ 160.2000n -0.001686 160.2100n -0.001678 160.2200n -0.001669 160.2300n -0.001660 160.2400n -0.001651 160.2500n -0.001640 160.2600n -0.001629 160.2700n -0.001618 160.2800n -0.001606 160.2900n -0.001594 160.3000n -0.001581 160.3100n -0.001567 160.3200n -0.001554 160.3300n -0.001539 160.3400n -0.001524
+ 160.3500n -0.001509 160.3600n -0.001493 160.3700n -0.001477 160.3800n -0.001460 160.3900n -0.001443 160.4000n -0.001426 160.4100n -0.001408 160.4200n -0.001389 160.4300n -0.001371 160.4400n -0.001352 160.4500n -0.001333 160.4600n -0.001313 160.4700n -0.001293 160.4800n -0.001273 160.4900n -0.001252
+ 160.5000n -0.001232 160.5100n -0.001211 160.5200n -0.001189 160.5300n -0.001168 160.5400n -0.001146 160.5500n -0.001124 160.5600n -0.001102 160.5700n -0.001080 160.5800n -0.001058 160.5900n -0.001036 160.6000n -0.001013 160.6100n -0.000991 160.6200n -0.000968 160.6300n -0.000945 160.6400n -0.000922
+ 160.6500n -0.000900 160.6600n -0.000877 160.6700n -0.000854 160.6800n -0.000831 160.6900n -0.000809 160.7000n -0.000786 160.7100n -0.000763 160.7200n -0.000741 160.7300n -0.000718 160.7400n -0.000696 160.7500n -0.000674 160.7600n -0.000652 160.7700n -0.000630 160.7800n -0.000608 160.7900n -0.000586
+ 160.8000n -0.000565 160.8100n -0.000544 160.8200n -0.000523 160.8300n -0.000502 160.8400n -0.000481 160.8500n -0.000461 160.8600n -0.000441 160.8700n -0.000421 160.8800n -0.000401 160.8900n -0.000382 160.9000n -0.000363 160.9100n -0.000345 160.9200n -0.000326 160.9300n -0.000308 160.9400n -0.000291
+ 160.9500n -0.000273 160.9600n -0.000256 160.9700n -0.000240 160.9800n -0.000223 160.9900n -0.000208 161.0000n -0.000192 161.0100n -0.000177 161.0200n -0.000162 161.0300n -0.000148 161.0400n -0.000134 161.0500n -0.000120 161.0600n -0.000107 161.0700n -0.000094 161.0800n -0.000082 161.0900n -0.000070
+ 161.1000n -0.000058 161.1100n -0.000047 161.1200n -0.000036 161.1300n -0.000026 161.1400n -0.000016 161.1500n -0.000006 161.1600n 0.000003 161.1700n 0.000011 161.1800n 0.000020 161.1900n 0.000028 161.2000n 0.000035 161.2100n 0.000042 161.2200n 0.000049 161.2300n 0.000055 161.2400n 0.000061
+ 161.2500n 0.000067 161.2600n 0.000072 161.2700n 0.000077 161.2800n 0.000081 161.2900n 0.000085 161.3000n 0.000089 161.3100n 0.000092 161.3200n 0.000096 161.3300n 0.000098 161.3400n 0.000101 161.3500n 0.000103 161.3600n 0.000104 161.3700n 0.000106 161.3800n 0.000107 161.3900n 0.000108
+ 161.4000n 0.000108 161.4100n 0.000109 161.4200n 0.000109 161.4300n 0.000108 161.4400n 0.000108 161.4500n 0.000107 161.4600n 0.000106 161.4700n 0.000105 161.4800n 0.000104 161.4900n 0.000102 161.5000n 0.000101 161.5100n 0.000099 161.5200n 0.000097 161.5300n 0.000094 161.5400n 0.000092
+ 161.5500n 0.000089 161.5600n 0.000087 161.5700n 0.000084 161.5800n 0.000081 161.5900n 0.000078 161.6000n 0.000075 161.6100n 0.000072 161.6200n 0.000069 161.6300n 0.000066 161.6400n 0.000063 161.6500n 0.000059 161.6600n 0.000056 161.6700n 0.000053 161.6800n 0.000050 161.6900n 0.000046
+ 161.7000n 0.000043 161.7100n 0.000040 161.7200n 0.000037 161.7300n 0.000034 161.7400n 0.000031 161.7500n 0.000028 161.7600n 0.000025 161.7700n 0.000022 161.7800n 0.000019 161.7900n 0.000017 161.8000n 0.000014 161.8100n 0.000012 161.8200n 0.000010 161.8300n 0.000008 161.8400n 0.000006
+ 161.8500n 0.000004 161.8600n 0.000002 161.8700n 0.000001 161.8800n -0.000001 161.8900n -0.000002 161.9000n -0.000003 161.9100n -0.000004 161.9200n -0.000004 161.9300n -0.000005 161.9400n -0.000005 161.9500n -0.000005 161.9600n -0.000005 161.9700n -0.000004 161.9800n -0.000004 161.9900n -0.000003
+ 162.0000n -0.000002 162.0100n -0.000001 162.0200n 0.000001 162.0300n 0.000002 162.0400n 0.000004 162.0500n 0.000006 162.0600n 0.000009 162.0700n 0.000011 162.0800n 0.000014 162.0900n 0.000017 162.1000n 0.000020 162.1100n 0.000023 162.1200n 0.000027 162.1300n 0.000030 162.1400n 0.000034
+ 162.1500n 0.000038 162.1600n 0.000043 162.1700n 0.000047 162.1800n 0.000052 162.1900n 0.000057 162.2000n 0.000062 162.2100n 0.000067 162.2200n 0.000072 162.2300n 0.000078 162.2400n 0.000083 162.2500n 0.000089 162.2600n 0.000095 162.2700n 0.000101 162.2800n 0.000107 162.2900n 0.000114
+ 162.3000n 0.000120 162.3100n 0.000127 162.3200n 0.000133 162.3300n 0.000140 162.3400n 0.000147 162.3500n 0.000153 162.3600n 0.000160 162.3700n 0.000167 162.3800n 0.000174 162.3900n 0.000181 162.4000n 0.000188 162.4100n 0.000195 162.4200n 0.000202 162.4300n 0.000209 162.4400n 0.000216
+ 162.4500n 0.000223 162.4600n 0.000230 162.4700n 0.000236 162.4800n 0.000243 162.4900n 0.000250 162.5000n 0.000256 162.5100n 0.000263 162.5200n 0.000269 162.5300n 0.000275 162.5400n 0.000281 162.5500n 0.000287 162.5600n 0.000293 162.5700n 0.000299 162.5800n 0.000304 162.5900n 0.000309
+ 162.6000n 0.000315 162.6100n 0.000319 162.6200n 0.000324 162.6300n 0.000328 162.6400n 0.000333 162.6500n 0.000337 162.6600n 0.000340 162.6700n 0.000344 162.6800n 0.000347 162.6900n 0.000350 162.7000n 0.000353 162.7100n 0.000355 162.7200n 0.000357 162.7300n 0.000359 162.7400n 0.000360
+ 162.7500n 0.000361 162.7600n 0.000362 162.7700n 0.000362 162.7800n 0.000362 162.7900n 0.000362 162.8000n 0.000361 162.8100n 0.000360 162.8200n 0.000359 162.8300n 0.000357 162.8400n 0.000355 162.8500n 0.000352 162.8600n 0.000349 162.8700n 0.000346 162.8800n 0.000342 162.8900n 0.000338
+ 162.9000n 0.000333 162.9100n 0.000328 162.9200n 0.000323 162.9300n 0.000317 162.9400n 0.000311 162.9500n 0.000304 162.9600n 0.000297 162.9700n 0.000290 162.9800n 0.000282 162.9900n 0.000274 163.0000n 0.000265 163.0100n 0.000256 163.0200n 0.000247 163.0300n 0.000237 163.0400n 0.000227
+ 163.0500n 0.000216 163.0600n 0.000205 163.0700n 0.000194 163.0800n 0.000182 163.0900n 0.000170 163.1000n 0.000158 163.1100n 0.000145 163.1200n 0.000132 163.1300n 0.000118 163.1400n 0.000104 163.1500n 0.000090 163.1600n 0.000075 163.1700n 0.000061 163.1800n 0.000045 163.1900n 0.000030
+ 163.2000n 0.000014 163.2100n -0.000002 163.2200n -0.000018 163.2300n -0.000035 163.2400n -0.000051 163.2500n -0.000068 163.2600n -0.000086 163.2700n -0.000103 163.2800n -0.000121 163.2900n -0.000138 163.3000n -0.000156 163.3100n -0.000175 163.3200n -0.000193 163.3300n -0.000211 163.3400n -0.000230
+ 163.3500n -0.000248 163.3600n -0.000267 163.3700n -0.000286 163.3800n -0.000305 163.3900n -0.000324 163.4000n -0.000343 163.4100n -0.000362 163.4200n -0.000381 163.4300n -0.000400 163.4400n -0.000419 163.4500n -0.000437 163.4600n -0.000456 163.4700n -0.000475 163.4800n -0.000494 163.4900n -0.000512
+ 163.5000n -0.000530 163.5100n -0.000549 163.5200n -0.000567 163.5300n -0.000585 163.5400n -0.000602 163.5500n -0.000620 163.5600n -0.000637 163.5700n -0.000654 163.5800n -0.000671 163.5900n -0.000688 163.6000n -0.000704 163.6100n -0.000720 163.6200n -0.000735 163.6300n -0.000751 163.6400n -0.000765
+ 163.6500n -0.000780 163.6600n -0.000794 163.6700n -0.000808 163.6800n -0.000821 163.6900n -0.000834 163.7000n -0.000847 163.7100n -0.000859 163.7200n -0.000871 163.7300n -0.000882 163.7400n -0.000892 163.7500n -0.000903 163.7600n -0.000912 163.7700n -0.000921 163.7800n -0.000930 163.7900n -0.000938
+ 163.8000n -0.000945 163.8100n -0.000952 163.8200n -0.000959 163.8300n -0.000964 163.8400n -0.000970 163.8500n -0.000974 163.8600n -0.000978 163.8700n -0.000981 163.8800n -0.000984 163.8900n -0.000986 163.9000n -0.000987 163.9100n -0.000988 163.9200n -0.000988 163.9300n -0.000988 163.9400n -0.000987
+ 163.9500n -0.000985 163.9600n -0.000982 163.9700n -0.000979 163.9800n -0.000975 163.9900n -0.000970 164.0000n -0.000965 164.0100n -0.000959 164.0200n -0.000952 164.0300n -0.000945 164.0400n -0.000937 164.0500n -0.000928 164.0600n -0.000919 164.0700n -0.000909 164.0800n -0.000898 164.0900n -0.000887
+ 164.1000n -0.000874 164.1100n -0.000862 164.1200n -0.000848 164.1300n -0.000834 164.1400n -0.000819 164.1500n -0.000804 164.1600n -0.000788 164.1700n -0.000771 164.1800n -0.000754 164.1900n -0.000736 164.2000n -0.000718 164.2100n -0.000698 164.2200n -0.000679 164.2300n -0.000658 164.2400n -0.000638
+ 164.2500n -0.000616 164.2600n -0.000594 164.2700n -0.000572 164.2800n -0.000549 164.2900n -0.000525 164.3000n -0.000501 164.3100n -0.000477 164.3200n -0.000452 164.3300n -0.000426 164.3400n -0.000400 164.3500n -0.000374 164.3600n -0.000347 164.3700n -0.000320 164.3800n -0.000293 164.3900n -0.000265
+ 164.4000n -0.000237 164.4100n -0.000208 164.4200n -0.000180 164.4300n -0.000150 164.4400n -0.000121 164.4500n -0.000091 164.4600n -0.000062 164.4700n -0.000032 164.4800n -0.000001 164.4900n 0.000029 164.5000n 0.000060 164.5100n 0.000091 164.5200n 0.000121 164.5300n 0.000152 164.5400n 0.000183
+ 164.5500n 0.000215 164.5600n 0.000246 164.5700n 0.000277 164.5800n 0.000308 164.5900n 0.000339 164.6000n 0.000370 164.6100n 0.000402 164.6200n 0.000433 164.6300n 0.000463 164.6400n 0.000494 164.6500n 0.000525 164.6600n 0.000555 164.6700n 0.000586 164.6800n 0.000616 164.6900n 0.000646
+ 164.7000n 0.000675 164.7100n 0.000705 164.7200n 0.000734 164.7300n 0.000762 164.7400n 0.000791 164.7500n 0.000819 164.7600n 0.000847 164.7700n 0.000874 164.7800n 0.000901 164.7900n 0.000928 164.8000n 0.000954 164.8100n 0.000980 164.8200n 0.001005 164.8300n 0.001030 164.8400n 0.001054
+ 164.8500n 0.001078 164.8600n 0.001101 164.8700n 0.001124 164.8800n 0.001146 164.8900n 0.001168 164.9000n 0.001189 164.9100n 0.001209 164.9200n 0.001229 164.9300n 0.001248 164.9400n 0.001267 164.9500n 0.001285 164.9600n 0.001302 164.9700n 0.001318 164.9800n 0.001334 164.9900n 0.001349
+ 165.0000n 0.001364 165.0100n 0.001378 165.0200n 0.001391 165.0300n 0.001403 165.0400n 0.001415 165.0500n 0.001425 165.0600n 0.001435 165.0700n 0.001445 165.0800n 0.001453 165.0900n 0.001461 165.1000n 0.001468 165.1100n 0.001474 165.1200n 0.001480 165.1300n 0.001484 165.1400n 0.001488
+ 165.1500n 0.001491 165.1600n 0.001493 165.1700n 0.001495 165.1800n 0.001496 165.1900n 0.001496 165.2000n 0.001495 165.2100n 0.001493 165.2200n 0.001490 165.2300n 0.001487 165.2400n 0.001483 165.2500n 0.001478 165.2600n 0.001473 165.2700n 0.001466 165.2800n 0.001459 165.2900n 0.001451
+ 165.3000n 0.001443 165.3100n 0.001433 165.3200n 0.001423 165.3300n 0.001412 165.3400n 0.001400 165.3500n 0.001388 165.3600n 0.001375 165.3700n 0.001361 165.3800n 0.001347 165.3900n 0.001332 165.4000n 0.001316 165.4100n 0.001299 165.4200n 0.001282 165.4300n 0.001264 165.4400n 0.001246
+ 165.4500n 0.001227 165.4600n 0.001207 165.4700n 0.001187 165.4800n 0.001166 165.4900n 0.001145 165.5000n 0.001123 165.5100n 0.001101 165.5200n 0.001078 165.5300n 0.001054 165.5400n 0.001030 165.5500n 0.001006 165.5600n 0.000981 165.5700n 0.000956 165.5800n 0.000930 165.5900n 0.000904
+ 165.6000n 0.000878 165.6100n 0.000851 165.6200n 0.000823 165.6300n 0.000796 165.6400n 0.000768 165.6500n 0.000740 165.6600n 0.000711 165.6700n 0.000683 165.6800n 0.000654 165.6900n 0.000624 165.7000n 0.000595 165.7100n 0.000565 165.7200n 0.000535 165.7300n 0.000505 165.7400n 0.000475
+ 165.7500n 0.000445 165.7600n 0.000415 165.7700n 0.000384 165.7800n 0.000354 165.7900n 0.000323 165.8000n 0.000292 165.8100n 0.000262 165.8200n 0.000231 165.8300n 0.000201 165.8400n 0.000170 165.8500n 0.000139 165.8600n 0.000109 165.8700n 0.000079 165.8800n 0.000048 165.8900n 0.000018
+ 165.9000n -0.000012 165.9100n -0.000042 165.9200n -0.000072 165.9300n -0.000101 165.9400n -0.000130 165.9500n -0.000160 165.9600n -0.000188 165.9700n -0.000217 165.9800n -0.000246 165.9900n -0.000274 166.0000n -0.000302 166.0100n -0.000329 166.0200n -0.000357 166.0300n -0.000384 166.0400n -0.000410
+ 166.0500n -0.000436 166.0600n -0.000462 166.0700n -0.000488 166.0800n -0.000513 166.0900n -0.000538 166.1000n -0.000562 166.1100n -0.000586 166.1200n -0.000610 166.1300n -0.000633 166.1400n -0.000656 166.1500n -0.000678 166.1600n -0.000700 166.1700n -0.000722 166.1800n -0.000743 166.1900n -0.000763
+ 166.2000n -0.000783 166.2100n -0.000803 166.2200n -0.000822 166.2300n -0.000840 166.2400n -0.000858 166.2500n -0.000876 166.2600n -0.000893 166.2700n -0.000909 166.2800n -0.000925 166.2900n -0.000941 166.3000n -0.000956 166.3100n -0.000971 166.3200n -0.000985 166.3300n -0.000998 166.3400n -0.001011
+ 166.3500n -0.001023 166.3600n -0.001035 166.3700n -0.001047 166.3800n -0.001058 166.3900n -0.001068 166.4000n -0.001078 166.4100n -0.001087 166.4200n -0.001096 166.4300n -0.001105 166.4400n -0.001113 166.4500n -0.001120 166.4600n -0.001127 166.4700n -0.001133 166.4800n -0.001139 166.4900n -0.001145
+ 166.5000n -0.001150 166.5100n -0.001154 166.5200n -0.001158 166.5300n -0.001162 166.5400n -0.001165 166.5500n -0.001167 166.5600n -0.001170 166.5700n -0.001172 166.5800n -0.001173 166.5900n -0.001174 166.6000n -0.001175 166.6100n -0.001175 166.6200n -0.001174 166.6300n -0.001174 166.6400n -0.001173
+ 166.6500n -0.001172 166.6600n -0.001170 166.6700n -0.001168 166.6800n -0.001165 166.6900n -0.001163 166.7000n -0.001159 166.7100n -0.001156 166.7200n -0.001152 166.7300n -0.001148 166.7400n -0.001144 166.7500n -0.001140 166.7600n -0.001135 166.7700n -0.001130 166.7800n -0.001124 166.7900n -0.001119
+ 166.8000n -0.001113 166.8100n -0.001107 166.8200n -0.001100 166.8300n -0.001094 166.8400n -0.001087 166.8500n -0.001080 166.8600n -0.001073 166.8700n -0.001066 166.8800n -0.001059 166.8900n -0.001051 166.9000n -0.001043 166.9100n -0.001036 166.9200n -0.001028 166.9300n -0.001019 166.9400n -0.001011
+ 166.9500n -0.001003 166.9600n -0.000994 166.9700n -0.000986 166.9800n -0.000977 166.9900n -0.000969 167.0000n -0.000960 167.0100n -0.000951 167.0200n -0.000942 167.0300n -0.000933 167.0400n -0.000924 167.0500n -0.000915 167.0600n -0.000906 167.0700n -0.000897 167.0800n -0.000888 167.0900n -0.000879
+ 167.1000n -0.000870 167.1100n -0.000861 167.1200n -0.000852 167.1300n -0.000842 167.1400n -0.000833 167.1500n -0.000824 167.1600n -0.000815 167.1700n -0.000806 167.1800n -0.000797 167.1900n -0.000788 167.2000n -0.000779 167.2100n -0.000770 167.2200n -0.000761 167.2300n -0.000752 167.2400n -0.000743
+ 167.2500n -0.000734 167.2600n -0.000725 167.2700n -0.000716 167.2800n -0.000707 167.2900n -0.000698 167.3000n -0.000689 167.3100n -0.000680 167.3200n -0.000672 167.3300n -0.000663 167.3400n -0.000654 167.3500n -0.000646 167.3600n -0.000637 167.3700n -0.000628 167.3800n -0.000620 167.3900n -0.000611
+ 167.4000n -0.000602 167.4100n -0.000594 167.4200n -0.000585 167.4300n -0.000577 167.4400n -0.000568 167.4500n -0.000559 167.4600n -0.000551 167.4700n -0.000542 167.4800n -0.000534 167.4900n -0.000525 167.5000n -0.000516 167.5100n -0.000508 167.5200n -0.000499 167.5300n -0.000490 167.5400n -0.000481
+ 167.5500n -0.000472 167.5600n -0.000463 167.5700n -0.000455 167.5800n -0.000446 167.5900n -0.000436 167.6000n -0.000427 167.6100n -0.000418 167.6200n -0.000409 167.6300n -0.000399 167.6400n -0.000390 167.6500n -0.000380 167.6600n -0.000371 167.6700n -0.000361 167.6800n -0.000351 167.6900n -0.000341
+ 167.7000n -0.000331 167.7100n -0.000321 167.7200n -0.000310 167.7300n -0.000300 167.7400n -0.000289 167.7500n -0.000278 167.7600n -0.000267 167.7700n -0.000256 167.7800n -0.000245 167.7900n -0.000234 167.8000n -0.000222 167.8100n -0.000210 167.8200n -0.000198 167.8300n -0.000186 167.8400n -0.000174
+ 167.8500n -0.000162 167.8600n -0.000149 167.8700n -0.000136 167.8800n -0.000123 167.8900n -0.000110 167.9000n -0.000097 167.9100n -0.000083 167.9200n -0.000069 167.9300n -0.000055 167.9400n -0.000041 167.9500n -0.000027 167.9600n -0.000012 167.9700n 0.000003 167.9800n 0.000018 167.9900n 0.000033
+ 168.0000n 0.000048 168.0100n 0.000064 168.0200n 0.000080 168.0300n 0.000096 168.0400n 0.000112 168.0500n 0.000128 168.0600n 0.000145 168.0700n 0.000162 168.0800n 0.000178 168.0900n 0.000196 168.1000n 0.000213 168.1100n 0.000230 168.1200n 0.000248 168.1300n 0.000266 168.1400n 0.000284
+ 168.1500n 0.000302 168.1600n 0.000320 168.1700n 0.000339 168.1800n 0.000357 168.1900n 0.000376 168.2000n 0.000395 168.2100n 0.000414 168.2200n 0.000433 168.2300n 0.000452 168.2400n 0.000472 168.2500n 0.000491 168.2600n 0.000511 168.2700n 0.000530 168.2800n 0.000550 168.2900n 0.000570
+ 168.3000n 0.000589 168.3100n 0.000609 168.3200n 0.000629 168.3300n 0.000649 168.3400n 0.000669 168.3500n 0.000689 168.3600n 0.000709 168.3700n 0.000728 168.3800n 0.000748 168.3900n 0.000768 168.4000n 0.000788 168.4100n 0.000807 168.4200n 0.000827 168.4300n 0.000846 168.4400n 0.000866
+ 168.4500n 0.000885 168.4600n 0.000904 168.4700n 0.000923 168.4800n 0.000942 168.4900n 0.000961 168.5000n 0.000979 168.5100n 0.000998 168.5200n 0.001016 168.5300n 0.001034 168.5400n 0.001051 168.5500n 0.001069 168.5600n 0.001086 168.5700n 0.001103 168.5800n 0.001119 168.5900n 0.001136
+ 168.6000n 0.001152 168.6100n 0.001167 168.6200n 0.001183 168.6300n 0.001198 168.6400n 0.001212 168.6500n 0.001227 168.6600n 0.001241 168.6700n 0.001254 168.6800n 0.001267 168.6900n 0.001280 168.7000n 0.001292 168.7100n 0.001304 168.7200n 0.001315 168.7300n 0.001326 168.7400n 0.001336
+ 168.7500n 0.001346 168.7600n 0.001355 168.7700n 0.001364 168.7800n 0.001372 168.7900n 0.001380 168.8000n 0.001387 168.8100n 0.001394 168.8200n 0.001400 168.8300n 0.001405 168.8400n 0.001410 168.8500n 0.001415 168.8600n 0.001418 168.8700n 0.001421 168.8800n 0.001424 168.8900n 0.001425
+ 168.9000n 0.001427 168.9100n 0.001427 168.9200n 0.001427 168.9300n 0.001426 168.9400n 0.001425 168.9500n 0.001422 168.9600n 0.001420 168.9700n 0.001416 168.9800n 0.001412 168.9900n 0.001407 169.0000n 0.001401 169.0100n 0.001395 169.0200n 0.001388 169.0300n 0.001380 169.0400n 0.001372
+ 169.0500n 0.001363 169.0600n 0.001353 169.0700n 0.001343 169.0800n 0.001331 169.0900n 0.001320 169.1000n 0.001307 169.1100n 0.001294 169.1200n 0.001280 169.1300n 0.001265 169.1400n 0.001250 169.1500n 0.001233 169.1600n 0.001217 169.1700n 0.001199 169.1800n 0.001181 169.1900n 0.001162
+ 169.2000n 0.001143 169.2100n 0.001123 169.2200n 0.001102 169.2300n 0.001080 169.2400n 0.001058 169.2500n 0.001036 169.2600n 0.001012 169.2700n 0.000988 169.2800n 0.000964 169.2900n 0.000939 169.3000n 0.000913 169.3100n 0.000887 169.3200n 0.000860 169.3300n 0.000833 169.3400n 0.000805
+ 169.3500n 0.000776 169.3600n 0.000747 169.3700n 0.000718 169.3800n 0.000688 169.3900n 0.000658 169.4000n 0.000627 169.4100n 0.000596 169.4200n 0.000564 169.4300n 0.000532 169.4400n 0.000499 169.4500n 0.000467 169.4600n 0.000433 169.4700n 0.000400 169.4800n 0.000366 169.4900n 0.000332
+ 169.5000n 0.000297 169.5100n 0.000263 169.5200n 0.000228 169.5300n 0.000193 169.5400n 0.000157 169.5500n 0.000122 169.5600n 0.000086 169.5700n 0.000050 169.5800n 0.000014 169.5900n -0.000022 169.6000n -0.000058 169.6100n -0.000095 169.6200n -0.000131 169.6300n -0.000167 169.6400n -0.000204
+ 169.6500n -0.000240 169.6600n -0.000277 169.6700n -0.000313 169.6800n -0.000349 169.6900n -0.000385 169.7000n -0.000421 169.7100n -0.000457 169.7200n -0.000493 169.7300n -0.000528 169.7400n -0.000564 169.7500n -0.000599 169.7600n -0.000634 169.7700n -0.000668 169.7800n -0.000703 169.7900n -0.000737
+ 169.8000n -0.000771 169.8100n -0.000804 169.8200n -0.000837 169.8300n -0.000870 169.8400n -0.000902 169.8500n -0.000934 169.8600n -0.000965 169.8700n -0.000996 169.8800n -0.001027 169.8900n -0.001057 169.9000n -0.001086 169.9100n -0.001115 169.9200n -0.001144 169.9300n -0.001172 169.9400n -0.001199
+ 169.9500n -0.001226 169.9600n -0.001252 169.9700n -0.001278 169.9800n -0.001302 169.9900n -0.001327 170.0000n -0.001350 170.0100n -0.001373 170.0200n -0.001395 170.0300n -0.001417 170.0400n -0.001438 170.0500n -0.001458 170.0600n -0.001477 170.0700n -0.001495 170.0800n -0.001513 170.0900n -0.001530
+ 170.1000n -0.001546 170.1100n -0.001562 170.1200n -0.001577 170.1300n -0.001590 170.1400n -0.001603 170.1500n -0.001616 170.1600n -0.001627 170.1700n -0.001638 170.1800n -0.001647 170.1900n -0.001656 170.2000n -0.001664 170.2100n -0.001671 170.2200n -0.001678 170.2300n -0.001683 170.2400n -0.001688
+ 170.2500n -0.001691 170.2600n -0.001694 170.2700n -0.001696 170.2800n -0.001697 170.2900n -0.001698 170.3000n -0.001697 170.3100n -0.001696 170.3200n -0.001693 170.3300n -0.001690 170.3400n -0.001686 170.3500n -0.001681 170.3600n -0.001675 170.3700n -0.001669 170.3800n -0.001662 170.3900n -0.001653
+ 170.4000n -0.001644 170.4100n -0.001635 170.4200n -0.001624 170.4300n -0.001613 170.4400n -0.001600 170.4500n -0.001587 170.4600n -0.001574 170.4700n -0.001559 170.4800n -0.001544 170.4900n -0.001528 170.5000n -0.001511 170.5100n -0.001494 170.5200n -0.001476 170.5300n -0.001457 170.5400n -0.001438
+ 170.5500n -0.001418 170.5600n -0.001397 170.5700n -0.001376 170.5800n -0.001354 170.5900n -0.001331 170.6000n -0.001308 170.6100n -0.001284 170.6200n -0.001260 170.6300n -0.001236 170.6400n -0.001210 170.6500n -0.001185 170.6600n -0.001158 170.6700n -0.001132 170.6800n -0.001105 170.6900n -0.001077
+ 170.7000n -0.001049 170.7100n -0.001021 170.7200n -0.000992 170.7300n -0.000963 170.7400n -0.000934 170.7500n -0.000905 170.7600n -0.000875 170.7700n -0.000845 170.7800n -0.000814 170.7900n -0.000784 170.8000n -0.000753 170.8100n -0.000722 170.8200n -0.000691 170.8300n -0.000660 170.8400n -0.000628
+ 170.8500n -0.000597 170.8600n -0.000566 170.8700n -0.000534 170.8800n -0.000503 170.8900n -0.000471 170.9000n -0.000440 170.9100n -0.000408 170.9200n -0.000377 170.9300n -0.000345 170.9400n -0.000314 170.9500n -0.000283 170.9600n -0.000252 170.9700n -0.000221 170.9800n -0.000191 170.9900n -0.000160
+ 171.0000n -0.000130 171.0100n -0.000100 171.0200n -0.000070 171.0300n -0.000041 171.0400n -0.000012 171.0500n 0.000017 171.0600n 0.000045 171.0700n 0.000073 171.0800n 0.000101 171.0900n 0.000128 171.1000n 0.000155 171.1100n 0.000181 171.1200n 0.000207 171.1300n 0.000233 171.1400n 0.000258
+ 171.1500n 0.000282 171.1600n 0.000306 171.1700n 0.000330 171.1800n 0.000353 171.1900n 0.000375 171.2000n 0.000397 171.2100n 0.000418 171.2200n 0.000439 171.2300n 0.000459 171.2400n 0.000478 171.2500n 0.000497 171.2600n 0.000515 171.2700n 0.000533 171.2800n 0.000550 171.2900n 0.000566
+ 171.3000n 0.000581 171.3100n 0.000596 171.3200n 0.000610 171.3300n 0.000623 171.3400n 0.000636 171.3500n 0.000648 171.3600n 0.000659 171.3700n 0.000669 171.3800n 0.000679 171.3900n 0.000687 171.4000n 0.000696 171.4100n 0.000703 171.4200n 0.000709 171.4300n 0.000715 171.4400n 0.000720
+ 171.4500n 0.000724 171.4600n 0.000728 171.4700n 0.000730 171.4800n 0.000732 171.4900n 0.000733 171.5000n 0.000734 171.5100n 0.000733 171.5200n 0.000732 171.5300n 0.000730 171.5400n 0.000727 171.5500n 0.000723 171.5600n 0.000719 171.5700n 0.000714 171.5800n 0.000708 171.5900n 0.000701
+ 171.6000n 0.000694 171.6100n 0.000685 171.6200n 0.000676 171.6300n 0.000667 171.6400n 0.000656 171.6500n 0.000645 171.6600n 0.000633 171.6700n 0.000620 171.6800n 0.000607 171.6900n 0.000593 171.7000n 0.000578 171.7100n 0.000563 171.7200n 0.000546 171.7300n 0.000530 171.7400n 0.000512
+ 171.7500n 0.000494 171.7600n 0.000475 171.7700n 0.000456 171.7800n 0.000436 171.7900n 0.000415 171.8000n 0.000394 171.8100n 0.000372 171.8200n 0.000350 171.8300n 0.000327 171.8400n 0.000303 171.8500n 0.000279 171.8600n 0.000255 171.8700n 0.000230 171.8800n 0.000204 171.8900n 0.000178
+ 171.9000n 0.000152 171.9100n 0.000125 171.9200n 0.000097 171.9300n 0.000069 171.9400n 0.000041 171.9500n 0.000013 171.9600n -0.000016 171.9700n -0.000046 171.9800n -0.000075 171.9900n -0.000105 172.0000n -0.000136 172.0100n -0.000166 172.0200n -0.000197 172.0300n -0.000228 172.0400n -0.000260
+ 172.0500n -0.000292 172.0600n -0.000324 172.0700n -0.000356 172.0800n -0.000388 172.0900n -0.000421 172.1000n -0.000453 172.1100n -0.000486 172.1200n -0.000519 172.1300n -0.000552 172.1400n -0.000585 172.1500n -0.000619 172.1600n -0.000652 172.1700n -0.000685 172.1800n -0.000719 172.1900n -0.000752
+ 172.2000n -0.000786 172.2100n -0.000819 172.2200n -0.000853 172.2300n -0.000886 172.2400n -0.000920 172.2500n -0.000953 172.2600n -0.000986 172.2700n -0.001020 172.2800n -0.001053 172.2900n -0.001086 172.3000n -0.001119 172.3100n -0.001151 172.3200n -0.001184 172.3300n -0.001216 172.3400n -0.001249
+ 172.3500n -0.001281 172.3600n -0.001313 172.3700n -0.001344 172.3800n -0.001376 172.3900n -0.001407 172.4000n -0.001438 172.4100n -0.001469 172.4200n -0.001499 172.4300n -0.001529 172.4400n -0.001559 172.4500n -0.001589 172.4600n -0.001618 172.4700n -0.001647 172.4800n -0.001676 172.4900n -0.001704
+ 172.5000n -0.001732 172.5100n -0.001759 172.5200n -0.001787 172.5300n -0.001814 172.5400n -0.001840 172.5500n -0.001866 172.5600n -0.001892 172.5700n -0.001917 172.5800n -0.001942 172.5900n -0.001967 172.6000n -0.001991 172.6100n -0.002015 172.6200n -0.002038 172.6300n -0.002061 172.6400n -0.002083
+ 172.6500n -0.002105 172.6600n -0.002127 172.6700n -0.002148 172.6800n -0.002168 172.6900n -0.002189 172.7000n -0.002208 172.7100n -0.002228 172.7200n -0.002246 172.7300n -0.002265 172.7400n -0.002283 172.7500n -0.002300 172.7600n -0.002317 172.7700n -0.002333 172.7800n -0.002349 172.7900n -0.002365
+ 172.8000n -0.002380 172.8100n -0.002394 172.8200n -0.002408 172.8300n -0.002422 172.8400n -0.002435 172.8500n -0.002448 172.8600n -0.002460 172.8700n -0.002471 172.8800n -0.002482 172.8900n -0.002493 172.9000n -0.002503 172.9100n -0.002513 172.9200n -0.002522 172.9300n -0.002531 172.9400n -0.002539
+ 172.9500n -0.002547 172.9600n -0.002555 172.9700n -0.002562 172.9800n -0.002568 172.9900n -0.002574 173.0000n -0.002579 173.0100n -0.002584 173.0200n -0.002589 173.0300n -0.002593 173.0400n -0.002597 173.0500n -0.002600 173.0600n -0.002603 173.0700n -0.002605 173.0800n -0.002607 173.0900n -0.002609
+ 173.1000n -0.002610 173.1100n -0.002611 173.1200n -0.002611 173.1300n -0.002611 173.1400n -0.002610 173.1500n -0.002609 173.1600n -0.002608 173.1700n -0.002606 173.1800n -0.002604 173.1900n -0.002601 173.2000n -0.002598 173.2100n -0.002595 173.2200n -0.002591 173.2300n -0.002587 173.2400n -0.002583
+ 173.2500n -0.002578 173.2600n -0.002573 173.2700n -0.002567 173.2800n -0.002561 173.2900n -0.002555 173.3000n -0.002549 173.3100n -0.002542 173.3200n -0.002535 173.3300n -0.002527 173.3400n -0.002519 173.3500n -0.002511 173.3600n -0.002503 173.3700n -0.002494 173.3800n -0.002485 173.3900n -0.002475
+ 173.4000n -0.002466 173.4100n -0.002456 173.4200n -0.002446 173.4300n -0.002435 173.4400n -0.002425 173.4500n -0.002414 173.4600n -0.002402 173.4700n -0.002391 173.4800n -0.002379 173.4900n -0.002367 173.5000n -0.002355 173.5100n -0.002342 173.5200n -0.002330 173.5300n -0.002317 173.5400n -0.002304
+ 173.5500n -0.002291 173.5600n -0.002277 173.5700n -0.002263 173.5800n -0.002249 173.5900n -0.002235 173.6000n -0.002221 173.6100n -0.002207 173.6200n -0.002192 173.6300n -0.002177 173.6400n -0.002162 173.6500n -0.002147 173.6600n -0.002132 173.6700n -0.002117 173.6800n -0.002101 173.6900n -0.002085
+ 173.7000n -0.002070 173.7100n -0.002054 173.7200n -0.002038 173.7300n -0.002022 173.7400n -0.002005 173.7500n -0.001989 173.7600n -0.001972 173.7700n -0.001956 173.7800n -0.001939 173.7900n -0.001923 173.8000n -0.001906 173.8100n -0.001889 173.8200n -0.001872 173.8300n -0.001855 173.8400n -0.001838
+ 173.8500n -0.001821 173.8600n -0.001804 173.8700n -0.001787 173.8800n -0.001769 173.8900n -0.001752 173.9000n -0.001735 173.9100n -0.001718 173.9200n -0.001700 173.9300n -0.001683 173.9400n -0.001666 173.9500n -0.001649 173.9600n -0.001631 173.9700n -0.001614 173.9800n -0.001597 173.9900n -0.001580
+ 174.0000n -0.001562 174.0100n -0.001545 174.0200n -0.001528 174.0300n -0.001511 174.0400n -0.001494 174.0500n -0.001477 174.0600n -0.001461 174.0700n -0.001444 174.0800n -0.001427 174.0900n -0.001411 174.1000n -0.001394 174.1100n -0.001378 174.1200n -0.001361 174.1300n -0.001345 174.1400n -0.001329
+ 174.1500n -0.001313 174.1600n -0.001297 174.1700n -0.001282 174.1800n -0.001266 174.1900n -0.001251 174.2000n -0.001235 174.2100n -0.001220 174.2200n -0.001205 174.2300n -0.001191 174.2400n -0.001176 174.2500n -0.001162 174.2600n -0.001147 174.2700n -0.001133 174.2800n -0.001119 174.2900n -0.001106
+ 174.3000n -0.001092 174.3100n -0.001079 174.3200n -0.001066 174.3300n -0.001053 174.3400n -0.001041 174.3500n -0.001029 174.3600n -0.001017 174.3700n -0.001005 174.3800n -0.000993 174.3900n -0.000982 174.4000n -0.000971 174.4100n -0.000960 174.4200n -0.000949 174.4300n -0.000939 174.4400n -0.000929
+ 174.4500n -0.000920 174.4600n -0.000910 174.4700n -0.000901 174.4800n -0.000892 174.4900n -0.000884 174.5000n -0.000876 174.5100n -0.000868 174.5200n -0.000860 174.5300n -0.000853 174.5400n -0.000846 174.5500n -0.000840 174.5600n -0.000833 174.5700n -0.000828 174.5800n -0.000822 174.5900n -0.000817
+ 174.6000n -0.000812 174.6100n -0.000807 174.6200n -0.000803 174.6300n -0.000799 174.6400n -0.000796 174.6500n -0.000793 174.6600n -0.000790 174.6700n -0.000787 174.6800n -0.000785 174.6900n -0.000784 174.7000n -0.000782 174.7100n -0.000781 174.7200n -0.000781 174.7300n -0.000780 174.7400n -0.000781
+ 174.7500n -0.000781 174.7600n -0.000782 174.7700n -0.000783 174.7800n -0.000785 174.7900n -0.000787 174.8000n -0.000789 174.8100n -0.000792 174.8200n -0.000795 174.8300n -0.000798 174.8400n -0.000802 174.8500n -0.000806 174.8600n -0.000810 174.8700n -0.000815 174.8800n -0.000820 174.8900n -0.000826
+ 174.9000n -0.000832 174.9100n -0.000838 174.9200n -0.000844 174.9300n -0.000851 174.9400n -0.000858 174.9500n -0.000866 174.9600n -0.000873 174.9700n -0.000882 174.9800n -0.000890 174.9900n -0.000899 175.0000n -0.000908 175.0100n -0.000917 175.0200n -0.000926 175.0300n -0.000936 175.0400n -0.000946
+ 175.0500n -0.000957 175.0600n -0.000967 175.0700n -0.000978 175.0800n -0.000989 175.0900n -0.001001 175.1000n -0.001012 175.1100n -0.001024 175.1200n -0.001036 175.1300n -0.001048 175.1400n -0.001061 175.1500n -0.001073 175.1600n -0.001086 175.1700n -0.001099 175.1800n -0.001112 175.1900n -0.001125
+ 175.2000n -0.001139 175.2100n -0.001152 175.2200n -0.001166 175.2300n -0.001180 175.2400n -0.001193 175.2500n -0.001207 175.2600n -0.001221 175.2700n -0.001235 175.2800n -0.001249 175.2900n -0.001264 175.3000n -0.001278 175.3100n -0.001292 175.3200n -0.001306 175.3300n -0.001320 175.3400n -0.001334
+ 175.3500n -0.001348 175.3600n -0.001362 175.3700n -0.001377 175.3800n -0.001390 175.3900n -0.001404 175.4000n -0.001418 175.4100n -0.001432 175.4200n -0.001445 175.4300n -0.001459 175.4400n -0.001472 175.4500n -0.001485 175.4600n -0.001498 175.4700n -0.001511 175.4800n -0.001524 175.4900n -0.001536
+ 175.5000n -0.001548 175.5100n -0.001560 175.5200n -0.001572 175.5300n -0.001583 175.5400n -0.001595 175.5500n -0.001606 175.5600n -0.001616 175.5700n -0.001627 175.5800n -0.001637 175.5900n -0.001646 175.6000n -0.001656 175.6100n -0.001665 175.6200n -0.001674 175.6300n -0.001682 175.6400n -0.001690
+ 175.6500n -0.001698 175.6600n -0.001705 175.6700n -0.001711 175.6800n -0.001718 175.6900n -0.001724 175.7000n -0.001729 175.7100n -0.001734 175.7200n -0.001739 175.7300n -0.001743 175.7400n -0.001747 175.7500n -0.001750 175.7600n -0.001753 175.7700n -0.001755 175.7800n -0.001757 175.7900n -0.001758
+ 175.8000n -0.001759 175.8100n -0.001759 175.8200n -0.001758 175.8300n -0.001757 175.8400n -0.001756 175.8500n -0.001754 175.8600n -0.001752 175.8700n -0.001748 175.8800n -0.001745 175.8900n -0.001741 175.9000n -0.001736 175.9100n -0.001730 175.9200n -0.001724 175.9300n -0.001718 175.9400n -0.001711
+ 175.9500n -0.001703 175.9600n -0.001695 175.9700n -0.001686 175.9800n -0.001677 175.9900n -0.001667 176.0000n -0.001656 176.0100n -0.001645 176.0200n -0.001633 176.0300n -0.001621 176.0400n -0.001608 176.0500n -0.001594 176.0600n -0.001580 176.0700n -0.001565 176.0800n -0.001550 176.0900n -0.001534
+ 176.1000n -0.001518 176.1100n -0.001501 176.1200n -0.001483 176.1300n -0.001465 176.1400n -0.001447 176.1500n -0.001428 176.1600n -0.001408 176.1700n -0.001388 176.1800n -0.001367 176.1900n -0.001346 176.2000n -0.001324 176.2100n -0.001302 176.2200n -0.001279 176.2300n -0.001256 176.2400n -0.001232
+ 176.2500n -0.001208 176.2600n -0.001184 176.2700n -0.001159 176.2800n -0.001133 176.2900n -0.001107 176.3000n -0.001081 176.3100n -0.001055 176.3200n -0.001027 176.3300n -0.001000 176.3400n -0.000972 176.3500n -0.000944 176.3600n -0.000916 176.3700n -0.000887 176.3800n -0.000858 176.3900n -0.000829
+ 176.4000n -0.000799 176.4100n -0.000769 176.4200n -0.000739 176.4300n -0.000708 176.4400n -0.000678 176.4500n -0.000647 176.4600n -0.000616 176.4700n -0.000585 176.4800n -0.000554 176.4900n -0.000522 176.5000n -0.000490 176.5100n -0.000459 176.5200n -0.000427 176.5300n -0.000395 176.5400n -0.000363
+ 176.5500n -0.000331 176.5600n -0.000299 176.5700n -0.000267 176.5800n -0.000235 176.5900n -0.000203 176.6000n -0.000171 176.6100n -0.000139 176.6200n -0.000107 176.6300n -0.000076 176.6400n -0.000044 176.6500n -0.000012 176.6600n 0.000019 176.6700n 0.000050 176.6800n 0.000081 176.6900n 0.000112
+ 176.7000n 0.000143 176.7100n 0.000173 176.7200n 0.000204 176.7300n 0.000234 176.7400n 0.000263 176.7500n 0.000293 176.7600n 0.000322 176.7700n 0.000351 176.7800n 0.000379 176.7900n 0.000407 176.8000n 0.000435 176.8100n 0.000462 176.8200n 0.000489 176.8300n 0.000516 176.8400n 0.000542
+ 176.8500n 0.000568 176.8600n 0.000593 176.8700n 0.000618 176.8800n 0.000642 176.8900n 0.000666 176.9000n 0.000690 176.9100n 0.000713 176.9200n 0.000735 176.9300n 0.000757 176.9400n 0.000778 176.9500n 0.000799 176.9600n 0.000819 176.9700n 0.000839 176.9800n 0.000858 176.9900n 0.000876
+ 177.0000n 0.000894 177.0100n 0.000911 177.0200n 0.000928 177.0300n 0.000944 177.0400n 0.000959 177.0500n 0.000974 177.0600n 0.000988 177.0700n 0.001002 177.0800n 0.001015 177.0900n 0.001027 177.1000n 0.001038 177.1100n 0.001049 177.1200n 0.001059 177.1300n 0.001069 177.1400n 0.001077
+ 177.1500n 0.001086 177.1600n 0.001093 177.1700n 0.001100 177.1800n 0.001106 177.1900n 0.001111 177.2000n 0.001116 177.2100n 0.001120 177.2200n 0.001123 177.2300n 0.001126 177.2400n 0.001128 177.2500n 0.001129 177.2600n 0.001130 177.2700n 0.001130 177.2800n 0.001129 177.2900n 0.001128
+ 177.3000n 0.001126 177.3100n 0.001123 177.3200n 0.001120 177.3300n 0.001116 177.3400n 0.001111 177.3500n 0.001106 177.3600n 0.001100 177.3700n 0.001094 177.3800n 0.001087 177.3900n 0.001079 177.4000n 0.001071 177.4100n 0.001062 177.4200n 0.001053 177.4300n 0.001043 177.4400n 0.001032
+ 177.4500n 0.001021 177.4600n 0.001010 177.4700n 0.000997 177.4800n 0.000985 177.4900n 0.000972 177.5000n 0.000958 177.5100n 0.000944 177.5200n 0.000930 177.5300n 0.000915 177.5400n 0.000899 177.5500n 0.000883 177.5600n 0.000867 177.5700n 0.000851 177.5800n 0.000834 177.5900n 0.000816
+ 177.6000n 0.000798 177.6100n 0.000780 177.6200n 0.000762 177.6300n 0.000743 177.6400n 0.000725 177.6500n 0.000705 177.6600n 0.000686 177.6700n 0.000666 177.6800n 0.000646 177.6900n 0.000626 177.7000n 0.000606 177.7100n 0.000585 177.7200n 0.000565 177.7300n 0.000544 177.7400n 0.000523
+ 177.7500n 0.000502 177.7600n 0.000481 177.7700n 0.000460 177.7800n 0.000438 177.7900n 0.000417 177.8000n 0.000396 177.8100n 0.000374 177.8200n 0.000353 177.8300n 0.000332 177.8400n 0.000310 177.8500n 0.000289 177.8600n 0.000268 177.8700n 0.000247 177.8800n 0.000226 177.8900n 0.000205
+ 177.9000n 0.000185 177.9100n 0.000164 177.9200n 0.000144 177.9300n 0.000124 177.9400n 0.000104 177.9500n 0.000084 177.9600n 0.000064 177.9700n 0.000045 177.9800n 0.000026 177.9900n 0.000007 178.0000n -0.000012 178.0100n -0.000030 178.0200n -0.000048 178.0300n -0.000065 178.0400n -0.000083
+ 178.0500n -0.000099 178.0600n -0.000116 178.0700n -0.000132 178.0800n -0.000148 178.0900n -0.000164 178.1000n -0.000179 178.1100n -0.000193 178.1200n -0.000207 178.1300n -0.000221 178.1400n -0.000235 178.1500n -0.000247 178.1600n -0.000260 178.1700n -0.000272 178.1800n -0.000283 178.1900n -0.000294
+ 178.2000n -0.000305 178.2100n -0.000315 178.2200n -0.000325 178.2300n -0.000334 178.2400n -0.000342 178.2500n -0.000350 178.2600n -0.000358 178.2700n -0.000365 178.2800n -0.000371 178.2900n -0.000377 178.3000n -0.000383 178.3100n -0.000388 178.3200n -0.000392 178.3300n -0.000396 178.3400n -0.000399
+ 178.3500n -0.000402 178.3600n -0.000404 178.3700n -0.000406 178.3800n -0.000407 178.3900n -0.000408 178.4000n -0.000408 178.4100n -0.000407 178.4200n -0.000406 178.4300n -0.000405 178.4400n -0.000403 178.4500n -0.000400 178.4600n -0.000397 178.4700n -0.000393 178.4800n -0.000389 178.4900n -0.000384
+ 178.5000n -0.000379 178.5100n -0.000374 178.5200n -0.000368 178.5300n -0.000361 178.5400n -0.000354 178.5500n -0.000346 178.5600n -0.000338 178.5700n -0.000330 178.5800n -0.000321 178.5900n -0.000312 178.6000n -0.000302 178.6100n -0.000292 178.6200n -0.000281 178.6300n -0.000270 178.6400n -0.000259
+ 178.6500n -0.000247 178.6600n -0.000235 178.6700n -0.000222 178.6800n -0.000209 178.6900n -0.000196 178.7000n -0.000182 178.7100n -0.000168 178.7200n -0.000154 178.7300n -0.000140 178.7400n -0.000125 178.7500n -0.000110 178.7600n -0.000094 178.7700n -0.000079 178.7800n -0.000063 178.7900n -0.000047
+ 178.8000n -0.000031 178.8100n -0.000014 178.8200n 0.000002 178.8300n 0.000019 178.8400n 0.000036 178.8500n 0.000053 178.8600n 0.000071 178.8700n 0.000088 178.8800n 0.000106 178.8900n 0.000123 178.9000n 0.000141 178.9100n 0.000159 178.9200n 0.000177 178.9300n 0.000195 178.9400n 0.000213
+ 178.9500n 0.000231 178.9600n 0.000249 178.9700n 0.000267 178.9800n 0.000285 178.9900n 0.000303 179.0000n 0.000321 179.0100n 0.000338 179.0200n 0.000356 179.0300n 0.000374 179.0400n 0.000392 179.0500n 0.000409 179.0600n 0.000427 179.0700n 0.000444 179.0800n 0.000461 179.0900n 0.000478
+ 179.1000n 0.000495 179.1100n 0.000512 179.1200n 0.000529 179.1300n 0.000545 179.1400n 0.000561 179.1500n 0.000577 179.1600n 0.000593 179.1700n 0.000609 179.1800n 0.000624 179.1900n 0.000639 179.2000n 0.000654 179.2100n 0.000669 179.2200n 0.000683 179.2300n 0.000697 179.2400n 0.000711
+ 179.2500n 0.000725 179.2600n 0.000738 179.2700n 0.000751 179.2800n 0.000764 179.2900n 0.000776 179.3000n 0.000788 179.3100n 0.000800 179.3200n 0.000811 179.3300n 0.000823 179.3400n 0.000833 179.3500n 0.000844 179.3600n 0.000854 179.3700n 0.000864 179.3800n 0.000873 179.3900n 0.000882
+ 179.4000n 0.000891 179.4100n 0.000899 179.4200n 0.000907 179.4300n 0.000915 179.4400n 0.000922 179.4500n 0.000929 179.4600n 0.000936 179.4700n 0.000942 179.4800n 0.000948 179.4900n 0.000953 179.5000n 0.000958 179.5100n 0.000963 179.5200n 0.000968 179.5300n 0.000972 179.5400n 0.000975
+ 179.5500n 0.000979 179.5600n 0.000982 179.5700n 0.000985 179.5800n 0.000987 179.5900n 0.000989 179.6000n 0.000991 179.6100n 0.000992 179.6200n 0.000993 179.6300n 0.000994 179.6400n 0.000994 179.6500n 0.000994 179.6600n 0.000994 179.6700n 0.000993 179.6800n 0.000992 179.6900n 0.000991
+ 179.7000n 0.000990 179.7100n 0.000988 179.7200n 0.000986 179.7300n 0.000984 179.7400n 0.000981 179.7500n 0.000978 179.7600n 0.000975 179.7700n 0.000972 179.7800n 0.000969 179.7900n 0.000965 179.8000n 0.000961 179.8100n 0.000957 179.8200n 0.000952 179.8300n 0.000948 179.8400n 0.000943
+ 179.8500n 0.000938 179.8600n 0.000933 179.8700n 0.000927 179.8800n 0.000922 179.8900n 0.000916 179.9000n 0.000911 179.9100n 0.000905 179.9200n 0.000899 179.9300n 0.000892 179.9400n 0.000886 179.9500n 0.000880 179.9600n 0.000873 179.9700n 0.000866 179.9800n 0.000860 179.9900n 0.000853
+ 180.0000n 0.000846 180.0100n 0.000839 180.0200n 0.000832 180.0300n 0.000825 180.0400n 0.000818 180.0500n 0.000811 180.0600n 0.000804 180.0700n 0.000797 180.0800n 0.000790 180.0900n 0.000783 180.1000n 0.000776 180.1100n 0.000769 180.1200n 0.000762 180.1300n 0.000755 180.1400n 0.000748
+ 180.1500n 0.000741 180.1600n 0.000734 180.1700n 0.000727 180.1800n 0.000720 180.1900n 0.000713 180.2000n 0.000707 180.2100n 0.000700 180.2200n 0.000694 180.2300n 0.000687 180.2400n 0.000681 180.2500n 0.000675 180.2600n 0.000668 180.2700n 0.000662 180.2800n 0.000656 180.2900n 0.000651
+ 180.3000n 0.000645 180.3100n 0.000639 180.3200n 0.000634 180.3300n 0.000628 180.3400n 0.000623 180.3500n 0.000618 180.3600n 0.000613 180.3700n 0.000608 180.3800n 0.000603 180.3900n 0.000598 180.4000n 0.000594 180.4100n 0.000589 180.4200n 0.000585 180.4300n 0.000581 180.4400n 0.000577
+ 180.4500n 0.000573 180.4600n 0.000569 180.4700n 0.000566 180.4800n 0.000562 180.4900n 0.000559 180.5000n 0.000556 180.5100n 0.000553 180.5200n 0.000550 180.5300n 0.000547 180.5400n 0.000544 180.5500n 0.000542 180.5600n 0.000539 180.5700n 0.000537 180.5800n 0.000534 180.5900n 0.000532
+ 180.6000n 0.000530 180.6100n 0.000528 180.6200n 0.000526 180.6300n 0.000524 180.6400n 0.000523 180.6500n 0.000521 180.6600n 0.000519 180.6700n 0.000518 180.6800n 0.000516 180.6900n 0.000515 180.7000n 0.000514 180.7100n 0.000513 180.7200n 0.000511 180.7300n 0.000510 180.7400n 0.000509
+ 180.7500n 0.000508 180.7600n 0.000507 180.7700n 0.000506 180.7800n 0.000504 180.7900n 0.000503 180.8000n 0.000502 180.8100n 0.000501 180.8200n 0.000500 180.8300n 0.000499 180.8400n 0.000497 180.8500n 0.000496 180.8600n 0.000495 180.8700n 0.000493 180.8800n 0.000492 180.8900n 0.000491
+ 180.9000n 0.000489 180.9100n 0.000487 180.9200n 0.000485 180.9300n 0.000484 180.9400n 0.000482 180.9500n 0.000480 180.9600n 0.000477 180.9700n 0.000475 180.9800n 0.000472 180.9900n 0.000470 181.0000n 0.000467 181.0100n 0.000464 181.0200n 0.000461 181.0300n 0.000458 181.0400n 0.000454
+ 181.0500n 0.000451 181.0600n 0.000447 181.0700n 0.000443 181.0800n 0.000438 181.0900n 0.000434 181.1000n 0.000429 181.1100n 0.000424 181.1200n 0.000419 181.1300n 0.000414 181.1400n 0.000408 181.1500n 0.000402 181.1600n 0.000396 181.1700n 0.000390 181.1800n 0.000383 181.1900n 0.000376
+ 181.2000n 0.000369 181.2100n 0.000361 181.2200n 0.000354 181.2300n 0.000346 181.2400n 0.000337 181.2500n 0.000329 181.2600n 0.000320 181.2700n 0.000310 181.2800n 0.000301 181.2900n 0.000291 181.3000n 0.000281 181.3100n 0.000270 181.3200n 0.000260 181.3300n 0.000248 181.3400n 0.000237
+ 181.3500n 0.000225 181.3600n 0.000213 181.3700n 0.000201 181.3800n 0.000188 181.3900n 0.000175 181.4000n 0.000162 181.4100n 0.000148 181.4200n 0.000134 181.4300n 0.000120 181.4400n 0.000105 181.4500n 0.000090 181.4600n 0.000074 181.4700n 0.000059 181.4800n 0.000043 181.4900n 0.000027
+ 181.5000n 0.000010 181.5100n -0.000007 181.5200n -0.000024 181.5300n -0.000042 181.5400n -0.000060 181.5500n -0.000078 181.5600n -0.000096 181.5700n -0.000115 181.5800n -0.000134 181.5900n -0.000153 181.6000n -0.000173 181.6100n -0.000193 181.6200n -0.000213 181.6300n -0.000233 181.6400n -0.000254
+ 181.6500n -0.000275 181.6600n -0.000296 181.6700n -0.000317 181.6800n -0.000339 181.6900n -0.000361 181.7000n -0.000383 181.7100n -0.000405 181.7200n -0.000428 181.7300n -0.000450 181.7400n -0.000473 181.7500n -0.000496 181.7600n -0.000520 181.7700n -0.000543 181.7800n -0.000567 181.7900n -0.000590
+ 181.8000n -0.000614 181.8100n -0.000638 181.8200n -0.000662 181.8300n -0.000686 181.8400n -0.000711 181.8500n -0.000735 181.8600n -0.000760 181.8700n -0.000784 181.8800n -0.000809 181.8900n -0.000833 181.9000n -0.000858 181.9100n -0.000883 181.9200n -0.000908 181.9300n -0.000932 181.9400n -0.000957
+ 181.9500n -0.000982 181.9600n -0.001006 181.9700n -0.001031 181.9800n -0.001056 181.9900n -0.001080 182.0000n -0.001105 182.0100n -0.001129 182.0200n -0.001153 182.0300n -0.001178 182.0400n -0.001202 182.0500n -0.001226 182.0600n -0.001250 182.0700n -0.001273 182.0800n -0.001297 182.0900n -0.001320
+ 182.1000n -0.001343 182.1100n -0.001366 182.1200n -0.001389 182.1300n -0.001411 182.1400n -0.001434 182.1500n -0.001456 182.1600n -0.001478 182.1700n -0.001499 182.1800n -0.001520 182.1900n -0.001541 182.2000n -0.001562 182.2100n -0.001582 182.2200n -0.001602 182.2300n -0.001622 182.2400n -0.001641
+ 182.2500n -0.001661 182.2600n -0.001679 182.2700n -0.001697 182.2800n -0.001715 182.2900n -0.001733 182.3000n -0.001750 182.3100n -0.001767 182.3200n -0.001783 182.3300n -0.001799 182.3400n -0.001814 182.3500n -0.001829 182.3600n -0.001844 182.3700n -0.001858 182.3800n -0.001871 182.3900n -0.001884
+ 182.4000n -0.001897 182.4100n -0.001909 182.4200n -0.001920 182.4300n -0.001931 182.4400n -0.001942 182.4500n -0.001952 182.4600n -0.001961 182.4700n -0.001970 182.4800n -0.001978 182.4900n -0.001986 182.5000n -0.001993 182.5100n -0.001999 182.5200n -0.002005 182.5300n -0.002011 182.5400n -0.002016
+ 182.5500n -0.002020 182.5600n -0.002023 182.5700n -0.002026 182.5800n -0.002029 182.5900n -0.002031 182.6000n -0.002032 182.6100n -0.002032 182.6200n -0.002032 182.6300n -0.002031 182.6400n -0.002030 182.6500n -0.002028 182.6600n -0.002025 182.6700n -0.002022 182.6800n -0.002018 182.6900n -0.002013
+ 182.7000n -0.002008 182.7100n -0.002002 182.7200n -0.001995 182.7300n -0.001988 182.7400n -0.001980 182.7500n -0.001971 182.7600n -0.001962 182.7700n -0.001952 182.7800n -0.001942 182.7900n -0.001931 182.8000n -0.001919 182.8100n -0.001906 182.8200n -0.001893 182.8300n -0.001879 182.8400n -0.001865
+ 182.8500n -0.001850 182.8600n -0.001834 182.8700n -0.001817 182.8800n -0.001800 182.8900n -0.001783 182.9000n -0.001764 182.9100n -0.001745 182.9200n -0.001726 182.9300n -0.001706 182.9400n -0.001685 182.9500n -0.001663 182.9600n -0.001641 182.9700n -0.001619 182.9800n -0.001595 182.9900n -0.001571
+ 183.0000n -0.001547 183.0100n -0.001522 183.0200n -0.001496 183.0300n -0.001470 183.0400n -0.001444 183.0500n -0.001416 183.0600n -0.001388 183.0700n -0.001360 183.0800n -0.001331 183.0900n -0.001302 183.1000n -0.001272 183.1100n -0.001241 183.1200n -0.001210 183.1300n -0.001179 183.1400n -0.001147
+ 183.1500n -0.001115 183.1600n -0.001082 183.1700n -0.001049 183.1800n -0.001015 183.1900n -0.000981 183.2000n -0.000946 183.2100n -0.000911 183.2200n -0.000876 183.2300n -0.000840 183.2400n -0.000804 183.2500n -0.000767 183.2600n -0.000730 183.2700n -0.000693 183.2800n -0.000655 183.2900n -0.000617
+ 183.3000n -0.000579 183.3100n -0.000540 183.3200n -0.000501 183.3300n -0.000462 183.3400n -0.000423 183.3500n -0.000383 183.3600n -0.000343 183.3700n -0.000303 183.3800n -0.000263 183.3900n -0.000222 183.4000n -0.000182 183.4100n -0.000141 183.4200n -0.000100 183.4300n -0.000058 183.4400n -0.000017
+ 183.4500n 0.000024 183.4600n 0.000066 183.4700n 0.000108 183.4800n 0.000150 183.4900n 0.000191 183.5000n 0.000233 183.5100n 0.000275 183.5200n 0.000317 183.5300n 0.000359 183.5400n 0.000401 183.5500n 0.000443 183.5600n 0.000485 183.5700n 0.000527 183.5800n 0.000569 183.5900n 0.000610
+ 183.6000n 0.000652 183.6100n 0.000694 183.6200n 0.000735 183.6300n 0.000776 183.6400n 0.000817 183.6500n 0.000858 183.6600n 0.000899 183.6700n 0.000940 183.6800n 0.000980 183.6900n 0.001020 183.7000n 0.001060 183.7100n 0.001100 183.7200n 0.001139 183.7300n 0.001179 183.7400n 0.001218
+ 183.7500n 0.001256 183.7600n 0.001294 183.7700n 0.001332 183.7800n 0.001370 183.7900n 0.001407 183.8000n 0.001444 183.8100n 0.001480 183.8200n 0.001516 183.8300n 0.001552 183.8400n 0.001587 183.8500n 0.001622 183.8600n 0.001656 183.8700n 0.001690 183.8800n 0.001723 183.8900n 0.001756
+ 183.9000n 0.001788 183.9100n 0.001820 183.9200n 0.001851 183.9300n 0.001882 183.9400n 0.001912 183.9500n 0.001941 183.9600n 0.001970 183.9700n 0.001999 183.9800n 0.002027 183.9900n 0.002054 184.0000n 0.002080 184.0100n 0.002106 184.0200n 0.002131 184.0300n 0.002156 184.0400n 0.002180
+ 184.0500n 0.002203 184.0600n 0.002225 184.0700n 0.002247 184.0800n 0.002268 184.0900n 0.002288 184.1000n 0.002308 184.1100n 0.002327 184.1200n 0.002345 184.1300n 0.002362 184.1400n 0.002379 184.1500n 0.002395 184.1600n 0.002410 184.1700n 0.002424 184.1800n 0.002437 184.1900n 0.002450
+ 184.2000n 0.002462 184.2100n 0.002473 184.2200n 0.002483 184.2300n 0.002492 184.2400n 0.002501 184.2500n 0.002508 184.2600n 0.002515 184.2700n 0.002521 184.2800n 0.002526 184.2900n 0.002531 184.3000n 0.002534 184.3100n 0.002537 184.3200n 0.002538 184.3300n 0.002539 184.3400n 0.002539
+ 184.3500n 0.002538 184.3600n 0.002537 184.3700n 0.002534 184.3800n 0.002531 184.3900n 0.002526 184.4000n 0.002521 184.4100n 0.002515 184.4200n 0.002508 184.4300n 0.002500 184.4400n 0.002492 184.4500n 0.002482 184.4600n 0.002472 184.4700n 0.002460 184.4800n 0.002448 184.4900n 0.002435
+ 184.5000n 0.002422 184.5100n 0.002407 184.5200n 0.002392 184.5300n 0.002375 184.5400n 0.002358 184.5500n 0.002340 184.5600n 0.002322 184.5700n 0.002302 184.5800n 0.002282 184.5900n 0.002261 184.6000n 0.002239 184.6100n 0.002216 184.6200n 0.002193 184.6300n 0.002169 184.6400n 0.002144
+ 184.6500n 0.002118 184.6600n 0.002092 184.6700n 0.002065 184.6800n 0.002037 184.6900n 0.002009 184.7000n 0.001980 184.7100n 0.001950 184.7200n 0.001920 184.7300n 0.001889 184.7400n 0.001857 184.7500n 0.001825 184.7600n 0.001792 184.7700n 0.001759 184.7800n 0.001725 184.7900n 0.001691
+ 184.8000n 0.001655 184.8100n 0.001620 184.8200n 0.001584 184.8300n 0.001547 184.8400n 0.001510 184.8500n 0.001473 184.8600n 0.001435 184.8700n 0.001397 184.8800n 0.001358 184.8900n 0.001319 184.9000n 0.001280 184.9100n 0.001240 184.9200n 0.001200 184.9300n 0.001160 184.9400n 0.001119
+ 184.9500n 0.001078 184.9600n 0.001037 184.9700n 0.000996 184.9800n 0.000954 184.9900n 0.000912 185.0000n 0.000870 185.0100n 0.000828 185.0200n 0.000786 185.0300n 0.000744 185.0400n 0.000701 185.0500n 0.000659 185.0600n 0.000616 185.0700n 0.000574 185.0800n 0.000531 185.0900n 0.000489
+ 185.1000n 0.000447 185.1100n 0.000404 185.1200n 0.000362 185.1300n 0.000320 185.1400n 0.000278 185.1500n 0.000236 185.1600n 0.000194 185.1700n 0.000153 185.1800n 0.000111 185.1900n 0.000070 185.2000n 0.000030 185.2100n -0.000011 185.2200n -0.000051 185.2300n -0.000091 185.2400n -0.000131
+ 185.2500n -0.000170 185.2600n -0.000209 185.2700n -0.000247 185.2800n -0.000285 185.2900n -0.000322 185.3000n -0.000359 185.3100n -0.000396 185.3200n -0.000432 185.3300n -0.000468 185.3400n -0.000503 185.3500n -0.000537 185.3600n -0.000571 185.3700n -0.000604 185.3800n -0.000637 185.3900n -0.000669
+ 185.4000n -0.000700 185.4100n -0.000731 185.4200n -0.000761 185.4300n -0.000790 185.4400n -0.000819 185.4500n -0.000847 185.4600n -0.000874 185.4700n -0.000901 185.4800n -0.000926 185.4900n -0.000951 185.5000n -0.000975 185.5100n -0.000999 185.5200n -0.001021 185.5300n -0.001043 185.5400n -0.001063
+ 185.5500n -0.001083 185.5600n -0.001102 185.5700n -0.001121 185.5800n -0.001138 185.5900n -0.001154 185.6000n -0.001170 185.6100n -0.001184 185.6200n -0.001198 185.6300n -0.001211 185.6400n -0.001223 185.6500n -0.001234 185.6600n -0.001243 185.6700n -0.001252 185.6800n -0.001261 185.6900n -0.001268
+ 185.7000n -0.001274 185.7100n -0.001279 185.7200n -0.001283 185.7300n -0.001287 185.7400n -0.001289 185.7500n -0.001290 185.7600n -0.001291 185.7700n -0.001290 185.7800n -0.001289 185.7900n -0.001286 185.8000n -0.001283 185.8100n -0.001278 185.8200n -0.001273 185.8300n -0.001267 185.8400n -0.001260
+ 185.8500n -0.001252 185.8600n -0.001243 185.8700n -0.001233 185.8800n -0.001222 185.8900n -0.001210 185.9000n -0.001198 185.9100n -0.001184 185.9200n -0.001170 185.9300n -0.001155 185.9400n -0.001139 185.9500n -0.001122 185.9600n -0.001104 185.9700n -0.001086 185.9800n -0.001066 185.9900n -0.001046
+ 186.0000n -0.001025 186.0100n -0.001004 186.0200n -0.000982 186.0300n -0.000958 186.0400n -0.000935 186.0500n -0.000910 186.0600n -0.000885 186.0700n -0.000860 186.0800n -0.000833 186.0900n -0.000806 186.1000n -0.000779 186.1100n -0.000751 186.1200n -0.000722 186.1300n -0.000693 186.1400n -0.000663
+ 186.1500n -0.000633 186.1600n -0.000602 186.1700n -0.000571 186.1800n -0.000539 186.1900n -0.000507 186.2000n -0.000475 186.2100n -0.000442 186.2200n -0.000409 186.2300n -0.000376 186.2400n -0.000342 186.2500n -0.000308 186.2600n -0.000274 186.2700n -0.000240 186.2800n -0.000205 186.2900n -0.000170
+ 186.3000n -0.000135 186.3100n -0.000100 186.3200n -0.000065 186.3300n -0.000030 186.3400n 0.000005 186.3500n 0.000040 186.3600n 0.000076 186.3700n 0.000111 186.3800n 0.000146 186.3900n 0.000181 186.4000n 0.000216 186.4100n 0.000251 186.4200n 0.000286 186.4300n 0.000320 186.4400n 0.000354
+ 186.4500n 0.000388 186.4600n 0.000422 186.4700n 0.000456 186.4800n 0.000489 186.4900n 0.000522 186.5000n 0.000555 186.5100n 0.000587 186.5200n 0.000619 186.5300n 0.000650 186.5400n 0.000681 186.5500n 0.000712 186.5600n 0.000742 186.5700n 0.000771 186.5800n 0.000800 186.5900n 0.000829
+ 186.6000n 0.000857 186.6100n 0.000884 186.6200n 0.000911 186.6300n 0.000937 186.6400n 0.000962 186.6500n 0.000987 186.6600n 0.001011 186.6700n 0.001035 186.6800n 0.001057 186.6900n 0.001079 186.7000n 0.001101 186.7100n 0.001121 186.7200n 0.001141 186.7300n 0.001160 186.7400n 0.001178
+ 186.7500n 0.001196 186.7600n 0.001212 186.7700n 0.001228 186.7800n 0.001243 186.7900n 0.001257 186.8000n 0.001270 186.8100n 0.001282 186.8200n 0.001294 186.8300n 0.001304 186.8400n 0.001314 186.8500n 0.001322 186.8600n 0.001330 186.8700n 0.001337 186.8800n 0.001343 186.8900n 0.001348
+ 186.9000n 0.001352 186.9100n 0.001355 186.9200n 0.001358 186.9300n 0.001359 186.9400n 0.001360 186.9500n 0.001359 186.9600n 0.001358 186.9700n 0.001355 186.9800n 0.001352 186.9900n 0.001348 187.0000n 0.001343 187.0100n 0.001337 187.0200n 0.001330 187.0300n 0.001322 187.0400n 0.001313
+ 187.0500n 0.001304 187.0600n 0.001293 187.0700n 0.001282 187.0800n 0.001270 187.0900n 0.001257 187.1000n 0.001243 187.1100n 0.001228 187.1200n 0.001212 187.1300n 0.001196 187.1400n 0.001179 187.1500n 0.001161 187.1600n 0.001143 187.1700n 0.001123 187.1800n 0.001103 187.1900n 0.001082
+ 187.2000n 0.001061 187.2100n 0.001039 187.2200n 0.001016 187.2300n 0.000992 187.2400n 0.000968 187.2500n 0.000943 187.2600n 0.000918 187.2700n 0.000892 187.2800n 0.000866 187.2900n 0.000839 187.3000n 0.000811 187.3100n 0.000783 187.3200n 0.000755 187.3300n 0.000726 187.3400n 0.000697
+ 187.3500n 0.000667 187.3600n 0.000638 187.3700n 0.000607 187.3800n 0.000577 187.3900n 0.000546 187.4000n 0.000515 187.4100n 0.000483 187.4200n 0.000452 187.4300n 0.000420 187.4400n 0.000388 187.4500n 0.000356 187.4600n 0.000323 187.4700n 0.000291 187.4800n 0.000259 187.4900n 0.000226
+ 187.5000n 0.000194 187.5100n 0.000161 187.5200n 0.000129 187.5300n 0.000097 187.5400n 0.000065 187.5500n 0.000032 187.5600n 0.000001 187.5700n -0.000031 187.5800n -0.000063 187.5900n -0.000094 187.6000n -0.000125 187.6100n -0.000156 187.6200n -0.000187 187.6300n -0.000217 187.6400n -0.000247
+ 187.6500n -0.000276 187.6600n -0.000305 187.6700n -0.000334 187.6800n -0.000362 187.6900n -0.000390 187.7000n -0.000417 187.7100n -0.000444 187.7200n -0.000470 187.7300n -0.000496 187.7400n -0.000521 187.7500n -0.000545 187.7600n -0.000569 187.7700n -0.000593 187.7800n -0.000615 187.7900n -0.000637
+ 187.8000n -0.000658 187.8100n -0.000679 187.8200n -0.000699 187.8300n -0.000718 187.8400n -0.000736 187.8500n -0.000754 187.8600n -0.000770 187.8700n -0.000786 187.8800n -0.000801 187.8900n -0.000816 187.9000n -0.000829 187.9100n -0.000842 187.9200n -0.000854 187.9300n -0.000864 187.9400n -0.000874
+ 187.9500n -0.000884 187.9600n -0.000892 187.9700n -0.000899 187.9800n -0.000906 187.9900n -0.000911 188.0000n -0.000916 188.0100n -0.000919 188.0200n -0.000922 188.0300n -0.000924 188.0400n -0.000925 188.0500n -0.000925 188.0600n -0.000924 188.0700n -0.000922 188.0800n -0.000919 188.0900n -0.000915
+ 188.1000n -0.000910 188.1100n -0.000904 188.1200n -0.000898 188.1300n -0.000890 188.1400n -0.000882 188.1500n -0.000872 188.1600n -0.000862 188.1700n -0.000851 188.1800n -0.000839 188.1900n -0.000826 188.2000n -0.000812 188.2100n -0.000798 188.2200n -0.000782 188.2300n -0.000766 188.2400n -0.000749
+ 188.2500n -0.000731 188.2600n -0.000712 188.2700n -0.000692 188.2800n -0.000672 188.2900n -0.000651 188.3000n -0.000629 188.3100n -0.000607 188.3200n -0.000584 188.3300n -0.000560 188.3400n -0.000535 188.3500n -0.000510 188.3600n -0.000484 188.3700n -0.000458 188.3800n -0.000431 188.3900n -0.000403
+ 188.4000n -0.000375 188.4100n -0.000346 188.4200n -0.000317 188.4300n -0.000288 188.4400n -0.000257 188.4500n -0.000227 188.4600n -0.000196 188.4700n -0.000165 188.4800n -0.000133 188.4900n -0.000101 188.5000n -0.000069 188.5100n -0.000036 188.5200n -0.000004 188.5300n 0.000029 188.5400n 0.000063
+ 188.5500n 0.000096 188.5600n 0.000130 188.5700n 0.000163 188.5800n 0.000197 188.5900n 0.000231 188.6000n 0.000265 188.6100n 0.000299 188.6200n 0.000333 188.6300n 0.000366 188.6400n 0.000400 188.6500n 0.000434 188.6600n 0.000468 188.6700n 0.000501 188.6800n 0.000534 188.6900n 0.000567
+ 188.7000n 0.000600 188.7100n 0.000633 188.7200n 0.000665 188.7300n 0.000697 188.7400n 0.000729 188.7500n 0.000760 188.7600n 0.000791 188.7700n 0.000822 188.7800n 0.000852 188.7900n 0.000882 188.8000n 0.000911 188.8100n 0.000940 188.8200n 0.000968 188.8300n 0.000995 188.8400n 0.001023
+ 188.8500n 0.001049 188.8600n 0.001075 188.8700n 0.001100 188.8800n 0.001125 188.8900n 0.001149 188.9000n 0.001172 188.9100n 0.001195 188.9200n 0.001217 188.9300n 0.001238 188.9400n 0.001258 188.9500n 0.001278 188.9600n 0.001297 188.9700n 0.001315 188.9800n 0.001332 188.9900n 0.001349
+ 189.0000n 0.001364 189.0100n 0.001379 189.0200n 0.001393 189.0300n 0.001406 189.0400n 0.001418 189.0500n 0.001429 189.0600n 0.001439 189.0700n 0.001449 189.0800n 0.001457 189.0900n 0.001465 189.1000n 0.001471 189.1100n 0.001477 189.1200n 0.001482 189.1300n 0.001485 189.1400n 0.001488
+ 189.1500n 0.001490 189.1600n 0.001491 189.1700n 0.001491 189.1800n 0.001490 189.1900n 0.001488 189.2000n 0.001485 189.2100n 0.001482 189.2200n 0.001477 189.2300n 0.001471 189.2400n 0.001465 189.2500n 0.001457 189.2600n 0.001449 189.2700n 0.001439 189.2800n 0.001429 189.2900n 0.001418
+ 189.3000n 0.001406 189.3100n 0.001393 189.3200n 0.001380 189.3300n 0.001365 189.3400n 0.001350 189.3500n 0.001333 189.3600n 0.001316 189.3700n 0.001298 189.3800n 0.001280 189.3900n 0.001260 189.4000n 0.001240 189.4100n 0.001219 189.4200n 0.001198 189.4300n 0.001175 189.4400n 0.001152
+ 189.4500n 0.001129 189.4600n 0.001105 189.4700n 0.001080 189.4800n 0.001054 189.4900n 0.001028 189.5000n 0.001002 189.5100n 0.000974 189.5200n 0.000947 189.5300n 0.000919 189.5400n 0.000890 189.5500n 0.000861 189.5600n 0.000831 189.5700n 0.000801 189.5800n 0.000771 189.5900n 0.000741
+ 189.6000n 0.000710 189.6100n 0.000678 189.6200n 0.000647 189.6300n 0.000615 189.6400n 0.000583 189.6500n 0.000551 189.6600n 0.000519 189.6700n 0.000486 189.6800n 0.000454 189.6900n 0.000421 189.7000n 0.000389 189.7100n 0.000356 189.7200n 0.000323 189.7300n 0.000290 189.7400n 0.000258
+ 189.7500n 0.000225 189.7600n 0.000193 189.7700n 0.000160 189.7800n 0.000128 189.7900n 0.000096 189.8000n 0.000064 189.8100n 0.000033 189.8200n 0.000001 189.8300n -0.000030 189.8400n -0.000060 189.8500n -0.000091 189.8600n -0.000121 189.8700n -0.000151 189.8800n -0.000180 189.8900n -0.000209
+ 189.9000n -0.000237 189.9100n -0.000265 189.9200n -0.000292 189.9300n -0.000319 189.9400n -0.000346 189.9500n -0.000372 189.9600n -0.000397 189.9700n -0.000421 189.9800n -0.000445 189.9900n -0.000469 190.0000n -0.000492 190.0100n -0.000514 190.0200n -0.000535 190.0300n -0.000556 190.0400n -0.000576
+ 190.0500n -0.000595 190.0600n -0.000613 190.0700n -0.000631 190.0800n -0.000648 190.0900n -0.000664 190.1000n -0.000679 190.1100n -0.000694 190.1200n -0.000707 190.1300n -0.000720 190.1400n -0.000732 190.1500n -0.000743 190.1600n -0.000754 190.1700n -0.000763 190.1800n -0.000772 190.1900n -0.000779
+ 190.2000n -0.000786 190.2100n -0.000792 190.2200n -0.000797 190.2300n -0.000801 190.2400n -0.000805 190.2500n -0.000807 190.2600n -0.000809 190.2700n -0.000809 190.2800n -0.000809 190.2900n -0.000808 190.3000n -0.000806 190.3100n -0.000803 190.3200n -0.000799 190.3300n -0.000794 190.3400n -0.000789
+ 190.3500n -0.000782 190.3600n -0.000775 190.3700n -0.000767 190.3800n -0.000758 190.3900n -0.000748 190.4000n -0.000738 190.4100n -0.000726 190.4200n -0.000714 190.4300n -0.000701 190.4400n -0.000688 190.4500n -0.000673 190.4600n -0.000658 190.4700n -0.000643 190.4800n -0.000626 190.4900n -0.000609
+ 190.5000n -0.000591 190.5100n -0.000573 190.5200n -0.000554 190.5300n -0.000534 190.5400n -0.000514 190.5500n -0.000493 190.5600n -0.000471 190.5700n -0.000449 190.5800n -0.000427 190.5900n -0.000404 190.6000n -0.000381 190.6100n -0.000357 190.6200n -0.000333 190.6300n -0.000308 190.6400n -0.000283
+ 190.6500n -0.000258 190.6600n -0.000232 190.6700n -0.000207 190.6800n -0.000180 190.6900n -0.000154 190.7000n -0.000127 190.7100n -0.000101 190.7200n -0.000074 190.7300n -0.000047 190.7400n -0.000020 190.7500n 0.000008 190.7600n 0.000035 190.7700n 0.000062 190.7800n 0.000089 190.7900n 0.000117
+ 190.8000n 0.000144 190.8100n 0.000171 190.8200n 0.000198 190.8300n 0.000225 190.8400n 0.000251 190.8500n 0.000278 190.8600n 0.000304 190.8700n 0.000330 190.8800n 0.000356 190.8900n 0.000381 190.9000n 0.000406 190.9100n 0.000431 190.9200n 0.000455 190.9300n 0.000479 190.9400n 0.000503
+ 190.9500n 0.000526 190.9600n 0.000549 190.9700n 0.000571 190.9800n 0.000592 190.9900n 0.000613 191.0000n 0.000634 191.0100n 0.000653 191.0200n 0.000673 191.0300n 0.000691 191.0400n 0.000709 191.0500n 0.000726 191.0600n 0.000743 191.0700n 0.000759 191.0800n 0.000774 191.0900n 0.000788
+ 191.1000n 0.000802 191.1100n 0.000814 191.1200n 0.000826 191.1300n 0.000838 191.1400n 0.000848 191.1500n 0.000857 191.1600n 0.000866 191.1700n 0.000873 191.1800n 0.000880 191.1900n 0.000886 191.2000n 0.000891 191.2100n 0.000895 191.2200n 0.000898 191.2300n 0.000900 191.2400n 0.000902
+ 191.2500n 0.000902 191.2600n 0.000901 191.2700n 0.000899 191.2800n 0.000897 191.2900n 0.000893 191.3000n 0.000888 191.3100n 0.000883 191.3200n 0.000876 191.3300n 0.000868 191.3400n 0.000860 191.3500n 0.000850 191.3600n 0.000839 191.3700n 0.000828 191.3800n 0.000815 191.3900n 0.000802
+ 191.4000n 0.000787 191.4100n 0.000772 191.4200n 0.000755 191.4300n 0.000738 191.4400n 0.000719 191.4500n 0.000700 191.4600n 0.000680 191.4700n 0.000659 191.4800n 0.000636 191.4900n 0.000613 191.5000n 0.000589 191.5100n 0.000565 191.5200n 0.000539 191.5300n 0.000512 191.5400n 0.000485
+ 191.5500n 0.000457 191.5600n 0.000428 191.5700n 0.000398 191.5800n 0.000368 191.5900n 0.000336 191.6000n 0.000304 191.6100n 0.000272 191.6200n 0.000238 191.6300n 0.000204 191.6400n 0.000169 191.6500n 0.000134 191.6600n 0.000098 191.6700n 0.000061 191.6800n 0.000024 191.6900n -0.000013
+ 191.7000n -0.000052 191.7100n -0.000090 191.7200n -0.000130 191.7300n -0.000169 191.7400n -0.000209 191.7500n -0.000250 191.7600n -0.000290 191.7700n -0.000332 191.7800n -0.000373 191.7900n -0.000415 191.8000n -0.000457 191.8100n -0.000499 191.8200n -0.000541 191.8300n -0.000584 191.8400n -0.000627
+ 191.8500n -0.000669 191.8600n -0.000712 191.8700n -0.000755 191.8800n -0.000798 191.8900n -0.000841 191.9000n -0.000884 191.9100n -0.000927 191.9200n -0.000970 191.9300n -0.001013 191.9400n -0.001056 191.9500n -0.001098 191.9600n -0.001141 191.9700n -0.001183 191.9800n -0.001224 191.9900n -0.001266
+ 192.0000n -0.001307 192.0100n -0.001348 192.0200n -0.001389 192.0300n -0.001429 192.0400n -0.001468 192.0500n -0.001508 192.0600n -0.001547 192.0700n -0.001585 192.0800n -0.001623 192.0900n -0.001660 192.1000n -0.001697 192.1100n -0.001733 192.1200n -0.001768 192.1300n -0.001803 192.1400n -0.001837
+ 192.1500n -0.001871 192.1600n -0.001904 192.1700n -0.001936 192.1800n -0.001967 192.1900n -0.001998 192.2000n -0.002028 192.2100n -0.002057 192.2200n -0.002085 192.2300n -0.002112 192.2400n -0.002139 192.2500n -0.002164 192.2600n -0.002189 192.2700n -0.002213 192.2800n -0.002236 192.2900n -0.002258
+ 192.3000n -0.002279 192.3100n -0.002299 192.3200n -0.002318 192.3300n -0.002336 192.3400n -0.002353 192.3500n -0.002369 192.3600n -0.002384 192.3700n -0.002398 192.3800n -0.002412 192.3900n -0.002424 192.4000n -0.002435 192.4100n -0.002444 192.4200n -0.002453 192.4300n -0.002461 192.4400n -0.002468
+ 192.4500n -0.002474 192.4600n -0.002478 192.4700n -0.002482 192.4800n -0.002485 192.4900n -0.002486 192.5000n -0.002486 192.5100n -0.002486 192.5200n -0.002484 192.5300n -0.002481 192.5400n -0.002478 192.5500n -0.002473 192.5600n -0.002467 192.5700n -0.002460 192.5800n -0.002452 192.5900n -0.002443
+ 192.6000n -0.002434 192.6100n -0.002423 192.6200n -0.002411 192.6300n -0.002398 192.6400n -0.002384 192.6500n -0.002369 192.6600n -0.002354 192.6700n -0.002337 192.6800n -0.002320 192.6900n -0.002301 192.7000n -0.002282 192.7100n -0.002262 192.7200n -0.002241 192.7300n -0.002219 192.7400n -0.002196
+ 192.7500n -0.002173 192.7600n -0.002149 192.7700n -0.002124 192.7800n -0.002098 192.7900n -0.002072 192.8000n -0.002045 192.8100n -0.002017 192.8200n -0.001989 192.8300n -0.001960 192.8400n -0.001930 192.8500n -0.001900 192.8600n -0.001869 192.8700n -0.001838 192.8800n -0.001806 192.8900n -0.001774
+ 192.9000n -0.001741 192.9100n -0.001708 192.9200n -0.001674 192.9300n -0.001640 192.9400n -0.001606 192.9500n -0.001571 192.9600n -0.001536 192.9700n -0.001501 192.9800n -0.001465 192.9900n -0.001429 193.0000n -0.001393 193.0100n -0.001357 193.0200n -0.001320 193.0300n -0.001284 193.0400n -0.001247
+ 193.0500n -0.001210 193.0600n -0.001173 193.0700n -0.001136 193.0800n -0.001100 193.0900n -0.001063 193.1000n -0.001026 193.1100n -0.000989 193.1200n -0.000952 193.1300n -0.000916 193.1400n -0.000879 193.1500n -0.000843 193.1600n -0.000807 193.1700n -0.000771 193.1800n -0.000735 193.1900n -0.000700
+ 193.2000n -0.000665 193.2100n -0.000630 193.2200n -0.000596 193.2300n -0.000561 193.2400n -0.000528 193.2500n -0.000494 193.2600n -0.000461 193.2700n -0.000429 193.2800n -0.000397 193.2900n -0.000365 193.3000n -0.000334 193.3100n -0.000303 193.3200n -0.000273 193.3300n -0.000243 193.3400n -0.000214
+ 193.3500n -0.000186 193.3600n -0.000158 193.3700n -0.000131 193.3800n -0.000104 193.3900n -0.000078 193.4000n -0.000053 193.4100n -0.000028 193.4200n -0.000004 193.4300n 0.000019 193.4400n 0.000042 193.4500n 0.000064 193.4600n 0.000085 193.4700n 0.000105 193.4800n 0.000125 193.4900n 0.000144
+ 193.5000n 0.000162 193.5100n 0.000180 193.5200n 0.000196 193.5300n 0.000212 193.5400n 0.000227 193.5500n 0.000242 193.5600n 0.000255 193.5700n 0.000268 193.5800n 0.000280 193.5900n 0.000291 193.6000n 0.000301 193.6100n 0.000311 193.6200n 0.000320 193.6300n 0.000328 193.6400n 0.000335
+ 193.6500n 0.000341 193.6600n 0.000347 193.6700n 0.000351 193.6800n 0.000355 193.6900n 0.000358 193.7000n 0.000361 193.7100n 0.000362 193.7200n 0.000363 193.7300n 0.000363 193.7400n 0.000363 193.7500n 0.000361 193.7600n 0.000359 193.7700n 0.000356 193.7800n 0.000352 193.7900n 0.000348
+ 193.8000n 0.000343 193.8100n 0.000337 193.8200n 0.000330 193.8300n 0.000323 193.8400n 0.000315 193.8500n 0.000307 193.8600n 0.000298 193.8700n 0.000288 193.8800n 0.000278 193.8900n 0.000267 193.9000n 0.000255 193.9100n 0.000243 193.9200n 0.000230 193.9300n 0.000217 193.9400n 0.000203
+ 193.9500n 0.000189 193.9600n 0.000174 193.9700n 0.000159 193.9800n 0.000143 193.9900n 0.000127 194.0000n 0.000110 194.0100n 0.000093 194.0200n 0.000076 194.0300n 0.000058 194.0400n 0.000040 194.0500n 0.000022 194.0600n 0.000003 194.0700n -0.000016 194.0800n -0.000036 194.0900n -0.000055
+ 194.1000n -0.000075 194.1100n -0.000095 194.1200n -0.000116 194.1300n -0.000136 194.1400n -0.000157 194.1500n -0.000178 194.1600n -0.000199 194.1700n -0.000220 194.1800n -0.000241 194.1900n -0.000262 194.2000n -0.000283 194.2100n -0.000305 194.2200n -0.000326 194.2300n -0.000347 194.2400n -0.000369
+ 194.2500n -0.000390 194.2600n -0.000411 194.2700n -0.000433 194.2800n -0.000454 194.2900n -0.000475 194.3000n -0.000496 194.3100n -0.000516 194.3200n -0.000537 194.3300n -0.000557 194.3400n -0.000577 194.3500n -0.000597 194.3600n -0.000617 194.3700n -0.000637 194.3800n -0.000656 194.3900n -0.000675
+ 194.4000n -0.000694 194.4100n -0.000712 194.4200n -0.000730 194.4300n -0.000748 194.4400n -0.000765 194.4500n -0.000782 194.4600n -0.000799 194.4700n -0.000815 194.4800n -0.000831 194.4900n -0.000847 194.5000n -0.000862 194.5100n -0.000877 194.5200n -0.000891 194.5300n -0.000905 194.5400n -0.000918
+ 194.5500n -0.000931 194.5600n -0.000943 194.5700n -0.000955 194.5800n -0.000967 194.5900n -0.000978 194.6000n -0.000988 194.6100n -0.000998 194.6200n -0.001007 194.6300n -0.001016 194.6400n -0.001025 194.6500n -0.001032 194.6600n -0.001040 194.6700n -0.001046 194.6800n -0.001052 194.6900n -0.001058
+ 194.7000n -0.001063 194.7100n -0.001068 194.7200n -0.001071 194.7300n -0.001075 194.7400n -0.001078 194.7500n -0.001080 194.7600n -0.001081 194.7700n -0.001083 194.7800n -0.001083 194.7900n -0.001083 194.8000n -0.001082 194.8100n -0.001081 194.8200n -0.001079 194.8300n -0.001077 194.8400n -0.001074
+ 194.8500n -0.001071 194.8600n -0.001067 194.8700n -0.001062 194.8800n -0.001057 194.8900n -0.001052 194.9000n -0.001045 194.9100n -0.001039 194.9200n -0.001031 194.9300n -0.001024 194.9400n -0.001015 194.9500n -0.001007 194.9600n -0.000997 194.9700n -0.000988 194.9800n -0.000977 194.9900n -0.000967
+ 195.0000n -0.000955 195.0100n -0.000944 195.0200n -0.000931 195.0300n -0.000919 195.0400n -0.000906 195.0500n -0.000892 195.0600n -0.000878 195.0700n -0.000864 195.0800n -0.000849 195.0900n -0.000834 195.1000n -0.000818 195.1100n -0.000802 195.1200n -0.000786 195.1300n -0.000769 195.1400n -0.000752
+ 195.1500n -0.000735 195.1600n -0.000717 195.1700n -0.000699 195.1800n -0.000681 195.1900n -0.000662 195.2000n -0.000643 195.2100n -0.000623 195.2200n -0.000604 195.2300n -0.000584 195.2400n -0.000564 195.2500n -0.000544 195.2600n -0.000523 195.2700n -0.000502 195.2800n -0.000481 195.2900n -0.000460
+ 195.3000n -0.000438 195.3100n -0.000417 195.3200n -0.000395 195.3300n -0.000373 195.3400n -0.000351 195.3500n -0.000328 195.3600n -0.000306 195.3700n -0.000283 195.3800n -0.000261 195.3900n -0.000238 195.4000n -0.000215 195.4100n -0.000192 195.4200n -0.000169 195.4300n -0.000146 195.4400n -0.000123
+ 195.4500n -0.000099 195.4600n -0.000076 195.4700n -0.000053 195.4800n -0.000029 195.4900n -0.000006 195.5000n 0.000018 195.5100n 0.000041 195.5200n 0.000065 195.5300n 0.000088 195.5400n 0.000112 195.5500n 0.000135 195.5600n 0.000159 195.5700n 0.000182 195.5800n 0.000205 195.5900n 0.000229
+ 195.6000n 0.000252 195.6100n 0.000275 195.6200n 0.000298 195.6300n 0.000321 195.6400n 0.000344 195.6500n 0.000367 195.6600n 0.000390 195.6700n 0.000413 195.6800n 0.000436 195.6900n 0.000458 195.7000n 0.000481 195.7100n 0.000503 195.7200n 0.000525 195.7300n 0.000547 195.7400n 0.000569
+ 195.7500n 0.000591 195.7600n 0.000613 195.7700n 0.000635 195.7800n 0.000656 195.7900n 0.000678 195.8000n 0.000699 195.8100n 0.000720 195.8200n 0.000741 195.8300n 0.000762 195.8400n 0.000783 195.8500n 0.000803 195.8600n 0.000824 195.8700n 0.000844 195.8800n 0.000864 195.8900n 0.000884
+ 195.9000n 0.000904 195.9100n 0.000924 195.9200n 0.000943 195.9300n 0.000963 195.9400n 0.000982 195.9500n 0.001001 195.9600n 0.001020 195.9700n 0.001039 195.9800n 0.001057 195.9900n 0.001076 196.0000n 0.001094 196.0100n 0.001112 196.0200n 0.001130 196.0300n 0.001148 196.0400n 0.001166
+ 196.0500n 0.001183 196.0600n 0.001201 196.0700n 0.001218 196.0800n 0.001235 196.0900n 0.001252 196.1000n 0.001269 196.1100n 0.001285 196.1200n 0.001302 196.1300n 0.001318 196.1400n 0.001334 196.1500n 0.001350 196.1600n 0.001366 196.1700n 0.001382 196.1800n 0.001397 196.1900n 0.001412
+ 196.2000n 0.001428 196.2100n 0.001443 196.2200n 0.001458 196.2300n 0.001472 196.2400n 0.001487 196.2500n 0.001501 196.2600n 0.001515 196.2700n 0.001529 196.2800n 0.001543 196.2900n 0.001557 196.3000n 0.001571 196.3100n 0.001584 196.3200n 0.001597 196.3300n 0.001610 196.3400n 0.001623
+ 196.3500n 0.001636 196.3600n 0.001649 196.3700n 0.001661 196.3800n 0.001673 196.3900n 0.001685 196.4000n 0.001697 196.4100n 0.001709 196.4200n 0.001720 196.4300n 0.001732 196.4400n 0.001743 196.4500n 0.001754 196.4600n 0.001764 196.4700n 0.001775 196.4800n 0.001785 196.4900n 0.001795
+ 196.5000n 0.001805 196.5100n 0.001815 196.5200n 0.001824 196.5300n 0.001834 196.5400n 0.001843 196.5500n 0.001852 196.5600n 0.001860 196.5700n 0.001868 196.5800n 0.001877 196.5900n 0.001884 196.6000n 0.001892 196.6100n 0.001899 196.6200n 0.001907 196.6300n 0.001913 196.6400n 0.001920
+ 196.6500n 0.001926 196.6600n 0.001932 196.6700n 0.001938 196.6800n 0.001944 196.6900n 0.001949 196.7000n 0.001954 196.7100n 0.001958 196.7200n 0.001963 196.7300n 0.001967 196.7400n 0.001970 196.7500n 0.001974 196.7600n 0.001977 196.7700n 0.001979 196.7800n 0.001982 196.7900n 0.001984
+ 196.8000n 0.001985 196.8100n 0.001987 196.8200n 0.001988 196.8300n 0.001988 196.8400n 0.001988 196.8500n 0.001988 196.8600n 0.001988 196.8700n 0.001987 196.8800n 0.001985 196.8900n 0.001984 196.9000n 0.001981 196.9100n 0.001979 196.9200n 0.001976 196.9300n 0.001973 196.9400n 0.001969
+ 196.9500n 0.001965 196.9600n 0.001960 196.9700n 0.001955 196.9800n 0.001949 196.9900n 0.001943 197.0000n 0.001937 197.0100n 0.001930 197.0200n 0.001923 197.0300n 0.001915 197.0400n 0.001907 197.0500n 0.001898 197.0600n 0.001889 197.0700n 0.001879 197.0800n 0.001869 197.0900n 0.001859
+ 197.1000n 0.001848 197.1100n 0.001836 197.1200n 0.001824 197.1300n 0.001812 197.1400n 0.001799 197.1500n 0.001785 197.1600n 0.001771 197.1700n 0.001757 197.1800n 0.001742 197.1900n 0.001727 197.2000n 0.001711 197.2100n 0.001694 197.2200n 0.001678 197.2300n 0.001660 197.2400n 0.001642
+ 197.2500n 0.001624 197.2600n 0.001605 197.2700n 0.001586 197.2800n 0.001567 197.2900n 0.001546 197.3000n 0.001526 197.3100n 0.001505 197.3200n 0.001483 197.3300n 0.001461 197.3400n 0.001439 197.3500n 0.001416 197.3600n 0.001393 197.3700n 0.001369 197.3800n 0.001345 197.3900n 0.001321
+ 197.4000n 0.001296 197.4100n 0.001270 197.4200n 0.001245 197.4300n 0.001218 197.4400n 0.001192 197.4500n 0.001165 197.4600n 0.001138 197.4700n 0.001110 197.4800n 0.001082 197.4900n 0.001054 197.5000n 0.001026 197.5100n 0.000997 197.5200n 0.000968 197.5300n 0.000938 197.5400n 0.000909
+ 197.5500n 0.000879 197.5600n 0.000848 197.5700n 0.000818 197.5800n 0.000787 197.5900n 0.000756 197.6000n 0.000725 197.6100n 0.000694 197.6200n 0.000662 197.6300n 0.000631 197.6400n 0.000599 197.6500n 0.000567 197.6600n 0.000535 197.6700n 0.000503 197.6800n 0.000471 197.6900n 0.000439
+ 197.7000n 0.000406 197.7100n 0.000374 197.7200n 0.000341 197.7300n 0.000309 197.7400n 0.000277 197.7500n 0.000244 197.7600n 0.000212 197.7700n 0.000180 197.7800n 0.000147 197.7900n 0.000115 197.8000n 0.000083 197.8100n 0.000052 197.8200n 0.000020 197.8300n -0.000012 197.8400n -0.000043
+ 197.8500n -0.000074 197.8600n -0.000105 197.8700n -0.000136 197.8800n -0.000167 197.8900n -0.000197 197.9000n -0.000227 197.9100n -0.000256 197.9200n -0.000286 197.9300n -0.000315 197.9400n -0.000343 197.9500n -0.000372 197.9600n -0.000399 197.9700n -0.000427 197.9800n -0.000454 197.9900n -0.000481
+ 198.0000n -0.000507 198.0100n -0.000532 198.0200n -0.000558 198.0300n -0.000582 198.0400n -0.000607 198.0500n -0.000630 198.0600n -0.000653 198.0700n -0.000676 198.0800n -0.000698 198.0900n -0.000719 198.1000n -0.000740 198.1100n -0.000760 198.1200n -0.000779 198.1300n -0.000798 198.1400n -0.000816
+ 198.1500n -0.000834 198.1600n -0.000851 198.1700n -0.000867 198.1800n -0.000882 198.1900n -0.000897 198.2000n -0.000911 198.2100n -0.000924 198.2200n -0.000936 198.2300n -0.000948 198.2400n -0.000959 198.2500n -0.000969 198.2600n -0.000978 198.2700n -0.000986 198.2800n -0.000994 198.2900n -0.001001
+ 198.3000n -0.001007 198.3100n -0.001012 198.3200n -0.001016 198.3300n -0.001020 198.3400n -0.001022 198.3500n -0.001024 198.3600n -0.001025 198.3700n -0.001025 198.3800n -0.001024 198.3900n -0.001022 198.4000n -0.001019 198.4100n -0.001016 198.4200n -0.001011 198.4300n -0.001006 198.4400n -0.001000
+ 198.4500n -0.000993 198.4600n -0.000985 198.4700n -0.000976 198.4800n -0.000966 198.4900n -0.000956 198.5000n -0.000944 198.5100n -0.000932 198.5200n -0.000919 198.5300n -0.000905 198.5400n -0.000890 198.5500n -0.000874 198.5600n -0.000857 198.5700n -0.000840 198.5800n -0.000822 198.5900n -0.000803
+ 198.6000n -0.000783 198.6100n -0.000762 198.6200n -0.000740 198.6300n -0.000718 198.6400n -0.000695 198.6500n -0.000671 198.6600n -0.000647 198.6700n -0.000621 198.6800n -0.000595 198.6900n -0.000568 198.7000n -0.000541 198.7100n -0.000513 198.7200n -0.000484 198.7300n -0.000454 198.7400n -0.000424
+ 198.7500n -0.000394 198.7600n -0.000362 198.7700n -0.000330 198.7800n -0.000298 198.7900n -0.000265 198.8000n -0.000231 198.8100n -0.000197 198.8200n -0.000162 198.8300n -0.000127 198.8400n -0.000091 198.8500n -0.000055 198.8600n -0.000019 198.8700n 0.000018 198.8800n 0.000056 198.8900n 0.000093
+ 198.9000n 0.000131 198.9100n 0.000170 198.9200n 0.000208 198.9300n 0.000247 198.9400n 0.000287 198.9500n 0.000326 198.9600n 0.000366 198.9700n 0.000406 198.9800n 0.000446 198.9900n 0.000486 199.0000n 0.000526 199.0100n 0.000566 199.0200n 0.000607 199.0300n 0.000647 199.0400n 0.000688
+ 199.0500n 0.000729 199.0600n 0.000769 199.0700n 0.000810 199.0800n 0.000850 199.0900n 0.000890 199.1000n 0.000931 199.1100n 0.000971 199.1200n 0.001011 199.1300n 0.001050 199.1400n 0.001090 199.1500n 0.001129 199.1600n 0.001168 199.1700n 0.001207 199.1800n 0.001246 199.1900n 0.001284
+ 199.2000n 0.001322 199.2100n 0.001359 199.2200n 0.001396 199.2300n 0.001433 199.2400n 0.001469 199.2500n 0.001505 199.2600n 0.001540 199.2700n 0.001575 199.2800n 0.001609 199.2900n 0.001643 199.3000n 0.001676 199.3100n 0.001708 199.3200n 0.001740 199.3300n 0.001772 199.3400n 0.001802
+ 199.3500n 0.001832 199.3600n 0.001862 199.3700n 0.001890 199.3800n 0.001918 199.3900n 0.001946 199.4000n 0.001972 199.4100n 0.001998 199.4200n 0.002023 199.4300n 0.002047 199.4400n 0.002070 199.4500n 0.002092 199.4600n 0.002114 199.4700n 0.002135 199.4800n 0.002155 199.4900n 0.002174
+ 199.5000n 0.002192 199.5100n 0.002209 199.5200n 0.002225 199.5300n 0.002241 199.5400n 0.002255 199.5500n 0.002269 199.5600n 0.002281 199.5700n 0.002293 199.5800n 0.002304 199.5900n 0.002313 199.6000n 0.002322 199.6100n 0.002329 199.6200n 0.002336 199.6300n 0.002342 199.6400n 0.002346
+ 199.6500n 0.002350 199.6600n 0.002352 199.6700n 0.002354 199.6800n 0.002355 199.6900n 0.002354 199.7000n 0.002353 199.7100n 0.002350 199.7200n 0.002347 199.7300n 0.002342 199.7400n 0.002336 199.7500n 0.002330 199.7600n 0.002322 199.7700n 0.002313 199.7800n 0.002304 199.7900n 0.002293
+ 199.8000n 0.002281 199.8100n 0.002269 199.8200n 0.002255 199.8300n 0.002240 199.8400n 0.002224 199.8500n 0.002208 199.8600n 0.002190 199.8700n 0.002172 199.8800n 0.002152 199.8900n 0.002131 199.9000n 0.002110 199.9100n 0.002088 199.9200n 0.002064 199.9300n 0.002040 199.9400n 0.002015
+ 199.9500n 0.001989 199.9600n 0.001963 199.9700n 0.001935 199.9800n 0.001906 199.9900n 0.001877 200.0000n 0.001847 200.0100n 0.001816 200.0200n 0.001784 200.0300n 0.001752 200.0400n 0.001719 200.0500n 0.001685 200.0600n 0.001650 200.0700n 0.001615 200.0800n 0.001579 200.0900n 0.001542
+ 200.1000n 0.001505 200.1100n 0.001467 200.1200n 0.001428 200.1300n 0.001389 200.1400n 0.001349 200.1500n 0.001309 200.1600n 0.001268 200.1700n 0.001227 200.1800n 0.001185 200.1900n 0.001142 200.2000n 0.001100 200.2100n 0.001056 200.2200n 0.001013 200.2300n 0.000969 200.2400n 0.000924
+ 200.2500n 0.000879 200.2600n 0.000834 200.2700n 0.000789 200.2800n 0.000743 200.2900n 0.000697 200.3000n 0.000651 200.3100n 0.000605 200.3200n 0.000558 200.3300n 0.000511 200.3400n 0.000464 200.3500n 0.000417 200.3600n 0.000370 200.3700n 0.000322 200.3800n 0.000275 200.3900n 0.000227
+ 200.4000n 0.000180 200.4100n 0.000132 200.4200n 0.000085 200.4300n 0.000037 200.4400n -0.000010 200.4500n -0.000058 200.4600n -0.000105 200.4700n -0.000152 200.4800n -0.000199 200.4900n -0.000246 200.5000n -0.000293 200.5100n -0.000340 200.5200n -0.000386 200.5300n -0.000432 200.5400n -0.000478
+ 200.5500n -0.000524 200.5600n -0.000569 200.5700n -0.000614 200.5800n -0.000659 200.5900n -0.000703 200.6000n -0.000748 200.6100n -0.000791 200.6200n -0.000835 200.6300n -0.000878 200.6400n -0.000920 200.6500n -0.000962 200.6600n -0.001004 200.6700n -0.001045 200.6800n -0.001086 200.6900n -0.001127
+ 200.7000n -0.001166 200.7100n -0.001206 200.7200n -0.001244 200.7300n -0.001283 200.7400n -0.001320 200.7500n -0.001358 200.7600n -0.001394 200.7700n -0.001430 200.7800n -0.001466 200.7900n -0.001500 200.8000n -0.001535 200.8100n -0.001568 200.8200n -0.001601 200.8300n -0.001633 200.8400n -0.001665
+ 200.8500n -0.001696 200.8600n -0.001727 200.8700n -0.001756 200.8800n -0.001785 200.8900n -0.001814 200.9000n -0.001841 200.9100n -0.001868 200.9200n -0.001895 200.9300n -0.001920 200.9400n -0.001945 200.9500n -0.001970 200.9600n -0.001993 200.9700n -0.002016 200.9800n -0.002038 200.9900n -0.002060
+ 201.0000n -0.002080 201.0100n -0.002100 201.0200n -0.002120 201.0300n -0.002138 201.0400n -0.002156 201.0500n -0.002173 201.0600n -0.002190 201.0700n -0.002205 201.0800n -0.002221 201.0900n -0.002235 201.1000n -0.002249 201.1100n -0.002262 201.1200n -0.002274 201.1300n -0.002285 201.1400n -0.002296
+ 201.1500n -0.002307 201.1600n -0.002316 201.1700n -0.002325 201.1800n -0.002333 201.1900n -0.002341 201.2000n -0.002348 201.2100n -0.002354 201.2200n -0.002360 201.2300n -0.002365 201.2400n -0.002369 201.2500n -0.002373 201.2600n -0.002376 201.2700n -0.002379 201.2800n -0.002381 201.2900n -0.002382
+ 201.3000n -0.002383 201.3100n -0.002383 201.3200n -0.002383 201.3300n -0.002382 201.3400n -0.002380 201.3500n -0.002379 201.3600n -0.002376 201.3700n -0.002373 201.3800n -0.002370 201.3900n -0.002366 201.4000n -0.002362 201.4100n -0.002357 201.4200n -0.002351 201.4300n -0.002346 201.4400n -0.002339
+ 201.4500n -0.002333 201.4600n -0.002326 201.4700n -0.002318 201.4800n -0.002311 201.4900n -0.002302 201.5000n -0.002294 201.5100n -0.002285 201.5200n -0.002276 201.5300n -0.002266 201.5400n -0.002256 201.5500n -0.002246 201.5600n -0.002236 201.5700n -0.002225 201.5800n -0.002214 201.5900n -0.002203
+ 201.6000n -0.002191 201.6100n -0.002180 201.6200n -0.002168 201.6300n -0.002155 201.6400n -0.002143 201.6500n -0.002130 201.6600n -0.002118 201.6700n -0.002105 201.6800n -0.002092 201.6900n -0.002079 201.7000n -0.002065 201.7100n -0.002052 201.7200n -0.002038 201.7300n -0.002025 201.7400n -0.002011
+ 201.7500n -0.001997 201.7600n -0.001983 201.7700n -0.001969 201.7800n -0.001955 201.7900n -0.001941 201.8000n -0.001927 201.8100n -0.001913 201.8200n -0.001899 201.8300n -0.001885 201.8400n -0.001871 201.8500n -0.001856 201.8600n -0.001842 201.8700n -0.001828 201.8800n -0.001814 201.8900n -0.001801
+ 201.9000n -0.001787 201.9100n -0.001773 201.9200n -0.001759 201.9300n -0.001746 201.9400n -0.001732 201.9500n -0.001719 201.9600n -0.001705 201.9700n -0.001692 201.9800n -0.001679 201.9900n -0.001666 202.0000n -0.001653 202.0100n -0.001640 202.0200n -0.001628 202.0300n -0.001615 202.0400n -0.001603
+ 202.0500n -0.001591 202.0600n -0.001579 202.0700n -0.001567 202.0800n -0.001556 202.0900n -0.001544 202.1000n -0.001533 202.1100n -0.001522 202.1200n -0.001511 202.1300n -0.001500 202.1400n -0.001490 202.1500n -0.001479 202.1600n -0.001469 202.1700n -0.001459 202.1800n -0.001450 202.1900n -0.001440
+ 202.2000n -0.001431 202.2100n -0.001422 202.2200n -0.001413 202.2300n -0.001404 202.2400n -0.001396 202.2500n -0.001388 202.2600n -0.001380 202.2700n -0.001372 202.2800n -0.001364 202.2900n -0.001357 202.3000n -0.001350 202.3100n -0.001343 202.3200n -0.001336 202.3300n -0.001329 202.3400n -0.001323
+ 202.3500n -0.001317 202.3600n -0.001311 202.3700n -0.001305 202.3800n -0.001300 202.3900n -0.001295 202.4000n -0.001290 202.4100n -0.001285 202.4200n -0.001280 202.4300n -0.001275 202.4400n -0.001271 202.4500n -0.001267 202.4600n -0.001263 202.4700n -0.001260 202.4800n -0.001256 202.4900n -0.001253
+ 202.5000n -0.001250 202.5100n -0.001247 202.5200n -0.001244 202.5300n -0.001241 202.5400n -0.001239 202.5500n -0.001236 202.5600n -0.001234 202.5700n -0.001232 202.5800n -0.001230 202.5900n -0.001229 202.6000n -0.001227 202.6100n -0.001226 202.6200n -0.001225 202.6300n -0.001224 202.6400n -0.001223
+ 202.6500n -0.001222 202.6600n -0.001221 202.6700n -0.001220 202.6800n -0.001220 202.6900n -0.001219 202.7000n -0.001219 202.7100n -0.001219 202.7200n -0.001219 202.7300n -0.001219 202.7400n -0.001219 202.7500n -0.001219 202.7600n -0.001219 202.7700n -0.001220 202.7800n -0.001220 202.7900n -0.001221
+ 202.8000n -0.001221 202.8100n -0.001222 202.8200n -0.001222 202.8300n -0.001223 202.8400n -0.001224 202.8500n -0.001225 202.8600n -0.001225 202.8700n -0.001226 202.8800n -0.001227 202.8900n -0.001228 202.9000n -0.001229 202.9100n -0.001230 202.9200n -0.001231 202.9300n -0.001232 202.9400n -0.001233
+ 202.9500n -0.001234 202.9600n -0.001235 202.9700n -0.001236 202.9800n -0.001237 202.9900n -0.001237 203.0000n -0.001238 203.0100n -0.001239 203.0200n -0.001240 203.0300n -0.001241 203.0400n -0.001242 203.0500n -0.001242 203.0600n -0.001243 203.0700n -0.001244 203.0800n -0.001244 203.0900n -0.001245
+ 203.1000n -0.001245 203.1100n -0.001246 203.1200n -0.001246 203.1300n -0.001247 203.1400n -0.001247 203.1500n -0.001247 203.1600n -0.001247 203.1700n -0.001247 203.1800n -0.001247 203.1900n -0.001247 203.2000n -0.001247 203.2100n -0.001247 203.2200n -0.001246 203.2300n -0.001246 203.2400n -0.001245
+ 203.2500n -0.001245 203.2600n -0.001244 203.2700n -0.001243 203.2800n -0.001242 203.2900n -0.001241 203.3000n -0.001240 203.3100n -0.001239 203.3200n -0.001237 203.3300n -0.001236 203.3400n -0.001234 203.3500n -0.001233 203.3600n -0.001231 203.3700n -0.001229 203.3800n -0.001227 203.3900n -0.001225
+ 203.4000n -0.001223 203.4100n -0.001220 203.4200n -0.001218 203.4300n -0.001215 203.4400n -0.001212 203.4500n -0.001209 203.4600n -0.001207 203.4700n -0.001203 203.4800n -0.001200 203.4900n -0.001197 203.5000n -0.001193 203.5100n -0.001190 203.5200n -0.001186 203.5300n -0.001182 203.5400n -0.001178
+ 203.5500n -0.001174 203.5600n -0.001170 203.5700n -0.001165 203.5800n -0.001161 203.5900n -0.001156 203.6000n -0.001151 203.6100n -0.001146 203.6200n -0.001141 203.6300n -0.001136 203.6400n -0.001131 203.6500n -0.001125 203.6600n -0.001119 203.6700n -0.001114 203.6800n -0.001108 203.6900n -0.001102
+ 203.7000n -0.001096 203.7100n -0.001089 203.7200n -0.001083 203.7300n -0.001076 203.7400n -0.001070 203.7500n -0.001063 203.7600n -0.001056 203.7700n -0.001049 203.7800n -0.001042 203.7900n -0.001035 203.8000n -0.001027 203.8100n -0.001020 203.8200n -0.001012 203.8300n -0.001004 203.8400n -0.000996
+ 203.8500n -0.000988 203.8600n -0.000980 203.8700n -0.000971 203.8800n -0.000963 203.8900n -0.000954 203.9000n -0.000946 203.9100n -0.000937 203.9200n -0.000928 203.9300n -0.000919 203.9400n -0.000909 203.9500n -0.000900 203.9600n -0.000891 203.9700n -0.000881 203.9800n -0.000871 203.9900n -0.000862
+ 204.0000n -0.000852 204.0100n -0.000842 204.0200n -0.000832 204.0300n -0.000821 204.0400n -0.000811 204.0500n -0.000800 204.0600n -0.000790 204.0700n -0.000779 204.0800n -0.000768 204.0900n -0.000757 204.1000n -0.000746 204.1100n -0.000735 204.1200n -0.000724 204.1300n -0.000713 204.1400n -0.000701
+ 204.1500n -0.000690 204.1600n -0.000678 204.1700n -0.000666 204.1800n -0.000654 204.1900n -0.000642 204.2000n -0.000630 204.2100n -0.000618 204.2200n -0.000606 204.2300n -0.000594 204.2400n -0.000581 204.2500n -0.000569 204.2600n -0.000556 204.2700n -0.000543 204.2800n -0.000531 204.2900n -0.000518
+ 204.3000n -0.000505 204.3100n -0.000492 204.3200n -0.000479 204.3300n -0.000465 204.3400n -0.000452 204.3500n -0.000439 204.3600n -0.000425 204.3700n -0.000412 204.3800n -0.000398 204.3900n -0.000385 204.4000n -0.000371 204.4100n -0.000357 204.4200n -0.000344 204.4300n -0.000330 204.4400n -0.000316
+ 204.4500n -0.000302 204.4600n -0.000288 204.4700n -0.000274 204.4800n -0.000259 204.4900n -0.000245 204.5000n -0.000231 204.5100n -0.000217 204.5200n -0.000202 204.5300n -0.000188 204.5400n -0.000174 204.5500n -0.000159 204.5600n -0.000145 204.5700n -0.000130 204.5800n -0.000115 204.5900n -0.000101
+ 204.6000n -0.000086 204.6100n -0.000072 204.6200n -0.000057 204.6300n -0.000042 204.6400n -0.000027 204.6500n -0.000013 204.6600n 0.000002 204.6700n 0.000017 204.6800n 0.000032 204.6900n 0.000046 204.7000n 0.000061 204.7100n 0.000076 204.7200n 0.000091 204.7300n 0.000106 204.7400n 0.000120
+ 204.7500n 0.000135 204.7600n 0.000150 204.7700n 0.000165 204.7800n 0.000179 204.7900n 0.000194 204.8000n 0.000209 204.8100n 0.000224 204.8200n 0.000238 204.8300n 0.000253 204.8400n 0.000267 204.8500n 0.000282 204.8600n 0.000297 204.8700n 0.000311 204.8800n 0.000325 204.8900n 0.000340
+ 204.9000n 0.000354 204.9100n 0.000369 204.9200n 0.000383 204.9300n 0.000397 204.9400n 0.000411 204.9500n 0.000425 204.9600n 0.000439 204.9700n 0.000453 204.9800n 0.000467 204.9900n 0.000481 205.0000n 0.000495 205.0100n 0.000508 205.0200n 0.000522 205.0300n 0.000535 205.0400n 0.000549
+ 205.0500n 0.000562 205.0600n 0.000575 205.0700n 0.000588 205.0800n 0.000601 205.0900n 0.000614 205.1000n 0.000627 205.1100n 0.000640 205.1200n 0.000652 205.1300n 0.000665 205.1400n 0.000677 205.1500n 0.000689 205.1600n 0.000701 205.1700n 0.000713 205.1800n 0.000725 205.1900n 0.000737
+ 205.2000n 0.000749 205.2100n 0.000760 205.2200n 0.000771 205.2300n 0.000783 205.2400n 0.000794 205.2500n 0.000805 205.2600n 0.000815 205.2700n 0.000826 205.2800n 0.000836 205.2900n 0.000847 205.3000n 0.000857 205.3100n 0.000867 205.3200n 0.000877 205.3300n 0.000886 205.3400n 0.000896
+ 205.3500n 0.000905 205.3600n 0.000914 205.3700n 0.000923 205.3800n 0.000932 205.3900n 0.000941 205.4000n 0.000949 205.4100n 0.000958 205.4200n 0.000966 205.4300n 0.000974 205.4400n 0.000982 205.4500n 0.000989 205.4600n 0.000996 205.4700n 0.001004 205.4800n 0.001011 205.4900n 0.001018
+ 205.5000n 0.001024 205.5100n 0.001031 205.5200n 0.001037 205.5300n 0.001043 205.5400n 0.001049 205.5500n 0.001054 205.5600n 0.001060 205.5700n 0.001065 205.5800n 0.001070 205.5900n 0.001075 205.6000n 0.001080 205.6100n 0.001084 205.6200n 0.001088 205.6300n 0.001092 205.6400n 0.001096
+ 205.6500n 0.001100 205.6600n 0.001103 205.6700n 0.001106 205.6800n 0.001109 205.6900n 0.001112 205.7000n 0.001115 205.7100n 0.001117 205.7200n 0.001119 205.7300n 0.001121 205.7400n 0.001123 205.7500n 0.001125 205.7600n 0.001126 205.7700n 0.001127 205.7800n 0.001128 205.7900n 0.001129
+ 205.8000n 0.001130 205.8100n 0.001130 205.8200n 0.001130 205.8300n 0.001130 205.8400n 0.001130 205.8500n 0.001129 205.8600n 0.001129 205.8700n 0.001128 205.8800n 0.001127 205.8900n 0.001126 205.9000n 0.001124 205.9100n 0.001123 205.9200n 0.001121 205.9300n 0.001119 205.9400n 0.001117
+ 205.9500n 0.001115 205.9600n 0.001112 205.9700n 0.001109 205.9800n 0.001107 205.9900n 0.001104 206.0000n 0.001100 206.0100n 0.001097 206.0200n 0.001094 206.0300n 0.001090 206.0400n 0.001086 206.0500n 0.001082 206.0600n 0.001078 206.0700n 0.001074 206.0800n 0.001069 206.0900n 0.001064
+ 206.1000n 0.001060 206.1100n 0.001055 206.1200n 0.001050 206.1300n 0.001045 206.1400n 0.001039 206.1500n 0.001034 206.1600n 0.001028 206.1700n 0.001023 206.1800n 0.001017 206.1900n 0.001011 206.2000n 0.001005 206.2100n 0.000999 206.2200n 0.000993 206.2300n 0.000986 206.2400n 0.000980
+ 206.2500n 0.000973 206.2600n 0.000967 206.2700n 0.000960 206.2800n 0.000953 206.2900n 0.000946 206.3000n 0.000939 206.3100n 0.000932 206.3200n 0.000925 206.3300n 0.000918 206.3400n 0.000911 206.3500n 0.000903 206.3600n 0.000896 206.3700n 0.000889 206.3800n 0.000881 206.3900n 0.000874
+ 206.4000n 0.000866 206.4100n 0.000859 206.4200n 0.000851 206.4300n 0.000844 206.4400n 0.000836 206.4500n 0.000829 206.4600n 0.000821 206.4700n 0.000813 206.4800n 0.000806 206.4900n 0.000798 206.5000n 0.000790 206.5100n 0.000783 206.5200n 0.000775 206.5300n 0.000768 206.5400n 0.000760
+ 206.5500n 0.000753 206.5600n 0.000745 206.5700n 0.000738 206.5800n 0.000730 206.5900n 0.000723 206.6000n 0.000716 206.6100n 0.000709 206.6200n 0.000701 206.6300n 0.000694 206.6400n 0.000687 206.6500n 0.000680 206.6600n 0.000673 206.6700n 0.000667 206.6800n 0.000660 206.6900n 0.000653
+ 206.7000n 0.000647 206.7100n 0.000640 206.7200n 0.000634 206.7300n 0.000628 206.7400n 0.000621 206.7500n 0.000615 206.7600n 0.000609 206.7700n 0.000604 206.7800n 0.000598 206.7900n 0.000592 206.8000n 0.000587 206.8100n 0.000582 206.8200n 0.000577 206.8300n 0.000572 206.8400n 0.000567
+ 206.8500n 0.000562 206.8600n 0.000557 206.8700n 0.000553 206.8800n 0.000549 206.8900n 0.000545 206.9000n 0.000541 206.9100n 0.000537 206.9200n 0.000533 206.9300n 0.000530 206.9400n 0.000527 206.9500n 0.000524 206.9600n 0.000521 206.9700n 0.000518 206.9800n 0.000515 206.9900n 0.000513
+ 207.0000n 0.000511 207.0100n 0.000509 207.0200n 0.000507 207.0300n 0.000505 207.0400n 0.000504 207.0500n 0.000503 207.0600n 0.000502 207.0700n 0.000501 207.0800n 0.000500 207.0900n 0.000500 207.1000n 0.000499 207.1100n 0.000499 207.1200n 0.000500 207.1300n 0.000500 207.1400n 0.000500
+ 207.1500n 0.000501 207.1600n 0.000502 207.1700n 0.000503 207.1800n 0.000505 207.1900n 0.000506 207.2000n 0.000508 207.2100n 0.000510 207.2200n 0.000512 207.2300n 0.000515 207.2400n 0.000517 207.2500n 0.000520 207.2600n 0.000523 207.2700n 0.000526 207.2800n 0.000529 207.2900n 0.000533
+ 207.3000n 0.000537 207.3100n 0.000541 207.3200n 0.000545 207.3300n 0.000549 207.3400n 0.000554 207.3500n 0.000558 207.3600n 0.000563 207.3700n 0.000568 207.3800n 0.000573 207.3900n 0.000579 207.4000n 0.000584 207.4100n 0.000590 207.4200n 0.000596 207.4300n 0.000602 207.4400n 0.000608
+ 207.4500n 0.000614 207.4600n 0.000621 207.4700n 0.000627 207.4800n 0.000634 207.4900n 0.000641 207.5000n 0.000648 207.5100n 0.000655 207.5200n 0.000663 207.5300n 0.000670 207.5400n 0.000678 207.5500n 0.000685 207.5600n 0.000693 207.5700n 0.000701 207.5800n 0.000709 207.5900n 0.000717
+ 207.6000n 0.000725 207.6100n 0.000733 207.6200n 0.000741 207.6300n 0.000750 207.6400n 0.000758 207.6500n 0.000766 207.6600n 0.000775 207.6700n 0.000783 207.6800n 0.000792 207.6900n 0.000800 207.7000n 0.000809 207.7100n 0.000818 207.7200n 0.000826 207.7300n 0.000835 207.7400n 0.000844
+ 207.7500n 0.000852 207.7600n 0.000861 207.7700n 0.000869 207.7800n 0.000878 207.7900n 0.000887 207.8000n 0.000895 207.8100n 0.000903 207.8200n 0.000912 207.8300n 0.000920 207.8400n 0.000928 207.8500n 0.000937 207.8600n 0.000945 207.8700n 0.000953 207.8800n 0.000960 207.8900n 0.000968
+ 207.9000n 0.000976 207.9100n 0.000983 207.9200n 0.000991 207.9300n 0.000998 207.9400n 0.001005 207.9500n 0.001012 207.9600n 0.001019 207.9700n 0.001025 207.9800n 0.001032 207.9900n 0.001038 208.0000n 0.001044 208.0100n 0.001050 208.0200n 0.001056 208.0300n 0.001061 208.0400n 0.001067
+ 208.0500n 0.001072 208.0600n 0.001076 208.0700n 0.001081 208.0800n 0.001085 208.0900n 0.001089 208.1000n 0.001093 208.1100n 0.001097 208.1200n 0.001100 208.1300n 0.001103 208.1400n 0.001106 208.1500n 0.001108 208.1600n 0.001110 208.1700n 0.001112 208.1800n 0.001113 208.1900n 0.001115
+ 208.2000n 0.001116 208.2100n 0.001116 208.2200n 0.001116 208.2300n 0.001116 208.2400n 0.001116 208.2500n 0.001115 208.2600n 0.001114 208.2700n 0.001112 208.2800n 0.001111 208.2900n 0.001108 208.3000n 0.001106 208.3100n 0.001103 208.3200n 0.001100 208.3300n 0.001096 208.3400n 0.001092
+ 208.3500n 0.001088 208.3600n 0.001083 208.3700n 0.001078 208.3800n 0.001072 208.3900n 0.001066 208.4000n 0.001060 208.4100n 0.001053 208.4200n 0.001046 208.4300n 0.001038 208.4400n 0.001030 208.4500n 0.001022 208.4600n 0.001013 208.4700n 0.001004 208.4800n 0.000995 208.4900n 0.000985
+ 208.5000n 0.000975 208.5100n 0.000964 208.5200n 0.000953 208.5300n 0.000942 208.5400n 0.000930 208.5500n 0.000917 208.5600n 0.000905 208.5700n 0.000892 208.5800n 0.000879 208.5900n 0.000865 208.6000n 0.000851 208.6100n 0.000836 208.6200n 0.000821 208.6300n 0.000806 208.6400n 0.000791
+ 208.6500n 0.000775 208.6600n 0.000758 208.6700n 0.000742 208.6800n 0.000725 208.6900n 0.000708 208.7000n 0.000690 208.7100n 0.000672 208.7200n 0.000654 208.7300n 0.000635 208.7400n 0.000617 208.7500n 0.000598 208.7600n 0.000578 208.7700n 0.000559 208.7800n 0.000539 208.7900n 0.000519
+ 208.8000n 0.000498 208.8100n 0.000478 208.8200n 0.000457 208.8300n 0.000436 208.8400n 0.000414 208.8500n 0.000393 208.8600n 0.000371 208.8700n 0.000349 208.8800n 0.000327 208.8900n 0.000305 208.9000n 0.000283 208.9100n 0.000260 208.9200n 0.000238 208.9300n 0.000215 208.9400n 0.000192
+ 208.9500n 0.000169 208.9600n 0.000146 208.9700n 0.000123 208.9800n 0.000100 208.9900n 0.000077 209.0000n 0.000054 209.0100n 0.000031 209.0200n 0.000008 209.0300n -0.000015 209.0400n -0.000039 209.0500n -0.000062 209.0600n -0.000085 209.0700n -0.000108 209.0800n -0.000130 209.0900n -0.000153
+ 209.1000n -0.000176 209.1100n -0.000198 209.1200n -0.000221 209.1300n -0.000243 209.1400n -0.000265 209.1500n -0.000287 209.1600n -0.000308 209.1700n -0.000330 209.1800n -0.000351 209.1900n -0.000372 209.2000n -0.000393 209.2100n -0.000413 209.2200n -0.000433 209.2300n -0.000453 209.2400n -0.000473
+ 209.2500n -0.000492 209.2600n -0.000511 209.2700n -0.000529 209.2800n -0.000547 209.2900n -0.000565 209.3000n -0.000582 209.3100n -0.000599 209.3200n -0.000616 209.3300n -0.000632 209.3400n -0.000647 209.3500n -0.000662 209.3600n -0.000677 209.3700n -0.000691 209.3800n -0.000704 209.3900n -0.000717
+ 209.4000n -0.000730 209.4100n -0.000742 209.4200n -0.000753 209.4300n -0.000764 209.4400n -0.000774 209.4500n -0.000784 209.4600n -0.000793 209.4700n -0.000801 209.4800n -0.000809 209.4900n -0.000816 209.5000n -0.000823 209.5100n -0.000828 209.5200n -0.000834 209.5300n -0.000838 209.5400n -0.000842
+ 209.5500n -0.000845 209.5600n -0.000847 209.5700n -0.000848 209.5800n -0.000849 209.5900n -0.000849 209.6000n -0.000849 209.6100n -0.000847 209.6200n -0.000845 209.6300n -0.000842 209.6400n -0.000838 209.6500n -0.000834 209.6600n -0.000828 209.6700n -0.000822 209.6800n -0.000815 209.6900n -0.000808
+ 209.7000n -0.000799 209.7100n -0.000790 209.7200n -0.000780 209.7300n -0.000769 209.7400n -0.000757 209.7500n -0.000744 209.7600n -0.000731 209.7700n -0.000716 209.7800n -0.000701 209.7900n -0.000685 209.8000n -0.000669 209.8100n -0.000651 209.8200n -0.000633 209.8300n -0.000613 209.8400n -0.000593
+ 209.8500n -0.000572 209.8600n -0.000551 209.8700n -0.000528 209.8800n -0.000505 209.8900n -0.000481 209.9000n -0.000456 209.9100n -0.000430 209.9200n -0.000403 209.9300n -0.000376 209.9400n -0.000348 209.9500n -0.000319 209.9600n -0.000289 209.9700n -0.000259 209.9800n -0.000228 209.9900n -0.000196
+ 210.0000n -0.000163 210.0100n -0.000130 210.0200n -0.000096 210.0300n -0.000061 210.0400n -0.000025 210.0500n 0.000011 210.0600n 0.000048 210.0700n 0.000085 210.0800n 0.000123 210.0900n 0.000162 210.1000n 0.000202 210.1100n 0.000242 210.1200n 0.000283 210.1300n 0.000324 210.1400n 0.000366
+ 210.1500n 0.000408 210.1600n 0.000451 210.1700n 0.000495 210.1800n 0.000539 210.1900n 0.000583 210.2000n 0.000628 210.2100n 0.000674 210.2200n 0.000720 210.2300n 0.000766 210.2400n 0.000813 210.2500n 0.000860 210.2600n 0.000908 210.2700n 0.000956 210.2800n 0.001004 210.2900n 0.001053
+ 210.3000n 0.001102 210.3100n 0.001151 210.3200n 0.001200 210.3300n 0.001250 210.3400n 0.001300 210.3500n 0.001350 210.3600n 0.001401 210.3700n 0.001452 210.3800n 0.001502 210.3900n 0.001553 210.4000n 0.001604 210.4100n 0.001655 210.4200n 0.001707 210.4300n 0.001758 210.4400n 0.001809
+ 210.4500n 0.001860 210.4600n 0.001912 210.4700n 0.001963 210.4800n 0.002014 210.4900n 0.002065 210.5000n 0.002117 210.5100n 0.002168 210.5200n 0.002218 210.5300n 0.002269 210.5400n 0.002320 210.5500n 0.002370 210.5600n 0.002420 210.5700n 0.002470 210.5800n 0.002520 210.5900n 0.002569
+ 210.6000n 0.002618 210.6100n 0.002667 210.6200n 0.002716 210.6300n 0.002764 210.6400n 0.002812 210.6500n 0.002859 210.6600n 0.002906 210.6700n 0.002953 210.6800n 0.002999 210.6900n 0.003044 210.7000n 0.003090 210.7100n 0.003134 210.7200n 0.003179 210.7300n 0.003222 210.7400n 0.003265
+ 210.7500n 0.003308 210.7600n 0.003350 210.7700n 0.003391 210.7800n 0.003432 210.7900n 0.003472 210.8000n 0.003512 210.8100n 0.003551 210.8200n 0.003589 210.8300n 0.003627 210.8400n 0.003663 210.8500n 0.003700 210.8600n 0.003735 210.8700n 0.003770 210.8800n 0.003804 210.8900n 0.003837
+ 210.9000n 0.003869 210.9100n 0.003901 210.9200n 0.003932 210.9300n 0.003962 210.9400n 0.003991 210.9500n 0.004019 210.9600n 0.004047 210.9700n 0.004073 210.9800n 0.004099 210.9900n 0.004124 211.0000n 0.004148 211.0100n 0.004172 211.0200n 0.004194 211.0300n 0.004215 211.0400n 0.004236
+ 211.0500n 0.004256 211.0600n 0.004275 211.0700n 0.004292 211.0800n 0.004309 211.0900n 0.004325 211.1000n 0.004341 211.1100n 0.004355 211.1200n 0.004368 211.1300n 0.004381 211.1400n 0.004392 211.1500n 0.004403 211.1600n 0.004412 211.1700n 0.004421 211.1800n 0.004429 211.1900n 0.004436
+ 211.2000n 0.004442 211.2100n 0.004447 211.2200n 0.004451 211.2300n 0.004454 211.2400n 0.004456 211.2500n 0.004458 211.2600n 0.004458 211.2700n 0.004458 211.2800n 0.004456 211.2900n 0.004454 211.3000n 0.004451 211.3100n 0.004447 211.3200n 0.004442 211.3300n 0.004437 211.3400n 0.004430
+ 211.3500n 0.004423 211.3600n 0.004415 211.3700n 0.004405 211.3800n 0.004396 211.3900n 0.004385 211.4000n 0.004373 211.4100n 0.004361 211.4200n 0.004348 211.4300n 0.004334 211.4400n 0.004319 211.4500n 0.004304 211.4600n 0.004288 211.4700n 0.004271 211.4800n 0.004253 211.4900n 0.004235
+ 211.5000n 0.004216 211.5100n 0.004196 211.5200n 0.004176 211.5300n 0.004155 211.5400n 0.004133 211.5500n 0.004110 211.5600n 0.004087 211.5700n 0.004064 211.5800n 0.004040 211.5900n 0.004015 211.6000n 0.003989 211.6100n 0.003963 211.6200n 0.003937 211.6300n 0.003910 211.6400n 0.003882
+ 211.6500n 0.003854 211.6600n 0.003826 211.6700n 0.003797 211.6800n 0.003767 211.6900n 0.003737 211.7000n 0.003707 211.7100n 0.003676 211.7200n 0.003645 211.7300n 0.003613 211.7400n 0.003581 211.7500n 0.003549 211.7600n 0.003516 211.7700n 0.003483 211.7800n 0.003450 211.7900n 0.003416
+ 211.8000n 0.003382 211.8100n 0.003348 211.8200n 0.003313 211.8300n 0.003279 211.8400n 0.003244 211.8500n 0.003208 211.8600n 0.003173 211.8700n 0.003137 211.8800n 0.003102 211.8900n 0.003066 211.9000n 0.003029 211.9100n 0.002993 211.9200n 0.002957 211.9300n 0.002920 211.9400n 0.002883
+ 211.9500n 0.002847 211.9600n 0.002810 211.9700n 0.002773 211.9800n 0.002736 211.9900n 0.002699 212.0000n 0.002662 212.0100n 0.002625 212.0200n 0.002587 212.0300n 0.002550 212.0400n 0.002513 212.0500n 0.002476 212.0600n 0.002439 212.0700n 0.002402 212.0800n 0.002365 212.0900n 0.002327
+ 212.1000n 0.002291 212.1100n 0.002254 212.1200n 0.002217 212.1300n 0.002180 212.1400n 0.002143 212.1500n 0.002107 212.1600n 0.002070 212.1700n 0.002034 212.1800n 0.001998 212.1900n 0.001961 212.2000n 0.001925 212.2100n 0.001889 212.2200n 0.001854 212.2300n 0.001818 212.2400n 0.001782
+ 212.2500n 0.001747 212.2600n 0.001712 212.2700n 0.001677 212.2800n 0.001642 212.2900n 0.001607 212.3000n 0.001573 212.3100n 0.001538 212.3200n 0.001504 212.3300n 0.001470 212.3400n 0.001436 212.3500n 0.001403 212.3600n 0.001369 212.3700n 0.001336 212.3800n 0.001303 212.3900n 0.001270
+ 212.4000n 0.001237 212.4100n 0.001204 212.4200n 0.001172 212.4300n 0.001140 212.4400n 0.001108 212.4500n 0.001076 212.4600n 0.001044 212.4700n 0.001013 212.4800n 0.000981 212.4900n 0.000950 212.5000n 0.000919 212.5100n 0.000888 212.5200n 0.000858 212.5300n 0.000827 212.5400n 0.000797
+ 212.5500n 0.000767 212.5600n 0.000737 212.5700n 0.000707 212.5800n 0.000677 212.5900n 0.000648 212.6000n 0.000619 212.6100n 0.000589 212.6200n 0.000560 212.6300n 0.000532 212.6400n 0.000503 212.6500n 0.000474 212.6600n 0.000446 212.6700n 0.000417 212.6800n 0.000389 212.6900n 0.000361
+ 212.7000n 0.000333 212.7100n 0.000305 212.7200n 0.000278 212.7300n 0.000250 212.7400n 0.000222 212.7500n 0.000195 212.7600n 0.000168 212.7700n 0.000141 212.7800n 0.000113 212.7900n 0.000086 212.8000n 0.000059 212.8100n 0.000033 212.8200n 0.000006 212.8300n -0.000021 212.8400n -0.000048
+ 212.8500n -0.000074 212.8600n -0.000101 212.8700n -0.000127 212.8800n -0.000153 212.8900n -0.000180 212.9000n -0.000206 212.9100n -0.000232 212.9200n -0.000258 212.9300n -0.000284 212.9400n -0.000311 212.9500n -0.000337 212.9600n -0.000363 212.9700n -0.000389 212.9800n -0.000414 212.9900n -0.000440
+ 213.0000n -0.000466 213.0100n -0.000492 213.0200n -0.000518 213.0300n -0.000543 213.0400n -0.000569 213.0500n -0.000595 213.0600n -0.000620 213.0700n -0.000646 213.0800n -0.000672 213.0900n -0.000697 213.1000n -0.000723 213.1100n -0.000748 213.1200n -0.000774 213.1300n -0.000799 213.1400n -0.000824
+ 213.1500n -0.000850 213.1600n -0.000875 213.1700n -0.000900 213.1800n -0.000926 213.1900n -0.000951 213.2000n -0.000976 213.2100n -0.001001 213.2200n -0.001026 213.2300n -0.001051 213.2400n -0.001076 213.2500n -0.001101 213.2600n -0.001126 213.2700n -0.001150 213.2800n -0.001175 213.2900n -0.001200
+ 213.3000n -0.001224 213.3100n -0.001249 213.3200n -0.001273 213.3300n -0.001297 213.3400n -0.001321 213.3500n -0.001346 213.3600n -0.001369 213.3700n -0.001393 213.3800n -0.001417 213.3900n -0.001441 213.4000n -0.001464 213.4100n -0.001487 213.4200n -0.001511 213.4300n -0.001534 213.4400n -0.001556
+ 213.4500n -0.001579 213.4600n -0.001602 213.4700n -0.001624 213.4800n -0.001646 213.4900n -0.001668 213.5000n -0.001690 213.5100n -0.001712 213.5200n -0.001733 213.5300n -0.001754 213.5400n -0.001775 213.5500n -0.001796 213.5600n -0.001816 213.5700n -0.001837 213.5800n -0.001857 213.5900n -0.001876
+ 213.6000n -0.001896 213.6100n -0.001915 213.6200n -0.001934 213.6300n -0.001953 213.6400n -0.001971 213.6500n -0.001989 213.6600n -0.002007 213.6700n -0.002024 213.6800n -0.002041 213.6900n -0.002058 213.7000n -0.002074 213.7100n -0.002090 213.7200n -0.002106 213.7300n -0.002121 213.7400n -0.002136
+ 213.7500n -0.002151 213.7600n -0.002165 213.7700n -0.002179 213.7800n -0.002193 213.7900n -0.002206 213.8000n -0.002218 213.8100n -0.002231 213.8200n -0.002242 213.8300n -0.002254 213.8400n -0.002265 213.8500n -0.002275 213.8600n -0.002286 213.8700n -0.002295 213.8800n -0.002305 213.8900n -0.002313
+ 213.9000n -0.002322 213.9100n -0.002330 213.9200n -0.002337 213.9300n -0.002344 213.9400n -0.002351 213.9500n -0.002357 213.9600n -0.002362 213.9700n -0.002367 213.9800n -0.002372 213.9900n -0.002376 214.0000n -0.002380 214.0100n -0.002383 214.0200n -0.002385 214.0300n -0.002388 214.0400n -0.002389
+ 214.0500n -0.002391 214.0600n -0.002391 214.0700n -0.002392 214.0800n -0.002391 214.0900n -0.002391 214.1000n -0.002389 214.1100n -0.002388 214.1200n -0.002385 214.1300n -0.002383 214.1400n -0.002380 214.1500n -0.002376 214.1600n -0.002372 214.1700n -0.002367 214.1800n -0.002362 214.1900n -0.002357
+ 214.2000n -0.002351 214.2100n -0.002344 214.2200n -0.002338 214.2300n -0.002330 214.2400n -0.002322 214.2500n -0.002314 214.2600n -0.002306 214.2700n -0.002297 214.2800n -0.002287 214.2900n -0.002277 214.3000n -0.002267 214.3100n -0.002256 214.3200n -0.002245 214.3300n -0.002234 214.3400n -0.002222
+ 214.3500n -0.002209 214.3600n -0.002197 214.3700n -0.002184 214.3800n -0.002170 214.3900n -0.002157 214.4000n -0.002143 214.4100n -0.002128 214.4200n -0.002114 214.4300n -0.002099 214.4400n -0.002084 214.4500n -0.002068 214.4600n -0.002052 214.4700n -0.002036 214.4800n -0.002020 214.4900n -0.002003
+ 214.5000n -0.001986 214.5100n -0.001969 214.5200n -0.001952 214.5300n -0.001935 214.5400n -0.001917 214.5500n -0.001899 214.5600n -0.001881 214.5700n -0.001863 214.5800n -0.001845 214.5900n -0.001826 214.6000n -0.001808 214.6100n -0.001789 214.6200n -0.001770 214.6300n -0.001751 214.6400n -0.001733
+ 214.6500n -0.001714 214.6600n -0.001694 214.6700n -0.001675 214.6800n -0.001656 214.6900n -0.001637 214.7000n -0.001618 214.7100n -0.001599 214.7200n -0.001580 214.7300n -0.001560 214.7400n -0.001541 214.7500n -0.001522 214.7600n -0.001503 214.7700n -0.001484 214.7800n -0.001466 214.7900n -0.001447
+ 214.8000n -0.001428 214.8100n -0.001410 214.8200n -0.001391 214.8300n -0.001373 214.8400n -0.001355 214.8500n -0.001337 214.8600n -0.001319 214.8700n -0.001302 214.8800n -0.001284 214.8900n -0.001267 214.9000n -0.001250 214.9100n -0.001233 214.9200n -0.001216 214.9300n -0.001200 214.9400n -0.001184
+ 214.9500n -0.001168 214.9600n -0.001152 214.9700n -0.001137 214.9800n -0.001122 214.9900n -0.001107 215.0000n -0.001092 215.0100n -0.001078 215.0200n -0.001064 215.0300n -0.001050 215.0400n -0.001036 215.0500n -0.001023 215.0600n -0.001011 215.0700n -0.000998 215.0800n -0.000986 215.0900n -0.000974
+ 215.1000n -0.000962 215.1100n -0.000951 215.1200n -0.000940 215.1300n -0.000930 215.1400n -0.000920 215.1500n -0.000910 215.1600n -0.000900 215.1700n -0.000891 215.1800n -0.000882 215.1900n -0.000874 215.2000n -0.000865 215.2100n -0.000858 215.2200n -0.000850 215.2300n -0.000843 215.2400n -0.000836
+ 215.2500n -0.000830 215.2600n -0.000824 215.2700n -0.000818 215.2800n -0.000812 215.2900n -0.000807 215.3000n -0.000803 215.3100n -0.000798 215.3200n -0.000794 215.3300n -0.000790 215.3400n -0.000787 215.3500n -0.000783 215.3600n -0.000781 215.3700n -0.000778 215.3800n -0.000776 215.3900n -0.000774
+ 215.4000n -0.000772 215.4100n -0.000770 215.4200n -0.000769 215.4300n -0.000768 215.4400n -0.000768 215.4500n -0.000767 215.4600n -0.000767 215.4700n -0.000767 215.4800n -0.000767 215.4900n -0.000768 215.5000n -0.000768 215.5100n -0.000769 215.5200n -0.000770 215.5300n -0.000772 215.5400n -0.000773
+ 215.5500n -0.000775 215.5600n -0.000776 215.5700n -0.000778 215.5800n -0.000780 215.5900n -0.000782 215.6000n -0.000785 215.6100n -0.000787 215.6200n -0.000789 215.6300n -0.000792 215.6400n -0.000795 215.6500n -0.000797 215.6600n -0.000800 215.6700n -0.000803 215.6800n -0.000805 215.6900n -0.000808
+ 215.7000n -0.000811 215.7100n -0.000814 215.7200n -0.000817 215.7300n -0.000819 215.7400n -0.000822 215.7500n -0.000825 215.7600n -0.000827 215.7700n -0.000830 215.7800n -0.000832 215.7900n -0.000835 215.8000n -0.000837 215.8100n -0.000839 215.8200n -0.000841 215.8300n -0.000843 215.8400n -0.000845
+ 215.8500n -0.000847 215.8600n -0.000848 215.8700n -0.000849 215.8800n -0.000850 215.8900n -0.000851 215.9000n -0.000852 215.9100n -0.000853 215.9200n -0.000853 215.9300n -0.000853 215.9400n -0.000853 215.9500n -0.000852 215.9600n -0.000852 215.9700n -0.000851 215.9800n -0.000850 215.9900n -0.000848
+ 216.0000n -0.000846 216.0100n -0.000844 216.0200n -0.000842 216.0300n -0.000839 216.0400n -0.000837 216.0500n -0.000833 216.0600n -0.000830 216.0700n -0.000826 216.0800n -0.000822 216.0900n -0.000817 216.1000n -0.000812 216.1100n -0.000807 216.1200n -0.000802 216.1300n -0.000796 216.1400n -0.000789
+ 216.1500n -0.000783 216.1600n -0.000776 216.1700n -0.000769 216.1800n -0.000761 216.1900n -0.000753 216.2000n -0.000745 216.2100n -0.000736 216.2200n -0.000727 216.2300n -0.000717 216.2400n -0.000708 216.2500n -0.000697 216.2600n -0.000687 216.2700n -0.000676 216.2800n -0.000665 216.2900n -0.000653
+ 216.3000n -0.000641 216.3100n -0.000629 216.3200n -0.000617 216.3300n -0.000604 216.3400n -0.000590 216.3500n -0.000577 216.3600n -0.000563 216.3700n -0.000549 216.3800n -0.000534 216.3900n -0.000519 216.4000n -0.000504 216.4100n -0.000489 216.4200n -0.000473 216.4300n -0.000457 216.4400n -0.000441
+ 216.4500n -0.000424 216.4600n -0.000407 216.4700n -0.000390 216.4800n -0.000373 216.4900n -0.000355 216.5000n -0.000338 216.5100n -0.000320 216.5200n -0.000301 216.5300n -0.000283 216.5400n -0.000264 216.5500n -0.000246 216.5600n -0.000227 216.5700n -0.000208 216.5800n -0.000189 216.5900n -0.000169
+ 216.6000n -0.000150 216.6100n -0.000130 216.6200n -0.000110 216.6300n -0.000091 216.6400n -0.000071 216.6500n -0.000051 216.6600n -0.000031 216.6700n -0.000011 216.6800n 0.000009 216.6900n 0.000029 216.7000n 0.000049 216.7100n 0.000069 216.7200n 0.000089 216.7300n 0.000109 216.7400n 0.000129
+ 216.7500n 0.000149 216.7600n 0.000169 216.7700n 0.000188 216.7800n 0.000208 216.7900n 0.000227 216.8000n 0.000247 216.8100n 0.000266 216.8200n 0.000285 216.8300n 0.000304 216.8400n 0.000323 216.8500n 0.000341 216.8600n 0.000360 216.8700n 0.000378 216.8800n 0.000396 216.8900n 0.000414
+ 216.9000n 0.000431 216.9100n 0.000448 216.9200n 0.000465 216.9300n 0.000482 216.9400n 0.000498 216.9500n 0.000514 216.9600n 0.000530 216.9700n 0.000545 216.9800n 0.000561 216.9900n 0.000575 217.0000n 0.000590 217.0100n 0.000604 217.0200n 0.000617 217.0300n 0.000631 217.0400n 0.000643
+ 217.0500n 0.000656 217.0600n 0.000668 217.0700n 0.000680 217.0800n 0.000691 217.0900n 0.000702 217.1000n 0.000712 217.1100n 0.000722 217.1200n 0.000732 217.1300n 0.000741 217.1400n 0.000749 217.1500n 0.000757 217.1600n 0.000765 217.1700n 0.000772 217.1800n 0.000779 217.1900n 0.000785
+ 217.2000n 0.000790 217.2100n 0.000796 217.2200n 0.000800 217.2300n 0.000804 217.2400n 0.000808 217.2500n 0.000811 217.2600n 0.000814 217.2700n 0.000816 217.2800n 0.000818 217.2900n 0.000819 217.3000n 0.000819 217.3100n 0.000819 217.3200n 0.000819 217.3300n 0.000818 217.3400n 0.000817
+ 217.3500n 0.000815 217.3600n 0.000812 217.3700n 0.000809 217.3800n 0.000806 217.3900n 0.000802 217.4000n 0.000798 217.4100n 0.000793 217.4200n 0.000787 217.4300n 0.000781 217.4400n 0.000775 217.4500n 0.000768 217.4600n 0.000761 217.4700n 0.000753 217.4800n 0.000745 217.4900n 0.000737
+ 217.5000n 0.000728 217.5100n 0.000718 217.5200n 0.000708 217.5300n 0.000698 217.5400n 0.000687 217.5500n 0.000676 217.5600n 0.000665 217.5700n 0.000653 217.5800n 0.000640 217.5900n 0.000628 217.6000n 0.000615 217.6100n 0.000602 217.6200n 0.000588 217.6300n 0.000574 217.6400n 0.000560
+ 217.6500n 0.000545 217.6600n 0.000530 217.6700n 0.000515 217.6800n 0.000500 217.6900n 0.000484 217.7000n 0.000469 217.7100n 0.000453 217.7200n 0.000436 217.7300n 0.000420 217.7400n 0.000403 217.7500n 0.000386 217.7600n 0.000369 217.7700n 0.000352 217.7800n 0.000335 217.7900n 0.000317
+ 217.8000n 0.000300 217.8100n 0.000282 217.8200n 0.000265 217.8300n 0.000247 217.8400n 0.000229 217.8500n 0.000211 217.8600n 0.000193 217.8700n 0.000175 217.8800n 0.000157 217.8900n 0.000139 217.9000n 0.000121 217.9100n 0.000103 217.9200n 0.000085 217.9300n 0.000068 217.9400n 0.000050
+ 217.9500n 0.000032 217.9600n 0.000015 217.9700n -0.000003 217.9800n -0.000020 217.9900n -0.000037 218.0000n -0.000054 218.0100n -0.000071 218.0200n -0.000088 218.0300n -0.000105 218.0400n -0.000121 218.0500n -0.000137 218.0600n -0.000153 218.0700n -0.000169 218.0800n -0.000184 218.0900n -0.000200
+ 218.1000n -0.000215 218.1100n -0.000230 218.1200n -0.000244 218.1300n -0.000258 218.1400n -0.000272 218.1500n -0.000286 218.1600n -0.000299 218.1700n -0.000312 218.1800n -0.000325 218.1900n -0.000337 218.2000n -0.000350 218.2100n -0.000361 218.2200n -0.000373 218.2300n -0.000384 218.2400n -0.000394
+ 218.2500n -0.000405 218.2600n -0.000415 218.2700n -0.000424 218.2800n -0.000434 218.2900n -0.000442 218.3000n -0.000451 218.3100n -0.000459 218.3200n -0.000467 218.3300n -0.000474 218.3400n -0.000481 218.3500n -0.000487 218.3600n -0.000493 218.3700n -0.000499 218.3800n -0.000504 218.3900n -0.000509
+ 218.4000n -0.000514 218.4100n -0.000518 218.4200n -0.000522 218.4300n -0.000525 218.4400n -0.000528 218.4500n -0.000531 218.4600n -0.000533 218.4700n -0.000534 218.4800n -0.000536 218.4900n -0.000537 218.5000n -0.000537 218.5100n -0.000538 218.5200n -0.000537 218.5300n -0.000537 218.5400n -0.000536
+ 218.5500n -0.000535 218.5600n -0.000533 218.5700n -0.000531 218.5800n -0.000529 218.5900n -0.000526 218.6000n -0.000523 218.6100n -0.000520 218.6200n -0.000517 218.6300n -0.000513 218.6400n -0.000509 218.6500n -0.000504 218.6600n -0.000499 218.6700n -0.000494 218.6800n -0.000489 218.6900n -0.000483
+ 218.7000n -0.000477 218.7100n -0.000471 218.7200n -0.000465 218.7300n -0.000458 218.7400n -0.000452 218.7500n -0.000445 218.7600n -0.000438 218.7700n -0.000430 218.7800n -0.000423 218.7900n -0.000415 218.8000n -0.000407 218.8100n -0.000399 218.8200n -0.000391 218.8300n -0.000383 218.8400n -0.000374
+ 218.8500n -0.000366 218.8600n -0.000357 218.8700n -0.000348 218.8800n -0.000340 218.8900n -0.000331 218.9000n -0.000322 218.9100n -0.000313 218.9200n -0.000304 218.9300n -0.000295 218.9400n -0.000286 218.9500n -0.000277 218.9600n -0.000268 218.9700n -0.000259 218.9800n -0.000250 218.9900n -0.000241
+ 219.0000n -0.000232 219.0100n -0.000223 219.0200n -0.000214 219.0300n -0.000206 219.0400n -0.000197 219.0500n -0.000189 219.0600n -0.000180 219.0700n -0.000172 219.0800n -0.000164 219.0900n -0.000156 219.1000n -0.000148 219.1100n -0.000140 219.1200n -0.000132 219.1300n -0.000125 219.1400n -0.000117
+ 219.1500n -0.000110 219.1600n -0.000103 219.1700n -0.000097 219.1800n -0.000090 219.1900n -0.000084 219.2000n -0.000077 219.2100n -0.000071 219.2200n -0.000066 219.2300n -0.000060 219.2400n -0.000055 219.2500n -0.000050 219.2600n -0.000045 219.2700n -0.000040 219.2800n -0.000036 219.2900n -0.000032
+ 219.3000n -0.000028 219.3100n -0.000024 219.3200n -0.000021 219.3300n -0.000018 219.3400n -0.000015 219.3500n -0.000013 219.3600n -0.000010 219.3700n -0.000008 219.3800n -0.000006 219.3900n -0.000005 219.4000n -0.000003 219.4100n -0.000002 219.4200n -0.000002 219.4300n -0.000001 219.4400n -0.000001
+ 219.4500n -0.000001 219.4600n -0.000001 219.4700n -0.000002 219.4800n -0.000002 219.4900n -0.000003 219.5000n -0.000005 219.5100n -0.000006 219.5200n -0.000008 219.5300n -0.000010 219.5400n -0.000012 219.5500n -0.000014 219.5600n -0.000017 219.5700n -0.000020 219.5800n -0.000023 219.5900n -0.000026
+ 219.6000n -0.000029 219.6100n -0.000033 219.6200n -0.000036 219.6300n -0.000040 219.6400n -0.000044 219.6500n -0.000049 219.6600n -0.000053 219.6700n -0.000058 219.6800n -0.000062 219.6900n -0.000067 219.7000n -0.000072 219.7100n -0.000077 219.7200n -0.000082 219.7300n -0.000087 219.7400n -0.000093
+ 219.7500n -0.000098 219.7600n -0.000103 219.7700n -0.000109 219.7800n -0.000114 219.7900n -0.000120 219.8000n -0.000125 219.8100n -0.000131 219.8200n -0.000137 219.8300n -0.000142 219.8400n -0.000148 219.8500n -0.000153 219.8600n -0.000159 219.8700n -0.000165 219.8800n -0.000170 219.8900n -0.000175
+ 219.9000n -0.000181 219.9100n -0.000186 219.9200n -0.000191 219.9300n -0.000196 219.9400n -0.000201 219.9500n -0.000206 219.9600n -0.000211 219.9700n -0.000215 219.9800n -0.000220 219.9900n -0.000224 220.0000n -0.000228 220.0100n -0.000232 220.0200n -0.000236 220.0300n -0.000239 220.0400n -0.000243
+ 220.0500n -0.000246 220.0600n -0.000249 220.0700n -0.000251 220.0800n -0.000254 220.0900n -0.000256 220.1000n -0.000258 220.1100n -0.000260 220.1200n -0.000261 220.1300n -0.000263 220.1400n -0.000263 220.1500n -0.000264 220.1600n -0.000264 220.1700n -0.000265 220.1800n -0.000264 220.1900n -0.000264
+ 220.2000n -0.000263 220.2100n -0.000262 220.2200n -0.000261 220.2300n -0.000259 220.2400n -0.000257 220.2500n -0.000254 220.2600n -0.000252 220.2700n -0.000249 220.2800n -0.000245 220.2900n -0.000242 220.3000n -0.000238 220.3100n -0.000233 220.3200n -0.000229 220.3300n -0.000223 220.3400n -0.000218
+ 220.3500n -0.000212 220.3600n -0.000206 220.3700n -0.000200 220.3800n -0.000193 220.3900n -0.000186 220.4000n -0.000179 220.4100n -0.000171 220.4200n -0.000163 220.4300n -0.000155 220.4400n -0.000147 220.4500n -0.000138 220.4600n -0.000128 220.4700n -0.000119 220.4800n -0.000109 220.4900n -0.000099
+ 220.5000n -0.000089 220.5100n -0.000078 220.5200n -0.000067 220.5300n -0.000056 220.5400n -0.000044 220.5500n -0.000033 220.5600n -0.000021 220.5700n -0.000009 220.5800n 0.000004 220.5900n 0.000016 220.6000n 0.000029 220.6100n 0.000042 220.6200n 0.000055 220.6300n 0.000069 220.6400n 0.000082
+ 220.6500n 0.000096 220.6600n 0.000109 220.6700n 0.000123 220.6800n 0.000137 220.6900n 0.000152 220.7000n 0.000166 220.7100n 0.000180 220.7200n 0.000195 220.7300n 0.000209 220.7400n 0.000224 220.7500n 0.000238 220.7600n 0.000253 220.7700n 0.000267 220.7800n 0.000282 220.7900n 0.000296
+ 220.8000n 0.000311 220.8100n 0.000325 220.8200n 0.000340 220.8300n 0.000354 220.8400n 0.000368 220.8500n 0.000383 220.8600n 0.000397 220.8700n 0.000410 220.8800n 0.000424 220.8900n 0.000438 220.9000n 0.000451 220.9100n 0.000464 220.9200n 0.000478 220.9300n 0.000490 220.9400n 0.000503
+ 220.9500n 0.000515 220.9600n 0.000527 220.9700n 0.000539 220.9800n 0.000551 220.9900n 0.000562 221.0000n 0.000573 221.0100n 0.000583 221.0200n 0.000594 221.0300n 0.000604 221.0400n 0.000613 221.0500n 0.000622 221.0600n 0.000631 221.0700n 0.000639 221.0800n 0.000647 221.0900n 0.000655
+ 221.1000n 0.000662 221.1100n 0.000668 221.1200n 0.000675 221.1300n 0.000680 221.1400n 0.000685 221.1500n 0.000690 221.1600n 0.000694 221.1700n 0.000698 221.1800n 0.000701 221.1900n 0.000704 221.2000n 0.000706 221.2100n 0.000707 221.2200n 0.000708 221.2300n 0.000709 221.2400n 0.000708
+ 221.2500n 0.000708 221.2600n 0.000706 221.2700n 0.000704 221.2800n 0.000702 221.2900n 0.000698 221.3000n 0.000695 221.3100n 0.000690 221.3200n 0.000685 221.3300n 0.000680 221.3400n 0.000673 221.3500n 0.000666 221.3600n 0.000659 221.3700n 0.000651 221.3800n 0.000642 221.3900n 0.000632
+ 221.4000n 0.000622 221.4100n 0.000611 221.4200n 0.000600 221.4300n 0.000588 221.4400n 0.000575 221.4500n 0.000562 221.4600n 0.000548 221.4700n 0.000533 221.4800n 0.000518 221.4900n 0.000502 221.5000n 0.000486 221.5100n 0.000469 221.5200n 0.000451 221.5300n 0.000433 221.5400n 0.000414
+ 221.5500n 0.000395 221.5600n 0.000375 221.5700n 0.000354 221.5800n 0.000333 221.5900n 0.000311 221.6000n 0.000289 221.6100n 0.000266 221.6200n 0.000242 221.6300n 0.000218 221.6400n 0.000194 221.6500n 0.000169 221.6600n 0.000144 221.6700n 0.000118 221.6800n 0.000091 221.6900n 0.000064
+ 221.7000n 0.000037 221.7100n 0.000009 221.7200n -0.000019 221.7300n -0.000047 221.7400n -0.000076 221.7500n -0.000106 221.7600n -0.000135 221.7700n -0.000165 221.7800n -0.000196 221.7900n -0.000226 221.8000n -0.000257 221.8100n -0.000289 221.8200n -0.000320 221.8300n -0.000352 221.8400n -0.000384
+ 221.8500n -0.000416 221.8600n -0.000448 221.8700n -0.000481 221.8800n -0.000514 221.8900n -0.000546 221.9000n -0.000579 221.9100n -0.000612 221.9200n -0.000645 221.9300n -0.000679 221.9400n -0.000712 221.9500n -0.000745 221.9600n -0.000778 221.9700n -0.000812 221.9800n -0.000845 221.9900n -0.000878
+ 222.0000n -0.000911 222.0100n -0.000944 222.0200n -0.000977 222.0300n -0.001010 222.0400n -0.001043 222.0500n -0.001075 222.0600n -0.001107 222.0700n -0.001139 222.0800n -0.001171 222.0900n -0.001203 222.1000n -0.001234 222.1100n -0.001265 222.1200n -0.001296 222.1300n -0.001326 222.1400n -0.001356
+ 222.1500n -0.001386 222.1600n -0.001415 222.1700n -0.001444 222.1800n -0.001472 222.1900n -0.001500 222.2000n -0.001528 222.2100n -0.001555 222.2200n -0.001582 222.2300n -0.001608 222.2400n -0.001633 222.2500n -0.001658 222.2600n -0.001683 222.2700n -0.001707 222.2800n -0.001730 222.2900n -0.001753
+ 222.3000n -0.001775 222.3100n -0.001797 222.3200n -0.001818 222.3300n -0.001838 222.3400n -0.001857 222.3500n -0.001876 222.3600n -0.001895 222.3700n -0.001912 222.3800n -0.001929 222.3900n -0.001945 222.4000n -0.001960 222.4100n -0.001975 222.4200n -0.001989 222.4300n -0.002002 222.4400n -0.002014
+ 222.4500n -0.002026 222.4600n -0.002036 222.4700n -0.002046 222.4800n -0.002055 222.4900n -0.002064 222.5000n -0.002071 222.5100n -0.002078 222.5200n -0.002084 222.5300n -0.002089 222.5400n -0.002093 222.5500n -0.002097 222.5600n -0.002099 222.5700n -0.002101 222.5800n -0.002102 222.5900n -0.002102
+ 222.6000n -0.002101 222.6100n -0.002100 222.6200n -0.002097 222.6300n -0.002094 222.6400n -0.002090 222.6500n -0.002085 222.6600n -0.002079 222.6700n -0.002072 222.6800n -0.002065 222.6900n -0.002057 222.7000n -0.002048 222.7100n -0.002038 222.7200n -0.002027 222.7300n -0.002016 222.7400n -0.002004
+ 222.7500n -0.001991 222.7600n -0.001977 222.7700n -0.001962 222.7800n -0.001947 222.7900n -0.001931 222.8000n -0.001914 222.8100n -0.001897 222.8200n -0.001879 222.8300n -0.001860 222.8400n -0.001840 222.8500n -0.001820 222.8600n -0.001799 222.8700n -0.001777 222.8800n -0.001755 222.8900n -0.001733
+ 222.9000n -0.001709 222.9100n -0.001685 222.9200n -0.001661 222.9300n -0.001635 222.9400n -0.001610 222.9500n -0.001584 222.9600n -0.001557 222.9700n -0.001530 222.9800n -0.001502 222.9900n -0.001474 223.0000n -0.001445 223.0100n -0.001416 223.0200n -0.001387 223.0300n -0.001357 223.0400n -0.001327
+ 223.0500n -0.001296 223.0600n -0.001265 223.0700n -0.001234 223.0800n -0.001203 223.0900n -0.001171 223.1000n -0.001139 223.1100n -0.001107 223.1200n -0.001074 223.1300n -0.001042 223.1400n -0.001009 223.1500n -0.000976 223.1600n -0.000943 223.1700n -0.000910 223.1800n -0.000877 223.1900n -0.000843
+ 223.2000n -0.000810 223.2100n -0.000776 223.2200n -0.000743 223.2300n -0.000710 223.2400n -0.000676 223.2500n -0.000643 223.2600n -0.000610 223.2700n -0.000577 223.2800n -0.000544 223.2900n -0.000511 223.3000n -0.000478 223.3100n -0.000446 223.3200n -0.000413 223.3300n -0.000381 223.3400n -0.000349
+ 223.3500n -0.000318 223.3600n -0.000286 223.3700n -0.000255 223.3800n -0.000224 223.3900n -0.000194 223.4000n -0.000164 223.4100n -0.000134 223.4200n -0.000105 223.4300n -0.000076 223.4400n -0.000047 223.4500n -0.000019 223.4600n 0.000008 223.4700n 0.000036 223.4800n 0.000062 223.4900n 0.000088
+ 223.5000n 0.000114 223.5100n 0.000139 223.5200n 0.000164 223.5300n 0.000188 223.5400n 0.000211 223.5500n 0.000234 223.5600n 0.000256 223.5700n 0.000278 223.5800n 0.000299 223.5900n 0.000320 223.6000n 0.000339 223.6100n 0.000358 223.6200n 0.000377 223.6300n 0.000395 223.6400n 0.000412
+ 223.6500n 0.000428 223.6600n 0.000444 223.6700n 0.000459 223.6800n 0.000473 223.6900n 0.000487 223.7000n 0.000500 223.7100n 0.000512 223.7200n 0.000523 223.7300n 0.000534 223.7400n 0.000544 223.7500n 0.000553 223.7600n 0.000561 223.7700n 0.000569 223.7800n 0.000575 223.7900n 0.000582
+ 223.8000n 0.000587 223.8100n 0.000591 223.8200n 0.000595 223.8300n 0.000598 223.8400n 0.000600 223.8500n 0.000602 223.8600n 0.000602 223.8700n 0.000602 223.8800n 0.000601 223.8900n 0.000600 223.9000n 0.000598 223.9100n 0.000594 223.9200n 0.000591 223.9300n 0.000586 223.9400n 0.000581
+ 223.9500n 0.000574 223.9600n 0.000568 223.9700n 0.000560 223.9800n 0.000552 223.9900n 0.000543 224.0000n 0.000533 224.0100n 0.000523 224.0200n 0.000512 224.0300n 0.000500 224.0400n 0.000488 224.0500n 0.000475 224.0600n 0.000461 224.0700n 0.000447 224.0800n 0.000432 224.0900n 0.000416
+ 224.1000n 0.000400 224.1100n 0.000384 224.1200n 0.000366 224.1300n 0.000348 224.1400n 0.000330 224.1500n 0.000311 224.1600n 0.000292 224.1700n 0.000272 224.1800n 0.000251 224.1900n 0.000230 224.2000n 0.000209 224.2100n 0.000187 224.2200n 0.000165 224.2300n 0.000142 224.2400n 0.000119
+ 224.2500n 0.000095 224.2600n 0.000071 224.2700n 0.000047 224.2800n 0.000022 224.2900n -0.000003 224.3000n -0.000028 224.3100n -0.000053 224.3200n -0.000079 224.3300n -0.000105 224.3400n -0.000132 224.3500n -0.000158 224.3600n -0.000185 224.3700n -0.000212 224.3800n -0.000239 224.3900n -0.000267
+ 224.4000n -0.000294 224.4100n -0.000322 224.4200n -0.000349 224.4300n -0.000377 224.4400n -0.000405 224.4500n -0.000433 224.4600n -0.000461 224.4700n -0.000489 224.4800n -0.000517 224.4900n -0.000545 224.5000n -0.000573 224.5100n -0.000600 224.5200n -0.000628 224.5300n -0.000656 224.5400n -0.000684
+ 224.5500n -0.000711 224.5600n -0.000738 224.5700n -0.000766 224.5800n -0.000793 224.5900n -0.000820 224.6000n -0.000846 224.6100n -0.000873 224.6200n -0.000899 224.6300n -0.000925 224.6400n -0.000951 224.6500n -0.000976 224.6600n -0.001002 224.6700n -0.001027 224.6800n -0.001051 224.6900n -0.001075
+ 224.7000n -0.001099 224.7100n -0.001123 224.7200n -0.001146 224.7300n -0.001169 224.7400n -0.001191 224.7500n -0.001213 224.7600n -0.001235 224.7700n -0.001256 224.7800n -0.001277 224.7900n -0.001297 224.8000n -0.001317 224.8100n -0.001336 224.8200n -0.001355 224.8300n -0.001374 224.8400n -0.001392
+ 224.8500n -0.001409 224.8600n -0.001426 224.8700n -0.001442 224.8800n -0.001458 224.8900n -0.001473 224.9000n -0.001488 224.9100n -0.001502 224.9200n -0.001515 224.9300n -0.001528 224.9400n -0.001541 224.9500n -0.001553 224.9600n -0.001564 224.9700n -0.001575 224.9800n -0.001585 224.9900n -0.001594
+ 225.0000n -0.001603 225.0100n -0.001611 225.0200n -0.001619 225.0300n -0.001626 225.0400n -0.001632 225.0500n -0.001638 225.0600n -0.001643 225.0700n -0.001647 225.0800n -0.001651 225.0900n -0.001654 225.1000n -0.001657 225.1100n -0.001659 225.1200n -0.001660 225.1300n -0.001661 225.1400n -0.001661
+ 225.1500n -0.001660 225.1600n -0.001659 225.1700n -0.001657 225.1800n -0.001654 225.1900n -0.001651 225.2000n -0.001647 225.2100n -0.001643 225.2200n -0.001638 225.2300n -0.001633 225.2400n -0.001626 225.2500n -0.001620 225.2600n -0.001612 225.2700n -0.001604 225.2800n -0.001595 225.2900n -0.001586
+ 225.3000n -0.001577 225.3100n -0.001566 225.3200n -0.001555 225.3300n -0.001544 225.3400n -0.001532 225.3500n -0.001519 225.3600n -0.001506 225.3700n -0.001492 225.3800n -0.001478 225.3900n -0.001463 225.4000n -0.001448 225.4100n -0.001432 225.4200n -0.001416 225.4300n -0.001399 225.4400n -0.001382
+ 225.4500n -0.001364 225.4600n -0.001346 225.4700n -0.001327 225.4800n -0.001308 225.4900n -0.001288 225.5000n -0.001268 225.5100n -0.001248 225.5200n -0.001227 225.5300n -0.001206 225.5400n -0.001184 225.5500n -0.001162 225.5600n -0.001139 225.5700n -0.001117 225.5800n -0.001093 225.5900n -0.001070
+ 225.6000n -0.001046 225.6100n -0.001022 225.6200n -0.000997 225.6300n -0.000972 225.6400n -0.000947 225.6500n -0.000922 225.6600n -0.000896 225.6700n -0.000870 225.6800n -0.000844 225.6900n -0.000817 225.7000n -0.000790 225.7100n -0.000763 225.7200n -0.000736 225.7300n -0.000708 225.7400n -0.000681
+ 225.7500n -0.000653 225.7600n -0.000625 225.7700n -0.000597 225.7800n -0.000568 225.7900n -0.000540 225.8000n -0.000511 225.8100n -0.000482 225.8200n -0.000453 225.8300n -0.000424 225.8400n -0.000395 225.8500n -0.000366 225.8600n -0.000336 225.8700n -0.000307 225.8800n -0.000277 225.8900n -0.000248
+ 225.9000n -0.000218 225.9100n -0.000188 225.9200n -0.000159 225.9300n -0.000129 225.9400n -0.000099 225.9500n -0.000069 225.9600n -0.000040 225.9700n -0.000010 225.9800n 0.000020 225.9900n 0.000050 226.0000n 0.000079 226.0100n 0.000109 226.0200n 0.000139 226.0300n 0.000168 226.0400n 0.000198
+ 226.0500n 0.000227 226.0600n 0.000257 226.0700n 0.000286 226.0800n 0.000315 226.0900n 0.000344 226.1000n 0.000373 226.1100n 0.000402 226.1200n 0.000431 226.1300n 0.000459 226.1400n 0.000488 226.1500n 0.000516 226.1600n 0.000545 226.1700n 0.000573 226.1800n 0.000601 226.1900n 0.000629
+ 226.2000n 0.000656 226.2100n 0.000684 226.2200n 0.000711 226.2300n 0.000738 226.2400n 0.000765 226.2500n 0.000792 226.2600n 0.000819 226.2700n 0.000845 226.2800n 0.000872 226.2900n 0.000898 226.3000n 0.000923 226.3100n 0.000949 226.3200n 0.000975 226.3300n 0.001000 226.3400n 0.001025
+ 226.3500n 0.001050 226.3600n 0.001074 226.3700n 0.001099 226.3800n 0.001123 226.3900n 0.001147 226.4000n 0.001170 226.4100n 0.001194 226.4200n 0.001217 226.4300n 0.001240 226.4400n 0.001263 226.4500n 0.001285 226.4600n 0.001307 226.4700n 0.001330 226.4800n 0.001351 226.4900n 0.001373
+ 226.5000n 0.001394 226.5100n 0.001415 226.5200n 0.001436 226.5300n 0.001456 226.5400n 0.001477 226.5500n 0.001497 226.5600n 0.001516 226.5700n 0.001536 226.5800n 0.001555 226.5900n 0.001574 226.6000n 0.001593 226.6100n 0.001611 226.6200n 0.001629 226.6300n 0.001647 226.6400n 0.001665
+ 226.6500n 0.001682 226.6600n 0.001700 226.6700n 0.001717 226.6800n 0.001733 226.6900n 0.001750 226.7000n 0.001766 226.7100n 0.001781 226.7200n 0.001797 226.7300n 0.001812 226.7400n 0.001827 226.7500n 0.001842 226.7600n 0.001857 226.7700n 0.001871 226.7800n 0.001885 226.7900n 0.001899
+ 226.8000n 0.001912 226.8100n 0.001925 226.8200n 0.001938 226.8300n 0.001951 226.8400n 0.001964 226.8500n 0.001976 226.8600n 0.001988 226.8700n 0.001999 226.8800n 0.002011 226.8900n 0.002022 226.9000n 0.002033 226.9100n 0.002043 226.9200n 0.002053 226.9300n 0.002064 226.9400n 0.002073
+ 226.9500n 0.002083 226.9600n 0.002092 226.9700n 0.002101 226.9800n 0.002110 226.9900n 0.002119 227.0000n 0.002127 227.0100n 0.002135 227.0200n 0.002142 227.0300n 0.002150 227.0400n 0.002157 227.0500n 0.002164 227.0600n 0.002171 227.0700n 0.002177 227.0800n 0.002183 227.0900n 0.002189
+ 227.1000n 0.002195 227.1100n 0.002200 227.1200n 0.002205 227.1300n 0.002210 227.1400n 0.002215 227.1500n 0.002219 227.1600n 0.002223 227.1700n 0.002227 227.1800n 0.002230 227.1900n 0.002234 227.2000n 0.002237 227.2100n 0.002240 227.2200n 0.002242 227.2300n 0.002244 227.2400n 0.002246
+ 227.2500n 0.002248 227.2600n 0.002249 227.2700n 0.002250 227.2800n 0.002251 227.2900n 0.002252 227.3000n 0.002252 227.3100n 0.002252 227.3200n 0.002252 227.3300n 0.002252 227.3400n 0.002251 227.3500n 0.002250 227.3600n 0.002248 227.3700n 0.002247 227.3800n 0.002245 227.3900n 0.002243
+ 227.4000n 0.002240 227.4100n 0.002238 227.4200n 0.002235 227.4300n 0.002232 227.4400n 0.002228 227.4500n 0.002224 227.4600n 0.002220 227.4700n 0.002216 227.4800n 0.002211 227.4900n 0.002206 227.5000n 0.002201 227.5100n 0.002196 227.5200n 0.002190 227.5300n 0.002184 227.5400n 0.002177
+ 227.5500n 0.002171 227.5600n 0.002164 227.5700n 0.002157 227.5800n 0.002149 227.5900n 0.002141 227.6000n 0.002133 227.6100n 0.002125 227.6200n 0.002116 227.6300n 0.002107 227.6400n 0.002098 227.6500n 0.002088 227.6600n 0.002079 227.6700n 0.002069 227.6800n 0.002058 227.6900n 0.002047
+ 227.7000n 0.002036 227.7100n 0.002025 227.7200n 0.002014 227.7300n 0.002002 227.7400n 0.001990 227.7500n 0.001977 227.7600n 0.001964 227.7700n 0.001951 227.7800n 0.001938 227.7900n 0.001924 227.8000n 0.001911 227.8100n 0.001896 227.8200n 0.001882 227.8300n 0.001867 227.8400n 0.001852
+ 227.8500n 0.001837 227.8600n 0.001821 227.8700n 0.001805 227.8800n 0.001789 227.8900n 0.001773 227.9000n 0.001756 227.9100n 0.001739 227.9200n 0.001721 227.9300n 0.001704 227.9400n 0.001686 227.9500n 0.001668 227.9600n 0.001649 227.9700n 0.001631 227.9800n 0.001612 227.9900n 0.001593
+ 228.0000n 0.001573 228.0100n 0.001553 228.0200n 0.001533 228.0300n 0.001513 228.0400n 0.001493 228.0500n 0.001472 228.0600n 0.001451 228.0700n 0.001429 228.0800n 0.001408 228.0900n 0.001386 228.1000n 0.001364 228.1100n 0.001342 228.1200n 0.001319 228.1300n 0.001297 228.1400n 0.001274
+ 228.1500n 0.001250 228.1600n 0.001227 228.1700n 0.001203 228.1800n 0.001179 228.1900n 0.001155 228.2000n 0.001131 228.2100n 0.001107 228.2200n 0.001082 228.2300n 0.001057 228.2400n 0.001032 228.2500n 0.001007 228.2600n 0.000981 228.2700n 0.000956 228.2800n 0.000930 228.2900n 0.000904
+ 228.3000n 0.000878 228.3100n 0.000851 228.3200n 0.000825 228.3300n 0.000798 228.3400n 0.000771 228.3500n 0.000744 228.3600n 0.000717 228.3700n 0.000690 228.3800n 0.000663 228.3900n 0.000635 228.4000n 0.000607 228.4100n 0.000580 228.4200n 0.000552 228.4300n 0.000524 228.4400n 0.000496
+ 228.4500n 0.000468 228.4600n 0.000439 228.4700n 0.000411 228.4800n 0.000383 228.4900n 0.000354 228.5000n 0.000326 228.5100n 0.000297 228.5200n 0.000268 228.5300n 0.000240 228.5400n 0.000211 228.5500n 0.000182 228.5600n 0.000153 228.5700n 0.000124 228.5800n 0.000095 228.5900n 0.000067
+ 228.6000n 0.000038 228.6100n 0.000009 228.6200n -0.000020 228.6300n -0.000049 228.6400n -0.000078 228.6500n -0.000107 228.6600n -0.000136 228.6700n -0.000165 228.6800n -0.000193 228.6900n -0.000222 228.7000n -0.000251 228.7100n -0.000280 228.7200n -0.000308 228.7300n -0.000337 228.7400n -0.000365
+ 228.7500n -0.000393 228.7600n -0.000422 228.7700n -0.000450 228.7800n -0.000478 228.7900n -0.000506 228.8000n -0.000534 228.8100n -0.000562 228.8200n -0.000589 228.8300n -0.000617 228.8400n -0.000644 228.8500n -0.000671 228.8600n -0.000698 228.8700n -0.000725 228.8800n -0.000752 228.8900n -0.000779
+ 228.9000n -0.000805 228.9100n -0.000831 228.9200n -0.000857 228.9300n -0.000883 228.9400n -0.000909 228.9500n -0.000934 228.9600n -0.000960 228.9700n -0.000985 228.9800n -0.001010 228.9900n -0.001034 229.0000n -0.001059 229.0100n -0.001083 229.0200n -0.001107 229.0300n -0.001131 229.0400n -0.001154
+ 229.0500n -0.001177 229.0600n -0.001200 229.0700n -0.001223 229.0800n -0.001245 229.0900n -0.001268 229.1000n -0.001290 229.1100n -0.001311 229.1200n -0.001333 229.1300n -0.001354 229.1400n -0.001374 229.1500n -0.001395 229.1600n -0.001415 229.1700n -0.001435 229.1800n -0.001454 229.1900n -0.001474
+ 229.2000n -0.001493 229.2100n -0.001511 229.2200n -0.001530 229.2300n -0.001548 229.2400n -0.001565 229.2500n -0.001583 229.2600n -0.001600 229.2700n -0.001616 229.2800n -0.001633 229.2900n -0.001649 229.3000n -0.001664 229.3100n -0.001680 229.3200n -0.001695 229.3300n -0.001709 229.3400n -0.001724
+ 229.3500n -0.001737 229.3600n -0.001751 229.3700n -0.001764 229.3800n -0.001777 229.3900n -0.001790 229.4000n -0.001802 229.4100n -0.001813 229.4200n -0.001825 229.4300n -0.001836 229.4400n -0.001847 229.4500n -0.001857 229.4600n -0.001867 229.4700n -0.001876 229.4800n -0.001886 229.4900n -0.001894
+ 229.5000n -0.001903 229.5100n -0.001911 229.5200n -0.001919 229.5300n -0.001926 229.5400n -0.001933 229.5500n -0.001940 229.5600n -0.001946 229.5700n -0.001952 229.5800n -0.001957 229.5900n -0.001962 229.6000n -0.001967 229.6100n -0.001971 229.6200n -0.001975 229.6300n -0.001979 229.6400n -0.001982
+ 229.6500n -0.001985 229.6600n -0.001988 229.6700n -0.001990 229.6800n -0.001992 229.6900n -0.001994 229.7000n -0.001995 229.7100n -0.001996 229.7200n -0.001996 229.7300n -0.001996 229.7400n -0.001996 229.7500n -0.001995 229.7600n -0.001994 229.7700n -0.001993 229.7800n -0.001992 229.7900n -0.001990
+ 229.8000n -0.001987 229.8100n -0.001985 229.8200n -0.001982 229.8300n -0.001979 229.8400n -0.001975 229.8500n -0.001971 229.8600n -0.001967 229.8700n -0.001963 229.8800n -0.001958 229.8900n -0.001953 229.9000n -0.001947 229.9100n -0.001942 229.9200n -0.001936 229.9300n -0.001929 229.9400n -0.001923
+ 229.9500n -0.001916 229.9600n -0.001909 229.9700n -0.001902 229.9800n -0.001894 229.9900n -0.001886 230.0000n -0.001878 230.0100n -0.001869 230.0200n -0.001861 230.0300n -0.001852 230.0400n -0.001842 230.0500n -0.001833 230.0600n -0.001823 230.0700n -0.001813 230.0800n -0.001803 230.0900n -0.001793
+ 230.1000n -0.001782 230.1100n -0.001771 230.1200n -0.001760 230.1300n -0.001749 230.1400n -0.001737 230.1500n -0.001726 230.1600n -0.001714 230.1700n -0.001702 230.1800n -0.001689 230.1900n -0.001677 230.2000n -0.001664 230.2100n -0.001651 230.2200n -0.001638 230.2300n -0.001625 230.2400n -0.001612
+ 230.2500n -0.001598 230.2600n -0.001584 230.2700n -0.001570 230.2800n -0.001556 230.2900n -0.001542 230.3000n -0.001528 230.3100n -0.001513 230.3200n -0.001499 230.3300n -0.001484 230.3400n -0.001469 230.3500n -0.001454 230.3600n -0.001439 230.3700n -0.001424 230.3800n -0.001408 230.3900n -0.001393
+ 230.4000n -0.001377 230.4100n -0.001362 230.4200n -0.001346 230.4300n -0.001330 230.4400n -0.001314 230.4500n -0.001298 230.4600n -0.001281 230.4700n -0.001265 230.4800n -0.001248 230.4900n -0.001232 230.5000n -0.001215 230.5100n -0.001199 230.5200n -0.001182 230.5300n -0.001165 230.5400n -0.001148
+ 230.5500n -0.001131 230.5600n -0.001114 230.5700n -0.001097 230.5800n -0.001080 230.5900n -0.001062 230.6000n -0.001045 230.6100n -0.001028 230.6200n -0.001010 230.6300n -0.000993 230.6400n -0.000975 230.6500n -0.000957 230.6600n -0.000940 230.6700n -0.000922 230.6800n -0.000904 230.6900n -0.000886
+ 230.7000n -0.000868 230.7100n -0.000850 230.7200n -0.000832 230.7300n -0.000814 230.7400n -0.000796 230.7500n -0.000778 230.7600n -0.000760 230.7700n -0.000742 230.7800n -0.000723 230.7900n -0.000705 230.8000n -0.000687 230.8100n -0.000668 230.8200n -0.000650 230.8300n -0.000631 230.8400n -0.000613
+ 230.8500n -0.000594 230.8600n -0.000576 230.8700n -0.000557 230.8800n -0.000538 230.8900n -0.000520 230.9000n -0.000501 230.9100n -0.000482 230.9200n -0.000463 230.9300n -0.000444 230.9400n -0.000425 230.9500n -0.000406 230.9600n -0.000387 230.9700n -0.000368 230.9800n -0.000349 230.9900n -0.000330
+ 231.0000n -0.000311 231.0100n -0.000292 231.0200n -0.000273 231.0300n -0.000253 231.0400n -0.000234 231.0500n -0.000215 231.0600n -0.000195 231.0700n -0.000176 231.0800n -0.000156 231.0900n -0.000137 231.1000n -0.000117 231.1100n -0.000098 231.1200n -0.000078 231.1300n -0.000058 231.1400n -0.000038
+ 231.1500n -0.000019 231.1600n 0.000001 231.1700n 0.000021 231.1800n 0.000041 231.1900n 0.000061 231.2000n 0.000081 231.2100n 0.000101 231.2200n 0.000121 231.2300n 0.000142 231.2400n 0.000162 231.2500n 0.000182 231.2600n 0.000202 231.2700n 0.000223 231.2800n 0.000243 231.2900n 0.000263
+ 231.3000n 0.000284 231.3100n 0.000304 231.3200n 0.000325 231.3300n 0.000346 231.3400n 0.000366 231.3500n 0.000387 231.3600n 0.000408 231.3700n 0.000428 231.3800n 0.000449 231.3900n 0.000470 231.4000n 0.000491 231.4100n 0.000512 231.4200n 0.000532 231.4300n 0.000553 231.4400n 0.000574
+ 231.4500n 0.000595 231.4600n 0.000616 231.4700n 0.000637 231.4800n 0.000658 231.4900n 0.000679 231.5000n 0.000700 231.5100n 0.000722 231.5200n 0.000743 231.5300n 0.000764 231.5400n 0.000785 231.5500n 0.000806 231.5600n 0.000827 231.5700n 0.000848 231.5800n 0.000869 231.5900n 0.000890
+ 231.6000n 0.000911 231.6100n 0.000932 231.6200n 0.000953 231.6300n 0.000974 231.6400n 0.000995 231.6500n 0.001016 231.6600n 0.001036 231.6700n 0.001057 231.6800n 0.001078 231.6900n 0.001098 231.7000n 0.001119 231.7100n 0.001139 231.7200n 0.001160 231.7300n 0.001180 231.7400n 0.001200
+ 231.7500n 0.001221 231.7600n 0.001241 231.7700n 0.001261 231.7800n 0.001280 231.7900n 0.001300 231.8000n 0.001320 231.8100n 0.001339 231.8200n 0.001359 231.8300n 0.001378 231.8400n 0.001397 231.8500n 0.001416 231.8600n 0.001435 231.8700n 0.001453 231.8800n 0.001472 231.8900n 0.001490
+ 231.9000n 0.001508 231.9100n 0.001526 231.9200n 0.001543 231.9300n 0.001561 231.9400n 0.001578 231.9500n 0.001595 231.9600n 0.001612 231.9700n 0.001628 231.9800n 0.001645 231.9900n 0.001661 232.0000n 0.001676 232.0100n 0.001692 232.0200n 0.001707 232.0300n 0.001722 232.0400n 0.001737
+ 232.0500n 0.001751 232.0600n 0.001765 232.0700n 0.001779 232.0800n 0.001792 232.0900n 0.001805 232.1000n 0.001818 232.1100n 0.001830 232.1200n 0.001842 232.1300n 0.001854 232.1400n 0.001865 232.1500n 0.001876 232.1600n 0.001886 232.1700n 0.001896 232.1800n 0.001906 232.1900n 0.001915
+ 232.2000n 0.001924 232.2100n 0.001932 232.2200n 0.001940 232.2300n 0.001948 232.2400n 0.001955 232.2500n 0.001961 232.2600n 0.001968 232.2700n 0.001973 232.2800n 0.001978 232.2900n 0.001983 232.3000n 0.001987 232.3100n 0.001991 232.3200n 0.001994 232.3300n 0.001997 232.3400n 0.001999
+ 232.3500n 0.002001 232.3600n 0.002002 232.3700n 0.002003 232.3800n 0.002003 232.3900n 0.002002 232.4000n 0.002001 232.4100n 0.002000 232.4200n 0.001998 232.4300n 0.001995 232.4400n 0.001992 232.4500n 0.001988 232.4600n 0.001983 232.4700n 0.001978 232.4800n 0.001973 232.4900n 0.001966
+ 232.5000n 0.001960 232.5100n 0.001952 232.5200n 0.001944 232.5300n 0.001936 232.5400n 0.001927 232.5500n 0.001917 232.5600n 0.001907 232.5700n 0.001896 232.5800n 0.001884 232.5900n 0.001872 232.6000n 0.001859 232.6100n 0.001846 232.6200n 0.001832 232.6300n 0.001817 232.6400n 0.001802
+ 232.6500n 0.001786 232.6600n 0.001770 232.6700n 0.001753 232.6800n 0.001735 232.6900n 0.001717 232.7000n 0.001698 232.7100n 0.001678 232.7200n 0.001658 232.7300n 0.001638 232.7400n 0.001617 232.7500n 0.001595 232.7600n 0.001573 232.7700n 0.001550 232.7800n 0.001526 232.7900n 0.001502
+ 232.8000n 0.001477 232.8100n 0.001452 232.8200n 0.001427 232.8300n 0.001400 232.8400n 0.001374 232.8500n 0.001346 232.8600n 0.001319 232.8700n 0.001290 232.8800n 0.001261 232.8900n 0.001232 232.9000n 0.001202 232.9100n 0.001172 232.9200n 0.001141 232.9300n 0.001110 232.9400n 0.001079
+ 232.9500n 0.001047 232.9600n 0.001014 232.9700n 0.000981 232.9800n 0.000948 232.9900n 0.000914 233.0000n 0.000880 233.0100n 0.000846 233.0200n 0.000811 233.0300n 0.000776 233.0400n 0.000740 233.0500n 0.000704 233.0600n 0.000668 233.0700n 0.000632 233.0800n 0.000595 233.0900n 0.000558
+ 233.1000n 0.000521 233.1100n 0.000483 233.1200n 0.000445 233.1300n 0.000407 233.1400n 0.000369 233.1500n 0.000331 233.1600n 0.000292 233.1700n 0.000254 233.1800n 0.000215 233.1900n 0.000176 233.2000n 0.000137 233.2100n 0.000098 233.2200n 0.000059 233.2300n 0.000019 233.2400n -0.000020
+ 233.2500n -0.000059 233.2600n -0.000099 233.2700n -0.000138 233.2800n -0.000178 233.2900n -0.000217 233.3000n -0.000256 233.3100n -0.000295 233.3200n -0.000335 233.3300n -0.000374 233.3400n -0.000413 233.3500n -0.000451 233.3600n -0.000490 233.3700n -0.000529 233.3800n -0.000567 233.3900n -0.000605
+ 233.4000n -0.000643 233.4100n -0.000681 233.4200n -0.000718 233.4300n -0.000755 233.4400n -0.000792 233.4500n -0.000829 233.4600n -0.000865 233.4700n -0.000901 233.4800n -0.000937 233.4900n -0.000972 233.5000n -0.001007 233.5100n -0.001042 233.5200n -0.001076 233.5300n -0.001110 233.5400n -0.001143
+ 233.5500n -0.001176 233.5600n -0.001208 233.5700n -0.001240 233.5800n -0.001272 233.5900n -0.001303 233.6000n -0.001333 233.6100n -0.001363 233.6200n -0.001393 233.6300n -0.001421 233.6400n -0.001450 233.6500n -0.001478 233.6600n -0.001505 233.6700n -0.001531 233.6800n -0.001557 233.6900n -0.001583
+ 233.7000n -0.001607 233.7100n -0.001632 233.7200n -0.001655 233.7300n -0.001678 233.7400n -0.001700 233.7500n -0.001721 233.7600n -0.001742 233.7700n -0.001762 233.7800n -0.001782 233.7900n -0.001800 233.8000n -0.001818 233.8100n -0.001836 233.8200n -0.001852 233.8300n -0.001868 233.8400n -0.001883
+ 233.8500n -0.001897 233.8600n -0.001911 233.8700n -0.001924 233.8800n -0.001936 233.8900n -0.001947 233.9000n -0.001958 233.9100n -0.001968 233.9200n -0.001977 233.9300n -0.001985 233.9400n -0.001993 233.9500n -0.002000 233.9600n -0.002006 233.9700n -0.002011 233.9800n -0.002015 233.9900n -0.002019
+ 234.0000n -0.002022 234.0100n -0.002024 234.0200n -0.002026 234.0300n -0.002027 234.0400n -0.002027 234.0500n -0.002026 234.0600n -0.002024 234.0700n -0.002022 234.0800n -0.002019 234.0900n -0.002015 234.1000n -0.002011 234.1100n -0.002006 234.1200n -0.002000 234.1300n -0.001993 234.1400n -0.001986
+ 234.1500n -0.001978 234.1600n -0.001970 234.1700n -0.001960 234.1800n -0.001950 234.1900n -0.001940 234.2000n -0.001929 234.2100n -0.001917 234.2200n -0.001904 234.2300n -0.001891 234.2400n -0.001877 234.2500n -0.001863 234.2600n -0.001848 234.2700n -0.001833 234.2800n -0.001817 234.2900n -0.001800
+ 234.3000n -0.001783 234.3100n -0.001766 234.3200n -0.001748 234.3300n -0.001729 234.3400n -0.001710 234.3500n -0.001691 234.3600n -0.001671 234.3700n -0.001650 234.3800n -0.001630 234.3900n -0.001609 234.4000n -0.001587 234.4100n -0.001565 234.4200n -0.001543 234.4300n -0.001520 234.4400n -0.001498
+ 234.4500n -0.001474 234.4600n -0.001451 234.4700n -0.001427 234.4800n -0.001403 234.4900n -0.001379 234.5000n -0.001355 234.5100n -0.001330 234.5200n -0.001305 234.5300n -0.001280 234.5400n -0.001255 234.5500n -0.001230 234.5600n -0.001204 234.5700n -0.001179 234.5800n -0.001153 234.5900n -0.001128
+ 234.6000n -0.001102 234.6100n -0.001076 234.6200n -0.001051 234.6300n -0.001025 234.6400n -0.000999 234.6500n -0.000974 234.6600n -0.000948 234.6700n -0.000923 234.6800n -0.000897 234.6900n -0.000872 234.7000n -0.000847 234.7100n -0.000822 234.7200n -0.000797 234.7300n -0.000772 234.7400n -0.000747
+ 234.7500n -0.000723 234.7600n -0.000699 234.7700n -0.000675 234.7800n -0.000651 234.7900n -0.000628 234.8000n -0.000605 234.8100n -0.000582 234.8200n -0.000559 234.8300n -0.000537 234.8400n -0.000515 234.8500n -0.000494 234.8600n -0.000473 234.8700n -0.000452 234.8800n -0.000431 234.8900n -0.000411
+ 234.9000n -0.000391 234.9100n -0.000372 234.9200n -0.000353 234.9300n -0.000335 234.9400n -0.000317 234.9500n -0.000299 234.9600n -0.000282 234.9700n -0.000266 234.9800n -0.000250 234.9900n -0.000234 235.0000n -0.000219 235.0100n -0.000204 235.0200n -0.000190 235.0300n -0.000176 235.0400n -0.000163
+ 235.0500n -0.000150 235.0600n -0.000138 235.0700n -0.000127 235.0800n -0.000116 235.0900n -0.000105 235.1000n -0.000095 235.1100n -0.000086 235.1200n -0.000077 235.1300n -0.000068 235.1400n -0.000060 235.1500n -0.000053 235.1600n -0.000046 235.1700n -0.000040 235.1800n -0.000034 235.1900n -0.000029
+ 235.2000n -0.000025 235.2100n -0.000021 235.2200n -0.000017 235.2300n -0.000014 235.2400n -0.000012 235.2500n -0.000010 235.2600n -0.000008 235.2700n -0.000007 235.2800n -0.000007 235.2900n -0.000007 235.3000n -0.000007 235.3100n -0.000008 235.3200n -0.000010 235.3300n -0.000012 235.3400n -0.000014
+ 235.3500n -0.000017 235.3600n -0.000021 235.3700n -0.000024 235.3800n -0.000029 235.3900n -0.000033 235.4000n -0.000038 235.4100n -0.000044 235.4200n -0.000050 235.4300n -0.000056 235.4400n -0.000062 235.4500n -0.000069 235.4600n -0.000077 235.4700n -0.000084 235.4800n -0.000092 235.4900n -0.000100
+ 235.5000n -0.000109 235.5100n -0.000117 235.5200n -0.000126 235.5300n -0.000136 235.5400n -0.000145 235.5500n -0.000155 235.5600n -0.000165 235.5700n -0.000175 235.5800n -0.000185 235.5900n -0.000195 235.6000n -0.000206 235.6100n -0.000216 235.6200n -0.000227 235.6300n -0.000238 235.6400n -0.000249
+ 235.6500n -0.000260 235.6600n -0.000271 235.6700n -0.000282 235.6800n -0.000293 235.6900n -0.000304 235.7000n -0.000315 235.7100n -0.000326 235.7200n -0.000336 235.7300n -0.000347 235.7400n -0.000358 235.7500n -0.000368 235.7600n -0.000379 235.7700n -0.000389 235.7800n -0.000399 235.7900n -0.000409
+ 235.8000n -0.000419 235.8100n -0.000428 235.8200n -0.000438 235.8300n -0.000447 235.8400n -0.000455 235.8500n -0.000464 235.8600n -0.000472 235.8700n -0.000480 235.8800n -0.000487 235.8900n -0.000495 235.9000n -0.000501 235.9100n -0.000508 235.9200n -0.000514 235.9300n -0.000520 235.9400n -0.000525
+ 235.9500n -0.000530 235.9600n -0.000534 235.9700n -0.000538 235.9800n -0.000541 235.9900n -0.000544 236.0000n -0.000547 236.0100n -0.000549 236.0200n -0.000550 236.0300n -0.000551 236.0400n -0.000552 236.0500n -0.000551 236.0600n -0.000551 236.0700n -0.000549 236.0800n -0.000547 236.0900n -0.000545
+ 236.1000n -0.000542 236.1100n -0.000538 236.1200n -0.000534 236.1300n -0.000529 236.1400n -0.000523 236.1500n -0.000517 236.1600n -0.000510 236.1700n -0.000502 236.1800n -0.000494 236.1900n -0.000485 236.2000n -0.000476 236.2100n -0.000466 236.2200n -0.000455 236.2300n -0.000443 236.2400n -0.000431
+ 236.2500n -0.000418 236.2600n -0.000405 236.2700n -0.000390 236.2800n -0.000376 236.2900n -0.000360 236.3000n -0.000344 236.3100n -0.000327 236.3200n -0.000309 236.3300n -0.000291 236.3400n -0.000272 236.3500n -0.000252 236.3600n -0.000232 236.3700n -0.000211 236.3800n -0.000189 236.3900n -0.000167
+ 236.4000n -0.000144 236.4100n -0.000120 236.4200n -0.000096 236.4300n -0.000071 236.4400n -0.000045 236.4500n -0.000019 236.4600n 0.000008 236.4700n 0.000035 236.4800n 0.000063 236.4900n 0.000091 236.5000n 0.000120 236.5100n 0.000150 236.5200n 0.000180 236.5300n 0.000211 236.5400n 0.000242
+ 236.5500n 0.000274 236.5600n 0.000306 236.5700n 0.000339 236.5800n 0.000372 236.5900n 0.000406 236.6000n 0.000440 236.6100n 0.000475 236.6200n 0.000510 236.6300n 0.000545 236.6400n 0.000581 236.6500n 0.000617 236.6600n 0.000653 236.6700n 0.000690 236.6800n 0.000727 236.6900n 0.000765
+ 236.7000n 0.000803 236.7100n 0.000841 236.7200n 0.000879 236.7300n 0.000917 236.7400n 0.000956 236.7500n 0.000995 236.7600n 0.001034 236.7700n 0.001073 236.7800n 0.001113 236.7900n 0.001152 236.8000n 0.001192 236.8100n 0.001232 236.8200n 0.001271 236.8300n 0.001311 236.8400n 0.001351
+ 236.8500n 0.001391 236.8600n 0.001431 236.8700n 0.001471 236.8800n 0.001510 236.8900n 0.001550 236.9000n 0.001589 236.9100n 0.001629 236.9200n 0.001668 236.9300n 0.001707 236.9400n 0.001746 236.9500n 0.001785 236.9600n 0.001824 236.9700n 0.001862 236.9800n 0.001900 236.9900n 0.001938
+ 237.0000n 0.001976 237.0100n 0.002013 237.0200n 0.002050 237.0300n 0.002086 237.0400n 0.002122 237.0500n 0.002158 237.0600n 0.002193 237.0700n 0.002228 237.0800n 0.002263 237.0900n 0.002297 237.1000n 0.002330 237.1100n 0.002363 237.1200n 0.002396 237.1300n 0.002428 237.1400n 0.002459
+ 237.1500n 0.002490 237.1600n 0.002521 237.1700n 0.002550 237.1800n 0.002579 237.1900n 0.002608 237.2000n 0.002636 237.2100n 0.002663 237.2200n 0.002689 237.2300n 0.002715 237.2400n 0.002740 237.2500n 0.002765 237.2600n 0.002788 237.2700n 0.002811 237.2800n 0.002833 237.2900n 0.002855
+ 237.3000n 0.002876 237.3100n 0.002895 237.3200n 0.002915 237.3300n 0.002933 237.3400n 0.002950 237.3500n 0.002967 237.3600n 0.002983 237.3700n 0.002998 237.3800n 0.003012 237.3900n 0.003025 237.4000n 0.003038 237.4100n 0.003050 237.4200n 0.003060 237.4300n 0.003070 237.4400n 0.003079
+ 237.4500n 0.003087 237.4600n 0.003095 237.4700n 0.003101 237.4800n 0.003106 237.4900n 0.003111 237.5000n 0.003115 237.5100n 0.003117 237.5200n 0.003119 237.5300n 0.003120 237.5400n 0.003121 237.5500n 0.003120 237.5600n 0.003118 237.5700n 0.003116 237.5800n 0.003112 237.5900n 0.003108
+ 237.6000n 0.003103 237.6100n 0.003096 237.6200n 0.003090 237.6300n 0.003082 237.6400n 0.003073 237.6500n 0.003063 237.6600n 0.003053 237.6700n 0.003042 237.6800n 0.003030 237.6900n 0.003017 237.7000n 0.003003 237.7100n 0.002989 237.7200n 0.002973 237.7300n 0.002957 237.7400n 0.002940
+ 237.7500n 0.002923 237.7600n 0.002904 237.7700n 0.002885 237.7800n 0.002865 237.7900n 0.002844 237.8000n 0.002823 237.8100n 0.002801 237.8200n 0.002778 237.8300n 0.002754 237.8400n 0.002730 237.8500n 0.002705 237.8600n 0.002680 237.8700n 0.002654 237.8800n 0.002627 237.8900n 0.002600
+ 237.9000n 0.002572 237.9100n 0.002543 237.9200n 0.002514 237.9300n 0.002485 237.9400n 0.002454 237.9500n 0.002424 237.9600n 0.002393 237.9700n 0.002361 237.9800n 0.002329 237.9900n 0.002297 238.0000n 0.002264 238.0100n 0.002230 238.0200n 0.002197 238.0300n 0.002163 238.0400n 0.002128
+ 238.0500n 0.002093 238.0600n 0.002058 238.0700n 0.002023 238.0800n 0.001987 238.0900n 0.001951 238.1000n 0.001915 238.1100n 0.001879 238.1200n 0.001842 238.1300n 0.001805 238.1400n 0.001768 238.1500n 0.001731 238.1600n 0.001693 238.1700n 0.001656 238.1800n 0.001618 238.1900n 0.001581
+ 238.2000n 0.001543 238.2100n 0.001505 238.2200n 0.001467 238.2300n 0.001430 238.2400n 0.001392 238.2500n 0.001354 238.2600n 0.001316 238.2700n 0.001278 238.2800n 0.001241 238.2900n 0.001203 238.3000n 0.001166 238.3100n 0.001128 238.3200n 0.001091 238.3300n 0.001054 238.3400n 0.001017
+ 238.3500n 0.000980 238.3600n 0.000943 238.3700n 0.000907 238.3800n 0.000871 238.3900n 0.000835 238.4000n 0.000799 238.4100n 0.000764 238.4200n 0.000729 238.4300n 0.000694 238.4400n 0.000659 238.4500n 0.000625 238.4600n 0.000591 238.4700n 0.000558 238.4800n 0.000525 238.4900n 0.000492
+ 238.5000n 0.000459 238.5100n 0.000427 238.5200n 0.000396 238.5300n 0.000364 238.5400n 0.000334 238.5500n 0.000303 238.5600n 0.000273 238.5700n 0.000244 238.5800n 0.000215 238.5900n 0.000186 238.6000n 0.000158 238.6100n 0.000130 238.6200n 0.000103 238.6300n 0.000076 238.6400n 0.000050
+ 238.6500n 0.000024 238.6600n -0.000001 238.6700n -0.000025 238.6800n -0.000050 238.6900n -0.000073 238.7000n -0.000096 238.7100n -0.000119 238.7200n -0.000141 238.7300n -0.000162 238.7400n -0.000183 238.7500n -0.000204 238.7600n -0.000224 238.7700n -0.000243 238.7800n -0.000262 238.7900n -0.000280
+ 238.8000n -0.000298 238.8100n -0.000315 238.8200n -0.000331 238.8300n -0.000347 238.8400n -0.000363 238.8500n -0.000378 238.8600n -0.000392 238.8700n -0.000406 238.8800n -0.000419 238.8900n -0.000432 238.9000n -0.000444 238.9100n -0.000456 238.9200n -0.000467 238.9300n -0.000478 238.9400n -0.000488
+ 238.9500n -0.000497 238.9600n -0.000507 238.9700n -0.000515 238.9800n -0.000523 238.9900n -0.000531 239.0000n -0.000538 239.0100n -0.000544 239.0200n -0.000551 239.0300n -0.000556 239.0400n -0.000562 239.0500n -0.000566 239.0600n -0.000571 239.0700n -0.000574 239.0800n -0.000578 239.0900n -0.000581
+ 239.1000n -0.000583 239.1100n -0.000586 239.1200n -0.000587 239.1300n -0.000589 239.1400n -0.000590 239.1500n -0.000590 239.1600n -0.000590 239.1700n -0.000590 239.1800n -0.000590 239.1900n -0.000589 239.2000n -0.000588 239.2100n -0.000586 239.2200n -0.000585 239.2300n -0.000582 239.2400n -0.000580
+ 239.2500n -0.000577 239.2600n -0.000574 239.2700n -0.000571 239.2800n -0.000568 239.2900n -0.000564 239.3000n -0.000560 239.3100n -0.000556 239.3200n -0.000551 239.3300n -0.000547 239.3400n -0.000542 239.3500n -0.000537 239.3600n -0.000532 239.3700n -0.000527 239.3800n -0.000521 239.3900n -0.000516
+ 239.4000n -0.000510 239.4100n -0.000504 239.4200n -0.000498 239.4300n -0.000492 239.4400n -0.000486 239.4500n -0.000479 239.4600n -0.000473 239.4700n -0.000467 239.4800n -0.000460 239.4900n -0.000454 239.5000n -0.000447 239.5100n -0.000441 239.5200n -0.000434 239.5300n -0.000427 239.5400n -0.000421
+ 239.5500n -0.000414 239.5600n -0.000407 239.5700n -0.000401 239.5800n -0.000394 239.5900n -0.000388 239.6000n -0.000381 239.6100n -0.000375 239.6200n -0.000368 239.6300n -0.000362 239.6400n -0.000356 239.6500n -0.000350 239.6600n -0.000344 239.6700n -0.000338 239.6800n -0.000332 239.6900n -0.000326
+ 239.7000n -0.000320 239.7100n -0.000315 239.7200n -0.000309 239.7300n -0.000304 239.7400n -0.000299 239.7500n -0.000294 239.7600n -0.000289 239.7700n -0.000284 239.7800n -0.000280 239.7900n -0.000275 239.8000n -0.000271 239.8100n -0.000267 239.8200n -0.000263 239.8300n -0.000259 239.8400n -0.000255
+ 239.8500n -0.000252 239.8600n -0.000249 239.8700n -0.000245 239.8800n -0.000243 239.8900n -0.000240 239.9000n -0.000237 239.9100n -0.000235 239.9200n -0.000233 239.9300n -0.000231 239.9400n -0.000229 239.9500n -0.000227 239.9600n -0.000226 239.9700n -0.000225 239.9800n -0.000224 239.9900n -0.000223
+ 240.0000n -0.000222 240.0100n -0.000222 240.0200n -0.000222 240.0300n -0.000222 240.0400n -0.000222 240.0500n -0.000222 240.0600n -0.000223 240.0700n -0.000223 240.0800n -0.000224 240.0900n -0.000225 240.1000n -0.000226 240.1100n -0.000228 240.1200n -0.000230 240.1300n -0.000231 240.1400n -0.000233
+ 240.1500n -0.000235 240.1600n -0.000238 240.1700n -0.000240 240.1800n -0.000243 240.1900n -0.000246 240.2000n -0.000249 240.2100n -0.000252 240.2200n -0.000255 240.2300n -0.000259 240.2400n -0.000262 240.2500n -0.000266 240.2600n -0.000270 240.2700n -0.000274 240.2800n -0.000278 240.2900n -0.000282
+ 240.3000n -0.000287 240.3100n -0.000291 240.3200n -0.000296 240.3300n -0.000301 240.3400n -0.000306 240.3500n -0.000311 240.3600n -0.000316 240.3700n -0.000321 240.3800n -0.000327 240.3900n -0.000332 240.4000n -0.000338 240.4100n -0.000343 240.4200n -0.000349 240.4300n -0.000355 240.4400n -0.000361
+ 240.4500n -0.000367 240.4600n -0.000373 240.4700n -0.000379 240.4800n -0.000385 240.4900n -0.000391 240.5000n -0.000397 240.5100n -0.000404 240.5200n -0.000410 240.5300n -0.000417 240.5400n -0.000423 240.5500n -0.000430 240.5600n -0.000436 240.5700n -0.000443 240.5800n -0.000450 240.5900n -0.000456
+ 240.6000n -0.000463 240.6100n -0.000470 240.6200n -0.000477 240.6300n -0.000484 240.6400n -0.000490 240.6500n -0.000497 240.6600n -0.000504 240.6700n -0.000511 240.6800n -0.000518 240.6900n -0.000525 240.7000n -0.000532 240.7100n -0.000539 240.7200n -0.000546 240.7300n -0.000553 240.7400n -0.000559
+ 240.7500n -0.000566 240.7600n -0.000573 240.7700n -0.000580 240.7800n -0.000587 240.7900n -0.000594 240.8000n -0.000601 240.8100n -0.000608 240.8200n -0.000615 240.8300n -0.000622 240.8400n -0.000629 240.8500n -0.000636 240.8600n -0.000643 240.8700n -0.000650 240.8800n -0.000657 240.8900n -0.000664
+ 240.9000n -0.000670 240.9100n -0.000677 240.9200n -0.000684 240.9300n -0.000691 240.9400n -0.000698 240.9500n -0.000705 240.9600n -0.000712 240.9700n -0.000719 240.9800n -0.000726 240.9900n -0.000733 241.0000n -0.000740 241.0100n -0.000746 241.0200n -0.000753 241.0300n -0.000760 241.0400n -0.000767
+ 241.0500n -0.000774 241.0600n -0.000781 241.0700n -0.000788 241.0800n -0.000795 241.0900n -0.000802 241.1000n -0.000809 241.1100n -0.000816 241.1200n -0.000823 241.1300n -0.000830 241.1400n -0.000837 241.1500n -0.000845 241.1600n -0.000852 241.1700n -0.000859 241.1800n -0.000866 241.1900n -0.000873
+ 241.2000n -0.000881 241.2100n -0.000888 241.2200n -0.000895 241.2300n -0.000903 241.2400n -0.000910 241.2500n -0.000918 241.2600n -0.000925 241.2700n -0.000933 241.2800n -0.000941 241.2900n -0.000948 241.3000n -0.000956 241.3100n -0.000964 241.3200n -0.000972 241.3300n -0.000980 241.3400n -0.000987
+ 241.3500n -0.000995 241.3600n -0.001004 241.3700n -0.001012 241.3800n -0.001020 241.3900n -0.001028 241.4000n -0.001036 241.4100n -0.001045 241.4200n -0.001053 241.4300n -0.001062 241.4400n -0.001070 241.4500n -0.001079 241.4600n -0.001088 241.4700n -0.001096 241.4800n -0.001105 241.4900n -0.001114
+ 241.5000n -0.001123 241.5100n -0.001132 241.5200n -0.001141 241.5300n -0.001150 241.5400n -0.001159 241.5500n -0.001168 241.5600n -0.001177 241.5700n -0.001187 241.5800n -0.001196 241.5900n -0.001206 241.6000n -0.001215 241.6100n -0.001224 241.6200n -0.001234 241.6300n -0.001244 241.6400n -0.001253
+ 241.6500n -0.001263 241.6600n -0.001272 241.6700n -0.001282 241.6800n -0.001292 241.6900n -0.001302 241.7000n -0.001311 241.7100n -0.001321 241.7200n -0.001331 241.7300n -0.001341 241.7400n -0.001350 241.7500n -0.001360 241.7600n -0.001370 241.7700n -0.001379 241.7800n -0.001389 241.7900n -0.001399
+ 241.8000n -0.001408 241.8100n -0.001418 241.8200n -0.001428 241.8300n -0.001437 241.8400n -0.001446 241.8500n -0.001456 241.8600n -0.001465 241.8700n -0.001474 241.8800n -0.001483 241.8900n -0.001492 241.9000n -0.001501 241.9100n -0.001510 241.9200n -0.001519 241.9300n -0.001528 241.9400n -0.001536
+ 241.9500n -0.001544 241.9600n -0.001552 241.9700n -0.001561 241.9800n -0.001568 241.9900n -0.001576 242.0000n -0.001584 242.0100n -0.001591 242.0200n -0.001598 242.0300n -0.001605 242.0400n -0.001612 242.0500n -0.001618 242.0600n -0.001625 242.0700n -0.001631 242.0800n -0.001636 242.0900n -0.001642
+ 242.1000n -0.001647 242.1100n -0.001652 242.1200n -0.001657 242.1300n -0.001661 242.1400n -0.001665 242.1500n -0.001669 242.1600n -0.001673 242.1700n -0.001676 242.1800n -0.001679 242.1900n -0.001681 242.2000n -0.001683 242.2100n -0.001685 242.2200n -0.001686 242.2300n -0.001687 242.2400n -0.001688
+ 242.2500n -0.001688 242.2600n -0.001688 242.2700n -0.001687 242.2800n -0.001686 242.2900n -0.001685 242.3000n -0.001683 242.3100n -0.001680 242.3200n -0.001678 242.3300n -0.001674 242.3400n -0.001671 242.3500n -0.001666 242.3600n -0.001662 242.3700n -0.001656 242.3800n -0.001651 242.3900n -0.001644
+ 242.4000n -0.001638 242.4100n -0.001630 242.4200n -0.001622 242.4300n -0.001614 242.4400n -0.001605 242.4500n -0.001596 242.4600n -0.001586 242.4700n -0.001575 242.4800n -0.001564 242.4900n -0.001552 242.5000n -0.001540 242.5100n -0.001527 242.5200n -0.001514 242.5300n -0.001500 242.5400n -0.001485
+ 242.5500n -0.001470 242.5600n -0.001454 242.5700n -0.001438 242.5800n -0.001421 242.5900n -0.001404 242.6000n -0.001386 242.6100n -0.001367 242.6200n -0.001347 242.6300n -0.001328 242.6400n -0.001307 242.6500n -0.001286 242.6600n -0.001264 242.6700n -0.001242 242.6800n -0.001219 242.6900n -0.001196
+ 242.7000n -0.001172 242.7100n -0.001147 242.7200n -0.001122 242.7300n -0.001096 242.7400n -0.001069 242.7500n -0.001042 242.7600n -0.001015 242.7700n -0.000987 242.7800n -0.000958 242.7900n -0.000929 242.8000n -0.000899 242.8100n -0.000869 242.8200n -0.000838 242.8300n -0.000807 242.8400n -0.000775
+ 242.8500n -0.000743 242.8600n -0.000710 242.8700n -0.000677 242.8800n -0.000643 242.8900n -0.000609 242.9000n -0.000574 242.9100n -0.000539 242.9200n -0.000503 242.9300n -0.000467 242.9400n -0.000431 242.9500n -0.000394 242.9600n -0.000357 242.9700n -0.000319 242.9800n -0.000281 242.9900n -0.000243
+ 243.0000n -0.000204 243.0100n -0.000165 243.0200n -0.000126 243.0300n -0.000086 243.0400n -0.000047 243.0500n -0.000007 243.0600n 0.000034 243.0700n 0.000074 243.0800n 0.000115 243.0900n 0.000156 243.1000n 0.000197 243.1100n 0.000238 243.1200n 0.000280 243.1300n 0.000321 243.1400n 0.000363
+ 243.1500n 0.000405 243.1600n 0.000446 243.1700n 0.000488 243.1800n 0.000530 243.1900n 0.000572 243.2000n 0.000614 243.2100n 0.000655 243.2200n 0.000697 243.2300n 0.000739 243.2400n 0.000780 243.2500n 0.000822 243.2600n 0.000863 243.2700n 0.000904 243.2800n 0.000945 243.2900n 0.000986
+ 243.3000n 0.001027 243.3100n 0.001067 243.3200n 0.001107 243.3300n 0.001147 243.3400n 0.001186 243.3500n 0.001225 243.3600n 0.001264 243.3700n 0.001302 243.3800n 0.001340 243.3900n 0.001378 243.4000n 0.001415 243.4100n 0.001452 243.4200n 0.001488 243.4300n 0.001524 243.4400n 0.001559
+ 243.4500n 0.001594 243.4600n 0.001628 243.4700n 0.001662 243.4800n 0.001695 243.4900n 0.001727 243.5000n 0.001759 243.5100n 0.001790 243.5200n 0.001820 243.5300n 0.001850 243.5400n 0.001879 243.5500n 0.001907 243.5600n 0.001934 243.5700n 0.001961 243.5800n 0.001987 243.5900n 0.002012
+ 243.6000n 0.002036 243.6100n 0.002060 243.6200n 0.002082 243.6300n 0.002104 243.6400n 0.002125 243.6500n 0.002145 243.6600n 0.002164 243.6700n 0.002182 243.6800n 0.002199 243.6900n 0.002215 243.7000n 0.002230 243.7100n 0.002244 243.7200n 0.002257 243.7300n 0.002270 243.7400n 0.002281
+ 243.7500n 0.002291 243.7600n 0.002300 243.7700n 0.002308 243.7800n 0.002315 243.7900n 0.002321 243.8000n 0.002325 243.8100n 0.002329 243.8200n 0.002332 243.8300n 0.002333 243.8400n 0.002333 243.8500n 0.002333 243.8600n 0.002331 243.8700n 0.002328 243.8800n 0.002324 243.8900n 0.002318
+ 243.9000n 0.002312 243.9100n 0.002305 243.9200n 0.002296 243.9300n 0.002286 243.9400n 0.002275 243.9500n 0.002263 243.9600n 0.002250 243.9700n 0.002236 243.9800n 0.002220 243.9900n 0.002204 244.0000n 0.002186 244.0100n 0.002167 244.0200n 0.002147 244.0300n 0.002126 244.0400n 0.002104
+ 244.0500n 0.002081 244.0600n 0.002057 244.0700n 0.002031 244.0800n 0.002005 244.0900n 0.001978 244.1000n 0.001949 244.1100n 0.001920 244.1200n 0.001889 244.1300n 0.001858 244.1400n 0.001825 244.1500n 0.001792 244.1600n 0.001757 244.1700n 0.001722 244.1800n 0.001686 244.1900n 0.001648
+ 244.2000n 0.001610 244.2100n 0.001571 244.2200n 0.001531 244.2300n 0.001491 244.2400n 0.001449 244.2500n 0.001407 244.2600n 0.001364 244.2700n 0.001320 244.2800n 0.001275 244.2900n 0.001230 244.3000n 0.001184 244.3100n 0.001137 244.3200n 0.001090 244.3300n 0.001042 244.3400n 0.000994
+ 244.3500n 0.000945 244.3600n 0.000895 244.3700n 0.000845 244.3800n 0.000794 244.3900n 0.000743 244.4000n 0.000691 244.4100n 0.000639 244.4200n 0.000587 244.4300n 0.000534 244.4400n 0.000481 244.4500n 0.000428 244.4600n 0.000374 244.4700n 0.000321 244.4800n 0.000266 244.4900n 0.000212
+ 244.5000n 0.000158 244.5100n 0.000103 244.5200n 0.000049 244.5300n -0.000006 244.5400n -0.000061 244.5500n -0.000115 244.5600n -0.000170 244.5700n -0.000225 244.5800n -0.000279 244.5900n -0.000334 244.6000n -0.000388 244.6100n -0.000442 244.6200n -0.000496 244.6300n -0.000550 244.6400n -0.000603
+ 244.6500n -0.000656 244.6600n -0.000709 244.6700n -0.000761 244.6800n -0.000813 244.6900n -0.000865 244.7000n -0.000916 244.7100n -0.000966 244.7200n -0.001016 244.7300n -0.001066 244.7400n -0.001115 244.7500n -0.001163 244.7600n -0.001211 244.7700n -0.001258 244.7800n -0.001304 244.7900n -0.001350
+ 244.8000n -0.001395 244.8100n -0.001439 244.8200n -0.001483 244.8300n -0.001525 244.8400n -0.001567 244.8500n -0.001608 244.8600n -0.001648 244.8700n -0.001687 244.8800n -0.001725 244.8900n -0.001763 244.9000n -0.001799 244.9100n -0.001834 244.9200n -0.001868 244.9300n -0.001901 244.9400n -0.001934
+ 244.9500n -0.001965 244.9600n -0.001995 244.9700n -0.002023 244.9800n -0.002051 244.9900n -0.002078 245.0000n -0.002103 245.0100n -0.002127 245.0200n -0.002150 245.0300n -0.002172 245.0400n -0.002193 245.0500n -0.002212 245.0600n -0.002231 245.0700n -0.002247 245.0800n -0.002263 245.0900n -0.002277
+ 245.1000n -0.002291 245.1100n -0.002302 245.1200n -0.002313 245.1300n -0.002322 245.1400n -0.002330 245.1500n -0.002337 245.1600n -0.002342 245.1700n -0.002346 245.1800n -0.002349 245.1900n -0.002351 245.2000n -0.002351 245.2100n -0.002350 245.2200n -0.002347 245.2300n -0.002344 245.2400n -0.002339
+ 245.2500n -0.002332 245.2600n -0.002325 245.2700n -0.002316 245.2800n -0.002306 245.2900n -0.002294 245.3000n -0.002282 245.3100n -0.002268 245.3200n -0.002253 245.3300n -0.002237 245.3400n -0.002219 245.3500n -0.002200 245.3600n -0.002180 245.3700n -0.002159 245.3800n -0.002137 245.3900n -0.002114
+ 245.4000n -0.002090 245.4100n -0.002064 245.4200n -0.002038 245.4300n -0.002010 245.4400n -0.001982 245.4500n -0.001952 245.4600n -0.001921 245.4700n -0.001890 245.4800n -0.001857 245.4900n -0.001824 245.5000n -0.001790 245.5100n -0.001754 245.5200n -0.001718 245.5300n -0.001682 245.5400n -0.001644
+ 245.5500n -0.001606 245.5600n -0.001566 245.5700n -0.001527 245.5800n -0.001486 245.5900n -0.001445 245.6000n -0.001403 245.6100n -0.001361 245.6200n -0.001318 245.6300n -0.001275 245.6400n -0.001231 245.6500n -0.001187 245.6600n -0.001142 245.6700n -0.001097 245.6800n -0.001052 245.6900n -0.001006
+ 245.7000n -0.000960 245.7100n -0.000914 245.7200n -0.000867 245.7300n -0.000821 245.7400n -0.000774 245.7500n -0.000727 245.7600n -0.000680 245.7700n -0.000633 245.7800n -0.000586 245.7900n -0.000539 245.8000n -0.000492 245.8100n -0.000445 245.8200n -0.000399 245.8300n -0.000352 245.8400n -0.000306
+ 245.8500n -0.000260 245.8600n -0.000214 245.8700n -0.000168 245.8800n -0.000123 245.8900n -0.000079 245.9000n -0.000034 245.9100n 0.000009 245.9200n 0.000053 245.9300n 0.000096 245.9400n 0.000138 245.9500n 0.000180 245.9600n 0.000221 245.9700n 0.000261 245.9800n 0.000301 245.9900n 0.000340
+ 246.0000n 0.000378 246.0100n 0.000416 246.0200n 0.000452 246.0300n 0.000488 246.0400n 0.000523 246.0500n 0.000557 246.0600n 0.000591 246.0700n 0.000623 246.0800n 0.000654 246.0900n 0.000684 246.1000n 0.000714 246.1100n 0.000742 246.1200n 0.000769 246.1300n 0.000795 246.1400n 0.000820
+ 246.1500n 0.000844 246.1600n 0.000866 246.1700n 0.000888 246.1800n 0.000908 246.1900n 0.000927 246.2000n 0.000945 246.2100n 0.000962 246.2200n 0.000977 246.2300n 0.000991 246.2400n 0.001004 246.2500n 0.001015 246.2600n 0.001026 246.2700n 0.001035 246.2800n 0.001042 246.2900n 0.001048
+ 246.3000n 0.001053 246.3100n 0.001057 246.3200n 0.001059 246.3300n 0.001059 246.3400n 0.001059 246.3500n 0.001057 246.3600n 0.001053 246.3700n 0.001049 246.3800n 0.001043 246.3900n 0.001035 246.4000n 0.001026 246.4100n 0.001016 246.4200n 0.001004 246.4300n 0.000991 246.4400n 0.000977
+ 246.4500n 0.000962 246.4600n 0.000945 246.4700n 0.000926 246.4800n 0.000907 246.4900n 0.000886 246.5000n 0.000863 246.5100n 0.000840 246.5200n 0.000815 246.5300n 0.000789 246.5400n 0.000762 246.5500n 0.000733 246.5600n 0.000703 246.5700n 0.000673 246.5800n 0.000640 246.5900n 0.000607
+ 246.6000n 0.000573 246.6100n 0.000537 246.6200n 0.000501 246.6300n 0.000463 246.6400n 0.000425 246.6500n 0.000385 246.6600n 0.000345 246.6700n 0.000303 246.6800n 0.000261 246.6900n 0.000217 246.7000n 0.000173 246.7100n 0.000128 246.7200n 0.000082 246.7300n 0.000036 246.7400n -0.000012
+ 246.7500n -0.000060 246.7600n -0.000108 246.7700n -0.000158 246.7800n -0.000208 246.7900n -0.000258 246.8000n -0.000309 246.8100n -0.000361 246.8200n -0.000413 246.8300n -0.000465 246.8400n -0.000518 246.8500n -0.000571 246.8600n -0.000625 246.8700n -0.000679 246.8800n -0.000733 246.8900n -0.000787
+ 246.9000n -0.000841 246.9100n -0.000896 246.9200n -0.000950 246.9300n -0.001005 246.9400n -0.001059 246.9500n -0.001114 246.9600n -0.001168 246.9700n -0.001223 246.9800n -0.001277 246.9900n -0.001331 247.0000n -0.001384 247.0100n -0.001438 247.0200n -0.001491 247.0300n -0.001544 247.0400n -0.001596
+ 247.0500n -0.001648 247.0600n -0.001699 247.0700n -0.001750 247.0800n -0.001801 247.0900n -0.001850 247.1000n -0.001900 247.1100n -0.001948 247.1200n -0.001996 247.1300n -0.002043 247.1400n -0.002089 247.1500n -0.002134 247.1600n -0.002179 247.1700n -0.002223 247.1800n -0.002266 247.1900n -0.002307
+ 247.2000n -0.002348 247.2100n -0.002388 247.2200n -0.002427 247.2300n -0.002464 247.2400n -0.002501 247.2500n -0.002536 247.2600n -0.002571 247.2700n -0.002604 247.2800n -0.002636 247.2900n -0.002666 247.3000n -0.002695 247.3100n -0.002723 247.3200n -0.002750 247.3300n -0.002775 247.3400n -0.002799
+ 247.3500n -0.002822 247.3600n -0.002843 247.3700n -0.002863 247.3800n -0.002881 247.3900n -0.002898 247.4000n -0.002913 247.4100n -0.002927 247.4200n -0.002939 247.4300n -0.002950 247.4400n -0.002959 247.4500n -0.002967 247.4600n -0.002973 247.4700n -0.002977 247.4800n -0.002980 247.4900n -0.002981
+ 247.5000n -0.002981 247.5100n -0.002979 247.5200n -0.002976 247.5300n -0.002971 247.5400n -0.002964 247.5500n -0.002956 247.5600n -0.002946 247.5700n -0.002934 247.5800n -0.002921 247.5900n -0.002906 247.6000n -0.002890 247.6100n -0.002872 247.6200n -0.002853 247.6300n -0.002832 247.6400n -0.002809
+ 247.6500n -0.002785 247.6600n -0.002759 247.6700n -0.002732 247.6800n -0.002703 247.6900n -0.002673 247.7000n -0.002641 247.7100n -0.002608 247.7200n -0.002573 247.7300n -0.002537 247.7400n -0.002499 247.7500n -0.002460 247.7600n -0.002420 247.7700n -0.002378 247.7800n -0.002335 247.7900n -0.002291
+ 247.8000n -0.002246 247.8100n -0.002199 247.8200n -0.002151 247.8300n -0.002102 247.8400n -0.002051 247.8500n -0.002000 247.8600n -0.001947 247.8700n -0.001893 247.8800n -0.001839 247.8900n -0.001783 247.9000n -0.001726 247.9100n -0.001669 247.9200n -0.001610 247.9300n -0.001551 247.9400n -0.001490
+ 247.9500n -0.001429 247.9600n -0.001368 247.9700n -0.001305 247.9800n -0.001242 247.9900n -0.001178 248.0000n -0.001114 248.0100n -0.001048 248.0200n -0.000983 248.0300n -0.000917 248.0400n -0.000850 248.0500n -0.000783 248.0600n -0.000716 248.0700n -0.000649 248.0800n -0.000581 248.0900n -0.000513
+ 248.1000n -0.000444 248.1100n -0.000376 248.1200n -0.000307 248.1300n -0.000239 248.1400n -0.000170 248.1500n -0.000101 248.1600n -0.000033 248.1700n 0.000036 248.1800n 0.000104 248.1900n 0.000172 248.2000n 0.000240 248.2100n 0.000308 248.2200n 0.000376 248.2300n 0.000443 248.2400n 0.000509
+ 248.2500n 0.000576 248.2600n 0.000642 248.2700n 0.000707 248.2800n 0.000772 248.2900n 0.000836 248.3000n 0.000899 248.3100n 0.000962 248.3200n 0.001025 248.3300n 0.001086 248.3400n 0.001147 248.3500n 0.001207 248.3600n 0.001266 248.3700n 0.001324 248.3800n 0.001382 248.3900n 0.001438
+ 248.4000n 0.001493 248.4100n 0.001548 248.4200n 0.001601 248.4300n 0.001654 248.4400n 0.001705 248.4500n 0.001755 248.4600n 0.001804 248.4700n 0.001852 248.4800n 0.001898 248.4900n 0.001944 248.5000n 0.001988 248.5100n 0.002031 248.5200n 0.002073 248.5300n 0.002113 248.5400n 0.002152
+ 248.5500n 0.002189 248.5600n 0.002226 248.5700n 0.002261 248.5800n 0.002294 248.5900n 0.002326 248.6000n 0.002357 248.6100n 0.002386 248.6200n 0.002414 248.6300n 0.002440 248.6400n 0.002465 248.6500n 0.002488 248.6600n 0.002510 248.6700n 0.002530 248.6800n 0.002549 248.6900n 0.002567
+ 248.7000n 0.002582 248.7100n 0.002597 248.7200n 0.002610 248.7300n 0.002621 248.7400n 0.002631 248.7500n 0.002639 248.7600n 0.002646 248.7700n 0.002651 248.7800n 0.002655 248.7900n 0.002657 248.8000n 0.002658 248.8100n 0.002657 248.8200n 0.002655 248.8300n 0.002652 248.8400n 0.002647
+ 248.8500n 0.002641 248.8600n 0.002633 248.8700n 0.002624 248.8800n 0.002613 248.8900n 0.002601 248.9000n 0.002588 248.9100n 0.002573 248.9200n 0.002558 248.9300n 0.002540 248.9400n 0.002522 248.9500n 0.002502 248.9600n 0.002482 248.9700n 0.002460 248.9800n 0.002436 248.9900n 0.002412
+ 249.0000n 0.002387 249.0100n 0.002360 249.0200n 0.002333 249.0300n 0.002304 249.0400n 0.002274 249.0500n 0.002244 249.0600n 0.002212 249.0700n 0.002180 249.0800n 0.002147 249.0900n 0.002113 249.1000n 0.002078 249.1100n 0.002042 249.1200n 0.002006 249.1300n 0.001969 249.1400n 0.001931
+ 249.1500n 0.001893 249.1600n 0.001854 249.1700n 0.001814 249.1800n 0.001774 249.1900n 0.001733 249.2000n 0.001692 249.2100n 0.001651 249.2200n 0.001609 249.2300n 0.001567 249.2400n 0.001524 249.2500n 0.001482 249.2600n 0.001439 249.2700n 0.001396 249.2800n 0.001352 249.2900n 0.001309
+ 249.3000n 0.001265 249.3100n 0.001222 249.3200n 0.001178 249.3300n 0.001135 249.3400n 0.001091 249.3500n 0.001048 249.3600n 0.001005 249.3700n 0.000962 249.3800n 0.000919 249.3900n 0.000877 249.4000n 0.000834 249.4100n 0.000792 249.4200n 0.000751 249.4300n 0.000710 249.4400n 0.000669
+ 249.4500n 0.000629 249.4600n 0.000589 249.4700n 0.000550 249.4800n 0.000511 249.4900n 0.000473 249.5000n 0.000435 249.5100n 0.000398 249.5200n 0.000362 249.5300n 0.000327 249.5400n 0.000292 249.5500n 0.000258 249.5600n 0.000224 249.5700n 0.000192 249.5800n 0.000160 249.5900n 0.000130
+ 249.6000n 0.000100 249.6100n 0.000071 249.6200n 0.000043 249.6300n 0.000016 249.6400n -0.000011 249.6500n -0.000036 249.6600n -0.000060 249.6700n -0.000083 249.6800n -0.000105 249.6900n -0.000126 249.7000n -0.000146 249.7100n -0.000165 249.7200n -0.000183 249.7300n -0.000200 249.7400n -0.000216
+ 249.7500n -0.000230 249.7600n -0.000244 249.7700n -0.000256 249.7800n -0.000267 249.7900n -0.000277 249.8000n -0.000286 249.8100n -0.000293 249.8200n -0.000300 249.8300n -0.000305 249.8400n -0.000310 249.8500n -0.000313 249.8600n -0.000315 249.8700n -0.000315 249.8800n -0.000315 249.8900n -0.000314
+ 249.9000n -0.000311 249.9100n -0.000307 249.9200n -0.000302 249.9300n -0.000296 249.9400n -0.000289 249.9500n -0.000281 249.9600n -0.000272 249.9700n -0.000261 249.9800n -0.000250 249.9900n -0.000237 250.0000n -0.000224 250.0100n -0.000209 250.0200n -0.000194 250.0300n -0.000177 250.0400n -0.000160
+ 250.0500n -0.000141 250.0600n -0.000122 250.0700n -0.000102 250.0800n -0.000081 250.0900n -0.000059 250.1000n -0.000036 250.1100n -0.000013 250.1200n 0.000012 250.1300n 0.000037 250.1400n 0.000063 250.1500n 0.000089 250.1600n 0.000116 250.1700n 0.000144 250.1800n 0.000173 250.1900n 0.000202
+ 250.2000n 0.000232 250.2100n 0.000262 250.2200n 0.000293 250.2300n 0.000324 250.2400n 0.000356 250.2500n 0.000388 250.2600n 0.000420 250.2700n 0.000453 250.2800n 0.000486 250.2900n 0.000520 250.3000n 0.000553 250.3100n 0.000587 250.3200n 0.000622 250.3300n 0.000656 250.3400n 0.000691
+ 250.3500n 0.000725 250.3600n 0.000760 250.3700n 0.000794 250.3800n 0.000829 250.3900n 0.000864 250.4000n 0.000899 250.4100n 0.000933 250.4200n 0.000967 250.4300n 0.001002 250.4400n 0.001036 250.4500n 0.001070 250.4600n 0.001103 250.4700n 0.001137 250.4800n 0.001170 250.4900n 0.001202
+ 250.5000n 0.001235 250.5100n 0.001267 250.5200n 0.001298 250.5300n 0.001329 250.5400n 0.001360 250.5500n 0.001390 250.5600n 0.001419 250.5700n 0.001448 250.5800n 0.001476 250.5900n 0.001504 250.6000n 0.001531 250.6100n 0.001558 250.6200n 0.001583 250.6300n 0.001608 250.6400n 0.001632
+ 250.6500n 0.001656 250.6600n 0.001679 250.6700n 0.001701 250.6800n 0.001722 250.6900n 0.001742 250.7000n 0.001761 250.7100n 0.001780 250.7200n 0.001797 250.7300n 0.001814 250.7400n 0.001830 250.7500n 0.001844 250.7600n 0.001858 250.7700n 0.001871 250.7800n 0.001883 250.7900n 0.001894
+ 250.8000n 0.001904 250.8100n 0.001913 250.8200n 0.001921 250.8300n 0.001927 250.8400n 0.001933 250.8500n 0.001938 250.8600n 0.001942 250.8700n 0.001944 250.8800n 0.001946 250.8900n 0.001947 250.9000n 0.001946 250.9100n 0.001945 250.9200n 0.001942 250.9300n 0.001939 250.9400n 0.001934
+ 250.9500n 0.001928 250.9600n 0.001921 250.9700n 0.001914 250.9800n 0.001905 250.9900n 0.001895 251.0000n 0.001884 251.0100n 0.001872 251.0200n 0.001859 251.0300n 0.001846 251.0400n 0.001831 251.0500n 0.001815 251.0600n 0.001798 251.0700n 0.001781 251.0800n 0.001762 251.0900n 0.001743
+ 251.1000n 0.001722 251.1100n 0.001701 251.1200n 0.001679 251.1300n 0.001656 251.1400n 0.001633 251.1500n 0.001608 251.1600n 0.001583 251.1700n 0.001557 251.1800n 0.001530 251.1900n 0.001503 251.2000n 0.001475 251.2100n 0.001446 251.2200n 0.001416 251.2300n 0.001386 251.2400n 0.001356
+ 251.2500n 0.001324 251.2600n 0.001293 251.2700n 0.001260 251.2800n 0.001228 251.2900n 0.001194 251.3000n 0.001161 251.3100n 0.001127 251.3200n 0.001092 251.3300n 0.001058 251.3400n 0.001023 251.3500n 0.000987 251.3600n 0.000952 251.3700n 0.000916 251.3800n 0.000880 251.3900n 0.000844
+ 251.4000n 0.000807 251.4100n 0.000771 251.4200n 0.000734 251.4300n 0.000698 251.4400n 0.000661 251.4500n 0.000624 251.4600n 0.000588 251.4700n 0.000551 251.4800n 0.000515 251.4900n 0.000479 251.5000n 0.000443 251.5100n 0.000407 251.5200n 0.000371 251.5300n 0.000336 251.5400n 0.000300
+ 251.5500n 0.000266 251.5600n 0.000231 251.5700n 0.000197 251.5800n 0.000163 251.5900n 0.000130 251.6000n 0.000097 251.6100n 0.000064 251.6200n 0.000032 251.6300n 0.000001 251.6400n -0.000030 251.6500n -0.000061 251.6600n -0.000090 251.6700n -0.000119 251.6800n -0.000148 251.6900n -0.000176
+ 251.7000n -0.000203 251.7100n -0.000230 251.7200n -0.000255 251.7300n -0.000280 251.7400n -0.000305 251.7500n -0.000328 251.7600n -0.000351 251.7700n -0.000373 251.7800n -0.000394 251.7900n -0.000414 251.8000n -0.000433 251.8100n -0.000452 251.8200n -0.000470 251.8300n -0.000486 251.8400n -0.000502
+ 251.8500n -0.000517 251.8600n -0.000531 251.8700n -0.000544 251.8800n -0.000556 251.8900n -0.000567 251.9000n -0.000577 251.9100n -0.000586 251.9200n -0.000595 251.9300n -0.000602 251.9400n -0.000608 251.9500n -0.000613 251.9600n -0.000618 251.9700n -0.000621 251.9800n -0.000623 251.9900n -0.000625
+ 252.0000n -0.000625 252.0100n -0.000624 252.0200n -0.000623 252.0300n -0.000620 252.0400n -0.000617 252.0500n -0.000612 252.0600n -0.000607 252.0700n -0.000600 252.0800n -0.000593 252.0900n -0.000585 252.1000n -0.000575 252.1100n -0.000565 252.1200n -0.000554 252.1300n -0.000542 252.1400n -0.000530
+ 252.1500n -0.000516 252.1600n -0.000501 252.1700n -0.000486 252.1800n -0.000470 252.1900n -0.000453 252.2000n -0.000435 252.2100n -0.000417 252.2200n -0.000397 252.2300n -0.000377 252.2400n -0.000357 252.2500n -0.000335 252.2600n -0.000313 252.2700n -0.000290 252.2800n -0.000267 252.2900n -0.000243
+ 252.3000n -0.000218 252.3100n -0.000193 252.3200n -0.000167 252.3300n -0.000141 252.3400n -0.000115 252.3500n -0.000087 252.3600n -0.000060 252.3700n -0.000032 252.3800n -0.000003 252.3900n 0.000026 252.4000n 0.000055 252.4100n 0.000085 252.4200n 0.000114 252.4300n 0.000144 252.4400n 0.000175
+ 252.4500n 0.000205 252.4600n 0.000236 252.4700n 0.000267 252.4800n 0.000298 252.4900n 0.000329 252.5000n 0.000361 252.5100n 0.000392 252.5200n 0.000424 252.5300n 0.000455 252.5400n 0.000486 252.5500n 0.000518 252.5600n 0.000549 252.5700n 0.000580 252.5800n 0.000611 252.5900n 0.000642
+ 252.6000n 0.000673 252.6100n 0.000704 252.6200n 0.000734 252.6300n 0.000764 252.6400n 0.000794 252.6500n 0.000824 252.6600n 0.000853 252.6700n 0.000882 252.6800n 0.000910 252.6900n 0.000938 252.7000n 0.000966 252.7100n 0.000994 252.7200n 0.001021 252.7300n 0.001047 252.7400n 0.001073
+ 252.7500n 0.001099 252.7600n 0.001123 252.7700n 0.001148 252.7800n 0.001172 252.7900n 0.001195 252.8000n 0.001218 252.8100n 0.001240 252.8200n 0.001261 252.8300n 0.001282 252.8400n 0.001303 252.8500n 0.001322 252.8600n 0.001341 252.8700n 0.001359 252.8800n 0.001377 252.8900n 0.001394
+ 252.9000n 0.001410 252.9100n 0.001425 252.9200n 0.001440 252.9300n 0.001454 252.9400n 0.001467 252.9500n 0.001479 252.9600n 0.001491 252.9700n 0.001502 252.9800n 0.001512 252.9900n 0.001521 253.0000n 0.001530 253.0100n 0.001537 253.0200n 0.001545 253.0300n 0.001551 253.0400n 0.001556
+ 253.0500n 0.001561 253.0600n 0.001565 253.0700n 0.001568 253.0800n 0.001570 253.0900n 0.001572 253.1000n 0.001573 253.1100n 0.001573 253.1200n 0.001573 253.1300n 0.001571 253.1400n 0.001569 253.1500n 0.001566 253.1600n 0.001563 253.1700n 0.001559 253.1800n 0.001554 253.1900n 0.001548
+ 253.2000n 0.001542 253.2100n 0.001535 253.2200n 0.001527 253.2300n 0.001519 253.2400n 0.001510 253.2500n 0.001501 253.2600n 0.001491 253.2700n 0.001480 253.2800n 0.001469 253.2900n 0.001457 253.3000n 0.001445 253.3100n 0.001433 253.3200n 0.001419 253.3300n 0.001406 253.3400n 0.001391
+ 253.3500n 0.001377 253.3600n 0.001362 253.3700n 0.001346 253.3800n 0.001331 253.3900n 0.001314 253.4000n 0.001298 253.4100n 0.001281 253.4200n 0.001264 253.4300n 0.001246 253.4400n 0.001229 253.4500n 0.001211 253.4600n 0.001193 253.4700n 0.001174 253.4800n 0.001156 253.4900n 0.001137
+ 253.5000n 0.001118 253.5100n 0.001099 253.5200n 0.001080 253.5300n 0.001061 253.5400n 0.001042 253.5500n 0.001023 253.5600n 0.001004 253.5700n 0.000985 253.5800n 0.000966 253.5900n 0.000946 253.6000n 0.000928 253.6100n 0.000909 253.6200n 0.000890 253.6300n 0.000871 253.6400n 0.000853
+ 253.6500n 0.000835 253.6600n 0.000816 253.6700n 0.000799 253.6800n 0.000781 253.6900n 0.000764 253.7000n 0.000746 253.7100n 0.000730 253.7200n 0.000713 253.7300n 0.000697 253.7400n 0.000681 253.7500n 0.000666 253.7600n 0.000650 253.7700n 0.000636 253.7800n 0.000621 253.7900n 0.000607
+ 253.8000n 0.000594 253.8100n 0.000581 253.8200n 0.000568 253.8300n 0.000556 253.8400n 0.000544 253.8500n 0.000533 253.8600n 0.000523 253.8700n 0.000512 253.8800n 0.000503 253.8900n 0.000494 253.9000n 0.000485 253.9100n 0.000477 253.9200n 0.000469 253.9300n 0.000462 253.9400n 0.000456
+ 253.9500n 0.000450 253.9600n 0.000445 253.9700n 0.000440 253.9800n 0.000436 253.9900n 0.000432 254.0000n 0.000429 254.0100n 0.000427 254.0200n 0.000425 254.0300n 0.000424 254.0400n 0.000423 254.0500n 0.000423 254.0600n 0.000423 254.0700n 0.000424 254.0800n 0.000425 254.0900n 0.000428
+ 254.1000n 0.000430 254.1100n 0.000433 254.1200n 0.000437 254.1300n 0.000441 254.1400n 0.000446 254.1500n 0.000451 254.1600n 0.000457 254.1700n 0.000463 254.1800n 0.000470 254.1900n 0.000477 254.2000n 0.000485 254.2100n 0.000493 254.2200n 0.000501 254.2300n 0.000510 254.2400n 0.000520
+ 254.2500n 0.000529 254.2600n 0.000540 254.2700n 0.000550 254.2800n 0.000561 254.2900n 0.000572 254.3000n 0.000584 254.3100n 0.000596 254.3200n 0.000608 254.3300n 0.000620 254.3400n 0.000633 254.3500n 0.000646 254.3600n 0.000659 254.3700n 0.000672 254.3800n 0.000685 254.3900n 0.000699
+ 254.4000n 0.000713 254.4100n 0.000727 254.4200n 0.000741 254.4300n 0.000755 254.4400n 0.000769 254.4500n 0.000783 254.4600n 0.000798 254.4700n 0.000812 254.4800n 0.000826 254.4900n 0.000840 254.5000n 0.000854 254.5100n 0.000868 254.5200n 0.000882 254.5300n 0.000896 254.5400n 0.000910
+ 254.5500n 0.000924 254.5600n 0.000937 254.5700n 0.000950 254.5800n 0.000963 254.5900n 0.000976 254.6000n 0.000988 254.6100n 0.001001 254.6200n 0.001013 254.6300n 0.001024 254.6400n 0.001036 254.6500n 0.001047 254.6600n 0.001057 254.6700n 0.001068 254.6800n 0.001077 254.6900n 0.001087
+ 254.7000n 0.001096 254.7100n 0.001104 254.7200n 0.001113 254.7300n 0.001120 254.7400n 0.001127 254.7500n 0.001134 254.7600n 0.001140 254.7700n 0.001146 254.7800n 0.001151 254.7900n 0.001155 254.8000n 0.001159 254.8100n 0.001163 254.8200n 0.001166 254.8300n 0.001168 254.8400n 0.001169
+ 254.8500n 0.001170 254.8600n 0.001171 254.8700n 0.001171 254.8800n 0.001170 254.8900n 0.001168 254.9000n 0.001166 254.9100n 0.001163 254.9200n 0.001160 254.9300n 0.001156 254.9400n 0.001151 254.9500n 0.001146 254.9600n 0.001140 254.9700n 0.001133 254.9800n 0.001126 254.9900n 0.001118
+ 255.0000n 0.001109 255.0100n 0.001100 255.0200n 0.001090 255.0300n 0.001079 255.0400n 0.001068 255.0500n 0.001056 255.0600n 0.001044 255.0700n 0.001030 255.0800n 0.001017 255.0900n 0.001002 255.1000n 0.000987 255.1100n 0.000972 255.1200n 0.000956 255.1300n 0.000939 255.1400n 0.000922
+ 255.1500n 0.000904 255.1600n 0.000885 255.1700n 0.000866 255.1800n 0.000847 255.1900n 0.000827 255.2000n 0.000807 255.2100n 0.000786 255.2200n 0.000765 255.2300n 0.000743 255.2400n 0.000721 255.2500n 0.000698 255.2600n 0.000675 255.2700n 0.000652 255.2800n 0.000628 255.2900n 0.000604
+ 255.3000n 0.000580 255.3100n 0.000556 255.3200n 0.000531 255.3300n 0.000506 255.3400n 0.000481 255.3500n 0.000455 255.3600n 0.000429 255.3700n 0.000404 255.3800n 0.000378 255.3900n 0.000352 255.4000n 0.000325 255.4100n 0.000299 255.4200n 0.000273 255.4300n 0.000247 255.4400n 0.000220
+ 255.4500n 0.000194 255.4600n 0.000168 255.4700n 0.000142 255.4800n 0.000116 255.4900n 0.000090 255.5000n 0.000064 255.5100n 0.000038 255.5200n 0.000013 255.5300n -0.000012 255.5400n -0.000037 255.5500n -0.000062 255.5600n -0.000086 255.5700n -0.000110 255.5800n -0.000134 255.5900n -0.000158
+ 255.6000n -0.000181 255.6100n -0.000203 255.6200n -0.000226 255.6300n -0.000247 255.6400n -0.000269 255.6500n -0.000289 255.6600n -0.000310 255.6700n -0.000329 255.6800n -0.000349 255.6900n -0.000367 255.7000n -0.000385 255.7100n -0.000403 255.7200n -0.000419 255.7300n -0.000436 255.7400n -0.000451
+ 255.7500n -0.000466 255.7600n -0.000480 255.7700n -0.000493 255.7800n -0.000506 255.7900n -0.000518 255.8000n -0.000529 255.8100n -0.000540 255.8200n -0.000549 255.8300n -0.000558 255.8400n -0.000566 255.8500n -0.000573 255.8600n -0.000580 255.8700n -0.000585 255.8800n -0.000590 255.8900n -0.000594
+ 255.9000n -0.000597 255.9100n -0.000599 255.9200n -0.000600 255.9300n -0.000601 255.9400n -0.000600 255.9500n -0.000599 255.9600n -0.000597 255.9700n -0.000594 255.9800n -0.000590 255.9900n -0.000585 256.0000n -0.000579 256.0100n -0.000572 256.0200n -0.000565 256.0300n -0.000556 256.0400n -0.000547
+ 256.0500n -0.000537 256.0600n -0.000526 256.0700n -0.000514 256.0800n -0.000501 256.0900n -0.000488 256.1000n -0.000473 256.1100n -0.000458 256.1200n -0.000442 256.1300n -0.000425 256.1400n -0.000408 256.1500n -0.000389 256.1600n -0.000370 256.1700n -0.000350 256.1800n -0.000329 256.1900n -0.000308
+ 256.2000n -0.000286 256.2100n -0.000263 256.2200n -0.000240 256.2300n -0.000216 256.2400n -0.000191 256.2500n -0.000166 256.2600n -0.000140 256.2700n -0.000113 256.2800n -0.000086 256.2900n -0.000059 256.3000n -0.000031 256.3100n -0.000002 256.3200n 0.000027 256.3300n 0.000056 256.3400n 0.000086
+ 256.3500n 0.000116 256.3600n 0.000147 256.3700n 0.000178 256.3800n 0.000209 256.3900n 0.000241 256.4000n 0.000272 256.4100n 0.000304 256.4200n 0.000336 256.4300n 0.000369 256.4400n 0.000401 256.4500n 0.000434 256.4600n 0.000466 256.4700n 0.000499 256.4800n 0.000532 256.4900n 0.000564
+ 256.5000n 0.000597 256.5100n 0.000629 256.5200n 0.000662 256.5300n 0.000694 256.5400n 0.000726 256.5500n 0.000758 256.5600n 0.000790 256.5700n 0.000822 256.5800n 0.000853 256.5900n 0.000884 256.6000n 0.000915 256.6100n 0.000945 256.6200n 0.000975 256.6300n 0.001004 256.6400n 0.001033
+ 256.6500n 0.001062 256.6600n 0.001090 256.6700n 0.001117 256.6800n 0.001144 256.6900n 0.001170 256.7000n 0.001196 256.7100n 0.001221 256.7200n 0.001245 256.7300n 0.001269 256.7400n 0.001292 256.7500n 0.001314 256.7600n 0.001336 256.7700n 0.001356 256.7800n 0.001376 256.7900n 0.001395
+ 256.8000n 0.001413 256.8100n 0.001431 256.8200n 0.001447 256.8300n 0.001463 256.8400n 0.001477 256.8500n 0.001491 256.8600n 0.001503 256.8700n 0.001515 256.8800n 0.001526 256.8900n 0.001535 256.9000n 0.001544 256.9100n 0.001551 256.9200n 0.001558 256.9300n 0.001563 256.9400n 0.001567
+ 256.9500n 0.001571 256.9600n 0.001573 256.9700n 0.001574 256.9800n 0.001573 256.9900n 0.001572 257.0000n 0.001570 257.0100n 0.001566 257.0200n 0.001562 257.0300n 0.001556 257.0400n 0.001549 257.0500n 0.001541 257.0600n 0.001531 257.0700n 0.001521 257.0800n 0.001509 257.0900n 0.001496
+ 257.1000n 0.001483 257.1100n 0.001468 257.1200n 0.001451 257.1300n 0.001434 257.1400n 0.001416 257.1500n 0.001396 257.1600n 0.001375 257.1700n 0.001354 257.1800n 0.001331 257.1900n 0.001307 257.2000n 0.001282 257.2100n 0.001256 257.2200n 0.001229 257.2300n 0.001201 257.2400n 0.001171
+ 257.2500n 0.001141 257.2600n 0.001110 257.2700n 0.001078 257.2800n 0.001045 257.2900n 0.001011 257.3000n 0.000976 257.3100n 0.000941 257.3200n 0.000904 257.3300n 0.000866 257.3400n 0.000828 257.3500n 0.000789 257.3600n 0.000749 257.3700n 0.000709 257.3800n 0.000668 257.3900n 0.000626
+ 257.4000n 0.000583 257.4100n 0.000540 257.4200n 0.000496 257.4300n 0.000451 257.4400n 0.000406 257.4500n 0.000361 257.4600n 0.000314 257.4700n 0.000268 257.4800n 0.000221 257.4900n 0.000174 257.5000n 0.000126 257.5100n 0.000078 257.5200n 0.000029 257.5300n -0.000019 257.5400n -0.000068
+ 257.5500n -0.000118 257.5600n -0.000167 257.5700n -0.000217 257.5800n -0.000266 257.5900n -0.000316 257.6000n -0.000366 257.6100n -0.000416 257.6200n -0.000465 257.6300n -0.000515 257.6400n -0.000565 257.6500n -0.000614 257.6600n -0.000664 257.6700n -0.000713 257.6800n -0.000762 257.6900n -0.000811
+ 257.7000n -0.000860 257.7100n -0.000908 257.7200n -0.000956 257.7300n -0.001003 257.7400n -0.001051 257.7500n -0.001097 257.7600n -0.001144 257.7700n -0.001189 257.7800n -0.001235 257.7900n -0.001279 257.8000n -0.001324 257.8100n -0.001367 257.8200n -0.001410 257.8300n -0.001452 257.8400n -0.001494
+ 257.8500n -0.001535 257.8600n -0.001575 257.8700n -0.001614 257.8800n -0.001653 257.8900n -0.001691 257.9000n -0.001728 257.9100n -0.001764 257.9200n -0.001799 257.9300n -0.001833 257.9400n -0.001867 257.9500n -0.001899 257.9600n -0.001931 257.9700n -0.001961 257.9800n -0.001991 257.9900n -0.002019
+ 258.0000n -0.002047 258.0100n -0.002073 258.0200n -0.002099 258.0300n -0.002123 258.0400n -0.002146 258.0500n -0.002169 258.0600n -0.002190 258.0700n -0.002210 258.0800n -0.002228 258.0900n -0.002246 258.1000n -0.002263 258.1100n -0.002278 258.1200n -0.002292 258.1300n -0.002305 258.1400n -0.002317
+ 258.1500n -0.002328 258.1600n -0.002338 258.1700n -0.002346 258.1800n -0.002353 258.1900n -0.002359 258.2000n -0.002364 258.2100n -0.002368 258.2200n -0.002371 258.2300n -0.002372 258.2400n -0.002372 258.2500n -0.002371 258.2600n -0.002369 258.2700n -0.002366 258.2800n -0.002362 258.2900n -0.002357
+ 258.3000n -0.002350 258.3100n -0.002343 258.3200n -0.002334 258.3300n -0.002324 258.3400n -0.002313 258.3500n -0.002301 258.3600n -0.002289 258.3700n -0.002275 258.3800n -0.002260 258.3900n -0.002244 258.4000n -0.002227 258.4100n -0.002209 258.4200n -0.002190 258.4300n -0.002171 258.4400n -0.002150
+ 258.4500n -0.002129 258.4600n -0.002106 258.4700n -0.002083 258.4800n -0.002059 258.4900n -0.002034 258.5000n -0.002009 258.5100n -0.001983 258.5200n -0.001956 258.5300n -0.001928 258.5400n -0.001900 258.5500n -0.001871 258.5600n -0.001841 258.5700n -0.001811 258.5800n -0.001780 258.5900n -0.001749
+ 258.6000n -0.001717 258.6100n -0.001684 258.6200n -0.001651 258.6300n -0.001618 258.6400n -0.001585 258.6500n -0.001550 258.6600n -0.001516 258.6700n -0.001481 258.6800n -0.001446 258.6900n -0.001411 258.7000n -0.001375 258.7100n -0.001339 258.7200n -0.001303 258.7300n -0.001267 258.7400n -0.001231
+ 258.7500n -0.001194 258.7600n -0.001158 258.7700n -0.001121 258.7800n -0.001084 258.7900n -0.001048 258.8000n -0.001011 258.8100n -0.000974 258.8200n -0.000938 258.8300n -0.000901 258.8400n -0.000865 258.8500n -0.000828 258.8600n -0.000792 258.8700n -0.000756 258.8800n -0.000721 258.8900n -0.000685
+ 258.9000n -0.000650 258.9100n -0.000615 258.9200n -0.000580 258.9300n -0.000546 258.9400n -0.000512 258.9500n -0.000478 258.9600n -0.000445 258.9700n -0.000412 258.9800n -0.000379 258.9900n -0.000347 259.0000n -0.000315 259.0100n -0.000284 259.0200n -0.000253 259.0300n -0.000223 259.0400n -0.000193
+ 259.0500n -0.000164 259.0600n -0.000135 259.0700n -0.000107 259.0800n -0.000079 259.0900n -0.000052 259.1000n -0.000026 259.1100n 0.000000 259.1200n 0.000026 259.1300n 0.000051 259.1400n 0.000075 259.1500n 0.000098 259.1600n 0.000121 259.1700n 0.000144 259.1800n 0.000166 259.1900n 0.000187
+ 259.2000n 0.000207 259.2100n 0.000227 259.2200n 0.000247 259.2300n 0.000265 259.2400n 0.000283 259.2500n 0.000301 259.2600n 0.000318 259.2700n 0.000334 259.2800n 0.000349 259.2900n 0.000364 259.3000n 0.000379 259.3100n 0.000392 259.3200n 0.000406 259.3300n 0.000418 259.3400n 0.000430
+ 259.3500n 0.000442 259.3600n 0.000453 259.3700n 0.000463 259.3800n 0.000473 259.3900n 0.000482 259.4000n 0.000491 259.4100n 0.000499 259.4200n 0.000507 259.4300n 0.000514 259.4400n 0.000521 259.4500n 0.000528 259.4600n 0.000533 259.4700n 0.000539 259.4800n 0.000544 259.4900n 0.000549
+ 259.5000n 0.000553 259.5100n 0.000557 259.5200n 0.000561 259.5300n 0.000564 259.5400n 0.000567 259.5500n 0.000570 259.5600n 0.000573 259.5700n 0.000575 259.5800n 0.000577 259.5900n 0.000579 259.6000n 0.000580 259.6100n 0.000582 259.6200n 0.000583 259.6300n 0.000584 259.6400n 0.000585
+ 259.6500n 0.000586 259.6600n 0.000587 259.6700n 0.000588 259.6800n 0.000588 259.6900n 0.000589 259.7000n 0.000590 259.7100n 0.000591 259.7200n 0.000592 259.7300n 0.000592 259.7400n 0.000593 259.7500n 0.000595 259.7600n 0.000596 259.7700n 0.000597 259.7800n 0.000599 259.7900n 0.000600
+ 259.8000n 0.000602 259.8100n 0.000604 259.8200n 0.000607 259.8300n 0.000609 259.8400n 0.000612 259.8500n 0.000615 259.8600n 0.000619 259.8700n 0.000623 259.8800n 0.000627 259.8900n 0.000631 259.9000n 0.000636 259.9100n 0.000642 259.9200n 0.000647 259.9300n 0.000653 259.9400n 0.000660
+ 259.9500n 0.000667 259.9600n 0.000674 259.9700n 0.000682 259.9800n 0.000690 259.9900n 0.000699 260.0000n 0.000708 260.0100n 0.000718 260.0200n 0.000728 260.0300n 0.000739 260.0400n 0.000750 260.0500n 0.000762 260.0600n 0.000775 260.0700n 0.000788 260.0800n 0.000801 260.0900n 0.000815
+ 260.1000n 0.000830 260.1100n 0.000845 260.1200n 0.000860 260.1300n 0.000877 260.1400n 0.000893 260.1500n 0.000911 260.1600n 0.000928 260.1700n 0.000947 260.1800n 0.000966 260.1900n 0.000985 260.2000n 0.001005 260.2100n 0.001026 260.2200n 0.001047 260.2300n 0.001069 260.2400n 0.001091
+ 260.2500n 0.001113 260.2600n 0.001136 260.2700n 0.001160 260.2800n 0.001184 260.2900n 0.001209 260.3000n 0.001234 260.3100n 0.001259 260.3200n 0.001285 260.3300n 0.001311 260.3400n 0.001338 260.3500n 0.001365 260.3600n 0.001393 260.3700n 0.001420 260.3800n 0.001448 260.3900n 0.001477
+ 260.4000n 0.001506 260.4100n 0.001535 260.4200n 0.001564 260.4300n 0.001594 260.4400n 0.001623 260.4500n 0.001653 260.4600n 0.001684 260.4700n 0.001714 260.4800n 0.001744 260.4900n 0.001775 260.5000n 0.001806 260.5100n 0.001836 260.5200n 0.001867 260.5300n 0.001898 260.5400n 0.001929
+ 260.5500n 0.001960 260.5600n 0.001991 260.5700n 0.002021 260.5800n 0.002052 260.5900n 0.002083 260.6000n 0.002113 260.6100n 0.002143 260.6200n 0.002173 260.6300n 0.002203 260.6400n 0.002233 260.6500n 0.002262 260.6600n 0.002291 260.6700n 0.002319 260.6800n 0.002348 260.6900n 0.002376
+ 260.7000n 0.002403 260.7100n 0.002430 260.7200n 0.002457 260.7300n 0.002483 260.7400n 0.002509 260.7500n 0.002534 260.7600n 0.002559 260.7700n 0.002583 260.7800n 0.002606 260.7900n 0.002629 260.8000n 0.002651 260.8100n 0.002673 260.8200n 0.002693 260.8300n 0.002713 260.8400n 0.002733
+ 260.8500n 0.002751 260.8600n 0.002769 260.8700n 0.002786 260.8800n 0.002802 260.8900n 0.002818 260.9000n 0.002832 260.9100n 0.002846 260.9200n 0.002858 260.9300n 0.002870 260.9400n 0.002881 260.9500n 0.002891 260.9600n 0.002900 260.9700n 0.002908 260.9800n 0.002915 260.9900n 0.002921
+ 261.0000n 0.002925 261.0100n 0.002929 261.0200n 0.002932 261.0300n 0.002934 261.0400n 0.002935 261.0500n 0.002934 261.0600n 0.002933 261.0700n 0.002930 261.0800n 0.002927 261.0900n 0.002922 261.1000n 0.002916 261.1100n 0.002909 261.1200n 0.002901 261.1300n 0.002892 261.1400n 0.002881
+ 261.1500n 0.002870 261.1600n 0.002857 261.1700n 0.002844 261.1800n 0.002829 261.1900n 0.002813 261.2000n 0.002796 261.2100n 0.002777 261.2200n 0.002758 261.2300n 0.002738 261.2400n 0.002716 261.2500n 0.002694 261.2600n 0.002670 261.2700n 0.002645 261.2800n 0.002619 261.2900n 0.002592
+ 261.3000n 0.002565 261.3100n 0.002536 261.3200n 0.002506 261.3300n 0.002475 261.3400n 0.002443 261.3500n 0.002410 261.3600n 0.002376 261.3700n 0.002341 261.3800n 0.002305 261.3900n 0.002269 261.4000n 0.002231 261.4100n 0.002193 261.4200n 0.002154 261.4300n 0.002114 261.4400n 0.002073
+ 261.4500n 0.002031 261.4600n 0.001989 261.4700n 0.001946 261.4800n 0.001902 261.4900n 0.001858 261.5000n 0.001813 261.5100n 0.001767 261.5200n 0.001721 261.5300n 0.001674 261.5400n 0.001627 261.5500n 0.001579 261.5600n 0.001530 261.5700n 0.001482 261.5800n 0.001432 261.5900n 0.001383
+ 261.6000n 0.001333 261.6100n 0.001282 261.6200n 0.001232 261.6300n 0.001181 261.6400n 0.001130 261.6500n 0.001078 261.6600n 0.001027 261.6700n 0.000975 261.6800n 0.000923 261.6900n 0.000871 261.7000n 0.000819 261.7100n 0.000767 261.7200n 0.000715 261.7300n 0.000664 261.7400n 0.000612
+ 261.7500n 0.000560 261.7600n 0.000508 261.7700n 0.000457 261.7800n 0.000406 261.7900n 0.000355 261.8000n 0.000304 261.8100n 0.000254 261.8200n 0.000204 261.8300n 0.000154 261.8400n 0.000105 261.8500n 0.000056 261.8600n 0.000007 261.8700n -0.000041 261.8800n -0.000088 261.8900n -0.000135
+ 261.9000n -0.000181 261.9100n -0.000227 261.9200n -0.000272 261.9300n -0.000317 261.9400n -0.000361 261.9500n -0.000404 261.9600n -0.000446 261.9700n -0.000488 261.9800n -0.000529 261.9900n -0.000569 262.0000n -0.000608 262.0100n -0.000647 262.0200n -0.000684 262.0300n -0.000721 262.0400n -0.000757
+ 262.0500n -0.000792 262.0600n -0.000826 262.0700n -0.000859 262.0800n -0.000891 262.0900n -0.000922 262.1000n -0.000952 262.1100n -0.000982 262.1200n -0.001010 262.1300n -0.001037 262.1400n -0.001063 262.1500n -0.001088 262.1600n -0.001112 262.1700n -0.001134 262.1800n -0.001156 262.1900n -0.001177
+ 262.2000n -0.001196 262.2100n -0.001215 262.2200n -0.001232 262.2300n -0.001248 262.2400n -0.001263 262.2500n -0.001278 262.2600n -0.001290 262.2700n -0.001302 262.2800n -0.001313 262.2900n -0.001323 262.3000n -0.001331 262.3100n -0.001338 262.3200n -0.001345 262.3300n -0.001350 262.3400n -0.001354
+ 262.3500n -0.001357 262.3600n -0.001359 262.3700n -0.001360 262.3800n -0.001360 262.3900n -0.001359 262.4000n -0.001356 262.4100n -0.001353 262.4200n -0.001349 262.4300n -0.001344 262.4400n -0.001338 262.4500n -0.001331 262.4600n -0.001323 262.4700n -0.001314 262.4800n -0.001304 262.4900n -0.001293
+ 262.5000n -0.001282 262.5100n -0.001269 262.5200n -0.001256 262.5300n -0.001242 262.5400n -0.001227 262.5500n -0.001212 262.5600n -0.001195 262.5700n -0.001178 262.5800n -0.001161 262.5900n -0.001142 262.6000n -0.001123 262.6100n -0.001104 262.6200n -0.001084 262.6300n -0.001063 262.6400n -0.001042
+ 262.6500n -0.001020 262.6600n -0.000998 262.6700n -0.000975 262.6800n -0.000952 262.6900n -0.000929 262.7000n -0.000905 262.7100n -0.000881 262.7200n -0.000857 262.7300n -0.000832 262.7400n -0.000807 262.7500n -0.000782 262.7600n -0.000757 262.7700n -0.000732 262.7800n -0.000706 262.7900n -0.000681
+ 262.8000n -0.000655 262.8100n -0.000630 262.8200n -0.000604 262.8300n -0.000578 262.8400n -0.000553 262.8500n -0.000528 262.8600n -0.000502 262.8700n -0.000477 262.8800n -0.000452 262.8900n -0.000428 262.9000n -0.000403 262.9100n -0.000379 262.9200n -0.000355 262.9300n -0.000332 262.9400n -0.000308
+ 262.9500n -0.000286 262.9600n -0.000263 262.9700n -0.000241 262.9800n -0.000220 262.9900n -0.000199 263.0000n -0.000178 263.0100n -0.000158 263.0200n -0.000139 263.0300n -0.000120 263.0400n -0.000102 263.0500n -0.000084 263.0600n -0.000068 263.0700n -0.000051 263.0800n -0.000036 263.0900n -0.000021
+ 263.1000n -0.000007 263.1100n 0.000007 263.1200n 0.000019 263.1300n 0.000031 263.1400n 0.000042 263.1500n 0.000053 263.1600n 0.000062 263.1700n 0.000071 263.1800n 0.000079 263.1900n 0.000085 263.2000n 0.000092 263.2100n 0.000097 263.2200n 0.000101 263.2300n 0.000104 263.2400n 0.000107
+ 263.2500n 0.000109 263.2600n 0.000109 263.2700n 0.000109 263.2800n 0.000108 263.2900n 0.000106 263.3000n 0.000103 263.3100n 0.000099 263.3200n 0.000094 263.3300n 0.000089 263.3400n 0.000082 263.3500n 0.000075 263.3600n 0.000066 263.3700n 0.000057 263.3800n 0.000046 263.3900n 0.000035
+ 263.4000n 0.000023 263.4100n 0.000010 263.4200n -0.000004 263.4300n -0.000018 263.4400n -0.000034 263.4500n -0.000050 263.4600n -0.000067 263.4700n -0.000085 263.4800n -0.000104 263.4900n -0.000124 263.5000n -0.000144 263.5100n -0.000165 263.5200n -0.000187 263.5300n -0.000209 263.5400n -0.000233
+ 263.5500n -0.000257 263.5600n -0.000281 263.5700n -0.000307 263.5800n -0.000332 263.5900n -0.000359 263.6000n -0.000386 263.6100n -0.000414 263.6200n -0.000442 263.6300n -0.000471 263.6400n -0.000500 263.6500n -0.000529 263.6600n -0.000559 263.6700n -0.000590 263.6800n -0.000621 263.6900n -0.000652
+ 263.7000n -0.000684 263.7100n -0.000715 263.7200n -0.000748 263.7300n -0.000780 263.7400n -0.000813 263.7500n -0.000846 263.7600n -0.000879 263.7700n -0.000912 263.7800n -0.000945 263.7900n -0.000978 263.8000n -0.001012 263.8100n -0.001045 263.8200n -0.001078 263.8300n -0.001112 263.8400n -0.001145
+ 263.8500n -0.001178 263.8600n -0.001211 263.8700n -0.001244 263.8800n -0.001277 263.8900n -0.001310 263.9000n -0.001342 263.9100n -0.001374 263.9200n -0.001406 263.9300n -0.001437 263.9400n -0.001468 263.9500n -0.001499 263.9600n -0.001529 263.9700n -0.001559 263.9800n -0.001589 263.9900n -0.001617
+ 264.0000n -0.001646 264.0100n -0.001674 264.0200n -0.001701 264.0300n -0.001728 264.0400n -0.001754 264.0500n -0.001779 264.0600n -0.001804 264.0700n -0.001828 264.0800n -0.001852 264.0900n -0.001874 264.1000n -0.001896 264.1100n -0.001918 264.1200n -0.001938 264.1300n -0.001958 264.1400n -0.001976
+ 264.1500n -0.001994 264.1600n -0.002012 264.1700n -0.002028 264.1800n -0.002043 264.1900n -0.002058 264.2000n -0.002071 264.2100n -0.002084 264.2200n -0.002095 264.2300n -0.002106 264.2400n -0.002116 264.2500n -0.002124 264.2600n -0.002132 264.2700n -0.002139 264.2800n -0.002145 264.2900n -0.002149
+ 264.3000n -0.002153 264.3100n -0.002156 264.3200n -0.002158 264.3300n -0.002158 264.3400n -0.002158 264.3500n -0.002156 264.3600n -0.002154 264.3700n -0.002151 264.3800n -0.002146 264.3900n -0.002141 264.4000n -0.002134 264.4100n -0.002126 264.4200n -0.002118 264.4300n -0.002108 264.4400n -0.002097
+ 264.4500n -0.002086 264.4600n -0.002073 264.4700n -0.002059 264.4800n -0.002045 264.4900n -0.002029 264.5000n -0.002013 264.5100n -0.001995 264.5200n -0.001977 264.5300n -0.001957 264.5400n -0.001937 264.5500n -0.001916 264.5600n -0.001894 264.5700n -0.001871 264.5800n -0.001847 264.5900n -0.001822
+ 264.6000n -0.001797 264.6100n -0.001770 264.6200n -0.001743 264.6300n -0.001716 264.6400n -0.001687 264.6500n -0.001658 264.6600n -0.001628 264.6700n -0.001597 264.6800n -0.001566 264.6900n -0.001534 264.7000n -0.001501 264.7100n -0.001468 264.7200n -0.001434 264.7300n -0.001400 264.7400n -0.001365
+ 264.7500n -0.001330 264.7600n -0.001294 264.7700n -0.001258 264.7800n -0.001222 264.7900n -0.001185 264.8000n -0.001147 264.8100n -0.001110 264.8200n -0.001072 264.8300n -0.001033 264.8400n -0.000995 264.8500n -0.000956 264.8600n -0.000917 264.8700n -0.000878 264.8800n -0.000839 264.8900n -0.000799
+ 264.9000n -0.000760 264.9100n -0.000720 264.9200n -0.000681 264.9300n -0.000641 264.9400n -0.000601 264.9500n -0.000562 264.9600n -0.000522 264.9700n -0.000483 264.9800n -0.000444 264.9900n -0.000405 265.0000n -0.000366 265.0100n -0.000327 265.0200n -0.000288 265.0300n -0.000250 265.0400n -0.000212
+ 265.0500n -0.000174 265.0600n -0.000137 265.0700n -0.000100 265.0800n -0.000063 265.0900n -0.000027 265.1000n 0.000009 265.1100n 0.000044 265.1200n 0.000079 265.1300n 0.000114 265.1400n 0.000148 265.1500n 0.000181 265.1600n 0.000214 265.1700n 0.000246 265.1800n 0.000278 265.1900n 0.000309
+ 265.2000n 0.000340 265.2100n 0.000370 265.2200n 0.000399 265.2300n 0.000428 265.2400n 0.000456 265.2500n 0.000483 265.2600n 0.000510 265.2700n 0.000536 265.2800n 0.000561 265.2900n 0.000585 265.3000n 0.000609 265.3100n 0.000632 265.3200n 0.000654 265.3300n 0.000676 265.3400n 0.000697
+ 265.3500n 0.000717 265.3600n 0.000736 265.3700n 0.000754 265.3800n 0.000772 265.3900n 0.000788 265.4000n 0.000804 265.4100n 0.000820 265.4200n 0.000834 265.4300n 0.000848 265.4400n 0.000860 265.4500n 0.000872 265.4600n 0.000884 265.4700n 0.000894 265.4800n 0.000904 265.4900n 0.000912
+ 265.5000n 0.000920 265.5100n 0.000928 265.5200n 0.000934 265.5300n 0.000940 265.5400n 0.000945 265.5500n 0.000949 265.5600n 0.000953 265.5700n 0.000956 265.5800n 0.000958 265.5900n 0.000959 265.6000n 0.000960 265.6100n 0.000960 265.6200n 0.000960 265.6300n 0.000958 265.6400n 0.000956
+ 265.6500n 0.000954 265.6600n 0.000951 265.6700n 0.000947 265.6800n 0.000943 265.6900n 0.000938 265.7000n 0.000933 265.7100n 0.000927 265.7200n 0.000921 265.7300n 0.000914 265.7400n 0.000907 265.7500n 0.000899 265.7600n 0.000891 265.7700n 0.000882 265.7800n 0.000873 265.7900n 0.000864
+ 265.8000n 0.000855 265.8100n 0.000845 265.8200n 0.000834 265.8300n 0.000824 265.8400n 0.000813 265.8500n 0.000802 265.8600n 0.000791 265.8700n 0.000780 265.8800n 0.000768 265.8900n 0.000757 265.9000n 0.000745 265.9100n 0.000733 265.9200n 0.000721 265.9300n 0.000709 265.9400n 0.000697
+ 265.9500n 0.000685 265.9600n 0.000673 265.9700n 0.000661 265.9800n 0.000650 265.9900n 0.000638 266.0000n 0.000626 266.0100n 0.000615 266.0200n 0.000603 266.0300n 0.000592 266.0400n 0.000581 266.0500n 0.000571 266.0600n 0.000560 266.0700n 0.000550 266.0800n 0.000540 266.0900n 0.000530
+ 266.1000n 0.000521 266.1100n 0.000512 266.1200n 0.000504 266.1300n 0.000495 266.1400n 0.000487 266.1500n 0.000480 266.1600n 0.000473 266.1700n 0.000466 266.1800n 0.000460 266.1900n 0.000455 266.2000n 0.000450 266.2100n 0.000445 266.2200n 0.000441 266.2300n 0.000437 266.2400n 0.000434
+ 266.2500n 0.000432 266.2600n 0.000430 266.2700n 0.000429 266.2800n 0.000428 266.2900n 0.000428 266.3000n 0.000428 266.3100n 0.000429 266.3200n 0.000431 266.3300n 0.000433 266.3400n 0.000436 266.3500n 0.000440 266.3600n 0.000444 266.3700n 0.000449 266.3800n 0.000455 266.3900n 0.000461
+ 266.4000n 0.000468 266.4100n 0.000475 266.4200n 0.000483 266.4300n 0.000492 266.4400n 0.000501 266.4500n 0.000512 266.4600n 0.000522 266.4700n 0.000534 266.4800n 0.000546 266.4900n 0.000558 266.5000n 0.000572 266.5100n 0.000586 266.5200n 0.000600 266.5300n 0.000615 266.5400n 0.000631
+ 266.5500n 0.000647 266.5600n 0.000664 266.5700n 0.000682 266.5800n 0.000700 266.5900n 0.000718 266.6000n 0.000737 266.6100n 0.000757 266.6200n 0.000777 266.6300n 0.000798 266.6400n 0.000819 266.6500n 0.000840 266.6600n 0.000862 266.6700n 0.000885 266.6800n 0.000908 266.6900n 0.000931
+ 266.7000n 0.000954 266.7100n 0.000978 266.7200n 0.001003 266.7300n 0.001027 266.7400n 0.001052 266.7500n 0.001078 266.7600n 0.001103 266.7700n 0.001129 266.7800n 0.001155 266.7900n 0.001181 266.8000n 0.001207 266.8100n 0.001234 266.8200n 0.001260 266.8300n 0.001287 266.8400n 0.001314
+ 266.8500n 0.001341 266.8600n 0.001368 266.8700n 0.001395 266.8800n 0.001422 266.8900n 0.001448 266.9000n 0.001475 266.9100n 0.001502 266.9200n 0.001529 266.9300n 0.001555 266.9400n 0.001581 266.9500n 0.001608 266.9600n 0.001634 266.9700n 0.001659 266.9800n 0.001685 266.9900n 0.001710
+ 267.0000n 0.001735 267.0100n 0.001760 267.0200n 0.001784 267.0300n 0.001808 267.0400n 0.001831 267.0500n 0.001854 267.0600n 0.001877 267.0700n 0.001899 267.0800n 0.001921 267.0900n 0.001942 267.1000n 0.001962 267.1100n 0.001983 267.1200n 0.002002 267.1300n 0.002021 267.1400n 0.002039
+ 267.1500n 0.002057 267.1600n 0.002074 267.1700n 0.002090 267.1800n 0.002106 267.1900n 0.002121 267.2000n 0.002135 267.2100n 0.002149 267.2200n 0.002161 267.2300n 0.002173 267.2400n 0.002184 267.2500n 0.002195 267.2600n 0.002204 267.2700n 0.002213 267.2800n 0.002221 267.2900n 0.002228
+ 267.3000n 0.002234 267.3100n 0.002239 267.3200n 0.002243 267.3300n 0.002247 267.3400n 0.002249 267.3500n 0.002251 267.3600n 0.002252 267.3700n 0.002251 267.3800n 0.002250 267.3900n 0.002248 267.4000n 0.002245 267.4100n 0.002240 267.4200n 0.002235 267.4300n 0.002229 267.4400n 0.002222
+ 267.4500n 0.002214 267.4600n 0.002205 267.4700n 0.002195 267.4800n 0.002185 267.4900n 0.002173 267.5000n 0.002160 267.5100n 0.002146 267.5200n 0.002131 267.5300n 0.002115 267.5400n 0.002099 267.5500n 0.002081 267.5600n 0.002062 267.5700n 0.002043 267.5800n 0.002022 267.5900n 0.002001
+ 267.6000n 0.001979 267.6100n 0.001956 267.6200n 0.001931 267.6300n 0.001907 267.6400n 0.001881 267.6500n 0.001854 267.6600n 0.001826 267.6700n 0.001798 267.6800n 0.001769 267.6900n 0.001739 267.7000n 0.001708 267.7100n 0.001677 267.7200n 0.001644 267.7300n 0.001611 267.7400n 0.001578
+ 267.7500n 0.001543 267.7600n 0.001508 267.7700n 0.001472 267.7800n 0.001436 267.7900n 0.001399 267.8000n 0.001361 267.8100n 0.001323 267.8200n 0.001284 267.8300n 0.001245 267.8400n 0.001205 267.8500n 0.001165 267.8600n 0.001124 267.8700n 0.001083 267.8800n 0.001041 267.8900n 0.000999
+ 267.9000n 0.000957 267.9100n 0.000914 267.9200n 0.000871 267.9300n 0.000828 267.9400n 0.000784 267.9500n 0.000740 267.9600n 0.000696 267.9700n 0.000652 267.9800n 0.000607 267.9900n 0.000562 268.0000n 0.000518 268.0100n 0.000473 268.0200n 0.000428 268.0300n 0.000383 268.0400n 0.000338
+ 268.0500n 0.000293 268.0600n 0.000248 268.0700n 0.000203 268.0800n 0.000158 268.0900n 0.000113 268.1000n 0.000069 268.1100n 0.000024 268.1200n -0.000020 268.1300n -0.000064 268.1400n -0.000108 268.1500n -0.000151 268.1600n -0.000195 268.1700n -0.000238 268.1800n -0.000280 268.1900n -0.000323
+ 268.2000n -0.000364 268.2100n -0.000406 268.2200n -0.000447 268.2300n -0.000488 268.2400n -0.000528 268.2500n -0.000568 268.2600n -0.000607 268.2700n -0.000646 268.2800n -0.000684 268.2900n -0.000721 268.3000n -0.000758 268.3100n -0.000795 268.3200n -0.000831 268.3300n -0.000866 268.3400n -0.000900
+ 268.3500n -0.000934 268.3600n -0.000967 268.3700n -0.001000 268.3800n -0.001032 268.3900n -0.001063 268.4000n -0.001093 268.4100n -0.001122 268.4200n -0.001151 268.4300n -0.001179 268.4400n -0.001206 268.4500n -0.001233 268.4600n -0.001258 268.4700n -0.001283 268.4800n -0.001307 268.4900n -0.001330
+ 268.5000n -0.001353 268.5100n -0.001374 268.5200n -0.001395 268.5300n -0.001414 268.5400n -0.001433 268.5500n -0.001451 268.5600n -0.001468 268.5700n -0.001485 268.5800n -0.001500 268.5900n -0.001514 268.6000n -0.001528 268.6100n -0.001541 268.6200n -0.001553 268.6300n -0.001564 268.6400n -0.001574
+ 268.6500n -0.001583 268.6600n -0.001591 268.6700n -0.001599 268.6800n -0.001605 268.6900n -0.001611 268.7000n -0.001616 268.7100n -0.001620 268.7200n -0.001623 268.7300n -0.001625 268.7400n -0.001627 268.7500n -0.001628 268.7600n -0.001628 268.7700n -0.001627 268.7800n -0.001625 268.7900n -0.001623
+ 268.8000n -0.001619 268.8100n -0.001615 268.8200n -0.001611 268.8300n -0.001605 268.8400n -0.001599 268.8500n -0.001592 268.8600n -0.001584 268.8700n -0.001576 268.8800n -0.001567 268.8900n -0.001557 268.9000n -0.001547 268.9100n -0.001536 268.9200n -0.001524 268.9300n -0.001512 268.9400n -0.001500
+ 268.9500n -0.001486 268.9600n -0.001473 268.9700n -0.001458 268.9800n -0.001443 268.9900n -0.001428 269.0000n -0.001412 269.0100n -0.001396 269.0200n -0.001379 269.0300n -0.001362 269.0400n -0.001345 269.0500n -0.001327 269.0600n -0.001308 269.0700n -0.001290 269.0800n -0.001271 269.0900n -0.001251
+ 269.1000n -0.001232 269.1100n -0.001212 269.1200n -0.001192 269.1300n -0.001172 269.1400n -0.001151 269.1500n -0.001131 269.1600n -0.001110 269.1700n -0.001089 269.1800n -0.001067 269.1900n -0.001046 269.2000n -0.001025 269.2100n -0.001003 269.2200n -0.000982 269.2300n -0.000960 269.2400n -0.000939
+ 269.2500n -0.000917 269.2600n -0.000896 269.2700n -0.000874 269.2800n -0.000853 269.2900n -0.000831 269.3000n -0.000810 269.3100n -0.000789 269.3200n -0.000767 269.3300n -0.000746 269.3400n -0.000726 269.3500n -0.000705 269.3600n -0.000685 269.3700n -0.000664 269.3800n -0.000644 269.3900n -0.000624
+ 269.4000n -0.000605 269.4100n -0.000586 269.4200n -0.000566 269.4300n -0.000548 269.4400n -0.000529 269.4500n -0.000511 269.4600n -0.000493 269.4700n -0.000476 269.4800n -0.000459 269.4900n -0.000442 269.5000n -0.000425 269.5100n -0.000409 269.5200n -0.000394 269.5300n -0.000379 269.5400n -0.000364
+ 269.5500n -0.000349 269.5600n -0.000335 269.5700n -0.000322 269.5800n -0.000309 269.5900n -0.000296 269.6000n -0.000284 269.6100n -0.000272 269.6200n -0.000261 269.6300n -0.000250 269.6400n -0.000240 269.6500n -0.000230 269.6600n -0.000220 269.6700n -0.000211 269.6800n -0.000203 269.6900n -0.000195
+ 269.7000n -0.000188 269.7100n -0.000181 269.7200n -0.000175 269.7300n -0.000169 269.7400n -0.000163 269.7500n -0.000158 269.7600n -0.000154 269.7700n -0.000150 269.7800n -0.000147 269.7900n -0.000144 269.8000n -0.000142 269.8100n -0.000140 269.8200n -0.000138 269.8300n -0.000138 269.8400n -0.000137
+ 269.8500n -0.000137 269.8600n -0.000138 269.8700n -0.000139 269.8800n -0.000141 269.8900n -0.000143 269.9000n -0.000145 269.9100n -0.000148 269.9200n -0.000152 269.9300n -0.000156 269.9400n -0.000160 269.9500n -0.000165 269.9600n -0.000170 269.9700n -0.000176 269.9800n -0.000182 269.9900n -0.000188
+ 270.0000n -0.000195 270.0100n -0.000202 270.0200n -0.000210 270.0300n -0.000218 270.0400n -0.000226 270.0500n -0.000235 270.0600n -0.000244 270.0700n -0.000254 270.0800n -0.000264 270.0900n -0.000274 270.1000n -0.000284 270.1100n -0.000295 270.1200n -0.000306 270.1300n -0.000318 270.1400n -0.000329
+ 270.1500n -0.000341 270.1600n -0.000354 270.1700n -0.000366 270.1800n -0.000379 270.1900n -0.000392 270.2000n -0.000405 270.2100n -0.000419 270.2200n -0.000432 270.2300n -0.000446 270.2400n -0.000460 270.2500n -0.000474 270.2600n -0.000489 270.2700n -0.000503 270.2800n -0.000518 270.2900n -0.000533
+ 270.3000n -0.000548 270.3100n -0.000563 270.3200n -0.000578 270.3300n -0.000594 270.3400n -0.000609 270.3500n -0.000625 270.3600n -0.000640 270.3700n -0.000656 270.3800n -0.000672 270.3900n -0.000688 270.4000n -0.000704 270.4100n -0.000719 270.4200n -0.000735 270.4300n -0.000751 270.4400n -0.000767
+ 270.4500n -0.000783 270.4600n -0.000799 270.4700n -0.000815 270.4800n -0.000831 270.4900n -0.000847 270.5000n -0.000863 270.5100n -0.000879 270.5200n -0.000895 270.5300n -0.000910 270.5400n -0.000926 270.5500n -0.000942 270.5600n -0.000957 270.5700n -0.000973 270.5800n -0.000988 270.5900n -0.001004
+ 270.6000n -0.001019 270.6100n -0.001034 270.6200n -0.001049 270.6300n -0.001064 270.6400n -0.001079 270.6500n -0.001094 270.6600n -0.001108 270.6700n -0.001123 270.6800n -0.001137 270.6900n -0.001151 270.7000n -0.001165 270.7100n -0.001179 270.7200n -0.001193 270.7300n -0.001207 270.7400n -0.001220
+ 270.7500n -0.001234 270.7600n -0.001247 270.7700n -0.001260 270.7800n -0.001273 270.7900n -0.001285 270.8000n -0.001298 270.8100n -0.001310 270.8200n -0.001323 270.8300n -0.001335 270.8400n -0.001347 270.8500n -0.001358 270.8600n -0.001370 270.8700n -0.001381 270.8800n -0.001392 270.8900n -0.001403
+ 270.9000n -0.001414 270.9100n -0.001425 270.9200n -0.001435 270.9300n -0.001446 270.9400n -0.001456 270.9500n -0.001466 270.9600n -0.001475 270.9700n -0.001485 270.9800n -0.001494 270.9900n -0.001503 271.0000n -0.001512 271.0100n -0.001521 271.0200n -0.001530 271.0300n -0.001538 271.0400n -0.001546
+ 271.0500n -0.001554 271.0600n -0.001562 271.0700n -0.001570 271.0800n -0.001577 271.0900n -0.001585 271.1000n -0.001592 271.1100n -0.001599 271.1200n -0.001605 271.1300n -0.001612 271.1400n -0.001618 271.1500n -0.001624 271.1600n -0.001630 271.1700n -0.001636 271.1800n -0.001641 271.1900n -0.001646
+ 271.2000n -0.001651 271.2100n -0.001656 271.2200n -0.001661 271.2300n -0.001665 271.2400n -0.001670 271.2500n -0.001674 271.2600n -0.001678 271.2700n -0.001681 271.2800n -0.001685 271.2900n -0.001688 271.3000n -0.001691 271.3100n -0.001694 271.3200n -0.001696 271.3300n -0.001699 271.3400n -0.001701
+ 271.3500n -0.001703 271.3600n -0.001704 271.3700n -0.001706 271.3800n -0.001707 271.3900n -0.001708 271.4000n -0.001709 271.4100n -0.001709 271.4200n -0.001710 271.4300n -0.001710 271.4400n -0.001710 271.4500n -0.001709 271.4600n -0.001709 271.4700n -0.001708 271.4800n -0.001707 271.4900n -0.001705
+ 271.5000n -0.001704 271.5100n -0.001702 271.5200n -0.001700 271.5300n -0.001697 271.5400n -0.001695 271.5500n -0.001692 271.5600n -0.001688 271.5700n -0.001685 271.5800n -0.001681 271.5900n -0.001677 271.6000n -0.001673 271.6100n -0.001668 271.6200n -0.001663 271.6300n -0.001658 271.6400n -0.001653
+ 271.6500n -0.001647 271.6600n -0.001641 271.6700n -0.001634 271.6800n -0.001628 271.6900n -0.001621 271.7000n -0.001614 271.7100n -0.001606 271.7200n -0.001598 271.7300n -0.001590 271.7400n -0.001581 271.7500n -0.001573 271.7600n -0.001563 271.7700n -0.001554 271.7800n -0.001544 271.7900n -0.001534
+ 271.8000n -0.001523 271.8100n -0.001513 271.8200n -0.001502 271.8300n -0.001490 271.8400n -0.001478 271.8500n -0.001466 271.8600n -0.001454 271.8700n -0.001441 271.8800n -0.001428 271.8900n -0.001414 271.9000n -0.001401 271.9100n -0.001386 271.9200n -0.001372 271.9300n -0.001357 271.9400n -0.001342
+ 271.9500n -0.001327 271.9600n -0.001311 271.9700n -0.001295 271.9800n -0.001278 271.9900n -0.001261 272.0000n -0.001244 272.0100n -0.001227 272.0200n -0.001209 272.0300n -0.001191 272.0400n -0.001172 272.0500n -0.001154 272.0600n -0.001135 272.0700n -0.001115 272.0800n -0.001096 272.0900n -0.001076
+ 272.1000n -0.001055 272.1100n -0.001035 272.1200n -0.001014 272.1300n -0.000993 272.1400n -0.000972 272.1500n -0.000950 272.1600n -0.000928 272.1700n -0.000906 272.1800n -0.000883 272.1900n -0.000861 272.2000n -0.000838 272.2100n -0.000815 272.2200n -0.000791 272.2300n -0.000768 272.2400n -0.000744
+ 272.2500n -0.000720 272.2600n -0.000696 272.2700n -0.000671 272.2800n -0.000647 272.2900n -0.000622 272.3000n -0.000597 272.3100n -0.000572 272.3200n -0.000547 272.3300n -0.000521 272.3400n -0.000496 272.3500n -0.000470 272.3600n -0.000445 272.3700n -0.000419 272.3800n -0.000393 272.3900n -0.000367
+ 272.4000n -0.000341 272.4100n -0.000316 272.4200n -0.000290 272.4300n -0.000264 272.4400n -0.000238 272.4500n -0.000212 272.4600n -0.000186 272.4700n -0.000160 272.4800n -0.000134 272.4900n -0.000108 272.5000n -0.000082 272.5100n -0.000057 272.5200n -0.000031 272.5300n -0.000006 272.5400n 0.000020
+ 272.5500n 0.000045 272.5600n 0.000070 272.5700n 0.000095 272.5800n 0.000120 272.5900n 0.000144 272.6000n 0.000168 272.6100n 0.000192 272.6200n 0.000216 272.6300n 0.000240 272.6400n 0.000263 272.6500n 0.000286 272.6600n 0.000309 272.6700n 0.000331 272.6800n 0.000353 272.6900n 0.000375
+ 272.7000n 0.000397 272.7100n 0.000418 272.7200n 0.000439 272.7300n 0.000459 272.7400n 0.000479 272.7500n 0.000498 272.7600n 0.000517 272.7700n 0.000536 272.7800n 0.000554 272.7900n 0.000572 272.8000n 0.000589 272.8100n 0.000606 272.8200n 0.000623 272.8300n 0.000638 272.8400n 0.000654
+ 272.8500n 0.000669 272.8600n 0.000683 272.8700n 0.000697 272.8800n 0.000710 272.8900n 0.000722 272.9000n 0.000734 272.9100n 0.000746 272.9200n 0.000757 272.9300n 0.000767 272.9400n 0.000776 272.9500n 0.000785 272.9600n 0.000794 272.9700n 0.000802 272.9800n 0.000809 272.9900n 0.000815
+ 273.0000n 0.000821 273.0100n 0.000826 273.0200n 0.000831 273.0300n 0.000835 273.0400n 0.000838 273.0500n 0.000841 273.0600n 0.000843 273.0700n 0.000844 273.0800n 0.000844 273.0900n 0.000844 273.1000n 0.000843 273.1100n 0.000842 273.1200n 0.000840 273.1300n 0.000837 273.1400n 0.000834
+ 273.1500n 0.000829 273.1600n 0.000825 273.1700n 0.000819 273.1800n 0.000813 273.1900n 0.000806 273.2000n 0.000799 273.2100n 0.000790 273.2200n 0.000782 273.2300n 0.000772 273.2400n 0.000762 273.2500n 0.000751 273.2600n 0.000740 273.2700n 0.000728 273.2800n 0.000716 273.2900n 0.000702
+ 273.3000n 0.000689 273.3100n 0.000674 273.3200n 0.000659 273.3300n 0.000644 273.3400n 0.000628 273.3500n 0.000611 273.3600n 0.000594 273.3700n 0.000577 273.3800n 0.000559 273.3900n 0.000540 273.4000n 0.000521 273.4100n 0.000501 273.4200n 0.000481 273.4300n 0.000461 273.4400n 0.000440
+ 273.4500n 0.000419 273.4600n 0.000397 273.4700n 0.000375 273.4800n 0.000352 273.4900n 0.000330 273.5000n 0.000307 273.5100n 0.000283 273.5200n 0.000259 273.5300n 0.000235 273.5400n 0.000211 273.5500n 0.000187 273.5600n 0.000162 273.5700n 0.000137 273.5800n 0.000112 273.5900n 0.000087
+ 273.6000n 0.000061 273.6100n 0.000036 273.6200n 0.000010 273.6300n -0.000016 273.6400n -0.000042 273.6500n -0.000067 273.6600n -0.000093 273.6700n -0.000119 273.6800n -0.000145 273.6900n -0.000171 273.7000n -0.000197 273.7100n -0.000222 273.7200n -0.000248 273.7300n -0.000274 273.7400n -0.000299
+ 273.7500n -0.000324 273.7600n -0.000349 273.7700n -0.000374 273.7800n -0.000399 273.7900n -0.000423 273.8000n -0.000448 273.8100n -0.000472 273.8200n -0.000495 273.8300n -0.000518 273.8400n -0.000541 273.8500n -0.000564 273.8600n -0.000586 273.8700n -0.000608 273.8800n -0.000630 273.8900n -0.000651
+ 273.9000n -0.000672 273.9100n -0.000692 273.9200n -0.000712 273.9300n -0.000731 273.9400n -0.000750 273.9500n -0.000768 273.9600n -0.000786 273.9700n -0.000803 273.9800n -0.000819 273.9900n -0.000835 274.0000n -0.000851 274.0100n -0.000866 274.0200n -0.000880 274.0300n -0.000893 274.0400n -0.000906
+ 274.0500n -0.000919 274.0600n -0.000930 274.0700n -0.000941 274.0800n -0.000952 274.0900n -0.000961 274.1000n -0.000970 274.1100n -0.000978 274.1200n -0.000986 274.1300n -0.000993 274.1400n -0.000999 274.1500n -0.001004 274.1600n -0.001009 274.1700n -0.001013 274.1800n -0.001016 274.1900n -0.001018
+ 274.2000n -0.001020 274.2100n -0.001021 274.2200n -0.001021 274.2300n -0.001020 274.2400n -0.001019 274.2500n -0.001017 274.2600n -0.001014 274.2700n -0.001010 274.2800n -0.001006 274.2900n -0.001001 274.3000n -0.000995 274.3100n -0.000988 274.3200n -0.000981 274.3300n -0.000973 274.3400n -0.000964
+ 274.3500n -0.000955 274.3600n -0.000945 274.3700n -0.000934 274.3800n -0.000922 274.3900n -0.000910 274.4000n -0.000897 274.4100n -0.000883 274.4200n -0.000869 274.4300n -0.000854 274.4400n -0.000839 274.4500n -0.000823 274.4600n -0.000806 274.4700n -0.000789 274.4800n -0.000771 274.4900n -0.000753
+ 274.5000n -0.000734 274.5100n -0.000714 274.5200n -0.000694 274.5300n -0.000674 274.5400n -0.000653 274.5500n -0.000632 274.5600n -0.000610 274.5700n -0.000587 274.5800n -0.000565 274.5900n -0.000542 274.6000n -0.000518 274.6100n -0.000495 274.6200n -0.000471 274.6300n -0.000446 274.6400n -0.000422
+ 274.6500n -0.000397 274.6600n -0.000372 274.6700n -0.000346 274.6800n -0.000321 274.6900n -0.000295 274.7000n -0.000269 274.7100n -0.000243 274.7200n -0.000217 274.7300n -0.000191 274.7400n -0.000165 274.7500n -0.000138 274.7600n -0.000112 274.7700n -0.000086 274.7800n -0.000060 274.7900n -0.000034
+ 274.8000n -0.000007 274.8100n 0.000019 274.8200n 0.000044 274.8300n 0.000070 274.8400n 0.000096 274.8500n 0.000121 274.8600n 0.000146 274.8700n 0.000171 274.8800n 0.000196 274.8900n 0.000220 274.9000n 0.000244 274.9100n 0.000268 274.9200n 0.000291 274.9300n 0.000314 274.9400n 0.000336
+ 274.9500n 0.000358 274.9600n 0.000380 274.9700n 0.000401 274.9800n 0.000422 274.9900n 0.000442 275.0000n 0.000462 275.0100n 0.000481 275.0200n 0.000500 275.0300n 0.000518 275.0400n 0.000535 275.0500n 0.000552 275.0600n 0.000568 275.0700n 0.000583 275.0800n 0.000598 275.0900n 0.000612
+ 275.1000n 0.000626 275.1100n 0.000639 275.1200n 0.000651 275.1300n 0.000662 275.1400n 0.000672 275.1500n 0.000682 275.1600n 0.000691 275.1700n 0.000699 275.1800n 0.000707 275.1900n 0.000713 275.2000n 0.000719 275.2100n 0.000724 275.2200n 0.000728 275.2300n 0.000732 275.2400n 0.000734
+ 275.2500n 0.000736 275.2600n 0.000736 275.2700n 0.000736 275.2800n 0.000735 275.2900n 0.000733 275.3000n 0.000731 275.3100n 0.000727 275.3200n 0.000722 275.3300n 0.000717 275.3400n 0.000711 275.3500n 0.000703 275.3600n 0.000695 275.3700n 0.000687 275.3800n 0.000677 275.3900n 0.000666
+ 275.4000n 0.000655 275.4100n 0.000642 275.4200n 0.000629 275.4300n 0.000615 275.4400n 0.000600 275.4500n 0.000584 275.4600n 0.000567 275.4700n 0.000550 275.4800n 0.000532 275.4900n 0.000513 275.5000n 0.000493 275.5100n 0.000472 275.5200n 0.000451 275.5300n 0.000429 275.5400n 0.000406
+ 275.5500n 0.000382 275.5600n 0.000358 275.5700n 0.000333 275.5800n 0.000307 275.5900n 0.000281 275.6000n 0.000254 275.6100n 0.000226 275.6200n 0.000198 275.6300n 0.000169 275.6400n 0.000140 275.6500n 0.000110 275.6600n 0.000079 275.6700n 0.000048 275.6800n 0.000017 275.6900n -0.000015
+ 275.7000n -0.000048 275.7100n -0.000081 275.7200n -0.000114 275.7300n -0.000148 275.7400n -0.000182 275.7500n -0.000216 275.7600n -0.000251 275.7700n -0.000286 275.7800n -0.000321 275.7900n -0.000357 275.8000n -0.000393 275.8100n -0.000429 275.8200n -0.000465 275.8300n -0.000502 275.8400n -0.000538
+ 275.8500n -0.000575 275.8600n -0.000612 275.8700n -0.000649 275.8800n -0.000686 275.8900n -0.000722 275.9000n -0.000759 275.9100n -0.000796 275.9200n -0.000833 275.9300n -0.000870 275.9400n -0.000907 275.9500n -0.000943 275.9600n -0.000979 275.9700n -0.001016 275.9800n -0.001052 275.9900n -0.001087
+ 276.0000n -0.001123 276.0100n -0.001158 276.0200n -0.001193 276.0300n -0.001228 276.0400n -0.001262 276.0500n -0.001296 276.0600n -0.001330 276.0700n -0.001363 276.0800n -0.001396 276.0900n -0.001429 276.1000n -0.001461 276.1100n -0.001492 276.1200n -0.001523 276.1300n -0.001554 276.1400n -0.001583
+ 276.1500n -0.001613 276.1600n -0.001642 276.1700n -0.001670 276.1800n -0.001698 276.1900n -0.001725 276.2000n -0.001751 276.2100n -0.001777 276.2200n -0.001802 276.2300n -0.001826 276.2400n -0.001850 276.2500n -0.001873 276.2600n -0.001896 276.2700n -0.001917 276.2800n -0.001938 276.2900n -0.001958
+ 276.3000n -0.001978 276.3100n -0.001997 276.3200n -0.002015 276.3300n -0.002032 276.3400n -0.002048 276.3500n -0.002064 276.3600n -0.002078 276.3700n -0.002092 276.3800n -0.002106 276.3900n -0.002118 276.4000n -0.002130 276.4100n -0.002141 276.4200n -0.002151 276.4300n -0.002160 276.4400n -0.002168
+ 276.4500n -0.002176 276.4600n -0.002183 276.4700n -0.002189 276.4800n -0.002194 276.4900n -0.002198 276.5000n -0.002202 276.5100n -0.002205 276.5200n -0.002207 276.5300n -0.002208 276.5400n -0.002208 276.5500n -0.002208 276.5600n -0.002207 276.5700n -0.002205 276.5800n -0.002203 276.5900n -0.002199
+ 276.6000n -0.002195 276.6100n -0.002191 276.6200n -0.002185 276.6300n -0.002179 276.6400n -0.002172 276.6500n -0.002165 276.6600n -0.002157 276.6700n -0.002148 276.6800n -0.002139 276.6900n -0.002129 276.7000n -0.002119 276.7100n -0.002108 276.7200n -0.002096 276.7300n -0.002084 276.7400n -0.002071
+ 276.7500n -0.002058 276.7600n -0.002044 276.7700n -0.002030 276.7800n -0.002015 276.7900n -0.002000 276.8000n -0.001985 276.8100n -0.001969 276.8200n -0.001953 276.8300n -0.001936 276.8400n -0.001919 276.8500n -0.001902 276.8600n -0.001884 276.8700n -0.001866 276.8800n -0.001848 276.8900n -0.001830
+ 276.9000n -0.001811 276.9100n -0.001792 276.9200n -0.001773 276.9300n -0.001754 276.9400n -0.001735 276.9500n -0.001716 276.9600n -0.001696 276.9700n -0.001677 276.9800n -0.001657 276.9900n -0.001637 277.0000n -0.001618 277.0100n -0.001598 277.0200n -0.001578 277.0300n -0.001559 277.0400n -0.001539
+ 277.0500n -0.001520 277.0600n -0.001500 277.0700n -0.001481 277.0800n -0.001462 277.0900n -0.001443 277.1000n -0.001424 277.1100n -0.001406 277.1200n -0.001388 277.1300n -0.001369 277.1400n -0.001352 277.1500n -0.001334 277.1600n -0.001317 277.1700n -0.001300 277.1800n -0.001283 277.1900n -0.001267
+ 277.2000n -0.001251 277.2100n -0.001235 277.2200n -0.001220 277.2300n -0.001205 277.2400n -0.001190 277.2500n -0.001176 277.2600n -0.001163 277.2700n -0.001150 277.2800n -0.001137 277.2900n -0.001124 277.3000n -0.001113 277.3100n -0.001101 277.3200n -0.001090 277.3300n -0.001080 277.3400n -0.001070
+ 277.3500n -0.001061 277.3600n -0.001052 277.3700n -0.001043 277.3800n -0.001036 277.3900n -0.001028 277.4000n -0.001022 277.4100n -0.001015 277.4200n -0.001010 277.4300n -0.001005 277.4400n -0.001000 277.4500n -0.000996 277.4600n -0.000993 277.4700n -0.000990 277.4800n -0.000987 277.4900n -0.000985
+ 277.5000n -0.000984 277.5100n -0.000983 277.5200n -0.000983 277.5300n -0.000983 277.5400n -0.000984 277.5500n -0.000986 277.5600n -0.000987 277.5700n -0.000990 277.5800n -0.000993 277.5900n -0.000996 277.6000n -0.001000 277.6100n -0.001004 277.6200n -0.001009 277.6300n -0.001015 277.6400n -0.001021
+ 277.6500n -0.001027 277.6600n -0.001033 277.6700n -0.001041 277.6800n -0.001048 277.6900n -0.001056 277.7000n -0.001064 277.7100n -0.001073 277.7200n -0.001082 277.7300n -0.001092 277.7400n -0.001101 277.7500n -0.001111 277.7600n -0.001122 277.7700n -0.001132 277.7800n -0.001143 277.7900n -0.001155
+ 277.8000n -0.001166 277.8100n -0.001178 277.8200n -0.001190 277.8300n -0.001202 277.8400n -0.001214 277.8500n -0.001227 277.8600n -0.001239 277.8700n -0.001252 277.8800n -0.001265 277.8900n -0.001278 277.9000n -0.001291 277.9100n -0.001304 277.9200n -0.001317 277.9300n -0.001330 277.9400n -0.001343
+ 277.9500n -0.001356 277.9600n -0.001369 277.9700n -0.001382 277.9800n -0.001395 277.9900n -0.001408 278.0000n -0.001420 278.0100n -0.001433 278.0200n -0.001445 278.0300n -0.001457 278.0400n -0.001470 278.0500n -0.001481 278.0600n -0.001493 278.0700n -0.001504 278.0800n -0.001516 278.0900n -0.001526
+ 278.1000n -0.001537 278.1100n -0.001547 278.1200n -0.001557 278.1300n -0.001567 278.1400n -0.001576 278.1500n -0.001585 278.1600n -0.001593 278.1700n -0.001601 278.1800n -0.001609 278.1900n -0.001616 278.2000n -0.001623 278.2100n -0.001629 278.2200n -0.001635 278.2300n -0.001640 278.2400n -0.001645
+ 278.2500n -0.001650 278.2600n -0.001653 278.2700n -0.001657 278.2800n -0.001659 278.2900n -0.001662 278.3000n -0.001663 278.3100n -0.001664 278.3200n -0.001665 278.3300n -0.001665 278.3400n -0.001664 278.3500n -0.001663 278.3600n -0.001661 278.3700n -0.001658 278.3800n -0.001655 278.3900n -0.001651
+ 278.4000n -0.001647 278.4100n -0.001642 278.4200n -0.001636 278.4300n -0.001630 278.4400n -0.001623 278.4500n -0.001616 278.4600n -0.001607 278.4700n -0.001598 278.4800n -0.001589 278.4900n -0.001579 278.5000n -0.001568 278.5100n -0.001557 278.5200n -0.001545 278.5300n -0.001532 278.5400n -0.001519
+ 278.5500n -0.001505 278.5600n -0.001490 278.5700n -0.001475 278.5800n -0.001459 278.5900n -0.001443 278.6000n -0.001426 278.6100n -0.001408 278.6200n -0.001390 278.6300n -0.001372 278.6400n -0.001352 278.6500n -0.001333 278.6600n -0.001312 278.6700n -0.001291 278.6800n -0.001270 278.6900n -0.001248
+ 278.7000n -0.001226 278.7100n -0.001203 278.7200n -0.001180 278.7300n -0.001156 278.7400n -0.001132 278.7500n -0.001107 278.7600n -0.001082 278.7700n -0.001057 278.7800n -0.001031 278.7900n -0.001005 278.8000n -0.000979 278.8100n -0.000952 278.8200n -0.000925 278.8300n -0.000897 278.8400n -0.000870
+ 278.8500n -0.000842 278.8600n -0.000813 278.8700n -0.000785 278.8800n -0.000756 278.8900n -0.000727 278.9000n -0.000698 278.9100n -0.000669 278.9200n -0.000640 278.9300n -0.000611 278.9400n -0.000581 278.9500n -0.000552 278.9600n -0.000522 278.9700n -0.000492 278.9800n -0.000463 278.9900n -0.000433
+ 279.0000n -0.000404 279.0100n -0.000374 279.0200n -0.000344 279.0300n -0.000315 279.0400n -0.000286 279.0500n -0.000256 279.0600n -0.000227 279.0700n -0.000198 279.0800n -0.000170 279.0900n -0.000141 279.1000n -0.000113 279.1100n -0.000085 279.1200n -0.000057 279.1300n -0.000029 279.1400n -0.000002
+ 279.1500n 0.000025 279.1600n 0.000052 279.1700n 0.000078 279.1800n 0.000104 279.1900n 0.000129 279.2000n 0.000155 279.2100n 0.000180 279.2200n 0.000204 279.2300n 0.000228 279.2400n 0.000251 279.2500n 0.000274 279.2600n 0.000297 279.2700n 0.000319 279.2800n 0.000341 279.2900n 0.000362
+ 279.3000n 0.000382 279.3100n 0.000402 279.3200n 0.000422 279.3300n 0.000440 279.3400n 0.000459 279.3500n 0.000476 279.3600n 0.000494 279.3700n 0.000510 279.3800n 0.000526 279.3900n 0.000541 279.4000n 0.000556 279.4100n 0.000570 279.4200n 0.000583 279.4300n 0.000596 279.4400n 0.000608
+ 279.4500n 0.000620 279.4600n 0.000630 279.4700n 0.000640 279.4800n 0.000650 279.4900n 0.000659 279.5000n 0.000667 279.5100n 0.000674 279.5200n 0.000681 279.5300n 0.000687 279.5400n 0.000692 279.5500n 0.000697 279.5600n 0.000701 279.5700n 0.000705 279.5800n 0.000707 279.5900n 0.000709
+ 279.6000n 0.000711 279.6100n 0.000711 279.6200n 0.000711 279.6300n 0.000711 279.6400n 0.000710 279.6500n 0.000708 279.6600n 0.000705 279.6700n 0.000702 279.6800n 0.000698 279.6900n 0.000694 279.7000n 0.000689 279.7100n 0.000684 279.7200n 0.000678 279.7300n 0.000671 279.7400n 0.000664
+ 279.7500n 0.000656 279.7600n 0.000647 279.7700n 0.000639 279.7800n 0.000629 279.7900n 0.000619 279.8000n 0.000609 279.8100n 0.000598 279.8200n 0.000587 279.8300n 0.000575 279.8400n 0.000563 279.8500n 0.000550 279.8600n 0.000537 279.8700n 0.000523 279.8800n 0.000509 279.8900n 0.000495
+ 279.9000n 0.000480 279.9100n 0.000466 279.9200n 0.000450 279.9300n 0.000435 279.9400n 0.000419 279.9500n 0.000403 279.9600n 0.000386 279.9700n 0.000370 279.9800n 0.000353 279.9900n 0.000336 280.0000n 0.000318 280.0100n 0.000301 280.0200n 0.000283 280.0300n 0.000266 280.0400n 0.000248
+ 280.0500n 0.000230 280.0600n 0.000212 280.0700n 0.000194 280.0800n 0.000175 280.0900n 0.000157 280.1000n 0.000139 280.1100n 0.000121 280.1200n 0.000102 280.1300n 0.000084 280.1400n 0.000066 280.1500n 0.000048 280.1600n 0.000030 280.1700n 0.000012 280.1800n -0.000006 280.1900n -0.000024
+ 280.2000n -0.000041 280.2100n -0.000059 280.2200n -0.000076 280.2300n -0.000093 280.2400n -0.000110 280.2500n -0.000127 280.2600n -0.000143 280.2700n -0.000160 280.2800n -0.000176 280.2900n -0.000191 280.3000n -0.000207 280.3100n -0.000222 280.3200n -0.000237 280.3300n -0.000252 280.3400n -0.000266
+ 280.3500n -0.000280 280.3600n -0.000293 280.3700n -0.000307 280.3800n -0.000320 280.3900n -0.000332 280.4000n -0.000344 280.4100n -0.000356 280.4200n -0.000368 280.4300n -0.000379 280.4400n -0.000389 280.4500n -0.000399 280.4600n -0.000409 280.4700n -0.000418 280.4800n -0.000427 280.4900n -0.000436
+ 280.5000n -0.000444 280.5100n -0.000451 280.5200n -0.000459 280.5300n -0.000465 280.5400n -0.000472 280.5500n -0.000477 280.5600n -0.000483 280.5700n -0.000488 280.5800n -0.000492 280.5900n -0.000496 280.6000n -0.000500 280.6100n -0.000503 280.6200n -0.000505 280.6300n -0.000507 280.6400n -0.000509
+ 280.6500n -0.000510 280.6600n -0.000511 280.6700n -0.000512 280.6800n -0.000511 280.6900n -0.000511 280.7000n -0.000510 280.7100n -0.000509 280.7200n -0.000507 280.7300n -0.000505 280.7400n -0.000502 280.7500n -0.000499 280.7600n -0.000496 280.7700n -0.000492 280.7800n -0.000488 280.7900n -0.000483
+ 280.8000n -0.000478 280.8100n -0.000473 280.8200n -0.000467 280.8300n -0.000461 280.8400n -0.000455 280.8500n -0.000448 280.8600n -0.000441 280.8700n -0.000434 280.8800n -0.000426 280.8900n -0.000418 280.9000n -0.000410 280.9100n -0.000402 280.9200n -0.000393 280.9300n -0.000384 280.9400n -0.000375
+ 280.9500n -0.000365 280.9600n -0.000356 280.9700n -0.000346 280.9800n -0.000336 280.9900n -0.000325 281.0000n -0.000315 281.0100n -0.000304 281.0200n -0.000294 281.0300n -0.000283 281.0400n -0.000272 281.0500n -0.000261 281.0600n -0.000249 281.0700n -0.000238 281.0800n -0.000226 281.0900n -0.000215
+ 281.1000n -0.000203 281.1100n -0.000192 281.1200n -0.000180 281.1300n -0.000168 281.1400n -0.000157 281.1500n -0.000145 281.1600n -0.000133 281.1700n -0.000121 281.1800n -0.000110 281.1900n -0.000098 281.2000n -0.000086 281.2100n -0.000075 281.2200n -0.000063 281.2300n -0.000052 281.2400n -0.000040
+ 281.2500n -0.000029 281.2600n -0.000017 281.2700n -0.000006 281.2800n 0.000005 281.2900n 0.000016 281.3000n 0.000027 281.3100n 0.000037 281.3200n 0.000048 281.3300n 0.000058 281.3400n 0.000069 281.3500n 0.000079 281.3600n 0.000089 281.3700n 0.000098 281.3800n 0.000108 281.3900n 0.000118
+ 281.4000n 0.000127 281.4100n 0.000136 281.4200n 0.000145 281.4300n 0.000154 281.4400n 0.000162 281.4500n 0.000171 281.4600n 0.000179 281.4700n 0.000187 281.4800n 0.000195 281.4900n 0.000202 281.5000n 0.000210 281.5100n 0.000217 281.5200n 0.000224 281.5300n 0.000231 281.5400n 0.000237
+ 281.5500n 0.000244 281.5600n 0.000250 281.5700n 0.000256 281.5800n 0.000262 281.5900n 0.000267 281.6000n 0.000273 281.6100n 0.000278 281.6200n 0.000283 281.6300n 0.000288 281.6400n 0.000293 281.6500n 0.000297 281.6600n 0.000302 281.6700n 0.000306 281.6800n 0.000310 281.6900n 0.000314
+ 281.7000n 0.000318 281.7100n 0.000322 281.7200n 0.000325 281.7300n 0.000328 281.7400n 0.000332 281.7500n 0.000335 281.7600n 0.000338 281.7700n 0.000341 281.7800n 0.000344 281.7900n 0.000346 281.8000n 0.000349 281.8100n 0.000352 281.8200n 0.000354 281.8300n 0.000357 281.8400n 0.000359
+ 281.8500n 0.000361 281.8600n 0.000364 281.8700n 0.000366 281.8800n 0.000368 281.8900n 0.000371 281.9000n 0.000373 281.9100n 0.000375 281.9200n 0.000378 281.9300n 0.000380 281.9400n 0.000382 281.9500n 0.000385 281.9600n 0.000387 281.9700n 0.000390 281.9800n 0.000392 281.9900n 0.000395
+ 282.0000n 0.000398 282.0100n 0.000400 282.0200n 0.000403 282.0300n 0.000406 282.0400n 0.000409 282.0500n 0.000413 282.0600n 0.000416 282.0700n 0.000420 282.0800n 0.000423 282.0900n 0.000427 282.1000n 0.000431 282.1100n 0.000435 282.1200n 0.000439 282.1300n 0.000444 282.1400n 0.000448
+ 282.1500n 0.000453 282.1600n 0.000458 282.1700n 0.000463 282.1800n 0.000469 282.1900n 0.000474 282.2000n 0.000480 282.2100n 0.000486 282.2200n 0.000492 282.2300n 0.000499 282.2400n 0.000505 282.2500n 0.000512 282.2600n 0.000519 282.2700n 0.000526 282.2800n 0.000534 282.2900n 0.000542
+ 282.3000n 0.000550 282.3100n 0.000558 282.3200n 0.000566 282.3300n 0.000575 282.3400n 0.000584 282.3500n 0.000593 282.3600n 0.000602 282.3700n 0.000612 282.3800n 0.000622 282.3900n 0.000632 282.4000n 0.000642 282.4100n 0.000652 282.4200n 0.000663 282.4300n 0.000674 282.4400n 0.000685
+ 282.4500n 0.000696 282.4600n 0.000707 282.4700n 0.000719 282.4800n 0.000730 282.4900n 0.000742 282.5000n 0.000754 282.5100n 0.000767 282.5200n 0.000779 282.5300n 0.000791 282.5400n 0.000804 282.5500n 0.000817 282.5600n 0.000830 282.5700n 0.000843 282.5800n 0.000856 282.5900n 0.000869
+ 282.6000n 0.000882 282.6100n 0.000895 282.6200n 0.000908 282.6300n 0.000922 282.6400n 0.000935 282.6500n 0.000948 282.6600n 0.000962 282.6700n 0.000975 282.6800n 0.000988 282.6900n 0.001002 282.7000n 0.001015 282.7100n 0.001028 282.7200n 0.001041 282.7300n 0.001054 282.7400n 0.001067
+ 282.7500n 0.001080 282.7600n 0.001092 282.7700n 0.001105 282.7800n 0.001117 282.7900n 0.001129 282.8000n 0.001141 282.8100n 0.001153 282.8200n 0.001165 282.8300n 0.001176 282.8400n 0.001187 282.8500n 0.001198 282.8600n 0.001208 282.8700n 0.001218 282.8800n 0.001228 282.8900n 0.001238
+ 282.9000n 0.001247 282.9100n 0.001256 282.9200n 0.001264 282.9300n 0.001272 282.9400n 0.001280 282.9500n 0.001287 282.9600n 0.001294 282.9700n 0.001300 282.9800n 0.001306 282.9900n 0.001312 283.0000n 0.001317 283.0100n 0.001321 283.0200n 0.001325 283.0300n 0.001329 283.0400n 0.001332
+ 283.0500n 0.001334 283.0600n 0.001336 283.0700n 0.001337 283.0800n 0.001338 283.0900n 0.001338 283.1000n 0.001338 283.1100n 0.001337 283.1200n 0.001335 283.1300n 0.001333 283.1400n 0.001330 283.1500n 0.001326 283.1600n 0.001322 283.1700n 0.001317 283.1800n 0.001311 283.1900n 0.001305
+ 283.2000n 0.001298 283.2100n 0.001290 283.2200n 0.001282 283.2300n 0.001273 283.2400n 0.001263 283.2500n 0.001253 283.2600n 0.001242 283.2700n 0.001230 283.2800n 0.001217 283.2900n 0.001204 283.3000n 0.001190 283.3100n 0.001175 283.3200n 0.001160 283.3300n 0.001144 283.3400n 0.001127
+ 283.3500n 0.001109 283.3600n 0.001091 283.3700n 0.001072 283.3800n 0.001053 283.3900n 0.001032 283.4000n 0.001011 283.4100n 0.000990 283.4200n 0.000967 283.4300n 0.000944 283.4400n 0.000921 283.4500n 0.000896 283.4600n 0.000871 283.4700n 0.000846 283.4800n 0.000819 283.4900n 0.000793
+ 283.5000n 0.000765 283.5100n 0.000737 283.5200n 0.000708 283.5300n 0.000679 283.5400n 0.000649 283.5500n 0.000619 283.5600n 0.000588 283.5700n 0.000557 283.5800n 0.000525 283.5900n 0.000493 283.6000n 0.000460 283.6100n 0.000427 283.6200n 0.000393 283.6300n 0.000359 283.6400n 0.000325
+ 283.6500n 0.000290 283.6600n 0.000255 283.6700n 0.000219 283.6800n 0.000183 283.6900n 0.000147 283.7000n 0.000111 283.7100n 0.000074 283.7200n 0.000037 283.7300n 0.000000 283.7400n -0.000037 283.7500n -0.000074 283.7600n -0.000112 283.7700n -0.000150 283.7800n -0.000188 283.7900n -0.000225
+ 283.8000n -0.000263 283.8100n -0.000301 283.8200n -0.000339 283.8300n -0.000377 283.8400n -0.000415 283.8500n -0.000453 283.8600n -0.000491 283.8700n -0.000528 283.8800n -0.000566 283.8900n -0.000603 283.9000n -0.000640 283.9100n -0.000677 283.9200n -0.000713 283.9300n -0.000749 283.9400n -0.000785
+ 283.9500n -0.000821 283.9600n -0.000856 283.9700n -0.000891 283.9800n -0.000926 283.9900n -0.000960 284.0000n -0.000994 284.0100n -0.001027 284.0200n -0.001060 284.0300n -0.001092 284.0400n -0.001124 284.0500n -0.001155 284.0600n -0.001185 284.0700n -0.001215 284.0800n -0.001244 284.0900n -0.001273
+ 284.1000n -0.001301 284.1100n -0.001328 284.1200n -0.001355 284.1300n -0.001380 284.1400n -0.001405 284.1500n -0.001429 284.1600n -0.001453 284.1700n -0.001476 284.1800n -0.001497 284.1900n -0.001518 284.2000n -0.001538 284.2100n -0.001557 284.2200n -0.001576 284.2300n -0.001593 284.2400n -0.001609
+ 284.2500n -0.001625 284.2600n -0.001639 284.2700n -0.001653 284.2800n -0.001665 284.2900n -0.001677 284.3000n -0.001687 284.3100n -0.001697 284.3200n -0.001705 284.3300n -0.001713 284.3400n -0.001719 284.3500n -0.001724 284.3600n -0.001729 284.3700n -0.001732 284.3800n -0.001734 284.3900n -0.001735
+ 284.4000n -0.001735 284.4100n -0.001734 284.4200n -0.001732 284.4300n -0.001728 284.4400n -0.001724 284.4500n -0.001718 284.4600n -0.001712 284.4700n -0.001704 284.4800n -0.001695 284.4900n -0.001685 284.5000n -0.001675 284.5100n -0.001663 284.5200n -0.001649 284.5300n -0.001635 284.5400n -0.001620
+ 284.5500n -0.001604 284.5600n -0.001586 284.5700n -0.001568 284.5800n -0.001549 284.5900n -0.001528 284.6000n -0.001507 284.6100n -0.001485 284.6200n -0.001461 284.6300n -0.001437 284.6400n -0.001412 284.6500n -0.001385 284.6600n -0.001358 284.6700n -0.001330 284.6800n -0.001301 284.6900n -0.001271
+ 284.7000n -0.001241 284.7100n -0.001209 284.7200n -0.001177 284.7300n -0.001143 284.7400n -0.001110 284.7500n -0.001075 284.7600n -0.001039 284.7700n -0.001003 284.7800n -0.000966 284.7900n -0.000929 284.8000n -0.000891 284.8100n -0.000852 284.8200n -0.000812 284.8300n -0.000772 284.8400n -0.000732
+ 284.8500n -0.000691 284.8600n -0.000649 284.8700n -0.000607 284.8800n -0.000565 284.8900n -0.000522 284.9000n -0.000479 284.9100n -0.000435 284.9200n -0.000391 284.9300n -0.000347 284.9400n -0.000302 284.9500n -0.000257 284.9600n -0.000212 284.9700n -0.000167 284.9800n -0.000121 284.9900n -0.000075
+ 285.0000n -0.000030 285.0100n 0.000016 285.0200n 0.000062 285.0300n 0.000108 285.0400n 0.000154 285.0500n 0.000200 285.0600n 0.000246 285.0700n 0.000291 285.0800n 0.000337 285.0900n 0.000382 285.1000n 0.000428 285.1100n 0.000473 285.1200n 0.000518 285.1300n 0.000562 285.1400n 0.000607
+ 285.1500n 0.000651 285.1600n 0.000695 285.1700n 0.000738 285.1800n 0.000781 285.1900n 0.000824 285.2000n 0.000866 285.2100n 0.000907 285.2200n 0.000949 285.2300n 0.000989 285.2400n 0.001029 285.2500n 0.001069 285.2600n 0.001108 285.2700n 0.001146 285.2800n 0.001184 285.2900n 0.001221
+ 285.3000n 0.001258 285.3100n 0.001294 285.3200n 0.001329 285.3300n 0.001363 285.3400n 0.001397 285.3500n 0.001430 285.3600n 0.001462 285.3700n 0.001493 285.3800n 0.001523 285.3900n 0.001553 285.4000n 0.001582 285.4100n 0.001610 285.4200n 0.001637 285.4300n 0.001663 285.4400n 0.001688
+ 285.4500n 0.001712 285.4600n 0.001736 285.4700n 0.001758 285.4800n 0.001780 285.4900n 0.001801 285.5000n 0.001820 285.5100n 0.001839 285.5200n 0.001857 285.5300n 0.001873 285.5400n 0.001889 285.5500n 0.001904 285.5600n 0.001918 285.5700n 0.001931 285.5800n 0.001943 285.5900n 0.001953
+ 285.6000n 0.001963 285.6100n 0.001972 285.6200n 0.001980 285.6300n 0.001987 285.6400n 0.001993 285.6500n 0.001998 285.6600n 0.002002 285.6700n 0.002005 285.6800n 0.002007 285.6900n 0.002008 285.7000n 0.002008 285.7100n 0.002007 285.7200n 0.002006 285.7300n 0.002003 285.7400n 0.001999
+ 285.7500n 0.001995 285.7600n 0.001990 285.7700n 0.001983 285.7800n 0.001976 285.7900n 0.001968 285.8000n 0.001959 285.8100n 0.001950 285.8200n 0.001939 285.8300n 0.001928 285.8400n 0.001916 285.8500n 0.001903 285.8600n 0.001890 285.8700n 0.001875 285.8800n 0.001860 285.8900n 0.001845
+ 285.9000n 0.001828 285.9100n 0.001811 285.9200n 0.001793 285.9300n 0.001775 285.9400n 0.001756 285.9500n 0.001737 285.9600n 0.001717 285.9700n 0.001696 285.9800n 0.001675 285.9900n 0.001654 286.0000n 0.001632 286.0100n 0.001609 286.0200n 0.001586 286.0300n 0.001563 286.0400n 0.001539
+ 286.0500n 0.001515 286.0600n 0.001491 286.0700n 0.001466 286.0800n 0.001441 286.0900n 0.001416 286.1000n 0.001390 286.1100n 0.001365 286.1200n 0.001339 286.1300n 0.001313 286.1400n 0.001286 286.1500n 0.001260 286.1600n 0.001234 286.1700n 0.001207 286.1800n 0.001181 286.1900n 0.001154
+ 286.2000n 0.001127 286.2100n 0.001101 286.2200n 0.001074 286.2300n 0.001048 286.2400n 0.001022 286.2500n 0.000995 286.2600n 0.000969 286.2700n 0.000943 286.2800n 0.000917 286.2900n 0.000891 286.3000n 0.000866 286.3100n 0.000841 286.3200n 0.000816 286.3300n 0.000791 286.3400n 0.000767
+ 286.3500n 0.000742 286.3600n 0.000719 286.3700n 0.000695 286.3800n 0.000672 286.3900n 0.000649 286.4000n 0.000627 286.4100n 0.000605 286.4200n 0.000583 286.4300n 0.000562 286.4400n 0.000541 286.4500n 0.000521 286.4600n 0.000501 286.4700n 0.000482 286.4800n 0.000463 286.4900n 0.000445
+ 286.5000n 0.000427 286.5100n 0.000410 286.5200n 0.000393 286.5300n 0.000377 286.5400n 0.000361 286.5500n 0.000346 286.5600n 0.000331 286.5700n 0.000317 286.5800n 0.000304 286.5900n 0.000291 286.6000n 0.000278 286.6100n 0.000267 286.6200n 0.000255 286.6300n 0.000245 286.6400n 0.000235
+ 286.6500n 0.000225 286.6600n 0.000216 286.6700n 0.000208 286.6800n 0.000200 286.6900n 0.000193 286.7000n 0.000187 286.7100n 0.000181 286.7200n 0.000175 286.7300n 0.000170 286.7400n 0.000166 286.7500n 0.000162 286.7600n 0.000159 286.7700n 0.000156 286.7800n 0.000154 286.7900n 0.000152
+ 286.8000n 0.000151 286.8100n 0.000150 286.8200n 0.000150 286.8300n 0.000150 286.8400n 0.000151 286.8500n 0.000152 286.8600n 0.000153 286.8700n 0.000155 286.8800n 0.000158 286.8900n 0.000160 286.9000n 0.000163 286.9100n 0.000167 286.9200n 0.000171 286.9300n 0.000175 286.9400n 0.000179
+ 286.9500n 0.000184 286.9600n 0.000189 286.9700n 0.000195 286.9800n 0.000200 286.9900n 0.000206 287.0000n 0.000212 287.0100n 0.000218 287.0200n 0.000225 287.0300n 0.000231 287.0400n 0.000238 287.0500n 0.000244 287.0600n 0.000251 287.0700n 0.000258 287.0800n 0.000265 287.0900n 0.000272
+ 287.1000n 0.000279 287.1100n 0.000286 287.1200n 0.000293 287.1300n 0.000300 287.1400n 0.000307 287.1500n 0.000314 287.1600n 0.000321 287.1700n 0.000327 287.1800n 0.000334 287.1900n 0.000340 287.2000n 0.000346 287.2100n 0.000352 287.2200n 0.000357 287.2300n 0.000363 287.2400n 0.000368
+ 287.2500n 0.000372 287.2600n 0.000377 287.2700n 0.000381 287.2800n 0.000385 287.2900n 0.000388 287.3000n 0.000391 287.3100n 0.000394 287.3200n 0.000396 287.3300n 0.000398 287.3400n 0.000399 287.3500n 0.000400 287.3600n 0.000400 287.3700n 0.000400 287.3800n 0.000400 287.3900n 0.000398
+ 287.4000n 0.000397 287.4100n 0.000394 287.4200n 0.000391 287.4300n 0.000388 287.4400n 0.000384 287.4500n 0.000379 287.4600n 0.000374 287.4700n 0.000368 287.4800n 0.000361 287.4900n 0.000354 287.5000n 0.000346 287.5100n 0.000338 287.5200n 0.000328 287.5300n 0.000318 287.5400n 0.000308
+ 287.5500n 0.000296 287.5600n 0.000284 287.5700n 0.000271 287.5800n 0.000258 287.5900n 0.000244 287.6000n 0.000229 287.6100n 0.000213 287.6200n 0.000197 287.6300n 0.000179 287.6400n 0.000161 287.6500n 0.000143 287.6600n 0.000123 287.6700n 0.000103 287.6800n 0.000083 287.6900n 0.000061
+ 287.7000n 0.000039 287.7100n 0.000016 287.7200n -0.000008 287.7300n -0.000032 287.7400n -0.000058 287.7500n -0.000083 287.7600n -0.000110 287.7700n -0.000137 287.7800n -0.000165 287.7900n -0.000193 287.8000n -0.000223 287.8100n -0.000252 287.8200n -0.000283 287.8300n -0.000314 287.8400n -0.000346
+ 287.8500n -0.000378 287.8600n -0.000411 287.8700n -0.000444 287.8800n -0.000478 287.8900n -0.000513 287.9000n -0.000548 287.9100n -0.000583 287.9200n -0.000619 287.9300n -0.000656 287.9400n -0.000693 287.9500n -0.000730 287.9600n -0.000768 287.9700n -0.000806 287.9800n -0.000844 287.9900n -0.000883
+ 288.0000n -0.000923 288.0100n -0.000962 288.0200n -0.001002 288.0300n -0.001042 288.0400n -0.001082 288.0500n -0.001123 288.0600n -0.001164 288.0700n -0.001205 288.0800n -0.001246 288.0900n -0.001287 288.1000n -0.001329 288.1100n -0.001370 288.1200n -0.001412 288.1300n -0.001453 288.1400n -0.001495
+ 288.1500n -0.001537 288.1600n -0.001578 288.1700n -0.001620 288.1800n -0.001661 288.1900n -0.001703 288.2000n -0.001744 288.2100n -0.001785 288.2200n -0.001826 288.2300n -0.001866 288.2400n -0.001907 288.2500n -0.001947 288.2600n -0.001987 288.2700n -0.002026 288.2800n -0.002066 288.2900n -0.002105
+ 288.3000n -0.002143 288.3100n -0.002181 288.3200n -0.002219 288.3300n -0.002256 288.3400n -0.002293 288.3500n -0.002329 288.3600n -0.002365 288.3700n -0.002400 288.3800n -0.002435 288.3900n -0.002469 288.4000n -0.002503 288.4100n -0.002536 288.4200n -0.002568 288.4300n -0.002599 288.4400n -0.002630
+ 288.4500n -0.002660 288.4600n -0.002690 288.4700n -0.002718 288.4800n -0.002746 288.4900n -0.002773 288.5000n -0.002800 288.5100n -0.002825 288.5200n -0.002850 288.5300n -0.002874 288.5400n -0.002896 288.5500n -0.002918 288.5600n -0.002940 288.5700n -0.002960 288.5800n -0.002979 288.5900n -0.002998
+ 288.6000n -0.003015 288.6100n -0.003031 288.6200n -0.003047 288.6300n -0.003061 288.6400n -0.003075 288.6500n -0.003087 288.6600n -0.003099 288.6700n -0.003109 288.6800n -0.003119 288.6900n -0.003127 288.7000n -0.003135 288.7100n -0.003141 288.7200n -0.003146 288.7300n -0.003151 288.7400n -0.003154
+ 288.7500n -0.003156 288.7600n -0.003157 288.7700n -0.003157 288.7800n -0.003156 288.7900n -0.003154 288.8000n -0.003151 288.8100n -0.003147 288.8200n -0.003141 288.8300n -0.003135 288.8400n -0.003128 288.8500n -0.003119 288.8600n -0.003110 288.8700n -0.003099 288.8800n -0.003088 288.8900n -0.003075
+ 288.9000n -0.003062 288.9100n -0.003047 288.9200n -0.003032 288.9300n -0.003015 288.9400n -0.002997 288.9500n -0.002979 288.9600n -0.002960 288.9700n -0.002939 288.9800n -0.002918 288.9900n -0.002896 289.0000n -0.002872 289.0100n -0.002848 289.0200n -0.002823 289.0300n -0.002798 289.0400n -0.002771
+ 289.0500n -0.002744 289.0600n -0.002715 289.0700n -0.002686 289.0800n -0.002656 289.0900n -0.002626 289.1000n -0.002594 289.1100n -0.002562 289.1200n -0.002529 289.1300n -0.002496 289.1400n -0.002462 289.1500n -0.002427 289.1600n -0.002392 289.1700n -0.002355 289.1800n -0.002319 289.1900n -0.002282
+ 289.2000n -0.002244 289.2100n -0.002206 289.2200n -0.002167 289.2300n -0.002128 289.2400n -0.002088 289.2500n -0.002048 289.2600n -0.002007 289.2700n -0.001966 289.2800n -0.001925 289.2900n -0.001883 289.3000n -0.001841 289.3100n -0.001799 289.3200n -0.001756 289.3300n -0.001714 289.3400n -0.001671
+ 289.3500n -0.001628 289.3600n -0.001584 289.3700n -0.001541 289.3800n -0.001497 289.3900n -0.001453 289.4000n -0.001409 289.4100n -0.001366 289.4200n -0.001322 289.4300n -0.001278 289.4400n -0.001234 289.4500n -0.001190 289.4600n -0.001146 289.4700n -0.001102 289.4800n -0.001059 289.4900n -0.001015
+ 289.5000n -0.000972 289.5100n -0.000929 289.5200n -0.000886 289.5300n -0.000843 289.5400n -0.000801 289.5500n -0.000758 289.5600n -0.000717 289.5700n -0.000675 289.5800n -0.000634 289.5900n -0.000593 289.6000n -0.000552 289.6100n -0.000512 289.6200n -0.000472 289.6300n -0.000432 289.6400n -0.000393
+ 289.6500n -0.000355 289.6600n -0.000317 289.6700n -0.000279 289.6800n -0.000242 289.6900n -0.000205 289.7000n -0.000169 289.7100n -0.000134 289.7200n -0.000099 289.7300n -0.000065 289.7400n -0.000031 289.7500n 0.000002 289.7600n 0.000035 289.7700n 0.000067 289.7800n 0.000098 289.7900n 0.000129
+ 289.8000n 0.000159 289.8100n 0.000188 289.8200n 0.000216 289.8300n 0.000244 289.8400n 0.000271 289.8500n 0.000298 289.8600n 0.000324 289.8700n 0.000349 289.8800n 0.000373 289.8900n 0.000397 289.9000n 0.000419 289.9100n 0.000442 289.9200n 0.000463 289.9300n 0.000483 289.9400n 0.000503
+ 289.9500n 0.000522 289.9600n 0.000541 289.9700n 0.000558 289.9800n 0.000575 289.9900n 0.000591 290.0000n 0.000606 290.0100n 0.000620 290.0200n 0.000634 290.0300n 0.000647 290.0400n 0.000659 290.0500n 0.000671 290.0600n 0.000681 290.0700n 0.000691 290.0800n 0.000700 290.0900n 0.000708
+ 290.1000n 0.000716 290.1100n 0.000723 290.1200n 0.000729 290.1300n 0.000734 290.1400n 0.000739 290.1500n 0.000743 290.1600n 0.000746 290.1700n 0.000749 290.1800n 0.000751 290.1900n 0.000752 290.2000n 0.000753 290.2100n 0.000752 290.2200n 0.000752 290.2300n 0.000750 290.2400n 0.000748
+ 290.2500n 0.000745 290.2600n 0.000742 290.2700n 0.000738 290.2800n 0.000733 290.2900n 0.000728 290.3000n 0.000723 290.3100n 0.000716 290.3200n 0.000710 290.3300n 0.000702 290.3400n 0.000694 290.3500n 0.000686 290.3600n 0.000677 290.3700n 0.000668 290.3800n 0.000658 290.3900n 0.000648
+ 290.4000n 0.000637 290.4100n 0.000626 290.4200n 0.000615 290.4300n 0.000603 290.4400n 0.000590 290.4500n 0.000578 290.4600n 0.000565 290.4700n 0.000552 290.4800n 0.000538 290.4900n 0.000524 290.5000n 0.000510 290.5100n 0.000495 290.5200n 0.000481 290.5300n 0.000466 290.5400n 0.000450
+ 290.5500n 0.000435 290.5600n 0.000419 290.5700n 0.000404 290.5800n 0.000388 290.5900n 0.000372 290.6000n 0.000355 290.6100n 0.000339 290.6200n 0.000323 290.6300n 0.000306 290.6400n 0.000290 290.6500n 0.000273 290.6600n 0.000256 290.6700n 0.000240 290.6800n 0.000223 290.6900n 0.000206
+ 290.7000n 0.000190 290.7100n 0.000173 290.7200n 0.000156 290.7300n 0.000140 290.7400n 0.000123 290.7500n 0.000107 290.7600n 0.000091 290.7700n 0.000074 290.7800n 0.000058 290.7900n 0.000042 290.8000n 0.000027 290.8100n 0.000011 290.8200n -0.000004 290.8300n -0.000019 290.8400n -0.000035
+ 290.8500n -0.000049 290.8600n -0.000064 290.8700n -0.000078 290.8800n -0.000092 290.8900n -0.000106 290.9000n -0.000120 290.9100n -0.000133 290.9200n -0.000146 290.9300n -0.000159 290.9400n -0.000171 290.9500n -0.000183 290.9600n -0.000195 290.9700n -0.000207 290.9800n -0.000218 290.9900n -0.000229
+ 291.0000n -0.000239 291.0100n -0.000249 291.0200n -0.000259 291.0300n -0.000268 291.0400n -0.000277 291.0500n -0.000286 291.0600n -0.000294 291.0700n -0.000302 291.0800n -0.000309 291.0900n -0.000316 291.1000n -0.000323 291.1100n -0.000329 291.1200n -0.000335 291.1300n -0.000340 291.1400n -0.000345
+ 291.1500n -0.000349 291.1600n -0.000353 291.1700n -0.000357 291.1800n -0.000360 291.1900n -0.000363 291.2000n -0.000365 291.2100n -0.000367 291.2200n -0.000369 291.2300n -0.000370 291.2400n -0.000371 291.2500n -0.000371 291.2600n -0.000371 291.2700n -0.000370 291.2800n -0.000369 291.2900n -0.000367
+ 291.3000n -0.000365 291.3100n -0.000363 291.3200n -0.000360 291.3300n -0.000357 291.3400n -0.000353 291.3500n -0.000349 291.3600n -0.000345 291.3700n -0.000340 291.3800n -0.000335 291.3900n -0.000329 291.4000n -0.000323 291.4100n -0.000316 291.4200n -0.000309 291.4300n -0.000302 291.4400n -0.000295
+ 291.4500n -0.000287 291.4600n -0.000278 291.4700n -0.000270 291.4800n -0.000260 291.4900n -0.000251 291.5000n -0.000241 291.5100n -0.000231 291.5200n -0.000221 291.5300n -0.000210 291.5400n -0.000199 291.5500n -0.000188 291.5600n -0.000176 291.5700n -0.000164 291.5800n -0.000152 291.5900n -0.000139
+ 291.6000n -0.000126 291.6100n -0.000113 291.6200n -0.000100 291.6300n -0.000086 291.6400n -0.000073 291.6500n -0.000058 291.6600n -0.000044 291.6700n -0.000030 291.6800n -0.000015 291.6900n -0.000000 291.7000n 0.000015 291.7100n 0.000030 291.7200n 0.000045 291.7300n 0.000061 291.7400n 0.000077
+ 291.7500n 0.000093 291.7600n 0.000109 291.7700n 0.000125 291.7800n 0.000141 291.7900n 0.000157 291.8000n 0.000173 291.8100n 0.000190 291.8200n 0.000206 291.8300n 0.000223 291.8400n 0.000240 291.8500n 0.000256 291.8600n 0.000273 291.8700n 0.000290 291.8800n 0.000306 291.8900n 0.000323
+ 291.9000n 0.000340 291.9100n 0.000357 291.9200n 0.000373 291.9300n 0.000390 291.9400n 0.000407 291.9500n 0.000423 291.9600n 0.000440 291.9700n 0.000456 291.9800n 0.000472 291.9900n 0.000488 292.0000n 0.000504 292.0100n 0.000520 292.0200n 0.000536 292.0300n 0.000552 292.0400n 0.000568
+ 292.0500n 0.000583 292.0600n 0.000598 292.0700n 0.000613 292.0800n 0.000628 292.0900n 0.000643 292.1000n 0.000657 292.1100n 0.000671 292.1200n 0.000685 292.1300n 0.000699 292.1400n 0.000713 292.1500n 0.000726 292.1600n 0.000739 292.1700n 0.000752 292.1800n 0.000764 292.1900n 0.000776
+ 292.2000n 0.000788 292.2100n 0.000800 292.2200n 0.000811 292.2300n 0.000822 292.2400n 0.000833 292.2500n 0.000843 292.2600n 0.000853 292.2700n 0.000863 292.2800n 0.000872 292.2900n 0.000881 292.3000n 0.000889 292.3100n 0.000897 292.3200n 0.000905 292.3300n 0.000913 292.3400n 0.000920
+ 292.3500n 0.000926 292.3600n 0.000932 292.3700n 0.000938 292.3800n 0.000943 292.3900n 0.000948 292.4000n 0.000953 292.4100n 0.000957 292.4200n 0.000960 292.4300n 0.000963 292.4400n 0.000966 292.4500n 0.000968 292.4600n 0.000970 292.4700n 0.000971 292.4800n 0.000972 292.4900n 0.000972
+ 292.5000n 0.000972 292.5100n 0.000971 292.5200n 0.000970 292.5300n 0.000968 292.5400n 0.000966 292.5500n 0.000964 292.5600n 0.000961 292.5700n 0.000957 292.5800n 0.000953 292.5900n 0.000948 292.6000n 0.000943 292.6100n 0.000937 292.6200n 0.000931 292.6300n 0.000924 292.6400n 0.000917
+ 292.6500n 0.000910 292.6600n 0.000901 292.6700n 0.000893 292.6800n 0.000883 292.6900n 0.000874 292.7000n 0.000863 292.7100n 0.000853 292.7200n 0.000841 292.7300n 0.000829 292.7400n 0.000817 292.7500n 0.000804 292.7600n 0.000791 292.7700n 0.000777 292.7800n 0.000763 292.7900n 0.000748
+ 292.8000n 0.000733 292.8100n 0.000717 292.8200n 0.000701 292.8300n 0.000684 292.8400n 0.000667 292.8500n 0.000649 292.8600n 0.000631 292.8700n 0.000613 292.8800n 0.000594 292.8900n 0.000574 292.9000n 0.000555 292.9100n 0.000534 292.9200n 0.000513 292.9300n 0.000492 292.9400n 0.000471
+ 292.9500n 0.000449 292.9600n 0.000426 292.9700n 0.000404 292.9800n 0.000381 292.9900n 0.000357 293.0000n 0.000333 293.0100n 0.000309 293.0200n 0.000284 293.0300n 0.000259 293.0400n 0.000234 293.0500n 0.000209 293.0600n 0.000183 293.0700n 0.000157 293.0800n 0.000130 293.0900n 0.000104
+ 293.1000n 0.000077 293.1100n 0.000050 293.1200n 0.000022 293.1300n -0.000006 293.1400n -0.000033 293.1500n -0.000062 293.1600n -0.000090 293.1700n -0.000118 293.1800n -0.000147 293.1900n -0.000176 293.2000n -0.000204 293.2100n -0.000233 293.2200n -0.000263 293.2300n -0.000292 293.2400n -0.000321
+ 293.2500n -0.000350 293.2600n -0.000380 293.2700n -0.000409 293.2800n -0.000439 293.2900n -0.000468 293.3000n -0.000498 293.3100n -0.000527 293.3200n -0.000556 293.3300n -0.000586 293.3400n -0.000615 293.3500n -0.000644 293.3600n -0.000673 293.3700n -0.000702 293.3800n -0.000731 293.3900n -0.000760
+ 293.4000n -0.000788 293.4100n -0.000817 293.4200n -0.000845 293.4300n -0.000873 293.4400n -0.000901 293.4500n -0.000928 293.4600n -0.000955 293.4700n -0.000982 293.4800n -0.001009 293.4900n -0.001035 293.5000n -0.001061 293.5100n -0.001087 293.5200n -0.001112 293.5300n -0.001137 293.5400n -0.001162
+ 293.5500n -0.001186 293.5600n -0.001210 293.5700n -0.001233 293.5800n -0.001256 293.5900n -0.001279 293.6000n -0.001301 293.6100n -0.001322 293.6200n -0.001343 293.6300n -0.001364 293.6400n -0.001384 293.6500n -0.001403 293.6600n -0.001422 293.6700n -0.001441 293.6800n -0.001458 293.6900n -0.001475
+ 293.7000n -0.001492 293.7100n -0.001508 293.7200n -0.001523 293.7300n -0.001538 293.7400n -0.001552 293.7500n -0.001565 293.7600n -0.001578 293.7700n -0.001590 293.7800n -0.001601 293.7900n -0.001611 293.8000n -0.001621 293.8100n -0.001630 293.8200n -0.001639 293.8300n -0.001646 293.8400n -0.001653
+ 293.8500n -0.001659 293.8600n -0.001664 293.8700n -0.001669 293.8800n -0.001673 293.8900n -0.001676 293.9000n -0.001678 293.9100n -0.001679 293.9200n -0.001680 293.9300n -0.001679 293.9400n -0.001678 293.9500n -0.001676 293.9600n -0.001674 293.9700n -0.001670 293.9800n -0.001666 293.9900n -0.001661
+ 294.0000n -0.001655 294.0100n -0.001648 294.0200n -0.001640 294.0300n -0.001632 294.0400n -0.001622 294.0500n -0.001612 294.0600n -0.001601 294.0700n -0.001590 294.0800n -0.001577 294.0900n -0.001563 294.1000n -0.001549 294.1100n -0.001534 294.1200n -0.001518 294.1300n -0.001502 294.1400n -0.001484
+ 294.1500n -0.001466 294.1600n -0.001447 294.1700n -0.001427 294.1800n -0.001407 294.1900n -0.001385 294.2000n -0.001363 294.2100n -0.001341 294.2200n -0.001317 294.2300n -0.001293 294.2400n -0.001268 294.2500n -0.001242 294.2600n -0.001216 294.2700n -0.001189 294.2800n -0.001161 294.2900n -0.001133
+ 294.3000n -0.001104 294.3100n -0.001075 294.3200n -0.001044 294.3300n -0.001014 294.3400n -0.000982 294.3500n -0.000951 294.3600n -0.000918 294.3700n -0.000885 294.3800n -0.000852 294.3900n -0.000818 294.4000n -0.000783 294.4100n -0.000748 294.4200n -0.000713 294.4300n -0.000677 294.4400n -0.000641
+ 294.4500n -0.000605 294.4600n -0.000568 294.4700n -0.000531 294.4800n -0.000493 294.4900n -0.000455 294.5000n -0.000417 294.5100n -0.000379 294.5200n -0.000340 294.5300n -0.000301 294.5400n -0.000262 294.5500n -0.000223 294.5600n -0.000184 294.5700n -0.000144 294.5800n -0.000104 294.5900n -0.000065
+ 294.6000n -0.000025 294.6100n 0.000015 294.6200n 0.000055 294.6300n 0.000095 294.6400n 0.000134 294.6500n 0.000174 294.6600n 0.000214 294.6700n 0.000254 294.6800n 0.000293 294.6900n 0.000332 294.7000n 0.000372 294.7100n 0.000411 294.7200n 0.000449 294.7300n 0.000488 294.7400n 0.000526
+ 294.7500n 0.000565 294.7600n 0.000602 294.7700n 0.000640 294.7800n 0.000677 294.7900n 0.000714 294.8000n 0.000750 294.8100n 0.000786 294.8200n 0.000822 294.8300n 0.000857 294.8400n 0.000892 294.8500n 0.000926 294.8600n 0.000959 294.8700n 0.000993 294.8800n 0.001025 294.8900n 0.001057
+ 294.9000n 0.001089 294.9100n 0.001120 294.9200n 0.001150 294.9300n 0.001180 294.9400n 0.001209 294.9500n 0.001237 294.9600n 0.001265 294.9700n 0.001292 294.9800n 0.001318 294.9900n 0.001344 295.0000n 0.001369 295.0100n 0.001393 295.0200n 0.001416 295.0300n 0.001439 295.0400n 0.001461
+ 295.0500n 0.001482 295.0600n 0.001502 295.0700n 0.001522 295.0800n 0.001540 295.0900n 0.001558 295.1000n 0.001575 295.1100n 0.001591 295.1200n 0.001606 295.1300n 0.001620 295.1400n 0.001634 295.1500n 0.001647 295.1600n 0.001658 295.1700n 0.001669 295.1800n 0.001679 295.1900n 0.001688
+ 295.2000n 0.001696 295.2100n 0.001704 295.2200n 0.001710 295.2300n 0.001716 295.2400n 0.001720 295.2500n 0.001724 295.2600n 0.001727 295.2700n 0.001729 295.2800n 0.001730 295.2900n 0.001730 295.3000n 0.001729 295.3100n 0.001728 295.3200n 0.001725 295.3300n 0.001722 295.3400n 0.001718
+ 295.3500n 0.001713 295.3600n 0.001707 295.3700n 0.001700 295.3800n 0.001693 295.3900n 0.001685 295.4000n 0.001676 295.4100n 0.001666 295.4200n 0.001655 295.4300n 0.001644 295.4400n 0.001631 295.4500n 0.001618 295.4600n 0.001605 295.4700n 0.001590 295.4800n 0.001575 295.4900n 0.001560
+ 295.5000n 0.001543 295.5100n 0.001526 295.5200n 0.001509 295.5300n 0.001490 295.5400n 0.001471 295.5500n 0.001452 295.5600n 0.001432 295.5700n 0.001411 295.5800n 0.001390 295.5900n 0.001369 295.6000n 0.001347 295.6100n 0.001324 295.6200n 0.001301 295.6300n 0.001278 295.6400n 0.001254
+ 295.6500n 0.001230 295.6600n 0.001205 295.6700n 0.001180 295.6800n 0.001155 295.6900n 0.001130 295.7000n 0.001104 295.7100n 0.001078 295.7200n 0.001051 295.7300n 0.001025 295.7400n 0.000998 295.7500n 0.000972 295.7600n 0.000945 295.7700n 0.000918 295.7800n 0.000891 295.7900n 0.000863
+ 295.8000n 0.000836 295.8100n 0.000809 295.8200n 0.000782 295.8300n 0.000755 295.8400n 0.000728 295.8500n 0.000700 295.8600n 0.000673 295.8700n 0.000647 295.8800n 0.000620 295.8900n 0.000593 295.9000n 0.000567 295.9100n 0.000541 295.9200n 0.000515 295.9300n 0.000489 295.9400n 0.000464
+ 295.9500n 0.000439 295.9600n 0.000414 295.9700n 0.000389 295.9800n 0.000365 295.9900n 0.000342 296.0000n 0.000318 296.0100n 0.000295 296.0200n 0.000273 296.0300n 0.000251 296.0400n 0.000229 296.0500n 0.000208 296.0600n 0.000187 296.0700n 0.000167 296.0800n 0.000147 296.0900n 0.000128
+ 296.1000n 0.000109 296.1100n 0.000091 296.1200n 0.000074 296.1300n 0.000057 296.1400n 0.000041 296.1500n 0.000025 296.1600n 0.000010 296.1700n -0.000004 296.1800n -0.000018 296.1900n -0.000031 296.2000n -0.000044 296.2100n -0.000056 296.2200n -0.000067 296.2300n -0.000077 296.2400n -0.000087
+ 296.2500n -0.000096 296.2600n -0.000105 296.2700n -0.000112 296.2800n -0.000120 296.2900n -0.000126 296.3000n -0.000132 296.3100n -0.000137 296.3200n -0.000141 296.3300n -0.000144 296.3400n -0.000147 296.3500n -0.000150 296.3600n -0.000151 296.3700n -0.000152 296.3800n -0.000152 296.3900n -0.000152
+ 296.4000n -0.000151 296.4100n -0.000149 296.4200n -0.000146 296.4300n -0.000143 296.4400n -0.000140 296.4500n -0.000135 296.4600n -0.000130 296.4700n -0.000125 296.4800n -0.000119 296.4900n -0.000112 296.5000n -0.000105 296.5100n -0.000097 296.5200n -0.000088 296.5300n -0.000079 296.5400n -0.000070
+ 296.5500n -0.000060 296.5600n -0.000050 296.5700n -0.000039 296.5800n -0.000027 296.5900n -0.000016 296.6000n -0.000004 296.6100n 0.000009 296.6200n 0.000022 296.6300n 0.000035 296.6400n 0.000049 296.6500n 0.000063 296.6600n 0.000077 296.6700n 0.000092 296.6800n 0.000106 296.6900n 0.000121
+ 296.7000n 0.000137 296.7100n 0.000152 296.7200n 0.000168 296.7300n 0.000183 296.7400n 0.000199 296.7500n 0.000215 296.7600n 0.000231 296.7700n 0.000247 296.7800n 0.000263 296.7900n 0.000280 296.8000n 0.000296 296.8100n 0.000312 296.8200n 0.000328 296.8300n 0.000344 296.8400n 0.000360
+ 296.8500n 0.000375 296.8600n 0.000391 296.8700n 0.000406 296.8800n 0.000421 296.8900n 0.000436 296.9000n 0.000451 296.9100n 0.000465 296.9200n 0.000479 296.9300n 0.000493 296.9400n 0.000507 296.9500n 0.000520 296.9600n 0.000533 296.9700n 0.000545 296.9800n 0.000557 296.9900n 0.000568
+ 297.0000n 0.000579 297.0100n 0.000590 297.0200n 0.000600 297.0300n 0.000609 297.0400n 0.000618 297.0500n 0.000627 297.0600n 0.000635 297.0700n 0.000642 297.0800n 0.000648 297.0900n 0.000654 297.1000n 0.000660 297.1100n 0.000665 297.1200n 0.000669 297.1300n 0.000672 297.1400n 0.000675
+ 297.1500n 0.000677 297.1600n 0.000678 297.1700n 0.000678 297.1800n 0.000678 297.1900n 0.000677 297.2000n 0.000675 297.2100n 0.000673 297.2200n 0.000670 297.2300n 0.000666 297.2400n 0.000661 297.2500n 0.000655 297.2600n 0.000649 297.2700n 0.000641 297.2800n 0.000633 297.2900n 0.000625
+ 297.3000n 0.000615 297.3100n 0.000604 297.3200n 0.000593 297.3300n 0.000581 297.3400n 0.000568 297.3500n 0.000555 297.3600n 0.000540 297.3700n 0.000525 297.3800n 0.000509 297.3900n 0.000492 297.4000n 0.000474 297.4100n 0.000456 297.4200n 0.000437 297.4300n 0.000417 297.4400n 0.000396
+ 297.4500n 0.000375 297.4600n 0.000353 297.4700n 0.000330 297.4800n 0.000307 297.4900n 0.000283 297.5000n 0.000258 297.5100n 0.000233 297.5200n 0.000207 297.5300n 0.000180 297.5400n 0.000153 297.5500n 0.000125 297.5600n 0.000097 297.5700n 0.000068 297.5800n 0.000038 297.5900n 0.000008
+ 297.6000n -0.000022 297.6100n -0.000053 297.6200n -0.000084 297.6300n -0.000116 297.6400n -0.000148 297.6500n -0.000180 297.6600n -0.000212 297.6700n -0.000245 297.6800n -0.000279 297.6900n -0.000312 297.7000n -0.000346 297.7100n -0.000380 297.7200n -0.000414 297.7300n -0.000448 297.7400n -0.000482
+ 297.7500n -0.000516 297.7600n -0.000550 297.7700n -0.000585 297.7800n -0.000619 297.7900n -0.000653 297.8000n -0.000687 297.8100n -0.000722 297.8200n -0.000755 297.8300n -0.000789 297.8400n -0.000823 297.8500n -0.000856 297.8600n -0.000889 297.8700n -0.000922 297.8800n -0.000954 297.8900n -0.000986
+ 297.9000n -0.001017 297.9100n -0.001048 297.9200n -0.001079 297.9300n -0.001109 297.9400n -0.001139 297.9500n -0.001168 297.9600n -0.001196 297.9700n -0.001224 297.9800n -0.001251 297.9900n -0.001278 298.0000n -0.001304 298.0100n -0.001329 298.0200n -0.001353 298.0300n -0.001377 298.0400n -0.001399
+ 298.0500n -0.001421 298.0600n -0.001442 298.0700n -0.001462 298.0800n -0.001481 298.0900n -0.001499 298.1000n -0.001516 298.1100n -0.001532 298.1200n -0.001547 298.1300n -0.001561 298.1400n -0.001574 298.1500n -0.001586 298.1600n -0.001596 298.1700n -0.001606 298.1800n -0.001614 298.1900n -0.001621
+ 298.2000n -0.001627 298.2100n -0.001632 298.2200n -0.001635 298.2300n -0.001637 298.2400n -0.001638 298.2500n -0.001638 298.2600n -0.001636 298.2700n -0.001633 298.2800n -0.001629 298.2900n -0.001623 298.3000n -0.001616 298.3100n -0.001608 298.3200n -0.001598 298.3300n -0.001587 298.3400n -0.001575
+ 298.3500n -0.001561 298.3600n -0.001546 298.3700n -0.001529 298.3800n -0.001511 298.3900n -0.001492 298.4000n -0.001471 298.4100n -0.001449 298.4200n -0.001425 298.4300n -0.001401 298.4400n -0.001374 298.4500n -0.001347 298.4600n -0.001318 298.4700n -0.001287 298.4800n -0.001256 298.4900n -0.001223
+ 298.5000n -0.001188 298.5100n -0.001153 298.5200n -0.001116 298.5300n -0.001078 298.5400n -0.001038 298.5500n -0.000998 298.5600n -0.000956 298.5700n -0.000913 298.5800n -0.000868 298.5900n -0.000823 298.6000n -0.000776 298.6100n -0.000728 298.6200n -0.000680 298.6300n -0.000630 298.6400n -0.000579
+ 298.6500n -0.000527 298.6600n -0.000473 298.6700n -0.000419 298.6800n -0.000365 298.6900n -0.000309 298.7000n -0.000252 298.7100n -0.000194 298.7200n -0.000136 298.7300n -0.000077 298.7400n -0.000017 298.7500n 0.000044 298.7600n 0.000105 298.7700n 0.000167 298.7800n 0.000230 298.7900n 0.000293
+ 298.8000n 0.000357 298.8100n 0.000421 298.8200n 0.000486 298.8300n 0.000551 298.8400n 0.000617 298.8500n 0.000683 298.8600n 0.000749 298.8700n 0.000815 298.8800n 0.000882 298.8900n 0.000949 298.9000n 0.001016 298.9100n 0.001083 298.9200n 0.001151 298.9300n 0.001218 298.9400n 0.001285
+ 298.9500n 0.001352 298.9600n 0.001419 298.9700n 0.001486 298.9800n 0.001553 298.9900n 0.001619 299.0000n 0.001686 299.0100n 0.001752 299.0200n 0.001817 299.0300n 0.001882 299.0400n 0.001947 299.0500n 0.002011 299.0600n 0.002075 299.0700n 0.002138 299.0800n 0.002201 299.0900n 0.002263
+ 299.1000n 0.002324 299.1100n 0.002384 299.1200n 0.002444 299.1300n 0.002503 299.1400n 0.002561 299.1500n 0.002618 299.1600n 0.002675 299.1700n 0.002730 299.1800n 0.002784 299.1900n 0.002838 299.2000n 0.002890 299.2100n 0.002941 299.2200n 0.002991 299.2300n 0.003040 299.2400n 0.003088
+ 299.2500n 0.003134 299.2600n 0.003179 299.2700n 0.003223 299.2800n 0.003266 299.2900n 0.003307 299.3000n 0.003347 299.3100n 0.003386 299.3200n 0.003423 299.3300n 0.003459 299.3400n 0.003493 299.3500n 0.003526 299.3600n 0.003557 299.3700n 0.003587 299.3800n 0.003615 299.3900n 0.003641
+ 299.4000n 0.003666 299.4100n 0.003690 299.4200n 0.003712 299.4300n 0.003732 299.4400n 0.003750 299.4500n 0.003767 299.4600n 0.003783 299.4700n 0.003796 299.4800n 0.003808 299.4900n 0.003819 299.5000n 0.003827 299.5100n 0.003834 299.5200n 0.003839 299.5300n 0.003843 299.5400n 0.003845
+ 299.5500n 0.003845 299.5600n 0.003843 299.5700n 0.003840 299.5800n 0.003835 299.5900n 0.003829 299.6000n 0.003821 299.6100n 0.003811 299.6200n 0.003799 299.6300n 0.003786 299.6400n 0.003772 299.6500n 0.003755 299.6600n 0.003737 299.6700n 0.003718 299.6800n 0.003697 299.6900n 0.003674
+ 299.7000n 0.003650 299.7100n 0.003624 299.7200n 0.003597 299.7300n 0.003568 299.7400n 0.003538 299.7500n 0.003507 299.7600n 0.003474 299.7700n 0.003440 299.7800n 0.003404 299.7900n 0.003367 299.8000n 0.003329 299.8100n 0.003290 299.8200n 0.003249 299.8300n 0.003207 299.8400n 0.003164
+ 299.8500n 0.003120 299.8600n 0.003075 299.8700n 0.003029 299.8800n 0.002981 299.8900n 0.002933 299.9000n 0.002884 299.9100n 0.002834 299.9200n 0.002783 299.9300n 0.002731 299.9400n 0.002678 299.9500n 0.002625 299.9600n 0.002571 299.9700n 0.002516 299.9800n 0.002460 299.9900n 0.002404
+ 300.0000n 0.002348 300.0100n 0.002291 300.0200n 0.002233 300.0300n 0.002175 300.0400n 0.002117 300.0500n 0.002058 300.0600n 0.001999 300.0700n 0.001940 300.0800n 0.001880 300.0900n 0.001821 300.1000n 0.001761 300.1100n 0.001701 300.1200n 0.001641 300.1300n 0.001581 300.1400n 0.001522
+ 300.1500n 0.001462 300.1600n 0.001402 300.1700n 0.001343 300.1800n 0.001284 300.1900n 0.001225 300.2000n 0.001166 300.2100n 0.001108 300.2200n 0.001050 300.2300n 0.000993 300.2400n 0.000936 300.2500n 0.000879 300.2600n 0.000824 300.2700n 0.000768 300.2800n 0.000714 300.2900n 0.000660
+ 300.3000n 0.000606 300.3100n 0.000554 300.3200n 0.000502 300.3300n 0.000451 300.3400n 0.000401 300.3500n 0.000352 300.3600n 0.000304 300.3700n 0.000256 300.3800n 0.000210 300.3900n 0.000165 300.4000n 0.000120 300.4100n 0.000077 300.4200n 0.000035 300.4300n -0.000006 300.4400n -0.000046
+ 300.4500n -0.000085 300.4600n -0.000122 300.4700n -0.000159 300.4800n -0.000194 300.4900n -0.000228 300.5000n -0.000260 300.5100n -0.000291 300.5200n -0.000321 300.5300n -0.000350 300.5400n -0.000377 300.5500n -0.000403 300.5600n -0.000427 300.5700n -0.000450 300.5800n -0.000472 300.5900n -0.000492
+ 300.6000n -0.000511 300.6100n -0.000529 300.6200n -0.000545 300.6300n -0.000559 300.6400n -0.000573 300.6500n -0.000584 300.6600n -0.000594 300.6700n -0.000603 300.6800n -0.000611 300.6900n -0.000617 300.7000n -0.000621 300.7100n -0.000624 300.7200n -0.000626 300.7300n -0.000626 300.7400n -0.000625
+ 300.7500n -0.000622 300.7600n -0.000618 300.7700n -0.000613 300.7800n -0.000606 300.7900n -0.000598 300.8000n -0.000588 300.8100n -0.000578 300.8200n -0.000566 300.8300n -0.000552 300.8400n -0.000538 300.8500n -0.000522 300.8600n -0.000504 300.8700n -0.000486 300.8800n -0.000467 300.8900n -0.000446
+ 300.9000n -0.000424 300.9100n -0.000401 300.9200n -0.000377 300.9300n -0.000352 300.9400n -0.000325 300.9500n -0.000298 300.9600n -0.000270 300.9700n -0.000241 300.9800n -0.000211 300.9900n -0.000180 301.0000n -0.000148 301.0100n -0.000116 301.0200n -0.000082 301.0300n -0.000048 301.0400n -0.000013
+ 301.0500n 0.000023 301.0600n 0.000059 301.0700n 0.000096 301.0800n 0.000133 301.0900n 0.000171 301.1000n 0.000210 301.1100n 0.000249 301.1200n 0.000288 301.1300n 0.000328 301.1400n 0.000368 301.1500n 0.000409 301.1600n 0.000450 301.1700n 0.000491 301.1800n 0.000532 301.1900n 0.000573
+ 301.2000n 0.000615 301.2100n 0.000657 301.2200n 0.000698 301.2300n 0.000740 301.2400n 0.000782 301.2500n 0.000824 301.2600n 0.000865 301.2700n 0.000907 301.2800n 0.000948 301.2900n 0.000989 301.3000n 0.001030 301.3100n 0.001071 301.3200n 0.001111 301.3300n 0.001151 301.3400n 0.001190
+ 301.3500n 0.001230 301.3600n 0.001268 301.3700n 0.001306 301.3800n 0.001344 301.3900n 0.001381 301.4000n 0.001418 301.4100n 0.001454 301.4200n 0.001489 301.4300n 0.001524 301.4400n 0.001558 301.4500n 0.001591 301.4600n 0.001623 301.4700n 0.001655 301.4800n 0.001686 301.4900n 0.001716
+ 301.5000n 0.001745 301.5100n 0.001773 301.5200n 0.001800 301.5300n 0.001827 301.5400n 0.001852 301.5500n 0.001877 301.5600n 0.001900 301.5700n 0.001923 301.5800n 0.001944 301.5900n 0.001965 301.6000n 0.001984 301.6100n 0.002002 301.6200n 0.002019 301.6300n 0.002035 301.6400n 0.002050
+ 301.6500n 0.002064 301.6600n 0.002077 301.6700n 0.002088 301.6800n 0.002099 301.6900n 0.002108 301.7000n 0.002116 301.7100n 0.002123 301.7200n 0.002129 301.7300n 0.002133 301.7400n 0.002137 301.7500n 0.002139 301.7600n 0.002140 301.7700n 0.002140 301.7800n 0.002139 301.7900n 0.002137
+ 301.8000n 0.002133 301.8100n 0.002128 301.8200n 0.002122 301.8300n 0.002115 301.8400n 0.002107 301.8500n 0.002098 301.8600n 0.002088 301.8700n 0.002076 301.8800n 0.002064 301.8900n 0.002050 301.9000n 0.002036 301.9100n 0.002020 301.9200n 0.002003 301.9300n 0.001986 301.9400n 0.001967
+ 301.9500n 0.001947 301.9600n 0.001927 301.9700n 0.001905 301.9800n 0.001883 301.9900n 0.001860 302.0000n 0.001836 302.0100n 0.001811 302.0200n 0.001785 302.0300n 0.001759 302.0400n 0.001731 302.0500n 0.001703 302.0600n 0.001675 302.0700n 0.001645 302.0800n 0.001615 302.0900n 0.001585
+ 302.1000n 0.001554 302.1100n 0.001522 302.1200n 0.001490 302.1300n 0.001457 302.1400n 0.001424 302.1500n 0.001390 302.1600n 0.001356 302.1700n 0.001322 302.1800n 0.001287 302.1900n 0.001252 302.2000n 0.001216 302.2100n 0.001181 302.2200n 0.001145 302.2300n 0.001109 302.2400n 0.001073
+ 302.2500n 0.001037 302.2600n 0.001000 302.2700n 0.000964 302.2800n 0.000928 302.2900n 0.000891 302.3000n 0.000855 302.3100n 0.000819 302.3200n 0.000783 302.3300n 0.000747 302.3400n 0.000711 302.3500n 0.000676 302.3600n 0.000641 302.3700n 0.000606 302.3800n 0.000571 302.3900n 0.000537
+ 302.4000n 0.000503 302.4100n 0.000469 302.4200n 0.000436 302.4300n 0.000404 302.4400n 0.000372 302.4500n 0.000340 302.4600n 0.000309 302.4700n 0.000279 302.4800n 0.000249 302.4900n 0.000219 302.5000n 0.000191 302.5100n 0.000163 302.5200n 0.000136 302.5300n 0.000109 302.5400n 0.000083
+ 302.5500n 0.000058 302.5600n 0.000034 302.5700n 0.000011 302.5800n -0.000012 302.5900n -0.000034 302.6000n -0.000055 302.6100n -0.000075 302.6200n -0.000094 302.6300n -0.000112 302.6400n -0.000129 302.6500n -0.000146 302.6600n -0.000161 302.6700n -0.000175 302.6800n -0.000189 302.6900n -0.000201
+ 302.7000n -0.000213 302.7100n -0.000224 302.7200n -0.000233 302.7300n -0.000242 302.7400n -0.000249 302.7500n -0.000256 302.7600n -0.000261 302.7700n -0.000266 302.7800n -0.000269 302.7900n -0.000271 302.8000n -0.000273 302.8100n -0.000273 302.8200n -0.000272 302.8300n -0.000271 302.8400n -0.000268
+ 302.8500n -0.000264 302.8600n -0.000260 302.8700n -0.000254 302.8800n -0.000248 302.8900n -0.000240 302.9000n -0.000231 302.9100n -0.000222 302.9200n -0.000211 302.9300n -0.000200 302.9400n -0.000188 302.9500n -0.000175 302.9600n -0.000161 302.9700n -0.000146 302.9800n -0.000130 302.9900n -0.000114
+ 303.0000n -0.000096 303.0100n -0.000078 303.0200n -0.000059 303.0300n -0.000039 303.0400n -0.000019 303.0500n 0.000002 303.0600n 0.000024 303.0700n 0.000046 303.0800n 0.000069 303.0900n 0.000093 303.1000n 0.000117 303.1100n 0.000142 303.1200n 0.000167 303.1300n 0.000193 303.1400n 0.000219
+ 303.1500n 0.000246 303.1600n 0.000273 303.1700n 0.000301 303.1800n 0.000329 303.1900n 0.000357 303.2000n 0.000385 303.2100n 0.000414 303.2200n 0.000443 303.2300n 0.000473 303.2400n 0.000502 303.2500n 0.000531 303.2600n 0.000561 303.2700n 0.000591 303.2800n 0.000621 303.2900n 0.000651
+ 303.3000n 0.000680 303.3100n 0.000710 303.3200n 0.000740 303.3300n 0.000770 303.3400n 0.000799 303.3500n 0.000828 303.3600n 0.000858 303.3700n 0.000886 303.3800n 0.000915 303.3900n 0.000943 303.4000n 0.000971 303.4100n 0.000999 303.4200n 0.001026 303.4300n 0.001053 303.4400n 0.001080
+ 303.4500n 0.001106 303.4600n 0.001131 303.4700n 0.001156 303.4800n 0.001181 303.4900n 0.001205 303.5000n 0.001228 303.5100n 0.001250 303.5200n 0.001272 303.5300n 0.001294 303.5400n 0.001314 303.5500n 0.001334 303.5600n 0.001353 303.5700n 0.001372 303.5800n 0.001389 303.5900n 0.001406
+ 303.6000n 0.001422 303.6100n 0.001437 303.6200n 0.001451 303.6300n 0.001465 303.6400n 0.001477 303.6500n 0.001489 303.6600n 0.001499 303.6700n 0.001509 303.6800n 0.001518 303.6900n 0.001525 303.7000n 0.001532 303.7100n 0.001538 303.7200n 0.001542 303.7300n 0.001546 303.7400n 0.001549
+ 303.7500n 0.001550 303.7600n 0.001551 303.7700n 0.001550 303.7800n 0.001549 303.7900n 0.001546 303.8000n 0.001543 303.8100n 0.001538 303.8200n 0.001532 303.8300n 0.001525 303.8400n 0.001518 303.8500n 0.001509 303.8600n 0.001499 303.8700n 0.001488 303.8800n 0.001476 303.8900n 0.001462
+ 303.9000n 0.001448 303.9100n 0.001433 303.9200n 0.001417 303.9300n 0.001400 303.9400n 0.001382 303.9500n 0.001362 303.9600n 0.001342 303.9700n 0.001321 303.9800n 0.001299 303.9900n 0.001276 304.0000n 0.001252 304.0100n 0.001227 304.0200n 0.001201 304.0300n 0.001175 304.0400n 0.001147
+ 304.0500n 0.001119 304.0600n 0.001090 304.0700n 0.001060 304.0800n 0.001029 304.0900n 0.000998 304.1000n 0.000966 304.1100n 0.000933 304.1200n 0.000899 304.1300n 0.000865 304.1400n 0.000830 304.1500n 0.000795 304.1600n 0.000759 304.1700n 0.000723 304.1800n 0.000685 304.1900n 0.000648
+ 304.2000n 0.000610 304.2100n 0.000571 304.2200n 0.000533 304.2300n 0.000493 304.2400n 0.000454 304.2500n 0.000414 304.2600n 0.000374 304.2700n 0.000333 304.2800n 0.000293 304.2900n 0.000252 304.3000n 0.000211 304.3100n 0.000169 304.3200n 0.000128 304.3300n 0.000087 304.3400n 0.000046
+ 304.3500n 0.000004 304.3600n -0.000037 304.3700n -0.000078 304.3800n -0.000120 304.3900n -0.000161 304.4000n -0.000202 304.4100n -0.000242 304.4200n -0.000283 304.4300n -0.000323 304.4400n -0.000363 304.4500n -0.000403 304.4600n -0.000442 304.4700n -0.000481 304.4800n -0.000520 304.4900n -0.000558
+ 304.5000n -0.000595 304.5100n -0.000633 304.5200n -0.000669 304.5300n -0.000705 304.5400n -0.000741 304.5500n -0.000776 304.5600n -0.000810 304.5700n -0.000844 304.5800n -0.000877 304.5900n -0.000909 304.6000n -0.000940 304.6100n -0.000971 304.6200n -0.001001 304.6300n -0.001030 304.6400n -0.001058
+ 304.6500n -0.001086 304.6600n -0.001112 304.6700n -0.001138 304.6800n -0.001163 304.6900n -0.001187 304.7000n -0.001210 304.7100n -0.001231 304.7200n -0.001252 304.7300n -0.001272 304.7400n -0.001291 304.7500n -0.001309 304.7600n -0.001326 304.7700n -0.001342 304.7800n -0.001357 304.7900n -0.001370
+ 304.8000n -0.001383 304.8100n -0.001394 304.8200n -0.001405 304.8300n -0.001414 304.8400n -0.001422 304.8500n -0.001429 304.8600n -0.001435 304.8700n -0.001440 304.8800n -0.001444 304.8900n -0.001446 304.9000n -0.001447 304.9100n -0.001448 304.9200n -0.001447 304.9300n -0.001445 304.9400n -0.001442
+ 304.9500n -0.001437 304.9600n -0.001432 304.9700n -0.001425 304.9800n -0.001418 304.9900n -0.001409 305.0000n -0.001399 305.0100n -0.001388 305.0200n -0.001376 305.0300n -0.001363 305.0400n -0.001349 305.0500n -0.001334 305.0600n -0.001318 305.0700n -0.001301 305.0800n -0.001283 305.0900n -0.001263
+ 305.1000n -0.001243 305.1100n -0.001222 305.1200n -0.001200 305.1300n -0.001177 305.1400n -0.001154 305.1500n -0.001129 305.1600n -0.001103 305.1700n -0.001077 305.1800n -0.001050 305.1900n -0.001022 305.2000n -0.000993 305.2100n -0.000964 305.2200n -0.000934 305.2300n -0.000903 305.2400n -0.000871
+ 305.2500n -0.000839 305.2600n -0.000806 305.2700n -0.000773 305.2800n -0.000739 305.2900n -0.000705 305.3000n -0.000670 305.3100n -0.000634 305.3200n -0.000599 305.3300n -0.000562 305.3400n -0.000526 305.3500n -0.000489 305.3600n -0.000451 305.3700n -0.000414 305.3800n -0.000376 305.3900n -0.000338
+ 305.4000n -0.000299 305.4100n -0.000261 305.4200n -0.000222 305.4300n -0.000184 305.4400n -0.000145 305.4500n -0.000106 305.4600n -0.000067 305.4700n -0.000028 305.4800n 0.000010 305.4900n 0.000049 305.5000n 0.000088 305.5100n 0.000126 305.5200n 0.000165 305.5300n 0.000203 305.5400n 0.000241
+ 305.5500n 0.000278 305.5600n 0.000315 305.5700n 0.000352 305.5800n 0.000389 305.5900n 0.000425 305.6000n 0.000461 305.6100n 0.000497 305.6200n 0.000532 305.6300n 0.000566 305.6400n 0.000600 305.6500n 0.000633 305.6600n 0.000666 305.6700n 0.000699 305.6800n 0.000730 305.6900n 0.000761
+ 305.7000n 0.000791 305.7100n 0.000821 305.7200n 0.000850 305.7300n 0.000878 305.7400n 0.000906 305.7500n 0.000932 305.7600n 0.000958 305.7700n 0.000983 305.7800n 0.001007 305.7900n 0.001030 305.8000n 0.001053 305.8100n 0.001074 305.8200n 0.001095 305.8300n 0.001115 305.8400n 0.001133
+ 305.8500n 0.001151 305.8600n 0.001168 305.8700n 0.001184 305.8800n 0.001199 305.8900n 0.001213 305.9000n 0.001225 305.9100n 0.001237 305.9200n 0.001248 305.9300n 0.001258 305.9400n 0.001267 305.9500n 0.001274 305.9600n 0.001281 305.9700n 0.001286 305.9800n 0.001291 305.9900n 0.001294
+ 306.0000n 0.001296 306.0100n 0.001298 306.0200n 0.001298 306.0300n 0.001297 306.0400n 0.001295 306.0500n 0.001292 306.0600n 0.001288 306.0700n 0.001283 306.0800n 0.001276 306.0900n 0.001269 306.1000n 0.001261 306.1100n 0.001251 306.1200n 0.001241 306.1300n 0.001230 306.1400n 0.001217
+ 306.1500n 0.001204 306.1600n 0.001189 306.1700n 0.001174 306.1800n 0.001157 306.1900n 0.001140 306.2000n 0.001121 306.2100n 0.001102 306.2200n 0.001082 306.2300n 0.001061 306.2400n 0.001039 306.2500n 0.001016 306.2600n 0.000992 306.2700n 0.000967 306.2800n 0.000942 306.2900n 0.000916
+ 306.3000n 0.000888 306.3100n 0.000861 306.3200n 0.000832 306.3300n 0.000803 306.3400n 0.000773 306.3500n 0.000742 306.3600n 0.000711 306.3700n 0.000678 306.3800n 0.000646 306.3900n 0.000612 306.4000n 0.000579 306.4100n 0.000544 306.4200n 0.000509 306.4300n 0.000474 306.4400n 0.000438
+ 306.4500n 0.000401 306.4600n 0.000365 306.4700n 0.000327 306.4800n 0.000290 306.4900n 0.000252 306.5000n 0.000213 306.5100n 0.000175 306.5200n 0.000136 306.5300n 0.000096 306.5400n 0.000057 306.5500n 0.000017 306.5600n -0.000023 306.5700n -0.000063 306.5800n -0.000103 306.5900n -0.000143
+ 306.6000n -0.000184 306.6100n -0.000224 306.6200n -0.000264 306.6300n -0.000305 306.6400n -0.000345 306.6500n -0.000386 306.6600n -0.000426 306.6700n -0.000467 306.6800n -0.000507 306.6900n -0.000547 306.7000n -0.000587 306.7100n -0.000627 306.7200n -0.000666 306.7300n -0.000705 306.7400n -0.000744
+ 306.7500n -0.000783 306.7600n -0.000822 306.7700n -0.000860 306.7800n -0.000898 306.7900n -0.000935 306.8000n -0.000973 306.8100n -0.001009 306.8200n -0.001046 306.8300n -0.001082 306.8400n -0.001117 306.8500n -0.001152 306.8600n -0.001187 306.8700n -0.001221 306.8800n -0.001255 306.8900n -0.001288
+ 306.9000n -0.001320 306.9100n -0.001352 306.9200n -0.001384 306.9300n -0.001415 306.9400n -0.001445 306.9500n -0.001474 306.9600n -0.001503 306.9700n -0.001532 306.9800n -0.001560 306.9900n -0.001587 307.0000n -0.001613 307.0100n -0.001639 307.0200n -0.001664 307.0300n -0.001689 307.0400n -0.001712
+ 307.0500n -0.001735 307.0600n -0.001758 307.0700n -0.001779 307.0800n -0.001800 307.0900n -0.001821 307.1000n -0.001840 307.1100n -0.001859 307.1200n -0.001877 307.1300n -0.001894 307.1400n -0.001911 307.1500n -0.001927 307.1600n -0.001942 307.1700n -0.001957 307.1800n -0.001970 307.1900n -0.001983
+ 307.2000n -0.001996 307.2100n -0.002007 307.2200n -0.002018 307.2300n -0.002028 307.2400n -0.002038 307.2500n -0.002046 307.2600n -0.002054 307.2700n -0.002062 307.2800n -0.002069 307.2900n -0.002075 307.3000n -0.002080 307.3100n -0.002085 307.3200n -0.002089 307.3300n -0.002092 307.3400n -0.002095
+ 307.3500n -0.002097 307.3600n -0.002098 307.3700n -0.002099 307.3800n -0.002099 307.3900n -0.002099 307.4000n -0.002098 307.4100n -0.002097 307.4200n -0.002095 307.4300n -0.002092 307.4400n -0.002089 307.4500n -0.002086 307.4600n -0.002081 307.4700n -0.002077 307.4800n -0.002072 307.4900n -0.002066
+ 307.5000n -0.002060 307.5100n -0.002054 307.5200n -0.002047 307.5300n -0.002039 307.5400n -0.002032 307.5500n -0.002024 307.5600n -0.002015 307.5700n -0.002006 307.5800n -0.001997 307.5900n -0.001988 307.6000n -0.001978 307.6100n -0.001968 307.6200n -0.001957 307.6300n -0.001946 307.6400n -0.001935
+ 307.6500n -0.001924 307.6600n -0.001913 307.6700n -0.001901 307.6800n -0.001889 307.6900n -0.001877 307.7000n -0.001865 307.7100n -0.001852 307.7200n -0.001839 307.7300n -0.001827 307.7400n -0.001814 307.7500n -0.001801 307.7600n -0.001787 307.7700n -0.001774 307.7800n -0.001761 307.7900n -0.001747
+ 307.8000n -0.001734 307.8100n -0.001720 307.8200n -0.001707 307.8300n -0.001693 307.8400n -0.001680 307.8500n -0.001666 307.8600n -0.001652 307.8700n -0.001639 307.8800n -0.001625 307.8900n -0.001612 307.9000n -0.001598 307.9100n -0.001584 307.9200n -0.001571 307.9300n -0.001558 307.9400n -0.001544
+ 307.9500n -0.001531 307.9600n -0.001518 307.9700n -0.001505 307.9800n -0.001492 307.9900n -0.001479 308.0000n -0.001466 308.0100n -0.001453 308.0200n -0.001441 308.0300n -0.001428 308.0400n -0.001416 308.0500n -0.001404 308.0600n -0.001392 308.0700n -0.001380 308.0800n -0.001368 308.0900n -0.001356
+ 308.1000n -0.001344 308.1100n -0.001333 308.1200n -0.001321 308.1300n -0.001310 308.1400n -0.001299 308.1500n -0.001288 308.1600n -0.001277 308.1700n -0.001267 308.1800n -0.001256 308.1900n -0.001246 308.2000n -0.001235 308.2100n -0.001225 308.2200n -0.001215 308.2300n -0.001205 308.2400n -0.001195
+ 308.2500n -0.001185 308.2600n -0.001176 308.2700n -0.001166 308.2800n -0.001157 308.2900n -0.001147 308.3000n -0.001138 308.3100n -0.001129 308.3200n -0.001120 308.3300n -0.001111 308.3400n -0.001102 308.3500n -0.001093 308.3600n -0.001084 308.3700n -0.001075 308.3800n -0.001066 308.3900n -0.001058
+ 308.4000n -0.001049 308.4100n -0.001040 308.4200n -0.001031 308.4300n -0.001023 308.4400n -0.001014 308.4500n -0.001005 308.4600n -0.000997 308.4700n -0.000988 308.4800n -0.000979 308.4900n -0.000970 308.5000n -0.000961 308.5100n -0.000952 308.5200n -0.000943 308.5300n -0.000934 308.5400n -0.000925
+ 308.5500n -0.000916 308.5600n -0.000906 308.5700n -0.000897 308.5800n -0.000887 308.5900n -0.000877 308.6000n -0.000868 308.6100n -0.000858 308.6200n -0.000848 308.6300n -0.000837 308.6400n -0.000827 308.6500n -0.000816 308.6600n -0.000806 308.6700n -0.000795 308.6800n -0.000784 308.6900n -0.000772
+ 308.7000n -0.000761 308.7100n -0.000749 308.7200n -0.000737 308.7300n -0.000725 308.7400n -0.000713 308.7500n -0.000700 308.7600n -0.000688 308.7700n -0.000675 308.7800n -0.000661 308.7900n -0.000648 308.8000n -0.000634 308.8100n -0.000620 308.8200n -0.000606 308.8300n -0.000592 308.8400n -0.000577
+ 308.8500n -0.000562 308.8600n -0.000547 308.8700n -0.000532 308.8800n -0.000516 308.8900n -0.000500 308.9000n -0.000484 308.9100n -0.000467 308.9200n -0.000451 308.9300n -0.000434 308.9400n -0.000417 308.9500n -0.000399 308.9600n -0.000381 308.9700n -0.000363 308.9800n -0.000345 308.9900n -0.000327
+ 309.0000n -0.000308 309.0100n -0.000289 309.0200n -0.000270 309.0300n -0.000251 309.0400n -0.000231 309.0500n -0.000211 309.0600n -0.000191 309.0700n -0.000171 309.0800n -0.000151 309.0900n -0.000130 309.1000n -0.000109 309.1100n -0.000088 309.1200n -0.000067 309.1300n -0.000046 309.1400n -0.000024
+ 309.1500n -0.000003 309.1600n 0.000019 309.1700n 0.000041 309.1800n 0.000063 309.1900n 0.000085 309.2000n 0.000107 309.2100n 0.000130 309.2200n 0.000152 309.2300n 0.000175 309.2400n 0.000197 309.2500n 0.000220 309.2600n 0.000242 309.2700n 0.000265 309.2800n 0.000288 309.2900n 0.000310
+ 309.3000n 0.000333 309.3100n 0.000356 309.3200n 0.000378 309.3300n 0.000401 309.3400n 0.000423 309.3500n 0.000446 309.3600n 0.000468 309.3700n 0.000490 309.3800n 0.000513 309.3900n 0.000535 309.4000n 0.000556 309.4100n 0.000578 309.4200n 0.000600 309.4300n 0.000621 309.4400n 0.000642
+ 309.4500n 0.000663 309.4600n 0.000684 309.4700n 0.000705 309.4800n 0.000725 309.4900n 0.000745 309.5000n 0.000765 309.5100n 0.000784 309.5200n 0.000803 309.5300n 0.000822 309.5400n 0.000840 309.5500n 0.000859 309.5600n 0.000876 309.5700n 0.000894 309.5800n 0.000911 309.5900n 0.000928
+ 309.6000n 0.000944 309.6100n 0.000960 309.6200n 0.000975 309.6300n 0.000990 309.6400n 0.001005 309.6500n 0.001019 309.6600n 0.001032 309.6700n 0.001045 309.6800n 0.001058 309.6900n 0.001070 309.7000n 0.001081 309.7100n 0.001092 309.7200n 0.001103 309.7300n 0.001113 309.7400n 0.001122
+ 309.7500n 0.001131 309.7600n 0.001139 309.7700n 0.001147 309.7800n 0.001154 309.7900n 0.001161 309.8000n 0.001167 309.8100n 0.001172 309.8200n 0.001176 309.8300n 0.001181 309.8400n 0.001184 309.8500n 0.001187 309.8600n 0.001189 309.8700n 0.001190 309.8800n 0.001191 309.8900n 0.001191
+ 309.9000n 0.001191 309.9100n 0.001190 309.9200n 0.001188 309.9300n 0.001186 309.9400n 0.001183 309.9500n 0.001179 309.9600n 0.001175 309.9700n 0.001170 309.9800n 0.001164 309.9900n 0.001158 310.0000n 0.001151 310.0100n 0.001143 310.0200n 0.001135 310.0300n 0.001126 310.0400n 0.001116
+ 310.0500n 0.001106 310.0600n 0.001095 310.0700n 0.001083 310.0800n 0.001071 310.0900n 0.001059 310.1000n 0.001045 310.1100n 0.001031 310.1200n 0.001017 310.1300n 0.001001 310.1400n 0.000986 310.1500n 0.000969 310.1600n 0.000952 310.1700n 0.000935 310.1800n 0.000917 310.1900n 0.000898
+ 310.2000n 0.000879 310.2100n 0.000860 310.2200n 0.000840 310.2300n 0.000819 310.2400n 0.000798 310.2500n 0.000776 310.2600n 0.000754 310.2700n 0.000732 310.2800n 0.000709 310.2900n 0.000685 310.3000n 0.000662 310.3100n 0.000637 310.3200n 0.000613 310.3300n 0.000588 310.3400n 0.000563
+ 310.3500n 0.000537 310.3600n 0.000511 310.3700n 0.000485 310.3800n 0.000458 310.3900n 0.000431 310.4000n 0.000404 310.4100n 0.000377 310.4200n 0.000349 310.4300n 0.000321 310.4400n 0.000293 310.4500n 0.000265 310.4600n 0.000237 310.4700n 0.000208 310.4800n 0.000180 310.4900n 0.000151
+ 310.5000n 0.000122 310.5100n 0.000093 310.5200n 0.000064 310.5300n 0.000035 310.5400n 0.000006 310.5500n -0.000023 310.5600n -0.000052 310.5700n -0.000081 310.5800n -0.000110 310.5900n -0.000139 310.6000n -0.000168 310.6100n -0.000197 310.6200n -0.000226 310.6300n -0.000255 310.6400n -0.000283
+ 310.6500n -0.000311 310.6600n -0.000340 310.6700n -0.000368 310.6800n -0.000395 310.6900n -0.000423 310.7000n -0.000450 310.7100n -0.000478 310.7200n -0.000504 310.7300n -0.000531 310.7400n -0.000557 310.7500n -0.000583 310.7600n -0.000609 310.7700n -0.000634 310.7800n -0.000659 310.7900n -0.000684
+ 310.8000n -0.000708 310.8100n -0.000732 310.8200n -0.000756 310.8300n -0.000779 310.8400n -0.000802 310.8500n -0.000824 310.8600n -0.000846 310.8700n -0.000867 310.8800n -0.000888 310.8900n -0.000909 310.9000n -0.000929 310.9100n -0.000948 310.9200n -0.000967 310.9300n -0.000986 310.9400n -0.001004
+ 310.9500n -0.001021 310.9600n -0.001038 310.9700n -0.001055 310.9800n -0.001070 310.9900n -0.001086 311.0000n -0.001101 311.0100n -0.001115 311.0200n -0.001129 311.0300n -0.001142 311.0400n -0.001154 311.0500n -0.001166 311.0600n -0.001178 311.0700n -0.001189 311.0800n -0.001199 311.0900n -0.001209
+ 311.1000n -0.001218 311.1100n -0.001227 311.1200n -0.001235 311.1300n -0.001242 311.1400n -0.001249 311.1500n -0.001256 311.1600n -0.001261 311.1700n -0.001267 311.1800n -0.001271 311.1900n -0.001275 311.2000n -0.001279 311.2100n -0.001282 311.2200n -0.001284 311.2300n -0.001286 311.2400n -0.001288
+ 311.2500n -0.001288 311.2600n -0.001289 311.2700n -0.001289 311.2800n -0.001288 311.2900n -0.001287 311.3000n -0.001285 311.3100n -0.001283 311.3200n -0.001280 311.3300n -0.001277 311.3400n -0.001273 311.3500n -0.001269 311.3600n -0.001265 311.3700n -0.001260 311.3800n -0.001254 311.3900n -0.001249
+ 311.4000n -0.001242 311.4100n -0.001236 311.4200n -0.001229 311.4300n -0.001221 311.4400n -0.001214 311.4500n -0.001206 311.4600n -0.001197 311.4700n -0.001189 311.4800n -0.001180 311.4900n -0.001170 311.5000n -0.001161 311.5100n -0.001151 311.5200n -0.001141 311.5300n -0.001130 311.5400n -0.001120
+ 311.5500n -0.001109 311.5600n -0.001098 311.5700n -0.001086 311.5800n -0.001075 311.5900n -0.001063 311.6000n -0.001051 311.6100n -0.001040 311.6200n -0.001028 311.6300n -0.001015 311.6400n -0.001003 311.6500n -0.000991 311.6600n -0.000978 311.6700n -0.000966 311.6800n -0.000953 311.6900n -0.000941
+ 311.7000n -0.000928 311.7100n -0.000916 311.7200n -0.000903 311.7300n -0.000890 311.7400n -0.000878 311.7500n -0.000865 311.7600n -0.000853 311.7700n -0.000841 311.7800n -0.000828 311.7900n -0.000816 311.8000n -0.000804 311.8100n -0.000792 311.8200n -0.000780 311.8300n -0.000769 311.8400n -0.000757
+ 311.8500n -0.000746 311.8600n -0.000734 311.8700n -0.000723 311.8800n -0.000712 311.8900n -0.000702 311.9000n -0.000691 311.9100n -0.000681 311.9200n -0.000671 311.9300n -0.000662 311.9400n -0.000652 311.9500n -0.000643 311.9600n -0.000634 311.9700n -0.000625 311.9800n -0.000617 311.9900n -0.000609
+ 312.0000n -0.000601 312.0100n -0.000593 312.0200n -0.000586 312.0300n -0.000579 312.0400n -0.000573 312.0500n -0.000566 312.0600n -0.000560 312.0700n -0.000555 312.0800n -0.000549 312.0900n -0.000544 312.1000n -0.000540 312.1100n -0.000536 312.1200n -0.000532 312.1300n -0.000528 312.1400n -0.000525
+ 312.1500n -0.000522 312.1600n -0.000519 312.1700n -0.000517 312.1800n -0.000515 312.1900n -0.000514 312.2000n -0.000513 312.2100n -0.000512 312.2200n -0.000512 312.2300n -0.000512 312.2400n -0.000512 312.2500n -0.000513 312.2600n -0.000514 312.2700n -0.000515 312.2800n -0.000516 312.2900n -0.000518
+ 312.3000n -0.000521 312.3100n -0.000523 312.3200n -0.000526 312.3300n -0.000530 312.3400n -0.000533 312.3500n -0.000537 312.3600n -0.000541 312.3700n -0.000546 312.3800n -0.000550 312.3900n -0.000556 312.4000n -0.000561 312.4100n -0.000566 312.4200n -0.000572 312.4300n -0.000578 312.4400n -0.000585
+ 312.4500n -0.000591 312.4600n -0.000598 312.4700n -0.000605 312.4800n -0.000612 312.4900n -0.000620 312.5000n -0.000627 312.5100n -0.000635 312.5200n -0.000643 312.5300n -0.000651 312.5400n -0.000659 312.5500n -0.000668 312.5600n -0.000676 312.5700n -0.000685 312.5800n -0.000694 312.5900n -0.000703
+ 312.6000n -0.000712 312.6100n -0.000721 312.6200n -0.000730 312.6300n -0.000739 312.6400n -0.000749 312.6500n -0.000758 312.6600n -0.000767 312.6700n -0.000777 312.6800n -0.000786 312.6900n -0.000795 312.7000n -0.000805 312.7100n -0.000814 312.7200n -0.000823 312.7300n -0.000833 312.7400n -0.000842
+ 312.7500n -0.000851 312.7600n -0.000860 312.7700n -0.000869 312.7800n -0.000878 312.7900n -0.000886 312.8000n -0.000895 312.8100n -0.000903 312.8200n -0.000912 312.8300n -0.000920 312.8400n -0.000928 312.8500n -0.000936 312.8600n -0.000944 312.8700n -0.000951 312.8800n -0.000958 312.8900n -0.000965
+ 312.9000n -0.000972 312.9100n -0.000979 312.9200n -0.000985 312.9300n -0.000991 312.9400n -0.000997 312.9500n -0.001003 312.9600n -0.001008 312.9700n -0.001013 312.9800n -0.001018 312.9900n -0.001023 313.0000n -0.001027 313.0100n -0.001031 313.0200n -0.001034 313.0300n -0.001038 313.0400n -0.001041
+ 313.0500n -0.001043 313.0600n -0.001046 313.0700n -0.001048 313.0800n -0.001049 313.0900n -0.001050 313.1000n -0.001051 313.1100n -0.001052 313.1200n -0.001052 313.1300n -0.001052 313.1400n -0.001051 313.1500n -0.001050 313.1600n -0.001049 313.1700n -0.001047 313.1800n -0.001045 313.1900n -0.001043
+ 313.2000n -0.001040 313.2100n -0.001037 313.2200n -0.001033 313.2300n -0.001029 313.2400n -0.001025 313.2500n -0.001020 313.2600n -0.001015 313.2700n -0.001010 313.2800n -0.001004 313.2900n -0.000998 313.3000n -0.000991 313.3100n -0.000984 313.3200n -0.000977 313.3300n -0.000969 313.3400n -0.000961
+ 313.3500n -0.000952 313.3600n -0.000943 313.3700n -0.000934 313.3800n -0.000924 313.3900n -0.000914 313.4000n -0.000904 313.4100n -0.000893 313.4200n -0.000882 313.4300n -0.000871 313.4400n -0.000859 313.4500n -0.000847 313.4600n -0.000835 313.4700n -0.000822 313.4800n -0.000809 313.4900n -0.000796
+ 313.5000n -0.000782 313.5100n -0.000769 313.5200n -0.000754 313.5300n -0.000740 313.5400n -0.000725 313.5500n -0.000710 313.5600n -0.000695 313.5700n -0.000680 313.5800n -0.000664 313.5900n -0.000648 313.6000n -0.000632 313.6100n -0.000615 313.6200n -0.000599 313.6300n -0.000582 313.6400n -0.000565
+ 313.6500n -0.000548 313.6600n -0.000530 313.6700n -0.000513 313.6800n -0.000495 313.6900n -0.000477 313.7000n -0.000459 313.7100n -0.000441 313.7200n -0.000423 313.7300n -0.000405 313.7400n -0.000386 313.7500n -0.000368 313.7600n -0.000349 313.7700n -0.000330 313.7800n -0.000312 313.7900n -0.000293
+ 313.8000n -0.000274 313.8100n -0.000255 313.8200n -0.000236 313.8300n -0.000217 313.8400n -0.000198 313.8500n -0.000179 313.8600n -0.000160 313.8700n -0.000141 313.8800n -0.000123 313.8900n -0.000104 313.9000n -0.000085 313.9100n -0.000066 313.9200n -0.000048 313.9300n -0.000029 313.9400n -0.000010
+ 313.9500n 0.000008 313.9600n 0.000026 313.9700n 0.000045 313.9800n 0.000063 313.9900n 0.000081 314.0000n 0.000099 314.0100n 0.000116 314.0200n 0.000134 314.0300n 0.000151 314.0400n 0.000168 314.0500n 0.000186 314.0600n 0.000202 314.0700n 0.000219 314.0800n 0.000236 314.0900n 0.000252
+ 314.1000n 0.000268 314.1100n 0.000284 314.1200n 0.000299 314.1300n 0.000315 314.1400n 0.000330 314.1500n 0.000345 314.1600n 0.000360 314.1700n 0.000374 314.1800n 0.000388 314.1900n 0.000402 314.2000n 0.000416 314.2100n 0.000429 314.2200n 0.000442 314.2300n 0.000455 314.2400n 0.000468
+ 314.2500n 0.000480 314.2600n 0.000492 314.2700n 0.000504 314.2800n 0.000515 314.2900n 0.000526 314.3000n 0.000537 314.3100n 0.000547 314.3200n 0.000557 314.3300n 0.000567 314.3400n 0.000577 314.3500n 0.000586 314.3600n 0.000595 314.3700n 0.000603 314.3800n 0.000611 314.3900n 0.000619
+ 314.4000n 0.000627 314.4100n 0.000634 314.4200n 0.000641 314.4300n 0.000647 314.4400n 0.000654 314.4500n 0.000659 314.4600n 0.000665 314.4700n 0.000670 314.4800n 0.000675 314.4900n 0.000680 314.5000n 0.000684 314.5100n 0.000688 314.5200n 0.000691 314.5300n 0.000694 314.5400n 0.000697
+ 314.5500n 0.000700 314.5600n 0.000702 314.5700n 0.000704 314.5800n 0.000706 314.5900n 0.000707 314.6000n 0.000708 314.6100n 0.000709 314.6200n 0.000709 314.6300n 0.000709 314.6400n 0.000709 314.6500n 0.000708 314.6600n 0.000707 314.6700n 0.000706 314.6800n 0.000705 314.6900n 0.000703
+ 314.7000n 0.000701 314.7100n 0.000699 314.7200n 0.000696 314.7300n 0.000693 314.7400n 0.000690 314.7500n 0.000687 314.7600n 0.000683 314.7700n 0.000679 314.7800n 0.000675 314.7900n 0.000671 314.8000n 0.000666 314.8100n 0.000661 314.8200n 0.000656 314.8300n 0.000651 314.8400n 0.000645
+ 314.8500n 0.000640 314.8600n 0.000634 314.8700n 0.000627 314.8800n 0.000621 314.8900n 0.000614 314.9000n 0.000608 314.9100n 0.000601 314.9200n 0.000594 314.9300n 0.000586 314.9400n 0.000579 314.9500n 0.000571 314.9600n 0.000563 314.9700n 0.000555 314.9800n 0.000547 314.9900n 0.000539
+ 315.0000n 0.000531 315.0100n 0.000522 315.0200n 0.000514 315.0300n 0.000505 315.0400n 0.000496 315.0500n 0.000487 315.0600n 0.000478 315.0700n 0.000469 315.0800n 0.000460 315.0900n 0.000450 315.1000n 0.000441 315.1100n 0.000432 315.1200n 0.000422 315.1300n 0.000413 315.1400n 0.000403
+ 315.1500n 0.000393 315.1600n 0.000384 315.1700n 0.000374 315.1800n 0.000364 315.1900n 0.000354 315.2000n 0.000345 315.2100n 0.000335 315.2200n 0.000325 315.2300n 0.000315 315.2400n 0.000306 315.2500n 0.000296 315.2600n 0.000286 315.2700n 0.000276 315.2800n 0.000267 315.2900n 0.000257
+ 315.3000n 0.000247 315.3100n 0.000238 315.3200n 0.000228 315.3300n 0.000219 315.3400n 0.000210 315.3500n 0.000200 315.3600n 0.000191 315.3700n 0.000182 315.3800n 0.000173 315.3900n 0.000164 315.4000n 0.000155 315.4100n 0.000146 315.4200n 0.000138 315.4300n 0.000129 315.4400n 0.000121
+ 315.4500n 0.000113 315.4600n 0.000104 315.4700n 0.000096 315.4800n 0.000088 315.4900n 0.000081 315.5000n 0.000073 315.5100n 0.000066 315.5200n 0.000058 315.5300n 0.000051 315.5400n 0.000044 315.5500n 0.000038 315.5600n 0.000031 315.5700n 0.000025 315.5800n 0.000018 315.5900n 0.000012
+ 315.6000n 0.000006 315.6100n 0.000001 315.6200n -0.000005 315.6300n -0.000010 315.6400n -0.000015 315.6500n -0.000020 315.6600n -0.000024 315.6700n -0.000029 315.6800n -0.000033 315.6900n -0.000037 315.7000n -0.000041 315.7100n -0.000044 315.7200n -0.000047 315.7300n -0.000050 315.7400n -0.000053
+ 315.7500n -0.000056 315.7600n -0.000058 315.7700n -0.000060 315.7800n -0.000062 315.7900n -0.000063 315.8000n -0.000064 315.8100n -0.000065 315.8200n -0.000066 315.8300n -0.000067 315.8400n -0.000067 315.8500n -0.000067 315.8600n -0.000066 315.8700n -0.000066 315.8800n -0.000065 315.8900n -0.000063
+ 315.9000n -0.000062 315.9100n -0.000060 315.9200n -0.000058 315.9300n -0.000056 315.9400n -0.000053 315.9500n -0.000050 315.9600n -0.000047 315.9700n -0.000043 315.9800n -0.000039 315.9900n -0.000035 316.0000n -0.000031 316.0100n -0.000026 316.0200n -0.000021 316.0300n -0.000016 316.0400n -0.000010
+ 316.0500n -0.000004 316.0600n 0.000002 316.0700n 0.000008 316.0800n 0.000015 316.0900n 0.000022 316.1000n 0.000029 316.1100n 0.000037 316.1200n 0.000045 316.1300n 0.000053 316.1400n 0.000062 316.1500n 0.000071 316.1600n 0.000080 316.1700n 0.000089 316.1800n 0.000099 316.1900n 0.000109
+ 316.2000n 0.000119 316.2100n 0.000130 316.2200n 0.000140 316.2300n 0.000151 316.2400n 0.000163 316.2500n 0.000174 316.2600n 0.000186 316.2700n 0.000198 316.2800n 0.000211 316.2900n 0.000223 316.3000n 0.000236 316.3100n 0.000249 316.3200n 0.000263 316.3300n 0.000276 316.3400n 0.000290
+ 316.3500n 0.000304 316.3600n 0.000319 316.3700n 0.000333 316.3800n 0.000348 316.3900n 0.000363 316.4000n 0.000378 316.4100n 0.000393 316.4200n 0.000409 316.4300n 0.000425 316.4400n 0.000441 316.4500n 0.000457 316.4600n 0.000473 316.4700n 0.000489 316.4800n 0.000506 316.4900n 0.000523
+ 316.5000n 0.000540 316.5100n 0.000557 316.5200n 0.000574 316.5300n 0.000591 316.5400n 0.000609 316.5500n 0.000626 316.5600n 0.000644 316.5700n 0.000661 316.5800n 0.000679 316.5900n 0.000697 316.6000n 0.000715 316.6100n 0.000733 316.6200n 0.000751 316.6300n 0.000769 316.6400n 0.000787
+ 316.6500n 0.000805 316.6600n 0.000823 316.6700n 0.000842 316.6800n 0.000860 316.6900n 0.000878 316.7000n 0.000896 316.7100n 0.000914 316.7200n 0.000932 316.7300n 0.000950 316.7400n 0.000968 316.7500n 0.000986 316.7600n 0.001004 316.7700n 0.001021 316.7800n 0.001039 316.7900n 0.001056
+ 316.8000n 0.001074 316.8100n 0.001091 316.8200n 0.001108 316.8300n 0.001125 316.8400n 0.001142 316.8500n 0.001158 316.8600n 0.001175 316.8700n 0.001191 316.8800n 0.001207 316.8900n 0.001223 316.9000n 0.001238 316.9100n 0.001254 316.9200n 0.001269 316.9300n 0.001283 316.9400n 0.001298
+ 316.9500n 0.001312 316.9600n 0.001326 316.9700n 0.001340 316.9800n 0.001353 316.9900n 0.001366 317.0000n 0.001379 317.0100n 0.001391 317.0200n 0.001403 317.0300n 0.001415 317.0400n 0.001426 317.0500n 0.001437 317.0600n 0.001448 317.0700n 0.001458 317.0800n 0.001467 317.0900n 0.001477
+ 317.1000n 0.001486 317.1100n 0.001494 317.1200n 0.001502 317.1300n 0.001509 317.1400n 0.001517 317.1500n 0.001523 317.1600n 0.001529 317.1700n 0.001535 317.1800n 0.001540 317.1900n 0.001545 317.2000n 0.001549 317.2100n 0.001552 317.2200n 0.001555 317.2300n 0.001558 317.2400n 0.001560
+ 317.2500n 0.001561 317.2600n 0.001562 317.2700n 0.001563 317.2800n 0.001562 317.2900n 0.001562 317.3000n 0.001560 317.3100n 0.001558 317.3200n 0.001556 317.3300n 0.001553 317.3400n 0.001549 317.3500n 0.001545 317.3600n 0.001540 317.3700n 0.001534 317.3800n 0.001528 317.3900n 0.001522
+ 317.4000n 0.001514 317.4100n 0.001507 317.4200n 0.001498 317.4300n 0.001489 317.4400n 0.001479 317.4500n 0.001469 317.4600n 0.001458 317.4700n 0.001447 317.4800n 0.001435 317.4900n 0.001422 317.5000n 0.001409 317.5100n 0.001395 317.5200n 0.001380 317.5300n 0.001365 317.5400n 0.001349
+ 317.5500n 0.001333 317.5600n 0.001316 317.5700n 0.001299 317.5800n 0.001281 317.5900n 0.001262 317.6000n 0.001243 317.6100n 0.001223 317.6200n 0.001203 317.6300n 0.001182 317.6400n 0.001161 317.6500n 0.001139 317.6600n 0.001116 317.6700n 0.001093 317.6800n 0.001070 317.6900n 0.001046
+ 317.7000n 0.001021 317.7100n 0.000996 317.7200n 0.000971 317.7300n 0.000945 317.7400n 0.000919 317.7500n 0.000892 317.7600n 0.000865 317.7700n 0.000837 317.7800n 0.000809 317.7900n 0.000780 317.8000n 0.000751 317.8100n 0.000722 317.8200n 0.000693 317.8300n 0.000663 317.8400n 0.000632
+ 317.8500n 0.000602 317.8600n 0.000571 317.8700n 0.000540 317.8800n 0.000508 317.8900n 0.000476 317.9000n 0.000444 317.9100n 0.000412 317.9200n 0.000380 317.9300n 0.000347 317.9400n 0.000314 317.9500n 0.000281 317.9600n 0.000248 317.9700n 0.000215 317.9800n 0.000181 317.9900n 0.000148
+ 318.0000n 0.000114 318.0100n 0.000080 318.0200n 0.000046 318.0300n 0.000013 318.0400n -0.000021 318.0500n -0.000055 318.0600n -0.000089 318.0700n -0.000123 318.0800n -0.000157 318.0900n -0.000190 318.1000n -0.000224 318.1100n -0.000257 318.1200n -0.000291 318.1300n -0.000324 318.1400n -0.000357
+ 318.1500n -0.000390 318.1600n -0.000423 318.1700n -0.000455 318.1800n -0.000488 318.1900n -0.000520 318.2000n -0.000551 318.2100n -0.000583 318.2200n -0.000614 318.2300n -0.000645 318.2400n -0.000676 318.2500n -0.000706 318.2600n -0.000736 318.2700n -0.000765 318.2800n -0.000794 318.2900n -0.000823
+ 318.3000n -0.000851 318.3100n -0.000879 318.3200n -0.000906 318.3300n -0.000933 318.3400n -0.000960 318.3500n -0.000985 318.3600n -0.001011 318.3700n -0.001036 318.3800n -0.001060 318.3900n -0.001084 318.4000n -0.001107 318.4100n -0.001129 318.4200n -0.001151 318.4300n -0.001172 318.4400n -0.001193
+ 318.4500n -0.001213 318.4600n -0.001232 318.4700n -0.001251 318.4800n -0.001269 318.4900n -0.001286 318.5000n -0.001303 318.5100n -0.001319 318.5200n -0.001334 318.5300n -0.001349 318.5400n -0.001363 318.5500n -0.001376 318.5600n -0.001388 318.5700n -0.001399 318.5800n -0.001410 318.5900n -0.001420
+ 318.6000n -0.001429 318.6100n -0.001438 318.6200n -0.001445 318.6300n -0.001452 318.6400n -0.001458 318.6500n -0.001463 318.6600n -0.001468 318.6700n -0.001471 318.6800n -0.001474 318.6900n -0.001476 318.7000n -0.001478 318.7100n -0.001478 318.7200n -0.001478 318.7300n -0.001476 318.7400n -0.001474
+ 318.7500n -0.001471 318.7600n -0.001468 318.7700n -0.001463 318.7800n -0.001458 318.7900n -0.001452 318.8000n -0.001445 318.8100n -0.001438 318.8200n -0.001429 318.8300n -0.001420 318.8400n -0.001410 318.8500n -0.001399 318.8600n -0.001388 318.8700n -0.001376 318.8800n -0.001363 318.8900n -0.001349
+ 318.9000n -0.001334 318.9100n -0.001319 318.9200n -0.001303 318.9300n -0.001287 318.9400n -0.001269 318.9500n -0.001251 318.9600n -0.001233 318.9700n -0.001214 318.9800n -0.001194 318.9900n -0.001173 319.0000n -0.001152 319.0100n -0.001130 319.0200n -0.001108 319.0300n -0.001085 319.0400n -0.001061
+ 319.0500n -0.001037 319.0600n -0.001012 319.0700n -0.000987 319.0800n -0.000962 319.0900n -0.000936 319.1000n -0.000909 319.1100n -0.000882 319.1200n -0.000854 319.1300n -0.000827 319.1400n -0.000798 319.1500n -0.000769 319.1600n -0.000740 319.1700n -0.000711 319.1800n -0.000681 319.1900n -0.000651
+ 319.2000n -0.000621 319.2100n -0.000590 319.2200n -0.000559 319.2300n -0.000528 319.2400n -0.000497 319.2500n -0.000465 319.2600n -0.000433 319.2700n -0.000402 319.2800n -0.000369 319.2900n -0.000337 319.3000n -0.000305 319.3100n -0.000273 319.3200n -0.000240 319.3300n -0.000208 319.3400n -0.000175
+ 319.3500n -0.000143 319.3600n -0.000110 319.3700n -0.000078 319.3800n -0.000045 319.3900n -0.000013 319.4000n 0.000019 319.4100n 0.000051 319.4200n 0.000083 319.4300n 0.000115 319.4400n 0.000147 319.4500n 0.000178 319.4600n 0.000209 319.4700n 0.000241 319.4800n 0.000271 319.4900n 0.000302
+ 319.5000n 0.000332 319.5100n 0.000362 319.5200n 0.000392 319.5300n 0.000421 319.5400n 0.000450 319.5500n 0.000479 319.5600n 0.000507 319.5700n 0.000535 319.5800n 0.000562 319.5900n 0.000589 319.6000n 0.000616 319.6100n 0.000642 319.6200n 0.000668 319.6300n 0.000693 319.6400n 0.000718
+ 319.6500n 0.000742 319.6600n 0.000766 319.6700n 0.000789 319.6800n 0.000811 319.6900n 0.000833 319.7000n 0.000855 319.7100n 0.000876 319.7200n 0.000896 319.7300n 0.000916 319.7400n 0.000935 319.7500n 0.000953 319.7600n 0.000971 319.7700n 0.000988 319.7800n 0.001005 319.7900n 0.001021
+ 319.8000n 0.001036 319.8100n 0.001051 319.8200n 0.001065 319.8300n 0.001078 319.8400n 0.001090 319.8500n 0.001102 319.8600n 0.001114 319.8700n 0.001124 319.8800n 0.001134 319.8900n 0.001143 319.9000n 0.001152 319.9100n 0.001159 319.9200n 0.001167 319.9300n 0.001173 319.9400n 0.001179
+ 319.9500n 0.001184 319.9600n 0.001188 319.9700n 0.001191 319.9800n 0.001194 319.9900n 0.001197 320.0000n 0.001198 320.0100n 0.001199 320.0200n 0.001199 320.0300n 0.001199 320.0400n 0.001197 320.0500n 0.001196 320.0600n 0.001193 320.0700n 0.001190 320.0800n 0.001186 320.0900n 0.001182
+ 320.1000n 0.001177 320.1100n 0.001171 320.1200n 0.001165 320.1300n 0.001158 320.1400n 0.001150 320.1500n 0.001142 320.1600n 0.001133 320.1700n 0.001124 320.1800n 0.001114 320.1900n 0.001104 320.2000n 0.001093 320.2100n 0.001081 320.2200n 0.001069 320.2300n 0.001057 320.2400n 0.001044
+ 320.2500n 0.001031 320.2600n 0.001017 320.2700n 0.001002 320.2800n 0.000988 320.2900n 0.000972 320.3000n 0.000957 320.3100n 0.000941 320.3200n 0.000924 320.3300n 0.000907 320.3400n 0.000890 320.3500n 0.000873 320.3600n 0.000855 320.3700n 0.000837 320.3800n 0.000818 320.3900n 0.000799
+ 320.4000n 0.000780 320.4100n 0.000761 320.4200n 0.000741 320.4300n 0.000722 320.4400n 0.000702 320.4500n 0.000682 320.4600n 0.000661 320.4700n 0.000641 320.4800n 0.000620 320.4900n 0.000599 320.5000n 0.000578 320.5100n 0.000557 320.5200n 0.000536 320.5300n 0.000515 320.5400n 0.000494
+ 320.5500n 0.000473 320.5600n 0.000451 320.5700n 0.000430 320.5800n 0.000409 320.5900n 0.000387 320.6000n 0.000366 320.6100n 0.000345 320.6200n 0.000324 320.6300n 0.000302 320.6400n 0.000281 320.6500n 0.000260 320.6600n 0.000240 320.6700n 0.000219 320.6800n 0.000198 320.6900n 0.000178
+ 320.7000n 0.000158 320.7100n 0.000138 320.7200n 0.000118 320.7300n 0.000098 320.7400n 0.000079 320.7500n 0.000059 320.7600n 0.000040 320.7700n 0.000022 320.7800n 0.000003 320.7900n -0.000015 320.8000n -0.000033 320.8100n -0.000051 320.8200n -0.000068 320.8300n -0.000086 320.8400n -0.000102
+ 320.8500n -0.000119 320.8600n -0.000135 320.8700n -0.000151 320.8800n -0.000167 320.8900n -0.000182 320.9000n -0.000197 320.9100n -0.000211 320.9200n -0.000225 320.9300n -0.000239 320.9400n -0.000253 320.9500n -0.000266 320.9600n -0.000278 320.9700n -0.000291 320.9800n -0.000302 320.9900n -0.000314
+ 321.0000n -0.000325 321.0100n -0.000336 321.0200n -0.000346 321.0300n -0.000356 321.0400n -0.000366 321.0500n -0.000375 321.0600n -0.000384 321.0700n -0.000392 321.0800n -0.000400 321.0900n -0.000408 321.1000n -0.000415 321.1100n -0.000422 321.1200n -0.000428 321.1300n -0.000434 321.1400n -0.000440
+ 321.1500n -0.000445 321.1600n -0.000450 321.1700n -0.000454 321.1800n -0.000458 321.1900n -0.000462 321.2000n -0.000465 321.2100n -0.000468 321.2200n -0.000471 321.2300n -0.000473 321.2400n -0.000475 321.2500n -0.000477 321.2600n -0.000478 321.2700n -0.000479 321.2800n -0.000480 321.2900n -0.000480
+ 321.3000n -0.000480 321.3100n -0.000480 321.3200n -0.000479 321.3300n -0.000478 321.3400n -0.000477 321.3500n -0.000475 321.3600n -0.000474 321.3700n -0.000472 321.3800n -0.000469 321.3900n -0.000467 321.4000n -0.000464 321.4100n -0.000461 321.4200n -0.000458 321.4300n -0.000454 321.4400n -0.000451
+ 321.4500n -0.000447 321.4600n -0.000443 321.4700n -0.000438 321.4800n -0.000434 321.4900n -0.000429 321.5000n -0.000425 321.5100n -0.000420 321.5200n -0.000415 321.5300n -0.000410 321.5400n -0.000404 321.5500n -0.000399 321.5600n -0.000394 321.5700n -0.000388 321.5800n -0.000382 321.5900n -0.000377
+ 321.6000n -0.000371 321.6100n -0.000365 321.6200n -0.000359 321.6300n -0.000353 321.6400n -0.000347 321.6500n -0.000341 321.6600n -0.000334 321.6700n -0.000328 321.6800n -0.000322 321.6900n -0.000316 321.7000n -0.000310 321.7100n -0.000304 321.7200n -0.000298 321.7300n -0.000291 321.7400n -0.000285
+ 321.7500n -0.000279 321.7600n -0.000273 321.7700n -0.000267 321.7800n -0.000261 321.7900n -0.000255 321.8000n -0.000250 321.8100n -0.000244 321.8200n -0.000238 321.8300n -0.000233 321.8400n -0.000227 321.8500n -0.000222 321.8600n -0.000216 321.8700n -0.000211 321.8800n -0.000206 321.8900n -0.000200
+ 321.9000n -0.000195 321.9100n -0.000191 321.9200n -0.000186 321.9300n -0.000181 321.9400n -0.000176 321.9500n -0.000172 321.9600n -0.000167 321.9700n -0.000163 321.9800n -0.000159 321.9900n -0.000155 322.0000n -0.000151 322.0100n -0.000147 322.0200n -0.000143 322.0300n -0.000139 322.0400n -0.000136
+ 322.0500n -0.000132 322.0600n -0.000129 322.0700n -0.000125 322.0800n -0.000122 322.0900n -0.000119 322.1000n -0.000116 322.1100n -0.000113 322.1200n -0.000110 322.1300n -0.000107 322.1400n -0.000105 322.1500n -0.000102 322.1600n -0.000100 322.1700n -0.000097 322.1800n -0.000095 322.1900n -0.000092
+ 322.2000n -0.000090 322.2100n -0.000088 322.2200n -0.000085 322.2300n -0.000083 322.2400n -0.000081 322.2500n -0.000079 322.2600n -0.000077 322.2700n -0.000075 322.2800n -0.000073 322.2900n -0.000071 322.3000n -0.000069 322.3100n -0.000067 322.3200n -0.000065 322.3300n -0.000063 322.3400n -0.000061
+ 322.3500n -0.000059 322.3600n -0.000056 322.3700n -0.000054 322.3800n -0.000052 322.3900n -0.000050 322.4000n -0.000048 322.4100n -0.000045 322.4200n -0.000043 322.4300n -0.000040 322.4400n -0.000038 322.4500n -0.000035 322.4600n -0.000032 322.4700n -0.000029 322.4800n -0.000026 322.4900n -0.000023
+ 322.5000n -0.000020 322.5100n -0.000017 322.5200n -0.000014 322.5300n -0.000010 322.5400n -0.000006 322.5500n -0.000003 322.5600n 0.000001 322.5700n 0.000005 322.5800n 0.000010 322.5900n 0.000014 322.6000n 0.000019 322.6100n 0.000023 322.6200n 0.000028 322.6300n 0.000033 322.6400n 0.000038
+ 322.6500n 0.000044 322.6600n 0.000049 322.6700n 0.000055 322.6800n 0.000061 322.6900n 0.000067 322.7000n 0.000073 322.7100n 0.000080 322.7200n 0.000087 322.7300n 0.000093 322.7400n 0.000100 322.7500n 0.000108 322.7600n 0.000115 322.7700n 0.000123 322.7800n 0.000130 322.7900n 0.000138
+ 322.8000n 0.000147 322.8100n 0.000155 322.8200n 0.000163 322.8300n 0.000172 322.8400n 0.000181 322.8500n 0.000190 322.8600n 0.000199 322.8700n 0.000209 322.8800n 0.000218 322.8900n 0.000228 322.9000n 0.000238 322.9100n 0.000248 322.9200n 0.000258 322.9300n 0.000268 322.9400n 0.000279
+ 322.9500n 0.000290 322.9600n 0.000300 322.9700n 0.000311 322.9800n 0.000322 322.9900n 0.000333 323.0000n 0.000344 323.0100n 0.000356 323.0200n 0.000367 323.0300n 0.000378 323.0400n 0.000390 323.0500n 0.000401 323.0600n 0.000413 323.0700n 0.000425 323.0800n 0.000436 323.0900n 0.000448
+ 323.1000n 0.000460 323.1100n 0.000471 323.1200n 0.000483 323.1300n 0.000495 323.1400n 0.000506 323.1500n 0.000518 323.1600n 0.000529 323.1700n 0.000541 323.1800n 0.000552 323.1900n 0.000563 323.2000n 0.000575 323.2100n 0.000586 323.2200n 0.000597 323.2300n 0.000607 323.2400n 0.000618
+ 323.2500n 0.000629 323.2600n 0.000639 323.2700n 0.000649 323.2800n 0.000659 323.2900n 0.000669 323.3000n 0.000678 323.3100n 0.000687 323.3200n 0.000696 323.3300n 0.000705 323.3400n 0.000714 323.3500n 0.000722 323.3600n 0.000730 323.3700n 0.000737 323.3800n 0.000744 323.3900n 0.000751
+ 323.4000n 0.000758 323.4100n 0.000764 323.4200n 0.000770 323.4300n 0.000775 323.4400n 0.000780 323.4500n 0.000785 323.4600n 0.000789 323.4700n 0.000793 323.4800n 0.000796 323.4900n 0.000799 323.5000n 0.000801 323.5100n 0.000803 323.5200n 0.000804 323.5300n 0.000805 323.5400n 0.000806
+ 323.5500n 0.000805 323.5600n 0.000805 323.5700n 0.000803 323.5800n 0.000802 323.5900n 0.000799 323.6000n 0.000796 323.6100n 0.000793 323.6200n 0.000789 323.6300n 0.000784 323.6400n 0.000779 323.6500n 0.000773 323.6600n 0.000766 323.6700n 0.000759 323.6800n 0.000752 323.6900n 0.000743
+ 323.7000n 0.000734 323.7100n 0.000725 323.7200n 0.000714 323.7300n 0.000703 323.7400n 0.000692 323.7500n 0.000680 323.7600n 0.000667 323.7700n 0.000653 323.7800n 0.000639 323.7900n 0.000624 323.8000n 0.000609 323.8100n 0.000593 323.8200n 0.000576 323.8300n 0.000559 323.8400n 0.000541
+ 323.8500n 0.000522 323.8600n 0.000503 323.8700n 0.000483 323.8800n 0.000462 323.8900n 0.000441 323.9000n 0.000419 323.9100n 0.000397 323.9200n 0.000374 323.9300n 0.000350 323.9400n 0.000326 323.9500n 0.000301 323.9600n 0.000275 323.9700n 0.000250 323.9800n 0.000223 323.9900n 0.000196
+ 324.0000n 0.000168 324.0100n 0.000140 324.0200n 0.000112 324.0300n 0.000082 324.0400n 0.000053 324.0500n 0.000023 324.0600n -0.000008 324.0700n -0.000039 324.0800n -0.000070 324.0900n -0.000102 324.1000n -0.000134 324.1100n -0.000167 324.1200n -0.000200 324.1300n -0.000233 324.1400n -0.000267
+ 324.1500n -0.000301 324.1600n -0.000335 324.1700n -0.000370 324.1800n -0.000405 324.1900n -0.000440 324.2000n -0.000475 324.2100n -0.000511 324.2200n -0.000547 324.2300n -0.000582 324.2400n -0.000618 324.2500n -0.000655 324.2600n -0.000691 324.2700n -0.000727 324.2800n -0.000763 324.2900n -0.000800
+ 324.3000n -0.000836 324.3100n -0.000873 324.3200n -0.000909 324.3300n -0.000945 324.3400n -0.000981 324.3500n -0.001018 324.3600n -0.001054 324.3700n -0.001089 324.3800n -0.001125 324.3900n -0.001160 324.4000n -0.001196 324.4100n -0.001231 324.4200n -0.001265 324.4300n -0.001300 324.4400n -0.001334
+ 324.4500n -0.001368 324.4600n -0.001401 324.4700n -0.001434 324.4800n -0.001466 324.4900n -0.001499 324.5000n -0.001530 324.5100n -0.001561 324.5200n -0.001592 324.5300n -0.001622 324.5400n -0.001652 324.5500n -0.001681 324.5600n -0.001709 324.5700n -0.001737 324.5800n -0.001764 324.5900n -0.001791
+ 324.6000n -0.001816 324.6100n -0.001842 324.6200n -0.001866 324.6300n -0.001890 324.6400n -0.001912 324.6500n -0.001934 324.6600n -0.001956 324.6700n -0.001976 324.6800n -0.001996 324.6900n -0.002014 324.7000n -0.002032 324.7100n -0.002049 324.7200n -0.002065 324.7300n -0.002080 324.7400n -0.002095
+ 324.7500n -0.002108 324.7600n -0.002120 324.7700n -0.002131 324.7800n -0.002142 324.7900n -0.002151 324.8000n -0.002159 324.8100n -0.002166 324.8200n -0.002173 324.8300n -0.002178 324.8400n -0.002182 324.8500n -0.002185 324.8600n -0.002187 324.8700n -0.002187 324.8800n -0.002187 324.8900n -0.002186
+ 324.9000n -0.002183 324.9100n -0.002179 324.9200n -0.002175 324.9300n -0.002169 324.9400n -0.002162 324.9500n -0.002154 324.9600n -0.002145 324.9700n -0.002134 324.9800n -0.002123 324.9900n -0.002110 325.0000n -0.002096 325.0100n -0.002082 325.0200n -0.002066 325.0300n -0.002049 325.0400n -0.002030
+ 325.0500n -0.002011 325.0600n -0.001991 325.0700n -0.001969 325.0800n -0.001947 325.0900n -0.001923 325.1000n -0.001898 325.1100n -0.001873 325.1200n -0.001846 325.1300n -0.001818 325.1400n -0.001789 325.1500n -0.001759 325.1600n -0.001729 325.1700n -0.001697 325.1800n -0.001664 325.1900n -0.001630
+ 325.2000n -0.001596 325.2100n -0.001560 325.2200n -0.001524 325.2300n -0.001486 325.2400n -0.001448 325.2500n -0.001409 325.2600n -0.001369 325.2700n -0.001329 325.2800n -0.001287 325.2900n -0.001245 325.3000n -0.001202 325.3100n -0.001158 325.3200n -0.001114 325.3300n -0.001069 325.3400n -0.001023
+ 325.3500n -0.000977 325.3600n -0.000930 325.3700n -0.000883 325.3800n -0.000835 325.3900n -0.000786 325.4000n -0.000737 325.4100n -0.000688 325.4200n -0.000638 325.4300n -0.000588 325.4400n -0.000537 325.4500n -0.000486 325.4600n -0.000435 325.4700n -0.000384 325.4800n -0.000332 325.4900n -0.000280
+ 325.5000n -0.000227 325.5100n -0.000175 325.5200n -0.000122 325.5300n -0.000070 325.5400n -0.000017 325.5500n 0.000036 325.5600n 0.000088 325.5700n 0.000141 325.5800n 0.000194 325.5900n 0.000247 325.6000n 0.000299 325.6100n 0.000352 325.6200n 0.000404 325.6300n 0.000456 325.6400n 0.000508
+ 325.6500n 0.000559 325.6600n 0.000610 325.6700n 0.000661 325.6800n 0.000712 325.6900n 0.000762 325.7000n 0.000812 325.7100n 0.000861 325.7200n 0.000910 325.7300n 0.000958 325.7400n 0.001006 325.7500n 0.001054 325.7600n 0.001100 325.7700n 0.001146 325.7800n 0.001192 325.7900n 0.001237
+ 325.8000n 0.001281 325.8100n 0.001324 325.8200n 0.001367 325.8300n 0.001408 325.8400n 0.001450 325.8500n 0.001490 325.8600n 0.001529 325.8700n 0.001568 325.8800n 0.001605 325.8900n 0.001642 325.9000n 0.001678 325.9100n 0.001713 325.9200n 0.001747 325.9300n 0.001780 325.9400n 0.001812
+ 325.9500n 0.001843 325.9600n 0.001872 325.9700n 0.001901 325.9800n 0.001929 325.9900n 0.001956 326.0000n 0.001981 326.0100n 0.002005 326.0200n 0.002029 326.0300n 0.002051 326.0400n 0.002072 326.0500n 0.002092 326.0600n 0.002110 326.0700n 0.002128 326.0800n 0.002144 326.0900n 0.002159
+ 326.1000n 0.002173 326.1100n 0.002186 326.1200n 0.002197 326.1300n 0.002207 326.1400n 0.002216 326.1500n 0.002224 326.1600n 0.002230 326.1700n 0.002236 326.1800n 0.002240 326.1900n 0.002243 326.2000n 0.002244 326.2100n 0.002245 326.2200n 0.002244 326.2300n 0.002242 326.2400n 0.002238
+ 326.2500n 0.002234 326.2600n 0.002228 326.2700n 0.002221 326.2800n 0.002213 326.2900n 0.002204 326.3000n 0.002193 326.3100n 0.002181 326.3200n 0.002168 326.3300n 0.002154 326.3400n 0.002139 326.3500n 0.002123 326.3600n 0.002106 326.3700n 0.002087 326.3800n 0.002068 326.3900n 0.002047
+ 326.4000n 0.002026 326.4100n 0.002003 326.4200n 0.001979 326.4300n 0.001955 326.4400n 0.001929 326.4500n 0.001902 326.4600n 0.001875 326.4700n 0.001847 326.4800n 0.001817 326.4900n 0.001787 326.5000n 0.001756 326.5100n 0.001724 326.5200n 0.001691 326.5300n 0.001658 326.5400n 0.001624
+ 326.5500n 0.001589 326.5600n 0.001553 326.5700n 0.001517 326.5800n 0.001480 326.5900n 0.001442 326.6000n 0.001404 326.6100n 0.001365 326.6200n 0.001326 326.6300n 0.001286 326.6400n 0.001245 326.6500n 0.001205 326.6600n 0.001163 326.6700n 0.001122 326.6800n 0.001080 326.6900n 0.001037
+ 326.7000n 0.000994 326.7100n 0.000951 326.7200n 0.000908 326.7300n 0.000865 326.7400n 0.000821 326.7500n 0.000777 326.7600n 0.000733 326.7700n 0.000689 326.7800n 0.000644 326.7900n 0.000600 326.8000n 0.000556 326.8100n 0.000511 326.8200n 0.000467 326.8300n 0.000422 326.8400n 0.000378
+ 326.8500n 0.000334 326.8600n 0.000290 326.8700n 0.000246 326.8800n 0.000203 326.8900n 0.000159 326.9000n 0.000116 326.9100n 0.000073 326.9200n 0.000031 326.9300n -0.000012 326.9400n -0.000054 326.9500n -0.000095 326.9600n -0.000136 326.9700n -0.000177 326.9800n -0.000217 326.9900n -0.000257
+ 327.0000n -0.000296 327.0100n -0.000335 327.0200n -0.000373 327.0300n -0.000411 327.0400n -0.000448 327.0500n -0.000484 327.0600n -0.000520 327.0700n -0.000555 327.0800n -0.000590 327.0900n -0.000624 327.1000n -0.000657 327.1100n -0.000689 327.1200n -0.000721 327.1300n -0.000751 327.1400n -0.000782
+ 327.1500n -0.000811 327.1600n -0.000839 327.1700n -0.000867 327.1800n -0.000894 327.1900n -0.000920 327.2000n -0.000945 327.2100n -0.000969 327.2200n -0.000993 327.2300n -0.001015 327.2400n -0.001037 327.2500n -0.001058 327.2600n -0.001078 327.2700n -0.001097 327.2800n -0.001115 327.2900n -0.001132
+ 327.3000n -0.001148 327.3100n -0.001163 327.3200n -0.001177 327.3300n -0.001191 327.3400n -0.001203 327.3500n -0.001215 327.3600n -0.001225 327.3700n -0.001235 327.3800n -0.001243 327.3900n -0.001251 327.4000n -0.001258 327.4100n -0.001263 327.4200n -0.001268 327.4300n -0.001272 327.4400n -0.001275
+ 327.4500n -0.001277 327.4600n -0.001278 327.4700n -0.001278 327.4800n -0.001278 327.4900n -0.001276 327.5000n -0.001274 327.5100n -0.001270 327.5200n -0.001266 327.5300n -0.001261 327.5400n -0.001255 327.5500n -0.001249 327.5600n -0.001241 327.5700n -0.001233 327.5800n -0.001223 327.5900n -0.001214
+ 327.6000n -0.001203 327.6100n -0.001191 327.6200n -0.001179 327.6300n -0.001166 327.6400n -0.001153 327.6500n -0.001138 327.6600n -0.001123 327.6700n -0.001107 327.6800n -0.001091 327.6900n -0.001074 327.7000n -0.001057 327.7100n -0.001038 327.7200n -0.001020 327.7300n -0.001001 327.7400n -0.000981
+ 327.7500n -0.000960 327.7600n -0.000940 327.7700n -0.000918 327.7800n -0.000897 327.7900n -0.000874 327.8000n -0.000852 327.8100n -0.000829 327.8200n -0.000805 327.8300n -0.000782 327.8400n -0.000758 327.8500n -0.000733 327.8600n -0.000709 327.8700n -0.000684 327.8800n -0.000659 327.8900n -0.000633
+ 327.9000n -0.000608 327.9100n -0.000582 327.9200n -0.000556 327.9300n -0.000530 327.9400n -0.000503 327.9500n -0.000477 327.9600n -0.000451 327.9700n -0.000424 327.9800n -0.000398 327.9900n -0.000371 328.0000n -0.000344 328.0100n -0.000318 328.0200n -0.000291 328.0300n -0.000265 328.0400n -0.000238
+ 328.0500n -0.000212 328.0600n -0.000186 328.0700n -0.000160 328.0800n -0.000134 328.0900n -0.000108 328.1000n -0.000082 328.1100n -0.000057 328.1200n -0.000031 328.1300n -0.000006 328.1400n 0.000019 328.1500n 0.000043 328.1600n 0.000067 328.1700n 0.000092 328.1800n 0.000115 328.1900n 0.000139
+ 328.2000n 0.000162 328.2100n 0.000185 328.2200n 0.000207 328.2300n 0.000229 328.2400n 0.000251 328.2500n 0.000272 328.2600n 0.000294 328.2700n 0.000314 328.2800n 0.000334 328.2900n 0.000354 328.3000n 0.000374 328.3100n 0.000393 328.3200n 0.000411 328.3300n 0.000429 328.3400n 0.000447
+ 328.3500n 0.000464 328.3600n 0.000481 328.3700n 0.000498 328.3800n 0.000514 328.3900n 0.000529 328.4000n 0.000544 328.4100n 0.000559 328.4200n 0.000573 328.4300n 0.000586 328.4400n 0.000600 328.4500n 0.000612 328.4600n 0.000625 328.4700n 0.000637 328.4800n 0.000648 328.4900n 0.000659
+ 328.5000n 0.000669 328.5100n 0.000679 328.5200n 0.000689 328.5300n 0.000698 328.5400n 0.000707 328.5500n 0.000715 328.5600n 0.000723 328.5700n 0.000730 328.5800n 0.000737 328.5900n 0.000744 328.6000n 0.000750 328.6100n 0.000756 328.6200n 0.000762 328.6300n 0.000767 328.6400n 0.000772
+ 328.6500n 0.000776 328.6600n 0.000780 328.6700n 0.000784 328.6800n 0.000787 328.6900n 0.000791 328.7000n 0.000793 328.7100n 0.000796 328.7200n 0.000798 328.7300n 0.000800 328.7400n 0.000802 328.7500n 0.000804 328.7600n 0.000805 328.7700n 0.000806 328.7800n 0.000807 328.7900n 0.000808
+ 328.8000n 0.000808 328.8100n 0.000809 328.8200n 0.000809 328.8300n 0.000809 328.8400n 0.000809 328.8500n 0.000809 328.8600n 0.000809 328.8700n 0.000809 328.8800n 0.000808 328.8900n 0.000808 328.9000n 0.000807 328.9100n 0.000807 328.9200n 0.000807 328.9300n 0.000806 328.9400n 0.000806
+ 328.9500n 0.000805 328.9600n 0.000805 328.9700n 0.000805 328.9800n 0.000805 328.9900n 0.000805 329.0000n 0.000805 329.0100n 0.000805 329.0200n 0.000805 329.0300n 0.000805 329.0400n 0.000806 329.0500n 0.000806 329.0600n 0.000807 329.0700n 0.000808 329.0800n 0.000809 329.0900n 0.000811
+ 329.1000n 0.000813 329.1100n 0.000814 329.1200n 0.000817 329.1300n 0.000819 329.1400n 0.000821 329.1500n 0.000824 329.1600n 0.000827 329.1700n 0.000831 329.1800n 0.000835 329.1900n 0.000839 329.2000n 0.000843 329.2100n 0.000847 329.2200n 0.000852 329.2300n 0.000858 329.2400n 0.000863
+ 329.2500n 0.000869 329.2600n 0.000875 329.2700n 0.000882 329.2800n 0.000888 329.2900n 0.000896 329.3000n 0.000903 329.3100n 0.000911 329.3200n 0.000919 329.3300n 0.000928 329.3400n 0.000937 329.3500n 0.000946 329.3600n 0.000956 329.3700n 0.000965 329.3800n 0.000976 329.3900n 0.000986
+ 329.4000n 0.000997 329.4100n 0.001008 329.4200n 0.001020 329.4300n 0.001032 329.4400n 0.001044 329.4500n 0.001057 329.4600n 0.001069 329.4700n 0.001083 329.4800n 0.001096 329.4900n 0.001110 329.5000n 0.001124 329.5100n 0.001138 329.5200n 0.001152 329.5300n 0.001167 329.5400n 0.001182
+ 329.5500n 0.001197 329.5600n 0.001212 329.5700n 0.001228 329.5800n 0.001244 329.5900n 0.001260 329.6000n 0.001276 329.6100n 0.001292 329.6200n 0.001308 329.6300n 0.001325 329.6400n 0.001342 329.6500n 0.001358 329.6600n 0.001375 329.6700n 0.001392 329.6800n 0.001409 329.6900n 0.001426
+ 329.7000n 0.001443 329.7100n 0.001460 329.7200n 0.001477 329.7300n 0.001494 329.7400n 0.001511 329.7500n 0.001528 329.7600n 0.001545 329.7700n 0.001561 329.7800n 0.001578 329.7900n 0.001594 329.8000n 0.001610 329.8100n 0.001626 329.8200n 0.001642 329.8300n 0.001658 329.8400n 0.001674
+ 329.8500n 0.001689 329.8600n 0.001704 329.8700n 0.001718 329.8800n 0.001733 329.8900n 0.001747 329.9000n 0.001761 329.9100n 0.001774 329.9200n 0.001787 329.9300n 0.001799 329.9400n 0.001812 329.9500n 0.001823 329.9600n 0.001835 329.9700n 0.001845 329.9800n 0.001856 329.9900n 0.001866
+ 330.0000n 0.001875 330.0100n 0.001884 330.0200n 0.001892 330.0300n 0.001900 330.0400n 0.001907 330.0500n 0.001913 330.0600n 0.001919 330.0700n 0.001924 330.0800n 0.001929 330.0900n 0.001933 330.1000n 0.001936 330.1100n 0.001938 330.1200n 0.001940 330.1300n 0.001941 330.1400n 0.001942
+ 330.1500n 0.001941 330.1600n 0.001940 330.1700n 0.001938 330.1800n 0.001936 330.1900n 0.001932 330.2000n 0.001928 330.2100n 0.001923 330.2200n 0.001917 330.2300n 0.001910 330.2400n 0.001903 330.2500n 0.001894 330.2600n 0.001885 330.2700n 0.001875 330.2800n 0.001864 330.2900n 0.001852
+ 330.3000n 0.001840 330.3100n 0.001826 330.3200n 0.001812 330.3300n 0.001796 330.3400n 0.001780 330.3500n 0.001763 330.3600n 0.001745 330.3700n 0.001727 330.3800n 0.001707 330.3900n 0.001686 330.4000n 0.001665 330.4100n 0.001643 330.4200n 0.001620 330.4300n 0.001596 330.4400n 0.001571
+ 330.4500n 0.001545 330.4600n 0.001518 330.4700n 0.001491 330.4800n 0.001463 330.4900n 0.001434 330.5000n 0.001404 330.5100n 0.001373 330.5200n 0.001342 330.5300n 0.001309 330.5400n 0.001276 330.5500n 0.001243 330.5600n 0.001208 330.5700n 0.001173 330.5800n 0.001137 330.5900n 0.001100
+ 330.6000n 0.001063 330.6100n 0.001025 330.6200n 0.000986 330.6300n 0.000947 330.6400n 0.000907 330.6500n 0.000866 330.6600n 0.000825 330.6700n 0.000783 330.6800n 0.000741 330.6900n 0.000698 330.7000n 0.000655 330.7100n 0.000611 330.7200n 0.000567 330.7300n 0.000522 330.7400n 0.000477
+ 330.7500n 0.000432 330.7600n 0.000386 330.7700n 0.000339 330.7800n 0.000293 330.7900n 0.000246 330.8000n 0.000199 330.8100n 0.000152 330.8200n 0.000104 330.8300n 0.000056 330.8400n 0.000008 330.8500n -0.000040 330.8600n -0.000088 330.8700n -0.000136 330.8800n -0.000185 330.8900n -0.000233
+ 330.9000n -0.000281 330.9100n -0.000330 330.9200n -0.000378 330.9300n -0.000426 330.9400n -0.000474 330.9500n -0.000523 330.9600n -0.000570 330.9700n -0.000618 330.9800n -0.000665 330.9900n -0.000713 331.0000n -0.000760 331.0100n -0.000806 331.0200n -0.000853 331.0300n -0.000899 331.0400n -0.000944
+ 331.0500n -0.000989 331.0600n -0.001034 331.0700n -0.001078 331.0800n -0.001122 331.0900n -0.001165 331.1000n -0.001208 331.1100n -0.001250 331.1200n -0.001292 331.1300n -0.001333 331.1400n -0.001373 331.1500n -0.001413 331.1600n -0.001452 331.1700n -0.001490 331.1800n -0.001527 331.1900n -0.001564
+ 331.2000n -0.001600 331.2100n -0.001635 331.2200n -0.001669 331.2300n -0.001703 331.2400n -0.001735 331.2500n -0.001767 331.2600n -0.001798 331.2700n -0.001828 331.2800n -0.001857 331.2900n -0.001884 331.3000n -0.001911 331.3100n -0.001937 331.3200n -0.001962 331.3300n -0.001986 331.3400n -0.002009
+ 331.3500n -0.002031 331.3600n -0.002051 331.3700n -0.002071 331.3800n -0.002089 331.3900n -0.002107 331.4000n -0.002123 331.4100n -0.002138 331.4200n -0.002152 331.4300n -0.002165 331.4400n -0.002177 331.4500n -0.002187 331.4600n -0.002196 331.4700n -0.002205 331.4800n -0.002211 331.4900n -0.002217
+ 331.5000n -0.002222 331.5100n -0.002225 331.5200n -0.002228 331.5300n -0.002229 331.5400n -0.002228 331.5500n -0.002227 331.5600n -0.002225 331.5700n -0.002221 331.5800n -0.002216 331.5900n -0.002210 331.6000n -0.002203 331.6100n -0.002194 331.6200n -0.002185 331.6300n -0.002174 331.6400n -0.002162
+ 331.6500n -0.002149 331.6600n -0.002135 331.6700n -0.002120 331.6800n -0.002104 331.6900n -0.002086 331.7000n -0.002068 331.7100n -0.002049 331.7200n -0.002028 331.7300n -0.002006 331.7400n -0.001984 331.7500n -0.001960 331.7600n -0.001936 331.7700n -0.001910 331.7800n -0.001884 331.7900n -0.001856
+ 331.8000n -0.001828 331.8100n -0.001799 331.8200n -0.001769 331.8300n -0.001738 331.8400n -0.001706 331.8500n -0.001674 331.8600n -0.001641 331.8700n -0.001607 331.8800n -0.001572 331.8900n -0.001536 331.9000n -0.001500 331.9100n -0.001464 331.9200n -0.001426 331.9300n -0.001388 331.9400n -0.001350
+ 331.9500n -0.001311 331.9600n -0.001271 331.9700n -0.001231 331.9800n -0.001191 331.9900n -0.001150 332.0000n -0.001109 332.0100n -0.001067 332.0200n -0.001025 332.0300n -0.000983 332.0400n -0.000940 332.0500n -0.000897 332.0600n -0.000854 332.0700n -0.000811 332.0800n -0.000768 332.0900n -0.000724
+ 332.1000n -0.000681 332.1100n -0.000637 332.1200n -0.000594 332.1300n -0.000550 332.1400n -0.000506 332.1500n -0.000463 332.1600n -0.000420 332.1700n -0.000376 332.1800n -0.000333 332.1900n -0.000290 332.2000n -0.000247 332.2100n -0.000205 332.2200n -0.000163 332.2300n -0.000121 332.2400n -0.000079
+ 332.2500n -0.000038 332.2600n 0.000003 332.2700n 0.000043 332.2800n 0.000083 332.2900n 0.000122 332.3000n 0.000161 332.3100n 0.000200 332.3200n 0.000238 332.3300n 0.000275 332.3400n 0.000311 332.3500n 0.000347 332.3600n 0.000383 332.3700n 0.000417 332.3800n 0.000451 332.3900n 0.000485
+ 332.4000n 0.000517 332.4100n 0.000549 332.4200n 0.000580 332.4300n 0.000610 332.4400n 0.000639 332.4500n 0.000667 332.4600n 0.000695 332.4700n 0.000721 332.4800n 0.000747 332.4900n 0.000772 332.5000n 0.000795 332.5100n 0.000818 332.5200n 0.000840 332.5300n 0.000861 332.5400n 0.000881
+ 332.5500n 0.000900 332.5600n 0.000917 332.5700n 0.000934 332.5800n 0.000950 332.5900n 0.000965 332.6000n 0.000978 332.6100n 0.000991 332.6200n 0.001002 332.6300n 0.001013 332.6400n 0.001022 332.6500n 0.001030 332.6600n 0.001037 332.6700n 0.001043 332.6800n 0.001048 332.6900n 0.001052
+ 332.7000n 0.001055 332.7100n 0.001056 332.7200n 0.001057 332.7300n 0.001056 332.7400n 0.001054 332.7500n 0.001051 332.7600n 0.001048 332.7700n 0.001043 332.7800n 0.001036 332.7900n 0.001029 332.8000n 0.001021 332.8100n 0.001012 332.8200n 0.001002 332.8300n 0.000990 332.8400n 0.000978
+ 332.8500n 0.000965 332.8600n 0.000950 332.8700n 0.000935 332.8800n 0.000919 332.8900n 0.000902 332.9000n 0.000883 332.9100n 0.000864 332.9200n 0.000844 332.9300n 0.000823 332.9400n 0.000802 332.9500n 0.000779 332.9600n 0.000756 332.9700n 0.000731 332.9800n 0.000706 332.9900n 0.000681
+ 333.0000n 0.000654 333.0100n 0.000627 333.0200n 0.000599 333.0300n 0.000570 333.0400n 0.000541 333.0500n 0.000511 333.0600n 0.000480 333.0700n 0.000449 333.0800n 0.000417 333.0900n 0.000385 333.1000n 0.000352 333.1100n 0.000319 333.1200n 0.000285 333.1300n 0.000251 333.1400n 0.000217
+ 333.1500n 0.000182 333.1600n 0.000147 333.1700n 0.000111 333.1800n 0.000075 333.1900n 0.000039 333.2000n 0.000003 333.2100n -0.000034 333.2200n -0.000070 333.2300n -0.000107 333.2400n -0.000144 333.2500n -0.000181 333.2600n -0.000218 333.2700n -0.000255 333.2800n -0.000293 333.2900n -0.000330
+ 333.3000n -0.000367 333.3100n -0.000404 333.3200n -0.000440 333.3300n -0.000477 333.3400n -0.000514 333.3500n -0.000550 333.3600n -0.000586 333.3700n -0.000622 333.3800n -0.000658 333.3900n -0.000693 333.4000n -0.000728 333.4100n -0.000762 333.4200n -0.000796 333.4300n -0.000830 333.4400n -0.000863
+ 333.4500n -0.000896 333.4600n -0.000929 333.4700n -0.000960 333.4800n -0.000992 333.4900n -0.001022 333.5000n -0.001053 333.5100n -0.001082 333.5200n -0.001111 333.5300n -0.001139 333.5400n -0.001167 333.5500n -0.001194 333.5600n -0.001220 333.5700n -0.001246 333.5800n -0.001270 333.5900n -0.001294
+ 333.6000n -0.001317 333.6100n -0.001340 333.6200n -0.001361 333.6300n -0.001382 333.6400n -0.001402 333.6500n -0.001421 333.6600n -0.001439 333.6700n -0.001456 333.6800n -0.001473 333.6900n -0.001488 333.7000n -0.001503 333.7100n -0.001517 333.7200n -0.001529 333.7300n -0.001541 333.7400n -0.001552
+ 333.7500n -0.001562 333.7600n -0.001571 333.7700n -0.001579 333.7800n -0.001586 333.7900n -0.001592 333.8000n -0.001597 333.8100n -0.001601 333.8200n -0.001604 333.8300n -0.001606 333.8400n -0.001607 333.8500n -0.001607 333.8600n -0.001606 333.8700n -0.001604 333.8800n -0.001602 333.8900n -0.001598
+ 333.9000n -0.001593 333.9100n -0.001587 333.9200n -0.001581 333.9300n -0.001573 333.9400n -0.001565 333.9500n -0.001555 333.9600n -0.001545 333.9700n -0.001534 333.9800n -0.001522 333.9900n -0.001509 334.0000n -0.001495 334.0100n -0.001480 334.0200n -0.001464 334.0300n -0.001448 334.0400n -0.001431
+ 334.0500n -0.001413 334.0600n -0.001394 334.0700n -0.001374 334.0800n -0.001354 334.0900n -0.001333 334.1000n -0.001311 334.1100n -0.001289 334.1200n -0.001266 334.1300n -0.001242 334.1400n -0.001217 334.1500n -0.001192 334.1600n -0.001167 334.1700n -0.001140 334.1800n -0.001114 334.1900n -0.001086
+ 334.2000n -0.001059 334.2100n -0.001030 334.2200n -0.001002 334.2300n -0.000972 334.2400n -0.000943 334.2500n -0.000913 334.2600n -0.000882 334.2700n -0.000852 334.2800n -0.000821 334.2900n -0.000789 334.3000n -0.000758 334.3100n -0.000726 334.3200n -0.000694 334.3300n -0.000662 334.3400n -0.000629
+ 334.3500n -0.000597 334.3600n -0.000564 334.3700n -0.000532 334.3800n -0.000499 334.3900n -0.000466 334.4000n -0.000433 334.4100n -0.000401 334.4200n -0.000368 334.4300n -0.000335 334.4400n -0.000303 334.4500n -0.000270 334.4600n -0.000238 334.4700n -0.000206 334.4800n -0.000174 334.4900n -0.000142
+ 334.5000n -0.000111 334.5100n -0.000079 334.5200n -0.000049 334.5300n -0.000018 334.5400n 0.000012 334.5500n 0.000042 334.5600n 0.000072 334.5700n 0.000101 334.5800n 0.000129 334.5900n 0.000158 334.6000n 0.000185 334.6100n 0.000213 334.6200n 0.000239 334.6300n 0.000266 334.6400n 0.000291
+ 334.6500n 0.000316 334.6600n 0.000341 334.6700n 0.000365 334.6800n 0.000388 334.6900n 0.000411 334.7000n 0.000433 334.7100n 0.000454 334.7200n 0.000475 334.7300n 0.000495 334.7400n 0.000514 334.7500n 0.000532 334.7600n 0.000550 334.7700n 0.000567 334.7800n 0.000583 334.7900n 0.000599
+ 334.8000n 0.000614 334.8100n 0.000627 334.8200n 0.000641 334.8300n 0.000653 334.8400n 0.000664 334.8500n 0.000675 334.8600n 0.000685 334.8700n 0.000694 334.8800n 0.000702 334.8900n 0.000710 334.9000n 0.000716 334.9100n 0.000722 334.9200n 0.000727 334.9300n 0.000731 334.9400n 0.000734
+ 334.9500n 0.000736 334.9600n 0.000738 334.9700n 0.000738 334.9800n 0.000738 334.9900n 0.000737 335.0000n 0.000735 335.0100n 0.000733 335.0200n 0.000729 335.0300n 0.000725 335.0400n 0.000720 335.0500n 0.000714 335.0600n 0.000707 335.0700n 0.000699 335.0800n 0.000691 335.0900n 0.000682
+ 335.1000n 0.000672 335.1100n 0.000662 335.1200n 0.000651 335.1300n 0.000639 335.1400n 0.000626 335.1500n 0.000613 335.1600n 0.000598 335.1700n 0.000584 335.1800n 0.000568 335.1900n 0.000552 335.2000n 0.000536 335.2100n 0.000519 335.2200n 0.000501 335.2300n 0.000482 335.2400n 0.000463
+ 335.2500n 0.000444 335.2600n 0.000424 335.2700n 0.000403 335.2800n 0.000383 335.2900n 0.000361 335.3000n 0.000339 335.3100n 0.000317 335.3200n 0.000294 335.3300n 0.000271 335.3400n 0.000248 335.3500n 0.000224 335.3600n 0.000200 335.3700n 0.000176 335.3800n 0.000151 335.3900n 0.000127
+ 335.4000n 0.000102 335.4100n 0.000076 335.4200n 0.000051 335.4300n 0.000025 335.4400n -0.000000 335.4500n -0.000026 335.4600n -0.000052 335.4700n -0.000078 335.4800n -0.000104 335.4900n -0.000130 335.5000n -0.000156 335.5100n -0.000182 335.5200n -0.000208 335.5300n -0.000234 335.5400n -0.000259
+ 335.5500n -0.000285 335.5600n -0.000311 335.5700n -0.000336 335.5800n -0.000361 335.5900n -0.000386 335.6000n -0.000411 335.6100n -0.000435 335.6200n -0.000459 335.6300n -0.000483 335.6400n -0.000507 335.6500n -0.000530 335.6600n -0.000553 335.6700n -0.000576 335.6800n -0.000598 335.6900n -0.000620
+ 335.7000n -0.000641 335.7100n -0.000662 335.7200n -0.000683 335.7300n -0.000703 335.7400n -0.000722 335.7500n -0.000741 335.7600n -0.000760 335.7700n -0.000778 335.7800n -0.000795 335.7900n -0.000812 335.8000n -0.000829 335.8100n -0.000844 335.8200n -0.000859 335.8300n -0.000874 335.8400n -0.000888
+ 335.8500n -0.000901 335.8600n -0.000914 335.8700n -0.000926 335.8800n -0.000937 335.8900n -0.000948 335.9000n -0.000958 335.9100n -0.000967 335.9200n -0.000976 335.9300n -0.000983 335.9400n -0.000991 335.9500n -0.000997 335.9600n -0.001003 335.9700n -0.001008 335.9800n -0.001012 335.9900n -0.001016
+ 336.0000n -0.001019 336.0100n -0.001021 336.0200n -0.001023 336.0300n -0.001023 336.0400n -0.001023 336.0500n -0.001023 336.0600n -0.001021 336.0700n -0.001019 336.0800n -0.001017 336.0900n -0.001013 336.1000n -0.001009 336.1100n -0.001004 336.1200n -0.000998 336.1300n -0.000992 336.1400n -0.000985
+ 336.1500n -0.000978 336.1600n -0.000970 336.1700n -0.000961 336.1800n -0.000951 336.1900n -0.000941 336.2000n -0.000930 336.2100n -0.000919 336.2200n -0.000907 336.2300n -0.000895 336.2400n -0.000882 336.2500n -0.000868 336.2600n -0.000854 336.2700n -0.000839 336.2800n -0.000824 336.2900n -0.000808
+ 336.3000n -0.000792 336.3100n -0.000775 336.3200n -0.000758 336.3300n -0.000741 336.3400n -0.000723 336.3500n -0.000705 336.3600n -0.000686 336.3700n -0.000667 336.3800n -0.000648 336.3900n -0.000628 336.4000n -0.000608 336.4100n -0.000588 336.4200n -0.000567 336.4300n -0.000546 336.4400n -0.000525
+ 336.4500n -0.000504 336.4600n -0.000483 336.4700n -0.000461 336.4800n -0.000440 336.4900n -0.000418 336.5000n -0.000396 336.5100n -0.000374 336.5200n -0.000352 336.5300n -0.000330 336.5400n -0.000308 336.5500n -0.000286 336.5600n -0.000264 336.5700n -0.000242 336.5800n -0.000220 336.5900n -0.000198
+ 336.6000n -0.000176 336.6100n -0.000155 336.6200n -0.000133 336.6300n -0.000112 336.6400n -0.000091 336.6500n -0.000070 336.6600n -0.000049 336.6700n -0.000029 336.6800n -0.000009 336.6900n 0.000011 336.7000n 0.000030 336.7100n 0.000050 336.7200n 0.000068 336.7300n 0.000087 336.7400n 0.000105
+ 336.7500n 0.000122 336.7600n 0.000140 336.7700n 0.000156 336.7800n 0.000173 336.7900n 0.000188 336.8000n 0.000204 336.8100n 0.000219 336.8200n 0.000233 336.8300n 0.000247 336.8400n 0.000260 336.8500n 0.000273 336.8600n 0.000285 336.8700n 0.000296 336.8800n 0.000307 336.8900n 0.000317
+ 336.9000n 0.000327 336.9100n 0.000336 336.9200n 0.000344 336.9300n 0.000352 336.9400n 0.000359 336.9500n 0.000365 336.9600n 0.000371 336.9700n 0.000376 336.9800n 0.000380 336.9900n 0.000384 337.0000n 0.000387 337.0100n 0.000389 337.0200n 0.000390 337.0300n 0.000391 337.0400n 0.000391
+ 337.0500n 0.000390 337.0600n 0.000388 337.0700n 0.000386 337.0800n 0.000383 337.0900n 0.000379 337.1000n 0.000375 337.1100n 0.000370 337.1200n 0.000364 337.1300n 0.000357 337.1400n 0.000349 337.1500n 0.000341 337.1600n 0.000332 337.1700n 0.000322 337.1800n 0.000312 337.1900n 0.000301
+ 337.2000n 0.000289 337.2100n 0.000277 337.2200n 0.000263 337.2300n 0.000249 337.2400n 0.000235 337.2500n 0.000219 337.2600n 0.000204 337.2700n 0.000187 337.2800n 0.000170 337.2900n 0.000152 337.3000n 0.000133 337.3100n 0.000114 337.3200n 0.000094 337.3300n 0.000074 337.3400n 0.000053
+ 337.3500n 0.000031 337.3600n 0.000009 337.3700n -0.000013 337.3800n -0.000036 337.3900n -0.000060 337.4000n -0.000084 337.4100n -0.000109 337.4200n -0.000134 337.4300n -0.000159 337.4400n -0.000185 337.4500n -0.000212 337.4600n -0.000238 337.4700n -0.000266 337.4800n -0.000293 337.4900n -0.000321
+ 337.5000n -0.000349 337.5100n -0.000378 337.5200n -0.000406 337.5300n -0.000435 337.5400n -0.000465 337.5500n -0.000494 337.5600n -0.000524 337.5700n -0.000554 337.5800n -0.000584 337.5900n -0.000614 337.6000n -0.000645 337.6100n -0.000675 337.6200n -0.000706 337.6300n -0.000736 337.6400n -0.000767
+ 337.6500n -0.000798 337.6600n -0.000829 337.6700n -0.000859 337.6800n -0.000890 337.6900n -0.000921 337.7000n -0.000951 337.7100n -0.000982 337.7200n -0.001012 337.7300n -0.001043 337.7400n -0.001073 337.7500n -0.001103 337.7600n -0.001133 337.7700n -0.001162 337.7800n -0.001192 337.7900n -0.001221
+ 337.8000n -0.001250 337.8100n -0.001278 337.8200n -0.001307 337.8300n -0.001335 337.8400n -0.001362 337.8500n -0.001390 337.8600n -0.001417 337.8700n -0.001443 337.8800n -0.001470 337.8900n -0.001495 337.9000n -0.001521 337.9100n -0.001546 337.9200n -0.001570 337.9300n -0.001594 337.9400n -0.001618
+ 337.9500n -0.001641 337.9600n -0.001664 337.9700n -0.001686 337.9800n -0.001707 337.9900n -0.001728 338.0000n -0.001749 338.0100n -0.001769 338.0200n -0.001788 338.0300n -0.001807 338.0400n -0.001825 338.0500n -0.001842 338.0600n -0.001859 338.0700n -0.001876 338.0800n -0.001891 338.0900n -0.001906
+ 338.1000n -0.001921 338.1100n -0.001935 338.1200n -0.001948 338.1300n -0.001960 338.1400n -0.001972 338.1500n -0.001983 338.1600n -0.001994 338.1700n -0.002004 338.1800n -0.002013 338.1900n -0.002022 338.2000n -0.002029 338.2100n -0.002037 338.2200n -0.002043 338.2300n -0.002049 338.2400n -0.002054
+ 338.2500n -0.002059 338.2600n -0.002063 338.2700n -0.002066 338.2800n -0.002068 338.2900n -0.002070 338.3000n -0.002071 338.3100n -0.002072 338.3200n -0.002072 338.3300n -0.002071 338.3400n -0.002070 338.3500n -0.002068 338.3600n -0.002065 338.3700n -0.002062 338.3800n -0.002058 338.3900n -0.002054
+ 338.4000n -0.002049 338.4100n -0.002043 338.4200n -0.002037 338.4300n -0.002031 338.4400n -0.002023 338.4500n -0.002015 338.4600n -0.002007 338.4700n -0.001998 338.4800n -0.001989 338.4900n -0.001979 338.5000n -0.001969 338.5100n -0.001958 338.5200n -0.001947 338.5300n -0.001935 338.5400n -0.001923
+ 338.5500n -0.001910 338.5600n -0.001897 338.5700n -0.001884 338.5800n -0.001870 338.5900n -0.001856 338.6000n -0.001841 338.6100n -0.001826 338.6200n -0.001811 338.6300n -0.001796 338.6400n -0.001780 338.6500n -0.001764 338.6600n -0.001747 338.6700n -0.001731 338.6800n -0.001714 338.6900n -0.001697
+ 338.7000n -0.001679 338.7100n -0.001662 338.7200n -0.001644 338.7300n -0.001626 338.7400n -0.001608 338.7500n -0.001590 338.7600n -0.001572 338.7700n -0.001554 338.7800n -0.001535 338.7900n -0.001517 338.8000n -0.001498 338.8100n -0.001479 338.8200n -0.001461 338.8300n -0.001442 338.8400n -0.001423
+ 338.8500n -0.001405 338.8600n -0.001386 338.8700n -0.001367 338.8800n -0.001349 338.8900n -0.001330 338.9000n -0.001312 338.9100n -0.001293 338.9200n -0.001275 338.9300n -0.001257 338.9400n -0.001239 338.9500n -0.001221 338.9600n -0.001203 338.9700n -0.001186 338.9800n -0.001168 338.9900n -0.001151
+ 339.0000n -0.001134 339.0100n -0.001117 339.0200n -0.001100 339.0300n -0.001084 339.0400n -0.001068 339.0500n -0.001052 339.0600n -0.001036 339.0700n -0.001020 339.0800n -0.001005 339.0900n -0.000990 339.1000n -0.000975 339.1100n -0.000961 339.1200n -0.000947 339.1300n -0.000933 339.1400n -0.000919
+ 339.1500n -0.000906 339.1600n -0.000893 339.1700n -0.000880 339.1800n -0.000868 339.1900n -0.000856 339.2000n -0.000844 339.2100n -0.000833 339.2200n -0.000821 339.2300n -0.000811 339.2400n -0.000800 339.2500n -0.000790 339.2600n -0.000780 339.2700n -0.000770 339.2800n -0.000761 339.2900n -0.000752
+ 339.3000n -0.000744 339.3100n -0.000735 339.3200n -0.000727 339.3300n -0.000720 339.3400n -0.000712 339.3500n -0.000705 339.3600n -0.000698 339.3700n -0.000692 339.3800n -0.000686 339.3900n -0.000680 339.4000n -0.000674 339.4100n -0.000669 339.4200n -0.000664 339.4300n -0.000659 339.4400n -0.000654
+ 339.4500n -0.000650 339.4600n -0.000646 339.4700n -0.000642 339.4800n -0.000638 339.4900n -0.000635 339.5000n -0.000632 339.5100n -0.000629 339.5200n -0.000626 339.5300n -0.000623 339.5400n -0.000621 339.5500n -0.000619 339.5600n -0.000617 339.5700n -0.000615 339.5800n -0.000613 339.5900n -0.000611
+ 339.6000n -0.000610 339.6100n -0.000608 339.6200n -0.000607 339.6300n -0.000606 339.6400n -0.000604 339.6500n -0.000603 339.6600n -0.000602 339.6700n -0.000601 339.6800n -0.000600 339.6900n -0.000599 339.7000n -0.000599 339.7100n -0.000598 339.7200n -0.000597 339.7300n -0.000596 339.7400n -0.000595
+ 339.7500n -0.000594 339.7600n -0.000593 339.7700n -0.000592 339.7800n -0.000591 339.7900n -0.000590 339.8000n -0.000588 339.8100n -0.000587 339.8200n -0.000585 339.8300n -0.000584 339.8400n -0.000582 339.8500n -0.000580 339.8600n -0.000578 339.8700n -0.000576 339.8800n -0.000574 339.8900n -0.000571
+ 339.9000n -0.000569 339.9100n -0.000566 339.9200n -0.000563 339.9300n -0.000559 339.9400n -0.000556 339.9500n -0.000552 339.9600n -0.000549 339.9700n -0.000544 339.9800n -0.000540 339.9900n -0.000535 340.0000n -0.000531 340.0100n -0.000526 340.0200n -0.000520 340.0300n -0.000515 340.0400n -0.000509
+ 340.0500n -0.000503 340.0600n -0.000496 340.0700n -0.000489 340.0800n -0.000482 340.0900n -0.000475 340.1000n -0.000468 340.1100n -0.000460 340.1200n -0.000452 340.1300n -0.000443 340.1400n -0.000435 340.1500n -0.000426 340.1600n -0.000416 340.1700n -0.000407 340.1800n -0.000397 340.1900n -0.000387
+ 340.2000n -0.000376 340.2100n -0.000365 340.2200n -0.000354 340.2300n -0.000343 340.2400n -0.000332 340.2500n -0.000320 340.2600n -0.000308 340.2700n -0.000295 340.2800n -0.000282 340.2900n -0.000270 340.3000n -0.000256 340.3100n -0.000243 340.3200n -0.000229 340.3300n -0.000215 340.3400n -0.000201
+ 340.3500n -0.000187 340.3600n -0.000172 340.3700n -0.000157 340.3800n -0.000142 340.3900n -0.000127 340.4000n -0.000112 340.4100n -0.000096 340.4200n -0.000081 340.4300n -0.000065 340.4400n -0.000049 340.4500n -0.000033 340.4600n -0.000016 340.4700n -0.000000 340.4800n 0.000016 340.4900n 0.000033
+ 340.5000n 0.000050 340.5100n 0.000066 340.5200n 0.000083 340.5300n 0.000100 340.5400n 0.000117 340.5500n 0.000134 340.5600n 0.000151 340.5700n 0.000168 340.5800n 0.000185 340.5900n 0.000201 340.6000n 0.000218 340.6100n 0.000235 340.6200n 0.000252 340.6300n 0.000268 340.6400n 0.000285
+ 340.6500n 0.000301 340.6600n 0.000318 340.6700n 0.000334 340.6800n 0.000350 340.6900n 0.000366 340.7000n 0.000382 340.7100n 0.000397 340.7200n 0.000412 340.7300n 0.000428 340.7400n 0.000443 340.7500n 0.000457 340.7600n 0.000472 340.7700n 0.000486 340.7800n 0.000500 340.7900n 0.000513
+ 340.8000n 0.000527 340.8100n 0.000540 340.8200n 0.000552 340.8300n 0.000565 340.8400n 0.000577 340.8500n 0.000588 340.8600n 0.000599 340.8700n 0.000610 340.8800n 0.000621 340.8900n 0.000631 340.9000n 0.000641 340.9100n 0.000650 340.9200n 0.000659 340.9300n 0.000667 340.9400n 0.000675
+ 340.9500n 0.000683 340.9600n 0.000690 340.9700n 0.000696 340.9800n 0.000702 340.9900n 0.000708 341.0000n 0.000713 341.0100n 0.000718 341.0200n 0.000722 341.0300n 0.000725 341.0400n 0.000728 341.0500n 0.000731 341.0600n 0.000733 341.0700n 0.000734 341.0800n 0.000735 341.0900n 0.000736
+ 341.1000n 0.000735 341.1100n 0.000735 341.1200n 0.000734 341.1300n 0.000732 341.1400n 0.000729 341.1500n 0.000727 341.1600n 0.000723 341.1700n 0.000719 341.1800n 0.000715 341.1900n 0.000710 341.2000n 0.000704 341.2100n 0.000698 341.2200n 0.000691 341.2300n 0.000684 341.2400n 0.000676
+ 341.2500n 0.000668 341.2600n 0.000659 341.2700n 0.000650 341.2800n 0.000640 341.2900n 0.000630 341.3000n 0.000619 341.3100n 0.000608 341.3200n 0.000596 341.3300n 0.000583 341.3400n 0.000571 341.3500n 0.000557 341.3600n 0.000544 341.3700n 0.000530 341.3800n 0.000515 341.3900n 0.000500
+ 341.4000n 0.000485 341.4100n 0.000469 341.4200n 0.000453 341.4300n 0.000436 341.4400n 0.000420 341.4500n 0.000402 341.4600n 0.000385 341.4700n 0.000367 341.4800n 0.000349 341.4900n 0.000330 341.5000n 0.000311 341.5100n 0.000292 341.5200n 0.000273 341.5300n 0.000253 341.5400n 0.000234
+ 341.5500n 0.000214 341.5600n 0.000194 341.5700n 0.000173 341.5800n 0.000153 341.5900n 0.000132 341.6000n 0.000112 341.6100n 0.000091 341.6200n 0.000070 341.6300n 0.000049 341.6400n 0.000028 341.6500n 0.000007 341.6600n -0.000014 341.6700n -0.000035 341.6800n -0.000057 341.6900n -0.000078
+ 341.7000n -0.000099 341.7100n -0.000119 341.7200n -0.000140 341.7300n -0.000161 341.7400n -0.000181 341.7500n -0.000202 341.7600n -0.000222 341.7700n -0.000242 341.7800n -0.000262 341.7900n -0.000282 341.8000n -0.000301 341.8100n -0.000320 341.8200n -0.000339 341.8300n -0.000358 341.8400n -0.000376
+ 341.8500n -0.000394 341.8600n -0.000412 341.8700n -0.000429 341.8800n -0.000446 341.8900n -0.000462 341.9000n -0.000478 341.9100n -0.000494 341.9200n -0.000509 341.9300n -0.000524 341.9400n -0.000539 341.9500n -0.000552 341.9600n -0.000566 341.9700n -0.000579 341.9800n -0.000591 341.9900n -0.000603
+ 342.0000n -0.000614 342.0100n -0.000625 342.0200n -0.000635 342.0300n -0.000644 342.0400n -0.000653 342.0500n -0.000662 342.0600n -0.000669 342.0700n -0.000677 342.0800n -0.000683 342.0900n -0.000689 342.1000n -0.000694 342.1100n -0.000699 342.1200n -0.000702 342.1300n -0.000706 342.1400n -0.000708
+ 342.1500n -0.000710 342.1600n -0.000711 342.1700n -0.000712 342.1800n -0.000711 342.1900n -0.000711 342.2000n -0.000709 342.2100n -0.000707 342.2200n -0.000704 342.2300n -0.000700 342.2400n -0.000695 342.2500n -0.000690 342.2600n -0.000684 342.2700n -0.000678 342.2800n -0.000671 342.2900n -0.000663
+ 342.3000n -0.000654 342.3100n -0.000645 342.3200n -0.000635 342.3300n -0.000624 342.3400n -0.000612 342.3500n -0.000600 342.3600n -0.000588 342.3700n -0.000574 342.3800n -0.000560 342.3900n -0.000545 342.4000n -0.000530 342.4100n -0.000514 342.4200n -0.000497 342.4300n -0.000480 342.4400n -0.000462
+ 342.4500n -0.000444 342.4600n -0.000425 342.4700n -0.000405 342.4800n -0.000385 342.4900n -0.000365 342.5000n -0.000343 342.5100n -0.000322 342.5200n -0.000300 342.5300n -0.000277 342.5400n -0.000254 342.5500n -0.000230 342.5600n -0.000206 342.5700n -0.000182 342.5800n -0.000157 342.5900n -0.000132
+ 342.6000n -0.000106 342.6100n -0.000080 342.6200n -0.000054 342.6300n -0.000027 342.6400n -0.000000 342.6500n 0.000027 342.6600n 0.000054 342.6700n 0.000082 342.6800n 0.000110 342.6900n 0.000138 342.7000n 0.000166 342.7100n 0.000194 342.7200n 0.000223 342.7300n 0.000252 342.7400n 0.000280
+ 342.7500n 0.000309 342.7600n 0.000338 342.7700n 0.000367 342.7800n 0.000396 342.7900n 0.000425 342.8000n 0.000453 342.8100n 0.000482 342.8200n 0.000511 342.8300n 0.000539 342.8400n 0.000568 342.8500n 0.000596 342.8600n 0.000624 342.8700n 0.000652 342.8800n 0.000680 342.8900n 0.000708
+ 342.9000n 0.000735 342.9100n 0.000762 342.9200n 0.000789 342.9300n 0.000815 342.9400n 0.000841 342.9500n 0.000867 342.9600n 0.000892 342.9700n 0.000917 342.9800n 0.000942 342.9900n 0.000966 343.0000n 0.000990 343.0100n 0.001013 343.0200n 0.001036 343.0300n 0.001058 343.0400n 0.001080
+ 343.0500n 0.001101 343.0600n 0.001121 343.0700n 0.001141 343.0800n 0.001161 343.0900n 0.001180 343.1000n 0.001198 343.1100n 0.001215 343.1200n 0.001232 343.1300n 0.001249 343.1400n 0.001264 343.1500n 0.001279 343.1600n 0.001293 343.1700n 0.001307 343.1800n 0.001320 343.1900n 0.001332
+ 343.2000n 0.001343 343.2100n 0.001354 343.2200n 0.001364 343.2300n 0.001373 343.2400n 0.001381 343.2500n 0.001388 343.2600n 0.001395 343.2700n 0.001401 343.2800n 0.001406 343.2900n 0.001410 343.3000n 0.001414 343.3100n 0.001417 343.3200n 0.001418 343.3300n 0.001420 343.3400n 0.001420
+ 343.3500n 0.001419 343.3600n 0.001418 343.3700n 0.001416 343.3800n 0.001412 343.3900n 0.001409 343.4000n 0.001404 343.4100n 0.001398 343.4200n 0.001392 343.4300n 0.001385 343.4400n 0.001377 343.4500n 0.001368 343.4600n 0.001359 343.4700n 0.001349 343.4800n 0.001337 343.4900n 0.001326
+ 343.5000n 0.001313 343.5100n 0.001300 343.5200n 0.001286 343.5300n 0.001271 343.5400n 0.001255 343.5500n 0.001239 343.5600n 0.001222 343.5700n 0.001204 343.5800n 0.001186 343.5900n 0.001167 343.6000n 0.001147 343.6100n 0.001127 343.6200n 0.001106 343.6300n 0.001085 343.6400n 0.001063
+ 343.6500n 0.001040 343.6600n 0.001017 343.6700n 0.000993 343.6800n 0.000969 343.6900n 0.000944 343.7000n 0.000919 343.7100n 0.000893 343.7200n 0.000867 343.7300n 0.000841 343.7400n 0.000814 343.7500n 0.000786 343.7600n 0.000759 343.7700n 0.000731 343.7800n 0.000702 343.7900n 0.000674
+ 343.8000n 0.000645 343.8100n 0.000616 343.8200n 0.000586 343.8300n 0.000556 343.8400n 0.000527 343.8500n 0.000497 343.8600n 0.000466 343.8700n 0.000436 343.8800n 0.000406 343.8900n 0.000375 343.9000n 0.000345 343.9100n 0.000314 343.9200n 0.000284 343.9300n 0.000253 343.9400n 0.000223
+ 343.9500n 0.000192 343.9600n 0.000162 343.9700n 0.000132 343.9800n 0.000102 343.9900n 0.000072 344.0000n 0.000042 344.0100n 0.000012 344.0200n -0.000017 344.0300n -0.000046 344.0400n -0.000075 344.0500n -0.000104 344.0600n -0.000132 344.0700n -0.000160 344.0800n -0.000188 344.0900n -0.000215
+ 344.1000n -0.000242 344.1100n -0.000268 344.1200n -0.000294 344.1300n -0.000320 344.1400n -0.000345 344.1500n -0.000370 344.1600n -0.000394 344.1700n -0.000417 344.1800n -0.000440 344.1900n -0.000463 344.2000n -0.000485 344.2100n -0.000506 344.2200n -0.000527 344.2300n -0.000547 344.2400n -0.000566
+ 344.2500n -0.000585 344.2600n -0.000603 344.2700n -0.000621 344.2800n -0.000638 344.2900n -0.000654 344.3000n -0.000669 344.3100n -0.000684 344.3200n -0.000698 344.3300n -0.000711 344.3400n -0.000723 344.3500n -0.000735 344.3600n -0.000746 344.3700n -0.000756 344.3800n -0.000765 344.3900n -0.000774
+ 344.4000n -0.000781 344.4100n -0.000788 344.4200n -0.000794 344.4300n -0.000799 344.4400n -0.000804 344.4500n -0.000808 344.4600n -0.000810 344.4700n -0.000812 344.4800n -0.000813 344.4900n -0.000814 344.5000n -0.000813 344.5100n -0.000812 344.5200n -0.000810 344.5300n -0.000807 344.5400n -0.000803
+ 344.5500n -0.000799 344.5600n -0.000793 344.5700n -0.000787 344.5800n -0.000780 344.5900n -0.000772 344.6000n -0.000764 344.6100n -0.000754 344.6200n -0.000744 344.6300n -0.000733 344.6400n -0.000721 344.6500n -0.000709 344.6600n -0.000696 344.6700n -0.000682 344.6800n -0.000667 344.6900n -0.000652
+ 344.7000n -0.000636 344.7100n -0.000620 344.7200n -0.000602 344.7300n -0.000584 344.7400n -0.000566 344.7500n -0.000547 344.7600n -0.000527 344.7700n -0.000506 344.7800n -0.000485 344.7900n -0.000464 344.8000n -0.000442 344.8100n -0.000419 344.8200n -0.000396 344.8300n -0.000372 344.8400n -0.000348
+ 344.8500n -0.000324 344.8600n -0.000299 344.8700n -0.000274 344.8800n -0.000248 344.8900n -0.000222 344.9000n -0.000195 344.9100n -0.000168 344.9200n -0.000141 344.9300n -0.000114 344.9400n -0.000086 344.9500n -0.000058 344.9600n -0.000030 344.9700n -0.000002 344.9800n 0.000027 344.9900n 0.000056
+ 345.0000n 0.000085 345.0100n 0.000114 345.0200n 0.000143 345.0300n 0.000172 345.0400n 0.000201 345.0500n 0.000230 345.0600n 0.000260 345.0700n 0.000289 345.0800n 0.000318 345.0900n 0.000347 345.1000n 0.000376 345.1100n 0.000405 345.1200n 0.000434 345.1300n 0.000463 345.1400n 0.000492
+ 345.1500n 0.000520 345.1600n 0.000548 345.1700n 0.000576 345.1800n 0.000604 345.1900n 0.000632 345.2000n 0.000659 345.2100n 0.000686 345.2200n 0.000712 345.2300n 0.000739 345.2400n 0.000764 345.2500n 0.000790 345.2600n 0.000815 345.2700n 0.000840 345.2800n 0.000864 345.2900n 0.000888
+ 345.3000n 0.000911 345.3100n 0.000934 345.3200n 0.000957 345.3300n 0.000979 345.3400n 0.001000 345.3500n 0.001021 345.3600n 0.001041 345.3700n 0.001061 345.3800n 0.001080 345.3900n 0.001099 345.4000n 0.001117 345.4100n 0.001134 345.4200n 0.001151 345.4300n 0.001167 345.4400n 0.001182
+ 345.4500n 0.001197 345.4600n 0.001211 345.4700n 0.001225 345.4800n 0.001237 345.4900n 0.001249 345.5000n 0.001261 345.5100n 0.001272 345.5200n 0.001282 345.5300n 0.001291 345.5400n 0.001299 345.5500n 0.001307 345.5600n 0.001314 345.5700n 0.001321 345.5800n 0.001327 345.5900n 0.001332
+ 345.6000n 0.001336 345.6100n 0.001339 345.6200n 0.001342 345.6300n 0.001344 345.6400n 0.001345 345.6500n 0.001346 345.6600n 0.001346 345.6700n 0.001345 345.6800n 0.001344 345.6900n 0.001341 345.7000n 0.001338 345.7100n 0.001335 345.7200n 0.001330 345.7300n 0.001325 345.7400n 0.001319
+ 345.7500n 0.001313 345.7600n 0.001306 345.7700n 0.001298 345.7800n 0.001290 345.7900n 0.001281 345.8000n 0.001271 345.8100n 0.001261 345.8200n 0.001250 345.8300n 0.001238 345.8400n 0.001226 345.8500n 0.001214 345.8600n 0.001200 345.8700n 0.001187 345.8800n 0.001172 345.8900n 0.001157
+ 345.9000n 0.001142 345.9100n 0.001126 345.9200n 0.001110 345.9300n 0.001093 345.9400n 0.001076 345.9500n 0.001058 345.9600n 0.001040 345.9700n 0.001022 345.9800n 0.001003 345.9900n 0.000983 346.0000n 0.000964 346.0100n 0.000944 346.0200n 0.000923 346.0300n 0.000903 346.0400n 0.000882
+ 346.0500n 0.000861 346.0600n 0.000839 346.0700n 0.000818 346.0800n 0.000796 346.0900n 0.000774 346.1000n 0.000752 346.1100n 0.000729 346.1200n 0.000707 346.1300n 0.000684 346.1400n 0.000661 346.1500n 0.000638 346.1600n 0.000616 346.1700n 0.000593 346.1800n 0.000570 346.1900n 0.000547
+ 346.2000n 0.000524 346.2100n 0.000501 346.2200n 0.000478 346.2300n 0.000455 346.2400n 0.000432 346.2500n 0.000409 346.2600n 0.000386 346.2700n 0.000364 346.2800n 0.000342 346.2900n 0.000319 346.3000n 0.000297 346.3100n 0.000276 346.3200n 0.000254 346.3300n 0.000233 346.3400n 0.000211
+ 346.3500n 0.000190 346.3600n 0.000170 346.3700n 0.000149 346.3800n 0.000129 346.3900n 0.000110 346.4000n 0.000090 346.4100n 0.000071 346.4200n 0.000053 346.4300n 0.000034 346.4400n 0.000016 346.4500n -0.000001 346.4600n -0.000019 346.4700n -0.000035 346.4800n -0.000052 346.4900n -0.000068
+ 346.5000n -0.000083 346.5100n -0.000098 346.5200n -0.000113 346.5300n -0.000127 346.5400n -0.000140 346.5500n -0.000153 346.5600n -0.000166 346.5700n -0.000178 346.5800n -0.000190 346.5900n -0.000201 346.6000n -0.000211 346.6100n -0.000221 346.6200n -0.000231 346.6300n -0.000240 346.6400n -0.000248
+ 346.6500n -0.000256 346.6600n -0.000264 346.6700n -0.000271 346.6800n -0.000277 346.6900n -0.000283 346.7000n -0.000288 346.7100n -0.000293 346.7200n -0.000297 346.7300n -0.000300 346.7400n -0.000303 346.7500n -0.000306 346.7600n -0.000308 346.7700n -0.000309 346.7800n -0.000310 346.7900n -0.000310
+ 346.8000n -0.000310 346.8100n -0.000309 346.8200n -0.000308 346.8300n -0.000306 346.8400n -0.000304 346.8500n -0.000301 346.8600n -0.000298 346.8700n -0.000294 346.8800n -0.000290 346.8900n -0.000285 346.9000n -0.000280 346.9100n -0.000275 346.9200n -0.000269 346.9300n -0.000262 346.9400n -0.000255
+ 346.9500n -0.000248 346.9600n -0.000240 346.9700n -0.000232 346.9800n -0.000223 346.9900n -0.000214 347.0000n -0.000205 347.0100n -0.000195 347.0200n -0.000185 347.0300n -0.000175 347.0400n -0.000164 347.0500n -0.000153 347.0600n -0.000142 347.0700n -0.000130 347.0800n -0.000118 347.0900n -0.000106
+ 347.1000n -0.000094 347.1100n -0.000081 347.1200n -0.000068 347.1300n -0.000055 347.1400n -0.000042 347.1500n -0.000028 347.1600n -0.000015 347.1700n -0.000001 347.1800n 0.000013 347.1900n 0.000027 347.2000n 0.000041 347.2100n 0.000056 347.2200n 0.000070 347.2300n 0.000084 347.2400n 0.000099
+ 347.2500n 0.000114 347.2600n 0.000128 347.2700n 0.000143 347.2800n 0.000157 347.2900n 0.000172 347.3000n 0.000187 347.3100n 0.000201 347.3200n 0.000216 347.3300n 0.000230 347.3400n 0.000245 347.3500n 0.000259 347.3600n 0.000273 347.3700n 0.000287 347.3800n 0.000301 347.3900n 0.000315
+ 347.4000n 0.000329 347.4100n 0.000343 347.4200n 0.000356 347.4300n 0.000370 347.4400n 0.000383 347.4500n 0.000396 347.4600n 0.000408 347.4700n 0.000421 347.4800n 0.000433 347.4900n 0.000445 347.5000n 0.000457 347.5100n 0.000469 347.5200n 0.000480 347.5300n 0.000491 347.5400n 0.000502
+ 347.5500n 0.000513 347.5600n 0.000523 347.5700n 0.000533 347.5800n 0.000543 347.5900n 0.000553 347.6000n 0.000562 347.6100n 0.000571 347.6200n 0.000579 347.6300n 0.000587 347.6400n 0.000595 347.6500n 0.000603 347.6600n 0.000610 347.6700n 0.000617 347.6800n 0.000624 347.6900n 0.000630
+ 347.7000n 0.000636 347.7100n 0.000642 347.7200n 0.000648 347.7300n 0.000653 347.7400n 0.000657 347.7500n 0.000662 347.7600n 0.000666 347.7700n 0.000670 347.7800n 0.000673 347.7900n 0.000676 347.8000n 0.000679 347.8100n 0.000682 347.8200n 0.000684 347.8300n 0.000686 347.8400n 0.000688
+ 347.8500n 0.000689 347.8600n 0.000690 347.8700n 0.000691 347.8800n 0.000692 347.8900n 0.000692 347.9000n 0.000692 347.9100n 0.000692 347.9200n 0.000691 347.9300n 0.000690 347.9400n 0.000689 347.9500n 0.000688 347.9600n 0.000687 347.9700n 0.000685 347.9800n 0.000684 347.9900n 0.000682
+ 348.0000n 0.000679 348.0100n 0.000677 348.0200n 0.000675 348.0300n 0.000672 348.0400n 0.000669 348.0500n 0.000666 348.0600n 0.000663 348.0700n 0.000660 348.0800n 0.000657 348.0900n 0.000654 348.1000n 0.000651 348.1100n 0.000647 348.1200n 0.000644 348.1300n 0.000640 348.1400n 0.000637
+ 348.1500n 0.000633 348.1600n 0.000630 348.1700n 0.000626 348.1800n 0.000623 348.1900n 0.000619 348.2000n 0.000616 348.2100n 0.000612 348.2200n 0.000609 348.2300n 0.000606 348.2400n 0.000603 348.2500n 0.000600 348.2600n 0.000597 348.2700n 0.000594 348.2800n 0.000591 348.2900n 0.000589
+ 348.3000n 0.000587 348.3100n 0.000585 348.3200n 0.000583 348.3300n 0.000581 348.3400n 0.000579 348.3500n 0.000578 348.3600n 0.000577 348.3700n 0.000576 348.3800n 0.000576 348.3900n 0.000575 348.4000n 0.000575 348.4100n 0.000576 348.4200n 0.000576 348.4300n 0.000577 348.4400n 0.000578
+ 348.4500n 0.000580 348.4600n 0.000582 348.4700n 0.000584 348.4800n 0.000586 348.4900n 0.000589 348.5000n 0.000592 348.5100n 0.000596 348.5200n 0.000600 348.5300n 0.000604 348.5400n 0.000609 348.5500n 0.000614 348.5600n 0.000619 348.5700n 0.000625 348.5800n 0.000632 348.5900n 0.000638
+ 348.6000n 0.000646 348.6100n 0.000653 348.6200n 0.000661 348.6300n 0.000670 348.6400n 0.000678 348.6500n 0.000688 348.6600n 0.000697 348.6700n 0.000707 348.6800n 0.000718 348.6900n 0.000729 348.7000n 0.000740 348.7100n 0.000752 348.7200n 0.000765 348.7300n 0.000777 348.7400n 0.000790
+ 348.7500n 0.000804 348.7600n 0.000818 348.7700n 0.000832 348.7800n 0.000847 348.7900n 0.000862 348.8000n 0.000878 348.8100n 0.000894 348.8200n 0.000910 348.8300n 0.000927 348.8400n 0.000944 348.8500n 0.000962 348.8600n 0.000980 348.8700n 0.000998 348.8800n 0.001017 348.8900n 0.001036
+ 348.9000n 0.001055 348.9100n 0.001075 348.9200n 0.001095 348.9300n 0.001116 348.9400n 0.001136 348.9500n 0.001157 348.9600n 0.001178 348.9700n 0.001200 348.9800n 0.001222 348.9900n 0.001244 349.0000n 0.001266 349.0100n 0.001289 349.0200n 0.001311 349.0300n 0.001334 349.0400n 0.001357
+ 349.0500n 0.001381 349.0600n 0.001404 349.0700n 0.001428 349.0800n 0.001451 349.0900n 0.001475 349.1000n 0.001499 349.1100n 0.001523 349.1200n 0.001547 349.1300n 0.001572 349.1400n 0.001596 349.1500n 0.001620 349.1600n 0.001644 349.1700n 0.001669 349.1800n 0.001693 349.1900n 0.001717
+ 349.2000n 0.001742 349.2100n 0.001766 349.2200n 0.001790 349.2300n 0.001814 349.2400n 0.001838 349.2500n 0.001861 349.2600n 0.001885 349.2700n 0.001908 349.2800n 0.001932 349.2900n 0.001955 349.3000n 0.001978 349.3100n 0.002000 349.3200n 0.002023 349.3300n 0.002045 349.3400n 0.002067
+ 349.3500n 0.002088 349.3600n 0.002110 349.3700n 0.002131 349.3800n 0.002151 349.3900n 0.002172 349.4000n 0.002192 349.4100n 0.002211 349.4200n 0.002230 349.4300n 0.002249 349.4400n 0.002267 349.4500n 0.002285 349.4600n 0.002303 349.4700n 0.002319 349.4800n 0.002336 349.4900n 0.002352
+ 349.5000n 0.002367 349.5100n 0.002382 349.5200n 0.002397 349.5300n 0.002410 349.5400n 0.002424 349.5500n 0.002436 349.5600n 0.002448 349.5700n 0.002460 349.5800n 0.002471 349.5900n 0.002481 349.6000n 0.002491 349.6100n 0.002500 349.6200n 0.002508 349.6300n 0.002516 349.6400n 0.002523
+ 349.6500n 0.002529 349.6600n 0.002535 349.6700n 0.002540 349.6800n 0.002544 349.6900n 0.002548 349.7000n 0.002551 349.7100n 0.002553 349.7200n 0.002554 349.7300n 0.002555 349.7400n 0.002555 349.7500n 0.002554 349.7600n 0.002553 349.7700n 0.002550 349.7800n 0.002547 349.7900n 0.002544
+ 349.8000n 0.002539 349.8100n 0.002534 349.8200n 0.002528 349.8300n 0.002521 349.8400n 0.002514 349.8500n 0.002505 349.8600n 0.002496 349.8700n 0.002487 349.8800n 0.002476 349.8900n 0.002465 349.9000n 0.002453 349.9100n 0.002440 349.9200n 0.002426 349.9300n 0.002412 349.9400n 0.002397
+ 349.9500n 0.002381 349.9600n 0.002365 349.9700n 0.002348 349.9800n 0.002330 349.9900n 0.002311 350.0000n 0.002292 350.0100n 0.002272 350.0200n 0.002251 350.0300n 0.002230 350.0400n 0.002208 350.0500n 0.002186 350.0600n 0.002162 350.0700n 0.002138 350.0800n 0.002114 350.0900n 0.002089
+ 350.1000n 0.002063 350.1100n 0.002037 350.1200n 0.002010 350.1300n 0.001982 350.1400n 0.001954 350.1500n 0.001926 350.1600n 0.001897 350.1700n 0.001867 350.1800n 0.001837 350.1900n 0.001806 350.2000n 0.001775 350.2100n 0.001744 350.2200n 0.001712 350.2300n 0.001679 350.2400n 0.001646
+ 350.2500n 0.001613 350.2600n 0.001580 350.2700n 0.001546 350.2800n 0.001511 350.2900n 0.001477 350.3000n 0.001442 350.3100n 0.001407 350.3200n 0.001371 350.3300n 0.001335 350.3400n 0.001299 350.3500n 0.001263 350.3600n 0.001226 350.3700n 0.001190 350.3800n 0.001153 350.3900n 0.001116
+ 350.4000n 0.001079 350.4100n 0.001042 350.4200n 0.001004 350.4300n 0.000967 350.4400n 0.000929 350.4500n 0.000892 350.4600n 0.000854 350.4700n 0.000817 350.4800n 0.000779 350.4900n 0.000742 350.5000n 0.000704 350.5100n 0.000667 350.5200n 0.000629 350.5300n 0.000592 350.5400n 0.000555
+ 350.5500n 0.000518 350.5600n 0.000481 350.5700n 0.000444 350.5800n 0.000408 350.5900n 0.000372 350.6000n 0.000336 350.6100n 0.000300 350.6200n 0.000264 350.6300n 0.000229 350.6400n 0.000194 350.6500n 0.000159 350.6600n 0.000125 350.6700n 0.000091 350.6800n 0.000057 350.6900n 0.000024
+ 350.7000n -0.000009 350.7100n -0.000042 350.7200n -0.000074 350.7300n -0.000105 350.7400n -0.000137 350.7500n -0.000167 350.7600n -0.000198 350.7700n -0.000228 350.7800n -0.000257 350.7900n -0.000286 350.8000n -0.000314 350.8100n -0.000342 350.8200n -0.000369 350.8300n -0.000396 350.8400n -0.000422
+ 350.8500n -0.000447 350.8600n -0.000472 350.8700n -0.000497 350.8800n -0.000520 350.8900n -0.000543 350.9000n -0.000566 350.9100n -0.000588 350.9200n -0.000609 350.9300n -0.000630 350.9400n -0.000649 350.9500n -0.000669 350.9600n -0.000687 350.9700n -0.000705 350.9800n -0.000722 350.9900n -0.000739
+ 351.0000n -0.000755 351.0100n -0.000770 351.0200n -0.000784 351.0300n -0.000798 351.0400n -0.000811 351.0500n -0.000823 351.0600n -0.000835 351.0700n -0.000846 351.0800n -0.000856 351.0900n -0.000865 351.1000n -0.000874 351.1100n -0.000882 351.1200n -0.000889 351.1300n -0.000896 351.1400n -0.000901
+ 351.1500n -0.000906 351.1600n -0.000911 351.1700n -0.000914 351.1800n -0.000917 351.1900n -0.000920 351.2000n -0.000921 351.2100n -0.000922 351.2200n -0.000922 351.2300n -0.000921 351.2400n -0.000920 351.2500n -0.000918 351.2600n -0.000915 351.2700n -0.000912 351.2800n -0.000908 351.2900n -0.000903
+ 351.3000n -0.000898 351.3100n -0.000892 351.3200n -0.000885 351.3300n -0.000878 351.3400n -0.000870 351.3500n -0.000861 351.3600n -0.000852 351.3700n -0.000842 351.3800n -0.000832 351.3900n -0.000821 351.4000n -0.000809 351.4100n -0.000797 351.4200n -0.000784 351.4300n -0.000771 351.4400n -0.000757
+ 351.4500n -0.000743 351.4600n -0.000728 351.4700n -0.000712 351.4800n -0.000696 351.4900n -0.000680 351.5000n -0.000663 351.5100n -0.000645 351.5200n -0.000628 351.5300n -0.000609 351.5400n -0.000590 351.5500n -0.000571 351.5600n -0.000552 351.5700n -0.000532 351.5800n -0.000511 351.5900n -0.000491
+ 351.6000n -0.000469 351.6100n -0.000448 351.6200n -0.000426 351.6300n -0.000404 351.6400n -0.000382 351.6500n -0.000359 351.6600n -0.000336 351.6700n -0.000313 351.6800n -0.000289 351.6900n -0.000265 351.7000n -0.000241 351.7100n -0.000217 351.7200n -0.000192 351.7300n -0.000168 351.7400n -0.000143
+ 351.7500n -0.000118 351.7600n -0.000093 351.7700n -0.000067 351.7800n -0.000042 351.7900n -0.000016 351.8000n 0.000009 351.8100n 0.000035 351.8200n 0.000061 351.8300n 0.000087 351.8400n 0.000113 351.8500n 0.000139 351.8600n 0.000165 351.8700n 0.000191 351.8800n 0.000217 351.8900n 0.000243
+ 351.9000n 0.000269 351.9100n 0.000295 351.9200n 0.000321 351.9300n 0.000347 351.9400n 0.000373 351.9500n 0.000398 351.9600n 0.000424 351.9700n 0.000450 351.9800n 0.000475 351.9900n 0.000500 352.0000n 0.000525 352.0100n 0.000550 352.0200n 0.000575 352.0300n 0.000600 352.0400n 0.000624
+ 352.0500n 0.000649 352.0600n 0.000673 352.0700n 0.000697 352.0800n 0.000720 352.0900n 0.000744 352.1000n 0.000767 352.1100n 0.000790 352.1200n 0.000813 352.1300n 0.000835 352.1400n 0.000857 352.1500n 0.000879 352.1600n 0.000901 352.1700n 0.000922 352.1800n 0.000943 352.1900n 0.000964
+ 352.2000n 0.000984 352.2100n 0.001004 352.2200n 0.001024 352.2300n 0.001043 352.2400n 0.001063 352.2500n 0.001081 352.2600n 0.001100 352.2700n 0.001118 352.2800n 0.001135 352.2900n 0.001152 352.3000n 0.001169 352.3100n 0.001186 352.3200n 0.001202 352.3300n 0.001218 352.3400n 0.001233
+ 352.3500n 0.001248 352.3600n 0.001262 352.3700n 0.001276 352.3800n 0.001290 352.3900n 0.001303 352.4000n 0.001316 352.4100n 0.001329 352.4200n 0.001341 352.4300n 0.001352 352.4400n 0.001363 352.4500n 0.001374 352.4600n 0.001384 352.4700n 0.001394 352.4800n 0.001404 352.4900n 0.001413
+ 352.5000n 0.001421 352.5100n 0.001429 352.5200n 0.001437 352.5300n 0.001444 352.5400n 0.001451 352.5500n 0.001457 352.5600n 0.001463 352.5700n 0.001468 352.5800n 0.001473 352.5900n 0.001478 352.6000n 0.001482 352.6100n 0.001485 352.6200n 0.001489 352.6300n 0.001491 352.6400n 0.001493
+ 352.6500n 0.001495 352.6600n 0.001497 352.6700n 0.001498 352.6800n 0.001498 352.6900n 0.001498 352.7000n 0.001498 352.7100n 0.001497 352.7200n 0.001496 352.7300n 0.001494 352.7400n 0.001492 352.7500n 0.001489 352.7600n 0.001486 352.7700n 0.001483 352.7800n 0.001479 352.7900n 0.001475
+ 352.8000n 0.001470 352.8100n 0.001465 352.8200n 0.001460 352.8300n 0.001454 352.8400n 0.001447 352.8500n 0.001440 352.8600n 0.001433 352.8700n 0.001426 352.8800n 0.001418 352.8900n 0.001409 352.9000n 0.001401 352.9100n 0.001392 352.9200n 0.001382 352.9300n 0.001372 352.9400n 0.001362
+ 352.9500n 0.001351 352.9600n 0.001340 352.9700n 0.001329 352.9800n 0.001317 352.9900n 0.001305 353.0000n 0.001292 353.0100n 0.001280 353.0200n 0.001266 353.0300n 0.001253 353.0400n 0.001239 353.0500n 0.001225 353.0600n 0.001210 353.0700n 0.001195 353.0800n 0.001180 353.0900n 0.001165
+ 353.1000n 0.001149 353.1100n 0.001133 353.1200n 0.001116 353.1300n 0.001099 353.1400n 0.001082 353.1500n 0.001065 353.1600n 0.001047 353.1700n 0.001029 353.1800n 0.001011 353.1900n 0.000992 353.2000n 0.000973 353.2100n 0.000954 353.2200n 0.000935 353.2300n 0.000915 353.2400n 0.000895
+ 353.2500n 0.000875 353.2600n 0.000855 353.2700n 0.000834 353.2800n 0.000813 353.2900n 0.000792 353.3000n 0.000771 353.3100n 0.000749 353.3200n 0.000727 353.3300n 0.000705 353.3400n 0.000683 353.3500n 0.000660 353.3600n 0.000638 353.3700n 0.000615 353.3800n 0.000592 353.3900n 0.000568
+ 353.4000n 0.000545 353.4100n 0.000521 353.4200n 0.000497 353.4300n 0.000473 353.4400n 0.000449 353.4500n 0.000424 353.4600n 0.000400 353.4700n 0.000375 353.4800n 0.000350 353.4900n 0.000325 353.5000n 0.000300 353.5100n 0.000275 353.5200n 0.000249 353.5300n 0.000224 353.5400n 0.000198
+ 353.5500n 0.000172 353.5600n 0.000147 353.5700n 0.000121 353.5800n 0.000094 353.5900n 0.000068 353.6000n 0.000042 353.6100n 0.000015 353.6200n -0.000011 353.6300n -0.000038 353.6400n -0.000064 353.6500n -0.000091 353.6600n -0.000118 353.6700n -0.000145 353.6800n -0.000171 353.6900n -0.000198
+ 353.7000n -0.000225 353.7100n -0.000252 353.7200n -0.000279 353.7300n -0.000306 353.7400n -0.000334 353.7500n -0.000361 353.7600n -0.000388 353.7700n -0.000415 353.7800n -0.000442 353.7900n -0.000469 353.8000n -0.000496 353.8100n -0.000523 353.8200n -0.000550 353.8300n -0.000577 353.8400n -0.000604
+ 353.8500n -0.000631 353.8600n -0.000658 353.8700n -0.000685 353.8800n -0.000712 353.8900n -0.000739 353.9000n -0.000765 353.9100n -0.000792 353.9200n -0.000818 353.9300n -0.000845 353.9400n -0.000871 353.9500n -0.000897 353.9600n -0.000923 353.9700n -0.000949 353.9800n -0.000975 353.9900n -0.001001
+ 354.0000n -0.001027 354.0100n -0.001052 354.0200n -0.001078 354.0300n -0.001103 354.0400n -0.001128 354.0500n -0.001153 354.0600n -0.001178 354.0700n -0.001202 354.0800n -0.001227 354.0900n -0.001251 354.1000n -0.001275 354.1100n -0.001299 354.1200n -0.001323 354.1300n -0.001346 354.1400n -0.001369
+ 354.1500n -0.001392 354.1600n -0.001415 354.1700n -0.001438 354.1800n -0.001460 354.1900n -0.001482 354.2000n -0.001504 354.2100n -0.001526 354.2200n -0.001547 354.2300n -0.001568 354.2400n -0.001589 354.2500n -0.001610 354.2600n -0.001630 354.2700n -0.001650 354.2800n -0.001670 354.2900n -0.001689
+ 354.3000n -0.001709 354.3100n -0.001727 354.3200n -0.001746 354.3300n -0.001764 354.3400n -0.001782 354.3500n -0.001800 354.3600n -0.001817 354.3700n -0.001834 354.3800n -0.001851 354.3900n -0.001867 354.4000n -0.001883 354.4100n -0.001898 354.4200n -0.001914 354.4300n -0.001928 354.4400n -0.001943
+ 354.4500n -0.001957 354.4600n -0.001971 354.4700n -0.001984 354.4800n -0.001997 354.4900n -0.002010 354.5000n -0.002022 354.5100n -0.002034 354.5200n -0.002046 354.5300n -0.002057 354.5400n -0.002067 354.5500n -0.002078 354.5600n -0.002088 354.5700n -0.002097 354.5800n -0.002106 354.5900n -0.002115
+ 354.6000n -0.002123 354.6100n -0.002131 354.6200n -0.002138 354.6300n -0.002145 354.6400n -0.002152 354.6500n -0.002158 354.6600n -0.002164 354.6700n -0.002169 354.6800n -0.002174 354.6900n -0.002178 354.7000n -0.002182 354.7100n -0.002186 354.7200n -0.002189 354.7300n -0.002191 354.7400n -0.002194
+ 354.7500n -0.002195 354.7600n -0.002197 354.7700n -0.002198 354.7800n -0.002198 354.7900n -0.002198 354.8000n -0.002198 354.8100n -0.002197 354.8200n -0.002196 354.8300n -0.002194 354.8400n -0.002192 354.8500n -0.002189 354.8600n -0.002186 354.8700n -0.002182 354.8800n -0.002179 354.8900n -0.002174
+ 354.9000n -0.002169 354.9100n -0.002164 354.9200n -0.002159 354.9300n -0.002153 354.9400n -0.002146 354.9500n -0.002139 354.9600n -0.002132 354.9700n -0.002124 354.9800n -0.002116 354.9900n -0.002107 355.0000n -0.002098 355.0100n -0.002089 355.0200n -0.002079 355.0300n -0.002069 355.0400n -0.002058
+ 355.0500n -0.002047 355.0600n -0.002036 355.0700n -0.002024 355.0800n -0.002012 355.0900n -0.001999 355.1000n -0.001987 355.1100n -0.001973 355.1200n -0.001960 355.1300n -0.001946 355.1400n -0.001931 355.1500n -0.001916 355.1600n -0.001901 355.1700n -0.001886 355.1800n -0.001870 355.1900n -0.001854
+ 355.2000n -0.001838 355.2100n -0.001821 355.2200n -0.001804 355.2300n -0.001787 355.2400n -0.001769 355.2500n -0.001751 355.2600n -0.001733 355.2700n -0.001714 355.2800n -0.001695 355.2900n -0.001676 355.3000n -0.001656 355.3100n -0.001637 355.3200n -0.001617 355.3300n -0.001597 355.3400n -0.001576
+ 355.3500n -0.001555 355.3600n -0.001535 355.3700n -0.001513 355.3800n -0.001492 355.3900n -0.001470 355.4000n -0.001449 355.4100n -0.001426 355.4200n -0.001404 355.4300n -0.001382 355.4400n -0.001359 355.4500n -0.001336 355.4600n -0.001313 355.4700n -0.001290 355.4800n -0.001267 355.4900n -0.001244
+ 355.5000n -0.001220 355.5100n -0.001196 355.5200n -0.001173 355.5300n -0.001149 355.5400n -0.001124 355.5500n -0.001100 355.5600n -0.001076 355.5700n -0.001052 355.5800n -0.001027 355.5900n -0.001003 355.6000n -0.000978 355.6100n -0.000953 355.6200n -0.000928 355.6300n -0.000904 355.6400n -0.000879
+ 355.6500n -0.000854 355.6600n -0.000829 355.6700n -0.000804 355.6800n -0.000779 355.6900n -0.000754 355.7000n -0.000729 355.7100n -0.000704 355.7200n -0.000679 355.7300n -0.000653 355.7400n -0.000628 355.7500n -0.000603 355.7600n -0.000578 355.7700n -0.000554 355.7800n -0.000529 355.7900n -0.000504
+ 355.8000n -0.000479 355.8100n -0.000454 355.8200n -0.000430 355.8300n -0.000405 355.8400n -0.000380 355.8500n -0.000356 355.8600n -0.000332 355.8700n -0.000307 355.8800n -0.000283 355.8900n -0.000259 355.9000n -0.000235 355.9100n -0.000211 355.9200n -0.000187 355.9300n -0.000164 355.9400n -0.000140
+ 355.9500n -0.000117 355.9600n -0.000094 355.9700n -0.000071 355.9800n -0.000048 355.9900n -0.000025 356.0000n -0.000002 356.0100n 0.000020 356.0200n 0.000042 356.0300n 0.000065 356.0400n 0.000087 356.0500n 0.000108 356.0600n 0.000130 356.0700n 0.000151 356.0800n 0.000173 356.0900n 0.000194
+ 356.1000n 0.000215 356.1100n 0.000235 356.1200n 0.000256 356.1300n 0.000276 356.1400n 0.000296 356.1500n 0.000316 356.1600n 0.000336 356.1700n 0.000355 356.1800n 0.000374 356.1900n 0.000393 356.2000n 0.000412 356.2100n 0.000431 356.2200n 0.000449 356.2300n 0.000467 356.2400n 0.000485
+ 356.2500n 0.000503 356.2600n 0.000520 356.2700n 0.000538 356.2800n 0.000555 356.2900n 0.000571 356.3000n 0.000588 356.3100n 0.000604 356.3200n 0.000620 356.3300n 0.000636 356.3400n 0.000652 356.3500n 0.000667 356.3600n 0.000682 356.3700n 0.000697 356.3800n 0.000712 356.3900n 0.000726
+ 356.4000n 0.000740 356.4100n 0.000754 356.4200n 0.000768 356.4300n 0.000781 356.4400n 0.000795 356.4500n 0.000808 356.4600n 0.000820 356.4700n 0.000833 356.4800n 0.000845 356.4900n 0.000857 356.5000n 0.000869 356.5100n 0.000881 356.5200n 0.000892 356.5300n 0.000903 356.5400n 0.000914
+ 356.5500n 0.000924 356.5600n 0.000935 356.5700n 0.000945 356.5800n 0.000955 356.5900n 0.000965 356.6000n 0.000974 356.6100n 0.000984 356.6200n 0.000993 356.6300n 0.001002 356.6400n 0.001010 356.6500n 0.001019 356.6600n 0.001027 356.6700n 0.001035 356.6800n 0.001043 356.6900n 0.001050
+ 356.7000n 0.001058 356.7100n 0.001065 356.7200n 0.001072 356.7300n 0.001079 356.7400n 0.001086 356.7500n 0.001092 356.7600n 0.001098 356.7700n 0.001104 356.7800n 0.001110 356.7900n 0.001116 356.8000n 0.001122 356.8100n 0.001127 356.8200n 0.001132 356.8300n 0.001137 356.8400n 0.001142
+ 356.8500n 0.001147 356.8600n 0.001151 356.8700n 0.001156 356.8800n 0.001160 356.8900n 0.001164 356.9000n 0.001168 356.9100n 0.001172 356.9200n 0.001175 356.9300n 0.001179 356.9400n 0.001182 356.9500n 0.001186 356.9600n 0.001189 356.9700n 0.001192 356.9800n 0.001195 356.9900n 0.001197
+ 357.0000n 0.001200 357.0100n 0.001203 357.0200n 0.001205 357.0300n 0.001207 357.0400n 0.001210 357.0500n 0.001212 357.0600n 0.001214 357.0700n 0.001216 357.0800n 0.001217 357.0900n 0.001219 357.1000n 0.001221 357.1100n 0.001222 357.1200n 0.001224 357.1300n 0.001225 357.1400n 0.001227
+ 357.1500n 0.001228 357.1600n 0.001229 357.1700n 0.001230 357.1800n 0.001231 357.1900n 0.001232 357.2000n 0.001233 357.2100n 0.001234 357.2200n 0.001235 357.2300n 0.001236 357.2400n 0.001237 357.2500n 0.001238 357.2600n 0.001238 357.2700n 0.001239 357.2800n 0.001240 357.2900n 0.001240
+ 357.3000n 0.001241 357.3100n 0.001241 357.3200n 0.001242 357.3300n 0.001242 357.3400n 0.001243 357.3500n 0.001243 357.3600n 0.001244 357.3700n 0.001244 357.3800n 0.001244 357.3900n 0.001245 357.4000n 0.001245 357.4100n 0.001246 357.4200n 0.001246 357.4300n 0.001246 357.4400n 0.001247
+ 357.4500n 0.001247 357.4600n 0.001248 357.4700n 0.001248 357.4800n 0.001248 357.4900n 0.001249 357.5000n 0.001249 357.5100n 0.001250 357.5200n 0.001250 357.5300n 0.001251 357.5400n 0.001251 357.5500n 0.001252 357.5600n 0.001252 357.5700n 0.001253 357.5800n 0.001253 357.5900n 0.001254
+ 357.6000n 0.001255 357.6100n 0.001255 357.6200n 0.001256 357.6300n 0.001257 357.6400n 0.001257 357.6500n 0.001258 357.6600n 0.001259 357.6700n 0.001260 357.6800n 0.001260 357.6900n 0.001261 357.7000n 0.001262 357.7100n 0.001263 357.7200n 0.001264 357.7300n 0.001265 357.7400n 0.001266
+ 357.7500n 0.001267 357.7600n 0.001268 357.7700n 0.001269 357.7800n 0.001270 357.7900n 0.001271 357.8000n 0.001272 357.8100n 0.001274 357.8200n 0.001275 357.8300n 0.001276 357.8400n 0.001277 357.8500n 0.001279 357.8600n 0.001280 357.8700n 0.001281 357.8800n 0.001283 357.8900n 0.001284
+ 357.9000n 0.001286 357.9100n 0.001287 357.9200n 0.001288 357.9300n 0.001290 357.9400n 0.001291 357.9500n 0.001293 357.9600n 0.001294 357.9700n 0.001296 357.9800n 0.001297 357.9900n 0.001299 358.0000n 0.001301 358.0100n 0.001302 358.0200n 0.001304 358.0300n 0.001305 358.0400n 0.001307
+ 358.0500n 0.001308 358.0600n 0.001310 358.0700n 0.001312 358.0800n 0.001313 358.0900n 0.001315 358.1000n 0.001316 358.1100n 0.001318 358.1200n 0.001319 358.1300n 0.001321 358.1400n 0.001322 358.1500n 0.001324 358.1600n 0.001325 358.1700n 0.001327 358.1800n 0.001328 358.1900n 0.001330
+ 358.2000n 0.001331 358.2100n 0.001333 358.2200n 0.001334 358.2300n 0.001335 358.2400n 0.001337 358.2500n 0.001338 358.2600n 0.001339 358.2700n 0.001340 358.2800n 0.001341 358.2900n 0.001342 358.3000n 0.001343 358.3100n 0.001344 358.3200n 0.001345 358.3300n 0.001346 358.3400n 0.001347
+ 358.3500n 0.001348 358.3600n 0.001348 358.3700n 0.001349 358.3800n 0.001350 358.3900n 0.001350 358.4000n 0.001351 358.4100n 0.001351 358.4200n 0.001351 358.4300n 0.001351 358.4400n 0.001352 358.4500n 0.001352 358.4600n 0.001352 358.4700n 0.001352 358.4800n 0.001351 358.4900n 0.001351
+ 358.5000n 0.001351 358.5100n 0.001350 358.5200n 0.001350 358.5300n 0.001349 358.5400n 0.001348 358.5500n 0.001348 358.5600n 0.001347 358.5700n 0.001346 358.5800n 0.001345 358.5900n 0.001343 358.6000n 0.001342 358.6100n 0.001341 358.6200n 0.001339 358.6300n 0.001337 358.6400n 0.001336
+ 358.6500n 0.001334 358.6600n 0.001332 358.6700n 0.001330 358.6800n 0.001327 358.6900n 0.001325 358.7000n 0.001323 358.7100n 0.001320 358.7200n 0.001318 358.7300n 0.001315 358.7400n 0.001312 358.7500n 0.001309 358.7600n 0.001306 358.7700n 0.001302 358.7800n 0.001299 358.7900n 0.001295
+ 358.8000n 0.001292 358.8100n 0.001288 358.8200n 0.001284 358.8300n 0.001280 358.8400n 0.001276 358.8500n 0.001272 358.8600n 0.001268 358.8700n 0.001263 358.8800n 0.001258 358.8900n 0.001254 358.9000n 0.001249 358.9100n 0.001244 358.9200n 0.001239 358.9300n 0.001234 358.9400n 0.001228
+ 358.9500n 0.001223 358.9600n 0.001217 358.9700n 0.001212 358.9800n 0.001206 358.9900n 0.001200 359.0000n 0.001194 359.0100n 0.001188 359.0200n 0.001182 359.0300n 0.001175 359.0400n 0.001169 359.0500n 0.001162 359.0600n 0.001156 359.0700n 0.001149 359.0800n 0.001142 359.0900n 0.001135
+ 359.1000n 0.001128 359.1100n 0.001121 359.1200n 0.001113 359.1300n 0.001106 359.1400n 0.001099 359.1500n 0.001091 359.1600n 0.001083 359.1700n 0.001076 359.1800n 0.001068 359.1900n 0.001060 359.2000n 0.001052 359.2100n 0.001044 359.2200n 0.001036 359.2300n 0.001028 359.2400n 0.001020
+ 359.2500n 0.001011 359.2600n 0.001003 359.2700n 0.000995 359.2800n 0.000986 359.2900n 0.000978 359.3000n 0.000969 359.3100n 0.000960 359.3200n 0.000952 359.3300n 0.000943 359.3400n 0.000934 359.3500n 0.000925 359.3600n 0.000916 359.3700n 0.000908 359.3800n 0.000899 359.3900n 0.000890
+ 359.4000n 0.000881 359.4100n 0.000872 359.4200n 0.000863 359.4300n 0.000854 359.4400n 0.000845 359.4500n 0.000836 359.4600n 0.000827 359.4700n 0.000818 359.4800n 0.000808 359.4900n 0.000799 359.5000n 0.000790 359.5100n 0.000781 359.5200n 0.000772 359.5300n 0.000763 359.5400n 0.000754
+ 359.5500n 0.000745 359.5600n 0.000736 359.5700n 0.000727 359.5800n 0.000718 359.5900n 0.000709 359.6000n 0.000701 359.6100n 0.000692 359.6200n 0.000683 359.6300n 0.000674 359.6400n 0.000665 359.6500n 0.000657 359.6600n 0.000648 359.6700n 0.000639 359.6800n 0.000631 359.6900n 0.000622
+ 359.7000n 0.000614 359.7100n 0.000606 359.7200n 0.000597 359.7300n 0.000589 359.7400n 0.000581 359.7500n 0.000573 359.7600n 0.000565 359.7700n 0.000557 359.7800n 0.000549 359.7900n 0.000541 359.8000n 0.000533 359.8100n 0.000525 359.8200n 0.000517 359.8300n 0.000510 359.8400n 0.000502
+ 359.8500n 0.000495 359.8600n 0.000487 359.8700n 0.000480 359.8800n 0.000473 359.8900n 0.000466 359.9000n 0.000459 359.9100n 0.000452 359.9200n 0.000445 359.9300n 0.000438 359.9400n 0.000431 359.9500n 0.000425 359.9600n 0.000418 359.9700n 0.000411 359.9800n 0.000405 359.9900n 0.000399
+ 360.0000n 0.000392 360.0100n 0.000386 360.0200n 0.000380 360.0300n 0.000374 360.0400n 0.000368 360.0500n 0.000362 360.0600n 0.000356 360.0700n 0.000351 360.0800n 0.000345 360.0900n 0.000339 360.1000n 0.000334 360.1100n 0.000328 360.1200n 0.000323 360.1300n 0.000318 360.1400n 0.000313
+ 360.1500n 0.000307 360.1600n 0.000302 360.1700n 0.000297 360.1800n 0.000292 360.1900n 0.000287 360.2000n 0.000282 360.2100n 0.000278 360.2200n 0.000273 360.2300n 0.000268 360.2400n 0.000263 360.2500n 0.000259 360.2600n 0.000254 360.2700n 0.000250 360.2800n 0.000245 360.2900n 0.000241
+ 360.3000n 0.000236 360.3100n 0.000232 360.3200n 0.000227 360.3300n 0.000223 360.3400n 0.000219 360.3500n 0.000214 360.3600n 0.000210 360.3700n 0.000206 360.3800n 0.000202 360.3900n 0.000197 360.4000n 0.000193 360.4100n 0.000189 360.4200n 0.000185 360.4300n 0.000180 360.4400n 0.000176
+ 360.4500n 0.000172 360.4600n 0.000168 360.4700n 0.000163 360.4800n 0.000159 360.4900n 0.000155 360.5000n 0.000150 360.5100n 0.000146 360.5200n 0.000142 360.5300n 0.000137 360.5400n 0.000133 360.5500n 0.000129 360.5600n 0.000124 360.5700n 0.000120 360.5800n 0.000115 360.5900n 0.000110
+ 360.6000n 0.000106 360.6100n 0.000101 360.6200n 0.000096 360.6300n 0.000092 360.6400n 0.000087 360.6500n 0.000082 360.6600n 0.000077 360.6700n 0.000072 360.6800n 0.000067 360.6900n 0.000062 360.7000n 0.000056 360.7100n 0.000051 360.7200n 0.000046 360.7300n 0.000041 360.7400n 0.000035
+ 360.7500n 0.000030 360.7600n 0.000024 360.7700n 0.000018 360.7800n 0.000013 360.7900n 0.000007 360.8000n 0.000001 360.8100n -0.000005 360.8200n -0.000011 360.8300n -0.000017 360.8400n -0.000023 360.8500n -0.000029 360.8600n -0.000036 360.8700n -0.000042 360.8800n -0.000048 360.8900n -0.000055
+ 360.9000n -0.000062 360.9100n -0.000068 360.9200n -0.000075 360.9300n -0.000082 360.9400n -0.000089 360.9500n -0.000096 360.9600n -0.000102 360.9700n -0.000110 360.9800n -0.000117 360.9900n -0.000124 361.0000n -0.000131 361.0100n -0.000138 361.0200n -0.000146 361.0300n -0.000153 361.0400n -0.000160
+ 361.0500n -0.000168 361.0600n -0.000175 361.0700n -0.000183 361.0800n -0.000190 361.0900n -0.000198 361.1000n -0.000206 361.1100n -0.000213 361.1200n -0.000221 361.1300n -0.000229 361.1400n -0.000236 361.1500n -0.000244 361.1600n -0.000252 361.1700n -0.000259 361.1800n -0.000267 361.1900n -0.000275
+ 361.2000n -0.000282 361.2100n -0.000290 361.2200n -0.000298 361.2300n -0.000305 361.2400n -0.000313 361.2500n -0.000321 361.2600n -0.000328 361.2700n -0.000335 361.2800n -0.000343 361.2900n -0.000350 361.3000n -0.000358 361.3100n -0.000365 361.3200n -0.000372 361.3300n -0.000379 361.3400n -0.000386
+ 361.3500n -0.000393 361.3600n -0.000400 361.3700n -0.000406 361.3800n -0.000413 361.3900n -0.000419 361.4000n -0.000425 361.4100n -0.000432 361.4200n -0.000438 361.4300n -0.000444 361.4400n -0.000449 361.4500n -0.000455 361.4600n -0.000461 361.4700n -0.000466 361.4800n -0.000471 361.4900n -0.000476
+ 361.5000n -0.000481 361.5100n -0.000485 361.5200n -0.000490 361.5300n -0.000494 361.5400n -0.000498 361.5500n -0.000502 361.5600n -0.000505 361.5700n -0.000508 361.5800n -0.000512 361.5900n -0.000514 361.6000n -0.000517 361.6100n -0.000519 361.6200n -0.000522 361.6300n -0.000523 361.6400n -0.000525
+ 361.6500n -0.000526 361.6600n -0.000527 361.6700n -0.000528 361.6800n -0.000529 361.6900n -0.000529 361.7000n -0.000529 361.7100n -0.000529 361.7200n -0.000528 361.7300n -0.000527 361.7400n -0.000526 361.7500n -0.000524 361.7600n -0.000523 361.7700n -0.000520 361.7800n -0.000518 361.7900n -0.000515
+ 361.8000n -0.000512 361.8100n -0.000509 361.8200n -0.000505 361.8300n -0.000501 361.8400n -0.000496 361.8500n -0.000491 361.8600n -0.000486 361.8700n -0.000481 361.8800n -0.000475 361.8900n -0.000469 361.9000n -0.000463 361.9100n -0.000456 361.9200n -0.000449 361.9300n -0.000441 361.9400n -0.000434
+ 361.9500n -0.000425 361.9600n -0.000417 361.9700n -0.000408 361.9800n -0.000399 361.9900n -0.000390 362.0000n -0.000380 362.0100n -0.000370 362.0200n -0.000359 362.0300n -0.000349 362.0400n -0.000338 362.0500n -0.000326 362.0600n -0.000314 362.0700n -0.000302 362.0800n -0.000290 362.0900n -0.000278
+ 362.1000n -0.000265 362.1100n -0.000251 362.1200n -0.000238 362.1300n -0.000224 362.1400n -0.000210 362.1500n -0.000196 362.1600n -0.000181 362.1700n -0.000167 362.1800n -0.000152 362.1900n -0.000136 362.2000n -0.000121 362.2100n -0.000105 362.2200n -0.000089 362.2300n -0.000073 362.2400n -0.000056
+ 362.2500n -0.000040 362.2600n -0.000023 362.2700n -0.000006 362.2800n 0.000011 362.2900n 0.000028 362.3000n 0.000046 362.3100n 0.000063 362.3200n 0.000081 362.3300n 0.000099 362.3400n 0.000117 362.3500n 0.000135 362.3600n 0.000153 362.3700n 0.000171 362.3800n 0.000190 362.3900n 0.000208
+ 362.4000n 0.000226 362.4100n 0.000245 362.4200n 0.000263 362.4300n 0.000282 362.4400n 0.000300 362.4500n 0.000319 362.4600n 0.000337 362.4700n 0.000356 362.4800n 0.000374 362.4900n 0.000392 362.5000n 0.000410 362.5100n 0.000429 362.5200n 0.000447 362.5300n 0.000465 362.5400n 0.000482
+ 362.5500n 0.000500 362.5600n 0.000518 362.5700n 0.000535 362.5800n 0.000552 362.5900n 0.000569 362.6000n 0.000586 362.6100n 0.000603 362.6200n 0.000619 362.6300n 0.000635 362.6400n 0.000651 362.6500n 0.000667 362.6600n 0.000682 362.6700n 0.000697 362.6800n 0.000712 362.6900n 0.000726
+ 362.7000n 0.000741 362.7100n 0.000754 362.7200n 0.000768 362.7300n 0.000781 362.7400n 0.000794 362.7500n 0.000806 362.7600n 0.000818 362.7700n 0.000830 362.7800n 0.000841 362.7900n 0.000852 362.8000n 0.000862 362.8100n 0.000872 362.8200n 0.000881 362.8300n 0.000890 362.8400n 0.000898
+ 362.8500n 0.000906 362.8600n 0.000914 362.8700n 0.000921 362.8800n 0.000927 362.8900n 0.000933 362.9000n 0.000938 362.9100n 0.000943 362.9200n 0.000947 362.9300n 0.000951 362.9400n 0.000954 362.9500n 0.000957 362.9600n 0.000959 362.9700n 0.000960 362.9800n 0.000961 362.9900n 0.000961
+ 363.0000n 0.000961 363.0100n 0.000960 363.0200n 0.000958 363.0300n 0.000956 363.0400n 0.000953 363.0500n 0.000950 363.0600n 0.000946 363.0700n 0.000941 363.0800n 0.000936 363.0900n 0.000930 363.1000n 0.000923 363.1100n 0.000916 363.1200n 0.000908 363.1300n 0.000899 363.1400n 0.000890
+ 363.1500n 0.000880 363.1600n 0.000869 363.1700n 0.000858 363.1800n 0.000847 363.1900n 0.000834 363.2000n 0.000821 363.2100n 0.000807 363.2200n 0.000793 363.2300n 0.000778 363.2400n 0.000763 363.2500n 0.000746 363.2600n 0.000730 363.2700n 0.000712 363.2800n 0.000694 363.2900n 0.000676
+ 363.3000n 0.000656 363.3100n 0.000636 363.3200n 0.000616 363.3300n 0.000595 363.3400n 0.000574 363.3500n 0.000552 363.3600n 0.000529 363.3700n 0.000506 363.3800n 0.000482 363.3900n 0.000458 363.4000n 0.000433 363.4100n 0.000408 363.4200n 0.000382 363.4300n 0.000356 363.4400n 0.000329
+ 363.4500n 0.000302 363.4600n 0.000274 363.4700n 0.000246 363.4800n 0.000218 363.4900n 0.000189 363.5000n 0.000160 363.5100n 0.000130 363.5200n 0.000100 363.5300n 0.000070 363.5400n 0.000039 363.5500n 0.000008 363.5600n -0.000023 363.5700n -0.000055 363.5800n -0.000087 363.5900n -0.000119
+ 363.6000n -0.000151 363.6100n -0.000184 363.6200n -0.000217 363.6300n -0.000250 363.6400n -0.000283 363.6500n -0.000316 363.6600n -0.000350 363.6700n -0.000383 363.6800n -0.000417 363.6900n -0.000451 363.7000n -0.000485 363.7100n -0.000519 363.7200n -0.000553 363.7300n -0.000587 363.7400n -0.000621
+ 363.7500n -0.000656 363.7600n -0.000690 363.7700n -0.000724 363.7800n -0.000758 363.7900n -0.000792 363.8000n -0.000825 363.8100n -0.000859 363.8200n -0.000893 363.8300n -0.000926 363.8400n -0.000959 363.8500n -0.000992 363.8600n -0.001025 363.8700n -0.001058 363.8800n -0.001090 363.8900n -0.001122
+ 363.9000n -0.001154 363.9100n -0.001186 363.9200n -0.001217 363.9300n -0.001248 363.9400n -0.001279 363.9500n -0.001309 363.9600n -0.001339 363.9700n -0.001368 363.9800n -0.001397 363.9900n -0.001426 364.0000n -0.001454 364.0100n -0.001482 364.0200n -0.001509 364.0300n -0.001536 364.0400n -0.001562
+ 364.0500n -0.001588 364.0600n -0.001614 364.0700n -0.001638 364.0800n -0.001662 364.0900n -0.001686 364.1000n -0.001709 364.1100n -0.001732 364.1200n -0.001754 364.1300n -0.001775 364.1400n -0.001795 364.1500n -0.001815 364.1600n -0.001835 364.1700n -0.001853 364.1800n -0.001871 364.1900n -0.001889
+ 364.2000n -0.001905 364.2100n -0.001921 364.2200n -0.001937 364.2300n -0.001951 364.2400n -0.001965 364.2500n -0.001978 364.2600n -0.001991 364.2700n -0.002002 364.2800n -0.002013 364.2900n -0.002023 364.3000n -0.002033 364.3100n -0.002041 364.3200n -0.002049 364.3300n -0.002057 364.3400n -0.002063
+ 364.3500n -0.002069 364.3600n -0.002073 364.3700n -0.002077 364.3800n -0.002081 364.3900n -0.002083 364.4000n -0.002085 364.4100n -0.002086 364.4200n -0.002086 364.4300n -0.002085 364.4400n -0.002084 364.4500n -0.002082 364.4600n -0.002079 364.4700n -0.002075 364.4800n -0.002071 364.4900n -0.002066
+ 364.5000n -0.002060 364.5100n -0.002053 364.5200n -0.002046 364.5300n -0.002038 364.5400n -0.002029 364.5500n -0.002019 364.5600n -0.002009 364.5700n -0.001998 364.5800n -0.001986 364.5900n -0.001974 364.6000n -0.001960 364.6100n -0.001947 364.6200n -0.001932 364.6300n -0.001917 364.6400n -0.001901
+ 364.6500n -0.001885 364.6600n -0.001868 364.6700n -0.001850 364.6800n -0.001832 364.6900n -0.001813 364.7000n -0.001793 364.7100n -0.001773 364.7200n -0.001753 364.7300n -0.001732 364.7400n -0.001710 364.7500n -0.001688 364.7600n -0.001665 364.7700n -0.001642 364.7800n -0.001618 364.7900n -0.001594
+ 364.8000n -0.001569 364.8100n -0.001544 364.8200n -0.001519 364.8300n -0.001493 364.8400n -0.001467 364.8500n -0.001440 364.8600n -0.001413 364.8700n -0.001386 364.8800n -0.001358 364.8900n -0.001330 364.9000n -0.001302 364.9100n -0.001274 364.9200n -0.001245 364.9300n -0.001216 364.9400n -0.001187
+ 364.9500n -0.001157 364.9600n -0.001128 364.9700n -0.001098 364.9800n -0.001068 364.9900n -0.001038 365.0000n -0.001007 365.0100n -0.000977 365.0200n -0.000947 365.0300n -0.000916 365.0400n -0.000885 365.0500n -0.000855 365.0600n -0.000824 365.0700n -0.000793 365.0800n -0.000763 365.0900n -0.000732
+ 365.1000n -0.000701 365.1100n -0.000671 365.1200n -0.000640 365.1300n -0.000610 365.1400n -0.000579 365.1500n -0.000549 365.1600n -0.000519 365.1700n -0.000489 365.1800n -0.000459 365.1900n -0.000429 365.2000n -0.000400 365.2100n -0.000370 365.2200n -0.000341 365.2300n -0.000312 365.2400n -0.000284
+ 365.2500n -0.000255 365.2600n -0.000227 365.2700n -0.000199 365.2800n -0.000172 365.2900n -0.000144 365.3000n -0.000117 365.3100n -0.000091 365.3200n -0.000064 365.3300n -0.000038 365.3400n -0.000013 365.3500n 0.000012 365.3600n 0.000037 365.3700n 0.000062 365.3800n 0.000086 365.3900n 0.000110
+ 365.4000n 0.000133 365.4100n 0.000156 365.4200n 0.000179 365.4300n 0.000201 365.4400n 0.000223 365.4500n 0.000244 365.4600n 0.000265 365.4700n 0.000285 365.4800n 0.000305 365.4900n 0.000325 365.5000n 0.000344 365.5100n 0.000362 365.5200n 0.000381 365.5300n 0.000398 365.5400n 0.000415
+ 365.5500n 0.000432 365.5600n 0.000448 365.5700n 0.000464 365.5800n 0.000480 365.5900n 0.000494 365.6000n 0.000509 365.6100n 0.000523 365.6200n 0.000536 365.6300n 0.000549 365.6400n 0.000562 365.6500n 0.000574 365.6600n 0.000585 365.6700n 0.000596 365.6800n 0.000607 365.6900n 0.000617
+ 365.7000n 0.000627 365.7100n 0.000636 365.7200n 0.000645 365.7300n 0.000654 365.7400n 0.000662 365.7500n 0.000669 365.7600n 0.000676 365.7700n 0.000683 365.7800n 0.000689 365.7900n 0.000695 365.8000n 0.000701 365.8100n 0.000706 365.8200n 0.000711 365.8300n 0.000715 365.8400n 0.000719
+ 365.8500n 0.000723 365.8600n 0.000726 365.8700n 0.000729 365.8800n 0.000732 365.8900n 0.000734 365.9000n 0.000736 365.9100n 0.000738 365.9200n 0.000739 365.9300n 0.000740 365.9400n 0.000741 365.9500n 0.000742 365.9600n 0.000742 365.9700n 0.000742 365.9800n 0.000742 365.9900n 0.000742
+ 366.0000n 0.000741 366.0100n 0.000741 366.0200n 0.000740 366.0300n 0.000739 366.0400n 0.000737 366.0500n 0.000736 366.0600n 0.000735 366.0700n 0.000733 366.0800n 0.000731 366.0900n 0.000729 366.1000n 0.000727 366.1100n 0.000725 366.1200n 0.000723 366.1300n 0.000721 366.1400n 0.000719
+ 366.1500n 0.000716 366.1600n 0.000714 366.1700n 0.000712 366.1800n 0.000709 366.1900n 0.000707 366.2000n 0.000705 366.2100n 0.000703 366.2200n 0.000700 366.2300n 0.000698 366.2400n 0.000696 366.2500n 0.000694 366.2600n 0.000692 366.2700n 0.000690 366.2800n 0.000688 366.2900n 0.000687
+ 366.3000n 0.000685 366.3100n 0.000684 366.3200n 0.000682 366.3300n 0.000681 366.3400n 0.000680 366.3500n 0.000680 366.3600n 0.000679 366.3700n 0.000678 366.3800n 0.000678 366.3900n 0.000678 366.4000n 0.000678 366.4100n 0.000679 366.4200n 0.000679 366.4300n 0.000680 366.4400n 0.000681
+ 366.4500n 0.000682 366.4600n 0.000683 366.4700n 0.000685 366.4800n 0.000687 366.4900n 0.000689 366.5000n 0.000692 366.5100n 0.000694 366.5200n 0.000697 366.5300n 0.000701 366.5400n 0.000704 366.5500n 0.000708 366.5600n 0.000712 366.5700n 0.000716 366.5800n 0.000721 366.5900n 0.000726
+ 366.6000n 0.000731 366.6100n 0.000736 366.6200n 0.000742 366.6300n 0.000748 366.6400n 0.000754 366.6500n 0.000761 366.6600n 0.000768 366.6700n 0.000775 366.6800n 0.000782 366.6900n 0.000790 366.7000n 0.000798 366.7100n 0.000806 366.7200n 0.000814 366.7300n 0.000823 366.7400n 0.000832
+ 366.7500n 0.000841 366.7600n 0.000851 366.7700n 0.000860 366.7800n 0.000870 366.7900n 0.000881 366.8000n 0.000891 366.8100n 0.000902 366.8200n 0.000912 366.8300n 0.000923 366.8400n 0.000935 366.8500n 0.000946 366.8600n 0.000958 366.8700n 0.000969 366.8800n 0.000981 366.8900n 0.000993
+ 366.9000n 0.001006 366.9100n 0.001018 366.9200n 0.001031 366.9300n 0.001043 366.9400n 0.001056 366.9500n 0.001069 366.9600n 0.001082 366.9700n 0.001095 366.9800n 0.001108 366.9900n 0.001121 367.0000n 0.001135 367.0100n 0.001148 367.0200n 0.001161 367.0300n 0.001175 367.0400n 0.001188
+ 367.0500n 0.001202 367.0600n 0.001215 367.0700n 0.001228 367.0800n 0.001242 367.0900n 0.001255 367.1000n 0.001268 367.1100n 0.001281 367.1200n 0.001295 367.1300n 0.001308 367.1400n 0.001321 367.1500n 0.001333 367.1600n 0.001346 367.1700n 0.001359 367.1800n 0.001371 367.1900n 0.001383
+ 367.2000n 0.001395 367.2100n 0.001407 367.2200n 0.001419 367.2300n 0.001431 367.2400n 0.001442 367.2500n 0.001453 367.2600n 0.001464 367.2700n 0.001474 367.2800n 0.001485 367.2900n 0.001495 367.3000n 0.001504 367.3100n 0.001514 367.3200n 0.001523 367.3300n 0.001532 367.3400n 0.001540
+ 367.3500n 0.001549 367.3600n 0.001556 367.3700n 0.001564 367.3800n 0.001571 367.3900n 0.001578 367.4000n 0.001584 367.4100n 0.001590 367.4200n 0.001596 367.4300n 0.001601 367.4400n 0.001606 367.4500n 0.001610 367.4600n 0.001614 367.4700n 0.001617 367.4800n 0.001620 367.4900n 0.001623
+ 367.5000n 0.001625 367.5100n 0.001626 367.5200n 0.001627 367.5300n 0.001628 367.5400n 0.001628 367.5500n 0.001628 367.5600n 0.001627 367.5700n 0.001625 367.5800n 0.001623 367.5900n 0.001621 367.6000n 0.001618 367.6100n 0.001614 367.6200n 0.001610 367.6300n 0.001606 367.6400n 0.001601
+ 367.6500n 0.001595 367.6600n 0.001589 367.6700n 0.001582 367.6800n 0.001575 367.6900n 0.001567 367.7000n 0.001559 367.7100n 0.001550 367.7200n 0.001540 367.7300n 0.001530 367.7400n 0.001520 367.7500n 0.001508 367.7600n 0.001497 367.7700n 0.001484 367.7800n 0.001472 367.7900n 0.001458
+ 367.8000n 0.001444 367.8100n 0.001430 367.8200n 0.001415 367.8300n 0.001399 367.8400n 0.001383 367.8500n 0.001367 367.8600n 0.001350 367.8700n 0.001332 367.8800n 0.001314 367.8900n 0.001295 367.9000n 0.001276 367.9100n 0.001256 367.9200n 0.001236 367.9300n 0.001215 367.9400n 0.001194
+ 367.9500n 0.001172 367.9600n 0.001150 367.9700n 0.001128 367.9800n 0.001105 367.9900n 0.001081 368.0000n 0.001057 368.0100n 0.001033 368.0200n 0.001008 368.0300n 0.000983 368.0400n 0.000957 368.0500n 0.000931 368.0600n 0.000904 368.0700n 0.000877 368.0800n 0.000850 368.0900n 0.000822
+ 368.1000n 0.000794 368.1100n 0.000766 368.1200n 0.000737 368.1300n 0.000708 368.1400n 0.000679 368.1500n 0.000649 368.1600n 0.000619 368.1700n 0.000589 368.1800n 0.000559 368.1900n 0.000528 368.2000n 0.000497 368.2100n 0.000465 368.2200n 0.000434 368.2300n 0.000402 368.2400n 0.000370
+ 368.2500n 0.000338 368.2600n 0.000306 368.2700n 0.000273 368.2800n 0.000241 368.2900n 0.000208 368.3000n 0.000175 368.3100n 0.000142 368.3200n 0.000108 368.3300n 0.000075 368.3400n 0.000041 368.3500n 0.000008 368.3600n -0.000026 368.3700n -0.000059 368.3800n -0.000093 368.3900n -0.000127
+ 368.4000n -0.000161 368.4100n -0.000194 368.4200n -0.000228 368.4300n -0.000262 368.4400n -0.000296 368.4500n -0.000329 368.4600n -0.000363 368.4700n -0.000397 368.4800n -0.000430 368.4900n -0.000464 368.5000n -0.000497 368.5100n -0.000531 368.5200n -0.000564 368.5300n -0.000597 368.5400n -0.000630
+ 368.5500n -0.000663 368.5600n -0.000695 368.5700n -0.000728 368.5800n -0.000760 368.5900n -0.000792 368.6000n -0.000824 368.6100n -0.000856 368.6200n -0.000888 368.6300n -0.000919 368.6400n -0.000950 368.6500n -0.000981 368.6600n -0.001012 368.6700n -0.001042 368.6800n -0.001072 368.6900n -0.001102
+ 368.7000n -0.001131 368.7100n -0.001161 368.7200n -0.001190 368.7300n -0.001218 368.7400n -0.001247 368.7500n -0.001275 368.7600n -0.001303 368.7700n -0.001330 368.7800n -0.001357 368.7900n -0.001384 368.8000n -0.001410 368.8100n -0.001436 368.8200n -0.001462 368.8300n -0.001487 368.8400n -0.001512
+ 368.8500n -0.001537 368.8600n -0.001561 368.8700n -0.001585 368.8800n -0.001608 368.8900n -0.001631 368.9000n -0.001654 368.9100n -0.001676 368.9200n -0.001698 368.9300n -0.001720 368.9400n -0.001741 368.9500n -0.001761 368.9600n -0.001781 368.9700n -0.001801 368.9800n -0.001820 368.9900n -0.001839
+ 369.0000n -0.001858 369.0100n -0.001876 369.0200n -0.001893 369.0300n -0.001911 369.0400n -0.001927 369.0500n -0.001944 369.0600n -0.001959 369.0700n -0.001975 369.0800n -0.001990 369.0900n -0.002004 369.1000n -0.002019 369.1100n -0.002032 369.1200n -0.002045 369.1300n -0.002058 369.1400n -0.002071
+ 369.1500n -0.002082 369.1600n -0.002094 369.1700n -0.002105 369.1800n -0.002115 369.1900n -0.002126 369.2000n -0.002135 369.2100n -0.002145 369.2200n -0.002153 369.2300n -0.002162 369.2400n -0.002170 369.2500n -0.002177 369.2600n -0.002184 369.2700n -0.002191 369.2800n -0.002197 369.2900n -0.002203
+ 369.3000n -0.002208 369.3100n -0.002213 369.3200n -0.002218 369.3300n -0.002222 369.3400n -0.002226 369.3500n -0.002229 369.3600n -0.002232 369.3700n -0.002234 369.3800n -0.002236 369.3900n -0.002238 369.4000n -0.002239 369.4100n -0.002240 369.4200n -0.002240 369.4300n -0.002240 369.4400n -0.002240
+ 369.4500n -0.002239 369.4600n -0.002238 369.4700n -0.002237 369.4800n -0.002235 369.4900n -0.002233 369.5000n -0.002230 369.5100n -0.002227 369.5200n -0.002224 369.5300n -0.002220 369.5400n -0.002216 369.5500n -0.002211 369.5600n -0.002206 369.5700n -0.002201 369.5800n -0.002196 369.5900n -0.002190
+ 369.6000n -0.002184 369.6100n -0.002177 369.6200n -0.002170 369.6300n -0.002163 369.6400n -0.002155 369.6500n -0.002147 369.6600n -0.002139 369.6700n -0.002131 369.6800n -0.002122 369.6900n -0.002112 369.7000n -0.002103 369.7100n -0.002093 369.7200n -0.002083 369.7300n -0.002072 369.7400n -0.002062
+ 369.7500n -0.002051 369.7600n -0.002039 369.7700n -0.002027 369.7800n -0.002016 369.7900n -0.002003 369.8000n -0.001991 369.8100n -0.001978 369.8200n -0.001965 369.8300n -0.001951 369.8400n -0.001938 369.8500n -0.001924 369.8600n -0.001909 369.8700n -0.001895 369.8800n -0.001880 369.8900n -0.001865
+ 369.9000n -0.001849 369.9100n -0.001834 369.9200n -0.001818 369.9300n -0.001802 369.9400n -0.001785 369.9500n -0.001769 369.9600n -0.001752 369.9700n -0.001735 369.9800n -0.001717 369.9900n -0.001700 370.0000n -0.001682 370.0100n -0.001664 370.0200n -0.001645 370.0300n -0.001627 370.0400n -0.001608
+ 370.0500n -0.001589 370.0600n -0.001570 370.0700n -0.001550 370.0800n -0.001530 370.0900n -0.001510 370.1000n -0.001490 370.1100n -0.001470 370.1200n -0.001449 370.1300n -0.001428 370.1400n -0.001407 370.1500n -0.001386 370.1600n -0.001365 370.1700n -0.001343 370.1800n -0.001321 370.1900n -0.001299
+ 370.2000n -0.001277 370.2100n -0.001255 370.2200n -0.001232 370.2300n -0.001209 370.2400n -0.001186 370.2500n -0.001163 370.2600n -0.001140 370.2700n -0.001116 370.2800n -0.001093 370.2900n -0.001069 370.3000n -0.001045 370.3100n -0.001021 370.3200n -0.000997 370.3300n -0.000972 370.3400n -0.000948
+ 370.3500n -0.000923 370.3600n -0.000898 370.3700n -0.000873 370.3800n -0.000848 370.3900n -0.000823 370.4000n -0.000797 370.4100n -0.000772 370.4200n -0.000746 370.4300n -0.000720 370.4400n -0.000695 370.4500n -0.000669 370.4600n -0.000643 370.4700n -0.000617 370.4800n -0.000590 370.4900n -0.000564
+ 370.5000n -0.000538 370.5100n -0.000511 370.5200n -0.000485 370.5300n -0.000458 370.5400n -0.000432 370.5500n -0.000405 370.5600n -0.000379 370.5700n -0.000352 370.5800n -0.000325 370.5900n -0.000298 370.6000n -0.000271 370.6100n -0.000245 370.6200n -0.000218 370.6300n -0.000191 370.6400n -0.000164
+ 370.6500n -0.000137 370.6600n -0.000111 370.6700n -0.000084 370.6800n -0.000057 370.6900n -0.000030 370.7000n -0.000004 370.7100n 0.000023 370.7200n 0.000049 370.7300n 0.000076 370.7400n 0.000102 370.7500n 0.000129 370.7600n 0.000155 370.7700n 0.000181 370.7800n 0.000207 370.7900n 0.000233
+ 370.8000n 0.000259 370.8100n 0.000285 370.8200n 0.000310 370.8300n 0.000336 370.8400n 0.000361 370.8500n 0.000386 370.8600n 0.000411 370.8700n 0.000436 370.8800n 0.000461 370.8900n 0.000485 370.9000n 0.000509 370.9100n 0.000534 370.9200n 0.000557 370.9300n 0.000581 370.9400n 0.000605
+ 370.9500n 0.000628 370.9600n 0.000651 370.9700n 0.000674 370.9800n 0.000696 370.9900n 0.000719 371.0000n 0.000741 371.0100n 0.000762 371.0200n 0.000784 371.0300n 0.000805 371.0400n 0.000826 371.0500n 0.000846 371.0600n 0.000867 371.0700n 0.000887 371.0800n 0.000906 371.0900n 0.000926
+ 371.1000n 0.000945 371.1100n 0.000963 371.1200n 0.000982 371.1300n 0.001000 371.1400n 0.001017 371.1500n 0.001035 371.1600n 0.001051 371.1700n 0.001068 371.1800n 0.001084 371.1900n 0.001100 371.2000n 0.001115 371.2100n 0.001130 371.2200n 0.001144 371.2300n 0.001159 371.2400n 0.001172
+ 371.2500n 0.001186 371.2600n 0.001198 371.2700n 0.001211 371.2800n 0.001223 371.2900n 0.001234 371.3000n 0.001245 371.3100n 0.001256 371.3200n 0.001266 371.3300n 0.001276 371.3400n 0.001285 371.3500n 0.001294 371.3600n 0.001302 371.3700n 0.001310 371.3800n 0.001318 371.3900n 0.001325
+ 371.4000n 0.001331 371.4100n 0.001337 371.4200n 0.001343 371.4300n 0.001348 371.4400n 0.001352 371.4500n 0.001356 371.4600n 0.001360 371.4700n 0.001363 371.4800n 0.001365 371.4900n 0.001368 371.5000n 0.001369 371.5100n 0.001370 371.5200n 0.001371 371.5300n 0.001371 371.5400n 0.001371
+ 371.5500n 0.001370 371.5600n 0.001369 371.5700n 0.001367 371.5800n 0.001364 371.5900n 0.001362 371.6000n 0.001358 371.6100n 0.001355 371.6200n 0.001351 371.6300n 0.001346 371.6400n 0.001341 371.6500n 0.001335 371.6600n 0.001329 371.6700n 0.001323 371.6800n 0.001316 371.6900n 0.001308
+ 371.7000n 0.001300 371.7100n 0.001292 371.7200n 0.001283 371.7300n 0.001274 371.7400n 0.001264 371.7500n 0.001254 371.7600n 0.001244 371.7700n 0.001233 371.7800n 0.001222 371.7900n 0.001210 371.8000n 0.001198 371.8100n 0.001186 371.8200n 0.001173 371.8300n 0.001160 371.8400n 0.001146
+ 371.8500n 0.001132 371.8600n 0.001118 371.8700n 0.001103 371.8800n 0.001088 371.8900n 0.001073 371.9000n 0.001057 371.9100n 0.001041 371.9200n 0.001025 371.9300n 0.001009 371.9400n 0.000992 371.9500n 0.000975 371.9600n 0.000957 371.9700n 0.000940 371.9800n 0.000922 371.9900n 0.000904
+ 372.0000n 0.000886 372.0100n 0.000867 372.0200n 0.000848 372.0300n 0.000829 372.0400n 0.000810 372.0500n 0.000791 372.0600n 0.000771 372.0700n 0.000752 372.0800n 0.000732 372.0900n 0.000712 372.1000n 0.000692 372.1100n 0.000672 372.1200n 0.000651 372.1300n 0.000631 372.1400n 0.000611
+ 372.1500n 0.000590 372.1600n 0.000569 372.1700n 0.000549 372.1800n 0.000528 372.1900n 0.000507 372.2000n 0.000486 372.2100n 0.000465 372.2200n 0.000445 372.2300n 0.000424 372.2400n 0.000403 372.2500n 0.000382 372.2600n 0.000361 372.2700n 0.000341 372.2800n 0.000320 372.2900n 0.000299
+ 372.3000n 0.000279 372.3100n 0.000258 372.3200n 0.000238 372.3300n 0.000218 372.3400n 0.000198 372.3500n 0.000178 372.3600n 0.000158 372.3700n 0.000138 372.3800n 0.000119 372.3900n 0.000099 372.4000n 0.000080 372.4100n 0.000061 372.4200n 0.000042 372.4300n 0.000024 372.4400n 0.000005
+ 372.4500n -0.000013 372.4600n -0.000031 372.4700n -0.000049 372.4800n -0.000066 372.4900n -0.000084 372.5000n -0.000101 372.5100n -0.000117 372.5200n -0.000134 372.5300n -0.000150 372.5400n -0.000166 372.5500n -0.000181 372.5600n -0.000197 372.5700n -0.000212 372.5800n -0.000226 372.5900n -0.000241
+ 372.6000n -0.000255 372.6100n -0.000268 372.6200n -0.000282 372.6300n -0.000295 372.6400n -0.000307 372.6500n -0.000320 372.6600n -0.000332 372.6700n -0.000343 372.6800n -0.000355 372.6900n -0.000365 372.7000n -0.000376 372.7100n -0.000386 372.7200n -0.000396 372.7300n -0.000405 372.7400n -0.000414
+ 372.7500n -0.000423 372.7600n -0.000431 372.7700n -0.000438 372.7800n -0.000446 372.7900n -0.000453 372.8000n -0.000459 372.8100n -0.000466 372.8200n -0.000471 372.8300n -0.000477 372.8400n -0.000482 372.8500n -0.000486 372.8600n -0.000490 372.8700n -0.000494 372.8800n -0.000497 372.8900n -0.000500
+ 372.9000n -0.000503 372.9100n -0.000505 372.9200n -0.000507 372.9300n -0.000508 372.9400n -0.000509 372.9500n -0.000509 372.9600n -0.000509 372.9700n -0.000509 372.9800n -0.000508 372.9900n -0.000507 373.0000n -0.000506 373.0100n -0.000504 373.0200n -0.000502 373.0300n -0.000499 373.0400n -0.000496
+ 373.0500n -0.000493 373.0600n -0.000489 373.0700n -0.000485 373.0800n -0.000481 373.0900n -0.000476 373.1000n -0.000471 373.1100n -0.000465 373.1200n -0.000459 373.1300n -0.000453 373.1400n -0.000447 373.1500n -0.000440 373.1600n -0.000433 373.1700n -0.000425 373.1800n -0.000417 373.1900n -0.000409
+ 373.2000n -0.000401 373.2100n -0.000392 373.2200n -0.000383 373.2300n -0.000374 373.2400n -0.000364 373.2500n -0.000355 373.2600n -0.000344 373.2700n -0.000334 373.2800n -0.000324 373.2900n -0.000313 373.3000n -0.000302 373.3100n -0.000290 373.3200n -0.000279 373.3300n -0.000267 373.3400n -0.000255
+ 373.3500n -0.000243 373.3600n -0.000231 373.3700n -0.000219 373.3800n -0.000206 373.3900n -0.000193 373.4000n -0.000180 373.4100n -0.000167 373.4200n -0.000154 373.4300n -0.000140 373.4400n -0.000127 373.4500n -0.000113 373.4600n -0.000099 373.4700n -0.000085 373.4800n -0.000071 373.4900n -0.000057
+ 373.5000n -0.000043 373.5100n -0.000029 373.5200n -0.000015 373.5300n -0.000000 373.5400n 0.000014 373.5500n 0.000029 373.5600n 0.000043 373.5700n 0.000058 373.5800n 0.000072 373.5900n 0.000087 373.6000n 0.000102 373.6100n 0.000116 373.6200n 0.000131 373.6300n 0.000145 373.6400n 0.000160
+ 373.6500n 0.000174 373.6600n 0.000189 373.6700n 0.000203 373.6800n 0.000218 373.6900n 0.000232 373.7000n 0.000246 373.7100n 0.000261 373.7200n 0.000275 373.7300n 0.000289 373.7400n 0.000303 373.7500n 0.000317 373.7600n 0.000330 373.7700n 0.000344 373.7800n 0.000358 373.7900n 0.000371
+ 373.8000n 0.000384 373.8100n 0.000398 373.8200n 0.000411 373.8300n 0.000424 373.8400n 0.000436 373.8500n 0.000449 373.8600n 0.000461 373.8700n 0.000474 373.8800n 0.000486 373.8900n 0.000498 373.9000n 0.000510 373.9100n 0.000521 373.9200n 0.000533 373.9300n 0.000544 373.9400n 0.000555
+ 373.9500n 0.000566 373.9600n 0.000576 373.9700n 0.000587 373.9800n 0.000597 373.9900n 0.000607 374.0000n 0.000617 374.0100n 0.000626 374.0200n 0.000636 374.0300n 0.000645 374.0400n 0.000654 374.0500n 0.000662 374.0600n 0.000671 374.0700n 0.000679 374.0800n 0.000687 374.0900n 0.000695
+ 374.1000n 0.000702 374.1100n 0.000709 374.1200n 0.000716 374.1300n 0.000723 374.1400n 0.000730 374.1500n 0.000736 374.1600n 0.000742 374.1700n 0.000748 374.1800n 0.000753 374.1900n 0.000758 374.2000n 0.000763 374.2100n 0.000768 374.2200n 0.000773 374.2300n 0.000777 374.2400n 0.000781
+ 374.2500n 0.000784 374.2600n 0.000788 374.2700n 0.000791 374.2800n 0.000794 374.2900n 0.000797 374.3000n 0.000799 374.3100n 0.000801 374.3200n 0.000803 374.3300n 0.000805 374.3400n 0.000806 374.3500n 0.000808 374.3600n 0.000809 374.3700n 0.000809 374.3800n 0.000810 374.3900n 0.000810
+ 374.4000n 0.000810 374.4100n 0.000810 374.4200n 0.000809 374.4300n 0.000808 374.4400n 0.000808 374.4500n 0.000806 374.4600n 0.000805 374.4700n 0.000803 374.4800n 0.000801 374.4900n 0.000799 374.5000n 0.000797 374.5100n 0.000795 374.5200n 0.000792 374.5300n 0.000789 374.5400n 0.000786
+ 374.5500n 0.000783 374.5600n 0.000779 374.5700n 0.000776 374.5800n 0.000772 374.5900n 0.000768 374.6000n 0.000763 374.6100n 0.000759 374.6200n 0.000754 374.6300n 0.000750 374.6400n 0.000745 374.6500n 0.000740 374.6600n 0.000735 374.6700n 0.000729 374.6800n 0.000724 374.6900n 0.000718
+ 374.7000n 0.000712 374.7100n 0.000707 374.7200n 0.000701 374.7300n 0.000694 374.7400n 0.000688 374.7500n 0.000682 374.7600n 0.000675 374.7700n 0.000669 374.7800n 0.000662 374.7900n 0.000655 374.8000n 0.000649 374.8100n 0.000642 374.8200n 0.000635 374.8300n 0.000628 374.8400n 0.000621
+ 374.8500n 0.000614 374.8600n 0.000606 374.8700n 0.000599 374.8800n 0.000592 374.8900n 0.000585 374.9000n 0.000577 374.9100n 0.000570 374.9200n 0.000562 374.9300n 0.000555 374.9400n 0.000548 374.9500n 0.000540 374.9600n 0.000533 374.9700n 0.000525 374.9800n 0.000518 374.9900n 0.000511
+ 375.0000n 0.000503 375.0100n 0.000496 375.0200n 0.000489 375.0300n 0.000482 375.0400n 0.000475 375.0500n 0.000468 375.0600n 0.000461 375.0700n 0.000454 375.0800n 0.000447 375.0900n 0.000440 375.1000n 0.000433 375.1100n 0.000427 375.1200n 0.000420 375.1300n 0.000414 375.1400n 0.000407
+ 375.1500n 0.000401 375.1600n 0.000395 375.1700n 0.000389 375.1800n 0.000383 375.1900n 0.000378 375.2000n 0.000372 375.2100n 0.000367 375.2200n 0.000361 375.2300n 0.000356 375.2400n 0.000351 375.2500n 0.000346 375.2600n 0.000342 375.2700n 0.000337 375.2800n 0.000333 375.2900n 0.000329
+ 375.3000n 0.000325 375.3100n 0.000321 375.3200n 0.000318 375.3300n 0.000315 375.3400n 0.000311 375.3500n 0.000309 375.3600n 0.000306 375.3700n 0.000303 375.3800n 0.000301 375.3900n 0.000299 375.4000n 0.000297 375.4100n 0.000295 375.4200n 0.000294 375.4300n 0.000293 375.4400n 0.000292
+ 375.4500n 0.000291 375.4600n 0.000291 375.4700n 0.000291 375.4800n 0.000291 375.4900n 0.000291 375.5000n 0.000292 375.5100n 0.000292 375.5200n 0.000293 375.5300n 0.000295 375.5400n 0.000296 375.5500n 0.000298 375.5600n 0.000300 375.5700n 0.000302 375.5800n 0.000305 375.5900n 0.000308
+ 375.6000n 0.000311 375.6100n 0.000314 375.6200n 0.000318 375.6300n 0.000322 375.6400n 0.000326 375.6500n 0.000330 375.6600n 0.000335 375.6700n 0.000339 375.6800n 0.000345 375.6900n 0.000350 375.7000n 0.000355 375.7100n 0.000361 375.7200n 0.000367 375.7300n 0.000374 375.7400n 0.000380
+ 375.7500n 0.000387 375.7600n 0.000394 375.7700n 0.000401 375.7800n 0.000409 375.7900n 0.000417 375.8000n 0.000425 375.8100n 0.000433 375.8200n 0.000441 375.8300n 0.000450 375.8400n 0.000458 375.8500n 0.000467 375.8600n 0.000476 375.8700n 0.000486 375.8800n 0.000495 375.8900n 0.000505
+ 375.9000n 0.000515 375.9100n 0.000525 375.9200n 0.000535 375.9300n 0.000545 375.9400n 0.000556 375.9500n 0.000566 375.9600n 0.000577 375.9700n 0.000588 375.9800n 0.000599 375.9900n 0.000610 376.0000n 0.000621 376.0100n 0.000632 376.0200n 0.000644 376.0300n 0.000655 376.0400n 0.000667
+ 376.0500n 0.000678 376.0600n 0.000690 376.0700n 0.000701 376.0800n 0.000713 376.0900n 0.000725 376.1000n 0.000736 376.1100n 0.000748 376.1200n 0.000760 376.1300n 0.000771 376.1400n 0.000783 376.1500n 0.000794 376.1600n 0.000806 376.1700n 0.000817 376.1800n 0.000828 376.1900n 0.000840
+ 376.2000n 0.000851 376.2100n 0.000862 376.2200n 0.000873 376.2300n 0.000884 376.2400n 0.000894 376.2500n 0.000905 376.2600n 0.000915 376.2700n 0.000925 376.2800n 0.000935 376.2900n 0.000945 376.3000n 0.000954 376.3100n 0.000964 376.3200n 0.000973 376.3300n 0.000982 376.3400n 0.000990
+ 376.3500n 0.000998 376.3600n 0.001006 376.3700n 0.001014 376.3800n 0.001021 376.3900n 0.001028 376.4000n 0.001035 376.4100n 0.001041 376.4200n 0.001047 376.4300n 0.001053 376.4400n 0.001058 376.4500n 0.001063 376.4600n 0.001068 376.4700n 0.001072 376.4800n 0.001075 376.4900n 0.001078
+ 376.5000n 0.001081 376.5100n 0.001083 376.5200n 0.001085 376.5300n 0.001086 376.5400n 0.001087 376.5500n 0.001087 376.5600n 0.001087 376.5700n 0.001086 376.5800n 0.001085 376.5900n 0.001083 376.6000n 0.001080 376.6100n 0.001077 376.6200n 0.001074 376.6300n 0.001070 376.6400n 0.001065
+ 376.6500n 0.001059 376.6600n 0.001053 376.6700n 0.001047 376.6800n 0.001039 376.6900n 0.001032 376.7000n 0.001023 376.7100n 0.001014 376.7200n 0.001004 376.7300n 0.000993 376.7400n 0.000982 376.7500n 0.000970 376.7600n 0.000958 376.7700n 0.000944 376.7800n 0.000930 376.7900n 0.000916
+ 376.8000n 0.000900 376.8100n 0.000884 376.8200n 0.000867 376.8300n 0.000850 376.8400n 0.000832 376.8500n 0.000813 376.8600n 0.000793 376.8700n 0.000773 376.8800n 0.000751 376.8900n 0.000730 376.9000n 0.000707 376.9100n 0.000684 376.9200n 0.000660 376.9300n 0.000635 376.9400n 0.000609
+ 376.9500n 0.000583 376.9600n 0.000556 376.9700n 0.000529 376.9800n 0.000500 376.9900n 0.000471 377.0000n 0.000441 377.0100n 0.000411 377.0200n 0.000380 377.0300n 0.000348 377.0400n 0.000315 377.0500n 0.000282 377.0600n 0.000248 377.0700n 0.000213 377.0800n 0.000178 377.0900n 0.000142
+ 377.1000n 0.000106 377.1100n 0.000069 377.1200n 0.000031 377.1300n -0.000008 377.1400n -0.000047 377.1500n -0.000086 377.1600n -0.000127 377.1700n -0.000167 377.1800n -0.000209 377.1900n -0.000251 377.2000n -0.000293 377.2100n -0.000336 377.2200n -0.000379 377.2300n -0.000423 377.2400n -0.000468
+ 377.2500n -0.000512 377.2600n -0.000558 377.2700n -0.000603 377.2800n -0.000650 377.2900n -0.000696 377.3000n -0.000743 377.3100n -0.000790 377.3200n -0.000838 377.3300n -0.000886 377.3400n -0.000934 377.3500n -0.000983 377.3600n -0.001031 377.3700n -0.001081 377.3800n -0.001130 377.3900n -0.001179
+ 377.4000n -0.001229 377.4100n -0.001279 377.4200n -0.001329 377.4300n -0.001379 377.4400n -0.001429 377.4500n -0.001479 377.4600n -0.001530 377.4700n -0.001580 377.4800n -0.001631 377.4900n -0.001681 377.5000n -0.001731 377.5100n -0.001782 377.5200n -0.001832 377.5300n -0.001882 377.5400n -0.001932
+ 377.5500n -0.001982 377.5600n -0.002032 377.5700n -0.002081 377.5800n -0.002130 377.5900n -0.002179 377.6000n -0.002228 377.6100n -0.002277 377.6200n -0.002325 377.6300n -0.002373 377.6400n -0.002420 377.6500n -0.002467 377.6600n -0.002514 377.6700n -0.002560 377.6800n -0.002606 377.6900n -0.002651
+ 377.7000n -0.002696 377.7100n -0.002740 377.7200n -0.002783 377.7300n -0.002826 377.7400n -0.002869 377.7500n -0.002911 377.7600n -0.002952 377.7700n -0.002993 377.7800n -0.003032 377.7900n -0.003071 377.8000n -0.003110 377.8100n -0.003147 377.8200n -0.003184 377.8300n -0.003220 377.8400n -0.003256
+ 377.8500n -0.003290 377.8600n -0.003323 377.8700n -0.003356 377.8800n -0.003388 377.8900n -0.003419 377.9000n -0.003449 377.9100n -0.003477 377.9200n -0.003505 377.9300n -0.003532 377.9400n -0.003558 377.9500n -0.003583 377.9600n -0.003607 377.9700n -0.003630 377.9800n -0.003652 377.9900n -0.003672
+ 378.0000n -0.003692 378.0100n -0.003710 378.0200n -0.003728 378.0300n -0.003744 378.0400n -0.003759 378.0500n -0.003773 378.0600n -0.003785 378.0700n -0.003797 378.0800n -0.003807 378.0900n -0.003816 378.1000n -0.003824 378.1100n -0.003831 378.1200n -0.003836 378.1300n -0.003840 378.1400n -0.003843
+ 378.1500n -0.003845 378.1600n -0.003846 378.1700n -0.003845 378.1800n -0.003843 378.1900n -0.003840 378.2000n -0.003835 378.2100n -0.003830 378.2200n -0.003823 378.2300n -0.003814 378.2400n -0.003805 378.2500n -0.003794 378.2600n -0.003782 378.2700n -0.003769 378.2800n -0.003754 378.2900n -0.003739
+ 378.3000n -0.003722 378.3100n -0.003703 378.3200n -0.003684 378.3300n -0.003663 378.3400n -0.003642 378.3500n -0.003619 378.3600n -0.003594 378.3700n -0.003569 378.3800n -0.003542 378.3900n -0.003515 378.4000n -0.003486 378.4100n -0.003456 378.4200n -0.003425 378.4300n -0.003393 378.4400n -0.003359
+ 378.4500n -0.003325 378.4600n -0.003290 378.4700n -0.003253 378.4800n -0.003216 378.4900n -0.003178 378.5000n -0.003138 378.5100n -0.003098 378.5200n -0.003057 378.5300n -0.003014 378.5400n -0.002971 378.5500n -0.002927 378.5600n -0.002882 378.5700n -0.002837 378.5800n -0.002790 378.5900n -0.002743
+ 378.6000n -0.002695 378.6100n -0.002646 378.6200n -0.002596 378.6300n -0.002546 378.6400n -0.002495 378.6500n -0.002444 378.6600n -0.002392 378.6700n -0.002339 378.6800n -0.002286 378.6900n -0.002232 378.7000n -0.002178 378.7100n -0.002123 378.7200n -0.002068 378.7300n -0.002012 378.7400n -0.001956
+ 378.7500n -0.001900 378.7600n -0.001843 378.7700n -0.001786 378.7800n -0.001728 378.7900n -0.001671 378.8000n -0.001613 378.8100n -0.001555 378.8200n -0.001497 378.8300n -0.001439 378.8400n -0.001381 378.8500n -0.001322 378.8600n -0.001264 378.8700n -0.001206 378.8800n -0.001147 378.8900n -0.001089
+ 378.9000n -0.001031 378.9100n -0.000973 378.9200n -0.000915 378.9300n -0.000857 378.9400n -0.000799 378.9500n -0.000742 378.9600n -0.000685 378.9700n -0.000628 378.9800n -0.000572 378.9900n -0.000516 379.0000n -0.000460 379.0100n -0.000405 379.0200n -0.000350 379.0300n -0.000296 379.0400n -0.000242
+ 379.0500n -0.000189 379.0600n -0.000136 379.0700n -0.000084 379.0800n -0.000032 379.0900n 0.000019 379.1000n 0.000069 379.1100n 0.000118 379.1200n 0.000167 379.1300n 0.000216 379.1400n 0.000263 379.1500n 0.000310 379.1600n 0.000355 379.1700n 0.000400 379.1800n 0.000445 379.1900n 0.000488
+ 379.2000n 0.000530 379.2100n 0.000572 379.2200n 0.000613 379.2300n 0.000652 379.2400n 0.000691 379.2500n 0.000729 379.2600n 0.000765 379.2700n 0.000801 379.2800n 0.000836 379.2900n 0.000870 379.3000n 0.000902 379.3100n 0.000934 379.3200n 0.000965 379.3300n 0.000994 379.3400n 0.001022
+ 379.3500n 0.001050 379.3600n 0.001076 379.3700n 0.001101 379.3800n 0.001125 379.3900n 0.001148 379.4000n 0.001169 379.4100n 0.001190 379.4200n 0.001209 379.4300n 0.001227 379.4400n 0.001244 379.4500n 0.001260 379.4600n 0.001275 379.4700n 0.001288 379.4800n 0.001301 379.4900n 0.001312
+ 379.5000n 0.001322 379.5100n 0.001331 379.5200n 0.001339 379.5300n 0.001345 379.5400n 0.001351 379.5500n 0.001355 379.5600n 0.001358 379.5700n 0.001360 379.5800n 0.001361 379.5900n 0.001361 379.6000n 0.001359 379.6100n 0.001357 379.6200n 0.001353 379.6300n 0.001349 379.6400n 0.001343
+ 379.6500n 0.001337 379.6600n 0.001329 379.6700n 0.001320 379.6800n 0.001310 379.6900n 0.001300 379.7000n 0.001288 379.7100n 0.001275 379.7200n 0.001261 379.7300n 0.001247 379.7400n 0.001231 379.7500n 0.001215 379.7600n 0.001198 379.7700n 0.001179 379.7800n 0.001160 379.7900n 0.001141
+ 379.8000n 0.001120 379.8100n 0.001099 379.8200n 0.001077 379.8300n 0.001054 379.8400n 0.001030 379.8500n 0.001006 379.8600n 0.000981 379.8700n 0.000956 379.8800n 0.000929 379.8900n 0.000903 379.9000n 0.000875 379.9100n 0.000848 379.9200n 0.000819 379.9300n 0.000790 379.9400n 0.000761
+ 379.9500n 0.000731 379.9600n 0.000701 379.9700n 0.000671 379.9800n 0.000640 379.9900n 0.000608 380.0000n 0.000577 380.0100n 0.000545 380.0200n 0.000513 380.0300n 0.000481 380.0400n 0.000448 380.0500n 0.000416 380.0600n 0.000383 380.0700n 0.000350 380.0800n 0.000317 380.0900n 0.000284
+ 380.1000n 0.000251 380.1100n 0.000218 380.1200n 0.000184 380.1300n 0.000151 380.1400n 0.000118 380.1500n 0.000085 380.1600n 0.000053 380.1700n 0.000020 380.1800n -0.000013 380.1900n -0.000045 380.2000n -0.000077 380.2100n -0.000109 380.2200n -0.000140 380.2300n -0.000172 380.2400n -0.000203
+ 380.2500n -0.000233 380.2600n -0.000264 380.2700n -0.000294 380.2800n -0.000323 380.2900n -0.000352 380.3000n -0.000381 380.3100n -0.000409 380.3200n -0.000437 380.3300n -0.000464 380.3400n -0.000491 380.3500n -0.000517 380.3600n -0.000543 380.3700n -0.000568 380.3800n -0.000592 380.3900n -0.000616
+ 380.4000n -0.000639 380.4100n -0.000662 380.4200n -0.000684 380.4300n -0.000705 380.4400n -0.000726 380.4500n -0.000746 380.4600n -0.000765 380.4700n -0.000784 380.4800n -0.000802 380.4900n -0.000819 380.5000n -0.000835 380.5100n -0.000851 380.5200n -0.000866 380.5300n -0.000880 380.5400n -0.000894
+ 380.5500n -0.000906 380.5600n -0.000918 380.5700n -0.000929 380.5800n -0.000940 380.5900n -0.000949 380.6000n -0.000958 380.6100n -0.000966 380.6200n -0.000973 380.6300n -0.000980 380.6400n -0.000985 380.6500n -0.000990 380.6600n -0.000994 380.6700n -0.000998 380.6800n -0.001000 380.6900n -0.001002
+ 380.7000n -0.001003 380.7100n -0.001003 380.7200n -0.001003 380.7300n -0.001002 380.7400n -0.001000 380.7500n -0.000997 380.7600n -0.000994 380.7700n -0.000990 380.7800n -0.000985 380.7900n -0.000980 380.8000n -0.000974 380.8100n -0.000967 380.8200n -0.000959 380.8300n -0.000951 380.8400n -0.000943
+ 380.8500n -0.000933 380.8600n -0.000924 380.8700n -0.000913 380.8800n -0.000902 380.8900n -0.000891 380.9000n -0.000879 380.9100n -0.000866 380.9200n -0.000853 380.9300n -0.000839 380.9400n -0.000825 380.9500n -0.000811 380.9600n -0.000796 380.9700n -0.000781 380.9800n -0.000765 380.9900n -0.000749
+ 381.0000n -0.000733 381.0100n -0.000716 381.0200n -0.000699 381.0300n -0.000682 381.0400n -0.000664 381.0500n -0.000647 381.0600n -0.000629 381.0700n -0.000611 381.0800n -0.000592 381.0900n -0.000574 381.1000n -0.000555 381.1100n -0.000537 381.1200n -0.000518 381.1300n -0.000499 381.1400n -0.000480
+ 381.1500n -0.000462 381.1600n -0.000443 381.1700n -0.000424 381.1800n -0.000405 381.1900n -0.000386 381.2000n -0.000368 381.2100n -0.000349 381.2200n -0.000331 381.2300n -0.000313 381.2400n -0.000295 381.2500n -0.000277 381.2600n -0.000260 381.2700n -0.000243 381.2800n -0.000226 381.2900n -0.000209
+ 381.3000n -0.000193 381.3100n -0.000177 381.3200n -0.000161 381.3300n -0.000146 381.3400n -0.000131 381.3500n -0.000116 381.3600n -0.000102 381.3700n -0.000089 381.3800n -0.000075 381.3900n -0.000063 381.4000n -0.000051 381.4100n -0.000039 381.4200n -0.000028 381.4300n -0.000017 381.4400n -0.000007
+ 381.4500n 0.000002 381.4600n 0.000011 381.4700n 0.000019 381.4800n 0.000027 381.4900n 0.000034 381.5000n 0.000040 381.5100n 0.000046 381.5200n 0.000051 381.5300n 0.000055 381.5400n 0.000059 381.5500n 0.000062 381.5600n 0.000064 381.5700n 0.000066 381.5800n 0.000067 381.5900n 0.000067
+ 381.6000n 0.000066 381.6100n 0.000065 381.6200n 0.000063 381.6300n 0.000060 381.6400n 0.000056 381.6500n 0.000052 381.6600n 0.000047 381.6700n 0.000041 381.6800n 0.000035 381.6900n 0.000027 381.7000n 0.000019 381.7100n 0.000011 381.7200n 0.000001 381.7300n -0.000009 381.7400n -0.000020
+ 381.7500n -0.000032 381.7600n -0.000044 381.7700n -0.000058 381.7800n -0.000072 381.7900n -0.000086 381.8000n -0.000102 381.8100n -0.000118 381.8200n -0.000134 381.8300n -0.000152 381.8400n -0.000170 381.8500n -0.000189 381.8600n -0.000208 381.8700n -0.000228 381.8800n -0.000249 381.8900n -0.000270
+ 381.9000n -0.000292 381.9100n -0.000315 381.9200n -0.000338 381.9300n -0.000362 381.9400n -0.000386 381.9500n -0.000411 381.9600n -0.000436 381.9700n -0.000462 381.9800n -0.000488 381.9900n -0.000515 382.0000n -0.000542 382.0100n -0.000570 382.0200n -0.000598 382.0300n -0.000626 382.0400n -0.000655
+ 382.0500n -0.000684 382.0600n -0.000714 382.0700n -0.000743 382.0800n -0.000774 382.0900n -0.000804 382.1000n -0.000835 382.1100n -0.000866 382.1200n -0.000897 382.1300n -0.000928 382.1400n -0.000960 382.1500n -0.000991 382.1600n -0.001023 382.1700n -0.001055 382.1800n -0.001087 382.1900n -0.001119
+ 382.2000n -0.001151 382.2100n -0.001183 382.2200n -0.001216 382.2300n -0.001248 382.2400n -0.001280 382.2500n -0.001312 382.2600n -0.001344 382.2700n -0.001376 382.2800n -0.001407 382.2900n -0.001439 382.3000n -0.001470 382.3100n -0.001501 382.3200n -0.001532 382.3300n -0.001563 382.3400n -0.001593
+ 382.3500n -0.001624 382.3600n -0.001653 382.3700n -0.001683 382.3800n -0.001712 382.3900n -0.001741 382.4000n -0.001770 382.4100n -0.001798 382.4200n -0.001825 382.4300n -0.001852 382.4400n -0.001879 382.4500n -0.001905 382.4600n -0.001931 382.4700n -0.001957 382.4800n -0.001981 382.4900n -0.002006
+ 382.5000n -0.002029 382.5100n -0.002052 382.5200n -0.002075 382.5300n -0.002097 382.5400n -0.002118 382.5500n -0.002139 382.5600n -0.002159 382.5700n -0.002178 382.5800n -0.002197 382.5900n -0.002215 382.6000n -0.002232 382.6100n -0.002249 382.6200n -0.002265 382.6300n -0.002280 382.6400n -0.002295
+ 382.6500n -0.002308 382.6600n -0.002321 382.6700n -0.002334 382.6800n -0.002345 382.6900n -0.002356 382.7000n -0.002366 382.7100n -0.002375 382.7200n -0.002384 382.7300n -0.002392 382.7400n -0.002399 382.7500n -0.002405 382.7600n -0.002410 382.7700n -0.002415 382.7800n -0.002419 382.7900n -0.002422
+ 382.8000n -0.002424 382.8100n -0.002425 382.8200n -0.002426 382.8300n -0.002426 382.8400n -0.002425 382.8500n -0.002424 382.8600n -0.002422 382.8700n -0.002419 382.8800n -0.002415 382.8900n -0.002410 382.9000n -0.002405 382.9100n -0.002399 382.9200n -0.002392 382.9300n -0.002385 382.9400n -0.002377
+ 382.9500n -0.002368 382.9600n -0.002359 382.9700n -0.002349 382.9800n -0.002338 382.9900n -0.002327 383.0000n -0.002315 383.0100n -0.002302 383.0200n -0.002289 383.0300n -0.002275 383.0400n -0.002261 383.0500n -0.002246 383.0600n -0.002231 383.0700n -0.002215 383.0800n -0.002199 383.0900n -0.002182
+ 383.1000n -0.002164 383.1100n -0.002146 383.1200n -0.002128 383.1300n -0.002109 383.1400n -0.002090 383.1500n -0.002071 383.1600n -0.002051 383.1700n -0.002031 383.1800n -0.002011 383.1900n -0.001990 383.2000n -0.001969 383.2100n -0.001947 383.2200n -0.001926 383.2300n -0.001904 383.2400n -0.001882
+ 383.2500n -0.001860 383.2600n -0.001838 383.2700n -0.001815 383.2800n -0.001793 383.2900n -0.001770 383.3000n -0.001747 383.3100n -0.001725 383.3200n -0.001702 383.3300n -0.001679 383.3400n -0.001656 383.3500n -0.001633 383.3600n -0.001611 383.3700n -0.001588 383.3800n -0.001565 383.3900n -0.001543
+ 383.4000n -0.001520 383.4100n -0.001498 383.4200n -0.001476 383.4300n -0.001454 383.4400n -0.001433 383.4500n -0.001411 383.4600n -0.001390 383.4700n -0.001369 383.4800n -0.001349 383.4900n -0.001329 383.5000n -0.001309 383.5100n -0.001289 383.5200n -0.001270 383.5300n -0.001251 383.5400n -0.001232
+ 383.5500n -0.001214 383.5600n -0.001197 383.5700n -0.001180 383.5800n -0.001163 383.5900n -0.001147 383.6000n -0.001131 383.6100n -0.001115 383.6200n -0.001101 383.6300n -0.001086 383.6400n -0.001073 383.6500n -0.001059 383.6600n -0.001047 383.6700n -0.001035 383.6800n -0.001023 383.6900n -0.001012
+ 383.7000n -0.001002 383.7100n -0.000992 383.7200n -0.000983 383.7300n -0.000975 383.7400n -0.000967 383.7500n -0.000960 383.7600n -0.000953 383.7700n -0.000947 383.7800n -0.000942 383.7900n -0.000938 383.8000n -0.000934 383.8100n -0.000930 383.8200n -0.000928 383.8300n -0.000926 383.8400n -0.000925
+ 383.8500n -0.000924 383.8600n -0.000924 383.8700n -0.000925 383.8800n -0.000926 383.8900n -0.000928 383.9000n -0.000931 383.9100n -0.000934 383.9200n -0.000938 383.9300n -0.000943 383.9400n -0.000948 383.9500n -0.000954 383.9600n -0.000961 383.9700n -0.000968 383.9800n -0.000976 383.9900n -0.000985
+ 384.0000n -0.000994 384.0100n -0.001003 384.0200n -0.001014 384.0300n -0.001024 384.0400n -0.001036 384.0500n -0.001048 384.0600n -0.001060 384.0700n -0.001073 384.0800n -0.001087 384.0900n -0.001101 384.1000n -0.001116 384.1100n -0.001131 384.1200n -0.001146 384.1300n -0.001162 384.1400n -0.001179
+ 384.1500n -0.001196 384.1600n -0.001213 384.1700n -0.001231 384.1800n -0.001249 384.1900n -0.001267 384.2000n -0.001286 384.2100n -0.001305 384.2200n -0.001325 384.2300n -0.001344 384.2400n -0.001364 384.2500n -0.001385 384.2600n -0.001405 384.2700n -0.001426 384.2800n -0.001447 384.2900n -0.001468
+ 384.3000n -0.001489 384.3100n -0.001511 384.3200n -0.001532 384.3300n -0.001554 384.3400n -0.001576 384.3500n -0.001597 384.3600n -0.001619 384.3700n -0.001641 384.3800n -0.001663 384.3900n -0.001685 384.4000n -0.001707 384.4100n -0.001729 384.4200n -0.001751 384.4300n -0.001772 384.4400n -0.001794
+ 384.4500n -0.001816 384.4600n -0.001837 384.4700n -0.001858 384.4800n -0.001879 384.4900n -0.001900 384.5000n -0.001920 384.5100n -0.001941 384.5200n -0.001961 384.5300n -0.001980 384.5400n -0.002000 384.5500n -0.002019 384.5600n -0.002038 384.5700n -0.002056 384.5800n -0.002075 384.5900n -0.002092
+ 384.6000n -0.002110 384.6100n -0.002127 384.6200n -0.002143 384.6300n -0.002159 384.6400n -0.002175 384.6500n -0.002190 384.6600n -0.002205 384.6700n -0.002219 384.6800n -0.002232 384.6900n -0.002245 384.7000n -0.002258 384.7100n -0.002270 384.7200n -0.002281 384.7300n -0.002292 384.7400n -0.002303
+ 384.7500n -0.002312 384.7600n -0.002321 384.7700n -0.002330 384.7800n -0.002338 384.7900n -0.002345 384.8000n -0.002351 384.8100n -0.002357 384.8200n -0.002362 384.8300n -0.002367 384.8400n -0.002371 384.8500n -0.002374 384.8600n -0.002377 384.8700n -0.002378 384.8800n -0.002380 384.8900n -0.002380
+ 384.9000n -0.002380 384.9100n -0.002379 384.9200n -0.002377 384.9300n -0.002375 384.9400n -0.002372 384.9500n -0.002368 384.9600n -0.002364 384.9700n -0.002359 384.9800n -0.002353 384.9900n -0.002346 385.0000n -0.002339 385.0100n -0.002331 385.0200n -0.002323 385.0300n -0.002313 385.0400n -0.002303
+ 385.0500n -0.002293 385.0600n -0.002282 385.0700n -0.002270 385.0800n -0.002257 385.0900n -0.002244 385.1000n -0.002230 385.1100n -0.002215 385.1200n -0.002200 385.1300n -0.002185 385.1400n -0.002168 385.1500n -0.002151 385.1600n -0.002134 385.1700n -0.002116 385.1800n -0.002097 385.1900n -0.002078
+ 385.2000n -0.002058 385.2100n -0.002038 385.2200n -0.002017 385.2300n -0.001996 385.2400n -0.001975 385.2500n -0.001952 385.2600n -0.001930 385.2700n -0.001907 385.2800n -0.001883 385.2900n -0.001859 385.3000n -0.001835 385.3100n -0.001810 385.3200n -0.001785 385.3300n -0.001760 385.3400n -0.001734
+ 385.3500n -0.001708 385.3600n -0.001682 385.3700n -0.001655 385.3800n -0.001628 385.3900n -0.001601 385.4000n -0.001574 385.4100n -0.001546 385.4200n -0.001519 385.4300n -0.001491 385.4400n -0.001463 385.4500n -0.001434 385.4600n -0.001406 385.4700n -0.001377 385.4800n -0.001349 385.4900n -0.001320
+ 385.5000n -0.001292 385.5100n -0.001263 385.5200n -0.001234 385.5300n -0.001205 385.5400n -0.001177 385.5500n -0.001148 385.5600n -0.001119 385.5700n -0.001091 385.5800n -0.001062 385.5900n -0.001034 385.6000n -0.001006 385.6100n -0.000978 385.6200n -0.000950 385.6300n -0.000922 385.6400n -0.000894
+ 385.6500n -0.000867 385.6600n -0.000840 385.6700n -0.000813 385.6800n -0.000786 385.6900n -0.000760 385.7000n -0.000734 385.7100n -0.000708 385.7200n -0.000682 385.7300n -0.000657 385.7400n -0.000632 385.7500n -0.000607 385.7600n -0.000583 385.7700n -0.000559 385.7800n -0.000536 385.7900n -0.000513
+ 385.8000n -0.000490 385.8100n -0.000468 385.8200n -0.000446 385.8300n -0.000425 385.8400n -0.000404 385.8500n -0.000383 385.8600n -0.000363 385.8700n -0.000344 385.8800n -0.000325 385.8900n -0.000306 385.9000n -0.000288 385.9100n -0.000270 385.9200n -0.000253 385.9300n -0.000237 385.9400n -0.000221
+ 385.9500n -0.000205 385.9600n -0.000190 385.9700n -0.000176 385.9800n -0.000162 385.9900n -0.000148 386.0000n -0.000136 386.0100n -0.000123 386.0200n -0.000112 386.0300n -0.000100 386.0400n -0.000090 386.0500n -0.000080 386.0600n -0.000070 386.0700n -0.000061 386.0800n -0.000052 386.0900n -0.000044
+ 386.1000n -0.000037 386.1100n -0.000030 386.1200n -0.000024 386.1300n -0.000018 386.1400n -0.000013 386.1500n -0.000008 386.1600n -0.000004 386.1700n -0.000000 386.1800n 0.000003 386.1900n 0.000006 386.2000n 0.000008 386.2100n 0.000010 386.2200n 0.000011 386.2300n 0.000012 386.2400n 0.000012
+ 386.2500n 0.000012 386.2600n 0.000011 386.2700n 0.000010 386.2800n 0.000008 386.2900n 0.000006 386.3000n 0.000004 386.3100n 0.000001 386.3200n -0.000002 386.3300n -0.000005 386.3400n -0.000009 386.3500n -0.000014 386.3600n -0.000018 386.3700n -0.000023 386.3800n -0.000029 386.3900n -0.000035
+ 386.4000n -0.000041 386.4100n -0.000047 386.4200n -0.000053 386.4300n -0.000060 386.4400n -0.000067 386.4500n -0.000075 386.4600n -0.000082 386.4700n -0.000090 386.4800n -0.000098 386.4900n -0.000106 386.5000n -0.000115 386.5100n -0.000123 386.5200n -0.000132 386.5300n -0.000141 386.5400n -0.000150
+ 386.5500n -0.000159 386.5600n -0.000169 386.5700n -0.000178 386.5800n -0.000187 386.5900n -0.000197 386.6000n -0.000206 386.6100n -0.000216 386.6200n -0.000226 386.6300n -0.000235 386.6400n -0.000245 386.6500n -0.000255 386.6600n -0.000264 386.6700n -0.000274 386.6800n -0.000283 386.6900n -0.000293
+ 386.7000n -0.000302 386.7100n -0.000311 386.7200n -0.000321 386.7300n -0.000330 386.7400n -0.000339 386.7500n -0.000348 386.7600n -0.000356 386.7700n -0.000365 386.7800n -0.000373 386.7900n -0.000382 386.8000n -0.000390 386.8100n -0.000398 386.8200n -0.000405 386.8300n -0.000413 386.8400n -0.000420
+ 386.8500n -0.000427 386.8600n -0.000434 386.8700n -0.000441 386.8800n -0.000447 386.8900n -0.000453 386.9000n -0.000459 386.9100n -0.000465 386.9200n -0.000470 386.9300n -0.000475 386.9400n -0.000480 386.9500n -0.000484 386.9600n -0.000489 386.9700n -0.000493 386.9800n -0.000496 386.9900n -0.000500
+ 387.0000n -0.000503 387.0100n -0.000505 387.0200n -0.000508 387.0300n -0.000510 387.0400n -0.000512 387.0500n -0.000513 387.0600n -0.000514 387.0700n -0.000515 387.0800n -0.000516 387.0900n -0.000516 387.1000n -0.000516 387.1100n -0.000515 387.1200n -0.000514 387.1300n -0.000513 387.1400n -0.000512
+ 387.1500n -0.000510 387.1600n -0.000509 387.1700n -0.000506 387.1800n -0.000504 387.1900n -0.000501 387.2000n -0.000498 387.2100n -0.000494 387.2200n -0.000491 387.2300n -0.000487 387.2400n -0.000483 387.2500n -0.000478 387.2600n -0.000473 387.2700n -0.000468 387.2800n -0.000463 387.2900n -0.000458
+ 387.3000n -0.000452 387.3100n -0.000446 387.3200n -0.000440 387.3300n -0.000434 387.3400n -0.000427 387.3500n -0.000420 387.3600n -0.000413 387.3700n -0.000406 387.3800n -0.000399 387.3900n -0.000392 387.4000n -0.000384 387.4100n -0.000377 387.4200n -0.000369 387.4300n -0.000361 387.4400n -0.000353
+ 387.4500n -0.000345 387.4600n -0.000336 387.4700n -0.000328 387.4800n -0.000320 387.4900n -0.000311 387.5000n -0.000303 387.5100n -0.000295 387.5200n -0.000286 387.5300n -0.000278 387.5400n -0.000269 387.5500n -0.000260 387.5600n -0.000252 387.5700n -0.000244 387.5800n -0.000235 387.5900n -0.000227
+ 387.6000n -0.000219 387.6100n -0.000210 387.6200n -0.000202 387.6300n -0.000194 387.6400n -0.000186 387.6500n -0.000178 387.6600n -0.000171 387.6700n -0.000163 387.6800n -0.000156 387.6900n -0.000149 387.7000n -0.000141 387.7100n -0.000135 387.7200n -0.000128 387.7300n -0.000121 387.7400n -0.000115
+ 387.7500n -0.000109 387.7600n -0.000103 387.7700n -0.000098 387.7800n -0.000092 387.7900n -0.000087 387.8000n -0.000082 387.8100n -0.000078 387.8200n -0.000073 387.8300n -0.000069 387.8400n -0.000065 387.8500n -0.000062 387.8600n -0.000059 387.8700n -0.000056 387.8800n -0.000053 387.8900n -0.000051
+ 387.9000n -0.000049 387.9100n -0.000048 387.9200n -0.000047 387.9300n -0.000046 387.9400n -0.000045 387.9500n -0.000045 387.9600n -0.000045 387.9700n -0.000046 387.9800n -0.000047 387.9900n -0.000048 388.0000n -0.000049 388.0100n -0.000051 388.0200n -0.000054 388.0300n -0.000057 388.0400n -0.000060
+ 388.0500n -0.000063 388.0600n -0.000067 388.0700n -0.000071 388.0800n -0.000076 388.0900n -0.000081 388.1000n -0.000086 388.1100n -0.000092 388.1200n -0.000098 388.1300n -0.000104 388.1400n -0.000111 388.1500n -0.000118 388.1600n -0.000126 388.1700n -0.000134 388.1800n -0.000142 388.1900n -0.000151
+ 388.2000n -0.000160 388.2100n -0.000169 388.2200n -0.000178 388.2300n -0.000188 388.2400n -0.000199 388.2500n -0.000209 388.2600n -0.000220 388.2700n -0.000231 388.2800n -0.000243 388.2900n -0.000255 388.3000n -0.000267 388.3100n -0.000279 388.3200n -0.000291 388.3300n -0.000304 388.3400n -0.000317
+ 388.3500n -0.000331 388.3600n -0.000344 388.3700n -0.000358 388.3800n -0.000372 388.3900n -0.000386 388.4000n -0.000401 388.4100n -0.000415 388.4200n -0.000430 388.4300n -0.000445 388.4400n -0.000460 388.4500n -0.000476 388.4600n -0.000491 388.4700n -0.000506 388.4800n -0.000522 388.4900n -0.000538
+ 388.5000n -0.000554 388.5100n -0.000569 388.5200n -0.000585 388.5300n -0.000601 388.5400n -0.000617 388.5500n -0.000633 388.5600n -0.000649 388.5700n -0.000666 388.5800n -0.000682 388.5900n -0.000698 388.6000n -0.000714 388.6100n -0.000730 388.6200n -0.000746 388.6300n -0.000761 388.6400n -0.000777
+ 388.6500n -0.000793 388.6600n -0.000808 388.6700n -0.000824 388.6800n -0.000839 388.6900n -0.000854 388.7000n -0.000869 388.7100n -0.000884 388.7200n -0.000899 388.7300n -0.000913 388.7400n -0.000928 388.7500n -0.000942 388.7600n -0.000956 388.7700n -0.000969 388.7800n -0.000983 388.7900n -0.000996
+ 388.8000n -0.001009 388.8100n -0.001021 388.8200n -0.001033 388.8300n -0.001045 388.8400n -0.001057 388.8500n -0.001068 388.8600n -0.001079 388.8700n -0.001090 388.8800n -0.001100 388.8900n -0.001110 388.9000n -0.001120 388.9100n -0.001129 388.9200n -0.001138 388.9300n -0.001146 388.9400n -0.001154
+ 388.9500n -0.001162 388.9600n -0.001169 388.9700n -0.001176 388.9800n -0.001182 388.9900n -0.001188 389.0000n -0.001194 389.0100n -0.001199 389.0200n -0.001203 389.0300n -0.001207 389.0400n -0.001211 389.0500n -0.001214 389.0600n -0.001217 389.0700n -0.001219 389.0800n -0.001221 389.0900n -0.001222
+ 389.1000n -0.001223 389.1100n -0.001223 389.1200n -0.001223 389.1300n -0.001222 389.1400n -0.001221 389.1500n -0.001219 389.1600n -0.001217 389.1700n -0.001214 389.1800n -0.001211 389.1900n -0.001207 389.2000n -0.001203 389.2100n -0.001198 389.2200n -0.001193 389.2300n -0.001187 389.2400n -0.001181
+ 389.2500n -0.001174 389.2600n -0.001167 389.2700n -0.001159 389.2800n -0.001150 389.2900n -0.001142 389.3000n -0.001132 389.3100n -0.001122 389.3200n -0.001112 389.3300n -0.001101 389.3400n -0.001090 389.3500n -0.001078 389.3600n -0.001066 389.3700n -0.001053 389.3800n -0.001040 389.3900n -0.001027
+ 389.4000n -0.001013 389.4100n -0.000998 389.4200n -0.000983 389.4300n -0.000968 389.4400n -0.000952 389.4500n -0.000936 389.4600n -0.000919 389.4700n -0.000902 389.4800n -0.000885 389.4900n -0.000867 389.5000n -0.000848 389.5100n -0.000830 389.5200n -0.000811 389.5300n -0.000792 389.5400n -0.000772
+ 389.5500n -0.000752 389.5600n -0.000731 389.5700n -0.000711 389.5800n -0.000690 389.5900n -0.000668 389.6000n -0.000647 389.6100n -0.000625 389.6200n -0.000603 389.6300n -0.000580 389.6400n -0.000557 389.6500n -0.000535 389.6600n -0.000511 389.6700n -0.000488 389.6800n -0.000464 389.6900n -0.000440
+ 389.7000n -0.000416 389.7100n -0.000392 389.7200n -0.000367 389.7300n -0.000343 389.7400n -0.000318 389.7500n -0.000293 389.7600n -0.000268 389.7700n -0.000243 389.7800n -0.000217 389.7900n -0.000192 389.8000n -0.000166 389.8100n -0.000141 389.8200n -0.000115 389.8300n -0.000089 389.8400n -0.000063
+ 389.8500n -0.000037 389.8600n -0.000012 389.8700n 0.000014 389.8800n 0.000040 389.8900n 0.000066 389.9000n 0.000092 389.9100n 0.000118 389.9200n 0.000144 389.9300n 0.000170 389.9400n 0.000196 389.9500n 0.000222 389.9600n 0.000248 389.9700n 0.000274 389.9800n 0.000299 389.9900n 0.000325
+ 390.0000n 0.000351 390.0100n 0.000376 390.0200n 0.000401 390.0300n 0.000426 390.0400n 0.000452 390.0500n 0.000476 390.0600n 0.000501 390.0700n 0.000526 390.0800n 0.000550 390.0900n 0.000575 390.1000n 0.000599 390.1100n 0.000623 390.1200n 0.000647 390.1300n 0.000670 390.1400n 0.000694
+ 390.1500n 0.000717 390.1600n 0.000740 390.1700n 0.000763 390.1800n 0.000786 390.1900n 0.000808 390.2000n 0.000830 390.2100n 0.000852 390.2200n 0.000874 390.2300n 0.000895 390.2400n 0.000917 390.2500n 0.000938 390.2600n 0.000958 390.2700n 0.000979 390.2800n 0.000999 390.2900n 0.001019
+ 390.3000n 0.001038 390.3100n 0.001058 390.3200n 0.001077 390.3300n 0.001096 390.3400n 0.001114 390.3500n 0.001133 390.3600n 0.001151 390.3700n 0.001168 390.3800n 0.001186 390.3900n 0.001203 390.4000n 0.001220 390.4100n 0.001236 390.4200n 0.001252 390.4300n 0.001268 390.4400n 0.001284
+ 390.4500n 0.001299 390.4600n 0.001314 390.4700n 0.001329 390.4800n 0.001343 390.4900n 0.001357 390.5000n 0.001371 390.5100n 0.001385 390.5200n 0.001398 390.5300n 0.001411 390.5400n 0.001423 390.5500n 0.001436 390.5600n 0.001448 390.5700n 0.001459 390.5800n 0.001471 390.5900n 0.001482
+ 390.6000n 0.001493 390.6100n 0.001503 390.6200n 0.001513 390.6300n 0.001523 390.6400n 0.001533 390.6500n 0.001542 390.6600n 0.001551 390.6700n 0.001560 390.6800n 0.001568 390.6900n 0.001577 390.7000n 0.001584 390.7100n 0.001592 390.7200n 0.001599 390.7300n 0.001606 390.7400n 0.001613
+ 390.7500n 0.001620 390.7600n 0.001626 390.7700n 0.001632 390.7800n 0.001637 390.7900n 0.001643 390.8000n 0.001648 390.8100n 0.001653 390.8200n 0.001657 390.8300n 0.001661 390.8400n 0.001665 390.8500n 0.001669 390.8600n 0.001673 390.8700n 0.001676 390.8800n 0.001679 390.8900n 0.001682
+ 390.9000n 0.001684 390.9100n 0.001686 390.9200n 0.001689 390.9300n 0.001690 390.9400n 0.001692 390.9500n 0.001693 390.9600n 0.001694 390.9700n 0.001695 390.9800n 0.001696 390.9900n 0.001696 391.0000n 0.001696 391.0100n 0.001696 391.0200n 0.001695 391.0300n 0.001695 391.0400n 0.001694
+ 391.0500n 0.001693 391.0600n 0.001692 391.0700n 0.001690 391.0800n 0.001689 391.0900n 0.001687 391.1000n 0.001685 391.1100n 0.001682 391.1200n 0.001680 391.1300n 0.001677 391.1400n 0.001674 391.1500n 0.001671 391.1600n 0.001667 391.1700n 0.001664 391.1800n 0.001660 391.1900n 0.001656
+ 391.2000n 0.001651 391.2100n 0.001647 391.2200n 0.001642 391.2300n 0.001637 391.2400n 0.001632 391.2500n 0.001627 391.2600n 0.001621 391.2700n 0.001616 391.2800n 0.001610 391.2900n 0.001603 391.3000n 0.001597 391.3100n 0.001591 391.3200n 0.001584 391.3300n 0.001577 391.3400n 0.001570
+ 391.3500n 0.001562 391.3600n 0.001555 391.3700n 0.001547 391.3800n 0.001539 391.3900n 0.001531 391.4000n 0.001522 391.4100n 0.001514 391.4200n 0.001505 391.4300n 0.001496 391.4400n 0.001487 391.4500n 0.001478 391.4600n 0.001468 391.4700n 0.001458 391.4800n 0.001448 391.4900n 0.001438
+ 391.5000n 0.001428 391.5100n 0.001417 391.5200n 0.001406 391.5300n 0.001395 391.5400n 0.001384 391.5500n 0.001373 391.5600n 0.001361 391.5700n 0.001349 391.5800n 0.001337 391.5900n 0.001325 391.6000n 0.001313 391.6100n 0.001300 391.6200n 0.001288 391.6300n 0.001275 391.6400n 0.001261
+ 391.6500n 0.001248 391.6600n 0.001235 391.6700n 0.001221 391.6800n 0.001207 391.6900n 0.001193 391.7000n 0.001179 391.7100n 0.001164 391.7200n 0.001150 391.7300n 0.001135 391.7400n 0.001120 391.7500n 0.001105 391.7600n 0.001090 391.7700n 0.001074 391.7800n 0.001059 391.7900n 0.001043
+ 391.8000n 0.001027 391.8100n 0.001011 391.8200n 0.000994 391.8300n 0.000978 391.8400n 0.000961 391.8500n 0.000945 391.8600n 0.000928 391.8700n 0.000911 391.8800n 0.000894 391.8900n 0.000876 391.9000n 0.000859 391.9100n 0.000841 391.9200n 0.000824 391.9300n 0.000806 391.9400n 0.000788
+ 391.9500n 0.000770 391.9600n 0.000752 391.9700n 0.000734 391.9800n 0.000715 391.9900n 0.000697 392.0000n 0.000678 392.0100n 0.000660 392.0200n 0.000641 392.0300n 0.000622 392.0400n 0.000604 392.0500n 0.000585 392.0600n 0.000566 392.0700n 0.000547 392.0800n 0.000528 392.0900n 0.000509
+ 392.1000n 0.000490 392.1100n 0.000471 392.1200n 0.000451 392.1300n 0.000432 392.1400n 0.000413 392.1500n 0.000394 392.1600n 0.000375 392.1700n 0.000356 392.1800n 0.000336 392.1900n 0.000317 392.2000n 0.000298 392.2100n 0.000279 392.2200n 0.000260 392.2300n 0.000241 392.2400n 0.000222
+ 392.2500n 0.000204 392.2600n 0.000185 392.2700n 0.000166 392.2800n 0.000148 392.2900n 0.000129 392.3000n 0.000111 392.3100n 0.000092 392.3200n 0.000074 392.3300n 0.000056 392.3400n 0.000038 392.3500n 0.000021 392.3600n 0.000003 392.3700n -0.000015 392.3800n -0.000032 392.3900n -0.000049
+ 392.4000n -0.000066 392.4100n -0.000083 392.4200n -0.000099 392.4300n -0.000116 392.4400n -0.000132 392.4500n -0.000148 392.4600n -0.000164 392.4700n -0.000179 392.4800n -0.000195 392.4900n -0.000210 392.5000n -0.000225 392.5100n -0.000239 392.5200n -0.000254 392.5300n -0.000268 392.5400n -0.000281
+ 392.5500n -0.000295 392.5600n -0.000308 392.5700n -0.000321 392.5800n -0.000334 392.5900n -0.000346 392.6000n -0.000358 392.6100n -0.000370 392.6200n -0.000381 392.6300n -0.000393 392.6400n -0.000403 392.6500n -0.000414 392.6600n -0.000424 392.6700n -0.000434 392.6800n -0.000443 392.6900n -0.000452
+ 392.7000n -0.000461 392.7100n -0.000469 392.7200n -0.000477 392.7300n -0.000485 392.7400n -0.000492 392.7500n -0.000499 392.7600n -0.000505 392.7700n -0.000511 392.7800n -0.000517 392.7900n -0.000522 392.8000n -0.000527 392.8100n -0.000532 392.8200n -0.000536 392.8300n -0.000540 392.8400n -0.000543
+ 392.8500n -0.000546 392.8600n -0.000549 392.8700n -0.000551 392.8800n -0.000553 392.8900n -0.000554 392.9000n -0.000555 392.9100n -0.000556 392.9200n -0.000556 392.9300n -0.000556 392.9400n -0.000555 392.9500n -0.000554 392.9600n -0.000553 392.9700n -0.000551 392.9800n -0.000548 392.9900n -0.000546
+ 393.0000n -0.000543 393.0100n -0.000539 393.0200n -0.000536 393.0300n -0.000532 393.0400n -0.000527 393.0500n -0.000522 393.0600n -0.000517 393.0700n -0.000511 393.0800n -0.000505 393.0900n -0.000499 393.1000n -0.000492 393.1100n -0.000485 393.1200n -0.000478 393.1300n -0.000470 393.1400n -0.000462
+ 393.1500n -0.000453 393.1600n -0.000444 393.1700n -0.000435 393.1800n -0.000426 393.1900n -0.000416 393.2000n -0.000406 393.2100n -0.000396 393.2200n -0.000385 393.2300n -0.000374 393.2400n -0.000363 393.2500n -0.000352 393.2600n -0.000340 393.2700n -0.000328 393.2800n -0.000316 393.2900n -0.000303
+ 393.3000n -0.000290 393.3100n -0.000278 393.3200n -0.000264 393.3300n -0.000251 393.3400n -0.000237 393.3500n -0.000224 393.3600n -0.000210 393.3700n -0.000196 393.3800n -0.000181 393.3900n -0.000167 393.4000n -0.000152 393.4100n -0.000138 393.4200n -0.000123 393.4300n -0.000108 393.4400n -0.000093
+ 393.4500n -0.000077 393.4600n -0.000062 393.4700n -0.000047 393.4800n -0.000031 393.4900n -0.000016 393.5000n -0.000000 393.5100n 0.000016 393.5200n 0.000031 393.5300n 0.000047 393.5400n 0.000063 393.5500n 0.000079 393.5600n 0.000095 393.5700n 0.000110 393.5800n 0.000126 393.5900n 0.000142
+ 393.6000n 0.000158 393.6100n 0.000173 393.6200n 0.000189 393.6300n 0.000205 393.6400n 0.000220 393.6500n 0.000236 393.6600n 0.000251 393.6700n 0.000266 393.6800n 0.000282 393.6900n 0.000297 393.7000n 0.000312 393.7100n 0.000327 393.7200n 0.000341 393.7300n 0.000356 393.7400n 0.000371
+ 393.7500n 0.000385 393.7600n 0.000399 393.7700n 0.000413 393.7800n 0.000427 393.7900n 0.000441 393.8000n 0.000454 393.8100n 0.000468 393.8200n 0.000481 393.8300n 0.000494 393.8400n 0.000507 393.8500n 0.000519 393.8600n 0.000531 393.8700n 0.000544 393.8800n 0.000555 393.8900n 0.000567
+ 393.9000n 0.000579 393.9100n 0.000590 393.9200n 0.000601 393.9300n 0.000611 393.9400n 0.000622 393.9500n 0.000632 393.9600n 0.000642 393.9700n 0.000652 393.9800n 0.000661 393.9900n 0.000670 394.0000n 0.000679 394.0100n 0.000688 394.0200n 0.000696 394.0300n 0.000704 394.0400n 0.000712
+ 394.0500n 0.000720 394.0600n 0.000727 394.0700n 0.000734 394.0800n 0.000741 394.0900n 0.000747 394.1000n 0.000754 394.1100n 0.000759 394.1200n 0.000765 394.1300n 0.000770 394.1400n 0.000776 394.1500n 0.000780 394.1600n 0.000785 394.1700n 0.000789 394.1800n 0.000793 394.1900n 0.000797
+ 394.2000n 0.000800 394.2100n 0.000804 394.2200n 0.000807 394.2300n 0.000809 394.2400n 0.000812 394.2500n 0.000814 394.2600n 0.000816 394.2700n 0.000818 394.2800n 0.000819 394.2900n 0.000820 394.3000n 0.000821 394.3100n 0.000822 394.3200n 0.000823 394.3300n 0.000823 394.3400n 0.000823
+ 394.3500n 0.000823 394.3600n 0.000823 394.3700n 0.000822 394.3800n 0.000822 394.3900n 0.000821 394.4000n 0.000820 394.4100n 0.000818 394.4200n 0.000817 394.4300n 0.000815 394.4400n 0.000814 394.4500n 0.000812 394.4600n 0.000810 394.4700n 0.000807 394.4800n 0.000805 394.4900n 0.000802
+ 394.5000n 0.000800 394.5100n 0.000797 394.5200n 0.000794 394.5300n 0.000791 394.5400n 0.000788 394.5500n 0.000785 394.5600n 0.000781 394.5700n 0.000778 394.5800n 0.000775 394.5900n 0.000771 394.6000n 0.000767 394.6100n 0.000764 394.6200n 0.000760 394.6300n 0.000756 394.6400n 0.000752
+ 394.6500n 0.000748 394.6600n 0.000745 394.6700n 0.000741 394.6800n 0.000737 394.6900n 0.000733 394.7000n 0.000729 394.7100n 0.000725 394.7200n 0.000721 394.7300n 0.000717 394.7400n 0.000713 394.7500n 0.000709 394.7600n 0.000705 394.7700n 0.000701 394.7800n 0.000697 394.7900n 0.000693
+ 394.8000n 0.000689 394.8100n 0.000685 394.8200n 0.000681 394.8300n 0.000678 394.8400n 0.000674 394.8500n 0.000671 394.8600n 0.000667 394.8700n 0.000664 394.8800n 0.000660 394.8900n 0.000657 394.9000n 0.000654 394.9100n 0.000651 394.9200n 0.000648 394.9300n 0.000645 394.9400n 0.000642
+ 394.9500n 0.000639 394.9600n 0.000636 394.9700n 0.000634 394.9800n 0.000631 394.9900n 0.000629 395.0000n 0.000627 395.0100n 0.000624 395.0200n 0.000622 395.0300n 0.000620 395.0400n 0.000618 395.0500n 0.000617 395.0600n 0.000615 395.0700n 0.000613 395.0800n 0.000612 395.0900n 0.000611
+ 395.1000n 0.000610 395.1100n 0.000608 395.1200n 0.000607 395.1300n 0.000607 395.1400n 0.000606 395.1500n 0.000605 395.1600n 0.000605 395.1700n 0.000604 395.1800n 0.000604 395.1900n 0.000604 395.2000n 0.000603 395.2100n 0.000603 395.2200n 0.000603 395.2300n 0.000604 395.2400n 0.000604
+ 395.2500n 0.000604 395.2600n 0.000605 395.2700n 0.000605 395.2800n 0.000606 395.2900n 0.000606 395.3000n 0.000607 395.3100n 0.000608 395.3200n 0.000609 395.3300n 0.000610 395.3400n 0.000611 395.3500n 0.000612 395.3600n 0.000613 395.3700n 0.000614 395.3800n 0.000616 395.3900n 0.000617
+ 395.4000n 0.000618 395.4100n 0.000620 395.4200n 0.000621 395.4300n 0.000622 395.4400n 0.000624 395.4500n 0.000625 395.4600n 0.000627 395.4700n 0.000628 395.4800n 0.000630 395.4900n 0.000632 395.5000n 0.000633 395.5100n 0.000635 395.5200n 0.000636 395.5300n 0.000638 395.5400n 0.000639
+ 395.5500n 0.000641 395.5600n 0.000642 395.5700n 0.000644 395.5800n 0.000645 395.5900n 0.000647 395.6000n 0.000648 395.6100n 0.000650 395.6200n 0.000651 395.6300n 0.000652 395.6400n 0.000653 395.6500n 0.000655 395.6600n 0.000656 395.6700n 0.000657 395.6800n 0.000658 395.6900n 0.000659
+ 395.7000n 0.000659 395.7100n 0.000660 395.7200n 0.000661 395.7300n 0.000662 395.7400n 0.000662 395.7500n 0.000663 395.7600n 0.000663 395.7700n 0.000663 395.7800n 0.000664 395.7900n 0.000664 395.8000n 0.000664 395.8100n 0.000664 395.8200n 0.000664 395.8300n 0.000663 395.8400n 0.000663
+ 395.8500n 0.000663 395.8600n 0.000662 395.8700n 0.000661 395.8800n 0.000661 395.8900n 0.000660 395.9000n 0.000659 395.9100n 0.000658 395.9200n 0.000657 395.9300n 0.000656 395.9400n 0.000654 395.9500n 0.000653 395.9600n 0.000651 395.9700n 0.000650 395.9800n 0.000648 395.9900n 0.000646
+ 396.0000n 0.000645 396.0100n 0.000643 396.0200n 0.000641 396.0300n 0.000639 396.0400n 0.000636 396.0500n 0.000634 396.0600n 0.000632 396.0700n 0.000630 396.0800n 0.000627 396.0900n 0.000625 396.1000n 0.000622 396.1100n 0.000619 396.1200n 0.000617 396.1300n 0.000614 396.1400n 0.000611
+ 396.1500n 0.000608 396.1600n 0.000606 396.1700n 0.000603 396.1800n 0.000600 396.1900n 0.000597 396.2000n 0.000594 396.2100n 0.000591 396.2200n 0.000588 396.2300n 0.000585 396.2400n 0.000582 396.2500n 0.000579 396.2600n 0.000577 396.2700n 0.000574 396.2800n 0.000571 396.2900n 0.000568
+ 396.3000n 0.000565 396.3100n 0.000563 396.3200n 0.000560 396.3300n 0.000557 396.3400n 0.000555 396.3500n 0.000552 396.3600n 0.000550 396.3700n 0.000548 396.3800n 0.000546 396.3900n 0.000544 396.4000n 0.000542 396.4100n 0.000540 396.4200n 0.000538 396.4300n 0.000536 396.4400n 0.000535
+ 396.4500n 0.000534 396.4600n 0.000532 396.4700n 0.000531 396.4800n 0.000530 396.4900n 0.000530 396.5000n 0.000529 396.5100n 0.000529 396.5200n 0.000529 396.5300n 0.000529 396.5400n 0.000529 396.5500n 0.000529 396.5600n 0.000530 396.5700n 0.000531 396.5800n 0.000532 396.5900n 0.000533
+ 396.6000n 0.000534 396.6100n 0.000536 396.6200n 0.000538 396.6300n 0.000540 396.6400n 0.000543 396.6500n 0.000545 396.6600n 0.000548 396.6700n 0.000552 396.6800n 0.000555 396.6900n 0.000559 396.7000n 0.000563 396.7100n 0.000567 396.7200n 0.000572 396.7300n 0.000576 396.7400n 0.000582
+ 396.7500n 0.000587 396.7600n 0.000593 396.7700n 0.000599 396.7800n 0.000605 396.7900n 0.000611 396.8000n 0.000618 396.8100n 0.000625 396.8200n 0.000633 396.8300n 0.000640 396.8400n 0.000648 396.8500n 0.000657 396.8600n 0.000665 396.8700n 0.000674 396.8800n 0.000683 396.8900n 0.000693
+ 396.9000n 0.000702 396.9100n 0.000712 396.9200n 0.000723 396.9300n 0.000733 396.9400n 0.000744 396.9500n 0.000755 396.9600n 0.000766 396.9700n 0.000778 396.9800n 0.000790 396.9900n 0.000802 397.0000n 0.000814 397.0100n 0.000827 397.0200n 0.000840 397.0300n 0.000853 397.0400n 0.000866
+ 397.0500n 0.000879 397.0600n 0.000893 397.0700n 0.000907 397.0800n 0.000921 397.0900n 0.000935 397.1000n 0.000950 397.1100n 0.000964 397.1200n 0.000979 397.1300n 0.000994 397.1400n 0.001009 397.1500n 0.001024 397.1600n 0.001039 397.1700n 0.001055 397.1800n 0.001070 397.1900n 0.001086
+ 397.2000n 0.001101 397.2100n 0.001117 397.2200n 0.001133 397.2300n 0.001148 397.2400n 0.001164 397.2500n 0.001180 397.2600n 0.001196 397.2700n 0.001212 397.2800n 0.001228 397.2900n 0.001243 397.3000n 0.001259 397.3100n 0.001275 397.3200n 0.001290 397.3300n 0.001306 397.3400n 0.001321
+ 397.3500n 0.001337 397.3600n 0.001352 397.3700n 0.001367 397.3800n 0.001382 397.3900n 0.001396 397.4000n 0.001411 397.4100n 0.001425 397.4200n 0.001439 397.4300n 0.001453 397.4400n 0.001467 397.4500n 0.001480 397.4600n 0.001493 397.4700n 0.001506 397.4800n 0.001519 397.4900n 0.001531
+ 397.5000n 0.001543 397.5100n 0.001554 397.5200n 0.001565 397.5300n 0.001576 397.5400n 0.001587 397.5500n 0.001597 397.5600n 0.001606 397.5700n 0.001615 397.5800n 0.001624 397.5900n 0.001632 397.6000n 0.001640 397.6100n 0.001647 397.6200n 0.001654 397.6300n 0.001660 397.6400n 0.001666
+ 397.6500n 0.001671 397.6600n 0.001676 397.6700n 0.001680 397.6800n 0.001684 397.6900n 0.001687 397.7000n 0.001689 397.7100n 0.001691 397.7200n 0.001692 397.7300n 0.001692 397.7400n 0.001692 397.7500n 0.001691 397.7600n 0.001690 397.7700n 0.001688 397.7800n 0.001685 397.7900n 0.001681
+ 397.8000n 0.001677 397.8100n 0.001672 397.8200n 0.001666 397.8300n 0.001660 397.8400n 0.001653 397.8500n 0.001645 397.8600n 0.001636 397.8700n 0.001627 397.8800n 0.001617 397.8900n 0.001606 397.9000n 0.001595 397.9100n 0.001582 397.9200n 0.001569 397.9300n 0.001555 397.9400n 0.001541
+ 397.9500n 0.001525 397.9600n 0.001509 397.9700n 0.001492 397.9800n 0.001474 397.9900n 0.001456 398.0000n 0.001436 398.0100n 0.001416 398.0200n 0.001395 398.0300n 0.001374 398.0400n 0.001351 398.0500n 0.001328 398.0600n 0.001304 398.0700n 0.001279 398.0800n 0.001254 398.0900n 0.001228
+ 398.1000n 0.001201 398.1100n 0.001173 398.1200n 0.001144 398.1300n 0.001115 398.1400n 0.001085 398.1500n 0.001055 398.1600n 0.001023 398.1700n 0.000991 398.1800n 0.000959 398.1900n 0.000925 398.2000n 0.000891 398.2100n 0.000856 398.2200n 0.000821 398.2300n 0.000785 398.2400n 0.000748
+ 398.2500n 0.000711 398.2600n 0.000673 398.2700n 0.000635 398.2800n 0.000596 398.2900n 0.000556 398.3000n 0.000516 398.3100n 0.000476 398.3200n 0.000435 398.3300n 0.000393 398.3400n 0.000351 398.3500n 0.000308 398.3600n 0.000265 398.3700n 0.000222 398.3800n 0.000178 398.3900n 0.000134
+ 398.4000n 0.000090 398.4100n 0.000045 398.4200n -0.000001 398.4300n -0.000046 398.4400n -0.000092 398.4500n -0.000138 398.4600n -0.000184 398.4700n -0.000231 398.4800n -0.000278 398.4900n -0.000325 398.5000n -0.000372 398.5100n -0.000419 398.5200n -0.000466 398.5300n -0.000514 398.5400n -0.000561
+ 398.5500n -0.000609 398.5600n -0.000657 398.5700n -0.000704 398.5800n -0.000752 398.5900n -0.000799 398.6000n -0.000847 398.6100n -0.000894 398.6200n -0.000942 398.6300n -0.000989 398.6400n -0.001036 398.6500n -0.001083 398.6600n -0.001129 398.6700n -0.001176 398.6800n -0.001222 398.6900n -0.001268
+ 398.7000n -0.001314 398.7100n -0.001359 398.7200n -0.001404 398.7300n -0.001449 398.7400n -0.001493 398.7500n -0.001537 398.7600n -0.001580 398.7700n -0.001623 398.7800n -0.001666 398.7900n -0.001707 398.8000n -0.001749 398.8100n -0.001790 398.8200n -0.001830 398.8300n -0.001870 398.8400n -0.001909
+ 398.8500n -0.001948 398.8600n -0.001986 398.8700n -0.002023 398.8800n -0.002060 398.8900n -0.002096 398.9000n -0.002131 398.9100n -0.002165 398.9200n -0.002199 398.9300n -0.002232 398.9400n -0.002264 398.9500n -0.002296 398.9600n -0.002326 398.9700n -0.002356 398.9800n -0.002385 398.9900n -0.002413
+ 399.0000n -0.002440 399.0100n -0.002466 399.0200n -0.002491 399.0300n -0.002516 399.0400n -0.002539 399.0500n -0.002562 399.0600n -0.002583 399.0700n -0.002604 399.0800n -0.002624 399.0900n -0.002642 399.1000n -0.002660 399.1100n -0.002677 399.1200n -0.002692 399.1300n -0.002707 399.1400n -0.002720
+ 399.1500n -0.002733 399.1600n -0.002744 399.1700n -0.002755 399.1800n -0.002764 399.1900n -0.002773 399.2000n -0.002780 399.2100n -0.002786 399.2200n -0.002791 399.2300n -0.002796 399.2400n -0.002799 399.2500n -0.002801 399.2600n -0.002801 399.2700n -0.002801 399.2800n -0.002800 399.2900n -0.002798
+ 399.3000n -0.002794 399.3100n -0.002790 399.3200n -0.002785 399.3300n -0.002778 399.3400n -0.002771 399.3500n -0.002762 399.3600n -0.002752 399.3700n -0.002742 399.3800n -0.002730 399.3900n -0.002717 399.4000n -0.002704 399.4100n -0.002689 399.4200n -0.002673 399.4300n -0.002657 399.4400n -0.002639
+ 399.4500n -0.002620 399.4600n -0.002601 399.4700n -0.002580 399.4800n -0.002559 399.4900n -0.002537 399.5000n -0.002513 399.5100n -0.002489 399.5200n -0.002464 399.5300n -0.002439 399.5400n -0.002412 399.5500n -0.002385 399.5600n -0.002356 399.5700n -0.002327 399.5800n -0.002298 399.5900n -0.002267
+ 399.6000n -0.002236 399.6100n -0.002204 399.6200n -0.002171 399.6300n -0.002137 399.6400n -0.002103 399.6500n -0.002069 399.6600n -0.002033 399.6700n -0.001997 399.6800n -0.001961 399.6900n -0.001924 399.7000n -0.001886 399.7100n -0.001848 399.7200n -0.001809 399.7300n -0.001770 399.7400n -0.001731
+ 399.7500n -0.001691 399.7600n -0.001650 399.7700n -0.001609 399.7800n -0.001568 399.7900n -0.001526 399.8000n -0.001485 399.8100n -0.001442 399.8200n -0.001400 399.8300n -0.001357 399.8400n -0.001314 399.8500n -0.001271 399.8600n -0.001228 399.8700n -0.001184 399.8800n -0.001140 399.8900n -0.001096
+ 399.9000n -0.001053 399.9100n -0.001009 399.9200n -0.000964 399.9300n -0.000920 399.9400n -0.000876 399.9500n -0.000832 399.9600n -0.000788 399.9700n -0.000744 399.9800n -0.000700 399.9900n -0.000656 400.0000n -0.000612 400.0100n -0.000569 400.0200n -0.000525 400.0300n -0.000482 400.0400n -0.000439
+ 400.0500n -0.000396 400.0600n -0.000353 400.0700n -0.000311 400.0800n -0.000269 400.0900n -0.000227 400.1000n -0.000185 400.1100n -0.000144 400.1200n -0.000103 400.1300n -0.000063 400.1400n -0.000023 400.1500n 0.000017 400.1600n 0.000056 400.1700n 0.000095 400.1800n 0.000134 400.1900n 0.000172
+ 400.2000n 0.000209 400.2100n 0.000246 400.2200n 0.000283 400.2300n 0.000319 400.2400n 0.000354 400.2500n 0.000389 400.2600n 0.000424 400.2700n 0.000457 400.2800n 0.000491 400.2900n 0.000523 400.3000n 0.000555 400.3100n 0.000587 400.3200n 0.000618 400.3300n 0.000648 400.3400n 0.000678
+ 400.3500n 0.000707 400.3600n 0.000735 400.3700n 0.000762 400.3800n 0.000790 400.3900n 0.000816 400.4000n 0.000842 400.4100n 0.000867 400.4200n 0.000891 400.4300n 0.000915 400.4400n 0.000937 400.4500n 0.000960 400.4600n 0.000981 400.4700n 0.001002 400.4800n 0.001023 400.4900n 0.001042
+ 400.5000n 0.001061 400.5100n 0.001079 400.5200n 0.001096 400.5300n 0.001113 400.5400n 0.001129 400.5500n 0.001145 400.5600n 0.001159 400.5700n 0.001173 400.5800n 0.001187 400.5900n 0.001200 400.6000n 0.001212 400.6100n 0.001223 400.6200n 0.001234 400.6300n 0.001244 400.6400n 0.001253
+ 400.6500n 0.001262 400.6600n 0.001270 400.6700n 0.001278 400.6800n 0.001284 400.6900n 0.001291 400.7000n 0.001296 400.7100n 0.001302 400.7200n 0.001306 400.7300n 0.001310 400.7400n 0.001314 400.7500n 0.001316 400.7600n 0.001319 400.7700n 0.001321 400.7800n 0.001322 400.7900n 0.001323
+ 400.8000n 0.001323 400.8100n 0.001323 400.8200n 0.001322 400.8300n 0.001321 400.8400n 0.001319 400.8500n 0.001317 400.8600n 0.001315 400.8700n 0.001312 400.8800n 0.001309 400.8900n 0.001305 400.9000n 0.001301 400.9100n 0.001297 400.9200n 0.001292 400.9300n 0.001287 400.9400n 0.001282
+ 400.9500n 0.001276 400.9600n 0.001270 400.9700n 0.001264 400.9800n 0.001258 400.9900n 0.001251 401.0000n 0.001244 401.0100n 0.001237 401.0200n 0.001230 401.0300n 0.001222 401.0400n 0.001215 401.0500n 0.001207 401.0600n 0.001199 401.0700n 0.001191 401.0800n 0.001183 401.0900n 0.001174
+ 401.1000n 0.001166 401.1100n 0.001157 401.1200n 0.001149 401.1300n 0.001140 401.1400n 0.001132 401.1500n 0.001123 401.1600n 0.001115 401.1700n 0.001106 401.1800n 0.001097 401.1900n 0.001089 401.2000n 0.001080 401.2100n 0.001072 401.2200n 0.001063 401.2300n 0.001055 401.2400n 0.001047
+ 401.2500n 0.001039 401.2600n 0.001031 401.2700n 0.001023 401.2800n 0.001015 401.2900n 0.001007 401.3000n 0.001000 401.3100n 0.000992 401.3200n 0.000985 401.3300n 0.000978 401.3400n 0.000972 401.3500n 0.000965 401.3600n 0.000959 401.3700n 0.000952 401.3800n 0.000946 401.3900n 0.000941
+ 401.4000n 0.000935 401.4100n 0.000930 401.4200n 0.000925 401.4300n 0.000920 401.4400n 0.000916 401.4500n 0.000911 401.4600n 0.000907 401.4700n 0.000904 401.4800n 0.000900 401.4900n 0.000897 401.5000n 0.000894 401.5100n 0.000892 401.5200n 0.000889 401.5300n 0.000887 401.5400n 0.000886
+ 401.5500n 0.000884 401.5600n 0.000883 401.5700n 0.000882 401.5800n 0.000882 401.5900n 0.000881 401.6000n 0.000881 401.6100n 0.000882 401.6200n 0.000882 401.6300n 0.000883 401.6400n 0.000884 401.6500n 0.000886 401.6600n 0.000888 401.6700n 0.000890 401.6800n 0.000892 401.6900n 0.000895
+ 401.7000n 0.000897 401.7100n 0.000901 401.7200n 0.000904 401.7300n 0.000908 401.7400n 0.000912 401.7500n 0.000916 401.7600n 0.000920 401.7700n 0.000925 401.7800n 0.000930 401.7900n 0.000935 401.8000n 0.000941 401.8100n 0.000946 401.8200n 0.000952 401.8300n 0.000958 401.8400n 0.000964
+ 401.8500n 0.000971 401.8600n 0.000978 401.8700n 0.000984 401.8800n 0.000991 401.8900n 0.000999 401.9000n 0.001006 401.9100n 0.001013 401.9200n 0.001021 401.9300n 0.001029 401.9400n 0.001037 401.9500n 0.001045 401.9600n 0.001053 401.9700n 0.001061 401.9800n 0.001069 401.9900n 0.001078
+ 402.0000n 0.001086 402.0100n 0.001095 402.0200n 0.001104 402.0300n 0.001112 402.0400n 0.001121 402.0500n 0.001130 402.0600n 0.001139 402.0700n 0.001147 402.0800n 0.001156 402.0900n 0.001165 402.1000n 0.001174 402.1100n 0.001183 402.1200n 0.001192 402.1300n 0.001200 402.1400n 0.001209
+ 402.1500n 0.001218 402.1600n 0.001227 402.1700n 0.001235 402.1800n 0.001244 402.1900n 0.001252 402.2000n 0.001260 402.2100n 0.001269 402.2200n 0.001277 402.2300n 0.001285 402.2400n 0.001293 402.2500n 0.001301 402.2600n 0.001308 402.2700n 0.001316 402.2800n 0.001323 402.2900n 0.001331
+ 402.3000n 0.001338 402.3100n 0.001345 402.3200n 0.001352 402.3300n 0.001358 402.3400n 0.001365 402.3500n 0.001371 402.3600n 0.001377 402.3700n 0.001383 402.3800n 0.001389 402.3900n 0.001395 402.4000n 0.001400 402.4100n 0.001405 402.4200n 0.001410 402.4300n 0.001415 402.4400n 0.001419
+ 402.4500n 0.001424 402.4600n 0.001428 402.4700n 0.001432 402.4800n 0.001435 402.4900n 0.001439 402.5000n 0.001442 402.5100n 0.001445 402.5200n 0.001448 402.5300n 0.001450 402.5400n 0.001453 402.5500n 0.001455 402.5600n 0.001457 402.5700n 0.001458 402.5800n 0.001460 402.5900n 0.001461
+ 402.6000n 0.001462 402.6100n 0.001463 402.6200n 0.001463 402.6300n 0.001464 402.6400n 0.001464 402.6500n 0.001464 402.6600n 0.001464 402.6700n 0.001463 402.6800n 0.001463 402.6900n 0.001462 402.7000n 0.001461 402.7100n 0.001459 402.7200n 0.001458 402.7300n 0.001456 402.7400n 0.001454
+ 402.7500n 0.001453 402.7600n 0.001450 402.7700n 0.001448 402.7800n 0.001446 402.7900n 0.001443 402.8000n 0.001440 402.8100n 0.001437 402.8200n 0.001434 402.8300n 0.001431 402.8400n 0.001428 402.8500n 0.001424 402.8600n 0.001421 402.8700n 0.001417 402.8800n 0.001413 402.8900n 0.001410
+ 402.9000n 0.001406 402.9100n 0.001402 402.9200n 0.001398 402.9300n 0.001393 402.9400n 0.001389 402.9500n 0.001385 402.9600n 0.001381 402.9700n 0.001376 402.9800n 0.001372 402.9900n 0.001367 403.0000n 0.001363 403.0100n 0.001359 403.0200n 0.001354 403.0300n 0.001350 403.0400n 0.001345
+ 403.0500n 0.001341 403.0600n 0.001336 403.0700n 0.001332 403.0800n 0.001328 403.0900n 0.001323 403.1000n 0.001319 403.1100n 0.001315 403.1200n 0.001311 403.1300n 0.001307 403.1400n 0.001303 403.1500n 0.001299 403.1600n 0.001295 403.1700n 0.001291 403.1800n 0.001288 403.1900n 0.001284
+ 403.2000n 0.001281 403.2100n 0.001278 403.2200n 0.001274 403.2300n 0.001271 403.2400n 0.001268 403.2500n 0.001266 403.2600n 0.001263 403.2700n 0.001261 403.2800n 0.001258 403.2900n 0.001256 403.3000n 0.001254 403.3100n 0.001252 403.3200n 0.001250 403.3300n 0.001249 403.3400n 0.001248
+ 403.3500n 0.001246 403.3600n 0.001245 403.3700n 0.001244 403.3800n 0.001244 403.3900n 0.001243 403.4000n 0.001243 403.4100n 0.001243 403.4200n 0.001243 403.4300n 0.001243 403.4400n 0.001244 403.4500n 0.001245 403.4600n 0.001245 403.4700n 0.001246 403.4800n 0.001248 403.4900n 0.001249
+ 403.5000n 0.001251 403.5100n 0.001253 403.5200n 0.001255 403.5300n 0.001257 403.5400n 0.001259 403.5500n 0.001262 403.5600n 0.001264 403.5700n 0.001267 403.5800n 0.001270 403.5900n 0.001274 403.6000n 0.001277 403.6100n 0.001281 403.6200n 0.001284 403.6300n 0.001288 403.6400n 0.001292
+ 403.6500n 0.001297 403.6600n 0.001301 403.6700n 0.001306 403.6800n 0.001310 403.6900n 0.001315 403.7000n 0.001320 403.7100n 0.001325 403.7200n 0.001330 403.7300n 0.001336 403.7400n 0.001341 403.7500n 0.001346 403.7600n 0.001352 403.7700n 0.001358 403.7800n 0.001364 403.7900n 0.001369
+ 403.8000n 0.001375 403.8100n 0.001381 403.8200n 0.001387 403.8300n 0.001394 403.8400n 0.001400 403.8500n 0.001406 403.8600n 0.001412 403.8700n 0.001418 403.8800n 0.001425 403.8900n 0.001431 403.9000n 0.001437 403.9100n 0.001443 403.9200n 0.001450 403.9300n 0.001456 403.9400n 0.001462
+ 403.9500n 0.001468 403.9600n 0.001474 403.9700n 0.001480 403.9800n 0.001486 403.9900n 0.001492 404.0000n 0.001498 404.0100n 0.001504 404.0200n 0.001510 404.0300n 0.001515 404.0400n 0.001521 404.0500n 0.001526 404.0600n 0.001531 404.0700n 0.001537 404.0800n 0.001542 404.0900n 0.001546
+ 404.1000n 0.001551 404.1100n 0.001556 404.1200n 0.001560 404.1300n 0.001564 404.1400n 0.001568 404.1500n 0.001572 404.1600n 0.001576 404.1700n 0.001580 404.1800n 0.001583 404.1900n 0.001586 404.2000n 0.001589 404.2100n 0.001592 404.2200n 0.001594 404.2300n 0.001596 404.2400n 0.001598
+ 404.2500n 0.001600 404.2600n 0.001602 404.2700n 0.001603 404.2800n 0.001604 404.2900n 0.001605 404.3000n 0.001606 404.3100n 0.001606 404.3200n 0.001606 404.3300n 0.001606 404.3400n 0.001605 404.3500n 0.001605 404.3600n 0.001604 404.3700n 0.001602 404.3800n 0.001601 404.3900n 0.001599
+ 404.4000n 0.001597 404.4100n 0.001595 404.4200n 0.001592 404.4300n 0.001589 404.4400n 0.001586 404.4500n 0.001583 404.4600n 0.001579 404.4700n 0.001575 404.4800n 0.001571 404.4900n 0.001566 404.5000n 0.001562 404.5100n 0.001557 404.5200n 0.001551 404.5300n 0.001546 404.5400n 0.001540
+ 404.5500n 0.001534 404.5600n 0.001528 404.5700n 0.001521 404.5800n 0.001515 404.5900n 0.001508 404.6000n 0.001501 404.6100n 0.001493 404.6200n 0.001486 404.6300n 0.001478 404.6400n 0.001470 404.6500n 0.001461 404.6600n 0.001453 404.6700n 0.001444 404.6800n 0.001435 404.6900n 0.001426
+ 404.7000n 0.001417 404.7100n 0.001408 404.7200n 0.001398 404.7300n 0.001389 404.7400n 0.001379 404.7500n 0.001369 404.7600n 0.001359 404.7700n 0.001349 404.7800n 0.001339 404.7900n 0.001328 404.8000n 0.001318 404.8100n 0.001307 404.8200n 0.001297 404.8300n 0.001286 404.8400n 0.001275
+ 404.8500n 0.001265 404.8600n 0.001254 404.8700n 0.001243 404.8800n 0.001232 404.8900n 0.001221 404.9000n 0.001210 404.9100n 0.001199 404.9200n 0.001189 404.9300n 0.001178 404.9400n 0.001167 404.9500n 0.001156 404.9600n 0.001146 404.9700n 0.001135 404.9800n 0.001125 404.9900n 0.001114
+ 405.0000n 0.001104 405.0100n 0.001094 405.0200n 0.001083 405.0300n 0.001073 405.0400n 0.001064 405.0500n 0.001054 405.0600n 0.001044 405.0700n 0.001035 405.0800n 0.001026 405.0900n 0.001017 405.1000n 0.001008 405.1100n 0.000999 405.1200n 0.000991 405.1300n 0.000982 405.1400n 0.000974
+ 405.1500n 0.000967 405.1600n 0.000959 405.1700n 0.000952 405.1800n 0.000945 405.1900n 0.000938 405.2000n 0.000931 405.2100n 0.000925 405.2200n 0.000919 405.2300n 0.000914 405.2400n 0.000908 405.2500n 0.000903 405.2600n 0.000898 405.2700n 0.000894 405.2800n 0.000890 405.2900n 0.000886
+ 405.3000n 0.000882 405.3100n 0.000879 405.3200n 0.000876 405.3300n 0.000873 405.3400n 0.000871 405.3500n 0.000869 405.3600n 0.000868 405.3700n 0.000866 405.3800n 0.000866 405.3900n 0.000865 405.4000n 0.000865 405.4100n 0.000865 405.4200n 0.000865 405.4300n 0.000866 405.4400n 0.000867
+ 405.4500n 0.000869 405.4600n 0.000871 405.4700n 0.000873 405.4800n 0.000876 405.4900n 0.000878 405.5000n 0.000882 405.5100n 0.000885 405.5200n 0.000889 405.5300n 0.000893 405.5400n 0.000898 405.5500n 0.000903 405.5600n 0.000908 405.5700n 0.000913 405.5800n 0.000919 405.5900n 0.000925
+ 405.6000n 0.000931 405.6100n 0.000938 405.6200n 0.000945 405.6300n 0.000952 405.6400n 0.000960 405.6500n 0.000967 405.6600n 0.000975 405.6700n 0.000983 405.6800n 0.000992 405.6900n 0.001000 405.7000n 0.001009 405.7100n 0.001018 405.7200n 0.001028 405.7300n 0.001037 405.7400n 0.001047
+ 405.7500n 0.001056 405.7600n 0.001066 405.7700n 0.001076 405.7800n 0.001087 405.7900n 0.001097 405.8000n 0.001107 405.8100n 0.001118 405.8200n 0.001128 405.8300n 0.001139 405.8400n 0.001150 405.8500n 0.001161 405.8600n 0.001171 405.8700n 0.001182 405.8800n 0.001193 405.8900n 0.001204
+ 405.9000n 0.001215 405.9100n 0.001225 405.9200n 0.001236 405.9300n 0.001247 405.9400n 0.001258 405.9500n 0.001268 405.9600n 0.001278 405.9700n 0.001289 405.9800n 0.001299 405.9900n 0.001309 406.0000n 0.001319 406.0100n 0.001329 406.0200n 0.001338 406.0300n 0.001348 406.0400n 0.001357
+ 406.0500n 0.001366 406.0600n 0.001374 406.0700n 0.001383 406.0800n 0.001391 406.0900n 0.001399 406.1000n 0.001406 406.1100n 0.001414 406.1200n 0.001421 406.1300n 0.001427 406.1400n 0.001434 406.1500n 0.001440 406.1600n 0.001445 406.1700n 0.001451 406.1800n 0.001455 406.1900n 0.001460
+ 406.2000n 0.001464 406.2100n 0.001468 406.2200n 0.001471 406.2300n 0.001474 406.2400n 0.001476 406.2500n 0.001478 406.2600n 0.001479 406.2700n 0.001480 406.2800n 0.001480 406.2900n 0.001480 406.3000n 0.001480 406.3100n 0.001479 406.3200n 0.001477 406.3300n 0.001475 406.3400n 0.001472
+ 406.3500n 0.001469 406.3600n 0.001465 406.3700n 0.001461 406.3800n 0.001456 406.3900n 0.001450 406.4000n 0.001444 406.4100n 0.001438 406.4200n 0.001431 406.4300n 0.001423 406.4400n 0.001415 406.4500n 0.001406 406.4600n 0.001396 406.4700n 0.001386 406.4800n 0.001375 406.4900n 0.001364
+ 406.5000n 0.001352 406.5100n 0.001340 406.5200n 0.001327 406.5300n 0.001313 406.5400n 0.001299 406.5500n 0.001284 406.5600n 0.001269 406.5700n 0.001253 406.5800n 0.001237 406.5900n 0.001220 406.6000n 0.001202 406.6100n 0.001184 406.6200n 0.001165 406.6300n 0.001146 406.6400n 0.001126
+ 406.6500n 0.001106 406.6600n 0.001085 406.6700n 0.001063 406.6800n 0.001041 406.6900n 0.001019 406.7000n 0.000996 406.7100n 0.000973 406.7200n 0.000949 406.7300n 0.000925 406.7400n 0.000900 406.7500n 0.000875 406.7600n 0.000849 406.7700n 0.000823 406.7800n 0.000797 406.7900n 0.000770
+ 406.8000n 0.000743 406.8100n 0.000715 406.8200n 0.000687 406.8300n 0.000659 406.8400n 0.000630 406.8500n 0.000601 406.8600n 0.000572 406.8700n 0.000543 406.8800n 0.000513 406.8900n 0.000483 406.9000n 0.000453 406.9100n 0.000423 406.9200n 0.000392 406.9300n 0.000361 406.9400n 0.000330
+ 406.9500n 0.000299 406.9600n 0.000268 406.9700n 0.000237 406.9800n 0.000205 406.9900n 0.000174 407.0000n 0.000142 407.0100n 0.000111 407.0200n 0.000079 407.0300n 0.000047 407.0400n 0.000016 407.0500n -0.000016 407.0600n -0.000047 407.0700n -0.000079 407.0800n -0.000110 407.0900n -0.000141
+ 407.1000n -0.000172 407.1100n -0.000203 407.1200n -0.000234 407.1300n -0.000265 407.1400n -0.000295 407.1500n -0.000325 407.1600n -0.000355 407.1700n -0.000385 407.1800n -0.000414 407.1900n -0.000443 407.2000n -0.000472 407.2100n -0.000501 407.2200n -0.000529 407.2300n -0.000557 407.2400n -0.000584
+ 407.2500n -0.000611 407.2600n -0.000638 407.2700n -0.000664 407.2800n -0.000689 407.2900n -0.000715 407.3000n -0.000739 407.3100n -0.000764 407.3200n -0.000788 407.3300n -0.000811 407.3400n -0.000834 407.3500n -0.000856 407.3600n -0.000877 407.3700n -0.000899 407.3800n -0.000919 407.3900n -0.000939
+ 407.4000n -0.000958 407.4100n -0.000977 407.4200n -0.000995 407.4300n -0.001012 407.4400n -0.001029 407.4500n -0.001045 407.4600n -0.001061 407.4700n -0.001075 407.4800n -0.001089 407.4900n -0.001103 407.5000n -0.001115 407.5100n -0.001127 407.5200n -0.001139 407.5300n -0.001149 407.5400n -0.001159
+ 407.5500n -0.001168 407.5600n -0.001176 407.5700n -0.001184 407.5800n -0.001191 407.5900n -0.001197 407.6000n -0.001202 407.6100n -0.001207 407.6200n -0.001211 407.6300n -0.001214 407.6400n -0.001216 407.6500n -0.001218 407.6600n -0.001219 407.6700n -0.001219 407.6800n -0.001219 407.6900n -0.001217
+ 407.7000n -0.001215 407.7100n -0.001213 407.7200n -0.001209 407.7300n -0.001205 407.7400n -0.001200 407.7500n -0.001195 407.7600n -0.001188 407.7700n -0.001181 407.7800n -0.001174 407.7900n -0.001165 407.8000n -0.001156 407.8100n -0.001147 407.8200n -0.001137 407.8300n -0.001126 407.8400n -0.001114
+ 407.8500n -0.001102 407.8600n -0.001089 407.8700n -0.001076 407.8800n -0.001062 407.8900n -0.001048 407.9000n -0.001033 407.9100n -0.001017 407.9200n -0.001001 407.9300n -0.000985 407.9400n -0.000968 407.9500n -0.000950 407.9600n -0.000932 407.9700n -0.000914 407.9800n -0.000895 407.9900n -0.000876
+ 408.0000n -0.000856 408.0100n -0.000837 408.0200n -0.000816 408.0300n -0.000796 408.0400n -0.000775 408.0500n -0.000754 408.0600n -0.000732 408.0700n -0.000710 408.0800n -0.000688 408.0900n -0.000666 408.1000n -0.000644 408.1100n -0.000621 408.1200n -0.000599 408.1300n -0.000576 408.1400n -0.000553
+ 408.1500n -0.000530 408.1600n -0.000507 408.1700n -0.000484 408.1800n -0.000461 408.1900n -0.000437 408.2000n -0.000414 408.2100n -0.000391 408.2200n -0.000368 408.2300n -0.000345 408.2400n -0.000322 408.2500n -0.000299 408.2600n -0.000277 408.2700n -0.000254 408.2800n -0.000232 408.2900n -0.000210
+ 408.3000n -0.000188 408.3100n -0.000166 408.3200n -0.000145 408.3300n -0.000123 408.3400n -0.000103 408.3500n -0.000082 408.3600n -0.000062 408.3700n -0.000042 408.3800n -0.000022 408.3900n -0.000003 408.4000n 0.000015 408.4100n 0.000034 408.4200n 0.000051 408.4300n 0.000069 408.4400n 0.000086
+ 408.4500n 0.000102 408.4600n 0.000118 408.4700n 0.000134 408.4800n 0.000148 408.4900n 0.000163 408.5000n 0.000177 408.5100n 0.000190 408.5200n 0.000202 408.5300n 0.000214 408.5400n 0.000226 408.5500n 0.000237 408.5600n 0.000247 408.5700n 0.000256 408.5800n 0.000265 408.5900n 0.000273
+ 408.6000n 0.000281 408.6100n 0.000288 408.6200n 0.000294 408.6300n 0.000300 408.6400n 0.000304 408.6500n 0.000308 408.6600n 0.000312 408.6700n 0.000315 408.6800n 0.000316 408.6900n 0.000318 408.7000n 0.000318 408.7100n 0.000318 408.7200n 0.000317 408.7300n 0.000315 408.7400n 0.000313
+ 408.7500n 0.000310 408.7600n 0.000306 408.7700n 0.000301 408.7800n 0.000296 408.7900n 0.000290 408.8000n 0.000283 408.8100n 0.000276 408.8200n 0.000267 408.8300n 0.000259 408.8400n 0.000249 408.8500n 0.000239 408.8600n 0.000228 408.8700n 0.000216 408.8800n 0.000204 408.8900n 0.000190
+ 408.9000n 0.000177 408.9100n 0.000162 408.9200n 0.000147 408.9300n 0.000132 408.9400n 0.000116 408.9500n 0.000099 408.9600n 0.000081 408.9700n 0.000063 408.9800n 0.000045 408.9900n 0.000025 409.0000n 0.000006 409.0100n -0.000014 409.0200n -0.000035 409.0300n -0.000056 409.0400n -0.000078
+ 409.0500n -0.000100 409.0600n -0.000123 409.0700n -0.000146 409.0800n -0.000170 409.0900n -0.000193 409.1000n -0.000218 409.1100n -0.000242 409.1200n -0.000267 409.1300n -0.000293 409.1400n -0.000318 409.1500n -0.000344 409.1600n -0.000370 409.1700n -0.000397 409.1800n -0.000423 409.1900n -0.000450
+ 409.2000n -0.000477 409.2100n -0.000504 409.2200n -0.000531 409.2300n -0.000559 409.2400n -0.000586 409.2500n -0.000614 409.2600n -0.000642 409.2700n -0.000669 409.2800n -0.000697 409.2900n -0.000725 409.3000n -0.000752 409.3100n -0.000780 409.3200n -0.000807 409.3300n -0.000835 409.3400n -0.000862
+ 409.3500n -0.000889 409.3600n -0.000916 409.3700n -0.000943 409.3800n -0.000970 409.3900n -0.000996 409.4000n -0.001022 409.4100n -0.001048 409.4200n -0.001074 409.4300n -0.001099 409.4400n -0.001124 409.4500n -0.001149 409.4600n -0.001173 409.4700n -0.001197 409.4800n -0.001220 409.4900n -0.001244
+ 409.5000n -0.001266 409.5100n -0.001288 409.5200n -0.001310 409.5300n -0.001331 409.5400n -0.001352 409.5500n -0.001372 409.5600n -0.001392 409.5700n -0.001411 409.5800n -0.001429 409.5900n -0.001447 409.6000n -0.001464 409.6100n -0.001481 409.6200n -0.001497 409.6300n -0.001512 409.6400n -0.001527
+ 409.6500n -0.001541 409.6600n -0.001554 409.6700n -0.001567 409.6800n -0.001579 409.6900n -0.001590 409.7000n -0.001600 409.7100n -0.001610 409.7200n -0.001619 409.7300n -0.001627 409.7400n -0.001635 409.7500n -0.001642 409.7600n -0.001648 409.7700n -0.001653 409.7800n -0.001657 409.7900n -0.001661
+ 409.8000n -0.001664 409.8100n -0.001666 409.8200n -0.001667 409.8300n -0.001667 409.8400n -0.001667 409.8500n -0.001666 409.8600n -0.001664 409.8700n -0.001661 409.8800n -0.001658 409.8900n -0.001654 409.9000n -0.001649 409.9100n -0.001643 409.9200n -0.001636 409.9300n -0.001629 409.9400n -0.001621
+ 409.9500n -0.001612 409.9600n -0.001602 409.9700n -0.001591 409.9800n -0.001580 409.9900n -0.001568 410.0000n -0.001556 410.0100n -0.001542 410.0200n -0.001528 410.0300n -0.001514 410.0400n -0.001498 410.0500n -0.001482 410.0600n -0.001465 410.0700n -0.001448 410.0800n -0.001430 410.0900n -0.001411
+ 410.1000n -0.001392 410.1100n -0.001372 410.1200n -0.001352 410.1300n -0.001331 410.1400n -0.001309 410.1500n -0.001287 410.1600n -0.001264 410.1700n -0.001241 410.1800n -0.001218 410.1900n -0.001194 410.2000n -0.001169 410.2100n -0.001145 410.2200n -0.001119 410.2300n -0.001094 410.2400n -0.001068
+ 410.2500n -0.001042 410.2600n -0.001015 410.2700n -0.000988 410.2800n -0.000961 410.2900n -0.000933 410.3000n -0.000906 410.3100n -0.000878 410.3200n -0.000850 410.3300n -0.000822 410.3400n -0.000793 410.3500n -0.000765 410.3600n -0.000736 410.3700n -0.000708 410.3800n -0.000679 410.3900n -0.000650
+ 410.4000n -0.000622 410.4100n -0.000593 410.4200n -0.000564 410.4300n -0.000536 410.4400n -0.000507 410.4500n -0.000479 410.4600n -0.000451 410.4700n -0.000423 410.4800n -0.000395 410.4900n -0.000367 410.5000n -0.000340 410.5100n -0.000313 410.5200n -0.000286 410.5300n -0.000259 410.5400n -0.000233
+ 410.5500n -0.000207 410.5600n -0.000181 410.5700n -0.000156 410.5800n -0.000131 410.5900n -0.000107 410.6000n -0.000083 410.6100n -0.000059 410.6200n -0.000036 410.6300n -0.000014 410.6400n 0.000008 410.6500n 0.000029 410.6600n 0.000050 410.6700n 0.000071 410.6800n 0.000090 410.6900n 0.000110
+ 410.7000n 0.000128 410.7100n 0.000146 410.7200n 0.000163 410.7300n 0.000179 410.7400n 0.000195 410.7500n 0.000210 410.7600n 0.000225 410.7700n 0.000238 410.7800n 0.000251 410.7900n 0.000264 410.8000n 0.000275 410.8100n 0.000286 410.8200n 0.000295 410.8300n 0.000304 410.8400n 0.000313
+ 410.8500n 0.000320 410.8600n 0.000327 410.8700n 0.000332 410.8800n 0.000337 410.8900n 0.000341 410.9000n 0.000345 410.9100n 0.000347 410.9200n 0.000349 410.9300n 0.000349 410.9400n 0.000349 410.9500n 0.000348 410.9600n 0.000346 410.9700n 0.000343 410.9800n 0.000339 410.9900n 0.000335
+ 411.0000n 0.000329 411.0100n 0.000323 411.0200n 0.000316 411.0300n 0.000308 411.0400n 0.000299 411.0500n 0.000289 411.0600n 0.000279 411.0700n 0.000267 411.0800n 0.000255 411.0900n 0.000242 411.1000n 0.000228 411.1100n 0.000213 411.1200n 0.000197 411.1300n 0.000181 411.1400n 0.000164
+ 411.1500n 0.000146 411.1600n 0.000127 411.1700n 0.000107 411.1800n 0.000087 411.1900n 0.000066 411.2000n 0.000044 411.2100n 0.000022 411.2200n -0.000001 411.2300n -0.000025 411.2400n -0.000050 411.2500n -0.000075 411.2600n -0.000101 411.2700n -0.000127 411.2800n -0.000154 411.2900n -0.000182
+ 411.3000n -0.000210 411.3100n -0.000239 411.3200n -0.000268 411.3300n -0.000298 411.3400n -0.000328 411.3500n -0.000359 411.3600n -0.000390 411.3700n -0.000422 411.3800n -0.000454 411.3900n -0.000487 411.4000n -0.000519 411.4100n -0.000553 411.4200n -0.000586 411.4300n -0.000620 411.4400n -0.000654
+ 411.4500n -0.000689 411.4600n -0.000724 411.4700n -0.000759 411.4800n -0.000794 411.4900n -0.000829 411.5000n -0.000865 411.5100n -0.000900 411.5200n -0.000936 411.5300n -0.000972 411.5400n -0.001008 411.5500n -0.001043 411.5600n -0.001079 411.5700n -0.001115 411.5800n -0.001151 411.5900n -0.001187
+ 411.6000n -0.001223 411.6100n -0.001259 411.6200n -0.001294 411.6300n -0.001330 411.6400n -0.001365 411.6500n -0.001400 411.6600n -0.001435 411.6700n -0.001469 411.6800n -0.001504 411.6900n -0.001538 411.7000n -0.001572 411.7100n -0.001605 411.7200n -0.001638 411.7300n -0.001671 411.7400n -0.001704
+ 411.7500n -0.001736 411.7600n -0.001767 411.7700n -0.001798 411.7800n -0.001829 411.7900n -0.001859 411.8000n -0.001889 411.8100n -0.001918 411.8200n -0.001947 411.8300n -0.001975 411.8400n -0.002002 411.8500n -0.002029 411.8600n -0.002055 411.8700n -0.002081 411.8800n -0.002106 411.8900n -0.002130
+ 411.9000n -0.002154 411.9100n -0.002177 411.9200n -0.002200 411.9300n -0.002221 411.9400n -0.002242 411.9500n -0.002262 411.9600n -0.002282 411.9700n -0.002300 411.9800n -0.002318 411.9900n -0.002335 412.0000n -0.002352 412.0100n -0.002367 412.0200n -0.002382 412.0300n -0.002396 412.0400n -0.002409
+ 412.0500n -0.002421 412.0600n -0.002433 412.0700n -0.002444 412.0800n -0.002453 412.0900n -0.002462 412.1000n -0.002470 412.1100n -0.002477 412.1200n -0.002484 412.1300n -0.002489 412.1400n -0.002494 412.1500n -0.002498 412.1600n -0.002500 412.1700n -0.002502 412.1800n -0.002504 412.1900n -0.002504
+ 412.2000n -0.002503 412.2100n -0.002502 412.2200n -0.002499 412.2300n -0.002496 412.2400n -0.002492 412.2500n -0.002487 412.2600n -0.002482 412.2700n -0.002475 412.2800n -0.002468 412.2900n -0.002459 412.3000n -0.002450 412.3100n -0.002440 412.3200n -0.002430 412.3300n -0.002418 412.3400n -0.002406
+ 412.3500n -0.002393 412.3600n -0.002379 412.3700n -0.002364 412.3800n -0.002349 412.3900n -0.002333 412.4000n -0.002316 412.4100n -0.002298 412.4200n -0.002280 412.4300n -0.002261 412.4400n -0.002241 412.4500n -0.002221 412.4600n -0.002200 412.4700n -0.002178 412.4800n -0.002156 412.4900n -0.002133
+ 412.5000n -0.002109 412.5100n -0.002085 412.5200n -0.002060 412.5300n -0.002035 412.5400n -0.002009 412.5500n -0.001983 412.5600n -0.001956 412.5700n -0.001928 412.5800n -0.001901 412.5900n -0.001872 412.6000n -0.001844 412.6100n -0.001814 412.6200n -0.001785 412.6300n -0.001755 412.6400n -0.001724
+ 412.6500n -0.001694 412.6600n -0.001663 412.6700n -0.001631 412.6800n -0.001600 412.6900n -0.001568 412.7000n -0.001535 412.7100n -0.001503 412.7200n -0.001470 412.7300n -0.001437 412.7400n -0.001404 412.7500n -0.001370 412.7600n -0.001337 412.7700n -0.001303 412.7800n -0.001269 412.7900n -0.001235
+ 412.8000n -0.001201 412.8100n -0.001167 412.8200n -0.001133 412.8300n -0.001099 412.8400n -0.001065 412.8500n -0.001030 412.8600n -0.000996 412.8700n -0.000962 412.8800n -0.000928 412.8900n -0.000894 412.9000n -0.000860 412.9100n -0.000826 412.9200n -0.000792 412.9300n -0.000758 412.9400n -0.000724
+ 412.9500n -0.000691 412.9600n -0.000657 412.9700n -0.000624 412.9800n -0.000591 412.9900n -0.000559 413.0000n -0.000526 413.0100n -0.000494 413.0200n -0.000462 413.0300n -0.000430 413.0400n -0.000399 413.0500n -0.000367 413.0600n -0.000336 413.0700n -0.000306 413.0800n -0.000275 413.0900n -0.000245
+ 413.1000n -0.000216 413.1100n -0.000186 413.1200n -0.000157 413.1300n -0.000129 413.1400n -0.000101 413.1500n -0.000073 413.1600n -0.000045 413.1700n -0.000018 413.1800n 0.000008 413.1900n 0.000034 413.2000n 0.000060 413.2100n 0.000086 413.2200n 0.000110 413.2300n 0.000135 413.2400n 0.000159
+ 413.2500n 0.000183 413.2600n 0.000206 413.2700n 0.000228 413.2800n 0.000250 413.2900n 0.000272 413.3000n 0.000293 413.3100n 0.000314 413.3200n 0.000334 413.3300n 0.000354 413.3400n 0.000374 413.3500n 0.000392 413.3600n 0.000411 413.3700n 0.000429 413.3800n 0.000446 413.3900n 0.000463
+ 413.4000n 0.000479 413.4100n 0.000495 413.4200n 0.000510 413.4300n 0.000525 413.4400n 0.000540 413.4500n 0.000554 413.4600n 0.000567 413.4700n 0.000580 413.4800n 0.000593 413.4900n 0.000605 413.5000n 0.000616 413.5100n 0.000627 413.5200n 0.000638 413.5300n 0.000648 413.5400n 0.000658
+ 413.5500n 0.000667 413.5600n 0.000676 413.5700n 0.000684 413.5800n 0.000692 413.5900n 0.000699 413.6000n 0.000706 413.6100n 0.000713 413.6200n 0.000719 413.6300n 0.000724 413.6400n 0.000730 413.6500n 0.000735 413.6600n 0.000739 413.6700n 0.000743 413.6800n 0.000747 413.6900n 0.000750
+ 413.7000n 0.000753 413.7100n 0.000756 413.7200n 0.000758 413.7300n 0.000760 413.7400n 0.000761 413.7500n 0.000762 413.7600n 0.000763 413.7700n 0.000763 413.7800n 0.000763 413.7900n 0.000763 413.8000n 0.000763 413.8100n 0.000762 413.8200n 0.000761 413.8300n 0.000759 413.8400n 0.000758
+ 413.8500n 0.000756 413.8600n 0.000754 413.8700n 0.000751 413.8800n 0.000748 413.8900n 0.000745 413.9000n 0.000742 413.9100n 0.000739 413.9200n 0.000735 413.9300n 0.000731 413.9400n 0.000727 413.9500n 0.000722 413.9600n 0.000718 413.9700n 0.000713 413.9800n 0.000708 413.9900n 0.000703
+ 414.0000n 0.000698 414.0100n 0.000692 414.0200n 0.000687 414.0300n 0.000681 414.0400n 0.000675 414.0500n 0.000669 414.0600n 0.000662 414.0700n 0.000656 414.0800n 0.000649 414.0900n 0.000643 414.1000n 0.000636 414.1100n 0.000629 414.1200n 0.000622 414.1300n 0.000615 414.1400n 0.000608
+ 414.1500n 0.000600 414.1600n 0.000593 414.1700n 0.000586 414.1800n 0.000578 414.1900n 0.000570 414.2000n 0.000562 414.2100n 0.000555 414.2200n 0.000547 414.2300n 0.000539 414.2400n 0.000531 414.2500n 0.000522 414.2600n 0.000514 414.2700n 0.000506 414.2800n 0.000498 414.2900n 0.000489
+ 414.3000n 0.000481 414.3100n 0.000472 414.3200n 0.000464 414.3300n 0.000455 414.3400n 0.000447 414.3500n 0.000438 414.3600n 0.000429 414.3700n 0.000421 414.3800n 0.000412 414.3900n 0.000403 414.4000n 0.000394 414.4100n 0.000385 414.4200n 0.000376 414.4300n 0.000367 414.4400n 0.000358
+ 414.4500n 0.000349 414.4600n 0.000340 414.4700n 0.000331 414.4800n 0.000322 414.4900n 0.000312 414.5000n 0.000303 414.5100n 0.000294 414.5200n 0.000285 414.5300n 0.000275 414.5400n 0.000266 414.5500n 0.000256 414.5600n 0.000247 414.5700n 0.000238 414.5800n 0.000228 414.5900n 0.000218
+ 414.6000n 0.000209 414.6100n 0.000199 414.6200n 0.000189 414.6300n 0.000180 414.6400n 0.000170 414.6500n 0.000160 414.6600n 0.000150 414.6700n 0.000140 414.6800n 0.000130 414.6900n 0.000120 414.7000n 0.000110 414.7100n 0.000100 414.7200n 0.000090 414.7300n 0.000080 414.7400n 0.000070
+ 414.7500n 0.000060 414.7600n 0.000049 414.7700n 0.000039 414.7800n 0.000028 414.7900n 0.000018 414.8000n 0.000008 414.8100n -0.000003 414.8200n -0.000014 414.8300n -0.000024 414.8400n -0.000035 414.8500n -0.000046 414.8600n -0.000056 414.8700n -0.000067 414.8800n -0.000078 414.8900n -0.000089
+ 414.9000n -0.000100 414.9100n -0.000111 414.9200n -0.000122 414.9300n -0.000133 414.9400n -0.000144 414.9500n -0.000155 414.9600n -0.000166 414.9700n -0.000177 414.9800n -0.000188 414.9900n -0.000200 415.0000n -0.000211 415.0100n -0.000222 415.0200n -0.000234 415.0300n -0.000245 415.0400n -0.000256
+ 415.0500n -0.000268 415.0600n -0.000279 415.0700n -0.000290 415.0800n -0.000302 415.0900n -0.000313 415.1000n -0.000324 415.1100n -0.000336 415.1200n -0.000347 415.1300n -0.000359 415.1400n -0.000370 415.1500n -0.000381 415.1600n -0.000393 415.1700n -0.000404 415.1800n -0.000415 415.1900n -0.000426
+ 415.2000n -0.000438 415.2100n -0.000449 415.2200n -0.000460 415.2300n -0.000471 415.2400n -0.000482 415.2500n -0.000493 415.2600n -0.000504 415.2700n -0.000515 415.2800n -0.000525 415.2900n -0.000536 415.3000n -0.000547 415.3100n -0.000557 415.3200n -0.000568 415.3300n -0.000578 415.3400n -0.000588
+ 415.3500n -0.000598 415.3600n -0.000608 415.3700n -0.000618 415.3800n -0.000628 415.3900n -0.000637 415.4000n -0.000647 415.4100n -0.000656 415.4200n -0.000666 415.4300n -0.000675 415.4400n -0.000684 415.4500n -0.000692 415.4600n -0.000701 415.4700n -0.000709 415.4800n -0.000718 415.4900n -0.000726
+ 415.5000n -0.000734 415.5100n -0.000742 415.5200n -0.000749 415.5300n -0.000756 415.5400n -0.000764 415.5500n -0.000771 415.5600n -0.000777 415.5700n -0.000784 415.5800n -0.000790 415.5900n -0.000796 415.6000n -0.000802 415.6100n -0.000808 415.6200n -0.000813 415.6300n -0.000818 415.6400n -0.000823
+ 415.6500n -0.000828 415.6600n -0.000833 415.6700n -0.000837 415.6800n -0.000841 415.6900n -0.000845 415.7000n -0.000848 415.7100n -0.000851 415.7200n -0.000854 415.7300n -0.000857 415.7400n -0.000859 415.7500n -0.000861 415.7600n -0.000863 415.7700n -0.000865 415.7800n -0.000866 415.7900n -0.000867
+ 415.8000n -0.000868 415.8100n -0.000869 415.8200n -0.000869 415.8300n -0.000869 415.8400n -0.000869 415.8500n -0.000868 415.8600n -0.000868 415.8700n -0.000867 415.8800n -0.000865 415.8900n -0.000864 415.9000n -0.000862 415.9100n -0.000860 415.9200n -0.000857 415.9300n -0.000855 415.9400n -0.000852
+ 415.9500n -0.000849 415.9600n -0.000845 415.9700n -0.000842 415.9800n -0.000838 415.9900n -0.000834 416.0000n -0.000830 416.0100n -0.000825 416.0200n -0.000820 416.0300n -0.000815 416.0400n -0.000810 416.0500n -0.000805 416.0600n -0.000799 416.0700n -0.000793 416.0800n -0.000787 416.0900n -0.000781
+ 416.1000n -0.000775 416.1100n -0.000768 416.1200n -0.000761 416.1300n -0.000754 416.1400n -0.000747 416.1500n -0.000740 416.1600n -0.000733 416.1700n -0.000725 416.1800n -0.000717 416.1900n -0.000710 416.2000n -0.000702 416.2100n -0.000694 416.2200n -0.000686 416.2300n -0.000678 416.2400n -0.000669
+ 416.2500n -0.000661 416.2600n -0.000653 416.2700n -0.000644 416.2800n -0.000636 416.2900n -0.000627 416.3000n -0.000619 416.3100n -0.000610 416.3200n -0.000602 416.3300n -0.000593 416.3400n -0.000584 416.3500n -0.000576 416.3600n -0.000567 416.3700n -0.000559 416.3800n -0.000550 416.3900n -0.000542
+ 416.4000n -0.000533 416.4100n -0.000525 416.4200n -0.000517 416.4300n -0.000509 416.4400n -0.000501 416.4500n -0.000493 416.4600n -0.000485 416.4700n -0.000477 416.4800n -0.000470 416.4900n -0.000462 416.5000n -0.000455 416.5100n -0.000448 416.5200n -0.000441 416.5300n -0.000434 416.5400n -0.000427
+ 416.5500n -0.000421 416.5600n -0.000415 416.5700n -0.000409 416.5800n -0.000403 416.5900n -0.000397 416.6000n -0.000392 416.6100n -0.000387 416.6200n -0.000382 416.6300n -0.000377 416.6400n -0.000373 416.6500n -0.000369 416.6600n -0.000365 416.6700n -0.000362 416.6800n -0.000358 416.6900n -0.000355
+ 416.7000n -0.000353 416.7100n -0.000350 416.7200n -0.000348 416.7300n -0.000346 416.7400n -0.000345 416.7500n -0.000344 416.7600n -0.000343 416.7700n -0.000342 416.7800n -0.000342 416.7900n -0.000342 416.8000n -0.000342 416.8100n -0.000343 416.8200n -0.000344 416.8300n -0.000345 416.8400n -0.000347
+ 416.8500n -0.000349 416.8600n -0.000352 416.8700n -0.000354 416.8800n -0.000357 416.8900n -0.000361 416.9000n -0.000364 416.9100n -0.000368 416.9200n -0.000373 416.9300n -0.000378 416.9400n -0.000383 416.9500n -0.000388 416.9600n -0.000393 416.9700n -0.000399 416.9800n -0.000406 416.9900n -0.000412
+ 417.0000n -0.000419 417.0100n -0.000426 417.0200n -0.000434 417.0300n -0.000441 417.0400n -0.000449 417.0500n -0.000458 417.0600n -0.000466 417.0700n -0.000475 417.0800n -0.000484 417.0900n -0.000493 417.1000n -0.000503 417.1100n -0.000513 417.1200n -0.000523 417.1300n -0.000533 417.1400n -0.000543
+ 417.1500n -0.000554 417.1600n -0.000565 417.1700n -0.000575 417.1800n -0.000587 417.1900n -0.000598 417.2000n -0.000609 417.2100n -0.000621 417.2200n -0.000632 417.2300n -0.000644 417.2400n -0.000656 417.2500n -0.000668 417.2600n -0.000680 417.2700n -0.000692 417.2800n -0.000704 417.2900n -0.000716
+ 417.3000n -0.000729 417.3100n -0.000741 417.3200n -0.000753 417.3300n -0.000765 417.3400n -0.000777 417.3500n -0.000790 417.3600n -0.000802 417.3700n -0.000814 417.3800n -0.000826 417.3900n -0.000838 417.4000n -0.000849 417.4100n -0.000861 417.4200n -0.000872 417.4300n -0.000884 417.4400n -0.000895
+ 417.4500n -0.000906 417.4600n -0.000917 417.4700n -0.000927 417.4800n -0.000938 417.4900n -0.000948 417.5000n -0.000958 417.5100n -0.000967 417.5200n -0.000977 417.5300n -0.000986 417.5400n -0.000995 417.5500n -0.001003 417.5600n -0.001011 417.5700n -0.001019 417.5800n -0.001027 417.5900n -0.001034
+ 417.6000n -0.001041 417.6100n -0.001047 417.6200n -0.001053 417.6300n -0.001059 417.6400n -0.001064 417.6500n -0.001069 417.6600n -0.001073 417.6700n -0.001077 417.6800n -0.001080 417.6900n -0.001083 417.7000n -0.001086 417.7100n -0.001087 417.7200n -0.001089 417.7300n -0.001090 417.7400n -0.001090
+ 417.7500n -0.001090 417.7600n -0.001090 417.7700n -0.001088 417.7800n -0.001087 417.7900n -0.001085 417.8000n -0.001082 417.8100n -0.001078 417.8200n -0.001074 417.8300n -0.001070 417.8400n -0.001065 417.8500n -0.001059 417.8600n -0.001053 417.8700n -0.001046 417.8800n -0.001039 417.8900n -0.001031
+ 417.9000n -0.001022 417.9100n -0.001013 417.9200n -0.001003 417.9300n -0.000993 417.9400n -0.000982 417.9500n -0.000970 417.9600n -0.000958 417.9700n -0.000945 417.9800n -0.000932 417.9900n -0.000918 418.0000n -0.000903 418.0100n -0.000888 418.0200n -0.000872 418.0300n -0.000856 418.0400n -0.000839
+ 418.0500n -0.000822 418.0600n -0.000803 418.0700n -0.000785 418.0800n -0.000766 418.0900n -0.000746 418.1000n -0.000726 418.1100n -0.000705 418.1200n -0.000684 418.1300n -0.000662 418.1400n -0.000640 418.1500n -0.000617 418.1600n -0.000594 418.1700n -0.000571 418.1800n -0.000547 418.1900n -0.000522
+ 418.2000n -0.000497 418.2100n -0.000472 418.2200n -0.000446 418.2300n -0.000420 418.2400n -0.000393 418.2500n -0.000366 418.2600n -0.000339 418.2700n -0.000311 418.2800n -0.000283 418.2900n -0.000255 418.3000n -0.000226 418.3100n -0.000198 418.3200n -0.000169 418.3300n -0.000139 418.3400n -0.000110
+ 418.3500n -0.000080 418.3600n -0.000050 418.3700n -0.000020 418.3800n 0.000010 418.3900n 0.000041 418.4000n 0.000071 418.4100n 0.000102 418.4200n 0.000133 418.4300n 0.000163 418.4400n 0.000194 418.4500n 0.000225 418.4600n 0.000256 418.4700n 0.000287 418.4800n 0.000318 418.4900n 0.000348
+ 418.5000n 0.000379 418.5100n 0.000410 418.5200n 0.000440 418.5300n 0.000470 418.5400n 0.000501 418.5500n 0.000531 418.5600n 0.000561 418.5700n 0.000590 418.5800n 0.000620 418.5900n 0.000649 418.6000n 0.000678 418.6100n 0.000706 418.6200n 0.000735 418.6300n 0.000763 418.6400n 0.000790
+ 418.6500n 0.000817 418.6600n 0.000844 418.6700n 0.000871 418.6800n 0.000897 418.6900n 0.000923 418.7000n 0.000948 418.7100n 0.000973 418.7200n 0.000997 418.7300n 0.001021 418.7400n 0.001044 418.7500n 0.001067 418.7600n 0.001089 418.7700n 0.001110 418.7800n 0.001132 418.7900n 0.001152
+ 418.8000n 0.001172 418.8100n 0.001191 418.8200n 0.001210 418.8300n 0.001228 418.8400n 0.001245 418.8500n 0.001261 418.8600n 0.001277 418.8700n 0.001293 418.8800n 0.001307 418.8900n 0.001321 418.9000n 0.001334 418.9100n 0.001346 418.9200n 0.001358 418.9300n 0.001369 418.9400n 0.001379
+ 418.9500n 0.001388 418.9600n 0.001397 418.9700n 0.001405 418.9800n 0.001412 418.9900n 0.001418 419.0000n 0.001423 419.0100n 0.001428 419.0200n 0.001432 419.0300n 0.001435 419.0400n 0.001437 419.0500n 0.001438 419.0600n 0.001439 419.0700n 0.001439 419.0800n 0.001438 419.0900n 0.001436
+ 419.1000n 0.001433 419.1100n 0.001430 419.1200n 0.001426 419.1300n 0.001421 419.1400n 0.001415 419.1500n 0.001408 419.1600n 0.001401 419.1700n 0.001392 419.1800n 0.001383 419.1900n 0.001374 419.2000n 0.001363 419.2100n 0.001352 419.2200n 0.001340 419.2300n 0.001327 419.2400n 0.001313
+ 419.2500n 0.001299 419.2600n 0.001284 419.2700n 0.001268 419.2800n 0.001252 419.2900n 0.001235 419.3000n 0.001217 419.3100n 0.001199 419.3200n 0.001180 419.3300n 0.001160 419.3400n 0.001140 419.3500n 0.001119 419.3600n 0.001098 419.3700n 0.001076 419.3800n 0.001053 419.3900n 0.001030
+ 419.4000n 0.001006 419.4100n 0.000982 419.4200n 0.000957 419.4300n 0.000932 419.4400n 0.000907 419.4500n 0.000881 419.4600n 0.000854 419.4700n 0.000828 419.4800n 0.000800 419.4900n 0.000773 419.5000n 0.000745 419.5100n 0.000717 419.5200n 0.000688 419.5300n 0.000660 419.5400n 0.000631
+ 419.5500n 0.000601 419.5600n 0.000572 419.5700n 0.000542 419.5800n 0.000512 419.5900n 0.000482 419.6000n 0.000452 419.6100n 0.000422 419.6200n 0.000392 419.6300n 0.000361 419.6400n 0.000331 419.6500n 0.000300 419.6600n 0.000270 419.6700n 0.000239 419.6800n 0.000209 419.6900n 0.000179
+ 419.7000n 0.000148 419.7100n 0.000118 419.7200n 0.000088 419.7300n 0.000058 419.7400n 0.000029 419.7500n -0.000001 419.7600n -0.000030 419.7700n -0.000059 419.7800n -0.000088 419.7900n -0.000117 419.8000n -0.000145 419.8100n -0.000173 419.8200n -0.000201 419.8300n -0.000228 419.8400n -0.000255
+ 419.8500n -0.000282 419.8600n -0.000308 419.8700n -0.000333 419.8800n -0.000359 419.8900n -0.000384 419.9000n -0.000408 419.9100n -0.000432 419.9200n -0.000455 419.9300n -0.000478 419.9400n -0.000500 419.9500n -0.000522 419.9600n -0.000543 419.9700n -0.000564 419.9800n -0.000584 419.9900n -0.000604
+ 420.0000n -0.000622 420.0100n -0.000641 420.0200n -0.000658 420.0300n -0.000675 420.0400n -0.000691 420.0500n -0.000707 420.0600n -0.000722 420.0700n -0.000736 420.0800n -0.000749 420.0900n -0.000762 420.1000n -0.000774 420.1100n -0.000786 420.1200n -0.000796 420.1300n -0.000806 420.1400n -0.000815
+ 420.1500n -0.000824 420.1600n -0.000831 420.1700n -0.000838 420.1800n -0.000845 420.1900n -0.000850 420.2000n -0.000855 420.2100n -0.000859 420.2200n -0.000862 420.2300n -0.000864 420.2400n -0.000866 420.2500n -0.000867 420.2600n -0.000867 420.2700n -0.000866 420.2800n -0.000865 420.2900n -0.000863
+ 420.3000n -0.000860 420.3100n -0.000856 420.3200n -0.000852 420.3300n -0.000847 420.3400n -0.000841 420.3500n -0.000835 420.3600n -0.000828 420.3700n -0.000820 420.3800n -0.000811 420.3900n -0.000802 420.4000n -0.000792 420.4100n -0.000782 420.4200n -0.000770 420.4300n -0.000758 420.4400n -0.000746
+ 420.4500n -0.000733 420.4600n -0.000719 420.4700n -0.000705 420.4800n -0.000690 420.4900n -0.000674 420.5000n -0.000658 420.5100n -0.000641 420.5200n -0.000624 420.5300n -0.000607 420.5400n -0.000588 420.5500n -0.000570 420.5600n -0.000550 420.5700n -0.000531 420.5800n -0.000511 420.5900n -0.000490
+ 420.6000n -0.000469 420.6100n -0.000448 420.6200n -0.000426 420.6300n -0.000404 420.6400n -0.000382 420.6500n -0.000359 420.6600n -0.000336 420.6700n -0.000313 420.6800n -0.000289 420.6900n -0.000265 420.7000n -0.000241 420.7100n -0.000217 420.7200n -0.000192 420.7300n -0.000167 420.7400n -0.000142
+ 420.7500n -0.000117 420.7600n -0.000092 420.7700n -0.000067 420.7800n -0.000041 420.7900n -0.000016 420.8000n 0.000010 420.8100n 0.000036 420.8200n 0.000061 420.8300n 0.000087 420.8400n 0.000113 420.8500n 0.000139 420.8600n 0.000164 420.8700n 0.000190 420.8800n 0.000215 420.8900n 0.000241
+ 420.9000n 0.000266 420.9100n 0.000292 420.9200n 0.000317 420.9300n 0.000342 420.9400n 0.000367 420.9500n 0.000391 420.9600n 0.000416 420.9700n 0.000440 420.9800n 0.000464 420.9900n 0.000488 421.0000n 0.000512 421.0100n 0.000535 421.0200n 0.000558 421.0300n 0.000581 421.0400n 0.000603
+ 421.0500n 0.000625 421.0600n 0.000647 421.0700n 0.000669 421.0800n 0.000690 421.0900n 0.000711 421.1000n 0.000732 421.1100n 0.000752 421.1200n 0.000772 421.1300n 0.000791 421.1400n 0.000810 421.1500n 0.000829 421.1600n 0.000847 421.1700n 0.000865 421.1800n 0.000882 421.1900n 0.000899
+ 421.2000n 0.000916 421.2100n 0.000932 421.2200n 0.000948 421.2300n 0.000963 421.2400n 0.000978 421.2500n 0.000992 421.2600n 0.001006 421.2700n 0.001020 421.2800n 0.001033 421.2900n 0.001045 421.3000n 0.001058 421.3100n 0.001069 421.3200n 0.001081 421.3300n 0.001091 421.3400n 0.001102
+ 421.3500n 0.001112 421.3600n 0.001121 421.3700n 0.001130 421.3800n 0.001139 421.3900n 0.001147 421.4000n 0.001155 421.4100n 0.001162 421.4200n 0.001169 421.4300n 0.001176 421.4400n 0.001182 421.4500n 0.001188 421.4600n 0.001193 421.4700n 0.001198 421.4800n 0.001203 421.4900n 0.001207
+ 421.5000n 0.001211 421.5100n 0.001214 421.5200n 0.001217 421.5300n 0.001220 421.5400n 0.001222 421.5500n 0.001224 421.5600n 0.001226 421.5700n 0.001228 421.5800n 0.001229 421.5900n 0.001230 421.6000n 0.001230 421.6100n 0.001230 421.6200n 0.001231 421.6300n 0.001230 421.6400n 0.001230
+ 421.6500n 0.001229 421.6600n 0.001228 421.6700n 0.001227 421.6800n 0.001226 421.6900n 0.001225 421.7000n 0.001223 421.7100n 0.001221 421.7200n 0.001219 421.7300n 0.001217 421.7400n 0.001215 421.7500n 0.001213 421.7600n 0.001210 421.7700n 0.001208 421.7800n 0.001205 421.7900n 0.001203
+ 421.8000n 0.001200 421.8100n 0.001197 421.8200n 0.001195 421.8300n 0.001192 421.8400n 0.001189 421.8500n 0.001186 421.8600n 0.001183 421.8700n 0.001181 421.8800n 0.001178 421.8900n 0.001175 421.9000n 0.001172 421.9100n 0.001170 421.9200n 0.001167 421.9300n 0.001165 421.9400n 0.001163
+ 421.9500n 0.001160 421.9600n 0.001158 421.9700n 0.001156 421.9800n 0.001154 421.9900n 0.001152 422.0000n 0.001151 422.0100n 0.001149 422.0200n 0.001148 422.0300n 0.001147 422.0400n 0.001146 422.0500n 0.001145 422.0600n 0.001144 422.0700n 0.001143 422.0800n 0.001143 422.0900n 0.001143
+ 422.1000n 0.001143 422.1100n 0.001143 422.1200n 0.001144 422.1300n 0.001144 422.1400n 0.001145 422.1500n 0.001146 422.1600n 0.001147 422.1700n 0.001149 422.1800n 0.001150 422.1900n 0.001152 422.2000n 0.001154 422.2100n 0.001156 422.2200n 0.001159 422.2300n 0.001161 422.2400n 0.001164
+ 422.2500n 0.001167 422.2600n 0.001171 422.2700n 0.001174 422.2800n 0.001178 422.2900n 0.001182 422.3000n 0.001186 422.3100n 0.001190 422.3200n 0.001194 422.3300n 0.001199 422.3400n 0.001203 422.3500n 0.001208 422.3600n 0.001213 422.3700n 0.001218 422.3800n 0.001224 422.3900n 0.001229
+ 422.4000n 0.001234 422.4100n 0.001240 422.4200n 0.001246 422.4300n 0.001252 422.4400n 0.001257 422.4500n 0.001263 422.4600n 0.001269 422.4700n 0.001276 422.4800n 0.001282 422.4900n 0.001288 422.5000n 0.001294 422.5100n 0.001300 422.5200n 0.001306 422.5300n 0.001312 422.5400n 0.001319
+ 422.5500n 0.001325 422.5600n 0.001331 422.5700n 0.001337 422.5800n 0.001342 422.5900n 0.001348 422.6000n 0.001354 422.6100n 0.001360 422.6200n 0.001365 422.6300n 0.001370 422.6400n 0.001375 422.6500n 0.001380 422.6600n 0.001385 422.6700n 0.001390 422.6800n 0.001394 422.6900n 0.001398
+ 422.7000n 0.001402 422.7100n 0.001406 422.7200n 0.001409 422.7300n 0.001412 422.7400n 0.001415 422.7500n 0.001418 422.7600n 0.001420 422.7700n 0.001422 422.7800n 0.001423 422.7900n 0.001425 422.8000n 0.001425 422.8100n 0.001426 422.8200n 0.001426 422.8300n 0.001425 422.8400n 0.001425
+ 422.8500n 0.001423 422.8600n 0.001422 422.8700n 0.001420 422.8800n 0.001417 422.8900n 0.001414 422.9000n 0.001410 422.9100n 0.001406 422.9200n 0.001402 422.9300n 0.001397 422.9400n 0.001391 422.9500n 0.001385 422.9600n 0.001378 422.9700n 0.001371 422.9800n 0.001363 422.9900n 0.001355
+ 423.0000n 0.001346 423.0100n 0.001337 423.0200n 0.001327 423.0300n 0.001316 423.0400n 0.001305 423.0500n 0.001293 423.0600n 0.001281 423.0700n 0.001268 423.0800n 0.001254 423.0900n 0.001240 423.1000n 0.001225 423.1100n 0.001210 423.1200n 0.001194 423.1300n 0.001177 423.1400n 0.001160
+ 423.1500n 0.001142 423.1600n 0.001123 423.1700n 0.001104 423.1800n 0.001085 423.1900n 0.001064 423.2000n 0.001043 423.2100n 0.001022 423.2200n 0.001000 423.2300n 0.000977 423.2400n 0.000954 423.2500n 0.000930 423.2600n 0.000906 423.2700n 0.000881 423.2800n 0.000856 423.2900n 0.000830
+ 423.3000n 0.000803 423.3100n 0.000776 423.3200n 0.000748 423.3300n 0.000720 423.3400n 0.000692 423.3500n 0.000663 423.3600n 0.000633 423.3700n 0.000603 423.3800n 0.000573 423.3900n 0.000542 423.4000n 0.000511 423.4100n 0.000480 423.4200n 0.000448 423.4300n 0.000415 423.4400n 0.000383
+ 423.4500n 0.000349 423.4600n 0.000316 423.4700n 0.000283 423.4800n 0.000249 423.4900n 0.000214 423.5000n 0.000180 423.5100n 0.000145 423.5200n 0.000110 423.5300n 0.000075 423.5400n 0.000040 423.5500n 0.000005 423.5600n -0.000031 423.5700n -0.000066 423.5800n -0.000102 423.5900n -0.000138
+ 423.6000n -0.000173 423.6100n -0.000209 423.6200n -0.000245 423.6300n -0.000281 423.6400n -0.000316 423.6500n -0.000352 423.6600n -0.000387 423.6700n -0.000423 423.6800n -0.000458 423.6900n -0.000493 423.7000n -0.000528 423.7100n -0.000563 423.7200n -0.000597 423.7300n -0.000632 423.7400n -0.000666
+ 423.7500n -0.000699 423.7600n -0.000733 423.7700n -0.000766 423.7800n -0.000798 423.7900n -0.000830 423.8000n -0.000862 423.8100n -0.000894 423.8200n -0.000925 423.8300n -0.000955 423.8400n -0.000985 423.8500n -0.001014 423.8600n -0.001043 423.8700n -0.001072 423.8800n -0.001099 423.8900n -0.001126
+ 423.9000n -0.001153 423.9100n -0.001179 423.9200n -0.001204 423.9300n -0.001228 423.9400n -0.001252 423.9500n -0.001275 423.9600n -0.001297 423.9700n -0.001319 423.9800n -0.001340 423.9900n -0.001359 424.0000n -0.001379 424.0100n -0.001397 424.0200n -0.001414 424.0300n -0.001431 424.0400n -0.001447
+ 424.0500n -0.001461 424.0600n -0.001475 424.0700n -0.001488 424.0800n -0.001500 424.0900n -0.001512 424.1000n -0.001522 424.1100n -0.001531 424.1200n -0.001539 424.1300n -0.001547 424.1400n -0.001553 424.1500n -0.001558 424.1600n -0.001562 424.1700n -0.001566 424.1800n -0.001568 424.1900n -0.001569
+ 424.2000n -0.001570 424.2100n -0.001569 424.2200n -0.001567 424.2300n -0.001564 424.2400n -0.001560 424.2500n -0.001555 424.2600n -0.001549 424.2700n -0.001542 424.2800n -0.001534 424.2900n -0.001525 424.3000n -0.001515 424.3100n -0.001504 424.3200n -0.001492 424.3300n -0.001478 424.3400n -0.001464
+ 424.3500n -0.001449 424.3600n -0.001433 424.3700n -0.001416 424.3800n -0.001397 424.3900n -0.001378 424.4000n -0.001358 424.4100n -0.001337 424.4200n -0.001315 424.4300n -0.001292 424.4400n -0.001268 424.4500n -0.001243 424.4600n -0.001217 424.4700n -0.001191 424.4800n -0.001163 424.4900n -0.001135
+ 424.5000n -0.001106 424.5100n -0.001076 424.5200n -0.001045 424.5300n -0.001014 424.5400n -0.000981 424.5500n -0.000948 424.5600n -0.000915 424.5700n -0.000880 424.5800n -0.000845 424.5900n -0.000809 424.6000n -0.000773 424.6100n -0.000735 424.6200n -0.000698 424.6300n -0.000659 424.6400n -0.000621
+ 424.6500n -0.000581 424.6600n -0.000541 424.6700n -0.000501 424.6800n -0.000460 424.6900n -0.000419 424.7000n -0.000377 424.7100n -0.000335 424.7200n -0.000293 424.7300n -0.000250 424.7400n -0.000207 424.7500n -0.000164 424.7600n -0.000120 424.7700n -0.000077 424.7800n -0.000033 424.7900n 0.000011
+ 424.8000n 0.000056 424.8100n 0.000100 424.8200n 0.000144 424.8300n 0.000189 424.8400n 0.000233 424.8500n 0.000278 424.8600n 0.000322 424.8700n 0.000367 424.8800n 0.000411 424.8900n 0.000455 424.9000n 0.000499 424.9100n 0.000543 424.9200n 0.000587 424.9300n 0.000630 424.9400n 0.000673
+ 424.9500n 0.000716 424.9600n 0.000759 424.9700n 0.000801 424.9800n 0.000843 424.9900n 0.000885 425.0000n 0.000926 425.0100n 0.000967 425.0200n 0.001007 425.0300n 0.001047 425.0400n 0.001086 425.0500n 0.001125 425.0600n 0.001163 425.0700n 0.001201 425.0800n 0.001237 425.0900n 0.001274
+ 425.1000n 0.001310 425.1100n 0.001345 425.1200n 0.001379 425.1300n 0.001413 425.1400n 0.001445 425.1500n 0.001478 425.1600n 0.001509 425.1700n 0.001540 425.1800n 0.001569 425.1900n 0.001598 425.2000n 0.001626 425.2100n 0.001654 425.2200n 0.001680 425.2300n 0.001706 425.2400n 0.001730
+ 425.2500n 0.001754 425.2600n 0.001777 425.2700n 0.001798 425.2800n 0.001819 425.2900n 0.001839 425.3000n 0.001858 425.3100n 0.001876 425.3200n 0.001893 425.3300n 0.001909 425.3400n 0.001924 425.3500n 0.001938 425.3600n 0.001951 425.3700n 0.001963 425.3800n 0.001973 425.3900n 0.001983
+ 425.4000n 0.001992 425.4100n 0.002000 425.4200n 0.002006 425.4300n 0.002012 425.4400n 0.002017 425.4500n 0.002020 425.4600n 0.002023 425.4700n 0.002024 425.4800n 0.002024 425.4900n 0.002024 425.5000n 0.002022 425.5100n 0.002019 425.5200n 0.002016 425.5300n 0.002011 425.5400n 0.002005
+ 425.5500n 0.001998 425.5600n 0.001990 425.5700n 0.001982 425.5800n 0.001972 425.5900n 0.001961 425.6000n 0.001949 425.6100n 0.001937 425.6200n 0.001923 425.6300n 0.001909 425.6400n 0.001893 425.6500n 0.001877 425.6600n 0.001860 425.6700n 0.001841 425.6800n 0.001822 425.6900n 0.001803
+ 425.7000n 0.001782 425.7100n 0.001760 425.7200n 0.001738 425.7300n 0.001715 425.7400n 0.001691 425.7500n 0.001667 425.7600n 0.001641 425.7700n 0.001615 425.7800n 0.001588 425.7900n 0.001561 425.8000n 0.001533 425.8100n 0.001504 425.8200n 0.001475 425.8300n 0.001445 425.8400n 0.001414
+ 425.8500n 0.001383 425.8600n 0.001352 425.8700n 0.001319 425.8800n 0.001287 425.8900n 0.001254 425.9000n 0.001220 425.9100n 0.001186 425.9200n 0.001152 425.9300n 0.001117 425.9400n 0.001082 425.9500n 0.001046 425.9600n 0.001011 425.9700n 0.000974 425.9800n 0.000938 425.9900n 0.000901
+ 426.0000n 0.000865 426.0100n 0.000827 426.0200n 0.000790 426.0300n 0.000753 426.0400n 0.000715 426.0500n 0.000677 426.0600n 0.000640 426.0700n 0.000602 426.0800n 0.000564 426.0900n 0.000526 426.1000n 0.000488 426.1100n 0.000450 426.1200n 0.000412 426.1300n 0.000374 426.1400n 0.000336
+ 426.1500n 0.000298 426.1600n 0.000261 426.1700n 0.000223 426.1800n 0.000186 426.1900n 0.000148 426.2000n 0.000111 426.2100n 0.000074 426.2200n 0.000038 426.2300n 0.000001 426.2400n -0.000035 426.2500n -0.000071 426.2600n -0.000107 426.2700n -0.000142 426.2800n -0.000177 426.2900n -0.000212
+ 426.3000n -0.000247 426.3100n -0.000281 426.3200n -0.000315 426.3300n -0.000348 426.3400n -0.000381 426.3500n -0.000414 426.3600n -0.000446 426.3700n -0.000478 426.3800n -0.000509 426.3900n -0.000540 426.4000n -0.000571 426.4100n -0.000601 426.4200n -0.000630 426.4300n -0.000659 426.4400n -0.000688
+ 426.4500n -0.000716 426.4600n -0.000744 426.4700n -0.000771 426.4800n -0.000798 426.4900n -0.000824 426.5000n -0.000850 426.5100n -0.000875 426.5200n -0.000900 426.5300n -0.000924 426.5400n -0.000947 426.5500n -0.000971 426.5600n -0.000993 426.5700n -0.001015 426.5800n -0.001037 426.5900n -0.001058
+ 426.6000n -0.001079 426.6100n -0.001099 426.6200n -0.001118 426.6300n -0.001137 426.6400n -0.001156 426.6500n -0.001174 426.6600n -0.001192 426.6700n -0.001209 426.6800n -0.001225 426.6900n -0.001241 426.7000n -0.001257 426.7100n -0.001272 426.7200n -0.001287 426.7300n -0.001301 426.7400n -0.001315
+ 426.7500n -0.001328 426.7600n -0.001341 426.7700n -0.001353 426.7800n -0.001365 426.7900n -0.001377 426.8000n -0.001388 426.8100n -0.001399 426.8200n -0.001409 426.8300n -0.001419 426.8400n -0.001429 426.8500n -0.001438 426.8600n -0.001447 426.8700n -0.001456 426.8800n -0.001464 426.8900n -0.001472
+ 426.9000n -0.001479 426.9100n -0.001487 426.9200n -0.001494 426.9300n -0.001500 426.9400n -0.001507 426.9500n -0.001513 426.9600n -0.001519 426.9700n -0.001525 426.9800n -0.001530 426.9900n -0.001536 427.0000n -0.001541 427.0100n -0.001546 427.0200n -0.001550 427.0300n -0.001555 427.0400n -0.001559
+ 427.0500n -0.001564 427.0600n -0.001568 427.0700n -0.001572 427.0800n -0.001576 427.0900n -0.001579 427.1000n -0.001583 427.1100n -0.001586 427.1200n -0.001590 427.1300n -0.001593 427.1400n -0.001596 427.1500n -0.001600 427.1600n -0.001603 427.1700n -0.001606 427.1800n -0.001609 427.1900n -0.001612
+ 427.2000n -0.001615 427.2100n -0.001618 427.2200n -0.001621 427.2300n -0.001625 427.2400n -0.001628 427.2500n -0.001631 427.2600n -0.001634 427.2700n -0.001637 427.2800n -0.001640 427.2900n -0.001643 427.3000n -0.001646 427.3100n -0.001650 427.3200n -0.001653 427.3300n -0.001656 427.3400n -0.001660
+ 427.3500n -0.001663 427.3600n -0.001666 427.3700n -0.001670 427.3800n -0.001673 427.3900n -0.001677 427.4000n -0.001681 427.4100n -0.001684 427.4200n -0.001688 427.4300n -0.001692 427.4400n -0.001696 427.4500n -0.001700 427.4600n -0.001704 427.4700n -0.001708 427.4800n -0.001712 427.4900n -0.001716
+ 427.5000n -0.001720 427.5100n -0.001724 427.5200n -0.001728 427.5300n -0.001732 427.5400n -0.001737 427.5500n -0.001741 427.5600n -0.001745 427.5700n -0.001749 427.5800n -0.001753 427.5900n -0.001757 427.6000n -0.001761 427.6100n -0.001765 427.6200n -0.001769 427.6300n -0.001773 427.6400n -0.001777
+ 427.6500n -0.001781 427.6600n -0.001785 427.6700n -0.001788 427.6800n -0.001792 427.6900n -0.001795 427.7000n -0.001798 427.7100n -0.001801 427.7200n -0.001804 427.7300n -0.001807 427.7400n -0.001810 427.7500n -0.001812 427.7600n -0.001814 427.7700n -0.001816 427.7800n -0.001818 427.7900n -0.001820
+ 427.8000n -0.001821 427.8100n -0.001822 427.8200n -0.001823 427.8300n -0.001823 427.8400n -0.001824 427.8500n -0.001824 427.8600n -0.001823 427.8700n -0.001822 427.8800n -0.001821 427.8900n -0.001820 427.9000n -0.001818 427.9100n -0.001816 427.9200n -0.001813 427.9300n -0.001810 427.9400n -0.001807
+ 427.9500n -0.001803 427.9600n -0.001799 427.9700n -0.001794 427.9800n -0.001789 427.9900n -0.001783 428.0000n -0.001777 428.0100n -0.001770 428.0200n -0.001763 428.0300n -0.001755 428.0400n -0.001747 428.0500n -0.001738 428.0600n -0.001728 428.0700n -0.001719 428.0800n -0.001708 428.0900n -0.001697
+ 428.1000n -0.001685 428.1100n -0.001673 428.1200n -0.001660 428.1300n -0.001646 428.1400n -0.001632 428.1500n -0.001618 428.1600n -0.001602 428.1700n -0.001586 428.1800n -0.001569 428.1900n -0.001552 428.2000n -0.001534 428.2100n -0.001515 428.2200n -0.001496 428.2300n -0.001476 428.2400n -0.001455
+ 428.2500n -0.001434 428.2600n -0.001412 428.2700n -0.001389 428.2800n -0.001366 428.2900n -0.001342 428.3000n -0.001317 428.3100n -0.001292 428.3200n -0.001266 428.3300n -0.001239 428.3400n -0.001212 428.3500n -0.001184 428.3600n -0.001155 428.3700n -0.001125 428.3800n -0.001095 428.3900n -0.001065
+ 428.4000n -0.001033 428.4100n -0.001002 428.4200n -0.000969 428.4300n -0.000936 428.4400n -0.000902 428.4500n -0.000868 428.4600n -0.000833 428.4700n -0.000797 428.4800n -0.000761 428.4900n -0.000724 428.5000n -0.000687 428.5100n -0.000649 428.5200n -0.000611 428.5300n -0.000572 428.5400n -0.000533
+ 428.5500n -0.000493 428.5600n -0.000453 428.5700n -0.000412 428.5800n -0.000371 428.5900n -0.000330 428.6000n -0.000288 428.6100n -0.000246 428.6200n -0.000203 428.6300n -0.000160 428.6400n -0.000117 428.6500n -0.000073 428.6600n -0.000029 428.6700n 0.000015 428.6800n 0.000059 428.6900n 0.000104
+ 428.7000n 0.000149 428.7100n 0.000194 428.7200n 0.000239 428.7300n 0.000284 428.7400n 0.000330 428.7500n 0.000375 428.7600n 0.000421 428.7700n 0.000467 428.7800n 0.000512 428.7900n 0.000558 428.8000n 0.000604 428.8100n 0.000649 428.8200n 0.000695 428.8300n 0.000740 428.8400n 0.000786
+ 428.8500n 0.000831 428.8600n 0.000876 428.8700n 0.000921 428.8800n 0.000965 428.8900n 0.001010 428.9000n 0.001054 428.9100n 0.001097 428.9200n 0.001141 428.9300n 0.001184 428.9400n 0.001227 428.9500n 0.001269 428.9600n 0.001311 428.9700n 0.001352 428.9800n 0.001393 428.9900n 0.001434
+ 429.0000n 0.001474 429.0100n 0.001513 429.0200n 0.001552 429.0300n 0.001590 429.0400n 0.001628 429.0500n 0.001665 429.0600n 0.001701 429.0700n 0.001737 429.0800n 0.001772 429.0900n 0.001806 429.1000n 0.001840 429.1100n 0.001873 429.1200n 0.001905 429.1300n 0.001936 429.1400n 0.001966
+ 429.1500n 0.001996 429.1600n 0.002024 429.1700n 0.002052 429.1800n 0.002079 429.1900n 0.002105 429.2000n 0.002130 429.2100n 0.002154 429.2200n 0.002177 429.2300n 0.002199 429.2400n 0.002220 429.2500n 0.002240 429.2600n 0.002259 429.2700n 0.002277 429.2800n 0.002294 429.2900n 0.002310
+ 429.3000n 0.002325 429.3100n 0.002338 429.3200n 0.002351 429.3300n 0.002362 429.3400n 0.002373 429.3500n 0.002382 429.3600n 0.002390 429.3700n 0.002397 429.3800n 0.002403 429.3900n 0.002408 429.4000n 0.002411 429.4100n 0.002414 429.4200n 0.002415 429.4300n 0.002415 429.4400n 0.002414
+ 429.4500n 0.002412 429.4600n 0.002409 429.4700n 0.002404 429.4800n 0.002399 429.4900n 0.002392 429.5000n 0.002384 429.5100n 0.002375 429.5200n 0.002364 429.5300n 0.002353 429.5400n 0.002341 429.5500n 0.002327 429.5600n 0.002312 429.5700n 0.002296 429.5800n 0.002279 429.5900n 0.002261
+ 429.6000n 0.002242 429.6100n 0.002222 429.6200n 0.002201 429.6300n 0.002178 429.6400n 0.002155 429.6500n 0.002131 429.6600n 0.002105 429.6700n 0.002079 429.6800n 0.002052 429.6900n 0.002023 429.7000n 0.001994 429.7100n 0.001964 429.7200n 0.001933 429.7300n 0.001901 429.7400n 0.001868
+ 429.7500n 0.001834 429.7600n 0.001800 429.7700n 0.001765 429.7800n 0.001729 429.7900n 0.001692 429.8000n 0.001654 429.8100n 0.001616 429.8200n 0.001577 429.8300n 0.001537 429.8400n 0.001497 429.8500n 0.001456 429.8600n 0.001414 429.8700n 0.001372 429.8800n 0.001330 429.8900n 0.001286
+ 429.9000n 0.001243 429.9100n 0.001198 429.9200n 0.001154 429.9300n 0.001109 429.9400n 0.001063 429.9500n 0.001017 429.9600n 0.000971 429.9700n 0.000925 429.9800n 0.000878 429.9900n 0.000831 430.0000n 0.000783 430.0100n 0.000736 430.0200n 0.000688 430.0300n 0.000640 430.0400n 0.000592
+ 430.0500n 0.000544 430.0600n 0.000496 430.0700n 0.000448 430.0800n 0.000400 430.0900n 0.000351 430.1000n 0.000303 430.1100n 0.000255 430.1200n 0.000207 430.1300n 0.000159 430.1400n 0.000111 430.1500n 0.000064 430.1600n 0.000016 430.1700n -0.000031 430.1800n -0.000078 430.1900n -0.000125
+ 430.2000n -0.000171 430.2100n -0.000217 430.2200n -0.000263 430.2300n -0.000309 430.2400n -0.000354 430.2500n -0.000398 430.2600n -0.000443 430.2700n -0.000486 430.2800n -0.000530 430.2900n -0.000572 430.3000n -0.000615 430.3100n -0.000656 430.3200n -0.000698 430.3300n -0.000738 430.3400n -0.000778
+ 430.3500n -0.000818 430.3600n -0.000857 430.3700n -0.000895 430.3800n -0.000932 430.3900n -0.000969 430.4000n -0.001005 430.4100n -0.001041 430.4200n -0.001075 430.4300n -0.001109 430.4400n -0.001143 430.4500n -0.001175 430.4600n -0.001207 430.4700n -0.001238 430.4800n -0.001268 430.4900n -0.001298
+ 430.5000n -0.001326 430.5100n -0.001354 430.5200n -0.001381 430.5300n -0.001407 430.5400n -0.001432 430.5500n -0.001457 430.5600n -0.001480 430.5700n -0.001503 430.5800n -0.001525 430.5900n -0.001546 430.6000n -0.001566 430.6100n -0.001586 430.6200n -0.001604 430.6300n -0.001622 430.6400n -0.001639
+ 430.6500n -0.001655 430.6600n -0.001670 430.6700n -0.001684 430.6800n -0.001697 430.6900n -0.001710 430.7000n -0.001722 430.7100n -0.001732 430.7200n -0.001742 430.7300n -0.001752 430.7400n -0.001760 430.7500n -0.001767 430.7600n -0.001774 430.7700n -0.001780 430.7800n -0.001785 430.7900n -0.001790
+ 430.8000n -0.001793 430.8100n -0.001796 430.8200n -0.001798 430.8300n -0.001800 430.8400n -0.001800 430.8500n -0.001800 430.8600n -0.001799 430.8700n -0.001798 430.8800n -0.001796 430.8900n -0.001793 430.9000n -0.001789 430.9100n -0.001785 430.9200n -0.001781 430.9300n -0.001775 430.9400n -0.001769
+ 430.9500n -0.001763 430.9600n -0.001756 430.9700n -0.001748 430.9800n -0.001740 430.9900n -0.001731 431.0000n -0.001722 431.0100n -0.001712 431.0200n -0.001702 431.0300n -0.001692 431.0400n -0.001681 431.0500n -0.001669 431.0600n -0.001658 431.0700n -0.001645 431.0800n -0.001633 431.0900n -0.001620
+ 431.1000n -0.001607 431.1100n -0.001593 431.1200n -0.001579 431.1300n -0.001565 431.1400n -0.001551 431.1500n -0.001536 431.1600n -0.001521 431.1700n -0.001506 431.1800n -0.001491 431.1900n -0.001476 431.2000n -0.001460 431.2100n -0.001445 431.2200n -0.001429 431.2300n -0.001413 431.2400n -0.001397
+ 431.2500n -0.001381 431.2600n -0.001365 431.2700n -0.001348 431.2800n -0.001332 431.2900n -0.001316 431.3000n -0.001300 431.3100n -0.001283 431.3200n -0.001267 431.3300n -0.001251 431.3400n -0.001235 431.3500n -0.001219 431.3600n -0.001203 431.3700n -0.001187 431.3800n -0.001171 431.3900n -0.001155
+ 431.4000n -0.001139 431.4100n -0.001124 431.4200n -0.001108 431.4300n -0.001093 431.4400n -0.001078 431.4500n -0.001063 431.4600n -0.001049 431.4700n -0.001034 431.4800n -0.001020 431.4900n -0.001005 431.5000n -0.000991 431.5100n -0.000978 431.5200n -0.000964 431.5300n -0.000951 431.5400n -0.000937
+ 431.5500n -0.000924 431.5600n -0.000912 431.5700n -0.000899 431.5800n -0.000887 431.5900n -0.000875 431.6000n -0.000863 431.6100n -0.000851 431.6200n -0.000840 431.6300n -0.000829 431.6400n -0.000818 431.6500n -0.000807 431.6600n -0.000796 431.6700n -0.000786 431.6800n -0.000776 431.6900n -0.000766
+ 431.7000n -0.000756 431.7100n -0.000747 431.7200n -0.000738 431.7300n -0.000729 431.7400n -0.000720 431.7500n -0.000711 431.7600n -0.000702 431.7700n -0.000694 431.7800n -0.000686 431.7900n -0.000678 431.8000n -0.000670 431.8100n -0.000662 431.8200n -0.000655 431.8300n -0.000647 431.8400n -0.000640
+ 431.8500n -0.000632 431.8600n -0.000625 431.8700n -0.000618 431.8800n -0.000611 431.8900n -0.000604 431.9000n -0.000597 431.9100n -0.000590 431.9200n -0.000584 431.9300n -0.000577 431.9400n -0.000570 431.9500n -0.000563 431.9600n -0.000557 431.9700n -0.000550 431.9800n -0.000543 431.9900n -0.000536
+ 432.0000n -0.000529 432.0100n -0.000522 432.0200n -0.000515 432.0300n -0.000508 432.0400n -0.000500 432.0500n -0.000493 432.0600n -0.000485 432.0700n -0.000478 432.0800n -0.000470 432.0900n -0.000462 432.1000n -0.000454 432.1100n -0.000445 432.1200n -0.000437 432.1300n -0.000428 432.1400n -0.000419
+ 432.1500n -0.000410 432.1600n -0.000400 432.1700n -0.000390 432.1800n -0.000380 432.1900n -0.000370 432.2000n -0.000360 432.2100n -0.000349 432.2200n -0.000338 432.2300n -0.000326 432.2400n -0.000314 432.2500n -0.000302 432.2600n -0.000290 432.2700n -0.000277 432.2800n -0.000264 432.2900n -0.000251
+ 432.3000n -0.000237 432.3100n -0.000223 432.3200n -0.000208 432.3300n -0.000193 432.3400n -0.000178 432.3500n -0.000162 432.3600n -0.000146 432.3700n -0.000130 432.3800n -0.000113 432.3900n -0.000095 432.4000n -0.000078 432.4100n -0.000060 432.4200n -0.000041 432.4300n -0.000023 432.4400n -0.000003
+ 432.4500n 0.000016 432.4600n 0.000036 432.4700n 0.000057 432.4800n 0.000078 432.4900n 0.000099 432.5000n 0.000120 432.5100n 0.000142 432.5200n 0.000165 432.5300n 0.000187 432.5400n 0.000210 432.5500n 0.000234 432.5600n 0.000258 432.5700n 0.000282 432.5800n 0.000306 432.5900n 0.000331
+ 432.6000n 0.000356 432.6100n 0.000381 432.6200n 0.000407 432.6300n 0.000433 432.6400n 0.000459 432.6500n 0.000486 432.6600n 0.000513 432.6700n 0.000540 432.6800n 0.000567 432.6900n 0.000594 432.7000n 0.000622 432.7100n 0.000650 432.7200n 0.000678 432.7300n 0.000706 432.7400n 0.000734
+ 432.7500n 0.000763 432.7600n 0.000791 432.7700n 0.000820 432.7800n 0.000848 432.7900n 0.000877 432.8000n 0.000906 432.8100n 0.000935 432.8200n 0.000964 432.8300n 0.000992 432.8400n 0.001021 432.8500n 0.001050 432.8600n 0.001078 432.8700n 0.001107 432.8800n 0.001135 432.8900n 0.001163
+ 432.9000n 0.001192 432.9100n 0.001219 432.9200n 0.001247 432.9300n 0.001275 432.9400n 0.001302 432.9500n 0.001329 432.9600n 0.001356 432.9700n 0.001382 432.9800n 0.001408 432.9900n 0.001434 433.0000n 0.001459 433.0100n 0.001484 433.0200n 0.001509 433.0300n 0.001533 433.0400n 0.001557
+ 433.0500n 0.001580 433.0600n 0.001602 433.0700n 0.001625 433.0800n 0.001646 433.0900n 0.001667 433.1000n 0.001688 433.1100n 0.001708 433.1200n 0.001727 433.1300n 0.001746 433.1400n 0.001764 433.1500n 0.001781 433.1600n 0.001798 433.1700n 0.001814 433.1800n 0.001829 433.1900n 0.001844
+ 433.2000n 0.001857 433.2100n 0.001870 433.2200n 0.001883 433.2300n 0.001894 433.2400n 0.001905 433.2500n 0.001914 433.2600n 0.001923 433.2700n 0.001931 433.2800n 0.001938 433.2900n 0.001945 433.3000n 0.001950 433.3100n 0.001954 433.3200n 0.001958 433.3300n 0.001961 433.3400n 0.001962
+ 433.3500n 0.001963 433.3600n 0.001963 433.3700n 0.001961 433.3800n 0.001959 433.3900n 0.001956 433.4000n 0.001952 433.4100n 0.001947 433.4200n 0.001941 433.4300n 0.001934 433.4400n 0.001926 433.4500n 0.001917 433.4600n 0.001907 433.4700n 0.001896 433.4800n 0.001884 433.4900n 0.001871
+ 433.5000n 0.001857 433.5100n 0.001842 433.5200n 0.001826 433.5300n 0.001809 433.5400n 0.001791 433.5500n 0.001772 433.5600n 0.001752 433.5700n 0.001731 433.5800n 0.001710 433.5900n 0.001687 433.6000n 0.001663 433.6100n 0.001639 433.6200n 0.001613 433.6300n 0.001587 433.6400n 0.001560
+ 433.6500n 0.001532 433.6600n 0.001503 433.6700n 0.001474 433.6800n 0.001443 433.6900n 0.001412 433.7000n 0.001380 433.7100n 0.001347 433.7200n 0.001314 433.7300n 0.001279 433.7400n 0.001245 433.7500n 0.001209 433.7600n 0.001173 433.7700n 0.001136 433.7800n 0.001098 433.7900n 0.001060
+ 433.8000n 0.001022 433.8100n 0.000982 433.8200n 0.000943 433.8300n 0.000903 433.8400n 0.000862 433.8500n 0.000821 433.8600n 0.000780 433.8700n 0.000738 433.8800n 0.000696 433.8900n 0.000653 433.9000n 0.000611 433.9100n 0.000568 433.9200n 0.000524 433.9300n 0.000481 433.9400n 0.000437
+ 433.9500n 0.000394 433.9600n 0.000350 433.9700n 0.000306 433.9800n 0.000262 433.9900n 0.000218 434.0000n 0.000174 434.0100n 0.000130 434.0200n 0.000087 434.0300n 0.000043 434.0400n -0.000001 434.0500n -0.000044 434.0600n -0.000087 434.0700n -0.000130 434.0800n -0.000172 434.0900n -0.000215
+ 434.1000n -0.000256 434.1100n -0.000298 434.1200n -0.000339 434.1300n -0.000380 434.1400n -0.000420 434.1500n -0.000459 434.1600n -0.000498 434.1700n -0.000537 434.1800n -0.000575 434.1900n -0.000612 434.2000n -0.000649 434.2100n -0.000685 434.2200n -0.000720 434.2300n -0.000754 434.2400n -0.000788
+ 434.2500n -0.000821 434.2600n -0.000853 434.2700n -0.000884 434.2800n -0.000914 434.2900n -0.000943 434.3000n -0.000972 434.3100n -0.000999 434.3200n -0.001026 434.3300n -0.001051 434.3400n -0.001076 434.3500n -0.001099 434.3600n -0.001121 434.3700n -0.001142 434.3800n -0.001162 434.3900n -0.001181
+ 434.4000n -0.001199 434.4100n -0.001215 434.4200n -0.001230 434.4300n -0.001245 434.4400n -0.001257 434.4500n -0.001269 434.4600n -0.001279 434.4700n -0.001288 434.4800n -0.001296 434.4900n -0.001303 434.5000n -0.001308 434.5100n -0.001312 434.5200n -0.001314 434.5300n -0.001316 434.5400n -0.001315
+ 434.5500n -0.001314 434.5600n -0.001311 434.5700n -0.001307 434.5800n -0.001302 434.5900n -0.001295 434.6000n -0.001286 434.6100n -0.001277 434.6200n -0.001266 434.6300n -0.001254 434.6400n -0.001240 434.6500n -0.001225 434.6600n -0.001209 434.6700n -0.001191 434.6800n -0.001172 434.6900n -0.001152
+ 434.7000n -0.001130 434.7100n -0.001108 434.7200n -0.001083 434.7300n -0.001058 434.7400n -0.001031 434.7500n -0.001003 434.7600n -0.000974 434.7700n -0.000944 434.7800n -0.000912 434.7900n -0.000880 434.8000n -0.000846 434.8100n -0.000811 434.8200n -0.000774 434.8300n -0.000737 434.8400n -0.000699
+ 434.8500n -0.000660 434.8600n -0.000619 434.8700n -0.000578 434.8800n -0.000535 434.8900n -0.000492 434.9000n -0.000448 434.9100n -0.000403 434.9200n -0.000357 434.9300n -0.000310 434.9400n -0.000262 434.9500n -0.000214 434.9600n -0.000165 434.9700n -0.000115 434.9800n -0.000064 434.9900n -0.000013
+ 435.0000n 0.000039 435.0100n 0.000091 435.0200n 0.000144 435.0300n 0.000198 435.0400n 0.000252 435.0500n 0.000306 435.0600n 0.000361 435.0700n 0.000416 435.0800n 0.000471 435.0900n 0.000527 435.1000n 0.000583 435.1100n 0.000639 435.1200n 0.000696 435.1300n 0.000752 435.1400n 0.000809
+ 435.1500n 0.000865 435.1600n 0.000922 435.1700n 0.000979 435.1800n 0.001035 435.1900n 0.001092 435.2000n 0.001148 435.2100n 0.001205 435.2200n 0.001261 435.2300n 0.001316 435.2400n 0.001372 435.2500n 0.001427 435.2600n 0.001482 435.2700n 0.001536 435.2800n 0.001590 435.2900n 0.001644
+ 435.3000n 0.001696 435.3100n 0.001749 435.3200n 0.001801 435.3300n 0.001852 435.3400n 0.001902 435.3500n 0.001952 435.3600n 0.002001 435.3700n 0.002049 435.3800n 0.002097 435.3900n 0.002143 435.4000n 0.002189 435.4100n 0.002234 435.4200n 0.002278 435.4300n 0.002321 435.4400n 0.002363
+ 435.4500n 0.002404 435.4600n 0.002444 435.4700n 0.002483 435.4800n 0.002520 435.4900n 0.002557 435.5000n 0.002592 435.5100n 0.002626 435.5200n 0.002659 435.5300n 0.002691 435.5400n 0.002722 435.5500n 0.002751 435.5600n 0.002779 435.5700n 0.002805 435.5800n 0.002830 435.5900n 0.002854
+ 435.6000n 0.002877 435.6100n 0.002898 435.6200n 0.002917 435.6300n 0.002935 435.6400n 0.002952 435.6500n 0.002968 435.6600n 0.002981 435.6700n 0.002994 435.6800n 0.003005 435.6900n 0.003014 435.7000n 0.003022 435.7100n 0.003028 435.7200n 0.003033 435.7300n 0.003036 435.7400n 0.003038
+ 435.7500n 0.003038 435.7600n 0.003037 435.7700n 0.003034 435.7800n 0.003030 435.7900n 0.003024 435.8000n 0.003017 435.8100n 0.003008 435.8200n 0.002997 435.8300n 0.002985 435.8400n 0.002972 435.8500n 0.002957 435.8600n 0.002940 435.8700n 0.002923 435.8800n 0.002903 435.8900n 0.002882
+ 435.9000n 0.002860 435.9100n 0.002836 435.9200n 0.002811 435.9300n 0.002785 435.9400n 0.002757 435.9500n 0.002727 435.9600n 0.002697 435.9700n 0.002665 435.9800n 0.002632 435.9900n 0.002597 436.0000n 0.002561 436.0100n 0.002524 436.0200n 0.002486 436.0300n 0.002446 436.0400n 0.002406
+ 436.0500n 0.002364 436.0600n 0.002321 436.0700n 0.002277 436.0800n 0.002232 436.0900n 0.002186 436.1000n 0.002139 436.1100n 0.002091 436.1200n 0.002042 436.1300n 0.001992 436.1400n 0.001941 436.1500n 0.001890 436.1600n 0.001837 436.1700n 0.001784 436.1800n 0.001730 436.1900n 0.001675
+ 436.2000n 0.001620 436.2100n 0.001564 436.2200n 0.001507 436.2300n 0.001450 436.2400n 0.001392 436.2500n 0.001334 436.2600n 0.001275 436.2700n 0.001216 436.2800n 0.001156 436.2900n 0.001096 436.3000n 0.001036 436.3100n 0.000975 436.3200n 0.000915 436.3300n 0.000854 436.3400n 0.000792
+ 436.3500n 0.000731 436.3600n 0.000670 436.3700n 0.000608 436.3800n 0.000547 436.3900n 0.000485 436.4000n 0.000424 436.4100n 0.000362 436.4200n 0.000301 436.4300n 0.000240 436.4400n 0.000179 436.4500n 0.000118 436.4600n 0.000057 436.4700n -0.000003 436.4800n -0.000063 436.4900n -0.000122
+ 436.5000n -0.000181 436.5100n -0.000240 436.5200n -0.000298 436.5300n -0.000356 436.5400n -0.000413 436.5500n -0.000470 436.5600n -0.000526 436.5700n -0.000581 436.5800n -0.000636 436.5900n -0.000690 436.6000n -0.000743 436.6100n -0.000796 436.6200n -0.000848 436.6300n -0.000899 436.6400n -0.000949
+ 436.6500n -0.000999 436.6600n -0.001048 436.6700n -0.001095 436.6800n -0.001142 436.6900n -0.001188 436.7000n -0.001233 436.7100n -0.001277 436.7200n -0.001320 436.7300n -0.001362 436.7400n -0.001403 436.7500n -0.001443 436.7600n -0.001482 436.7700n -0.001519 436.7800n -0.001556 436.7900n -0.001591
+ 436.8000n -0.001626 436.8100n -0.001659 436.8200n -0.001691 436.8300n -0.001722 436.8400n -0.001752 436.8500n -0.001781 436.8600n -0.001808 436.8700n -0.001834 436.8800n -0.001859 436.8900n -0.001883 436.9000n -0.001906 436.9100n -0.001927 436.9200n -0.001947 436.9300n -0.001966 436.9400n -0.001984
+ 436.9500n -0.002000 436.9600n -0.002016 436.9700n -0.002030 436.9800n -0.002043 436.9900n -0.002054 437.0000n -0.002065 437.0100n -0.002074 437.0200n -0.002082 437.0300n -0.002089 437.0400n -0.002095 437.0500n -0.002099 437.0600n -0.002102 437.0700n -0.002104 437.0800n -0.002105 437.0900n -0.002105
+ 437.1000n -0.002104 437.1100n -0.002102 437.1200n -0.002098 437.1300n -0.002094 437.1400n -0.002088 437.1500n -0.002081 437.1600n -0.002073 437.1700n -0.002065 437.1800n -0.002055 437.1900n -0.002044 437.2000n -0.002032 437.2100n -0.002019 437.2200n -0.002006 437.2300n -0.001991 437.2400n -0.001976
+ 437.2500n -0.001959 437.2600n -0.001942 437.2700n -0.001924 437.2800n -0.001905 437.2900n -0.001885 437.3000n -0.001865 437.3100n -0.001843 437.3200n -0.001822 437.3300n -0.001799 437.3400n -0.001775 437.3500n -0.001751 437.3600n -0.001727 437.3700n -0.001702 437.3800n -0.001676 437.3900n -0.001649
+ 437.4000n -0.001622 437.4100n -0.001595 437.4200n -0.001567 437.4300n -0.001539 437.4400n -0.001510 437.4500n -0.001480 437.4600n -0.001451 437.4700n -0.001421 437.4800n -0.001390 437.4900n -0.001360 437.5000n -0.001329 437.5100n -0.001298 437.5200n -0.001266 437.5300n -0.001234 437.5400n -0.001203
+ 437.5500n -0.001171 437.5600n -0.001138 437.5700n -0.001106 437.5800n -0.001074 437.5900n -0.001041 437.6000n -0.001009 437.6100n -0.000976 437.6200n -0.000944 437.6300n -0.000911 437.6400n -0.000879 437.6500n -0.000846 437.6600n -0.000814 437.6700n -0.000782 437.6800n -0.000749 437.6900n -0.000717
+ 437.7000n -0.000686 437.7100n -0.000654 437.7200n -0.000623 437.7300n -0.000591 437.7400n -0.000560 437.7500n -0.000530 437.7600n -0.000499 437.7700n -0.000469 437.7800n -0.000439 437.7900n -0.000410 437.8000n -0.000380 437.8100n -0.000351 437.8200n -0.000323 437.8300n -0.000295 437.8400n -0.000267
+ 437.8500n -0.000239 437.8600n -0.000212 437.8700n -0.000186 437.8800n -0.000160 437.8900n -0.000134 437.9000n -0.000109 437.9100n -0.000084 437.9200n -0.000060 437.9300n -0.000036 437.9400n -0.000012 437.9500n 0.000011 437.9600n 0.000033 437.9700n 0.000055 437.9800n 0.000076 437.9900n 0.000097
+ 438.0000n 0.000118 438.0100n 0.000138 438.0200n 0.000157 438.0300n 0.000176 438.0400n 0.000195 438.0500n 0.000213 438.0600n 0.000230 438.0700n 0.000247 438.0800n 0.000263 438.0900n 0.000279 438.1000n 0.000295 438.1100n 0.000310 438.1200n 0.000324 438.1300n 0.000338 438.1400n 0.000351
+ 438.1500n 0.000364 438.1600n 0.000377 438.1700n 0.000389 438.1800n 0.000400 438.1900n 0.000411 438.2000n 0.000422 438.2100n 0.000432 438.2200n 0.000442 438.2300n 0.000451 438.2400n 0.000460 438.2500n 0.000469 438.2600n 0.000477 438.2700n 0.000485 438.2800n 0.000492 438.2900n 0.000499
+ 438.3000n 0.000505 438.3100n 0.000512 438.3200n 0.000518 438.3300n 0.000523 438.3400n 0.000528 438.3500n 0.000533 438.3600n 0.000538 438.3700n 0.000542 438.3800n 0.000546 438.3900n 0.000550 438.4000n 0.000554 438.4100n 0.000557 438.4200n 0.000560 438.4300n 0.000563 438.4400n 0.000566
+ 438.4500n 0.000569 438.4600n 0.000571 438.4700n 0.000573 438.4800n 0.000575 438.4900n 0.000577 438.5000n 0.000579 438.5100n 0.000581 438.5200n 0.000582 438.5300n 0.000584 438.5400n 0.000585 438.5500n 0.000587 438.5600n 0.000588 438.5700n 0.000590 438.5800n 0.000591 438.5900n 0.000592
+ 438.6000n 0.000593 438.6100n 0.000595 438.6200n 0.000596 438.6300n 0.000597 438.6400n 0.000599 438.6500n 0.000600 438.6600n 0.000602 438.6700n 0.000603 438.6800n 0.000605 438.6900n 0.000607 438.7000n 0.000609 438.7100n 0.000611 438.7200n 0.000613 438.7300n 0.000615 438.7400n 0.000617
+ 438.7500n 0.000620 438.7600n 0.000622 438.7700n 0.000625 438.7800n 0.000628 438.7900n 0.000631 438.8000n 0.000634 438.8100n 0.000637 438.8200n 0.000641 438.8300n 0.000645 438.8400n 0.000649 438.8500n 0.000653 438.8600n 0.000657 438.8700n 0.000661 438.8800n 0.000666 438.8900n 0.000671
+ 438.9000n 0.000676 438.9100n 0.000681 438.9200n 0.000686 438.9300n 0.000692 438.9400n 0.000698 438.9500n 0.000704 438.9600n 0.000710 438.9700n 0.000716 438.9800n 0.000723 438.9900n 0.000729 439.0000n 0.000736 439.0100n 0.000743 439.0200n 0.000751 439.0300n 0.000758 439.0400n 0.000765
+ 439.0500n 0.000773 439.0600n 0.000781 439.0700n 0.000789 439.0800n 0.000797 439.0900n 0.000805 439.1000n 0.000813 439.1100n 0.000822 439.1200n 0.000830 439.1300n 0.000839 439.1400n 0.000848 439.1500n 0.000856 439.1600n 0.000865 439.1700n 0.000874 439.1800n 0.000883 439.1900n 0.000892
+ 439.2000n 0.000901 439.2100n 0.000910 439.2200n 0.000919 439.2300n 0.000928 439.2400n 0.000937 439.2500n 0.000946 439.2600n 0.000954 439.2700n 0.000963 439.2800n 0.000972 439.2900n 0.000981 439.3000n 0.000989 439.3100n 0.000998 439.3200n 0.001006 439.3300n 0.001014 439.3400n 0.001022
+ 439.3500n 0.001030 439.3600n 0.001038 439.3700n 0.001045 439.3800n 0.001053 439.3900n 0.001060 439.4000n 0.001067 439.4100n 0.001073 439.4200n 0.001080 439.4300n 0.001086 439.4400n 0.001091 439.4500n 0.001097 439.4600n 0.001102 439.4700n 0.001107 439.4800n 0.001112 439.4900n 0.001116
+ 439.5000n 0.001120 439.5100n 0.001123 439.5200n 0.001127 439.5300n 0.001129 439.5400n 0.001132 439.5500n 0.001134 439.5600n 0.001135 439.5700n 0.001136 439.5800n 0.001137 439.5900n 0.001137 439.6000n 0.001137 439.6100n 0.001136 439.6200n 0.001135 439.6300n 0.001133 439.6400n 0.001131
+ 439.6500n 0.001128 439.6600n 0.001125 439.6700n 0.001121 439.6800n 0.001116 439.6900n 0.001111 439.7000n 0.001106 439.7100n 0.001100 439.7200n 0.001094 439.7300n 0.001086 439.7400n 0.001079 439.7500n 0.001070 439.7600n 0.001062 439.7700n 0.001052 439.7800n 0.001042 439.7900n 0.001032
+ 439.8000n 0.001020 439.8100n 0.001009 439.8200n 0.000996 439.8300n 0.000983 439.8400n 0.000970 439.8500n 0.000956 439.8600n 0.000941 439.8700n 0.000926 439.8800n 0.000910 439.8900n 0.000893 439.9000n 0.000876 439.9100n 0.000858 439.9200n 0.000840 439.9300n 0.000821 439.9400n 0.000802
+ 439.9500n 0.000782 439.9600n 0.000762 439.9700n 0.000741 439.9800n 0.000719 439.9900n 0.000697 440.0000n 0.000674 440.0100n 0.000651 440.0200n 0.000627 440.0300n 0.000603 440.0400n 0.000579 440.0500n 0.000554 440.0600n 0.000528 440.0700n 0.000502 440.0800n 0.000475 440.0900n 0.000448
+ 440.1000n 0.000421 440.1100n 0.000393 440.1200n 0.000365 440.1300n 0.000336 440.1400n 0.000308 440.1500n 0.000278 440.1600n 0.000249 440.1700n 0.000219 440.1800n 0.000188 440.1900n 0.000158 440.2000n 0.000127 440.2100n 0.000096 440.2200n 0.000064 440.2300n 0.000033 440.2400n 0.000001
+ 440.2500n -0.000031 440.2600n -0.000063 440.2700n -0.000096 440.2800n -0.000128 440.2900n -0.000161 440.3000n -0.000193 440.3100n -0.000226 440.3200n -0.000259 440.3300n -0.000292 440.3400n -0.000325 440.3500n -0.000358 440.3600n -0.000391 440.3700n -0.000424 440.3800n -0.000457 440.3900n -0.000490
+ 440.4000n -0.000522 440.4100n -0.000555 440.4200n -0.000588 440.4300n -0.000620 440.4400n -0.000652 440.4500n -0.000684 440.4600n -0.000716 440.4700n -0.000748 440.4800n -0.000779 440.4900n -0.000810 440.5000n -0.000841 440.5100n -0.000871 440.5200n -0.000902 440.5300n -0.000932 440.5400n -0.000961
+ 440.5500n -0.000990 440.5600n -0.001019 440.5700n -0.001047 440.5800n -0.001075 440.5900n -0.001103 440.6000n -0.001130 440.6100n -0.001156 440.6200n -0.001183 440.6300n -0.001208 440.6400n -0.001233 440.6500n -0.001258 440.6600n -0.001282 440.6700n -0.001305 440.6800n -0.001328 440.6900n -0.001350
+ 440.7000n -0.001372 440.7100n -0.001393 440.7200n -0.001413 440.7300n -0.001433 440.7400n -0.001452 440.7500n -0.001470 440.7600n -0.001488 440.7700n -0.001505 440.7800n -0.001521 440.7900n -0.001536 440.8000n -0.001551 440.8100n -0.001565 440.8200n -0.001579 440.8300n -0.001591 440.8400n -0.001603
+ 440.8500n -0.001614 440.8600n -0.001624 440.8700n -0.001634 440.8800n -0.001643 440.8900n -0.001651 440.9000n -0.001658 440.9100n -0.001664 440.9200n -0.001670 440.9300n -0.001675 440.9400n -0.001679 440.9500n -0.001682 440.9600n -0.001684 440.9700n -0.001686 440.9800n -0.001687 440.9900n -0.001687
+ 441.0000n -0.001686 441.0100n -0.001684 441.0200n -0.001682 441.0300n -0.001678 441.0400n -0.001674 441.0500n -0.001669 441.0600n -0.001664 441.0700n -0.001657 441.0800n -0.001650 441.0900n -0.001642 441.1000n -0.001634 441.1100n -0.001624 441.1200n -0.001614 441.1300n -0.001603 441.1400n -0.001591
+ 441.1500n -0.001579 441.1600n -0.001566 441.1700n -0.001552 441.1800n -0.001537 441.1900n -0.001522 441.2000n -0.001506 441.2100n -0.001489 441.2200n -0.001472 441.2300n -0.001454 441.2400n -0.001436 441.2500n -0.001416 441.2600n -0.001397 441.2700n -0.001376 441.2800n -0.001355 441.2900n -0.001334
+ 441.3000n -0.001312 441.3100n -0.001289 441.3200n -0.001266 441.3300n -0.001242 441.3400n -0.001218 441.3500n -0.001193 441.3600n -0.001168 441.3700n -0.001143 441.3800n -0.001117 441.3900n -0.001090 441.4000n -0.001063 441.4100n -0.001036 441.4200n -0.001009 441.4300n -0.000981 441.4400n -0.000952
+ 441.4500n -0.000924 441.4600n -0.000895 441.4700n -0.000866 441.4800n -0.000836 441.4900n -0.000807 441.5000n -0.000777 441.5100n -0.000746 441.5200n -0.000716 441.5300n -0.000686 441.5400n -0.000655 441.5500n -0.000624 441.5600n -0.000593 441.5700n -0.000562 441.5800n -0.000531 441.5900n -0.000499
+ 441.6000n -0.000468 441.6100n -0.000437 441.6200n -0.000405 441.6300n -0.000374 441.6400n -0.000342 441.6500n -0.000311 441.6600n -0.000280 441.6700n -0.000248 441.6800n -0.000217 441.6900n -0.000186 441.7000n -0.000155 441.7100n -0.000124 441.7200n -0.000093 441.7300n -0.000062 441.7400n -0.000031
+ 441.7500n -0.000001 441.7600n 0.000029 441.7700n 0.000059 441.7800n 0.000089 441.7900n 0.000119 441.8000n 0.000148 441.8100n 0.000178 441.8200n 0.000207 441.8300n 0.000235 441.8400n 0.000264 441.8500n 0.000292 441.8600n 0.000320 441.8700n 0.000347 441.8800n 0.000375 441.8900n 0.000401
+ 441.9000n 0.000428 441.9100n 0.000454 441.9200n 0.000480 441.9300n 0.000506 441.9400n 0.000531 441.9500n 0.000556 441.9600n 0.000580 441.9700n 0.000604 441.9800n 0.000628 441.9900n 0.000652 442.0000n 0.000674 442.0100n 0.000697 442.0200n 0.000719 442.0300n 0.000741 442.0400n 0.000762
+ 442.0500n 0.000783 442.0600n 0.000804 442.0700n 0.000824 442.0800n 0.000844 442.0900n 0.000863 442.1000n 0.000882 442.1100n 0.000900 442.1200n 0.000918 442.1300n 0.000936 442.1400n 0.000953 442.1500n 0.000970 442.1600n 0.000986 442.1700n 0.001002 442.1800n 0.001018 442.1900n 0.001033
+ 442.2000n 0.001048 442.2100n 0.001062 442.2200n 0.001076 442.2300n 0.001089 442.2400n 0.001103 442.2500n 0.001115 442.2600n 0.001128 442.2700n 0.001140 442.2800n 0.001151 442.2900n 0.001163 442.3000n 0.001173 442.3100n 0.001184 442.3200n 0.001194 442.3300n 0.001204 442.3400n 0.001213
+ 442.3500n 0.001223 442.3600n 0.001231 442.3700n 0.001240 442.3800n 0.001248 442.3900n 0.001256 442.4000n 0.001263 442.4100n 0.001271 442.4200n 0.001278 442.4300n 0.001284 442.4400n 0.001291 442.4500n 0.001297 442.4600n 0.001303 442.4700n 0.001308 442.4800n 0.001314 442.4900n 0.001319
+ 442.5000n 0.001324 442.5100n 0.001329 442.5200n 0.001333 442.5300n 0.001337 442.5400n 0.001341 442.5500n 0.001345 442.5600n 0.001349 442.5700n 0.001352 442.5800n 0.001356 442.5900n 0.001359 442.6000n 0.001362 442.6100n 0.001365 442.6200n 0.001367 442.6300n 0.001370 442.6400n 0.001372
+ 442.6500n 0.001375 442.6600n 0.001377 442.6700n 0.001379 442.6800n 0.001381 442.6900n 0.001383 442.7000n 0.001384 442.7100n 0.001386 442.7200n 0.001388 442.7300n 0.001389 442.7400n 0.001391 442.7500n 0.001392 442.7600n 0.001393 442.7700n 0.001395 442.7800n 0.001396 442.7900n 0.001397
+ 442.8000n 0.001398 442.8100n 0.001399 442.8200n 0.001400 442.8300n 0.001401 442.8400n 0.001402 442.8500n 0.001402 442.8600n 0.001403 442.8700n 0.001404 442.8800n 0.001405 442.8900n 0.001405 442.9000n 0.001406 442.9100n 0.001406 442.9200n 0.001407 442.9300n 0.001408 442.9400n 0.001408
+ 442.9500n 0.001408 442.9600n 0.001409 442.9700n 0.001409 442.9800n 0.001410 442.9900n 0.001410 443.0000n 0.001410 443.0100n 0.001410 443.0200n 0.001410 443.0300n 0.001411 443.0400n 0.001411 443.0500n 0.001411 443.0600n 0.001410 443.0700n 0.001410 443.0800n 0.001410 443.0900n 0.001410
+ 443.1000n 0.001409 443.1100n 0.001409 443.1200n 0.001408 443.1300n 0.001408 443.1400n 0.001407 443.1500n 0.001406 443.1600n 0.001405 443.1700n 0.001404 443.1800n 0.001403 443.1900n 0.001401 443.2000n 0.001400 443.2100n 0.001398 443.2200n 0.001396 443.2300n 0.001394 443.2400n 0.001392
+ 443.2500n 0.001390 443.2600n 0.001388 443.2700n 0.001385 443.2800n 0.001382 443.2900n 0.001379 443.3000n 0.001376 443.3100n 0.001372 443.3200n 0.001368 443.3300n 0.001364 443.3400n 0.001360 443.3500n 0.001356 443.3600n 0.001351 443.3700n 0.001346 443.3800n 0.001341 443.3900n 0.001335
+ 443.4000n 0.001330 443.4100n 0.001323 443.4200n 0.001317 443.4300n 0.001310 443.4400n 0.001303 443.4500n 0.001296 443.4600n 0.001288 443.4700n 0.001280 443.4800n 0.001272 443.4900n 0.001263 443.5000n 0.001254 443.5100n 0.001245 443.5200n 0.001235 443.5300n 0.001225 443.5400n 0.001214
+ 443.5500n 0.001203 443.5600n 0.001192 443.5700n 0.001180 443.5800n 0.001168 443.5900n 0.001156 443.6000n 0.001143 443.6100n 0.001129 443.6200n 0.001116 443.6300n 0.001101 443.6400n 0.001087 443.6500n 0.001072 443.6600n 0.001056 443.6700n 0.001040 443.6800n 0.001024 443.6900n 0.001007
+ 443.7000n 0.000990 443.7100n 0.000973 443.7200n 0.000955 443.7300n 0.000936 443.7400n 0.000917 443.7500n 0.000898 443.7600n 0.000878 443.7700n 0.000858 443.7800n 0.000838 443.7900n 0.000817 443.8000n 0.000795 443.8100n 0.000773 443.8200n 0.000751 443.8300n 0.000728 443.8400n 0.000705
+ 443.8500n 0.000682 443.8600n 0.000658 443.8700n 0.000634 443.8800n 0.000609 443.8900n 0.000585 443.9000n 0.000559 443.9100n 0.000534 443.9200n 0.000508 443.9300n 0.000481 443.9400n 0.000455 443.9500n 0.000428 443.9600n 0.000400 443.9700n 0.000373 443.9800n 0.000345 443.9900n 0.000317
+ 444.0000n 0.000288 444.0100n 0.000260 444.0200n 0.000231 444.0300n 0.000202 444.0400n 0.000172 444.0500n 0.000143 444.0600n 0.000113 444.0700n 0.000083 444.0800n 0.000053 444.0900n 0.000023 444.1000n -0.000008 444.1100n -0.000038 444.1200n -0.000069 444.1300n -0.000099 444.1400n -0.000130
+ 444.1500n -0.000161 444.1600n -0.000192 444.1700n -0.000222 444.1800n -0.000253 444.1900n -0.000284 444.2000n -0.000315 444.2100n -0.000345 444.2200n -0.000376 444.2300n -0.000407 444.2400n -0.000437 444.2500n -0.000467 444.2600n -0.000498 444.2700n -0.000528 444.2800n -0.000557 444.2900n -0.000587
+ 444.3000n -0.000616 444.3100n -0.000646 444.3200n -0.000674 444.3300n -0.000703 444.3400n -0.000731 444.3500n -0.000759 444.3600n -0.000787 444.3700n -0.000814 444.3800n -0.000841 444.3900n -0.000868 444.4000n -0.000894 444.4100n -0.000920 444.4200n -0.000945 444.4300n -0.000970 444.4400n -0.000994
+ 444.4500n -0.001018 444.4600n -0.001041 444.4700n -0.001064 444.4800n -0.001086 444.4900n -0.001108 444.5000n -0.001129 444.5100n -0.001149 444.5200n -0.001169 444.5300n -0.001188 444.5400n -0.001207 444.5500n -0.001224 444.5600n -0.001242 444.5700n -0.001258 444.5800n -0.001274 444.5900n -0.001289
+ 444.6000n -0.001303 444.6100n -0.001316 444.6200n -0.001329 444.6300n -0.001341 444.6400n -0.001352 444.6500n -0.001362 444.6600n -0.001372 444.6700n -0.001380 444.6800n -0.001388 444.6900n -0.001395 444.7000n -0.001401 444.7100n -0.001407 444.7200n -0.001411 444.7300n -0.001414 444.7400n -0.001417
+ 444.7500n -0.001419 444.7600n -0.001419 444.7700n -0.001419 444.7800n -0.001418 444.7900n -0.001416 444.8000n -0.001413 444.8100n -0.001410 444.8200n -0.001405 444.8300n -0.001399 444.8400n -0.001393 444.8500n -0.001385 444.8600n -0.001377 444.8700n -0.001367 444.8800n -0.001357 444.8900n -0.001346
+ 444.9000n -0.001333 444.9100n -0.001320 444.9200n -0.001306 444.9300n -0.001291 444.9400n -0.001275 444.9500n -0.001259 444.9600n -0.001241 444.9700n -0.001223 444.9800n -0.001203 444.9900n -0.001183 445.0000n -0.001162 445.0100n -0.001140 445.0200n -0.001117 445.0300n -0.001093 445.0400n -0.001069
+ 445.0500n -0.001044 445.0600n -0.001018 445.0700n -0.000991 445.0800n -0.000963 445.0900n -0.000935 445.1000n -0.000906 445.1100n -0.000876 445.1200n -0.000845 445.1300n -0.000814 445.1400n -0.000782 445.1500n -0.000750 445.1600n -0.000717 445.1700n -0.000683 445.1800n -0.000649 445.1900n -0.000614
+ 445.2000n -0.000578 445.2100n -0.000542 445.2200n -0.000506 445.2300n -0.000469 445.2400n -0.000431 445.2500n -0.000393 445.2600n -0.000355 445.2700n -0.000316 445.2800n -0.000277 445.2900n -0.000238 445.3000n -0.000198 445.3100n -0.000158 445.3200n -0.000117 445.3300n -0.000077 445.3400n -0.000036
+ 445.3500n 0.000005 445.3600n 0.000046 445.3700n 0.000088 445.3800n 0.000129 445.3900n 0.000171 445.4000n 0.000213 445.4100n 0.000254 445.4200n 0.000296 445.4300n 0.000338 445.4400n 0.000379 445.4500n 0.000421 445.4600n 0.000463 445.4700n 0.000504 445.4800n 0.000545 445.4900n 0.000586
+ 445.5000n 0.000627 445.5100n 0.000668 445.5200n 0.000708 445.5300n 0.000748 445.5400n 0.000788 445.5500n 0.000828 445.5600n 0.000867 445.5700n 0.000906 445.5800n 0.000944 445.5900n 0.000982 445.6000n 0.001020 445.6100n 0.001057 445.6200n 0.001093 445.6300n 0.001129 445.6400n 0.001165
+ 445.6500n 0.001199 445.6600n 0.001234 445.6700n 0.001267 445.6800n 0.001300 445.6900n 0.001333 445.7000n 0.001364 445.7100n 0.001395 445.7200n 0.001425 445.7300n 0.001455 445.7400n 0.001484 445.7500n 0.001512 445.7600n 0.001539 445.7700n 0.001565 445.7800n 0.001591 445.7900n 0.001615
+ 445.8000n 0.001639 445.8100n 0.001662 445.8200n 0.001684 445.8300n 0.001705 445.8400n 0.001725 445.8500n 0.001744 445.8600n 0.001762 445.8700n 0.001780 445.8800n 0.001796 445.8900n 0.001811 445.9000n 0.001826 445.9100n 0.001839 445.9200n 0.001851 445.9300n 0.001863 445.9400n 0.001873
+ 445.9500n 0.001882 445.9600n 0.001891 445.9700n 0.001898 445.9800n 0.001904 445.9900n 0.001909 446.0000n 0.001913 446.0100n 0.001916 446.0200n 0.001918 446.0300n 0.001919 446.0400n 0.001919 446.0500n 0.001918 446.0600n 0.001916 446.0700n 0.001913 446.0800n 0.001909 446.0900n 0.001903
+ 446.1000n 0.001897 446.1100n 0.001890 446.1200n 0.001882 446.1300n 0.001872 446.1400n 0.001862 446.1500n 0.001851 446.1600n 0.001839 446.1700n 0.001826 446.1800n 0.001812 446.1900n 0.001797 446.2000n 0.001781 446.2100n 0.001764 446.2200n 0.001746 446.2300n 0.001728 446.2400n 0.001708
+ 446.2500n 0.001688 446.2600n 0.001667 446.2700n 0.001645 446.2800n 0.001622 446.2900n 0.001598 446.3000n 0.001574 446.3100n 0.001549 446.3200n 0.001523 446.3300n 0.001497 446.3400n 0.001470 446.3500n 0.001442 446.3600n 0.001414 446.3700n 0.001385 446.3800n 0.001355 446.3900n 0.001325
+ 446.4000n 0.001295 446.4100n 0.001264 446.4200n 0.001232 446.4300n 0.001200 446.4400n 0.001167 446.4500n 0.001134 446.4600n 0.001101 446.4700n 0.001068 446.4800n 0.001034 446.4900n 0.000999 446.5000n 0.000965 446.5100n 0.000930 446.5200n 0.000895 446.5300n 0.000860 446.5400n 0.000824
+ 446.5500n 0.000789 446.5600n 0.000753 446.5700n 0.000718 446.5800n 0.000682 446.5900n 0.000646 446.6000n 0.000611 446.6100n 0.000575 446.6200n 0.000539 446.6300n 0.000504 446.6400n 0.000468 446.6500n 0.000433 446.6600n 0.000398 446.6700n 0.000363 446.6800n 0.000328 446.6900n 0.000294
+ 446.7000n 0.000260 446.7100n 0.000226 446.7200n 0.000192 446.7300n 0.000159 446.7400n 0.000127 446.7500n 0.000094 446.7600n 0.000062 446.7700n 0.000031 446.7800n -0.000000 446.7900n -0.000031 446.8000n -0.000060 446.8100n -0.000090 446.8200n -0.000118 446.8300n -0.000147 446.8400n -0.000174
+ 446.8500n -0.000201 446.8600n -0.000227 446.8700n -0.000253 446.8800n -0.000278 446.8900n -0.000302 446.9000n -0.000325 446.9100n -0.000348 446.9200n -0.000369 446.9300n -0.000390 446.9400n -0.000411 446.9500n -0.000430 446.9600n -0.000448 446.9700n -0.000466 446.9800n -0.000483 446.9900n -0.000499
+ 447.0000n -0.000514 447.0100n -0.000528 447.0200n -0.000541 447.0300n -0.000553 447.0400n -0.000564 447.0500n -0.000575 447.0600n -0.000584 447.0700n -0.000593 447.0800n -0.000600 447.0900n -0.000607 447.1000n -0.000612 447.1100n -0.000617 447.1200n -0.000620 447.1300n -0.000623 447.1400n -0.000624
+ 447.1500n -0.000625 447.1600n -0.000624 447.1700n -0.000623 447.1800n -0.000620 447.1900n -0.000617 447.2000n -0.000613 447.2100n -0.000607 447.2200n -0.000601 447.2300n -0.000594 447.2400n -0.000585 447.2500n -0.000576 447.2600n -0.000566 447.2700n -0.000555 447.2800n -0.000543 447.2900n -0.000530
+ 447.3000n -0.000516 447.3100n -0.000501 447.3200n -0.000485 447.3300n -0.000468 447.3400n -0.000451 447.3500n -0.000433 447.3600n -0.000413 447.3700n -0.000393 447.3800n -0.000373 447.3900n -0.000351 447.4000n -0.000329 447.4100n -0.000305 447.4200n -0.000282 447.4300n -0.000257 447.4400n -0.000232
+ 447.4500n -0.000206 447.4600n -0.000179 447.4700n -0.000152 447.4800n -0.000124 447.4900n -0.000095 447.5000n -0.000066 447.5100n -0.000036 447.5200n -0.000006 447.5300n 0.000025 447.5400n 0.000056 447.5500n 0.000087 447.5600n 0.000120 447.5700n 0.000152 447.5800n 0.000185 447.5900n 0.000218
+ 447.6000n 0.000252 447.6100n 0.000286 447.6200n 0.000320 447.6300n 0.000355 447.6400n 0.000389 447.6500n 0.000424 447.6600n 0.000459 447.6700n 0.000495 447.6800n 0.000530 447.6900n 0.000565 447.7000n 0.000601 447.7100n 0.000637 447.7200n 0.000672 447.7300n 0.000708 447.7400n 0.000743
+ 447.7500n 0.000779 447.7600n 0.000814 447.7700n 0.000850 447.7800n 0.000885 447.7900n 0.000920 447.8000n 0.000955 447.8100n 0.000989 447.8200n 0.001024 447.8300n 0.001058 447.8400n 0.001091 447.8500n 0.001125 447.8600n 0.001158 447.8700n 0.001191 447.8800n 0.001223 447.8900n 0.001255
+ 447.9000n 0.001286 447.9100n 0.001317 447.9200n 0.001348 447.9300n 0.001378 447.9400n 0.001407 447.9500n 0.001436 447.9600n 0.001464 447.9700n 0.001492 447.9800n 0.001519 447.9900n 0.001545 448.0000n 0.001571 448.0100n 0.001596 448.0200n 0.001620 448.0300n 0.001644 448.0400n 0.001667
+ 448.0500n 0.001689 448.0600n 0.001710 448.0700n 0.001731 448.0800n 0.001751 448.0900n 0.001770 448.1000n 0.001788 448.1100n 0.001805 448.1200n 0.001821 448.1300n 0.001837 448.1400n 0.001851 448.1500n 0.001865 448.1600n 0.001878 448.1700n 0.001890 448.1800n 0.001901 448.1900n 0.001911
+ 448.2000n 0.001920 448.2100n 0.001929 448.2200n 0.001936 448.2300n 0.001942 448.2400n 0.001947 448.2500n 0.001952 448.2600n 0.001955 448.2700n 0.001958 448.2800n 0.001959 448.2900n 0.001960 448.3000n 0.001959 448.3100n 0.001958 448.3200n 0.001956 448.3300n 0.001952 448.3400n 0.001948
+ 448.3500n 0.001943 448.3600n 0.001936 448.3700n 0.001929 448.3800n 0.001921 448.3900n 0.001912 448.4000n 0.001902 448.4100n 0.001891 448.4200n 0.001879 448.4300n 0.001867 448.4400n 0.001853 448.4500n 0.001838 448.4600n 0.001823 448.4700n 0.001807 448.4800n 0.001790 448.4900n 0.001772
+ 448.5000n 0.001753 448.5100n 0.001733 448.5200n 0.001713 448.5300n 0.001691 448.5400n 0.001669 448.5500n 0.001647 448.5600n 0.001623 448.5700n 0.001599 448.5800n 0.001574 448.5900n 0.001548 448.6000n 0.001522 448.6100n 0.001495 448.6200n 0.001467 448.6300n 0.001439 448.6400n 0.001410
+ 448.6500n 0.001381 448.6600n 0.001351 448.6700n 0.001321 448.6800n 0.001290 448.6900n 0.001258 448.7000n 0.001226 448.7100n 0.001194 448.7200n 0.001161 448.7300n 0.001128 448.7400n 0.001094 448.7500n 0.001060 448.7600n 0.001026 448.7700n 0.000991 448.7800n 0.000956 448.7900n 0.000921
+ 448.8000n 0.000886 448.8100n 0.000850 448.8200n 0.000814 448.8300n 0.000778 448.8400n 0.000742 448.8500n 0.000706 448.8600n 0.000669 448.8700n 0.000633 448.8800n 0.000596 448.8900n 0.000560 448.9000n 0.000523 448.9100n 0.000487 448.9200n 0.000450 448.9300n 0.000414 448.9400n 0.000378
+ 448.9500n 0.000341 448.9600n 0.000305 448.9700n 0.000269 448.9800n 0.000234 448.9900n 0.000198 449.0000n 0.000163 449.0100n 0.000128 449.0200n 0.000093 449.0300n 0.000059 449.0400n 0.000025 449.0500n -0.000009 449.0600n -0.000043 449.0700n -0.000076 449.0800n -0.000109 449.0900n -0.000141
+ 449.1000n -0.000173 449.1100n -0.000204 449.1200n -0.000235 449.1300n -0.000266 449.1400n -0.000296 449.1500n -0.000325 449.1600n -0.000354 449.1700n -0.000382 449.1800n -0.000410 449.1900n -0.000437 449.2000n -0.000464 449.2100n -0.000490 449.2200n -0.000515 449.2300n -0.000540 449.2400n -0.000564
+ 449.2500n -0.000588 449.2600n -0.000611 449.2700n -0.000633 449.2800n -0.000654 449.2900n -0.000675 449.3000n -0.000695 449.3100n -0.000714 449.3200n -0.000733 449.3300n -0.000751 449.3400n -0.000768 449.3500n -0.000784 449.3600n -0.000800 449.3700n -0.000815 449.3800n -0.000829 449.3900n -0.000842
+ 449.4000n -0.000855 449.4100n -0.000867 449.4200n -0.000878 449.4300n -0.000888 449.4400n -0.000898 449.4500n -0.000907 449.4600n -0.000915 449.4700n -0.000922 449.4800n -0.000928 449.4900n -0.000934 449.5000n -0.000939 449.5100n -0.000943 449.5200n -0.000947 449.5300n -0.000950 449.5400n -0.000952
+ 449.5500n -0.000953 449.5600n -0.000954 449.5700n -0.000953 449.5800n -0.000953 449.5900n -0.000951 449.6000n -0.000949 449.6100n -0.000946 449.6200n -0.000942 449.6300n -0.000938 449.6400n -0.000933 449.6500n -0.000927 449.6600n -0.000921 449.6700n -0.000914 449.6800n -0.000907 449.6900n -0.000899
+ 449.7000n -0.000890 449.7100n -0.000881 449.7200n -0.000871 449.7300n -0.000861 449.7400n -0.000850 449.7500n -0.000839 449.7600n -0.000827 449.7700n -0.000815 449.7800n -0.000802 449.7900n -0.000789 449.8000n -0.000775 449.8100n -0.000761 449.8200n -0.000747 449.8300n -0.000732 449.8400n -0.000717
+ 449.8500n -0.000701 449.8600n -0.000685 449.8700n -0.000669 449.8800n -0.000653 449.8900n -0.000636 449.9000n -0.000619 449.9100n -0.000602 449.9200n -0.000584 449.9300n -0.000567 449.9400n -0.000549 449.9500n -0.000531 449.9600n -0.000513 449.9700n -0.000494 449.9800n -0.000476 449.9900n -0.000458
+ 450.0000n -0.000439 450.0100n -0.000421 450.0200n -0.000402 450.0300n -0.000383 450.0400n -0.000365 450.0500n -0.000346 450.0600n -0.000328 450.0700n -0.000309 450.0800n -0.000291 450.0900n -0.000273 450.1000n -0.000254 450.1100n -0.000236 450.1200n -0.000218 450.1300n -0.000201 450.1400n -0.000183
+ 450.1500n -0.000166 450.1600n -0.000149 450.1700n -0.000132 450.1800n -0.000115 450.1900n -0.000099 450.2000n -0.000083 450.2100n -0.000067 450.2200n -0.000051 450.2300n -0.000036 450.2400n -0.000021 450.2500n -0.000007 450.2600n 0.000007 450.2700n 0.000021 450.2800n 0.000035 450.2900n 0.000047
+ 450.3000n 0.000060 450.3100n 0.000072 450.3200n 0.000084 450.3300n 0.000095 450.3400n 0.000106 450.3500n 0.000116 450.3600n 0.000126 450.3700n 0.000135 450.3800n 0.000144 450.3900n 0.000153 450.4000n 0.000161 450.4100n 0.000168 450.4200n 0.000175 450.4300n 0.000181 450.4400n 0.000187
+ 450.4500n 0.000192 450.4600n 0.000197 450.4700n 0.000201 450.4800n 0.000204 450.4900n 0.000208 450.5000n 0.000210 450.5100n 0.000212 450.5200n 0.000213 450.5300n 0.000214 450.5400n 0.000215 450.5500n 0.000214 450.5600n 0.000213 450.5700n 0.000212 450.5800n 0.000210 450.5900n 0.000208
+ 450.6000n 0.000204 450.6100n 0.000201 450.6200n 0.000197 450.6300n 0.000192 450.6400n 0.000187 450.6500n 0.000181 450.6600n 0.000175 450.6700n 0.000168 450.6800n 0.000161 450.6900n 0.000153 450.7000n 0.000144 450.7100n 0.000136 450.7200n 0.000126 450.7300n 0.000116 450.7400n 0.000106
+ 450.7500n 0.000095 450.7600n 0.000084 450.7700n 0.000073 450.7800n 0.000061 450.7900n 0.000048 450.8000n 0.000035 450.8100n 0.000022 450.8200n 0.000008 450.8300n -0.000006 450.8400n -0.000020 450.8500n -0.000035 450.8600n -0.000050 450.8700n -0.000066 450.8800n -0.000082 450.8900n -0.000098
+ 450.9000n -0.000114 450.9100n -0.000131 450.9200n -0.000147 450.9300n -0.000165 450.9400n -0.000182 450.9500n -0.000200 450.9600n -0.000217 450.9700n -0.000235 450.9800n -0.000253 450.9900n -0.000272 451.0000n -0.000290 451.0100n -0.000309 451.0200n -0.000327 451.0300n -0.000346 451.0400n -0.000365
+ 451.0500n -0.000384 451.0600n -0.000403 451.0700n -0.000422 451.0800n -0.000441 451.0900n -0.000460 451.1000n -0.000479 451.1100n -0.000498 451.1200n -0.000517 451.1300n -0.000535 451.1400n -0.000554 451.1500n -0.000573 451.1600n -0.000591 451.1700n -0.000610 451.1800n -0.000628 451.1900n -0.000646
+ 451.2000n -0.000664 451.2100n -0.000682 451.2200n -0.000699 451.2300n -0.000716 451.2400n -0.000733 451.2500n -0.000750 451.2600n -0.000767 451.2700n -0.000783 451.2800n -0.000799 451.2900n -0.000814 451.3000n -0.000830 451.3100n -0.000845 451.3200n -0.000859 451.3300n -0.000874 451.3400n -0.000888
+ 451.3500n -0.000901 451.3600n -0.000914 451.3700n -0.000927 451.3800n -0.000939 451.3900n -0.000951 451.4000n -0.000962 451.4100n -0.000973 451.4200n -0.000984 451.4300n -0.000994 451.4400n -0.001003 451.4500n -0.001012 451.4600n -0.001021 451.4700n -0.001029 451.4800n -0.001036 451.4900n -0.001043
+ 451.5000n -0.001050 451.5100n -0.001056 451.5200n -0.001061 451.5300n -0.001066 451.5400n -0.001070 451.5500n -0.001074 451.5600n -0.001077 451.5700n -0.001080 451.5800n -0.001082 451.5900n -0.001083 451.6000n -0.001084 451.6100n -0.001084 451.6200n -0.001084 451.6300n -0.001083 451.6400n -0.001082
+ 451.6500n -0.001080 451.6600n -0.001077 451.6700n -0.001074 451.6800n -0.001070 451.6900n -0.001065 451.7000n -0.001060 451.7100n -0.001055 451.7200n -0.001048 451.7300n -0.001042 451.7400n -0.001034 451.7500n -0.001026 451.7600n -0.001018 451.7700n -0.001009 451.7800n -0.000999 451.7900n -0.000989
+ 451.8000n -0.000978 451.8100n -0.000967 451.8200n -0.000955 451.8300n -0.000943 451.8400n -0.000930 451.8500n -0.000916 451.8600n -0.000902 451.8700n -0.000888 451.8800n -0.000873 451.8900n -0.000858 451.9000n -0.000842 451.9100n -0.000825 451.9200n -0.000808 451.9300n -0.000791 451.9400n -0.000773
+ 451.9500n -0.000755 451.9600n -0.000736 451.9700n -0.000717 451.9800n -0.000698 451.9900n -0.000678 452.0000n -0.000658 452.0100n -0.000638 452.0200n -0.000617 452.0300n -0.000595 452.0400n -0.000574 452.0500n -0.000552 452.0600n -0.000530 452.0700n -0.000507 452.0800n -0.000485 452.0900n -0.000462
+ 452.1000n -0.000438 452.1100n -0.000415 452.1200n -0.000391 452.1300n -0.000368 452.1400n -0.000344 452.1500n -0.000319 452.1600n -0.000295 452.1700n -0.000270 452.1800n -0.000246 452.1900n -0.000221 452.2000n -0.000196 452.2100n -0.000171 452.2200n -0.000146 452.2300n -0.000121 452.2400n -0.000096
+ 452.2500n -0.000071 452.2600n -0.000046 452.2700n -0.000021 452.2800n 0.000004 452.2900n 0.000029 452.3000n 0.000054 452.3100n 0.000078 452.3200n 0.000103 452.3300n 0.000128 452.3400n 0.000152 452.3500n 0.000177 452.3600n 0.000201 452.3700n 0.000225 452.3800n 0.000249 452.3900n 0.000272
+ 452.4000n 0.000296 452.4100n 0.000319 452.4200n 0.000342 452.4300n 0.000365 452.4400n 0.000387 452.4500n 0.000409 452.4600n 0.000431 452.4700n 0.000453 452.4800n 0.000474 452.4900n 0.000495 452.5000n 0.000515 452.5100n 0.000536 452.5200n 0.000555 452.5300n 0.000575 452.5400n 0.000594
+ 452.5500n 0.000612 452.5600n 0.000631 452.5700n 0.000648 452.5800n 0.000666 452.5900n 0.000682 452.6000n 0.000699 452.6100n 0.000715 452.6200n 0.000730 452.6300n 0.000745 452.6400n 0.000759 452.6500n 0.000773 452.6600n 0.000787 452.6700n 0.000799 452.6800n 0.000812 452.6900n 0.000823
+ 452.7000n 0.000835 452.7100n 0.000845 452.7200n 0.000855 452.7300n 0.000865 452.7400n 0.000874 452.7500n 0.000882 452.7600n 0.000890 452.7700n 0.000897 452.7800n 0.000904 452.7900n 0.000910 452.8000n 0.000915 452.8100n 0.000920 452.8200n 0.000924 452.8300n 0.000927 452.8400n 0.000930
+ 452.8500n 0.000933 452.8600n 0.000934 452.8700n 0.000936 452.8800n 0.000936 452.8900n 0.000936 452.9000n 0.000935 452.9100n 0.000934 452.9200n 0.000932 452.9300n 0.000929 452.9400n 0.000926 452.9500n 0.000922 452.9600n 0.000918 452.9700n 0.000913 452.9800n 0.000907 452.9900n 0.000901
+ 453.0000n 0.000894 453.0100n 0.000887 453.0200n 0.000879 453.0300n 0.000870 453.0400n 0.000861 453.0500n 0.000851 453.0600n 0.000841 453.0700n 0.000830 453.0800n 0.000819 453.0900n 0.000807 453.1000n 0.000795 453.1100n 0.000782 453.1200n 0.000768 453.1300n 0.000754 453.1400n 0.000740
+ 453.1500n 0.000725 453.1600n 0.000710 453.1700n 0.000694 453.1800n 0.000677 453.1900n 0.000661 453.2000n 0.000644 453.2100n 0.000626 453.2200n 0.000608 453.2300n 0.000589 453.2400n 0.000571 453.2500n 0.000552 453.2600n 0.000532 453.2700n 0.000512 453.2800n 0.000492 453.2900n 0.000471
+ 453.3000n 0.000450 453.3100n 0.000429 453.3200n 0.000408 453.3300n 0.000386 453.3400n 0.000364 453.3500n 0.000342 453.3600n 0.000320 453.3700n 0.000297 453.3800n 0.000274 453.3900n 0.000251 453.4000n 0.000228 453.4100n 0.000204 453.4200n 0.000181 453.4300n 0.000157 453.4400n 0.000134
+ 453.4500n 0.000110 453.4600n 0.000086 453.4700n 0.000062 453.4800n 0.000038 453.4900n 0.000014 453.5000n -0.000010 453.5100n -0.000034 453.5200n -0.000058 453.5300n -0.000082 453.5400n -0.000106 453.5500n -0.000130 453.5600n -0.000154 453.5700n -0.000178 453.5800n -0.000201 453.5900n -0.000225
+ 453.6000n -0.000248 453.6100n -0.000272 453.6200n -0.000295 453.6300n -0.000317 453.6400n -0.000340 453.6500n -0.000363 453.6600n -0.000385 453.6700n -0.000407 453.6800n -0.000429 453.6900n -0.000450 453.7000n -0.000471 453.7100n -0.000492 453.7200n -0.000513 453.7300n -0.000533 453.7400n -0.000553
+ 453.7500n -0.000572 453.7600n -0.000591 453.7700n -0.000610 453.7800n -0.000628 453.7900n -0.000646 453.8000n -0.000664 453.8100n -0.000681 453.8200n -0.000698 453.8300n -0.000714 453.8400n -0.000730 453.8500n -0.000745 453.8600n -0.000760 453.8700n -0.000774 453.8800n -0.000788 453.8900n -0.000801
+ 453.9000n -0.000814 453.9100n -0.000826 453.9200n -0.000838 453.9300n -0.000849 453.9400n -0.000859 453.9500n -0.000869 453.9600n -0.000879 453.9700n -0.000888 453.9800n -0.000896 453.9900n -0.000903 454.0000n -0.000910 454.0100n -0.000917 454.0200n -0.000923 454.0300n -0.000928 454.0400n -0.000932
+ 454.0500n -0.000936 454.0600n -0.000939 454.0700n -0.000942 454.0800n -0.000944 454.0900n -0.000945 454.1000n -0.000946 454.1100n -0.000946 454.1200n -0.000946 454.1300n -0.000944 454.1400n -0.000942 454.1500n -0.000940 454.1600n -0.000937 454.1700n -0.000933 454.1800n -0.000928 454.1900n -0.000923
+ 454.2000n -0.000917 454.2100n -0.000911 454.2200n -0.000903 454.2300n -0.000896 454.2400n -0.000887 454.2500n -0.000878 454.2600n -0.000868 454.2700n -0.000858 454.2800n -0.000847 454.2900n -0.000835 454.3000n -0.000823 454.3100n -0.000810 454.3200n -0.000797 454.3300n -0.000783 454.3400n -0.000768
+ 454.3500n -0.000753 454.3600n -0.000737 454.3700n -0.000721 454.3800n -0.000704 454.3900n -0.000687 454.4000n -0.000669 454.4100n -0.000650 454.4200n -0.000631 454.4300n -0.000612 454.4400n -0.000592 454.4500n -0.000571 454.4600n -0.000550 454.4700n -0.000529 454.4800n -0.000507 454.4900n -0.000484
+ 454.5000n -0.000461 454.5100n -0.000438 454.5200n -0.000415 454.5300n -0.000391 454.5400n -0.000366 454.5500n -0.000341 454.5600n -0.000316 454.5700n -0.000291 454.5800n -0.000265 454.5900n -0.000239 454.6000n -0.000213 454.6100n -0.000186 454.6200n -0.000159 454.6300n -0.000132 454.6400n -0.000105
+ 454.6500n -0.000077 454.6600n -0.000049 454.6700n -0.000021 454.6800n 0.000007 454.6900n 0.000035 454.7000n 0.000063 454.7100n 0.000092 454.7200n 0.000120 454.7300n 0.000149 454.7400n 0.000178 454.7500n 0.000206 454.7600n 0.000235 454.7700n 0.000264 454.7800n 0.000292 454.7900n 0.000321
+ 454.8000n 0.000350 454.8100n 0.000378 454.8200n 0.000407 454.8300n 0.000435 454.8400n 0.000463 454.8500n 0.000491 454.8600n 0.000519 454.8700n 0.000547 454.8800n 0.000574 454.8900n 0.000602 454.9000n 0.000629 454.9100n 0.000656 454.9200n 0.000682 454.9300n 0.000708 454.9400n 0.000734
+ 454.9500n 0.000760 454.9600n 0.000785 454.9700n 0.000810 454.9800n 0.000834 454.9900n 0.000858 455.0000n 0.000882 455.0100n 0.000905 455.0200n 0.000928 455.0300n 0.000950 455.0400n 0.000972 455.0500n 0.000993 455.0600n 0.001014 455.0700n 0.001035 455.0800n 0.001054 455.0900n 0.001073
+ 455.1000n 0.001092 455.1100n 0.001110 455.1200n 0.001127 455.1300n 0.001144 455.1400n 0.001160 455.1500n 0.001175 455.1600n 0.001190 455.1700n 0.001204 455.1800n 0.001218 455.1900n 0.001230 455.2000n 0.001242 455.2100n 0.001253 455.2200n 0.001264 455.2300n 0.001274 455.2400n 0.001283
+ 455.2500n 0.001291 455.2600n 0.001298 455.2700n 0.001305 455.2800n 0.001311 455.2900n 0.001315 455.3000n 0.001320 455.3100n 0.001323 455.3200n 0.001325 455.3300n 0.001327 455.3400n 0.001328 455.3500n 0.001328 455.3600n 0.001327 455.3700n 0.001325 455.3800n 0.001322 455.3900n 0.001319
+ 455.4000n 0.001314 455.4100n 0.001309 455.4200n 0.001302 455.4300n 0.001295 455.4400n 0.001287 455.4500n 0.001278 455.4600n 0.001268 455.4700n 0.001257 455.4800n 0.001246 455.4900n 0.001233 455.5000n 0.001220 455.5100n 0.001205 455.5200n 0.001190 455.5300n 0.001174 455.5400n 0.001157
+ 455.5500n 0.001139 455.5600n 0.001120 455.5700n 0.001100 455.5800n 0.001079 455.5900n 0.001058 455.6000n 0.001035 455.6100n 0.001012 455.6200n 0.000988 455.6300n 0.000963 455.6400n 0.000937 455.6500n 0.000910 455.6600n 0.000883 455.6700n 0.000854 455.6800n 0.000825 455.6900n 0.000795
+ 455.7000n 0.000764 455.7100n 0.000733 455.7200n 0.000700 455.7300n 0.000667 455.7400n 0.000633 455.7500n 0.000599 455.7600n 0.000563 455.7700n 0.000527 455.7800n 0.000490 455.7900n 0.000453 455.8000n 0.000415 455.8100n 0.000376 455.8200n 0.000337 455.8300n 0.000297 455.8400n 0.000256
+ 455.8500n 0.000215 455.8600n 0.000173 455.8700n 0.000130 455.8800n 0.000087 455.8900n 0.000044 455.9000n -0.000000 455.9100n -0.000045 455.9200n -0.000090 455.9300n -0.000135 455.9400n -0.000181 455.9500n -0.000227 455.9600n -0.000274 455.9700n -0.000321 455.9800n -0.000369 455.9900n -0.000416
+ 456.0000n -0.000464 456.0100n -0.000513 456.0200n -0.000562 456.0300n -0.000611 456.0400n -0.000660 456.0500n -0.000709 456.0600n -0.000759 456.0700n -0.000808 456.0800n -0.000858 456.0900n -0.000908 456.1000n -0.000959 456.1100n -0.001009 456.1200n -0.001059 456.1300n -0.001110 456.1400n -0.001160
+ 456.1500n -0.001210 456.1600n -0.001261 456.1700n -0.001311 456.1800n -0.001361 456.1900n -0.001411 456.2000n -0.001461 456.2100n -0.001511 456.2200n -0.001561 456.2300n -0.001611 456.2400n -0.001660 456.2500n -0.001709 456.2600n -0.001758 456.2700n -0.001807 456.2800n -0.001855 456.2900n -0.001903
+ 456.3000n -0.001951 456.3100n -0.001998 456.3200n -0.002045 456.3300n -0.002092 456.3400n -0.002138 456.3500n -0.002183 456.3600n -0.002229 456.3700n -0.002273 456.3800n -0.002318 456.3900n -0.002361 456.4000n -0.002405 456.4100n -0.002447 456.4200n -0.002489 456.4300n -0.002531 456.4400n -0.002572
+ 456.4500n -0.002612 456.4600n -0.002652 456.4700n -0.002691 456.4800n -0.002729 456.4900n -0.002767 456.5000n -0.002803 456.5100n -0.002840 456.5200n -0.002875 456.5300n -0.002910 456.5400n -0.002943 456.5500n -0.002976 456.5600n -0.003009 456.5700n -0.003040 456.5800n -0.003071 456.5900n -0.003101
+ 456.6000n -0.003129 456.6100n -0.003158 456.6200n -0.003185 456.6300n -0.003211 456.6400n -0.003236 456.6500n -0.003261 456.6600n -0.003284 456.6700n -0.003307 456.6800n -0.003329 456.6900n -0.003349 456.7000n -0.003369 456.7100n -0.003388 456.7200n -0.003406 456.7300n -0.003423 456.7400n -0.003439
+ 456.7500n -0.003454 456.7600n -0.003468 456.7700n -0.003480 456.7800n -0.003492 456.7900n -0.003503 456.8000n -0.003513 456.8100n -0.003522 456.8200n -0.003530 456.8300n -0.003537 456.8400n -0.003543 456.8500n -0.003548 456.8600n -0.003552 456.8700n -0.003555 456.8800n -0.003557 456.8900n -0.003558
+ 456.9000n -0.003557 456.9100n -0.003556 456.9200n -0.003554 456.9300n -0.003551 456.9400n -0.003547 456.9500n -0.003542 456.9600n -0.003536 456.9700n -0.003529 456.9800n -0.003521 456.9900n -0.003512 457.0000n -0.003502 457.0100n -0.003492 457.0200n -0.003480 457.0300n -0.003467 457.0400n -0.003454
+ 457.0500n -0.003439 457.0600n -0.003424 457.0700n -0.003408 457.0800n -0.003390 457.0900n -0.003372 457.1000n -0.003354 457.1100n -0.003334 457.1200n -0.003313 457.1300n -0.003292 457.1400n -0.003270 457.1500n -0.003247 457.1600n -0.003223 457.1700n -0.003199 457.1800n -0.003174 457.1900n -0.003148
+ 457.2000n -0.003121 457.2100n -0.003094 457.2200n -0.003066 457.2300n -0.003037 457.2400n -0.003008 457.2500n -0.002978 457.2600n -0.002948 457.2700n -0.002916 457.2800n -0.002885 457.2900n -0.002852 457.3000n -0.002820 457.3100n -0.002786 457.3200n -0.002752 457.3300n -0.002718 457.3400n -0.002683
+ 457.3500n -0.002648 457.3600n -0.002612 457.3700n -0.002576 457.3800n -0.002540 457.3900n -0.002503 457.4000n -0.002465 457.4100n -0.002428 457.4200n -0.002390 457.4300n -0.002352 457.4400n -0.002313 457.4500n -0.002274 457.4600n -0.002235 457.4700n -0.002196 457.4800n -0.002157 457.4900n -0.002117
+ 457.5000n -0.002077 457.5100n -0.002037 457.5200n -0.001997 457.5300n -0.001957 457.5400n -0.001917 457.5500n -0.001877 457.5600n -0.001837 457.5700n -0.001796 457.5800n -0.001756 457.5900n -0.001716 457.6000n -0.001675 457.6100n -0.001635 457.6200n -0.001595 457.6300n -0.001555 457.6400n -0.001515
+ 457.6500n -0.001475 457.6600n -0.001435 457.6700n -0.001396 457.6800n -0.001357 457.6900n -0.001317 457.7000n -0.001279 457.7100n -0.001240 457.7200n -0.001201 457.7300n -0.001163 457.7400n -0.001125 457.7500n -0.001088 457.7600n -0.001050 457.7700n -0.001013 457.7800n -0.000977 457.7900n -0.000941
+ 457.8000n -0.000905 457.8100n -0.000869 457.8200n -0.000834 457.8300n -0.000799 457.8400n -0.000765 457.8500n -0.000731 457.8600n -0.000698 457.8700n -0.000665 457.8800n -0.000633 457.8900n -0.000601 457.9000n -0.000569 457.9100n -0.000539 457.9200n -0.000508 457.9300n -0.000478 457.9400n -0.000449
+ 457.9500n -0.000420 457.9600n -0.000392 457.9700n -0.000365 457.9800n -0.000337 457.9900n -0.000311 458.0000n -0.000285 458.0100n -0.000260 458.0200n -0.000235 458.0300n -0.000211 458.0400n -0.000188 458.0500n -0.000165 458.0600n -0.000143 458.0700n -0.000121 458.0800n -0.000101 458.0900n -0.000080
+ 458.1000n -0.000061 458.1100n -0.000042 458.1200n -0.000024 458.1300n -0.000006 458.1400n 0.000011 458.1500n 0.000027 458.1600n 0.000043 458.1700n 0.000058 458.1800n 0.000072 458.1900n 0.000086 458.2000n 0.000099 458.2100n 0.000111 458.2200n 0.000123 458.2300n 0.000134 458.2400n 0.000144
+ 458.2500n 0.000154 458.2600n 0.000163 458.2700n 0.000171 458.2800n 0.000179 458.2900n 0.000186 458.3000n 0.000192 458.3100n 0.000198 458.3200n 0.000203 458.3300n 0.000208 458.3400n 0.000212 458.3500n 0.000215 458.3600n 0.000218 458.3700n 0.000220 458.3800n 0.000221 458.3900n 0.000222
+ 458.4000n 0.000222 458.4100n 0.000222 458.4200n 0.000221 458.4300n 0.000219 458.4400n 0.000217 458.4500n 0.000215 458.4600n 0.000211 458.4700n 0.000208 458.4800n 0.000203 458.4900n 0.000199 458.5000n 0.000193 458.5100n 0.000187 458.5200n 0.000181 458.5300n 0.000174 458.5400n 0.000167
+ 458.5500n 0.000159 458.5600n 0.000151 458.5700n 0.000143 458.5800n 0.000133 458.5900n 0.000124 458.6000n 0.000114 458.6100n 0.000104 458.6200n 0.000093 458.6300n 0.000082 458.6400n 0.000070 458.6500n 0.000058 458.6600n 0.000046 458.6700n 0.000034 458.6800n 0.000021 458.6900n 0.000007
+ 458.7000n -0.000006 458.7100n -0.000020 458.7200n -0.000034 458.7300n -0.000049 458.7400n -0.000063 458.7500n -0.000078 458.7600n -0.000093 458.7700n -0.000109 458.7800n -0.000125 458.7900n -0.000140 458.8000n -0.000157 458.8100n -0.000173 458.8200n -0.000189 458.8300n -0.000206 458.8400n -0.000223
+ 458.8500n -0.000240 458.8600n -0.000257 458.8700n -0.000274 458.8800n -0.000291 458.8900n -0.000309 458.9000n -0.000326 458.9100n -0.000344 458.9200n -0.000361 458.9300n -0.000379 458.9400n -0.000397 458.9500n -0.000415 458.9600n -0.000433 458.9700n -0.000451 458.9800n -0.000469 458.9900n -0.000486
+ 459.0000n -0.000504 459.0100n -0.000522 459.0200n -0.000540 459.0300n -0.000558 459.0400n -0.000576 459.0500n -0.000594 459.0600n -0.000611 459.0700n -0.000629 459.0800n -0.000647 459.0900n -0.000664 459.1000n -0.000682 459.1100n -0.000699 459.1200n -0.000716 459.1300n -0.000733 459.1400n -0.000750
+ 459.1500n -0.000767 459.1600n -0.000784 459.1700n -0.000801 459.1800n -0.000817 459.1900n -0.000833 459.2000n -0.000849 459.2100n -0.000865 459.2200n -0.000881 459.2300n -0.000897 459.2400n -0.000912 459.2500n -0.000928 459.2600n -0.000943 459.2700n -0.000958 459.2800n -0.000972 459.2900n -0.000987
+ 459.3000n -0.001001 459.3100n -0.001015 459.3200n -0.001029 459.3300n -0.001043 459.3400n -0.001056 459.3500n -0.001069 459.3600n -0.001082 459.3700n -0.001095 459.3800n -0.001107 459.3900n -0.001120 459.4000n -0.001132 459.4100n -0.001143 459.4200n -0.001155 459.4300n -0.001166 459.4400n -0.001177
+ 459.4500n -0.001188 459.4600n -0.001198 459.4700n -0.001208 459.4800n -0.001218 459.4900n -0.001228 459.5000n -0.001237 459.5100n -0.001246 459.5200n -0.001255 459.5300n -0.001264 459.5400n -0.001272 459.5500n -0.001280 459.5600n -0.001288 459.5700n -0.001296 459.5800n -0.001303 459.5900n -0.001310
+ 459.6000n -0.001316 459.6100n -0.001323 459.6200n -0.001329 459.6300n -0.001335 459.6400n -0.001340 459.6500n -0.001346 459.6600n -0.001351 459.6700n -0.001355 459.6800n -0.001360 459.6900n -0.001364 459.7000n -0.001368 459.7100n -0.001372 459.7200n -0.001375 459.7300n -0.001378 459.7400n -0.001381
+ 459.7500n -0.001384 459.7600n -0.001386 459.7700n -0.001388 459.7800n -0.001390 459.7900n -0.001391 459.8000n -0.001392 459.8100n -0.001393 459.8200n -0.001394 459.8300n -0.001394 459.8400n -0.001395 459.8500n -0.001395 459.8600n -0.001394 459.8700n -0.001394 459.8800n -0.001393 459.8900n -0.001392
+ 459.9000n -0.001391 459.9100n -0.001389 459.9200n -0.001387 459.9300n -0.001385 459.9400n -0.001383 459.9500n -0.001380 459.9600n -0.001377 459.9700n -0.001374 459.9800n -0.001371 459.9900n -0.001368 460.0000n -0.001364 460.0100n -0.001360 460.0200n -0.001356 460.0300n -0.001351 460.0400n -0.001347
+ 460.0500n -0.001342 460.0600n -0.001337 460.0700n -0.001332 460.0800n -0.001326 460.0900n -0.001321 460.1000n -0.001315 460.1100n -0.001308 460.1200n -0.001302 460.1300n -0.001296 460.1400n -0.001289 460.1500n -0.001282 460.1600n -0.001275 460.1700n -0.001268 460.1800n -0.001260 460.1900n -0.001252
+ 460.2000n -0.001244 460.2100n -0.001236 460.2200n -0.001228 460.2300n -0.001220 460.2400n -0.001211 460.2500n -0.001202 460.2600n -0.001193 460.2700n -0.001184 460.2800n -0.001175 460.2900n -0.001166 460.3000n -0.001156 460.3100n -0.001146 460.3200n -0.001136 460.3300n -0.001126 460.3400n -0.001116
+ 460.3500n -0.001106 460.3600n -0.001095 460.3700n -0.001085 460.3800n -0.001074 460.3900n -0.001063 460.4000n -0.001052 460.4100n -0.001041 460.4200n -0.001029 460.4300n -0.001018 460.4400n -0.001007 460.4500n -0.000995 460.4600n -0.000983 460.4700n -0.000971 460.4800n -0.000959 460.4900n -0.000947
+ 460.5000n -0.000935 460.5100n -0.000923 460.5200n -0.000911 460.5300n -0.000898 460.5400n -0.000886 460.5500n -0.000873 460.5600n -0.000861 460.5700n -0.000848 460.5800n -0.000835 460.5900n -0.000823 460.6000n -0.000810 460.6100n -0.000797 460.6200n -0.000784 460.6300n -0.000771 460.6400n -0.000758
+ 460.6500n -0.000745 460.6600n -0.000732 460.6700n -0.000719 460.6800n -0.000706 460.6900n -0.000693 460.7000n -0.000680 460.7100n -0.000667 460.7200n -0.000653 460.7300n -0.000640 460.7400n -0.000627 460.7500n -0.000614 460.7600n -0.000601 460.7700n -0.000588 460.7800n -0.000575 460.7900n -0.000563
+ 460.8000n -0.000550 460.8100n -0.000537 460.8200n -0.000524 460.8300n -0.000512 460.8400n -0.000499 460.8500n -0.000487 460.8600n -0.000474 460.8700n -0.000462 460.8800n -0.000450 460.8900n -0.000438 460.9000n -0.000426 460.9100n -0.000414 460.9200n -0.000402 460.9300n -0.000391 460.9400n -0.000379
+ 460.9500n -0.000368 460.9600n -0.000357 460.9700n -0.000346 460.9800n -0.000335 460.9900n -0.000324 461.0000n -0.000314 461.0100n -0.000303 461.0200n -0.000293 461.0300n -0.000283 461.0400n -0.000274 461.0500n -0.000264 461.0600n -0.000255 461.0700n -0.000246 461.0800n -0.000237 461.0900n -0.000228
+ 461.1000n -0.000220 461.1100n -0.000212 461.1200n -0.000204 461.1300n -0.000196 461.1400n -0.000189 461.1500n -0.000182 461.1600n -0.000175 461.1700n -0.000168 461.1800n -0.000162 461.1900n -0.000156 461.2000n -0.000150 461.2100n -0.000145 461.2200n -0.000140 461.2300n -0.000135 461.2400n -0.000131
+ 461.2500n -0.000127 461.2600n -0.000123 461.2700n -0.000120 461.2800n -0.000117 461.2900n -0.000114 461.3000n -0.000111 461.3100n -0.000109 461.3200n -0.000108 461.3300n -0.000106 461.3400n -0.000105 461.3500n -0.000105 461.3600n -0.000104 461.3700n -0.000105 461.3800n -0.000105 461.3900n -0.000106
+ 461.4000n -0.000107 461.4100n -0.000109 461.4200n -0.000111 461.4300n -0.000113 461.4400n -0.000116 461.4500n -0.000119 461.4600n -0.000123 461.4700n -0.000127 461.4800n -0.000131 461.4900n -0.000136 461.5000n -0.000141 461.5100n -0.000147 461.5200n -0.000153 461.5300n -0.000159 461.5400n -0.000166
+ 461.5500n -0.000173 461.5600n -0.000181 461.5700n -0.000189 461.5800n -0.000197 461.5900n -0.000206 461.6000n -0.000215 461.6100n -0.000225 461.6200n -0.000235 461.6300n -0.000245 461.6400n -0.000256 461.6500n -0.000267 461.6600n -0.000279 461.6700n -0.000290 461.6800n -0.000303 461.6900n -0.000315
+ 461.7000n -0.000328 461.7100n -0.000342 461.7200n -0.000355 461.7300n -0.000369 461.7400n -0.000384 461.7500n -0.000398 461.7600n -0.000413 461.7700n -0.000429 461.7800n -0.000444 461.7900n -0.000460 461.8000n -0.000477 461.8100n -0.000493 461.8200n -0.000510 461.8300n -0.000527 461.8400n -0.000545
+ 461.8500n -0.000562 461.8600n -0.000580 461.8700n -0.000599 461.8800n -0.000617 461.8900n -0.000636 461.9000n -0.000655 461.9100n -0.000674 461.9200n -0.000693 461.9300n -0.000713 461.9400n -0.000732 461.9500n -0.000752 461.9600n -0.000772 461.9700n -0.000793 461.9800n -0.000813 461.9900n -0.000833
+ 462.0000n -0.000854 462.0100n -0.000875 462.0200n -0.000896 462.0300n -0.000917 462.0400n -0.000938 462.0500n -0.000959 462.0600n -0.000980 462.0700n -0.001001 462.0800n -0.001022 462.0900n -0.001044 462.1000n -0.001065 462.1100n -0.001086 462.1200n -0.001107 462.1300n -0.001129 462.1400n -0.001150
+ 462.1500n -0.001171 462.1600n -0.001192 462.1700n -0.001213 462.1800n -0.001234 462.1900n -0.001255 462.2000n -0.001275 462.2100n -0.001296 462.2200n -0.001316 462.2300n -0.001336 462.2400n -0.001356 462.2500n -0.001376 462.2600n -0.001396 462.2700n -0.001415 462.2800n -0.001435 462.2900n -0.001454
+ 462.3000n -0.001473 462.3100n -0.001491 462.3200n -0.001509 462.3300n -0.001527 462.3400n -0.001545 462.3500n -0.001563 462.3600n -0.001580 462.3700n -0.001596 462.3800n -0.001613 462.3900n -0.001629 462.4000n -0.001645 462.4100n -0.001660 462.4200n -0.001675 462.4300n -0.001690 462.4400n -0.001704
+ 462.4500n -0.001718 462.4600n -0.001731 462.4700n -0.001744 462.4800n -0.001756 462.4900n -0.001769 462.5000n -0.001780 462.5100n -0.001791 462.5200n -0.001802 462.5300n -0.001812 462.5400n -0.001822 462.5500n -0.001831 462.5600n -0.001840 462.5700n -0.001848 462.5800n -0.001856 462.5900n -0.001863
+ 462.6000n -0.001869 462.6100n -0.001875 462.6200n -0.001881 462.6300n -0.001886 462.6400n -0.001890 462.6500n -0.001894 462.6600n -0.001898 462.6700n -0.001901 462.6800n -0.001903 462.6900n -0.001904 462.7000n -0.001905 462.7100n -0.001906 462.7200n -0.001906 462.7300n -0.001905 462.7400n -0.001904
+ 462.7500n -0.001902 462.7600n -0.001900 462.7700n -0.001897 462.7800n -0.001894 462.7900n -0.001889 462.8000n -0.001885 462.8100n -0.001880 462.8200n -0.001874 462.8300n -0.001867 462.8400n -0.001860 462.8500n -0.001853 462.8600n -0.001845 462.8700n -0.001836 462.8800n -0.001827 462.8900n -0.001817
+ 462.9000n -0.001807 462.9100n -0.001796 462.9200n -0.001785 462.9300n -0.001773 462.9400n -0.001761 462.9500n -0.001748 462.9600n -0.001735 462.9700n -0.001721 462.9800n -0.001706 462.9900n -0.001692 463.0000n -0.001676 463.0100n -0.001661 463.0200n -0.001644 463.0300n -0.001628 463.0400n -0.001611
+ 463.0500n -0.001593 463.0600n -0.001575 463.0700n -0.001557 463.0800n -0.001538 463.0900n -0.001519 463.1000n -0.001500 463.1100n -0.001480 463.1200n -0.001460 463.1300n -0.001439 463.1400n -0.001418 463.1500n -0.001397 463.1600n -0.001376 463.1700n -0.001354 463.1800n -0.001332 463.1900n -0.001310
+ 463.2000n -0.001287 463.2100n -0.001265 463.2200n -0.001242 463.2300n -0.001219 463.2400n -0.001196 463.2500n -0.001172 463.2600n -0.001148 463.2700n -0.001125 463.2800n -0.001101 463.2900n -0.001077 463.3000n -0.001053 463.3100n -0.001029 463.3200n -0.001004 463.3300n -0.000980 463.3400n -0.000956
+ 463.3500n -0.000932 463.3600n -0.000907 463.3700n -0.000883 463.3800n -0.000859 463.3900n -0.000834 463.4000n -0.000810 463.4100n -0.000786 463.4200n -0.000762 463.4300n -0.000738 463.4400n -0.000714 463.4500n -0.000691 463.4600n -0.000667 463.4700n -0.000644 463.4800n -0.000620 463.4900n -0.000597
+ 463.5000n -0.000574 463.5100n -0.000552 463.5200n -0.000529 463.5300n -0.000507 463.5400n -0.000485 463.5500n -0.000464 463.5600n -0.000442 463.5700n -0.000421 463.5800n -0.000400 463.5900n -0.000380 463.6000n -0.000360 463.6100n -0.000340 463.6200n -0.000320 463.6300n -0.000301 463.6400n -0.000282
+ 463.6500n -0.000264 463.6600n -0.000246 463.6700n -0.000229 463.6800n -0.000211 463.6900n -0.000195 463.7000n -0.000178 463.7100n -0.000162 463.7200n -0.000147 463.7300n -0.000132 463.7400n -0.000117 463.7500n -0.000103 463.7600n -0.000090 463.7700n -0.000077 463.7800n -0.000064 463.7900n -0.000052
+ 463.8000n -0.000040 463.8100n -0.000029 463.8200n -0.000018 463.8300n -0.000008 463.8400n 0.000002 463.8500n 0.000011 463.8600n 0.000019 463.8700n 0.000028 463.8800n 0.000035 463.8900n 0.000042 463.9000n 0.000049 463.9100n 0.000055 463.9200n 0.000060 463.9300n 0.000066 463.9400n 0.000070
+ 463.9500n 0.000074 463.9600n 0.000078 463.9700n 0.000081 463.9800n 0.000083 463.9900n 0.000085 464.0000n 0.000087 464.0100n 0.000088 464.0200n 0.000088 464.0300n 0.000088 464.0400n 0.000088 464.0500n 0.000087 464.0600n 0.000085 464.0700n 0.000084 464.0800n 0.000081 464.0900n 0.000078
+ 464.1000n 0.000075 464.1100n 0.000072 464.1200n 0.000068 464.1300n 0.000063 464.1400n 0.000058 464.1500n 0.000053 464.1600n 0.000047 464.1700n 0.000041 464.1800n 0.000035 464.1900n 0.000028 464.2000n 0.000021 464.2100n 0.000014 464.2200n 0.000006 464.2300n -0.000002 464.2400n -0.000010
+ 464.2500n -0.000019 464.2600n -0.000028 464.2700n -0.000037 464.2800n -0.000046 464.2900n -0.000056 464.3000n -0.000066 464.3100n -0.000076 464.3200n -0.000086 464.3300n -0.000097 464.3400n -0.000107 464.3500n -0.000118 464.3600n -0.000129 464.3700n -0.000140 464.3800n -0.000151 464.3900n -0.000162
+ 464.4000n -0.000174 464.4100n -0.000185 464.4200n -0.000196 464.4300n -0.000208 464.4400n -0.000219 464.4500n -0.000231 464.4600n -0.000242 464.4700n -0.000253 464.4800n -0.000265 464.4900n -0.000276 464.5000n -0.000287 464.5100n -0.000298 464.5200n -0.000309 464.5300n -0.000320 464.5400n -0.000331
+ 464.5500n -0.000342 464.5600n -0.000352 464.5700n -0.000362 464.5800n -0.000373 464.5900n -0.000382 464.6000n -0.000392 464.6100n -0.000402 464.6200n -0.000411 464.6300n -0.000420 464.6400n -0.000428 464.6500n -0.000437 464.6600n -0.000445 464.6700n -0.000453 464.6800n -0.000460 464.6900n -0.000467
+ 464.7000n -0.000474 464.7100n -0.000481 464.7200n -0.000487 464.7300n -0.000492 464.7400n -0.000498 464.7500n -0.000503 464.7600n -0.000507 464.7700n -0.000511 464.7800n -0.000515 464.7900n -0.000518 464.8000n -0.000521 464.8100n -0.000523 464.8200n -0.000525 464.8300n -0.000527 464.8400n -0.000528
+ 464.8500n -0.000528 464.8600n -0.000528 464.8700n -0.000528 464.8800n -0.000527 464.8900n -0.000525 464.9000n -0.000523 464.9100n -0.000521 464.9200n -0.000518 464.9300n -0.000514 464.9400n -0.000510 464.9500n -0.000505 464.9600n -0.000500 464.9700n -0.000495 464.9800n -0.000489 464.9900n -0.000482
+ 465.0000n -0.000475 465.0100n -0.000467 465.0200n -0.000459 465.0300n -0.000450 465.0400n -0.000441 465.0500n -0.000431 465.0600n -0.000421 465.0700n -0.000410 465.0800n -0.000398 465.0900n -0.000387 465.1000n -0.000374 465.1100n -0.000361 465.1200n -0.000348 465.1300n -0.000334 465.1400n -0.000320
+ 465.1500n -0.000305 465.1600n -0.000290 465.1700n -0.000274 465.1800n -0.000258 465.1900n -0.000241 465.2000n -0.000224 465.2100n -0.000207 465.2200n -0.000189 465.2300n -0.000170 465.2400n -0.000152 465.2500n -0.000132 465.2600n -0.000113 465.2700n -0.000093 465.2800n -0.000073 465.2900n -0.000052
+ 465.3000n -0.000031 465.3100n -0.000010 465.3200n 0.000012 465.3300n 0.000034 465.3400n 0.000056 465.3500n 0.000079 465.3600n 0.000102 465.3700n 0.000125 465.3800n 0.000148 465.3900n 0.000172 465.4000n 0.000195 465.4100n 0.000219 465.4200n 0.000244 465.4300n 0.000268 465.4400n 0.000292
+ 465.4500n 0.000317 465.4600n 0.000342 465.4700n 0.000367 465.4800n 0.000392 465.4900n 0.000417 465.5000n 0.000442 465.5100n 0.000468 465.5200n 0.000493 465.5300n 0.000518 465.5400n 0.000544 465.5500n 0.000569 465.5600n 0.000595 465.5700n 0.000620 465.5800n 0.000646 465.5900n 0.000671
+ 465.6000n 0.000696 465.6100n 0.000721 465.6200n 0.000746 465.6300n 0.000771 465.6400n 0.000796 465.6500n 0.000821 465.6600n 0.000846 465.6700n 0.000870 465.6800n 0.000894 465.6900n 0.000919 465.7000n 0.000943 465.7100n 0.000966 465.7200n 0.000990 465.7300n 0.001013 465.7400n 0.001036
+ 465.7500n 0.001059 465.7600n 0.001081 465.7700n 0.001103 465.7800n 0.001125 465.7900n 0.001147 465.8000n 0.001168 465.8100n 0.001189 465.8200n 0.001210 465.8300n 0.001230 465.8400n 0.001250 465.8500n 0.001270 465.8600n 0.001289 465.8700n 0.001308 465.8800n 0.001327 465.8900n 0.001345
+ 465.9000n 0.001362 465.9100n 0.001380 465.9200n 0.001397 465.9300n 0.001413 465.9400n 0.001429 465.9500n 0.001445 465.9600n 0.001460 465.9700n 0.001475 465.9800n 0.001489 465.9900n 0.001503 466.0000n 0.001517 466.0100n 0.001530 466.0200n 0.001542 466.0300n 0.001554 466.0400n 0.001566
+ 466.0500n 0.001577 466.0600n 0.001588 466.0700n 0.001598 466.0800n 0.001608 466.0900n 0.001618 466.1000n 0.001627 466.1100n 0.001635 466.1200n 0.001643 466.1300n 0.001651 466.1400n 0.001658 466.1500n 0.001665 466.1600n 0.001671 466.1700n 0.001677 466.1800n 0.001682 466.1900n 0.001687
+ 466.2000n 0.001692 466.2100n 0.001696 466.2200n 0.001700 466.2300n 0.001703 466.2400n 0.001706 466.2500n 0.001708 466.2600n 0.001710 466.2700n 0.001712 466.2800n 0.001713 466.2900n 0.001714 466.3000n 0.001715 466.3100n 0.001715 466.3200n 0.001715 466.3300n 0.001715 466.3400n 0.001714
+ 466.3500n 0.001713 466.3600n 0.001711 466.3700n 0.001710 466.3800n 0.001707 466.3900n 0.001705 466.4000n 0.001703 466.4100n 0.001700 466.4200n 0.001697 466.4300n 0.001693 466.4400n 0.001690 466.4500n 0.001686 466.4600n 0.001682 466.4700n 0.001678 466.4800n 0.001673 466.4900n 0.001669
+ 466.5000n 0.001664 466.5100n 0.001659 466.5200n 0.001654 466.5300n 0.001649 466.5400n 0.001644 466.5500n 0.001638 466.5600n 0.001633 466.5700n 0.001627 466.5800n 0.001622 466.5900n 0.001616 466.6000n 0.001610 466.6100n 0.001604 466.6200n 0.001599 466.6300n 0.001593 466.6400n 0.001587
+ 466.6500n 0.001581 466.6600n 0.001575 466.6700n 0.001569 466.6800n 0.001564 466.6900n 0.001558 466.7000n 0.001552 466.7100n 0.001547 466.7200n 0.001541 466.7300n 0.001535 466.7400n 0.001530 466.7500n 0.001525 466.7600n 0.001520 466.7700n 0.001515 466.7800n 0.001510 466.7900n 0.001505
+ 466.8000n 0.001500 466.8100n 0.001496 466.8200n 0.001491 466.8300n 0.001487 466.8400n 0.001483 466.8500n 0.001479 466.8600n 0.001476 466.8700n 0.001472 466.8800n 0.001469 466.8900n 0.001466 466.9000n 0.001463 466.9100n 0.001461 466.9200n 0.001458 466.9300n 0.001456 466.9400n 0.001454
+ 466.9500n 0.001453 466.9600n 0.001451 466.9700n 0.001450 466.9800n 0.001449 466.9900n 0.001448 467.0000n 0.001448 467.0100n 0.001447 467.0200n 0.001447 467.0300n 0.001447 467.0400n 0.001448 467.0500n 0.001449 467.0600n 0.001449 467.0700n 0.001451 467.0800n 0.001452 467.0900n 0.001454
+ 467.1000n 0.001456 467.1100n 0.001458 467.1200n 0.001460 467.1300n 0.001462 467.1400n 0.001465 467.1500n 0.001468 467.1600n 0.001471 467.1700n 0.001475 467.1800n 0.001478 467.1900n 0.001482 467.2000n 0.001486 467.2100n 0.001490 467.2200n 0.001495 467.2300n 0.001499 467.2400n 0.001504
+ 467.2500n 0.001509 467.2600n 0.001514 467.2700n 0.001519 467.2800n 0.001524 467.2900n 0.001530 467.3000n 0.001535 467.3100n 0.001541 467.3200n 0.001547 467.3300n 0.001552 467.3400n 0.001558 467.3500n 0.001564 467.3600n 0.001570 467.3700n 0.001577 467.3800n 0.001583 467.3900n 0.001589
+ 467.4000n 0.001595 467.4100n 0.001601 467.4200n 0.001607 467.4300n 0.001614 467.4400n 0.001620 467.4500n 0.001626 467.4600n 0.001632 467.4700n 0.001638 467.4800n 0.001644 467.4900n 0.001650 467.5000n 0.001655 467.5100n 0.001661 467.5200n 0.001667 467.5300n 0.001672 467.5400n 0.001677
+ 467.5500n 0.001682 467.5600n 0.001687 467.5700n 0.001692 467.5800n 0.001697 467.5900n 0.001701 467.6000n 0.001705 467.6100n 0.001709 467.6200n 0.001713 467.6300n 0.001717 467.6400n 0.001720 467.6500n 0.001723 467.6600n 0.001726 467.6700n 0.001728 467.6800n 0.001730 467.6900n 0.001732
+ 467.7000n 0.001734 467.7100n 0.001735 467.7200n 0.001736 467.7300n 0.001736 467.7400n 0.001737 467.7500n 0.001736 467.7600n 0.001736 467.7700n 0.001735 467.7800n 0.001734 467.7900n 0.001732 467.8000n 0.001730 467.8100n 0.001728 467.8200n 0.001725 467.8300n 0.001722 467.8400n 0.001718
+ 467.8500n 0.001714 467.8600n 0.001710 467.8700n 0.001705 467.8800n 0.001700 467.8900n 0.001694 467.9000n 0.001688 467.9100n 0.001681 467.9200n 0.001674 467.9300n 0.001667 467.9400n 0.001659 467.9500n 0.001650 467.9600n 0.001642 467.9700n 0.001632 467.9800n 0.001623 467.9900n 0.001613
+ 468.0000n 0.001602 468.0100n 0.001591 468.0200n 0.001580 468.0300n 0.001568 468.0400n 0.001556 468.0500n 0.001543 468.0600n 0.001530 468.0700n 0.001516 468.0800n 0.001503 468.0900n 0.001488 468.1000n 0.001474 468.1100n 0.001458 468.1200n 0.001443 468.1300n 0.001427 468.1400n 0.001411
+ 468.1500n 0.001394 468.1600n 0.001377 468.1700n 0.001360 468.1800n 0.001343 468.1900n 0.001325 468.2000n 0.001307 468.2100n 0.001288 468.2200n 0.001269 468.2300n 0.001250 468.2400n 0.001231 468.2500n 0.001211 468.2600n 0.001192 468.2700n 0.001172 468.2800n 0.001151 468.2900n 0.001131
+ 468.3000n 0.001110 468.3100n 0.001090 468.3200n 0.001069 468.3300n 0.001048 468.3400n 0.001027 468.3500n 0.001005 468.3600n 0.000984 468.3700n 0.000963 468.3800n 0.000941 468.3900n 0.000920 468.4000n 0.000898 468.4100n 0.000877 468.4200n 0.000855 468.4300n 0.000834 468.4400n 0.000812
+ 468.4500n 0.000791 468.4600n 0.000769 468.4700n 0.000748 468.4800n 0.000727 468.4900n 0.000706 468.5000n 0.000685 468.5100n 0.000665 468.5200n 0.000644 468.5300n 0.000624 468.5400n 0.000604 468.5500n 0.000584 468.5600n 0.000565 468.5700n 0.000546 468.5800n 0.000527 468.5900n 0.000508
+ 468.6000n 0.000490 468.6100n 0.000472 468.6200n 0.000454 468.6300n 0.000437 468.6400n 0.000420 468.6500n 0.000404 468.6600n 0.000388 468.6700n 0.000373 468.6800n 0.000358 468.6900n 0.000343 468.7000n 0.000329 468.7100n 0.000315 468.7200n 0.000302 468.7300n 0.000290 468.7400n 0.000278
+ 468.7500n 0.000267 468.7600n 0.000256 468.7700n 0.000246 468.7800n 0.000236 468.7900n 0.000227 468.8000n 0.000219 468.8100n 0.000211 468.8200n 0.000204 468.8300n 0.000198 468.8400n 0.000192 468.8500n 0.000187 468.8600n 0.000183 468.8700n 0.000179 468.8800n 0.000176 468.8900n 0.000174
+ 468.9000n 0.000172 468.9100n 0.000171 468.9200n 0.000171 468.9300n 0.000172 468.9400n 0.000174 468.9500n 0.000176 468.9600n 0.000179 468.9700n 0.000182 468.9800n 0.000187 468.9900n 0.000192 469.0000n 0.000198 469.0100n 0.000204 469.0200n 0.000212 469.0300n 0.000220 469.0400n 0.000229
+ 469.0500n 0.000238 469.0600n 0.000249 469.0700n 0.000260 469.0800n 0.000272 469.0900n 0.000284 469.1000n 0.000298 469.1100n 0.000312 469.1200n 0.000327 469.1300n 0.000342 469.1400n 0.000358 469.1500n 0.000375 469.1600n 0.000393 469.1700n 0.000411 469.1800n 0.000430 469.1900n 0.000449
+ 469.2000n 0.000469 469.2100n 0.000490 469.2200n 0.000511 469.2300n 0.000533 469.2400n 0.000556 469.2500n 0.000579 469.2600n 0.000603 469.2700n 0.000627 469.2800n 0.000652 469.2900n 0.000677 469.3000n 0.000702 469.3100n 0.000729 469.3200n 0.000755 469.3300n 0.000782 469.3400n 0.000810
+ 469.3500n 0.000837 469.3600n 0.000866 469.3700n 0.000894 469.3800n 0.000923 469.3900n 0.000952 469.4000n 0.000982 469.4100n 0.001011 469.4200n 0.001041 469.4300n 0.001072 469.4400n 0.001102 469.4500n 0.001132 469.4600n 0.001163 469.4700n 0.001194 469.4800n 0.001225 469.4900n 0.001256
+ 469.5000n 0.001287 469.5100n 0.001318 469.5200n 0.001349 469.5300n 0.001380 469.5400n 0.001410 469.5500n 0.001441 469.5600n 0.001472 469.5700n 0.001503 469.5800n 0.001533 469.5900n 0.001563 469.6000n 0.001593 469.6100n 0.001623 469.6200n 0.001653 469.6300n 0.001682 469.6400n 0.001711
+ 469.6500n 0.001739 469.6600n 0.001768 469.6700n 0.001795 469.6800n 0.001823 469.6900n 0.001850 469.7000n 0.001876 469.7100n 0.001902 469.7200n 0.001928 469.7300n 0.001953 469.7400n 0.001977 469.7500n 0.002001 469.7600n 0.002024 469.7700n 0.002047 469.7800n 0.002069 469.7900n 0.002090
+ 469.8000n 0.002110 469.8100n 0.002130 469.8200n 0.002149 469.8300n 0.002168 469.8400n 0.002185 469.8500n 0.002202 469.8600n 0.002218 469.8700n 0.002233 469.8800n 0.002247 469.8900n 0.002260 469.9000n 0.002273 469.9100n 0.002285 469.9200n 0.002295 469.9300n 0.002305 469.9400n 0.002314
+ 469.9500n 0.002322 469.9600n 0.002328 469.9700n 0.002334 469.9800n 0.002339 469.9900n 0.002343 470.0000n 0.002346 470.0100n 0.002348 470.0200n 0.002349 470.0300n 0.002349 470.0400n 0.002347 470.0500n 0.002345 470.0600n 0.002342 470.0700n 0.002337 470.0800n 0.002332 470.0900n 0.002325
+ 470.1000n 0.002318 470.1100n 0.002309 470.1200n 0.002299 470.1300n 0.002288 470.1400n 0.002276 470.1500n 0.002264 470.1600n 0.002250 470.1700n 0.002234 470.1800n 0.002218 470.1900n 0.002201 470.2000n 0.002183 470.2100n 0.002164 470.2200n 0.002143 470.2300n 0.002122 470.2400n 0.002100
+ 470.2500n 0.002077 470.2600n 0.002052 470.2700n 0.002027 470.2800n 0.002001 470.2900n 0.001974 470.3000n 0.001946 470.3100n 0.001917 470.3200n 0.001887 470.3300n 0.001856 470.3400n 0.001824 470.3500n 0.001792 470.3600n 0.001758 470.3700n 0.001724 470.3800n 0.001689 470.3900n 0.001653
+ 470.4000n 0.001617 470.4100n 0.001580 470.4200n 0.001542 470.4300n 0.001503 470.4400n 0.001464 470.4500n 0.001424 470.4600n 0.001384 470.4700n 0.001342 470.4800n 0.001301 470.4900n 0.001259 470.5000n 0.001216 470.5100n 0.001173 470.5200n 0.001129 470.5300n 0.001085 470.5400n 0.001041
+ 470.5500n 0.000996 470.5600n 0.000951 470.5700n 0.000906 470.5800n 0.000860 470.5900n 0.000814 470.6000n 0.000768 470.6100n 0.000721 470.6200n 0.000675 470.6300n 0.000628 470.6400n 0.000582 470.6500n 0.000535 470.6600n 0.000488 470.6700n 0.000442 470.6800n 0.000395 470.6900n 0.000348
+ 470.7000n 0.000302 470.7100n 0.000256 470.7200n 0.000209 470.7300n 0.000163 470.7400n 0.000118 470.7500n 0.000072 470.7600n 0.000027 470.7700n -0.000018 470.7800n -0.000062 470.7900n -0.000106 470.8000n -0.000150 470.8100n -0.000193 470.8200n -0.000236 470.8300n -0.000278 470.8400n -0.000320
+ 470.8500n -0.000361 470.8600n -0.000401 470.8700n -0.000441 470.8800n -0.000480 470.8900n -0.000519 470.9000n -0.000557 470.9100n -0.000594 470.9200n -0.000630 470.9300n -0.000666 470.9400n -0.000700 470.9500n -0.000734 470.9600n -0.000767 470.9700n -0.000799 470.9800n -0.000830 470.9900n -0.000860
+ 471.0000n -0.000890 471.0100n -0.000918 471.0200n -0.000945 471.0300n -0.000971 471.0400n -0.000997 471.0500n -0.001021 471.0600n -0.001044 471.0700n -0.001066 471.0800n -0.001087 471.0900n -0.001107 471.1000n -0.001125 471.1100n -0.001143 471.1200n -0.001159 471.1300n -0.001174 471.1400n -0.001188
+ 471.1500n -0.001201 471.1600n -0.001213 471.1700n -0.001223 471.1800n -0.001232 471.1900n -0.001240 471.2000n -0.001247 471.2100n -0.001253 471.2200n -0.001257 471.2300n -0.001260 471.2400n -0.001262 471.2500n -0.001263 471.2600n -0.001262 471.2700n -0.001260 471.2800n -0.001257 471.2900n -0.001253
+ 471.3000n -0.001248 471.3100n -0.001241 471.3200n -0.001233 471.3300n -0.001224 471.3400n -0.001214 471.3500n -0.001202 471.3600n -0.001190 471.3700n -0.001176 471.3800n -0.001161 471.3900n -0.001145 471.4000n -0.001128 471.4100n -0.001110 471.4200n -0.001091 471.4300n -0.001070 471.4400n -0.001049
+ 471.4500n -0.001026 471.4600n -0.001003 471.4700n -0.000979 471.4800n -0.000953 471.4900n -0.000927 471.5000n -0.000900 471.5100n -0.000871 471.5200n -0.000842 471.5300n -0.000812 471.5400n -0.000782 471.5500n -0.000750 471.5600n -0.000718 471.5700n -0.000685 471.5800n -0.000651 471.5900n -0.000616
+ 471.6000n -0.000581 471.6100n -0.000545 471.6200n -0.000509 471.6300n -0.000472 471.6400n -0.000434 471.6500n -0.000396 471.6600n -0.000358 471.6700n -0.000319 471.6800n -0.000280 471.6900n -0.000240 471.7000n -0.000200 471.7100n -0.000159 471.7200n -0.000119 471.7300n -0.000078 471.7400n -0.000037
+ 471.7500n 0.000005 471.7600n 0.000046 471.7700n 0.000088 471.7800n 0.000129 471.7900n 0.000171 471.8000n 0.000213 471.8100n 0.000254 471.8200n 0.000296 471.8300n 0.000337 471.8400n 0.000379 471.8500n 0.000420 471.8600n 0.000461 471.8700n 0.000501 471.8800n 0.000542 471.8900n 0.000582
+ 471.9000n 0.000622 471.9100n 0.000661 471.9200n 0.000700 471.9300n 0.000738 471.9400n 0.000776 471.9500n 0.000814 471.9600n 0.000851 471.9700n 0.000887 471.9800n 0.000923 471.9900n 0.000958 472.0000n 0.000992 472.0100n 0.001026 472.0200n 0.001059 472.0300n 0.001091 472.0400n 0.001122
+ 472.0500n 0.001153 472.0600n 0.001183 472.0700n 0.001211 472.0800n 0.001239 472.0900n 0.001266 472.1000n 0.001293 472.1100n 0.001318 472.1200n 0.001342 472.1300n 0.001365 472.1400n 0.001387 472.1500n 0.001408 472.1600n 0.001428 472.1700n 0.001447 472.1800n 0.001464 472.1900n 0.001481
+ 472.2000n 0.001496 472.2100n 0.001510 472.2200n 0.001524 472.2300n 0.001535 472.2400n 0.001546 472.2500n 0.001556 472.2600n 0.001564 472.2700n 0.001571 472.2800n 0.001577 472.2900n 0.001581 472.3000n 0.001584 472.3100n 0.001586 472.3200n 0.001587 472.3300n 0.001586 472.3400n 0.001584
+ 472.3500n 0.001581 472.3600n 0.001577 472.3700n 0.001571 472.3800n 0.001564 472.3900n 0.001556 472.4000n 0.001547 472.4100n 0.001536 472.4200n 0.001524 472.4300n 0.001511 472.4400n 0.001496 472.4500n 0.001480 472.4600n 0.001463 472.4700n 0.001445 472.4800n 0.001426 472.4900n 0.001405
+ 472.5000n 0.001384 472.5100n 0.001361 472.5200n 0.001337 472.5300n 0.001312 472.5400n 0.001285 472.5500n 0.001258 472.5600n 0.001230 472.5700n 0.001200 472.5800n 0.001170 472.5900n 0.001138 472.6000n 0.001106 472.6100n 0.001072 472.6200n 0.001038 472.6300n 0.001003 472.6400n 0.000967
+ 472.6500n 0.000930 472.6600n 0.000892 472.6700n 0.000853 472.6800n 0.000814 472.6900n 0.000774 472.7000n 0.000733 472.7100n 0.000691 472.7200n 0.000649 472.7300n 0.000606 472.7400n 0.000563 472.7500n 0.000519 472.7600n 0.000475 472.7700n 0.000430 472.7800n 0.000384 472.7900n 0.000339
+ 472.8000n 0.000292 472.8100n 0.000246 472.8200n 0.000199 472.8300n 0.000152 472.8400n 0.000105 472.8500n 0.000058 472.8600n 0.000010 472.8700n -0.000038 472.8800n -0.000086 472.8900n -0.000133 472.9000n -0.000181 472.9100n -0.000229 472.9200n -0.000277 472.9300n -0.000324 472.9400n -0.000372
+ 472.9500n -0.000419 472.9600n -0.000466 472.9700n -0.000513 472.9800n -0.000559 472.9900n -0.000606 473.0000n -0.000651 473.0100n -0.000697 473.0200n -0.000742 473.0300n -0.000786 473.0400n -0.000830 473.0500n -0.000873 473.0600n -0.000916 473.0700n -0.000958 473.0800n -0.001000 473.0900n -0.001041
+ 473.1000n -0.001081 473.1100n -0.001120 473.1200n -0.001159 473.1300n -0.001196 473.1400n -0.001233 473.1500n -0.001269 473.1600n -0.001304 473.1700n -0.001338 473.1800n -0.001371 473.1900n -0.001403 473.2000n -0.001434 473.2100n -0.001464 473.2200n -0.001493 473.2300n -0.001521 473.2400n -0.001548
+ 473.2500n -0.001573 473.2600n -0.001598 473.2700n -0.001621 473.2800n -0.001643 473.2900n -0.001663 473.3000n -0.001683 473.3100n -0.001701 473.3200n -0.001718 473.3300n -0.001733 473.3400n -0.001747 473.3500n -0.001760 473.3600n -0.001772 473.3700n -0.001782 473.3800n -0.001791 473.3900n -0.001798
+ 473.4000n -0.001804 473.4100n -0.001809 473.4200n -0.001812 473.4300n -0.001814 473.4400n -0.001814 473.4500n -0.001813 473.4600n -0.001811 473.4700n -0.001807 473.4800n -0.001801 473.4900n -0.001795 473.5000n -0.001786 473.5100n -0.001777 473.5200n -0.001766 473.5300n -0.001753 473.5400n -0.001739
+ 473.5500n -0.001724 473.5600n -0.001708 473.5700n -0.001690 473.5800n -0.001670 473.5900n -0.001650 473.6000n -0.001627 473.6100n -0.001604 473.6200n -0.001579 473.6300n -0.001553 473.6400n -0.001526 473.6500n -0.001497 473.6600n -0.001468 473.6700n -0.001437 473.6800n -0.001404 473.6900n -0.001371
+ 473.7000n -0.001336 473.7100n -0.001301 473.7200n -0.001264 473.7300n -0.001226 473.7400n -0.001187 473.7500n -0.001147 473.7600n -0.001106 473.7700n -0.001064 473.7800n -0.001021 473.7900n -0.000977 473.8000n -0.000932 473.8100n -0.000886 473.8200n -0.000840 473.8300n -0.000792 473.8400n -0.000744
+ 473.8500n -0.000695 473.8600n -0.000646 473.8700n -0.000596 473.8800n -0.000545 473.8900n -0.000493 473.9000n -0.000441 473.9100n -0.000389 473.9200n -0.000336 473.9300n -0.000283 473.9400n -0.000229 473.9500n -0.000175 473.9600n -0.000120 473.9700n -0.000065 473.9800n -0.000010 473.9900n 0.000045
+ 474.0000n 0.000101 474.0100n 0.000156 474.0200n 0.000212 474.0300n 0.000268 474.0400n 0.000323 474.0500n 0.000379 474.0600n 0.000435 474.0700n 0.000490 474.0800n 0.000546 474.0900n 0.000601 474.1000n 0.000656 474.1100n 0.000711 474.1200n 0.000765 474.1300n 0.000820 474.1400n 0.000873
+ 474.1500n 0.000927 474.1600n 0.000980 474.1700n 0.001032 474.1800n 0.001084 474.1900n 0.001135 474.2000n 0.001186 474.2100n 0.001236 474.2200n 0.001286 474.2300n 0.001335 474.2400n 0.001383 474.2500n 0.001430 474.2600n 0.001476 474.2700n 0.001522 474.2800n 0.001567 474.2900n 0.001611
+ 474.3000n 0.001654 474.3100n 0.001696 474.3200n 0.001737 474.3300n 0.001777 474.3400n 0.001815 474.3500n 0.001853 474.3600n 0.001890 474.3700n 0.001926 474.3800n 0.001960 474.3900n 0.001994 474.4000n 0.002026 474.4100n 0.002057 474.4200n 0.002087 474.4300n 0.002115 474.4400n 0.002142
+ 474.4500n 0.002168 474.4600n 0.002193 474.4700n 0.002216 474.4800n 0.002238 474.4900n 0.002259 474.5000n 0.002278 474.5100n 0.002296 474.5200n 0.002312 474.5300n 0.002328 474.5400n 0.002341 474.5500n 0.002354 474.5600n 0.002364 474.5700n 0.002374 474.5800n 0.002382 474.5900n 0.002389
+ 474.6000n 0.002394 474.6100n 0.002397 474.6200n 0.002400 474.6300n 0.002401 474.6400n 0.002400 474.6500n 0.002398 474.6600n 0.002395 474.6700n 0.002390 474.6800n 0.002384 474.6900n 0.002376 474.7000n 0.002367 474.7100n 0.002357 474.7200n 0.002345 474.7300n 0.002332 474.7400n 0.002317
+ 474.7500n 0.002301 474.7600n 0.002284 474.7700n 0.002266 474.7800n 0.002246 474.7900n 0.002225 474.8000n 0.002203 474.8100n 0.002179 474.8200n 0.002154 474.8300n 0.002128 474.8400n 0.002101 474.8500n 0.002073 474.8600n 0.002044 474.8700n 0.002013 474.8800n 0.001981 474.8900n 0.001949
+ 474.9000n 0.001915 474.9100n 0.001880 474.9200n 0.001845 474.9300n 0.001808 474.9400n 0.001771 474.9500n 0.001732 474.9600n 0.001693 474.9700n 0.001653 474.9800n 0.001612 474.9900n 0.001570 475.0000n 0.001528 475.0100n 0.001485 475.0200n 0.001441 475.0300n 0.001397 475.0400n 0.001352
+ 475.0500n 0.001306 475.0600n 0.001260 475.0700n 0.001213 475.0800n 0.001166 475.0900n 0.001119 475.1000n 0.001071 475.1100n 0.001023 475.1200n 0.000975 475.1300n 0.000926 475.1400n 0.000877 475.1500n 0.000828 475.1600n 0.000778 475.1700n 0.000729 475.1800n 0.000679 475.1900n 0.000630
+ 475.2000n 0.000580 475.2100n 0.000531 475.2200n 0.000481 475.2300n 0.000432 475.2400n 0.000382 475.2500n 0.000333 475.2600n 0.000284 475.2700n 0.000235 475.2800n 0.000187 475.2900n 0.000139 475.3000n 0.000091 475.3100n 0.000044 475.3200n -0.000003 475.3300n -0.000050 475.3400n -0.000096
+ 475.3500n -0.000141 475.3600n -0.000186 475.3700n -0.000231 475.3800n -0.000275 475.3900n -0.000318 475.4000n -0.000360 475.4100n -0.000402 475.4200n -0.000443 475.4300n -0.000484 475.4400n -0.000523 475.4500n -0.000562 475.4600n -0.000600 475.4700n -0.000637 475.4800n -0.000673 475.4900n -0.000708
+ 475.5000n -0.000743 475.5100n -0.000776 475.5200n -0.000808 475.5300n -0.000840 475.5400n -0.000870 475.5500n -0.000900 475.5600n -0.000928 475.5700n -0.000955 475.5800n -0.000981 475.5900n -0.001006 475.6000n -0.001030 475.6100n -0.001053 475.6200n -0.001075 475.6300n -0.001095 475.6400n -0.001114
+ 475.6500n -0.001132 475.6600n -0.001149 475.6700n -0.001165 475.6800n -0.001180 475.6900n -0.001193 475.7000n -0.001205 475.7100n -0.001216 475.7200n -0.001226 475.7300n -0.001234 475.7400n -0.001241 475.7500n -0.001247 475.7600n -0.001252 475.7700n -0.001256 475.7800n -0.001258 475.7900n -0.001259
+ 475.8000n -0.001259 475.8100n -0.001257 475.8200n -0.001255 475.8300n -0.001251 475.8400n -0.001246 475.8500n -0.001240 475.8600n -0.001233 475.8700n -0.001225 475.8800n -0.001215 475.8900n -0.001204 475.9000n -0.001192 475.9100n -0.001180 475.9200n -0.001166 475.9300n -0.001150 475.9400n -0.001134
+ 475.9500n -0.001117 475.9600n -0.001099 475.9700n -0.001080 475.9800n -0.001059 475.9900n -0.001038 476.0000n -0.001016 476.0100n -0.000993 476.0200n -0.000969 476.0300n -0.000944 476.0400n -0.000919 476.0500n -0.000892 476.0600n -0.000865 476.0700n -0.000837 476.0800n -0.000808 476.0900n -0.000778
+ 476.1000n -0.000748 476.1100n -0.000717 476.1200n -0.000686 476.1300n -0.000653 476.1400n -0.000621 476.1500n -0.000587 476.1600n -0.000553 476.1700n -0.000519 476.1800n -0.000484 476.1900n -0.000449 476.2000n -0.000413 476.2100n -0.000377 476.2200n -0.000341 476.2300n -0.000304 476.2400n -0.000267
+ 476.2500n -0.000230 476.2600n -0.000193 476.2700n -0.000155 476.2800n -0.000117 476.2900n -0.000079 476.3000n -0.000041 476.3100n -0.000003 476.3200n 0.000035 476.3300n 0.000073 476.3400n 0.000111 476.3500n 0.000149 476.3600n 0.000187 476.3700n 0.000225 476.3800n 0.000262 476.3900n 0.000300
+ 476.4000n 0.000337 476.4100n 0.000374 476.4200n 0.000411 476.4300n 0.000447 476.4400n 0.000483 476.4500n 0.000519 476.4600n 0.000554 476.4700n 0.000589 476.4800n 0.000623 476.4900n 0.000657 476.5000n 0.000690 476.5100n 0.000723 476.5200n 0.000756 476.5300n 0.000787 476.5400n 0.000818
+ 476.5500n 0.000849 476.5600n 0.000879 476.5700n 0.000908 476.5800n 0.000936 476.5900n 0.000964 476.6000n 0.000991 476.6100n 0.001017 476.6200n 0.001042 476.6300n 0.001067 476.6400n 0.001091 476.6500n 0.001114 476.6600n 0.001136 476.6700n 0.001157 476.6800n 0.001177 476.6900n 0.001197
+ 476.7000n 0.001215 476.7100n 0.001233 476.7200n 0.001249 476.7300n 0.001265 476.7400n 0.001280 476.7500n 0.001293 476.7600n 0.001306 476.7700n 0.001318 476.7800n 0.001328 476.7900n 0.001338 476.8000n 0.001347 476.8100n 0.001354 476.8200n 0.001361 476.8300n 0.001367 476.8400n 0.001371
+ 476.8500n 0.001375 476.8600n 0.001377 476.8700n 0.001379 476.8800n 0.001379 476.8900n 0.001378 476.9000n 0.001377 476.9100n 0.001374 476.9200n 0.001370 476.9300n 0.001365 476.9400n 0.001359 476.9500n 0.001352 476.9600n 0.001345 476.9700n 0.001336 476.9800n 0.001326 476.9900n 0.001315
+ 477.0000n 0.001303 477.0100n 0.001290 477.0200n 0.001277 477.0300n 0.001262 477.0400n 0.001246 477.0500n 0.001230 477.0600n 0.001212 477.0700n 0.001194 477.0800n 0.001175 477.0900n 0.001154 477.1000n 0.001134 477.1100n 0.001112 477.1200n 0.001089 477.1300n 0.001066 477.1400n 0.001042
+ 477.1500n 0.001017 477.1600n 0.000991 477.1700n 0.000964 477.1800n 0.000937 477.1900n 0.000910 477.2000n 0.000881 477.2100n 0.000852 477.2200n 0.000822 477.2300n 0.000792 477.2400n 0.000761 477.2500n 0.000730 477.2600n 0.000698 477.2700n 0.000665 477.2800n 0.000632 477.2900n 0.000599
+ 477.3000n 0.000565 477.3100n 0.000531 477.3200n 0.000496 477.3300n 0.000461 477.3400n 0.000426 477.3500n 0.000391 477.3600n 0.000355 477.3700n 0.000319 477.3800n 0.000282 477.3900n 0.000246 477.4000n 0.000209 477.4100n 0.000172 477.4200n 0.000135 477.4300n 0.000098 477.4400n 0.000061
+ 477.4500n 0.000023 477.4600n -0.000014 477.4700n -0.000051 477.4800n -0.000089 477.4900n -0.000126 477.5000n -0.000163 477.5100n -0.000200 477.5200n -0.000237 477.5300n -0.000274 477.5400n -0.000310 477.5500n -0.000347 477.5600n -0.000383 477.5700n -0.000419 477.5800n -0.000455 477.5900n -0.000490
+ 477.6000n -0.000525 477.6100n -0.000560 477.6200n -0.000594 477.6300n -0.000628 477.6400n -0.000662 477.6500n -0.000695 477.6600n -0.000728 477.6700n -0.000760 477.6800n -0.000792 477.6900n -0.000824 477.7000n -0.000855 477.7100n -0.000885 477.7200n -0.000915 477.7300n -0.000944 477.7400n -0.000973
+ 477.7500n -0.001001 477.7600n -0.001029 477.7700n -0.001055 477.7800n -0.001082 477.7900n -0.001107 477.8000n -0.001132 477.8100n -0.001157 477.8200n -0.001180 477.8300n -0.001203 477.8400n -0.001225 477.8500n -0.001247 477.8600n -0.001268 477.8700n -0.001288 477.8800n -0.001307 477.8900n -0.001326
+ 477.9000n -0.001344 477.9100n -0.001361 477.9200n -0.001377 477.9300n -0.001393 477.9400n -0.001407 477.9500n -0.001421 477.9600n -0.001434 477.9700n -0.001447 477.9800n -0.001459 477.9900n -0.001469 478.0000n -0.001480 478.0100n -0.001489 478.0200n -0.001497 478.0300n -0.001505 478.0400n -0.001512
+ 478.0500n -0.001518 478.0600n -0.001523 478.0700n -0.001528 478.0800n -0.001532 478.0900n -0.001535 478.1000n -0.001537 478.1100n -0.001539 478.1200n -0.001540 478.1300n -0.001540 478.1400n -0.001539 478.1500n -0.001537 478.1600n -0.001535 478.1700n -0.001532 478.1800n -0.001529 478.1900n -0.001525
+ 478.2000n -0.001520 478.2100n -0.001514 478.2200n -0.001508 478.2300n -0.001501 478.2400n -0.001493 478.2500n -0.001485 478.2600n -0.001476 478.2700n -0.001466 478.2800n -0.001456 478.2900n -0.001446 478.3000n -0.001434 478.3100n -0.001422 478.3200n -0.001410 478.3300n -0.001397 478.3400n -0.001384
+ 478.3500n -0.001370 478.3600n -0.001355 478.3700n -0.001341 478.3800n -0.001325 478.3900n -0.001309 478.4000n -0.001293 478.4100n -0.001277 478.4200n -0.001260 478.4300n -0.001242 478.4400n -0.001224 478.4500n -0.001206 478.4600n -0.001188 478.4700n -0.001169 478.4800n -0.001150 478.4900n -0.001131
+ 478.5000n -0.001111 478.5100n -0.001091 478.5200n -0.001071 478.5300n -0.001050 478.5400n -0.001030 478.5500n -0.001009 478.5600n -0.000988 478.5700n -0.000967 478.5800n -0.000946 478.5900n -0.000924 478.6000n -0.000903 478.6100n -0.000881 478.6200n -0.000860 478.6300n -0.000838 478.6400n -0.000816
+ 478.6500n -0.000794 478.6600n -0.000772 478.6700n -0.000751 478.6800n -0.000729 478.6900n -0.000707 478.7000n -0.000685 478.7100n -0.000663 478.7200n -0.000642 478.7300n -0.000620 478.7400n -0.000598 478.7500n -0.000577 478.7600n -0.000555 478.7700n -0.000534 478.7800n -0.000513 478.7900n -0.000492
+ 478.8000n -0.000471 478.8100n -0.000451 478.8200n -0.000430 478.8300n -0.000410 478.8400n -0.000390 478.8500n -0.000370 478.8600n -0.000350 478.8700n -0.000330 478.8800n -0.000311 478.8900n -0.000292 478.9000n -0.000273 478.9100n -0.000255 478.9200n -0.000236 478.9300n -0.000218 478.9400n -0.000201
+ 478.9500n -0.000183 478.9600n -0.000166 478.9700n -0.000149 478.9800n -0.000132 478.9900n -0.000116 479.0000n -0.000100 479.0100n -0.000084 479.0200n -0.000069 479.0300n -0.000053 479.0400n -0.000039 479.0500n -0.000024 479.0600n -0.000010 479.0700n 0.000004 479.0800n 0.000018 479.0900n 0.000031
+ 479.1000n 0.000044 479.1100n 0.000057 479.1200n 0.000069 479.1300n 0.000081 479.1400n 0.000093 479.1500n 0.000104 479.1600n 0.000115 479.1700n 0.000126 479.1800n 0.000136 479.1900n 0.000147 479.2000n 0.000156 479.2100n 0.000166 479.2200n 0.000175 479.2300n 0.000184 479.2400n 0.000193
+ 479.2500n 0.000201 479.2600n 0.000209 479.2700n 0.000217 479.2800n 0.000225 479.2900n 0.000232 479.3000n 0.000239 479.3100n 0.000245 479.3200n 0.000252 479.3300n 0.000258 479.3400n 0.000264 479.3500n 0.000269 479.3600n 0.000275 479.3700n 0.000280 479.3800n 0.000285 479.3900n 0.000290
+ 479.4000n 0.000294 479.4100n 0.000298 479.4200n 0.000302 479.4300n 0.000306 479.4400n 0.000310 479.4500n 0.000313 479.4600n 0.000316 479.4700n 0.000319 479.4800n 0.000322 479.4900n 0.000324 479.5000n 0.000327 479.5100n 0.000329 479.5200n 0.000331 479.5300n 0.000333 479.5400n 0.000335
+ 479.5500n 0.000336 479.5600n 0.000338 479.5700n 0.000339 479.5800n 0.000340 479.5900n 0.000341 479.6000n 0.000342 479.6100n 0.000343 479.6200n 0.000344 479.6300n 0.000344 479.6400n 0.000345 479.6500n 0.000345 479.6600n 0.000345 479.6700n 0.000345 479.6800n 0.000345 479.6900n 0.000345
+ 479.7000n 0.000344 479.7100n 0.000344 479.7200n 0.000344 479.7300n 0.000343 479.7400n 0.000342 479.7500n 0.000342 479.7600n 0.000341 479.7700n 0.000340 479.7800n 0.000339 479.7900n 0.000337 479.8000n 0.000336 479.8100n 0.000335 479.8200n 0.000333 479.8300n 0.000332 479.8400n 0.000330
+ 479.8500n 0.000328 479.8600n 0.000327 479.8700n 0.000325 479.8800n 0.000323 479.8900n 0.000320 479.9000n 0.000318 479.9100n 0.000316 479.9200n 0.000313 479.9300n 0.000311 479.9400n 0.000308 479.9500n 0.000305 479.9600n 0.000302 479.9700n 0.000299 479.9800n 0.000296 479.9900n 0.000292
+ 480.0000n 0.000289 480.0100n 0.000285 480.0200n 0.000281 480.0300n 0.000277 480.0400n 0.000273 480.0500n 0.000269 480.0600n 0.000264 480.0700n 0.000259 480.0800n 0.000255 480.0900n 0.000250 480.1000n 0.000244 480.1100n 0.000239 480.1200n 0.000233 480.1300n 0.000227 480.1400n 0.000221
+ 480.1500n 0.000215 480.1600n 0.000208 480.1700n 0.000201 480.1800n 0.000194 480.1900n 0.000187 480.2000n 0.000179 480.2100n 0.000171 480.2200n 0.000163 480.2300n 0.000154 480.2400n 0.000146 480.2500n 0.000137 480.2600n 0.000127 480.2700n 0.000117 480.2800n 0.000107 480.2900n 0.000097
+ 480.3000n 0.000086 480.3100n 0.000075 480.3200n 0.000064 480.3300n 0.000052 480.3400n 0.000040 480.3500n 0.000028 480.3600n 0.000015 480.3700n 0.000002 480.3800n -0.000012 480.3900n -0.000026 480.4000n -0.000041 480.4100n -0.000055 480.4200n -0.000071 480.4300n -0.000086 480.4400n -0.000102
+ 480.4500n -0.000119 480.4600n -0.000136 480.4700n -0.000153 480.4800n -0.000171 480.4900n -0.000189 480.5000n -0.000207 480.5100n -0.000226 480.5200n -0.000246 480.5300n -0.000266 480.5400n -0.000286 480.5500n -0.000307 480.5600n -0.000328 480.5700n -0.000350 480.5800n -0.000372 480.5900n -0.000395
+ 480.6000n -0.000418 480.6100n -0.000442 480.6200n -0.000466 480.6300n -0.000490 480.6400n -0.000515 480.6500n -0.000540 480.6600n -0.000566 480.6700n -0.000592 480.6800n -0.000619 480.6900n -0.000646 480.7000n -0.000673 480.7100n -0.000701 480.7200n -0.000730 480.7300n -0.000758 480.7400n -0.000787
+ 480.7500n -0.000817 480.7600n -0.000847 480.7700n -0.000877 480.7800n -0.000908 480.7900n -0.000938 480.8000n -0.000970 480.8100n -0.001001 480.8200n -0.001033 480.8300n -0.001066 480.8400n -0.001098 480.8500n -0.001131 480.8600n -0.001164 480.8700n -0.001198 480.8800n -0.001232 480.8900n -0.001266
+ 480.9000n -0.001300 480.9100n -0.001334 480.9200n -0.001369 480.9300n -0.001404 480.9400n -0.001439 480.9500n -0.001474 480.9600n -0.001509 480.9700n -0.001545 480.9800n -0.001580 480.9900n -0.001616 481.0000n -0.001651 481.0100n -0.001687 481.0200n -0.001723 481.0300n -0.001759 481.0400n -0.001795
+ 481.0500n -0.001830 481.0600n -0.001866 481.0700n -0.001902 481.0800n -0.001937 481.0900n -0.001973 481.1000n -0.002008 481.1100n -0.002044 481.1200n -0.002079 481.1300n -0.002114 481.1400n -0.002148 481.1500n -0.002183 481.1600n -0.002217 481.1700n -0.002251 481.1800n -0.002285 481.1900n -0.002318
+ 481.2000n -0.002351 481.2100n -0.002384 481.2200n -0.002416 481.2300n -0.002448 481.2400n -0.002479 481.2500n -0.002510 481.2600n -0.002541 481.2700n -0.002571 481.2800n -0.002600 481.2900n -0.002629 481.3000n -0.002657 481.3100n -0.002685 481.3200n -0.002712 481.3300n -0.002739 481.3400n -0.002765
+ 481.3500n -0.002790 481.3600n -0.002815 481.3700n -0.002839 481.3800n -0.002862 481.3900n -0.002884 481.4000n -0.002905 481.4100n -0.002926 481.4200n -0.002946 481.4300n -0.002965 481.4400n -0.002983 481.4500n -0.003001 481.4600n -0.003017 481.4700n -0.003033 481.4800n -0.003047 481.4900n -0.003061
+ 481.5000n -0.003073 481.5100n -0.003085 481.5200n -0.003096 481.5300n -0.003105 481.5400n -0.003114 481.5500n -0.003121 481.5600n -0.003128 481.5700n -0.003133 481.5800n -0.003137 481.5900n -0.003140 481.6000n -0.003142 481.6100n -0.003143 481.6200n -0.003143 481.6300n -0.003141 481.6400n -0.003139
+ 481.6500n -0.003135 481.6600n -0.003130 481.6700n -0.003123 481.6800n -0.003116 481.6900n -0.003107 481.7000n -0.003097 481.7100n -0.003086 481.7200n -0.003074 481.7300n -0.003060 481.7400n -0.003045 481.7500n -0.003029 481.7600n -0.003012 481.7700n -0.002994 481.7800n -0.002974 481.7900n -0.002953
+ 481.8000n -0.002930 481.8100n -0.002907 481.8200n -0.002882 481.8300n -0.002856 481.8400n -0.002829 481.8500n -0.002800 481.8600n -0.002770 481.8700n -0.002739 481.8800n -0.002707 481.8900n -0.002674 481.9000n -0.002639 481.9100n -0.002603 481.9200n -0.002566 481.9300n -0.002528 481.9400n -0.002489
+ 481.9500n -0.002448 481.9600n -0.002407 481.9700n -0.002364 481.9800n -0.002320 481.9900n -0.002275 482.0000n -0.002229 482.0100n -0.002182 482.0200n -0.002134 482.0300n -0.002085 482.0400n -0.002035 482.0500n -0.001984 482.0600n -0.001932 482.0700n -0.001879 482.0800n -0.001825 482.0900n -0.001771
+ 482.1000n -0.001715 482.1100n -0.001658 482.1200n -0.001601 482.1300n -0.001543 482.1400n -0.001484 482.1500n -0.001424 482.1600n -0.001364 482.1700n -0.001303 482.1800n -0.001241 482.1900n -0.001179 482.2000n -0.001116 482.2100n -0.001052 482.2200n -0.000988 482.2300n -0.000924 482.2400n -0.000859
+ 482.2500n -0.000793 482.2600n -0.000727 482.2700n -0.000661 482.2800n -0.000594 482.2900n -0.000527 482.3000n -0.000459 482.3100n -0.000392 482.3200n -0.000324 482.3300n -0.000256 482.3400n -0.000188 482.3500n -0.000119 482.3600n -0.000051 482.3700n 0.000018 482.3800n 0.000086 482.3900n 0.000155
+ 482.4000n 0.000223 482.4100n 0.000291 482.4200n 0.000360 482.4300n 0.000428 482.4400n 0.000496 482.4500n 0.000563 482.4600n 0.000631 482.4700n 0.000698 482.4800n 0.000765 482.4900n 0.000831 482.5000n 0.000897 482.5100n 0.000963 482.5200n 0.001028 482.5300n 0.001092 482.5400n 0.001156
+ 482.5500n 0.001220 482.5600n 0.001283 482.5700n 0.001345 482.5800n 0.001407 482.5900n 0.001468 482.6000n 0.001528 482.6100n 0.001587 482.6200n 0.001646 482.6300n 0.001703 482.6400n 0.001760 482.6500n 0.001816 482.6600n 0.001871 482.6700n 0.001925 482.6800n 0.001979 482.6900n 0.002031
+ 482.7000n 0.002082 482.7100n 0.002132 482.7200n 0.002181 482.7300n 0.002228 482.7400n 0.002275 482.7500n 0.002321 482.7600n 0.002365 482.7700n 0.002408 482.7800n 0.002450 482.7900n 0.002490 482.8000n 0.002530 482.8100n 0.002568 482.8200n 0.002604 482.8300n 0.002640 482.8400n 0.002674
+ 482.8500n 0.002706 482.8600n 0.002738 482.8700n 0.002767 482.8800n 0.002796 482.8900n 0.002823 482.9000n 0.002848 482.9100n 0.002872 482.9200n 0.002895 482.9300n 0.002916 482.9400n 0.002936 482.9500n 0.002954 482.9600n 0.002970 482.9700n 0.002985 482.9800n 0.002999 482.9900n 0.003011
+ 483.0000n 0.003021 483.0100n 0.003030 483.0200n 0.003038 483.0300n 0.003043 483.0400n 0.003048 483.0500n 0.003051 483.0600n 0.003052 483.0700n 0.003052 483.0800n 0.003050 483.0900n 0.003046 483.1000n 0.003042 483.1100n 0.003035 483.1200n 0.003027 483.1300n 0.003018 483.1400n 0.003007
+ 483.1500n 0.002995 483.1600n 0.002981 483.1700n 0.002966 483.1800n 0.002949 483.1900n 0.002931 483.2000n 0.002911 483.2100n 0.002890 483.2200n 0.002868 483.2300n 0.002844 483.2400n 0.002819 483.2500n 0.002793 483.2600n 0.002765 483.2700n 0.002736 483.2800n 0.002706 483.2900n 0.002674
+ 483.3000n 0.002641 483.3100n 0.002607 483.3200n 0.002572 483.3300n 0.002536 483.3400n 0.002499 483.3500n 0.002460 483.3600n 0.002420 483.3700n 0.002380 483.3800n 0.002338 483.3900n 0.002295 483.4000n 0.002252 483.4100n 0.002207 483.4200n 0.002162 483.4300n 0.002115 483.4400n 0.002068
+ 483.4500n 0.002020 483.4600n 0.001971 483.4700n 0.001922 483.4800n 0.001871 483.4900n 0.001820 483.5000n 0.001769 483.5100n 0.001717 483.5200n 0.001664 483.5300n 0.001611 483.5400n 0.001557 483.5500n 0.001502 483.5600n 0.001448 483.5700n 0.001393 483.5800n 0.001337 483.5900n 0.001281
+ 483.6000n 0.001225 483.6100n 0.001169 483.6200n 0.001112 483.6300n 0.001055 483.6400n 0.000998 483.6500n 0.000941 483.6600n 0.000884 483.6700n 0.000827 483.6800n 0.000770 483.6900n 0.000713 483.7000n 0.000656 483.7100n 0.000599 483.7200n 0.000542 483.7300n 0.000485 483.7400n 0.000429
+ 483.7500n 0.000373 483.7600n 0.000317 483.7700n 0.000261 483.7800n 0.000206 483.7900n 0.000151 483.8000n 0.000097 483.8100n 0.000043 483.8200n -0.000011 483.8300n -0.000063 483.8400n -0.000116 483.8500n -0.000168 483.8600n -0.000219 483.8700n -0.000269 483.8800n -0.000319 483.8900n -0.000368
+ 483.9000n -0.000417 483.9100n -0.000464 483.9200n -0.000511 483.9300n -0.000557 483.9400n -0.000602 483.9500n -0.000647 483.9600n -0.000690 483.9700n -0.000733 483.9800n -0.000774 483.9900n -0.000815 484.0000n -0.000854 484.0100n -0.000893 484.0200n -0.000930 484.0300n -0.000967 484.0400n -0.001002
+ 484.0500n -0.001036 484.0600n -0.001069 484.0700n -0.001101 484.0800n -0.001132 484.0900n -0.001162 484.1000n -0.001191 484.1100n -0.001218 484.1200n -0.001244 484.1300n -0.001269 484.1400n -0.001293 484.1500n -0.001315 484.1600n -0.001336 484.1700n -0.001356 484.1800n -0.001375 484.1900n -0.001392
+ 484.2000n -0.001408 484.2100n -0.001423 484.2200n -0.001436 484.2300n -0.001448 484.2400n -0.001459 484.2500n -0.001469 484.2600n -0.001477 484.2700n -0.001484 484.2800n -0.001490 484.2900n -0.001494 484.3000n -0.001497 484.3100n -0.001499 484.3200n -0.001500 484.3300n -0.001499 484.3400n -0.001497
+ 484.3500n -0.001493 484.3600n -0.001489 484.3700n -0.001483 484.3800n -0.001476 484.3900n -0.001467 484.4000n -0.001458 484.4100n -0.001447 484.4200n -0.001435 484.4300n -0.001422 484.4400n -0.001407 484.4500n -0.001392 484.4600n -0.001375 484.4700n -0.001357 484.4800n -0.001338 484.4900n -0.001318
+ 484.5000n -0.001297 484.5100n -0.001275 484.5200n -0.001252 484.5300n -0.001228 484.5400n -0.001203 484.5500n -0.001176 484.5600n -0.001149 484.5700n -0.001121 484.5800n -0.001092 484.5900n -0.001062 484.6000n -0.001032 484.6100n -0.001000 484.6200n -0.000968 484.6300n -0.000935 484.6400n -0.000901
+ 484.6500n -0.000866 484.6600n -0.000831 484.6700n -0.000795 484.6800n -0.000758 484.6900n -0.000721 484.7000n -0.000683 484.7100n -0.000645 484.7200n -0.000606 484.7300n -0.000566 484.7400n -0.000526 484.7500n -0.000486 484.7600n -0.000445 484.7700n -0.000404 484.7800n -0.000362 484.7900n -0.000320
+ 484.8000n -0.000278 484.8100n -0.000236 484.8200n -0.000193 484.8300n -0.000150 484.8400n -0.000107 484.8500n -0.000064 484.8600n -0.000020 484.8700n 0.000023 484.8800n 0.000066 484.8900n 0.000110 484.9000n 0.000153 484.9100n 0.000197 484.9200n 0.000240 484.9300n 0.000283 484.9400n 0.000326
+ 484.9500n 0.000369 484.9600n 0.000412 484.9700n 0.000455 484.9800n 0.000497 484.9900n 0.000539 485.0000n 0.000581 485.0100n 0.000622 485.0200n 0.000663 485.0300n 0.000704 485.0400n 0.000744 485.0500n 0.000784 485.0600n 0.000823 485.0700n 0.000862 485.0800n 0.000900 485.0900n 0.000938
+ 485.1000n 0.000976 485.1100n 0.001012 485.1200n 0.001048 485.1300n 0.001084 485.1400n 0.001118 485.1500n 0.001152 485.1600n 0.001186 485.1700n 0.001218 485.1800n 0.001250 485.1900n 0.001281 485.2000n 0.001312 485.2100n 0.001341 485.2200n 0.001370 485.2300n 0.001398 485.2400n 0.001425
+ 485.2500n 0.001451 485.2600n 0.001477 485.2700n 0.001501 485.2800n 0.001525 485.2900n 0.001547 485.3000n 0.001569 485.3100n 0.001590 485.3200n 0.001610 485.3300n 0.001629 485.3400n 0.001647 485.3500n 0.001663 485.3600n 0.001679 485.3700n 0.001694 485.3800n 0.001708 485.3900n 0.001721
+ 485.4000n 0.001733 485.4100n 0.001744 485.4200n 0.001754 485.4300n 0.001763 485.4400n 0.001771 485.4500n 0.001777 485.4600n 0.001783 485.4700n 0.001788 485.4800n 0.001792 485.4900n 0.001794 485.5000n 0.001796 485.5100n 0.001797 485.5200n 0.001796 485.5300n 0.001795 485.5400n 0.001792
+ 485.5500n 0.001789 485.5600n 0.001785 485.5700n 0.001779 485.5800n 0.001773 485.5900n 0.001766 485.6000n 0.001757 485.6100n 0.001748 485.6200n 0.001738 485.6300n 0.001727 485.6400n 0.001715 485.6500n 0.001702 485.6600n 0.001688 485.6700n 0.001673 485.6800n 0.001657 485.6900n 0.001641
+ 485.7000n 0.001623 485.7100n 0.001605 485.7200n 0.001586 485.7300n 0.001566 485.7400n 0.001546 485.7500n 0.001524 485.7600n 0.001502 485.7700n 0.001480 485.7800n 0.001456 485.7900n 0.001432 485.8000n 0.001407 485.8100n 0.001381 485.8200n 0.001355 485.8300n 0.001328 485.8400n 0.001301
+ 485.8500n 0.001273 485.8600n 0.001244 485.8700n 0.001215 485.8800n 0.001185 485.8900n 0.001155 485.9000n 0.001125 485.9100n 0.001094 485.9200n 0.001062 485.9300n 0.001030 485.9400n 0.000998 485.9500n 0.000965 485.9600n 0.000932 485.9700n 0.000899 485.9800n 0.000866 485.9900n 0.000832
+ 486.0000n 0.000798 486.0100n 0.000764 486.0200n 0.000729 486.0300n 0.000694 486.0400n 0.000660 486.0500n 0.000625 486.0600n 0.000590 486.0700n 0.000555 486.0800n 0.000519 486.0900n 0.000484 486.1000n 0.000449 486.1100n 0.000414 486.1200n 0.000379 486.1300n 0.000343 486.1400n 0.000308
+ 486.1500n 0.000274 486.1600n 0.000239 486.1700n 0.000204 486.1800n 0.000170 486.1900n 0.000135 486.2000n 0.000101 486.2100n 0.000067 486.2200n 0.000034 486.2300n 0.000000 486.2400n -0.000033 486.2500n -0.000066 486.2600n -0.000098 486.2700n -0.000130 486.2800n -0.000162 486.2900n -0.000193
+ 486.3000n -0.000224 486.3100n -0.000255 486.3200n -0.000285 486.3300n -0.000314 486.3400n -0.000343 486.3500n -0.000372 486.3600n -0.000400 486.3700n -0.000428 486.3800n -0.000455 486.3900n -0.000481 486.4000n -0.000507 486.4100n -0.000533 486.4200n -0.000558 486.4300n -0.000582 486.4400n -0.000606
+ 486.4500n -0.000629 486.4600n -0.000651 486.4700n -0.000673 486.4800n -0.000694 486.4900n -0.000714 486.5000n -0.000734 486.5100n -0.000753 486.5200n -0.000772 486.5300n -0.000789 486.5400n -0.000806 486.5500n -0.000823 486.5600n -0.000838 486.5700n -0.000853 486.5800n -0.000867 486.5900n -0.000881
+ 486.6000n -0.000893 486.6100n -0.000905 486.6200n -0.000916 486.6300n -0.000927 486.6400n -0.000937 486.6500n -0.000946 486.6600n -0.000954 486.6700n -0.000961 486.6800n -0.000968 486.6900n -0.000974 486.7000n -0.000980 486.7100n -0.000984 486.7200n -0.000988 486.7300n -0.000991 486.7400n -0.000993
+ 486.7500n -0.000995 486.7600n -0.000996 486.7700n -0.000996 486.7800n -0.000996 486.7900n -0.000994 486.8000n -0.000992 486.8100n -0.000990 486.8200n -0.000987 486.8300n -0.000983 486.8400n -0.000978 486.8500n -0.000973 486.8600n -0.000967 486.8700n -0.000960 486.8800n -0.000953 486.8900n -0.000945
+ 486.9000n -0.000937 486.9100n -0.000927 486.9200n -0.000918 486.9300n -0.000907 486.9400n -0.000897 486.9500n -0.000885 486.9600n -0.000873 486.9700n -0.000861 486.9800n -0.000848 486.9900n -0.000834 487.0000n -0.000820 487.0100n -0.000806 487.0200n -0.000791 487.0300n -0.000775 487.0400n -0.000759
+ 487.0500n -0.000743 487.0600n -0.000726 487.0700n -0.000709 487.0800n -0.000692 487.0900n -0.000674 487.1000n -0.000655 487.1100n -0.000637 487.1200n -0.000618 487.1300n -0.000599 487.1400n -0.000579 487.1500n -0.000559 487.1600n -0.000539 487.1700n -0.000519 487.1800n -0.000498 487.1900n -0.000477
+ 487.2000n -0.000456 487.2100n -0.000435 487.2200n -0.000414 487.2300n -0.000392 487.2400n -0.000371 487.2500n -0.000349 487.2600n -0.000327 487.2700n -0.000305 487.2800n -0.000283 487.2900n -0.000261 487.3000n -0.000239 487.3100n -0.000216 487.3200n -0.000194 487.3300n -0.000172 487.3400n -0.000150
+ 487.3500n -0.000128 487.3600n -0.000106 487.3700n -0.000084 487.3800n -0.000062 487.3900n -0.000040 487.4000n -0.000018 487.4100n 0.000004 487.4200n 0.000025 487.4300n 0.000047 487.4400n 0.000068 487.4500n 0.000089 487.4600n 0.000110 487.4700n 0.000130 487.4800n 0.000151 487.4900n 0.000171
+ 487.5000n 0.000191 487.5100n 0.000211 487.5200n 0.000230 487.5300n 0.000250 487.5400n 0.000268 487.5500n 0.000287 487.5600n 0.000305 487.5700n 0.000323 487.5800n 0.000341 487.5900n 0.000358 487.6000n 0.000375 487.6100n 0.000392 487.6200n 0.000408 487.6300n 0.000424 487.6400n 0.000440
+ 487.6500n 0.000455 487.6600n 0.000469 487.6700n 0.000484 487.6800n 0.000498 487.6900n 0.000511 487.7000n 0.000524 487.7100n 0.000537 487.7200n 0.000549 487.7300n 0.000560 487.7400n 0.000572 487.7500n 0.000583 487.7600n 0.000593 487.7700n 0.000603 487.7800n 0.000612 487.7900n 0.000621
+ 487.8000n 0.000629 487.8100n 0.000637 487.8200n 0.000645 487.8300n 0.000652 487.8400n 0.000658 487.8500n 0.000664 487.8600n 0.000670 487.8700n 0.000675 487.8800n 0.000679 487.8900n 0.000683 487.9000n 0.000687 487.9100n 0.000690 487.9200n 0.000692 487.9300n 0.000694 487.9400n 0.000696
+ 487.9500n 0.000697 487.9600n 0.000697 487.9700n 0.000697 487.9800n 0.000697 487.9900n 0.000696 488.0000n 0.000694 488.0100n 0.000692 488.0200n 0.000690 488.0300n 0.000687 488.0400n 0.000683 488.0500n 0.000679 488.0600n 0.000675 488.0700n 0.000670 488.0800n 0.000665 488.0900n 0.000659
+ 488.1000n 0.000653 488.1100n 0.000646 488.1200n 0.000639 488.1300n 0.000631 488.1400n 0.000623 488.1500n 0.000615 488.1600n 0.000606 488.1700n 0.000597 488.1800n 0.000587 488.1900n 0.000577 488.2000n 0.000567 488.2100n 0.000556 488.2200n 0.000544 488.2300n 0.000533 488.2400n 0.000521
+ 488.2500n 0.000508 488.2600n 0.000495 488.2700n 0.000482 488.2800n 0.000469 488.2900n 0.000455 488.3000n 0.000441 488.3100n 0.000426 488.3200n 0.000412 488.3300n 0.000396 488.3400n 0.000381 488.3500n 0.000365 488.3600n 0.000349 488.3700n 0.000333 488.3800n 0.000317 488.3900n 0.000300
+ 488.4000n 0.000283 488.4100n 0.000266 488.4200n 0.000248 488.4300n 0.000230 488.4400n 0.000212 488.4500n 0.000194 488.4600n 0.000176 488.4700n 0.000157 488.4800n 0.000139 488.4900n 0.000120 488.5000n 0.000101 488.5100n 0.000081 488.5200n 0.000062 488.5300n 0.000043 488.5400n 0.000023
+ 488.5500n 0.000003 488.5600n -0.000017 488.5700n -0.000037 488.5800n -0.000057 488.5900n -0.000077 488.6000n -0.000097 488.6100n -0.000118 488.6200n -0.000138 488.6300n -0.000158 488.6400n -0.000179 488.6500n -0.000199 488.6600n -0.000220 488.6700n -0.000241 488.6800n -0.000261 488.6900n -0.000282
+ 488.7000n -0.000302 488.7100n -0.000323 488.7200n -0.000344 488.7300n -0.000364 488.7400n -0.000385 488.7500n -0.000405 488.7600n -0.000426 488.7700n -0.000446 488.7800n -0.000467 488.7900n -0.000487 488.8000n -0.000507 488.8100n -0.000527 488.8200n -0.000547 488.8300n -0.000567 488.8400n -0.000587
+ 488.8500n -0.000607 488.8600n -0.000627 488.8700n -0.000646 488.8800n -0.000666 488.8900n -0.000685 488.9000n -0.000704 488.9100n -0.000723 488.9200n -0.000742 488.9300n -0.000761 488.9400n -0.000780 488.9500n -0.000798 488.9600n -0.000816 488.9700n -0.000834 488.9800n -0.000852 488.9900n -0.000870
+ 489.0000n -0.000888 489.0100n -0.000905 489.0200n -0.000922 489.0300n -0.000939 489.0400n -0.000956 489.0500n -0.000973 489.0600n -0.000989 489.0700n -0.001005 489.0800n -0.001021 489.0900n -0.001037 489.1000n -0.001052 489.1100n -0.001068 489.1200n -0.001083 489.1300n -0.001098 489.1400n -0.001112
+ 489.1500n -0.001126 489.1600n -0.001140 489.1700n -0.001154 489.1800n -0.001168 489.1900n -0.001181 489.2000n -0.001194 489.2100n -0.001207 489.2200n -0.001220 489.2300n -0.001232 489.2400n -0.001244 489.2500n -0.001256 489.2600n -0.001267 489.2700n -0.001279 489.2800n -0.001290 489.2900n -0.001300
+ 489.3000n -0.001311 489.3100n -0.001321 489.3200n -0.001331 489.3300n -0.001340 489.3400n -0.001350 489.3500n -0.001359 489.3600n -0.001367 489.3700n -0.001376 489.3800n -0.001384 489.3900n -0.001392 489.4000n -0.001400 489.4100n -0.001407 489.4200n -0.001414 489.4300n -0.001421 489.4400n -0.001427
+ 489.4500n -0.001433 489.4600n -0.001439 489.4700n -0.001445 489.4800n -0.001450 489.4900n -0.001455 489.5000n -0.001460 489.5100n -0.001464 489.5200n -0.001468 489.5300n -0.001472 489.5400n -0.001476 489.5500n -0.001479 489.5600n -0.001482 489.5700n -0.001485 489.5800n -0.001487 489.5900n -0.001489
+ 489.6000n -0.001491 489.6100n -0.001493 489.6200n -0.001494 489.6300n -0.001495 489.6400n -0.001496 489.6500n -0.001496 489.6600n -0.001496 489.6700n -0.001496 489.6800n -0.001496 489.6900n -0.001495 489.7000n -0.001494 489.7100n -0.001493 489.7200n -0.001491 489.7300n -0.001489 489.7400n -0.001487
+ 489.7500n -0.001485 489.7600n -0.001482 489.7700n -0.001479 489.7800n -0.001476 489.7900n -0.001473 489.8000n -0.001469 489.8100n -0.001465 489.8200n -0.001461 489.8300n -0.001456 489.8400n -0.001452 489.8500n -0.001447 489.8600n -0.001441 489.8700n -0.001436 489.8800n -0.001430 489.8900n -0.001424
+ 489.9000n -0.001418 489.9100n -0.001411 489.9200n -0.001405 489.9300n -0.001398 489.9400n -0.001391 489.9500n -0.001383 489.9600n -0.001375 489.9700n -0.001368 489.9800n -0.001359 489.9900n -0.001351 490.0000n -0.001342 490.0100n -0.001334 490.0200n -0.001325 490.0300n -0.001315 490.0400n -0.001306
+ 490.0500n -0.001296 490.0600n -0.001286 490.0700n -0.001276 490.0800n -0.001266 490.0900n -0.001256 490.1000n -0.001245 490.1100n -0.001234 490.1200n -0.001223 490.1300n -0.001212 490.1400n -0.001200 490.1500n -0.001189 490.1600n -0.001177 490.1700n -0.001165 490.1800n -0.001153 490.1900n -0.001141
+ 490.2000n -0.001128 490.2100n -0.001116 490.2200n -0.001103 490.2300n -0.001090 490.2400n -0.001077 490.2500n -0.001064 490.2600n -0.001051 490.2700n -0.001037 490.2800n -0.001024 490.2900n -0.001010 490.3000n -0.000996 490.3100n -0.000982 490.3200n -0.000968 490.3300n -0.000954 490.3400n -0.000939
+ 490.3500n -0.000925 490.3600n -0.000911 490.3700n -0.000896 490.3800n -0.000881 490.3900n -0.000867 490.4000n -0.000852 490.4100n -0.000837 490.4200n -0.000822 490.4300n -0.000807 490.4400n -0.000791 490.4500n -0.000776 490.4600n -0.000761 490.4700n -0.000746 490.4800n -0.000730 490.4900n -0.000715
+ 490.5000n -0.000699 490.5100n -0.000684 490.5200n -0.000669 490.5300n -0.000653 490.5400n -0.000637 490.5500n -0.000622 490.5600n -0.000606 490.5700n -0.000591 490.5800n -0.000575 490.5900n -0.000560 490.6000n -0.000544 490.6100n -0.000528 490.6200n -0.000513 490.6300n -0.000497 490.6400n -0.000482
+ 490.6500n -0.000466 490.6600n -0.000451 490.6700n -0.000436 490.6800n -0.000420 490.6900n -0.000405 490.7000n -0.000390 490.7100n -0.000375 490.7200n -0.000360 490.7300n -0.000345 490.7400n -0.000330 490.7500n -0.000315 490.7600n -0.000300 490.7700n -0.000285 490.7800n -0.000271 490.7900n -0.000256
+ 490.8000n -0.000242 490.8100n -0.000227 490.8200n -0.000213 490.8300n -0.000199 490.8400n -0.000185 490.8500n -0.000171 490.8600n -0.000158 490.8700n -0.000144 490.8800n -0.000131 490.8900n -0.000117 490.9000n -0.000104 490.9100n -0.000091 490.9200n -0.000078 490.9300n -0.000066 490.9400n -0.000053
+ 490.9500n -0.000041 490.9600n -0.000029 490.9700n -0.000016 490.9800n -0.000005 490.9900n 0.000007 491.0000n 0.000019 491.0100n 0.000030 491.0200n 0.000041 491.0300n 0.000052 491.0400n 0.000063 491.0500n 0.000073 491.0600n 0.000084 491.0700n 0.000094 491.0800n 0.000104 491.0900n 0.000113
+ 491.1000n 0.000123 491.1100n 0.000132 491.1200n 0.000141 491.1300n 0.000150 491.1400n 0.000159 491.1500n 0.000167 491.1600n 0.000175 491.1700n 0.000183 491.1800n 0.000191 491.1900n 0.000198 491.2000n 0.000206 491.2100n 0.000213 491.2200n 0.000219 491.2300n 0.000226 491.2400n 0.000232
+ 491.2500n 0.000238 491.2600n 0.000244 491.2700n 0.000250 491.2800n 0.000255 491.2900n 0.000260 491.3000n 0.000265 491.3100n 0.000270 491.3200n 0.000274 491.3300n 0.000278 491.3400n 0.000282 491.3500n 0.000285 491.3600n 0.000289 491.3700n 0.000292 491.3800n 0.000295 491.3900n 0.000297
+ 491.4000n 0.000300 491.4100n 0.000302 491.4200n 0.000304 491.4300n 0.000305 491.4400n 0.000307 491.4500n 0.000308 491.4600n 0.000309 491.4700n 0.000309 491.4800n 0.000310 491.4900n 0.000310 491.5000n 0.000310 491.5100n 0.000310 491.5200n 0.000309 491.5300n 0.000308 491.5400n 0.000307
+ 491.5500n 0.000306 491.5600n 0.000305 491.5700n 0.000303 491.5800n 0.000301 491.5900n 0.000299 491.6000n 0.000297 491.6100n 0.000294 491.6200n 0.000292 491.6300n 0.000289 491.6400n 0.000286 491.6500n 0.000282 491.6600n 0.000279 491.6700n 0.000275 491.6800n 0.000271 491.6900n 0.000267
+ 491.7000n 0.000263 491.7100n 0.000258 491.7200n 0.000253 491.7300n 0.000249 491.7400n 0.000244 491.7500n 0.000238 491.7600n 0.000233 491.7700n 0.000228 491.7800n 0.000222 491.7900n 0.000216 491.8000n 0.000210 491.8100n 0.000204 491.8200n 0.000198 491.8300n 0.000191 491.8400n 0.000185
+ 491.8500n 0.000178 491.8600n 0.000172 491.8700n 0.000165 491.8800n 0.000158 491.8900n 0.000151 491.9000n 0.000144 491.9100n 0.000136 491.9200n 0.000129 491.9300n 0.000122 491.9400n 0.000114 491.9500n 0.000106 491.9600n 0.000099 491.9700n 0.000091 491.9800n 0.000083 491.9900n 0.000075
+ 492.0000n 0.000067 492.0100n 0.000059 492.0200n 0.000051 492.0300n 0.000043 492.0400n 0.000035 492.0500n 0.000027 492.0600n 0.000019 492.0700n 0.000011 492.0800n 0.000003 492.0900n -0.000005 492.1000n -0.000014 492.1100n -0.000022 492.1200n -0.000030 492.1300n -0.000038 492.1400n -0.000046
+ 492.1500n -0.000054 492.1600n -0.000062 492.1700n -0.000070 492.1800n -0.000079 492.1900n -0.000086 492.2000n -0.000094 492.2100n -0.000102 492.2200n -0.000110 492.2300n -0.000118 492.2400n -0.000126 492.2500n -0.000133 492.2600n -0.000141 492.2700n -0.000148 492.2800n -0.000156 492.2900n -0.000163
+ 492.3000n -0.000170 492.3100n -0.000177 492.3200n -0.000184 492.3300n -0.000191 492.3400n -0.000198 492.3500n -0.000205 492.3600n -0.000211 492.3700n -0.000218 492.3800n -0.000224 492.3900n -0.000230 492.4000n -0.000236 492.4100n -0.000242 492.4200n -0.000248 492.4300n -0.000254 492.4400n -0.000259
+ 492.4500n -0.000264 492.4600n -0.000270 492.4700n -0.000275 492.4800n -0.000280 492.4900n -0.000284 492.5000n -0.000289 492.5100n -0.000293 492.5200n -0.000297 492.5300n -0.000302 492.5400n -0.000305 492.5500n -0.000309 492.5600n -0.000313 492.5700n -0.000316 492.5800n -0.000319 492.5900n -0.000322
+ 492.6000n -0.000325 492.6100n -0.000328 492.6200n -0.000330 492.6300n -0.000332 492.6400n -0.000334 492.6500n -0.000336 492.6600n -0.000338 492.6700n -0.000339 492.6800n -0.000340 492.6900n -0.000341 492.7000n -0.000342 492.7100n -0.000343 492.7200n -0.000343 492.7300n -0.000344 492.7400n -0.000344
+ 492.7500n -0.000344 492.7600n -0.000343 492.7700n -0.000343 492.7800n -0.000342 492.7900n -0.000341 492.8000n -0.000340 492.8100n -0.000339 492.8200n -0.000337 492.8300n -0.000335 492.8400n -0.000333 492.8500n -0.000331 492.8600n -0.000329 492.8700n -0.000326 492.8800n -0.000324 492.8900n -0.000321
+ 492.9000n -0.000318 492.9100n -0.000314 492.9200n -0.000311 492.9300n -0.000307 492.9400n -0.000304 492.9500n -0.000300 492.9600n -0.000295 492.9700n -0.000291 492.9800n -0.000286 492.9900n -0.000282 493.0000n -0.000277 493.0100n -0.000272 493.0200n -0.000267 493.0300n -0.000261 493.0400n -0.000256
+ 493.0500n -0.000250 493.0600n -0.000244 493.0700n -0.000238 493.0800n -0.000232 493.0900n -0.000226 493.1000n -0.000220 493.1100n -0.000213 493.1200n -0.000206 493.1300n -0.000200 493.1400n -0.000193 493.1500n -0.000186 493.1600n -0.000179 493.1700n -0.000171 493.1800n -0.000164 493.1900n -0.000156
+ 493.2000n -0.000149 493.2100n -0.000141 493.2200n -0.000134 493.2300n -0.000126 493.2400n -0.000118 493.2500n -0.000110 493.2600n -0.000102 493.2700n -0.000094 493.2800n -0.000085 493.2900n -0.000077 493.3000n -0.000069 493.3100n -0.000061 493.3200n -0.000052 493.3300n -0.000044 493.3400n -0.000035
+ 493.3500n -0.000027 493.3600n -0.000018 493.3700n -0.000010 493.3800n -0.000001 493.3900n 0.000007 493.4000n 0.000016 493.4100n 0.000024 493.4200n 0.000033 493.4300n 0.000041 493.4400n 0.000050 493.4500n 0.000058 493.4600n 0.000066 493.4700n 0.000075 493.4800n 0.000083 493.4900n 0.000091
+ 493.5000n 0.000100 493.5100n 0.000108 493.5200n 0.000116 493.5300n 0.000124 493.5400n 0.000132 493.5500n 0.000140 493.5600n 0.000148 493.5700n 0.000155 493.5800n 0.000163 493.5900n 0.000171 493.6000n 0.000178 493.6100n 0.000185 493.6200n 0.000192 493.6300n 0.000199 493.6400n 0.000206
+ 493.6500n 0.000213 493.6600n 0.000220 493.6700n 0.000226 493.6800n 0.000233 493.6900n 0.000239 493.7000n 0.000245 493.7100n 0.000251 493.7200n 0.000257 493.7300n 0.000262 493.7400n 0.000268 493.7500n 0.000273 493.7600n 0.000278 493.7700n 0.000283 493.7800n 0.000287 493.7900n 0.000292
+ 493.8000n 0.000296 493.8100n 0.000300 493.8200n 0.000304 493.8300n 0.000308 493.8400n 0.000311 493.8500n 0.000314 493.8600n 0.000317 493.8700n 0.000320 493.8800n 0.000322 493.8900n 0.000325 493.9000n 0.000327 493.9100n 0.000329 493.9200n 0.000330 493.9300n 0.000332 493.9400n 0.000333
+ 493.9500n 0.000333 493.9600n 0.000334 493.9700n 0.000334 493.9800n 0.000334 493.9900n 0.000334 494.0000n 0.000334 494.0100n 0.000333 494.0200n 0.000332 494.0300n 0.000331 494.0400n 0.000330 494.0500n 0.000328 494.0600n 0.000326 494.0700n 0.000324 494.0800n 0.000321 494.0900n 0.000318
+ 494.1000n 0.000315 494.1100n 0.000312 494.1200n 0.000308 494.1300n 0.000305 494.1400n 0.000301 494.1500n 0.000296 494.1600n 0.000292 494.1700n 0.000287 494.1800n 0.000282 494.1900n 0.000276 494.2000n 0.000270 494.2100n 0.000265 494.2200n 0.000258 494.2300n 0.000252 494.2400n 0.000245
+ 494.2500n 0.000238 494.2600n 0.000231 494.2700n 0.000224 494.2800n 0.000216 494.2900n 0.000208 494.3000n 0.000200 494.3100n 0.000192 494.3200n 0.000183 494.3300n 0.000175 494.3400n 0.000166 494.3500n 0.000156 494.3600n 0.000147 494.3700n 0.000137 494.3800n 0.000128 494.3900n 0.000118
+ 494.4000n 0.000107 494.4100n 0.000097 494.4200n 0.000086 494.4300n 0.000076 494.4400n 0.000065 494.4500n 0.000054 494.4600n 0.000042 494.4700n 0.000031 494.4800n 0.000020 494.4900n 0.000008 494.5000n -0.000004 494.5100n -0.000016 494.5200n -0.000028 494.5300n -0.000040 494.5400n -0.000052
+ 494.5500n -0.000064 494.5600n -0.000077 494.5700n -0.000089 494.5800n -0.000102 494.5900n -0.000114 494.6000n -0.000127 494.6100n -0.000140 494.6200n -0.000153 494.6300n -0.000165 494.6400n -0.000178 494.6500n -0.000191 494.6600n -0.000204 494.6700n -0.000217 494.6800n -0.000230 494.6900n -0.000242
+ 494.7000n -0.000255 494.7100n -0.000268 494.7200n -0.000281 494.7300n -0.000293 494.7400n -0.000306 494.7500n -0.000318 494.7600n -0.000331 494.7700n -0.000343 494.7800n -0.000355 494.7900n -0.000367 494.8000n -0.000379 494.8100n -0.000391 494.8200n -0.000403 494.8300n -0.000414 494.8400n -0.000426
+ 494.8500n -0.000437 494.8600n -0.000448 494.8700n -0.000459 494.8800n -0.000469 494.8900n -0.000480 494.9000n -0.000490 494.9100n -0.000500 494.9200n -0.000510 494.9300n -0.000519 494.9400n -0.000528 494.9500n -0.000537 494.9600n -0.000546 494.9700n -0.000554 494.9800n -0.000563 494.9900n -0.000570
+ 495.0000n -0.000578 495.0100n -0.000585 495.0200n -0.000592 495.0300n -0.000598 495.0400n -0.000605 495.0500n -0.000610 495.0600n -0.000616 495.0700n -0.000621 495.0800n -0.000626 495.0900n -0.000630 495.1000n -0.000634 495.1100n -0.000638 495.1200n -0.000641 495.1300n -0.000643 495.1400n -0.000646
+ 495.1500n -0.000648 495.1600n -0.000649 495.1700n -0.000650 495.1800n -0.000650 495.1900n -0.000651 495.2000n -0.000650 495.2100n -0.000649 495.2200n -0.000648 495.2300n -0.000646 495.2400n -0.000644 495.2500n -0.000641 495.2600n -0.000638 495.2700n -0.000634 495.2800n -0.000630 495.2900n -0.000625
+ 495.3000n -0.000620 495.3100n -0.000614 495.3200n -0.000608 495.3300n -0.000601 495.3400n -0.000594 495.3500n -0.000586 495.3600n -0.000578 495.3700n -0.000569 495.3800n -0.000559 495.3900n -0.000549 495.4000n -0.000539 495.4100n -0.000528 495.4200n -0.000517 495.4300n -0.000505 495.4400n -0.000492
+ 495.4500n -0.000479 495.4600n -0.000465 495.4700n -0.000451 495.4800n -0.000437 495.4900n -0.000422 495.5000n -0.000406 495.5100n -0.000390 495.5200n -0.000373 495.5300n -0.000356 495.5400n -0.000338 495.5500n -0.000320 495.5600n -0.000302 495.5700n -0.000283 495.5800n -0.000263 495.5900n -0.000243
+ 495.6000n -0.000222 495.6100n -0.000201 495.6200n -0.000180 495.6300n -0.000158 495.6400n -0.000136 495.6500n -0.000113 495.6600n -0.000090 495.6700n -0.000066 495.6800n -0.000042 495.6900n -0.000018 495.7000n 0.000007 495.7100n 0.000032 495.7200n 0.000058 495.7300n 0.000084 495.7400n 0.000110
+ 495.7500n 0.000137 495.7600n 0.000164 495.7700n 0.000191 495.7800n 0.000218 495.7900n 0.000246 495.8000n 0.000274 495.8100n 0.000303 495.8200n 0.000331 495.8300n 0.000360 495.8400n 0.000390 495.8500n 0.000419 495.8600n 0.000448 495.8700n 0.000478 495.8800n 0.000508 495.8900n 0.000538
+ 495.9000n 0.000568 495.9100n 0.000599 495.9200n 0.000629 495.9300n 0.000660 495.9400n 0.000691 495.9500n 0.000721 495.9600n 0.000752 495.9700n 0.000783 495.9800n 0.000814 495.9900n 0.000845 496.0000n 0.000876 496.0100n 0.000907 496.0200n 0.000938 496.0300n 0.000969 496.0400n 0.000999
+ 496.0500n 0.001030 496.0600n 0.001060 496.0700n 0.001091 496.0800n 0.001121 496.0900n 0.001151 496.1000n 0.001181 496.1100n 0.001211 496.1200n 0.001241 496.1300n 0.001270 496.1400n 0.001299 496.1500n 0.001328 496.1600n 0.001357 496.1700n 0.001385 496.1800n 0.001413 496.1900n 0.001441
+ 496.2000n 0.001468 496.2100n 0.001495 496.2200n 0.001522 496.2300n 0.001548 496.2400n 0.001574 496.2500n 0.001600 496.2600n 0.001625 496.2700n 0.001649 496.2800n 0.001673 496.2900n 0.001697 496.3000n 0.001720 496.3100n 0.001743 496.3200n 0.001765 496.3300n 0.001787 496.3400n 0.001808
+ 496.3500n 0.001828 496.3600n 0.001848 496.3700n 0.001867 496.3800n 0.001886 496.3900n 0.001904 496.4000n 0.001922 496.4100n 0.001938 496.4200n 0.001955 496.4300n 0.001970 496.4400n 0.001985 496.4500n 0.001999 496.4600n 0.002013 496.4700n 0.002025 496.4800n 0.002037 496.4900n 0.002048
+ 496.5000n 0.002059 496.5100n 0.002069 496.5200n 0.002078 496.5300n 0.002086 496.5400n 0.002093 496.5500n 0.002100 496.5600n 0.002106 496.5700n 0.002111 496.5800n 0.002115 496.5900n 0.002119 496.6000n 0.002122 496.6100n 0.002123 496.6200n 0.002124 496.6300n 0.002125 496.6400n 0.002124
+ 496.6500n 0.002122 496.6600n 0.002120 496.6700n 0.002117 496.6800n 0.002113 496.6900n 0.002108 496.7000n 0.002102 496.7100n 0.002096 496.7200n 0.002088 496.7300n 0.002080 496.7400n 0.002071 496.7500n 0.002061 496.7600n 0.002050 496.7700n 0.002039 496.7800n 0.002026 496.7900n 0.002013
+ 496.8000n 0.001999 496.8100n 0.001984 496.8200n 0.001968 496.8300n 0.001951 496.8400n 0.001934 496.8500n 0.001916 496.8600n 0.001897 496.8700n 0.001877 496.8800n 0.001856 496.8900n 0.001835 496.9000n 0.001813 496.9100n 0.001790 496.9200n 0.001766 496.9300n 0.001742 496.9400n 0.001717
+ 496.9500n 0.001691 496.9600n 0.001665 496.9700n 0.001637 496.9800n 0.001609 496.9900n 0.001581 497.0000n 0.001552 497.0100n 0.001522 497.0200n 0.001491 497.0300n 0.001460 497.0400n 0.001428 497.0500n 0.001396 497.0600n 0.001363 497.0700n 0.001329 497.0800n 0.001295 497.0900n 0.001261
+ 497.1000n 0.001225 497.1100n 0.001190 497.1200n 0.001154 497.1300n 0.001117 497.1400n 0.001080 497.1500n 0.001043 497.1600n 0.001005 497.1700n 0.000966 497.1800n 0.000928 497.1900n 0.000889 497.2000n 0.000849 497.2100n 0.000810 497.2200n 0.000770 497.2300n 0.000730 497.2400n 0.000689
+ 497.2500n 0.000648 497.2600n 0.000607 497.2700n 0.000566 497.2800n 0.000525 497.2900n 0.000483 497.3000n 0.000441 497.3100n 0.000399 497.3200n 0.000357 497.3300n 0.000315 497.3400n 0.000273 497.3500n 0.000231 497.3600n 0.000189 497.3700n 0.000147 497.3800n 0.000104 497.3900n 0.000062
+ 497.4000n 0.000020 497.4100n -0.000022 497.4200n -0.000064 497.4300n -0.000106 497.4400n -0.000148 497.4500n -0.000189 497.4600n -0.000231 497.4700n -0.000272 497.4800n -0.000313 497.4900n -0.000354 497.5000n -0.000394 497.5100n -0.000435 497.5200n -0.000475 497.5300n -0.000514 497.5400n -0.000554
+ 497.5500n -0.000593 497.5600n -0.000632 497.5700n -0.000670 497.5800n -0.000708 497.5900n -0.000746 497.6000n -0.000783 497.6100n -0.000820 497.6200n -0.000856 497.6300n -0.000892 497.6400n -0.000927 497.6500n -0.000962 497.6600n -0.000996 497.6700n -0.001030 497.6800n -0.001064 497.6900n -0.001096
+ 497.7000n -0.001129 497.7100n -0.001160 497.7200n -0.001191 497.7300n -0.001222 497.7400n -0.001252 497.7500n -0.001281 497.7600n -0.001310 497.7700n -0.001338 497.7800n -0.001366 497.7900n -0.001392 497.8000n -0.001418 497.8100n -0.001444 497.8200n -0.001469 497.8300n -0.001493 497.8400n -0.001516
+ 497.8500n -0.001539 497.8600n -0.001561 497.8700n -0.001583 497.8800n -0.001604 497.8900n -0.001624 497.9000n -0.001643 497.9100n -0.001662 497.9200n -0.001679 497.9300n -0.001697 497.9400n -0.001713 497.9500n -0.001729 497.9600n -0.001744 497.9700n -0.001759 497.9800n -0.001772 497.9900n -0.001785
+ 498.0000n -0.001798 498.0100n -0.001809 498.0200n -0.001820 498.0300n -0.001830 498.0400n -0.001840 498.0500n -0.001849 498.0600n -0.001857 498.0700n -0.001864 498.0800n -0.001871 498.0900n -0.001877 498.1000n -0.001883 498.1100n -0.001888 498.1200n -0.001892 498.1300n -0.001896 498.1400n -0.001899
+ 498.1500n -0.001901 498.1600n -0.001903 498.1700n -0.001904 498.1800n -0.001905 498.1900n -0.001905 498.2000n -0.001905 498.2100n -0.001904 498.2200n -0.001902 498.2300n -0.001900 498.2400n -0.001898 498.2500n -0.001895 498.2600n -0.001891 498.2700n -0.001887 498.2800n -0.001883 498.2900n -0.001878
+ 498.3000n -0.001873 498.3100n -0.001867 498.3200n -0.001861 498.3300n -0.001855 498.3400n -0.001848 498.3500n -0.001841 498.3600n -0.001834 498.3700n -0.001826 498.3800n -0.001818 498.3900n -0.001810 498.4000n -0.001802 498.4100n -0.001793 498.4200n -0.001784 498.4300n -0.001775 498.4400n -0.001766
+ 498.4500n -0.001756 498.4600n -0.001746 498.4700n -0.001737 498.4800n -0.001727 498.4900n -0.001717 498.5000n -0.001707 498.5100n -0.001697 498.5200n -0.001687 498.5300n -0.001676 498.5400n -0.001666 498.5500n -0.001656 498.5600n -0.001646 498.5700n -0.001636 498.5800n -0.001626 498.5900n -0.001616
+ 498.6000n -0.001606 498.6100n -0.001596 498.6200n -0.001587 498.6300n -0.001577 498.6400n -0.001568 498.6500n -0.001559 498.6600n -0.001550 498.6700n -0.001541 498.6800n -0.001532 498.6900n -0.001524 498.7000n -0.001516 498.7100n -0.001508 498.7200n -0.001501 498.7300n -0.001494 498.7400n -0.001487
+ 498.7500n -0.001480 498.7600n -0.001474 498.7700n -0.001468 498.7800n -0.001463 498.7900n -0.001458 498.8000n -0.001453 498.8100n -0.001448 498.8200n -0.001445 498.8300n -0.001441 498.8400n -0.001438 498.8500n -0.001435 498.8600n -0.001433 498.8700n -0.001431 498.8800n -0.001430 498.8900n -0.001429
+ 498.9000n -0.001429 498.9100n -0.001429 498.9200n -0.001429 498.9300n -0.001430 498.9400n -0.001432 498.9500n -0.001434 498.9600n -0.001437 498.9700n -0.001440 498.9800n -0.001443 498.9900n -0.001447 499.0000n -0.001452 499.0100n -0.001457 499.0200n -0.001463 499.0300n -0.001469 499.0400n -0.001476
+ 499.0500n -0.001483 499.0600n -0.001491 499.0700n -0.001499 499.0800n -0.001508 499.0900n -0.001517 499.1000n -0.001527 499.1100n -0.001537 499.1200n -0.001548 499.1300n -0.001559 499.1400n -0.001571 499.1500n -0.001583 499.1600n -0.001596 499.1700n -0.001609 499.1800n -0.001623 499.1900n -0.001637
+ 499.2000n -0.001651 499.2100n -0.001666 499.2200n -0.001682 499.2300n -0.001697 499.2400n -0.001714 499.2500n -0.001730 499.2600n -0.001747 499.2700n -0.001765 499.2800n -0.001783 499.2900n -0.001801 499.3000n -0.001819 499.3100n -0.001838 499.3200n -0.001857 499.3300n -0.001876 499.3400n -0.001896
+ 499.3500n -0.001916 499.3600n -0.001936 499.3700n -0.001957 499.3800n -0.001978 499.3900n -0.001999 499.4000n -0.002020 499.4100n -0.002041 499.4200n -0.002062 499.4300n -0.002084 499.4400n -0.002106 499.4500n -0.002128 499.4600n -0.002150 499.4700n -0.002172 499.4800n -0.002194 499.4900n -0.002216
+ 499.5000n -0.002238 499.5100n -0.002260 499.5200n -0.002282 499.5300n -0.002305 499.5400n -0.002327 499.5500n -0.002349 499.5600n -0.002371 499.5700n -0.002393 499.5800n -0.002414 499.5900n -0.002436 499.6000n -0.002457 499.6100n -0.002479 499.6200n -0.002500 499.6300n -0.002521 499.6400n -0.002541
+ 499.6500n -0.002562 499.6600n -0.002582 499.6700n -0.002602 499.6800n -0.002621 499.6900n -0.002641 499.7000n -0.002659 499.7100n -0.002678 499.7200n -0.002696 499.7300n -0.002714 499.7400n -0.002731 499.7500n -0.002748 499.7600n -0.002765 499.7700n -0.002781 499.7800n -0.002797 499.7900n -0.002812
+ 499.8000n -0.002827 499.8100n -0.002841 499.8200n -0.002855 499.8300n -0.002868 499.8400n -0.002880 499.8500n -0.002892 499.8600n -0.002904 499.8700n -0.002915 499.8800n -0.002925 499.8900n -0.002935 499.9000n -0.002944 499.9100n -0.002952 499.9200n -0.002960 499.9300n -0.002967 499.9400n -0.002973
+ 499.9500n -0.002979 499.9600n -0.002984 499.9700n -0.002989 499.9800n -0.002992 499.9900n -0.002995 500.0000n -0.002998 500.0100n -0.002999 500.0200n -0.003000 500.0300n -0.003000 500.0400n -0.003000 )

R1_DAMP b1_src b1_q1 100
R2_DAMP b2_src b2_q2 100
.ends

.subckt p1_noise_amp OUT_P OUT_N IN_P IN_N VCC VSS
R_DAMP_IN1 IN_P in_p_q1 100
R_DAMP_IN2 IN_N in_n_q2 100

XQ1 c1_n in_p_q1 e1_1 VSS npn13G2 Nx=2
XQ2 c1_p in_n_q2 e1_2 VSS npn13G2 Nx=2
RE1_1 e1_1 e1_common 15
RE1_2 e1_2 e1_common 15
RC1_1 VCC c1_n 240 m=1
RC1_2 VCC c1_p 240 m=1
R_TAIL1 e1_common VSS 316

XQEF1 VCC c1_p b2_p VSS npn13G2 Nx=1
XQEF2 VCC c1_n b2_n VSS npn13G2 Nx=1
REF1 b2_p VSS 5k m=1
REF2 b2_n VSS 5k m=1

* Stage 2
XQ3 OUT_N b2_p e2_1 VSS npn13G2 Nx=1
XQ4 OUT_P b2_n e2_2 VSS npn13G2 Nx=1
RE2_1 e2_1 e2_common 15
RE2_2 e2_2 e2_common 15
RC2_1 VCC OUT_N 240 m=1
RC2_2 VCC OUT_P 240 m=1
R_TAIL2 e2_common VSS 316
.ends

.subckt p1_comparator PBIT_OUT PBIT_RAW CLK_OUT_DIV IN_P IN_N CLK_P CLK_N VCC_HBT VDD VSS params: trim_val=512
RIN1 IN_P in_p_int 100
RIN2 IN_N in_n_int 100

RCLK1 CLK_P clk_p_int 100
RCLK2 CLK_N clk_n_int 100

XQEF_IN1 VCC_HBT in_p_int b_latch_p VSS npn13G2 Nx=1
XQEF_IN2 VCC_HBT in_n_int b_latch_n VSS npn13G2 Nx=1
REF_IN1 b_latch_p VSS 5k m=1
REF_IN2 b_latch_n VSS 5k m=1

XQCLK_TRACK e_track clk_p_int e_tail VSS npn13G2 Nx=1
XQCLK_LATCH e_latch clk_n_int e_tail VSS npn13G2 Nx=1
ISET e_tail VSS DC 2.0m

C_ETRACK e_track VSS 50f
C_ELATCH e_latch VSS 50f

XQ1 c_n b_latch_p e_track VSS npn13G2 Nx=1
XQ2 c_p b_latch_n e_track VSS npn13G2 Nx=1

XQ3 c_n c_p e_latch VSS npn13G2 Nx=1
XQ4 c_p c_n e_latch VSS npn13G2 Nx=1

RC1 VCC_HBT c_n 150 m=1
RC2 VCC_HBT c_p 150 m=1

ITRIM_P c_p VSS DC '66.85u + (trim_val - 512) * 0.1307u'
ITRIM_N c_n VSS DC '66.85u - (trim_val - 512) * 0.1307u'

XQEF1 VCC_HBT c_p ef_p VSS npn13G2 Nx=1
XQEF2 VCC_HBT c_n ef_n VSS npn13G2 Nx=1
REF1 ef_p VSS 5k m=1
REF2 ef_n VSS 5k m=1

R1_P ef_p g_p 10k m=1
R2_P g_p VSS 10k m=1
R1_N ef_n g_n 10k m=1
R2_N g_n VSS 10k m=1

XQBUF1 VCC_HBT g_p cml_out_p VSS npn13G2 Nx=1
XQBUF2 VCC_HBT g_n cml_out_n VSS npn13G2 Nx=1
RBUF1 cml_out_p VSS 5k m=1
RBUF2 cml_out_n VSS 5k m=1
.ends

XGEN gen_p gen_n vcc_hbt 0 p1_noise_gen
XAMP amp_p amp_n gen_p gen_n vcc_hbt 0 p1_noise_amp
XCOMP pbit_out raw clk_div amp_p amp_n clk_p clk_n vcc_hbt vdd 0 p1_comparator trim_val=512

VCC_HBT vcc_hbt 0 DC 2.50
VDD vdd 0 DC 1.20

VCLK_P clk_p 0 PULSE(0.775 0.925 0p 20p 20p 400.0p 1000.0p)
VCLK_N clk_n 0 PULSE(0.925 0.775 0p 20p 20p 400.0p 1000.0p)

.options method=gear reltol=1e-3

.control
op
wrdata run/pbit_op_ungv2_1.0g_seg1.txt v(xgen.xq1.t) v(xamp.xq1.t) v(gen_p) v(amp_p) v(xcomp.b_latch_p)
tran 20p 500n 0 20p
setplot tran1
wrdata run/pbit_raw_ungv2_1.0g_seg1.txt v(amp_p) v(amp_n) v(xcomp.c_p) v(xcomp.c_n) v(xcomp.b_latch_p) v(xcomp.b_latch_n)
quit
.endc
.end
