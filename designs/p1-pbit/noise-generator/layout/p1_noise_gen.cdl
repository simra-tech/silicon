** sch_path: ./cace_ihp_sg13g2_demo/xschem/p1_noise_gen.sch
.subckt p1_noise_gen IE RAW_NOISE_N RAW_NOISE_P VB1 VB2 VCC VSS
Q1 RAW_NOISE_N VB1 IE sub! npn13G2 we=70n le=900n Nx=1 m=1
Q2 RAW_NOISE_P VB2 IE sub! npn13G2 we=70n le=900n Nx=1 m=1
R1 RAW_NOISE_N VCC sub! rppd w=1u l=3.85u ps=0u b=0 m=1
R2 RAW_NOISE_P VCC sub! rppd w=1u l=3.85u ps=0u b=0 m=1
R5 VSS sub! ptap1 A=4p P=8u
.ends
.end
