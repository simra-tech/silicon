* Extracted by KLayout with SG13G2 LVS runset on : 30/07/2026 02:46

.SUBCKT p1_noise_gen IE RAW_NOISE_N RAW_NOISE_P VB1 VB2 VCC VSS
Q$1 RAW_NOISE_N VB1 IE \$1 npn13G2 we=70n le=900n Nx=1 m=1
Q$2 RAW_NOISE_P VB2 IE \$1 npn13G2 we=70n le=900n Nx=1 m=1
R$3 RAW_NOISE_N VCC \$1 rppd w=1u l=3.85u ps=0u b=0 m=1
R$4 RAW_NOISE_P VCC \$1 rppd w=1u l=3.85u ps=0u b=0 m=1
R$5 VSS \$1 ptap1 A=4p P=8u
.ENDS p1_noise_gen
