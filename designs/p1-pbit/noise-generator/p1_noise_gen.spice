** sch_path: xschem/p1_noise_gen.sch
.subckt p1_noise_gen RAW_NOISE_P RAW_NOISE_N VCC VSS
*.PININFO RAW_NOISE_P:O RAW_NOISE_N:O VCC:B VSS:B
XQ1 RAW_NOISE_N b1 e VSS npn13G2 Nx=1
XQ2 RAW_NOISE_P b2 e VSS npn13G2 Nx=1
RC1 VCC RAW_NOISE_N 1.0k m=1
RC2 VCC RAW_NOISE_P 1.0k m=1
VB1 b1 VSS DC 0.872
VB2 b2 VSS DC 0.872
ISET e VSS DC 2.0m
.ends
