* P1_NOISE_GEN Corrected Noise Testbench
.lib $PDK_ROOT/ihp-sg13g2/libs.tech/ngspice/models/cornerHBT.lib hbt_typ

* Differential HBT Noise Generator Netlist
.subckt p1_noise_gen RAW_NOISE_P RAW_NOISE_N b1 b2 VCC VSS
XQ1 RAW_NOISE_N b1 e VSS npn13G2 Nx=1
XQ2 RAW_NOISE_P b2 e VSS npn13G2 Nx=1
RC1 VCC RAW_NOISE_N 1.0k m=1
RC2 VCC RAW_NOISE_P 1.0k m=1
ISET e VSS DC 2.0m
.ends

* Testbench Top
X1 raw_p raw_n b1 b2 vcc 0 p1_noise_gen

* Power Supply
VCC vcc 0 DC 2.5

* Common-mode base bias + Differential AC source VIN
VCM b_cm 0 DC 0.872
VVIN b1 b2 DC 0 AC 1

* Connect b1 and b2 to b_cm for DC
RDC1 b1 b_cm 1meg
RDC2 b2 b_cm 1meg

.control
osdi $PDK_ROOT/ihp-sg13g2/libs.tech/ngspice/osdi/psp103.osdi
op

* Noise analysis referenced to differential input VIN
noise v(raw_p, raw_n) VVIN dec 10 100k 20G
setplot noise1
print frequency onoise_spectrum inoise_spectrum

quit
.endc
.end
