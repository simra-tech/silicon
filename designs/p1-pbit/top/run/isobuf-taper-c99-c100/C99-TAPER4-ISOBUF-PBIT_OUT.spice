* C99 TAPER4 ISOBUF PBIT_OUT - 4-stage non-inverting taper of
* iso_buf_pbit_out (SOURCE ONLY, UNRUN)
* Stage 1: EXACTLY as C11-V2 draws it (Wp=2.83u Wn=2.0u L=0.13u ng=1
*   m=1) - UNTOUCHED, so core loading is unchanged from the lineage.
* Stage 2: same geometry m=2. Stage 3: same geometry m=4.
* Stage 4: the existing output inverter UNCHANGED (Wp=14.4u m=2,
*   Wn=7.2u m=2). Four stages keeps it non-inverting.
* Model-valid primitives: sg13_lv_pmos / sg13_lv_nmos (cornerMOSlv.lib
* mos_tt supplied by the including deck).
* No .end (this file is .include'd by the deck).
.subckt iso_buf_pbit_out IN OUT VDD VSS
* stage 1: input inverter - EXACT C11-V2 core geometry, untouched
XP1 N1 IN VDD VDD sg13_lv_pmos w=2.83u l=0.13u ng=1 m=1 mm_ok=1
XN1 N1 IN VSS VSS sg13_lv_nmos w=2.0u l=0.13u ng=1 m=1 mm_ok=1
* stage 2: same geometry m=2
XP2 N2 N1 VDD VDD sg13_lv_pmos w=2.83u l=0.13u ng=1 m=2 mm_ok=1
XN2 N2 N1 VSS VSS sg13_lv_nmos w=2.0u l=0.13u ng=1 m=2 mm_ok=1
* stage 3: same geometry m=4
XP3 N3 N2 VDD VDD sg13_lv_pmos w=2.83u l=0.13u ng=1 m=4 mm_ok=1
XN3 N3 N2 VSS VSS sg13_lv_nmos w=2.0u l=0.13u ng=1 m=4 mm_ok=1
* stage 4: the existing output inverter, unchanged
XP4 OUT N3 VDD VDD sg13_lv_pmos w=14.4u l=0.13u ng=1 m=2 mm_ok=1
XN4 OUT N3 VSS VSS sg13_lv_nmos w=7.2u l=0.13u ng=1 m=2 mm_ok=1
.ends iso_buf_pbit_out
